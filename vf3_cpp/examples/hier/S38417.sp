* Synopsys Nettran: RHEL64 R-2020.09.5783960 2020/08/19
* Created:  9/12/2024  12:27
* Options: -verilog s38417_net.v -sp gsclib045.cdl -verilog-b0 VSS -verilog-b1 VDD -outType SPICE -outName s38417_net_hr.sp

.GLOBAL VDD VSS

.SUBCKT XOR3XL A B C VDD VSS Y
Mmn3 n56 n60 n50 VSS g45n1svt M=1 L=45n W=190n
Mmn10 n62 A VSS VSS g45n1svt M=1 L=45n W=190n
Mmn4 n44 C n50 VSS g45n1svt M=1 L=45n W=190n
Mmn8 n60 C VSS VSS g45n1svt M=1 L=45n W=190n
Mmn9 n61 B VSS VSS g45n1svt M=1 L=45n W=190n
Mmn6 n56 B n11 VSS g45n1svt M=1 L=45n W=190n
Mmn1 n62 B n44 VSS g45n1svt M=1 L=45n W=190n
Mmn2 n11 n61 n44 VSS g45n1svt M=1 L=45n W=190n
Mmn0 n11 n62 VSS VSS g45n1svt M=1 L=45n W=190n
Mmn5 n62 n61 n56 VSS g45n1svt M=1 L=45n W=190n
Mmn7 Y n50 VSS VSS g45n1svt M=1 L=45n W=190n
Mmp10 n62 A VDD VDD g45p1svt M=1 L=45n W=310n
Mmp1 n44 n61 n62 VDD g45p1svt M=1 L=45n W=310n
Mmp7 Y n50 VDD VDD g45p1svt M=1 L=45n W=205n
Mmp2 n44 B n11 VDD g45p1svt M=1 L=45n W=310n
Mmp9 n61 B VDD VDD g45p1svt M=1 L=45n W=310n
Mmp3 n50 C n56 VDD g45p1svt M=1 L=45n W=310n
Mmp8 n60 C VDD VDD g45p1svt M=1 L=45n W=310n
Mmp4 n50 n60 n44 VDD g45p1svt M=1 L=45n W=310n
Mmp0 n11 n62 VDD VDD g45p1svt M=1 L=45n W=310n
Mmp6 n11 n61 n56 VDD g45p1svt M=1 L=45n W=310n
Mmp5 n56 B n62 VDD g45p1svt M=1 L=45n W=310n
.ENDS

.SUBCKT XOR3X1 A B C VDD VSS Y
Mmn3 n56 n60 n50 VSS g45n1svt M=1 L=45n W=190n
Mmn10 n62 A VSS VSS g45n1svt M=1 L=45n W=205n
Mmn4 n44 C n50 VSS g45n1svt M=1 L=45n W=190n
Mmn8 n60 C VSS VSS g45n1svt M=1 L=45n W=190n
Mmn9 n61 B VSS VSS g45n1svt M=1 L=45n W=190n
Mmn6 n56 B n11 VSS g45n1svt M=1 L=45n W=190n
Mmn1 n62 B n44 VSS g45n1svt M=1 L=45n W=205n
Mmn2 n11 n61 n44 VSS g45n1svt M=1 L=45n W=190n
Mmn0 n11 n62 VSS VSS g45n1svt M=1 L=45n W=190n
Mmn5 n62 n61 n56 VSS g45n1svt M=1 L=45n W=205n
Mmn7 Y n50 VSS VSS g45n1svt M=1 L=45n W=205n
Mmp10 n62 A VDD VDD g45p1svt M=1 L=45n W=390n
Mmp1 n44 n61 n62 VDD g45p1svt M=1 L=45n W=390n
Mmp7 Y n50 VDD VDD g45p1svt M=1 L=45n W=390n
Mmp2 n44 B n11 VDD g45p1svt M=1 L=45n W=310n
Mmp9 n61 B VDD VDD g45p1svt M=1 L=45n W=310n
Mmp3 n50 C n56 VDD g45p1svt M=1 L=45n W=310n
Mmp8 n60 C VDD VDD g45p1svt M=1 L=45n W=310n
Mmp4 n50 n60 n44 VDD g45p1svt M=1 L=45n W=310n
Mmp0 n11 n62 VDD VDD g45p1svt M=1 L=45n W=310n
Mmp6 n11 n61 n56 VDD g45p1svt M=1 L=45n W=310n
Mmp5 n56 B n62 VDD g45p1svt M=1 L=45n W=390n
.ENDS

.SUBCKT XOR2XL A B VDD VSS Y
Mmn1 n2 B VSS VSS g45n1svt M=1 L=45n W=145n
Mmn0 n1 A VSS VSS g45n1svt M=1 L=45n W=145n
Mmn5 Y n0 VSS VSS g45n1svt M=1 L=45n W=145n
Mmn3 n0 B net131 VSS g45n1svt M=1 L=45n W=145n
Mmn4 n0 n2 n1 VSS g45n1svt M=1 L=45n W=145n
Mmn2 net131 n1 VSS VSS g45n1svt M=1 L=45n W=145n
Mmp3 n0 n2 net130 VDD g45p1svt M=1 L=45n W=215n
Mmp1 n2 B VDD VDD g45p1svt M=1 L=45n W=215n
Mmp4 n1 B n0 VDD g45p1svt M=1 L=45n W=215n
Mmp0 n1 A VDD VDD g45p1svt M=1 L=45n W=215n
Mmp5 Y n0 VDD VDD g45p1svt M=1 L=45n W=215n
Mmp2 net130 n1 VDD VDD g45p1svt M=1 L=45n W=215n
.ENDS

.SUBCKT XOR2X4 A B VDD VSS Y
Mmn1 n2 B VSS VSS g45n1svt M=1 L=45n W=145n
Mmn0 n1 A VSS VSS g45n1svt M=1 L=45n W=145n
Mmn5 Y n0 VSS VSS g45n1svt M=1 L=45n W=1.04u
Mmn3 n0 B net131 VSS g45n1svt M=1 L=45n W=260n
Mmn4 n0 n2 n1 VSS g45n1svt M=1 L=45n W=260n
Mmn2 net131 n1 VSS VSS g45n1svt M=1 L=45n W=260n
Mmp3 n0 n2 net130 VDD g45p1svt M=1 L=45n W=390n
Mmp1 n2 B VDD VDD g45p1svt M=1 L=45n W=215n
Mmp4 n1 B n0 VDD g45p1svt M=1 L=45n W=390n
Mmp0 n1 A VDD VDD g45p1svt M=1 L=45n W=215n
Mmp5 Y n0 VDD VDD g45p1svt M=1 L=45n W=1.56u
Mmp2 net130 n1 VDD VDD g45p1svt M=1 L=45n W=390n
.ENDS

.SUBCKT XOR2X2 A B VDD VSS Y
Mmn1 n2 B VSS VSS g45n1svt M=1 L=45n W=145n
Mmn0 n1 A VSS VSS g45n1svt M=1 L=45n W=145n
Mmn5 Y n0 VSS VSS g45n1svt M=1 L=45n W=520n
Mmn3 n0 B net131 VSS g45n1svt M=1 L=45n W=145n
Mmn4 n0 n2 n1 VSS g45n1svt M=1 L=45n W=145n
Mmn2 net131 n1 VSS VSS g45n1svt M=1 L=45n W=145n
Mmp3 n0 n2 net130 VDD g45p1svt M=1 L=45n W=215n
Mmp1 n2 B VDD VDD g45p1svt M=1 L=45n W=215n
Mmp4 n1 B n0 VDD g45p1svt M=1 L=45n W=215n
Mmp0 n1 A VDD VDD g45p1svt M=1 L=45n W=215n
Mmp5 Y n0 VDD VDD g45p1svt M=1 L=45n W=780n
Mmp2 net130 n1 VDD VDD g45p1svt M=1 L=45n W=215n
.ENDS

.SUBCKT XNOR3XL A B C VDD VSS Y
Mmn8 Y n11 VSS VSS g45n1svt M=1 L=45n W=205n
Mmn10 n12 n61 n8 VSS g45n1svt M=1 L=45n W=205n
Mmn2 n9 n61 n62 VSS g45n1svt M=1 L=45n W=190n
Mmn1 n9 B n8 VSS g45n1svt M=1 L=45n W=190n
Mmn9 n8 n62 VSS VSS g45n1svt M=1 L=45n W=190n
Mmn11 n12 B n62 VSS g45n1svt M=1 L=45n W=190n
Mmn6 n11 C n9 VSS g45n1svt M=1 L=45n W=190n
Mmn5 n11 n60 n12 VSS g45n1svt M=1 L=45n W=190n
Mmn7 n60 C VSS VSS g45n1svt M=1 L=45n W=190n
Mmn4 n61 B VSS VSS g45n1svt M=1 L=45n W=190n
Mmn3 n62 A VSS VSS g45n1svt M=1 L=45n W=205n
Mmp8 Y n11 VDD VDD g45p1svt M=1 L=45n W=205n
Mmp3 n62 A VDD VDD g45p1svt M=1 L=45n W=310n
Mmp6 n9 n60 n11 VDD g45p1svt M=1 L=45n W=310n
Mmp11 n62 n61 n12 VDD g45p1svt M=1 L=45n W=310n
Mmp2 n62 B n9 VDD g45p1svt M=1 L=45n W=310n
Mmp5 n12 C n11 VDD g45p1svt M=1 L=45n W=310n
Mmp1 n8 n61 n9 VDD g45p1svt M=1 L=45n W=310n
Mmp10 n8 B n12 VDD g45p1svt M=1 L=45n W=310n
Mmp4 n61 B VDD VDD g45p1svt M=1 L=45n W=310n
Mmp9 n8 n62 VDD VDD g45p1svt M=1 L=45n W=310n
Mmp7 n60 C VDD VDD g45p1svt M=1 L=45n W=310n
.ENDS

.SUBCKT XNOR3X1 A B C VDD VSS Y
Mmn8 Y n11 VSS VSS g45n1svt M=1 L=45n W=205n
Mmn10 n12 n61 n8 VSS g45n1svt M=1 L=45n W=205n
Mmn2 n9 n61 n62 VSS g45n1svt M=1 L=45n W=205n
Mmn1 n9 B n8 VSS g45n1svt M=1 L=45n W=190n
Mmn9 n8 n62 VSS VSS g45n1svt M=1 L=45n W=190n
Mmn11 n12 B n62 VSS g45n1svt M=1 L=45n W=205n
Mmn6 n11 C n9 VSS g45n1svt M=1 L=45n W=190n
Mmn5 n11 n60 n12 VSS g45n1svt M=1 L=45n W=190n
Mmn7 n60 C VSS VSS g45n1svt M=1 L=45n W=190n
Mmn4 n61 B VSS VSS g45n1svt M=1 L=45n W=190n
Mmn3 n62 A VSS VSS g45n1svt M=1 L=45n W=205n
Mmp8 Y n11 VDD VDD g45p1svt M=1 L=45n W=390n
Mmp3 n62 A VDD VDD g45p1svt M=1 L=45n W=390n
Mmp6 n9 n60 n11 VDD g45p1svt M=1 L=45n W=310n
Mmp11 n62 n61 n12 VDD g45p1svt M=1 L=45n W=390n
Mmp2 n62 B n9 VDD g45p1svt M=1 L=45n W=390n
Mmp5 n12 C n11 VDD g45p1svt M=1 L=45n W=310n
Mmp1 n8 n61 n9 VDD g45p1svt M=1 L=45n W=310n
Mmp10 n8 B n12 VDD g45p1svt M=1 L=45n W=310n
Mmp4 n61 B VDD VDD g45p1svt M=1 L=45n W=310n
Mmp9 n8 n62 VDD VDD g45p1svt M=1 L=45n W=310n
Mmp7 n60 C VDD VDD g45p1svt M=1 L=45n W=310n
.ENDS

.SUBCKT XNOR2XL A B VDD VSS Y
Mmn1 n2 B VSS VSS g45n1svt M=1 L=45n W=145n
Mmn2 net145 n1 VSS VSS g45n1svt M=1 L=45n W=145n
Mmn3 n0 n2 net145 VSS g45n1svt M=1 L=45n W=145n
Mmn5 Y n0 VSS VSS g45n1svt M=1 L=45n W=145n
Mmn0 n1 A VSS VSS g45n1svt M=1 L=45n W=145n
Mmn4 n0 B n1 VSS g45n1svt M=1 L=45n W=145n
Mmp0 n1 A VDD VDD g45p1svt M=1 L=45n W=215n
Mmp4 n1 n2 n0 VDD g45p1svt M=1 L=45n W=215n
Mmp2 net112 n1 VDD VDD g45p1svt M=1 L=45n W=215n
Mmp1 n2 B VDD VDD g45p1svt M=1 L=45n W=215n
Mmp3 n0 B net112 VDD g45p1svt M=1 L=45n W=215n
Mmp5 Y n0 VDD VDD g45p1svt M=1 L=45n W=215n
.ENDS

.SUBCKT XNOR2X4 A B VDD VSS Y
Mmn1 n2 B VSS VSS g45n1svt M=1 L=45n W=145n
Mmn2 net145 n1 VSS VSS g45n1svt M=1 L=45n W=260n
Mmn3 n0 n2 net145 VSS g45n1svt M=1 L=45n W=260n
Mmn5 Y n0 VSS VSS g45n1svt M=1 L=45n W=1.04u
Mmn0 n1 A VSS VSS g45n1svt M=1 L=45n W=145n
Mmn4 n0 B n1 VSS g45n1svt M=1 L=45n W=260n
Mmp0 n1 A VDD VDD g45p1svt M=1 L=45n W=215n
Mmp4 n1 n2 n0 VDD g45p1svt M=1 L=45n W=390n
Mmp2 net112 n1 VDD VDD g45p1svt M=1 L=45n W=390n
Mmp1 n2 B VDD VDD g45p1svt M=1 L=45n W=215n
Mmp3 n0 B net112 VDD g45p1svt M=1 L=45n W=390n
Mmp5 Y n0 VDD VDD g45p1svt M=1 L=45n W=1.56u
.ENDS

.SUBCKT XNOR2X2 A B VDD VSS Y
Mmn1 n2 B VSS VSS g45n1svt M=1 L=45n W=145n
Mmn2 net145 n1 VSS VSS g45n1svt M=1 L=45n W=145n
Mmn3 n0 n2 net145 VSS g45n1svt M=1 L=45n W=145n
Mmn5 Y n0 VSS VSS g45n1svt M=1 L=45n W=520n
Mmn0 n1 A VSS VSS g45n1svt M=1 L=45n W=145n
Mmn4 n0 B n1 VSS g45n1svt M=1 L=45n W=145n
Mmp0 n1 A VDD VDD g45p1svt M=1 L=45n W=215n
Mmp4 n1 n2 n0 VDD g45p1svt M=1 L=45n W=215n
Mmp2 net112 n1 VDD VDD g45p1svt M=1 L=45n W=215n
Mmp1 n2 B VDD VDD g45p1svt M=1 L=45n W=215n
Mmp3 n0 B net112 VDD g45p1svt M=1 L=45n W=215n
Mmp5 Y n0 VDD VDD g45p1svt M=1 L=45n W=780n
.ENDS

.SUBCKT XNOR2X1 A B VDD VSS Y
Mmn1 n2 B VSS VSS g45n1svt M=1 L=45n W=145n
Mmn2 net145 n1 VSS VSS g45n1svt M=1 L=45n W=145n
Mmn3 n0 n2 net145 VSS g45n1svt M=1 L=45n W=145n
Mmn5 Y n0 VSS VSS g45n1svt M=1 L=45n W=260n
Mmn0 n1 A VSS VSS g45n1svt M=1 L=45n W=145n
Mmn4 n0 B n1 VSS g45n1svt M=1 L=45n W=145n
Mmp0 n1 A VDD VDD g45p1svt M=1 L=45n W=215n
Mmp4 n1 n2 n0 VDD g45p1svt M=1 L=45n W=215n
Mmp2 net112 n1 VDD VDD g45p1svt M=1 L=45n W=215n
Mmp1 n2 B VDD VDD g45p1svt M=1 L=45n W=215n
Mmp3 n0 B net112 VDD g45p1svt M=1 L=45n W=215n
Mmp5 Y n0 VDD VDD g45p1svt M=1 L=45n W=390n
.ENDS

.SUBCKT TLATXL D G Q QN VDD VSS
Mmn5 net257 D VSS VSS g45n1svt M=1 L=45n W=145n
Mmn6 n0 Gbb net257 VSS g45n1svt M=1 L=45n W=145n
Mmn16 n0 Gb net245 VSS g45n1svt M=1 L=45n W=145n
Mmn15 net245 Qint VSS VSS g45n1svt M=1 L=45n W=145n
Mmn22 QN Qint VSS VSS g45n1svt M=1 L=45n W=145n
Mmn21 Q Qbint VSS VSS g45n1svt M=1 L=45n W=145n
Mmn0 Gb G VSS VSS g45n1svt M=1 L=45n W=145n
Mmn10 Qint n0 VSS VSS g45n1svt M=1 L=45n W=145n
Mmn20 Qbint Qint VSS VSS g45n1svt M=1 L=45n W=145n
Mmn1 Gbb Gb VSS VSS g45n1svt M=1 L=45n W=145n
Mmp6 n0 Gb net220 VDD g45p1svt M=1 L=45n W=215n
Mmp5 net220 D VDD VDD g45p1svt M=1 L=45n W=215n
Mmp16 n0 Gbb net212 VDD g45p1svt M=1 L=45n W=215n
Mmp15 net212 Qint VDD VDD g45p1svt M=1 L=45n W=215n
Mmp22 QN Qint VDD VDD g45p1svt M=1 L=45n W=215n
Mmp21 Q Qbint VDD VDD g45p1svt M=1 L=45n W=215n
Mmp0 Gb G VDD VDD g45p1svt M=1 L=45n W=215n
Mmp1 Gbb Gb VDD VDD g45p1svt M=1 L=45n W=215n
Mmp10 Qint n0 VDD VDD g45p1svt M=1 L=45n W=215n
Mmp20 Qbint Qint VDD VDD g45p1svt M=1 L=45n W=215n
.ENDS

.SUBCKT TLATX4 D G Q QN VDD VSS
Mmn5 net257 D VSS VSS g45n1svt M=1 L=45n W=145n
Mmn6 n0 Gbb net257 VSS g45n1svt M=1 L=45n W=145n
Mmn16 n0 Gb net245 VSS g45n1svt M=1 L=45n W=145n
Mmn15 net245 Qint VSS VSS g45n1svt M=1 L=45n W=145n
Mmn22 QN Qint VSS VSS g45n1svt M=1 L=45n W=1.04u
Mmn21 Q Qbint VSS VSS g45n1svt M=1 L=45n W=1.04u
Mmn0 Gb G VSS VSS g45n1svt M=1 L=45n W=145n
Mmn10 Qint n0 VSS VSS g45n1svt M=1 L=45n W=410n
Mmn20 Qbint Qint VSS VSS g45n1svt M=1 L=45n W=1.04u
Mmn1 Gbb Gb VSS VSS g45n1svt M=1 L=45n W=145n
Mmp6 n0 Gb net220 VDD g45p1svt M=1 L=45n W=215n
Mmp5 net220 D VDD VDD g45p1svt M=1 L=45n W=215n
Mmp16 n0 Gbb net212 VDD g45p1svt M=1 L=45n W=215n
Mmp15 net212 Qint VDD VDD g45p1svt M=1 L=45n W=215n
Mmp22 QN Qint VDD VDD g45p1svt M=1 L=45n W=1.56u
Mmp21 Q Qbint VDD VDD g45p1svt M=1 L=45n W=1.56u
Mmp0 Gb G VDD VDD g45p1svt M=1 L=45n W=215n
Mmp1 Gbb Gb VDD VDD g45p1svt M=1 L=45n W=215n
Mmp10 Qint n0 VDD VDD g45p1svt M=1 L=45n W=620n
Mmp20 Qbint Qint VDD VDD g45p1svt M=1 L=45n W=1.56u
.ENDS

.SUBCKT TLATX2 D G Q QN VDD VSS
Mmn5 net257 D VSS VSS g45n1svt M=1 L=45n W=145n
Mmn6 n0 Gbb net257 VSS g45n1svt M=1 L=45n W=145n
Mmn16 n0 Gb net245 VSS g45n1svt M=1 L=45n W=145n
Mmn15 net245 Qint VSS VSS g45n1svt M=1 L=45n W=145n
Mmn22 QN Qint VSS VSS g45n1svt M=1 L=45n W=520n
Mmn21 Q Qbint VSS VSS g45n1svt M=1 L=45n W=520n
Mmn0 Gb G VSS VSS g45n1svt M=1 L=45n W=145n
Mmn10 Qint n0 VSS VSS g45n1svt M=1 L=45n W=205n
Mmn20 Qbint Qint VSS VSS g45n1svt M=1 L=45n W=520n
Mmn1 Gbb Gb VSS VSS g45n1svt M=1 L=45n W=145n
Mmp6 n0 Gb net220 VDD g45p1svt M=1 L=45n W=215n
Mmp5 net220 D VDD VDD g45p1svt M=1 L=45n W=215n
Mmp16 n0 Gbb net212 VDD g45p1svt M=1 L=45n W=215n
Mmp15 net212 Qint VDD VDD g45p1svt M=1 L=45n W=215n
Mmp22 QN Qint VDD VDD g45p1svt M=1 L=45n W=780n
Mmp21 Q Qbint VDD VDD g45p1svt M=1 L=45n W=780n
Mmp0 Gb G VDD VDD g45p1svt M=1 L=45n W=215n
Mmp1 Gbb Gb VDD VDD g45p1svt M=1 L=45n W=215n
Mmp10 Qint n0 VDD VDD g45p1svt M=1 L=45n W=310n
Mmp20 Qbint Qint VDD VDD g45p1svt M=1 L=45n W=780n
.ENDS

.SUBCKT TLATX1 D G Q QN VDD VSS
Mmn5 net257 D VSS VSS g45n1svt M=1 L=45n W=145n
Mmn6 n0 Gbb net257 VSS g45n1svt M=1 L=45n W=145n
Mmn16 n0 Gb net245 VSS g45n1svt M=1 L=45n W=145n
Mmn15 net245 Qint VSS VSS g45n1svt M=1 L=45n W=145n
Mmn22 QN Qint VSS VSS g45n1svt M=1 L=45n W=260n
Mmn21 Q Qbint VSS VSS g45n1svt M=1 L=45n W=260n
Mmn0 Gb G VSS VSS g45n1svt M=1 L=45n W=145n
Mmn10 Qint n0 VSS VSS g45n1svt M=1 L=45n W=145n
Mmn20 Qbint Qint VSS VSS g45n1svt M=1 L=45n W=260n
Mmn1 Gbb Gb VSS VSS g45n1svt M=1 L=45n W=145n
Mmp6 n0 Gb net220 VDD g45p1svt M=1 L=45n W=215n
Mmp5 net220 D VDD VDD g45p1svt M=1 L=45n W=215n
Mmp16 n0 Gbb net212 VDD g45p1svt M=1 L=45n W=215n
Mmp15 net212 Qint VDD VDD g45p1svt M=1 L=45n W=215n
Mmp22 QN Qint VDD VDD g45p1svt M=1 L=45n W=390n
Mmp21 Q Qbint VDD VDD g45p1svt M=1 L=45n W=390n
Mmp0 Gb G VDD VDD g45p1svt M=1 L=45n W=215n
Mmp1 Gbb Gb VDD VDD g45p1svt M=1 L=45n W=215n
Mmp10 Qint n0 VDD VDD g45p1svt M=1 L=45n W=215n
Mmp20 Qbint Qint VDD VDD g45p1svt M=1 L=45n W=390n
.ENDS

.SUBCKT TLATSRXL D G Q QN RN SN VDD VSS
Mmn5 net191 D VSS VSS g45n1svt M=1 L=45n W=145n
Mmn6 n5 Gbb net191 VSS g45n1svt M=1 L=45n W=145n
Mmn10 net183 SN VSS VSS g45n1svt M=1 L=45n W=145n
Mmn11 Qint n5 net183 VSS g45n1svt M=1 L=45n W=145n
Mmn17 n5 Gb net171 VSS g45n1svt M=1 L=45n W=145n
Mmn16 net171 Qint net167 VSS g45n1svt M=1 L=45n W=145n
Mmn15 net167 RN VSS VSS g45n1svt M=1 L=45n W=145n
Mmn1 Gb G net159 VSS g45n1svt M=1 L=45n W=145n
Mmn0 net159 RN VSS VSS g45n1svt M=1 L=45n W=145n
Mmn22 QN Qint VSS VSS g45n1svt M=1 L=45n W=145n
Mmn21 Q Qbint VSS VSS g45n1svt M=1 L=45n W=145n
Mmn2 Gbb Gb VSS VSS g45n1svt M=1 L=45n W=145n
Mmn20 Qbint Qint VSS VSS g45n1svt M=1 L=45n W=145n
Mmp6 n5 Gb net142 VDD g45p1svt M=1 L=45n W=215n
Mmp5 net142 D VDD VDD g45p1svt M=1 L=45n W=215n
Mmp10 Qint SN VDD VDD g45p1svt M=1 L=45n W=215n
Mmp1 Gb G VDD VDD g45p1svt M=1 L=45n W=215n
Mmp22 QN Qint VDD VDD g45p1svt M=1 L=45n W=215n
Mmp21 Q Qbint VDD VDD g45p1svt M=1 L=45n W=215n
Mmp2 Gbb Gb VDD VDD g45p1svt M=1 L=45n W=215n
Mmp17 n5 Gbb net103 VDD g45p1svt M=1 L=45n W=215n
Mmp16 net103 Qint VDD VDD g45p1svt M=1 L=45n W=215n
Mmp15 net103 RN VDD VDD g45p1svt M=1 L=45n W=215n
Mmp0 Gb RN VDD VDD g45p1svt M=1 L=45n W=215n
Mmp20 Qbint Qint VDD VDD g45p1svt M=1 L=45n W=215n
Mmp11 Qint n5 VDD VDD g45p1svt M=1 L=45n W=215n
.ENDS

.SUBCKT TLATSRX4 D G Q QN RN SN VDD VSS
Mmn5 net191 D VSS VSS g45n1svt M=1 L=45n W=145n
Mmn6 n5 Gbb net191 VSS g45n1svt M=1 L=45n W=145n
Mmn10 net183 SN VSS VSS g45n1svt M=1 L=45n W=410n
Mmn11 Qint n5 net183 VSS g45n1svt M=1 L=45n W=410n
Mmn17 n5 Gb net171 VSS g45n1svt M=1 L=45n W=145n
Mmn16 net171 Qint net167 VSS g45n1svt M=1 L=45n W=145n
Mmn15 net167 RN VSS VSS g45n1svt M=1 L=45n W=145n
Mmn1 Gb G net159 VSS g45n1svt M=1 L=45n W=145n
Mmn0 net159 RN VSS VSS g45n1svt M=1 L=45n W=145n
Mmn22 QN Qint VSS VSS g45n1svt M=1 L=45n W=1.04u
Mmn21 Q Qbint VSS VSS g45n1svt M=1 L=45n W=1.04u
Mmn2 Gbb Gb VSS VSS g45n1svt M=1 L=45n W=145n
Mmn20 Qbint Qint VSS VSS g45n1svt M=1 L=45n W=1.04u
Mmp6 n5 Gb net142 VDD g45p1svt M=1 L=45n W=215n
Mmp5 net142 D VDD VDD g45p1svt M=1 L=45n W=215n
Mmp10 Qint SN VDD VDD g45p1svt M=1 L=45n W=620n
Mmp1 Gb G VDD VDD g45p1svt M=1 L=45n W=215n
Mmp22 QN Qint VDD VDD g45p1svt M=1 L=45n W=1.56u
Mmp21 Q Qbint VDD VDD g45p1svt M=1 L=45n W=1.56u
Mmp2 Gbb Gb VDD VDD g45p1svt M=1 L=45n W=215n
Mmp17 n5 Gbb net103 VDD g45p1svt M=1 L=45n W=215n
Mmp16 net103 Qint VDD VDD g45p1svt M=1 L=45n W=215n
Mmp15 net103 RN VDD VDD g45p1svt M=1 L=45n W=215n
Mmp0 Gb RN VDD VDD g45p1svt M=1 L=45n W=215n
Mmp20 Qbint Qint VDD VDD g45p1svt M=1 L=45n W=1.56u
Mmp11 Qint n5 VDD VDD g45p1svt M=1 L=45n W=620n
.ENDS

.SUBCKT TLATSRX2 D G Q QN RN SN VDD VSS
Mmn5 net191 D VSS VSS g45n1svt M=1 L=45n W=145n
Mmn6 n5 Gbb net191 VSS g45n1svt M=1 L=45n W=145n
Mmn10 net183 SN VSS VSS g45n1svt M=1 L=45n W=205n
Mmn11 Qint n5 net183 VSS g45n1svt M=1 L=45n W=205n
Mmn17 n5 Gb net171 VSS g45n1svt M=1 L=45n W=145n
Mmn16 net171 Qint net167 VSS g45n1svt M=1 L=45n W=145n
Mmn15 net167 RN VSS VSS g45n1svt M=1 L=45n W=145n
Mmn1 Gb G net159 VSS g45n1svt M=1 L=45n W=145n
Mmn0 net159 RN VSS VSS g45n1svt M=1 L=45n W=145n
Mmn22 QN Qint VSS VSS g45n1svt M=1 L=45n W=520n
Mmn21 Q Qbint VSS VSS g45n1svt M=1 L=45n W=520n
Mmn2 Gbb Gb VSS VSS g45n1svt M=1 L=45n W=145n
Mmn20 Qbint Qint VSS VSS g45n1svt M=1 L=45n W=520n
Mmp6 n5 Gb net142 VDD g45p1svt M=1 L=45n W=215n
Mmp5 net142 D VDD VDD g45p1svt M=1 L=45n W=215n
Mmp10 Qint SN VDD VDD g45p1svt M=1 L=45n W=310n
Mmp1 Gb G VDD VDD g45p1svt M=1 L=45n W=215n
Mmp22 QN Qint VDD VDD g45p1svt M=1 L=45n W=780n
Mmp21 Q Qbint VDD VDD g45p1svt M=1 L=45n W=780n
Mmp2 Gbb Gb VDD VDD g45p1svt M=1 L=45n W=215n
Mmp17 n5 Gbb net103 VDD g45p1svt M=1 L=45n W=215n
Mmp16 net103 Qint VDD VDD g45p1svt M=1 L=45n W=215n
Mmp15 net103 RN VDD VDD g45p1svt M=1 L=45n W=215n
Mmp0 Gb RN VDD VDD g45p1svt M=1 L=45n W=215n
Mmp20 Qbint Qint VDD VDD g45p1svt M=1 L=45n W=780n
Mmp11 Qint n5 VDD VDD g45p1svt M=1 L=45n W=310n
.ENDS

.SUBCKT TLATSRX1 D G Q QN RN SN VDD VSS
Mmn5 net191 D VSS VSS g45n1svt M=1 L=45n W=145n
Mmn6 n5 Gbb net191 VSS g45n1svt M=1 L=45n W=145n
Mmn10 net183 SN VSS VSS g45n1svt M=1 L=45n W=145n
Mmn11 Qint n5 net183 VSS g45n1svt M=1 L=45n W=145n
Mmn17 n5 Gb net171 VSS g45n1svt M=1 L=45n W=145n
Mmn16 net171 Qint net167 VSS g45n1svt M=1 L=45n W=145n
Mmn15 net167 RN VSS VSS g45n1svt M=1 L=45n W=145n
Mmn1 Gb G net159 VSS g45n1svt M=1 L=45n W=145n
Mmn0 net159 RN VSS VSS g45n1svt M=1 L=45n W=145n
Mmn22 QN Qint VSS VSS g45n1svt M=1 L=45n W=260n
Mmn21 Q Qbint VSS VSS g45n1svt M=1 L=45n W=260n
Mmn2 Gbb Gb VSS VSS g45n1svt M=1 L=45n W=145n
Mmn20 Qbint Qint VSS VSS g45n1svt M=1 L=45n W=260n
Mmp6 n5 Gb net142 VDD g45p1svt M=1 L=45n W=215n
Mmp5 net142 D VDD VDD g45p1svt M=1 L=45n W=215n
Mmp10 Qint SN VDD VDD g45p1svt M=1 L=45n W=215n
Mmp1 Gb G VDD VDD g45p1svt M=1 L=45n W=215n
Mmp22 QN Qint VDD VDD g45p1svt M=1 L=45n W=390n
Mmp21 Q Qbint VDD VDD g45p1svt M=1 L=45n W=390n
Mmp2 Gbb Gb VDD VDD g45p1svt M=1 L=45n W=215n
Mmp17 n5 Gbb net103 VDD g45p1svt M=1 L=45n W=215n
Mmp16 net103 Qint VDD VDD g45p1svt M=1 L=45n W=215n
Mmp15 net103 RN VDD VDD g45p1svt M=1 L=45n W=215n
Mmp0 Gb RN VDD VDD g45p1svt M=1 L=45n W=215n
Mmp20 Qbint Qint VDD VDD g45p1svt M=1 L=45n W=390n
Mmp11 Qint n5 VDD VDD g45p1svt M=1 L=45n W=215n
.ENDS

.SUBCKT TLATNXL D GN Q QN VDD VSS
Mmn5 net257 D VSS VSS g45n1svt M=1 L=45n W=145n
Mmn6 n0 GNb net257 VSS g45n1svt M=1 L=45n W=145n
Mmn16 n0 GNbb net245 VSS g45n1svt M=1 L=45n W=145n
Mmn15 net245 Qint VSS VSS g45n1svt M=1 L=45n W=145n
Mmn22 QN Qint VSS VSS g45n1svt M=1 L=45n W=145n
Mmn21 Q Qbint VSS VSS g45n1svt M=1 L=45n W=145n
Mmn0 GNb GN VSS VSS g45n1svt M=1 L=45n W=145n
Mmn1 GNbb GNb VSS VSS g45n1svt M=1 L=45n W=145n
Mmn10 Qint n0 VSS VSS g45n1svt M=1 L=45n W=145n
Mmn20 Qbint Qint VSS VSS g45n1svt M=1 L=45n W=145n
Mmp6 n0 GNbb net220 VDD g45p1svt M=1 L=45n W=215n
Mmp5 net220 D VDD VDD g45p1svt M=1 L=45n W=215n
Mmp16 n0 GNb net212 VDD g45p1svt M=1 L=45n W=215n
Mmp15 net212 Qint VDD VDD g45p1svt M=1 L=45n W=215n
Mmp22 QN Qint VDD VDD g45p1svt M=1 L=45n W=215n
Mmp21 Q Qbint VDD VDD g45p1svt M=1 L=45n W=215n
Mmp0 GNb GN VDD VDD g45p1svt M=1 L=45n W=215n
Mmp1 GNbb GNb VDD VDD g45p1svt M=1 L=45n W=215n
Mmp10 Qint n0 VDD VDD g45p1svt M=1 L=45n W=215n
Mmp20 Qbint Qint VDD VDD g45p1svt M=1 L=45n W=215n
.ENDS

.SUBCKT TLATNX4 D GN Q QN VDD VSS
Mmn5 net257 D VSS VSS g45n1svt M=1 L=45n W=145n
Mmn6 n0 GNb net257 VSS g45n1svt M=1 L=45n W=145n
Mmn16 n0 GNbb net245 VSS g45n1svt M=1 L=45n W=145n
Mmn15 net245 Qint VSS VSS g45n1svt M=1 L=45n W=145n
Mmn22 QN Qint VSS VSS g45n1svt M=1 L=45n W=1.04u
Mmn21 Q Qbint VSS VSS g45n1svt M=1 L=45n W=1.04u
Mmn0 GNb GN VSS VSS g45n1svt M=1 L=45n W=145n
Mmn1 GNbb GNb VSS VSS g45n1svt M=1 L=45n W=145n
Mmn10 Qint n0 VSS VSS g45n1svt M=1 L=45n W=410n
Mmn20 Qbint Qint VSS VSS g45n1svt M=1 L=45n W=1.04u
Mmp6 n0 GNbb net220 VDD g45p1svt M=1 L=45n W=215n
Mmp5 net220 D VDD VDD g45p1svt M=1 L=45n W=215n
Mmp16 n0 GNb net212 VDD g45p1svt M=1 L=45n W=215n
Mmp15 net212 Qint VDD VDD g45p1svt M=1 L=45n W=215n
Mmp22 QN Qint VDD VDD g45p1svt M=1 L=45n W=1.56u
Mmp21 Q Qbint VDD VDD g45p1svt M=1 L=45n W=1.56u
Mmp0 GNb GN VDD VDD g45p1svt M=1 L=45n W=215n
Mmp1 GNbb GNb VDD VDD g45p1svt M=1 L=45n W=215n
Mmp10 Qint n0 VDD VDD g45p1svt M=1 L=45n W=620n
Mmp20 Qbint Qint VDD VDD g45p1svt M=1 L=45n W=1.56u
.ENDS

.SUBCKT TLATNX2 D GN Q QN VDD VSS
Mmn5 net257 D VSS VSS g45n1svt M=1 L=45n W=145n
Mmn6 n0 GNb net257 VSS g45n1svt M=1 L=45n W=145n
Mmn16 n0 GNbb net245 VSS g45n1svt M=1 L=45n W=145n
Mmn15 net245 Qint VSS VSS g45n1svt M=1 L=45n W=145n
Mmn22 QN Qint VSS VSS g45n1svt M=1 L=45n W=520n
Mmn21 Q Qbint VSS VSS g45n1svt M=1 L=45n W=520n
Mmn0 GNb GN VSS VSS g45n1svt M=1 L=45n W=145n
Mmn1 GNbb GNb VSS VSS g45n1svt M=1 L=45n W=145n
Mmn10 Qint n0 VSS VSS g45n1svt M=1 L=45n W=205n
Mmn20 Qbint Qint VSS VSS g45n1svt M=1 L=45n W=520n
Mmp6 n0 GNbb net220 VDD g45p1svt M=1 L=45n W=215n
Mmp5 net220 D VDD VDD g45p1svt M=1 L=45n W=215n
Mmp16 n0 GNb net212 VDD g45p1svt M=1 L=45n W=215n
Mmp15 net212 Qint VDD VDD g45p1svt M=1 L=45n W=215n
Mmp22 QN Qint VDD VDD g45p1svt M=1 L=45n W=780n
Mmp21 Q Qbint VDD VDD g45p1svt M=1 L=45n W=780n
Mmp0 GNb GN VDD VDD g45p1svt M=1 L=45n W=215n
Mmp1 GNbb GNb VDD VDD g45p1svt M=1 L=45n W=215n
Mmp10 Qint n0 VDD VDD g45p1svt M=1 L=45n W=310n
Mmp20 Qbint Qint VDD VDD g45p1svt M=1 L=45n W=780n
.ENDS

.SUBCKT TLATNX1 D GN Q QN VDD VSS
Mmn5 net257 D VSS VSS g45n1svt M=1 L=45n W=145n
Mmn6 n0 GNb net257 VSS g45n1svt M=1 L=45n W=145n
Mmn16 n0 GNbb net245 VSS g45n1svt M=1 L=45n W=145n
Mmn15 net245 Qint VSS VSS g45n1svt M=1 L=45n W=145n
Mmn22 QN Qint VSS VSS g45n1svt M=1 L=45n W=260n
Mmn21 Q Qbint VSS VSS g45n1svt M=1 L=45n W=260n
Mmn0 GNb GN VSS VSS g45n1svt M=1 L=45n W=145n
Mmn1 GNbb GNb VSS VSS g45n1svt M=1 L=45n W=145n
Mmn10 Qint n0 VSS VSS g45n1svt M=1 L=45n W=145n
Mmn20 Qbint Qint VSS VSS g45n1svt M=1 L=45n W=260n
Mmp6 n0 GNbb net220 VDD g45p1svt M=1 L=45n W=215n
Mmp5 net220 D VDD VDD g45p1svt M=1 L=45n W=215n
Mmp16 n0 GNb net212 VDD g45p1svt M=1 L=45n W=215n
Mmp15 net212 Qint VDD VDD g45p1svt M=1 L=45n W=215n
Mmp22 QN Qint VDD VDD g45p1svt M=1 L=45n W=390n
Mmp21 Q Qbint VDD VDD g45p1svt M=1 L=45n W=390n
Mmp0 GNb GN VDD VDD g45p1svt M=1 L=45n W=215n
Mmp1 GNbb GNb VDD VDD g45p1svt M=1 L=45n W=215n
Mmp10 Qint n0 VDD VDD g45p1svt M=1 L=45n W=215n
Mmp20 Qbint Qint VDD VDD g45p1svt M=1 L=45n W=390n
.ENDS

.SUBCKT TLATNTSCAX8 CK E ECK SE VDD VSS
Mmn1 Eb E VSS VSS g45n1svt M=1 L=45n W=145n
Mmn0 Eb SE VSS VSS g45n1svt M=1 L=45n W=145n
Mmn22 ECK ECKb VSS VSS g45n1svt M=1 L=45n W=2.065u
Mmn21 ECKb CKbb net271 VSS g45n1svt M=1 L=45n W=520n
Mmn20 net271 Eint VSS VSS g45n1svt M=1 L=45n W=520n
Mmn16 n5 CKbb net263 VSS g45n1svt M=1 L=45n W=145n
Mmn15 net263 Eint VSS VSS g45n1svt M=1 L=45n W=145n
Mmn2 CKb CK VSS VSS g45n1svt M=1 L=45n W=145n
Mmn10 Eint n5 VSS VSS g45n1svt M=1 L=45n W=205n
Mmn5 Eb CKb n5 VSS g45n1svt M=1 L=45n W=145n
Mmn3 CKbb CKb VSS VSS g45n1svt M=1 L=45n W=145n
Mmp1 Eb E net246 VDD g45p1svt M=1 L=45n W=215n
Mmp0 net246 SE VDD VDD g45p1svt M=1 L=45n W=215n
Mmp22 ECK ECKb VDD VDD g45p1svt M=1 L=45n W=3.115u
Mmp16 n5 CKb net234 VDD g45p1svt M=1 L=45n W=215n
Mmp15 net234 Eint VDD VDD g45p1svt M=1 L=45n W=215n
Mmp2 CKb CK VDD VDD g45p1svt M=1 L=45n W=215n
Mmp10 Eint n5 VDD VDD g45p1svt M=1 L=45n W=310n
Mmp3 CKbb CKb VDD VDD g45p1svt M=1 L=45n W=215n
Mmp5 n5 CKbb Eb VDD g45p1svt M=1 L=45n W=215n
Mmp21 ECKb CKbb VDD VDD g45p1svt M=1 L=45n W=780n
Mmp20 ECKb Eint VDD VDD g45p1svt M=1 L=45n W=780n
.ENDS

.SUBCKT TLATNTSCAX6 CK E ECK SE VDD VSS
Mmn1 Eb E VSS VSS g45n1svt M=1 L=45n W=145n
Mmn0 Eb SE VSS VSS g45n1svt M=1 L=45n W=145n
Mmn22 ECK ECKb VSS VSS g45n1svt M=1 L=45n W=1.55u
Mmn21 ECKb CKbb net271 VSS g45n1svt M=1 L=45n W=520n
Mmn20 net271 Eint VSS VSS g45n1svt M=1 L=45n W=520n
Mmn16 n5 CKbb net263 VSS g45n1svt M=1 L=45n W=145n
Mmn15 net263 Eint VSS VSS g45n1svt M=1 L=45n W=145n
Mmn2 CKb CK VSS VSS g45n1svt M=1 L=45n W=145n
Mmn10 Eint n5 VSS VSS g45n1svt M=1 L=45n W=205n
Mmn5 Eb CKb n5 VSS g45n1svt M=1 L=45n W=145n
Mmn3 CKbb CKb VSS VSS g45n1svt M=1 L=45n W=145n
Mmp1 Eb E net246 VDD g45p1svt M=1 L=45n W=215n
Mmp0 net246 SE VDD VDD g45p1svt M=1 L=45n W=215n
Mmp22 ECK ECKb VDD VDD g45p1svt M=1 L=45n W=2.35u
Mmp16 n5 CKb net234 VDD g45p1svt M=1 L=45n W=215n
Mmp15 net234 Eint VDD VDD g45p1svt M=1 L=45n W=215n
Mmp2 CKb CK VDD VDD g45p1svt M=1 L=45n W=215n
Mmp10 Eint n5 VDD VDD g45p1svt M=1 L=45n W=310n
Mmp3 CKbb CKb VDD VDD g45p1svt M=1 L=45n W=215n
Mmp5 n5 CKbb Eb VDD g45p1svt M=1 L=45n W=215n
Mmp21 ECKb CKbb VDD VDD g45p1svt M=1 L=45n W=780n
Mmp20 ECKb Eint VDD VDD g45p1svt M=1 L=45n W=780n
.ENDS

.SUBCKT TLATNTSCAX4 CK E ECK SE VDD VSS
Mmn1 Eb E VSS VSS g45n1svt M=1 L=45n W=145n
Mmn0 Eb SE VSS VSS g45n1svt M=1 L=45n W=145n
Mmn22 ECK ECKb VSS VSS g45n1svt M=1 L=45n W=1.04u
Mmn21 ECKb CKbb net271 VSS g45n1svt M=1 L=45n W=260n
Mmn20 net271 Eint VSS VSS g45n1svt M=1 L=45n W=260n
Mmn16 n5 CKbb net263 VSS g45n1svt M=1 L=45n W=145n
Mmn15 net263 Eint VSS VSS g45n1svt M=1 L=45n W=145n
Mmn2 CKb CK VSS VSS g45n1svt M=1 L=45n W=145n
Mmn10 Eint n5 VSS VSS g45n1svt M=1 L=45n W=145n
Mmn5 Eb CKb n5 VSS g45n1svt M=1 L=45n W=145n
Mmn3 CKbb CKb VSS VSS g45n1svt M=1 L=45n W=145n
Mmp1 Eb E net246 VDD g45p1svt M=1 L=45n W=215n
Mmp0 net246 SE VDD VDD g45p1svt M=1 L=45n W=215n
Mmp22 ECK ECKb VDD VDD g45p1svt M=1 L=45n W=1.56u
Mmp16 n5 CKb net234 VDD g45p1svt M=1 L=45n W=215n
Mmp15 net234 Eint VDD VDD g45p1svt M=1 L=45n W=215n
Mmp2 CKb CK VDD VDD g45p1svt M=1 L=45n W=215n
Mmp10 Eint n5 VDD VDD g45p1svt M=1 L=45n W=215n
Mmp3 CKbb CKb VDD VDD g45p1svt M=1 L=45n W=215n
Mmp5 n5 CKbb Eb VDD g45p1svt M=1 L=45n W=215n
Mmp21 ECKb CKbb VDD VDD g45p1svt M=1 L=45n W=390n
Mmp20 ECKb Eint VDD VDD g45p1svt M=1 L=45n W=390n
.ENDS

.SUBCKT TLATNTSCAX3 CK E ECK SE VDD VSS
Mmn1 Eb E VSS VSS g45n1svt M=1 L=45n W=145n
Mmn0 Eb SE VSS VSS g45n1svt M=1 L=45n W=145n
Mmn22 ECK ECKb VSS VSS g45n1svt M=1 L=45n W=780n
Mmn21 ECKb CKbb net271 VSS g45n1svt M=1 L=45n W=260n
Mmn20 net271 Eint VSS VSS g45n1svt M=1 L=45n W=260n
Mmn16 n5 CKbb net263 VSS g45n1svt M=1 L=45n W=145n
Mmn15 net263 Eint VSS VSS g45n1svt M=1 L=45n W=145n
Mmn2 CKb CK VSS VSS g45n1svt M=1 L=45n W=145n
Mmn10 Eint n5 VSS VSS g45n1svt M=1 L=45n W=145n
Mmn5 Eb CKb n5 VSS g45n1svt M=1 L=45n W=145n
Mmn3 CKbb CKb VSS VSS g45n1svt M=1 L=45n W=145n
Mmp1 Eb E net246 VDD g45p1svt M=1 L=45n W=215n
Mmp0 net246 SE VDD VDD g45p1svt M=1 L=45n W=215n
Mmp22 ECK ECKb VDD VDD g45p1svt M=1 L=45n W=1.17u
Mmp16 n5 CKb net234 VDD g45p1svt M=1 L=45n W=215n
Mmp15 net234 Eint VDD VDD g45p1svt M=1 L=45n W=215n
Mmp2 CKb CK VDD VDD g45p1svt M=1 L=45n W=215n
Mmp10 Eint n5 VDD VDD g45p1svt M=1 L=45n W=215n
Mmp3 CKbb CKb VDD VDD g45p1svt M=1 L=45n W=215n
Mmp5 n5 CKbb Eb VDD g45p1svt M=1 L=45n W=215n
Mmp21 ECKb CKbb VDD VDD g45p1svt M=1 L=45n W=390n
Mmp20 ECKb Eint VDD VDD g45p1svt M=1 L=45n W=390n
.ENDS

.SUBCKT TLATNTSCAX2 CK E ECK SE VDD VSS
Mmn1 Eb E VSS VSS g45n1svt M=1 L=45n W=145n
Mmn0 Eb SE VSS VSS g45n1svt M=1 L=45n W=145n
Mmn22 ECK ECKb VSS VSS g45n1svt M=1 L=45n W=520n
Mmn21 ECKb CKbb net271 VSS g45n1svt M=1 L=45n W=145n
Mmn20 net271 Eint VSS VSS g45n1svt M=1 L=45n W=145n
Mmn16 n5 CKbb net263 VSS g45n1svt M=1 L=45n W=145n
Mmn15 net263 Eint VSS VSS g45n1svt M=1 L=45n W=145n
Mmn2 CKb CK VSS VSS g45n1svt M=1 L=45n W=145n
Mmn10 Eint n5 VSS VSS g45n1svt M=1 L=45n W=145n
Mmn5 Eb CKb n5 VSS g45n1svt M=1 L=45n W=145n
Mmn3 CKbb CKb VSS VSS g45n1svt M=1 L=45n W=145n
Mmp1 Eb E net246 VDD g45p1svt M=1 L=45n W=215n
Mmp0 net246 SE VDD VDD g45p1svt M=1 L=45n W=215n
Mmp22 ECK ECKb VDD VDD g45p1svt M=1 L=45n W=780n
Mmp16 n5 CKb net234 VDD g45p1svt M=1 L=45n W=215n
Mmp15 net234 Eint VDD VDD g45p1svt M=1 L=45n W=215n
Mmp2 CKb CK VDD VDD g45p1svt M=1 L=45n W=215n
Mmp10 Eint n5 VDD VDD g45p1svt M=1 L=45n W=215n
Mmp3 CKbb CKb VDD VDD g45p1svt M=1 L=45n W=215n
Mmp5 n5 CKbb Eb VDD g45p1svt M=1 L=45n W=215n
Mmp21 ECKb CKbb VDD VDD g45p1svt M=1 L=45n W=215n
Mmp20 ECKb Eint VDD VDD g45p1svt M=1 L=45n W=215n
.ENDS

.SUBCKT TLATNTSCAX20 CK E ECK SE VDD VSS
Mmn1 Eb E VSS VSS g45n1svt M=1 L=45n W=145n
Mmn0 Eb SE VSS VSS g45n1svt M=1 L=45n W=145n
Mmn22 ECK ECKb VSS VSS g45n1svt M=1 L=45n W=5.185u
Mmn21 ECKb CKbb net271 VSS g45n1svt M=1 L=45n W=1.3u
Mmn20 net271 Eint VSS VSS g45n1svt M=1 L=45n W=1.3u
Mmn16 n5 CKbb net263 VSS g45n1svt M=1 L=45n W=145n
Mmn15 net263 Eint VSS VSS g45n1svt M=1 L=45n W=145n
Mmn2 CKb CK VSS VSS g45n1svt M=1 L=45n W=145n
Mmn10 Eint n5 VSS VSS g45n1svt M=1 L=45n W=520n
Mmn5 Eb CKb n5 VSS g45n1svt M=1 L=45n W=145n
Mmn3 CKbb CKb VSS VSS g45n1svt M=1 L=45n W=145n
Mmp1 Eb E net246 VDD g45p1svt M=1 L=45n W=215n
Mmp0 net246 SE VDD VDD g45p1svt M=1 L=45n W=215n
Mmp22 ECK ECKb VDD VDD g45p1svt M=1 L=45n W=7.815u
Mmp16 n5 CKb net234 VDD g45p1svt M=1 L=45n W=215n
Mmp15 net234 Eint VDD VDD g45p1svt M=1 L=45n W=215n
Mmp2 CKb CK VDD VDD g45p1svt M=1 L=45n W=215n
Mmp10 Eint n5 VDD VDD g45p1svt M=1 L=45n W=780n
Mmp3 CKbb CKb VDD VDD g45p1svt M=1 L=45n W=215n
Mmp5 n5 CKbb Eb VDD g45p1svt M=1 L=45n W=215n
Mmp21 ECKb CKbb VDD VDD g45p1svt M=1 L=45n W=1.95u
Mmp20 ECKb Eint VDD VDD g45p1svt M=1 L=45n W=1.95u
.ENDS

.SUBCKT TLATNTSCAX16 CK E ECK SE VDD VSS
Mmn1 Eb E VSS VSS g45n1svt M=1 L=45n W=145n
Mmn0 Eb SE VSS VSS g45n1svt M=1 L=45n W=145n
Mmn22 ECK ECKb VSS VSS g45n1svt M=1 L=45n W=4.13u
Mmn21 ECKb CKbb net271 VSS g45n1svt M=1 L=45n W=1.04u
Mmn20 net271 Eint VSS VSS g45n1svt M=1 L=45n W=1.04u
Mmn16 n5 CKbb net263 VSS g45n1svt M=1 L=45n W=145n
Mmn15 net263 Eint VSS VSS g45n1svt M=1 L=45n W=145n
Mmn2 CKb CK VSS VSS g45n1svt M=1 L=45n W=145n
Mmn10 Eint n5 VSS VSS g45n1svt M=1 L=45n W=410n
Mmn5 Eb CKb n5 VSS g45n1svt M=1 L=45n W=145n
Mmn3 CKbb CKb VSS VSS g45n1svt M=1 L=45n W=145n
Mmp1 Eb E net246 VDD g45p1svt M=1 L=45n W=215n
Mmp0 net246 SE VDD VDD g45p1svt M=1 L=45n W=215n
Mmp22 ECK ECKb VDD VDD g45p1svt M=1 L=45n W=6.23u
Mmp16 n5 CKb net234 VDD g45p1svt M=1 L=45n W=215n
Mmp15 net234 Eint VDD VDD g45p1svt M=1 L=45n W=215n
Mmp2 CKb CK VDD VDD g45p1svt M=1 L=45n W=215n
Mmp10 Eint n5 VDD VDD g45p1svt M=1 L=45n W=620n
Mmp3 CKbb CKb VDD VDD g45p1svt M=1 L=45n W=215n
Mmp5 n5 CKbb Eb VDD g45p1svt M=1 L=45n W=215n
Mmp21 ECKb CKbb VDD VDD g45p1svt M=1 L=45n W=1.56u
Mmp20 ECKb Eint VDD VDD g45p1svt M=1 L=45n W=1.56u
.ENDS

.SUBCKT TLATNTSCAX12 CK E ECK SE VDD VSS
Mmn1 Eb E VSS VSS g45n1svt M=1 L=45n W=145n
Mmn0 Eb SE VSS VSS g45n1svt M=1 L=45n W=145n
Mmn22 ECK ECKb VSS VSS g45n1svt M=1 L=45n W=3.1u
Mmn21 ECKb CKbb net271 VSS g45n1svt M=1 L=45n W=780n
Mmn20 net271 Eint VSS VSS g45n1svt M=1 L=45n W=780n
Mmn16 n5 CKbb net263 VSS g45n1svt M=1 L=45n W=145n
Mmn15 net263 Eint VSS VSS g45n1svt M=1 L=45n W=145n
Mmn2 CKb CK VSS VSS g45n1svt M=1 L=45n W=145n
Mmn10 Eint n5 VSS VSS g45n1svt M=1 L=45n W=260n
Mmn5 Eb CKb n5 VSS g45n1svt M=1 L=45n W=145n
Mmn3 CKbb CKb VSS VSS g45n1svt M=1 L=45n W=145n
Mmp1 Eb E net246 VDD g45p1svt M=1 L=45n W=215n
Mmp0 net246 SE VDD VDD g45p1svt M=1 L=45n W=215n
Mmp22 ECK ECKb VDD VDD g45p1svt M=1 L=45n W=4.7u
Mmp16 n5 CKb net234 VDD g45p1svt M=1 L=45n W=215n
Mmp15 net234 Eint VDD VDD g45p1svt M=1 L=45n W=215n
Mmp2 CKb CK VDD VDD g45p1svt M=1 L=45n W=215n
Mmp10 Eint n5 VDD VDD g45p1svt M=1 L=45n W=390n
Mmp3 CKbb CKb VDD VDD g45p1svt M=1 L=45n W=215n
Mmp5 n5 CKbb Eb VDD g45p1svt M=1 L=45n W=215n
Mmp21 ECKb CKbb VDD VDD g45p1svt M=1 L=45n W=1.17u
Mmp20 ECKb Eint VDD VDD g45p1svt M=1 L=45n W=1.17u
.ENDS

.SUBCKT TLATNSRXL D GN Q QN RN SN VDD VSS
Mmn5 net366 D VSS VSS g45n1svt M=1 L=45n W=145n
Mmn6 n5 GNb net366 VSS g45n1svt M=1 L=45n W=145n
Mmn17 n5 GNbb net354 VSS g45n1svt M=1 L=45n W=145n
Mmn16 net354 qint net350 VSS g45n1svt M=1 L=45n W=145n
Mmn15 net350 RN VSS VSS g45n1svt M=1 L=45n W=145n
Mmn11 qint n5 net342 VSS g45n1svt M=1 L=45n W=145n
Mmn10 net342 SN VSS VSS g45n1svt M=1 L=45n W=145n
Mmn21 Q qbint VSS VSS g45n1svt M=1 L=45n W=145n
Mmn0 GNbp GN VSS VSS g45n1svt M=1 L=45n W=145n
Mmn2 GNbb GNbp net326 VSS g45n1svt M=1 L=45n W=145n
Mmn1 net326 RN VSS VSS g45n1svt M=1 L=45n W=145n
Mmn3 GNb GNbb VSS VSS g45n1svt M=1 L=45n W=145n
Mmn20 qbint qint VSS VSS g45n1svt M=1 L=45n W=145n
Mmn22 QN qint VSS VSS g45n1svt M=1 L=45n W=145n
Mmp6 n5 GNbb net313 VDD g45p1svt M=1 L=45n W=215n
Mmp5 net313 D VDD VDD g45p1svt M=1 L=45n W=215n
Mmp10 qint SN VDD VDD g45p1svt M=1 L=45n W=215n
Mmp22 QN qint VDD VDD g45p1svt M=1 L=45n W=215n
Mmp21 Q qbint VDD VDD g45p1svt M=1 L=45n W=215n
Mmp0 GNbp GN VDD VDD g45p1svt M=1 L=45n W=215n
Mmp3 GNb GNbb VDD VDD g45p1svt M=1 L=45n W=215n
Mmp17 n5 GNb net270 VDD g45p1svt M=1 L=45n W=215n
Mmp2 GNbb GNbp VDD VDD g45p1svt M=1 L=45n W=215n
Mmp16 net270 qint VDD VDD g45p1svt M=1 L=45n W=215n
Mmp15 net270 RN VDD VDD g45p1svt M=1 L=45n W=215n
Mmp20 qbint qint VDD VDD g45p1svt M=1 L=45n W=215n
Mmp1 GNbb RN VDD VDD g45p1svt M=1 L=45n W=215n
Mmp11 qint n5 VDD VDD g45p1svt M=1 L=45n W=215n
.ENDS

.SUBCKT TLATNSRX4 D GN Q QN RN SN VDD VSS
Mmn5 net366 D VSS VSS g45n1svt M=1 L=45n W=145n
Mmn6 n5 GNb net366 VSS g45n1svt M=1 L=45n W=145n
Mmn17 n5 GNbb net354 VSS g45n1svt M=1 L=45n W=145n
Mmn16 net354 qint net350 VSS g45n1svt M=1 L=45n W=145n
Mmn15 net350 RN VSS VSS g45n1svt M=1 L=45n W=145n
Mmn11 qint n5 net342 VSS g45n1svt M=1 L=45n W=410n
Mmn10 net342 SN VSS VSS g45n1svt M=1 L=45n W=410n
Mmn21 Q qbint VSS VSS g45n1svt M=1 L=45n W=1.04u
Mmn0 GNbp GN VSS VSS g45n1svt M=1 L=45n W=145n
Mmn2 GNbb GNbp net326 VSS g45n1svt M=1 L=45n W=145n
Mmn1 net326 RN VSS VSS g45n1svt M=1 L=45n W=145n
Mmn3 GNb GNbb VSS VSS g45n1svt M=1 L=45n W=145n
Mmn20 qbint qint VSS VSS g45n1svt M=1 L=45n W=1.04u
Mmn22 QN qint VSS VSS g45n1svt M=1 L=45n W=1.04u
Mmp6 n5 GNbb net313 VDD g45p1svt M=1 L=45n W=215n
Mmp5 net313 D VDD VDD g45p1svt M=1 L=45n W=215n
Mmp10 qint SN VDD VDD g45p1svt M=1 L=45n W=620n
Mmp22 QN qint VDD VDD g45p1svt M=1 L=45n W=1.56u
Mmp21 Q qbint VDD VDD g45p1svt M=1 L=45n W=1.56u
Mmp0 GNbp GN VDD VDD g45p1svt M=1 L=45n W=215n
Mmp3 GNb GNbb VDD VDD g45p1svt M=1 L=45n W=215n
Mmp17 n5 GNb net270 VDD g45p1svt M=1 L=45n W=215n
Mmp2 GNbb GNbp VDD VDD g45p1svt M=1 L=45n W=215n
Mmp16 net270 qint VDD VDD g45p1svt M=1 L=45n W=215n
Mmp15 net270 RN VDD VDD g45p1svt M=1 L=45n W=215n
Mmp20 qbint qint VDD VDD g45p1svt M=1 L=45n W=1.56u
Mmp1 GNbb RN VDD VDD g45p1svt M=1 L=45n W=215n
Mmp11 qint n5 VDD VDD g45p1svt M=1 L=45n W=620n
.ENDS

.SUBCKT TLATNSRX2 D GN Q QN RN SN VDD VSS
Mmn5 net366 D VSS VSS g45n1svt M=1 L=45n W=145n
Mmn6 n5 GNb net366 VSS g45n1svt M=1 L=45n W=145n
Mmn17 n5 GNbb net354 VSS g45n1svt M=1 L=45n W=145n
Mmn16 net354 qint net350 VSS g45n1svt M=1 L=45n W=145n
Mmn15 net350 RN VSS VSS g45n1svt M=1 L=45n W=145n
Mmn11 qint n5 net342 VSS g45n1svt M=1 L=45n W=205n
Mmn10 net342 SN VSS VSS g45n1svt M=1 L=45n W=205n
Mmn21 Q qbint VSS VSS g45n1svt M=1 L=45n W=520n
Mmn0 GNbp GN VSS VSS g45n1svt M=1 L=45n W=145n
Mmn2 GNbb GNbp net326 VSS g45n1svt M=1 L=45n W=145n
Mmn1 net326 RN VSS VSS g45n1svt M=1 L=45n W=145n
Mmn3 GNb GNbb VSS VSS g45n1svt M=1 L=45n W=145n
Mmn20 qbint qint VSS VSS g45n1svt M=1 L=45n W=520n
Mmn22 QN qint VSS VSS g45n1svt M=1 L=45n W=520n
Mmp6 n5 GNbb net313 VDD g45p1svt M=1 L=45n W=215n
Mmp5 net313 D VDD VDD g45p1svt M=1 L=45n W=215n
Mmp10 qint SN VDD VDD g45p1svt M=1 L=45n W=310n
Mmp22 QN qint VDD VDD g45p1svt M=1 L=45n W=780n
Mmp21 Q qbint VDD VDD g45p1svt M=1 L=45n W=780n
Mmp0 GNbp GN VDD VDD g45p1svt M=1 L=45n W=215n
Mmp3 GNb GNbb VDD VDD g45p1svt M=1 L=45n W=215n
Mmp17 n5 GNb net270 VDD g45p1svt M=1 L=45n W=215n
Mmp2 GNbb GNbp VDD VDD g45p1svt M=1 L=45n W=215n
Mmp16 net270 qint VDD VDD g45p1svt M=1 L=45n W=215n
Mmp15 net270 RN VDD VDD g45p1svt M=1 L=45n W=215n
Mmp20 qbint qint VDD VDD g45p1svt M=1 L=45n W=780n
Mmp1 GNbb RN VDD VDD g45p1svt M=1 L=45n W=215n
Mmp11 qint n5 VDD VDD g45p1svt M=1 L=45n W=310n
.ENDS

.SUBCKT TLATNSRX1 D GN Q QN RN SN VDD VSS
Mmn5 net366 D VSS VSS g45n1svt M=1 L=45n W=145n
Mmn6 n5 GNb net366 VSS g45n1svt M=1 L=45n W=145n
Mmn17 n5 GNbb net354 VSS g45n1svt M=1 L=45n W=145n
Mmn16 net354 qint net350 VSS g45n1svt M=1 L=45n W=145n
Mmn15 net350 RN VSS VSS g45n1svt M=1 L=45n W=145n
Mmn11 qint n5 net342 VSS g45n1svt M=1 L=45n W=145n
Mmn10 net342 SN VSS VSS g45n1svt M=1 L=45n W=145n
Mmn21 Q qbint VSS VSS g45n1svt M=1 L=45n W=260n
Mmn0 GNbp GN VSS VSS g45n1svt M=1 L=45n W=145n
Mmn2 GNbb GNbp net326 VSS g45n1svt M=1 L=45n W=145n
Mmn1 net326 RN VSS VSS g45n1svt M=1 L=45n W=145n
Mmn3 GNb GNbb VSS VSS g45n1svt M=1 L=45n W=145n
Mmn20 qbint qint VSS VSS g45n1svt M=1 L=45n W=260n
Mmn22 QN qint VSS VSS g45n1svt M=1 L=45n W=260n
Mmp6 n5 GNbb net313 VDD g45p1svt M=1 L=45n W=215n
Mmp5 net313 D VDD VDD g45p1svt M=1 L=45n W=215n
Mmp10 qint SN VDD VDD g45p1svt M=1 L=45n W=215n
Mmp22 QN qint VDD VDD g45p1svt M=1 L=45n W=390n
Mmp21 Q qbint VDD VDD g45p1svt M=1 L=45n W=390n
Mmp0 GNbp GN VDD VDD g45p1svt M=1 L=45n W=215n
Mmp3 GNb GNbb VDD VDD g45p1svt M=1 L=45n W=215n
Mmp17 n5 GNb net270 VDD g45p1svt M=1 L=45n W=215n
Mmp2 GNbb GNbp VDD VDD g45p1svt M=1 L=45n W=215n
Mmp16 net270 qint VDD VDD g45p1svt M=1 L=45n W=215n
Mmp15 net270 RN VDD VDD g45p1svt M=1 L=45n W=215n
Mmp20 qbint qint VDD VDD g45p1svt M=1 L=45n W=390n
Mmp1 GNbb RN VDD VDD g45p1svt M=1 L=45n W=215n
Mmp11 qint n5 VDD VDD g45p1svt M=1 L=45n W=215n
.ENDS

.SUBCKT TLATNCAX8 CK E ECK VDD VSS
Mmn5 net254 E VSS VSS g45n1svt M=1 L=45n W=145n
Mmn6 n0 CKb net254 VSS g45n1svt M=1 L=45n W=145n
Mmn22 ECK ECKb VSS VSS g45n1svt M=1 L=45n W=2.065u
Mmn21 ECKb CKbb net238 VSS g45n1svt M=1 L=45n W=520n
Mmn20 net238 Eint VSS VSS g45n1svt M=1 L=45n W=520n
Mmn16 n0 CKbb net230 VSS g45n1svt M=1 L=45n W=145n
Mmn15 net230 Eint VSS VSS g45n1svt M=1 L=45n W=145n
Mmn0 CKb CK VSS VSS g45n1svt M=1 L=45n W=145n
Mmn10 Eint n0 VSS VSS g45n1svt M=1 L=45n W=205n
Mmn1 CKbb CKb VSS VSS g45n1svt M=1 L=45n W=145n
Mmp6 n0 CKbb net217 VDD g45p1svt M=1 L=45n W=215n
Mmp5 net217 E VDD VDD g45p1svt M=1 L=45n W=215n
Mmp22 ECK ECKb VDD VDD g45p1svt M=1 L=45n W=3.115u
Mmp16 n0 CKb net205 VDD g45p1svt M=1 L=45n W=215n
Mmp15 net205 Eint VDD VDD g45p1svt M=1 L=45n W=215n
Mmp0 CKb CK VDD VDD g45p1svt M=1 L=45n W=215n
Mmp1 CKbb CKb VDD VDD g45p1svt M=1 L=45n W=215n
Mmp20 ECKb Eint VDD VDD g45p1svt M=1 L=45n W=780n
Mmp21 ECKb CKbb VDD VDD g45p1svt M=1 L=45n W=780n
Mmp10 Eint n0 VDD VDD g45p1svt M=1 L=45n W=310n
.ENDS

.SUBCKT TLATNCAX6 CK E ECK VDD VSS
Mmn5 net254 E VSS VSS g45n1svt M=1 L=45n W=145n
Mmn6 n0 CKb net254 VSS g45n1svt M=1 L=45n W=145n
Mmn22 ECK ECKb VSS VSS g45n1svt M=1 L=45n W=1.55u
Mmn21 ECKb CKbb net238 VSS g45n1svt M=1 L=45n W=520n
Mmn20 net238 Eint VSS VSS g45n1svt M=1 L=45n W=520n
Mmn16 n0 CKbb net230 VSS g45n1svt M=1 L=45n W=145n
Mmn15 net230 Eint VSS VSS g45n1svt M=1 L=45n W=145n
Mmn0 CKb CK VSS VSS g45n1svt M=1 L=45n W=145n
Mmn10 Eint n0 VSS VSS g45n1svt M=1 L=45n W=205n
Mmn1 CKbb CKb VSS VSS g45n1svt M=1 L=45n W=145n
Mmp6 n0 CKbb net217 VDD g45p1svt M=1 L=45n W=215n
Mmp5 net217 E VDD VDD g45p1svt M=1 L=45n W=215n
Mmp22 ECK ECKb VDD VDD g45p1svt M=1 L=45n W=2.35u
Mmp16 n0 CKb net205 VDD g45p1svt M=1 L=45n W=215n
Mmp15 net205 Eint VDD VDD g45p1svt M=1 L=45n W=215n
Mmp0 CKb CK VDD VDD g45p1svt M=1 L=45n W=215n
Mmp1 CKbb CKb VDD VDD g45p1svt M=1 L=45n W=215n
Mmp20 ECKb Eint VDD VDD g45p1svt M=1 L=45n W=780n
Mmp21 ECKb CKbb VDD VDD g45p1svt M=1 L=45n W=780n
Mmp10 Eint n0 VDD VDD g45p1svt M=1 L=45n W=310n
.ENDS

.SUBCKT TLATNCAX4 CK E ECK VDD VSS
Mmn5 net254 E VSS VSS g45n1svt M=1 L=45n W=145n
Mmn6 n0 CKb net254 VSS g45n1svt M=1 L=45n W=145n
Mmn22 ECK ECKb VSS VSS g45n1svt M=1 L=45n W=1.04u
Mmn21 ECKb CKbb net238 VSS g45n1svt M=1 L=45n W=260n
Mmn20 net238 Eint VSS VSS g45n1svt M=1 L=45n W=260n
Mmn16 n0 CKbb net230 VSS g45n1svt M=1 L=45n W=145n
Mmn15 net230 Eint VSS VSS g45n1svt M=1 L=45n W=145n
Mmn0 CKb CK VSS VSS g45n1svt M=1 L=45n W=145n
Mmn10 Eint n0 VSS VSS g45n1svt M=1 L=45n W=145n
Mmn1 CKbb CKb VSS VSS g45n1svt M=1 L=45n W=145n
Mmp6 n0 CKbb net217 VDD g45p1svt M=1 L=45n W=215n
Mmp5 net217 E VDD VDD g45p1svt M=1 L=45n W=215n
Mmp22 ECK ECKb VDD VDD g45p1svt M=1 L=45n W=1.56u
Mmp16 n0 CKb net205 VDD g45p1svt M=1 L=45n W=215n
Mmp15 net205 Eint VDD VDD g45p1svt M=1 L=45n W=215n
Mmp0 CKb CK VDD VDD g45p1svt M=1 L=45n W=215n
Mmp1 CKbb CKb VDD VDD g45p1svt M=1 L=45n W=215n
Mmp20 ECKb Eint VDD VDD g45p1svt M=1 L=45n W=390n
Mmp21 ECKb CKbb VDD VDD g45p1svt M=1 L=45n W=390n
Mmp10 Eint n0 VDD VDD g45p1svt M=1 L=45n W=215n
.ENDS

.SUBCKT TLATNCAX3 CK E ECK VDD VSS
Mmn5 net254 E VSS VSS g45n1svt M=1 L=45n W=145n
Mmn6 n0 CKb net254 VSS g45n1svt M=1 L=45n W=145n
Mmn22 ECK ECKb VSS VSS g45n1svt M=1 L=45n W=780n
Mmn21 ECKb CKbb net238 VSS g45n1svt M=1 L=45n W=260n
Mmn20 net238 Eint VSS VSS g45n1svt M=1 L=45n W=260n
Mmn16 n0 CKbb net230 VSS g45n1svt M=1 L=45n W=145n
Mmn15 net230 Eint VSS VSS g45n1svt M=1 L=45n W=145n
Mmn0 CKb CK VSS VSS g45n1svt M=1 L=45n W=145n
Mmn10 Eint n0 VSS VSS g45n1svt M=1 L=45n W=145n
Mmn1 CKbb CKb VSS VSS g45n1svt M=1 L=45n W=145n
Mmp6 n0 CKbb net217 VDD g45p1svt M=1 L=45n W=215n
Mmp5 net217 E VDD VDD g45p1svt M=1 L=45n W=215n
Mmp22 ECK ECKb VDD VDD g45p1svt M=1 L=45n W=1.17u
Mmp16 n0 CKb net205 VDD g45p1svt M=1 L=45n W=215n
Mmp15 net205 Eint VDD VDD g45p1svt M=1 L=45n W=215n
Mmp0 CKb CK VDD VDD g45p1svt M=1 L=45n W=215n
Mmp1 CKbb CKb VDD VDD g45p1svt M=1 L=45n W=215n
Mmp20 ECKb Eint VDD VDD g45p1svt M=1 L=45n W=390n
Mmp21 ECKb CKbb VDD VDD g45p1svt M=1 L=45n W=390n
Mmp10 Eint n0 VDD VDD g45p1svt M=1 L=45n W=215n
.ENDS

.SUBCKT TLATNCAX2 CK E ECK VDD VSS
Mmn5 net254 E VSS VSS g45n1svt M=1 L=45n W=145n
Mmn6 n0 CKb net254 VSS g45n1svt M=1 L=45n W=145n
Mmn22 ECK ECKb VSS VSS g45n1svt M=1 L=45n W=520n
Mmn21 ECKb CKbb net238 VSS g45n1svt M=1 L=45n W=145n
Mmn20 net238 Eint VSS VSS g45n1svt M=1 L=45n W=145n
Mmn16 n0 CKbb net230 VSS g45n1svt M=1 L=45n W=145n
Mmn15 net230 Eint VSS VSS g45n1svt M=1 L=45n W=145n
Mmn0 CKb CK VSS VSS g45n1svt M=1 L=45n W=145n
Mmn10 Eint n0 VSS VSS g45n1svt M=1 L=45n W=145n
Mmn1 CKbb CKb VSS VSS g45n1svt M=1 L=45n W=145n
Mmp6 n0 CKbb net217 VDD g45p1svt M=1 L=45n W=215n
Mmp5 net217 E VDD VDD g45p1svt M=1 L=45n W=215n
Mmp22 ECK ECKb VDD VDD g45p1svt M=1 L=45n W=780n
Mmp16 n0 CKb net205 VDD g45p1svt M=1 L=45n W=215n
Mmp15 net205 Eint VDD VDD g45p1svt M=1 L=45n W=215n
Mmp0 CKb CK VDD VDD g45p1svt M=1 L=45n W=215n
Mmp1 CKbb CKb VDD VDD g45p1svt M=1 L=45n W=215n
Mmp20 ECKb Eint VDD VDD g45p1svt M=1 L=45n W=215n
Mmp21 ECKb CKbb VDD VDD g45p1svt M=1 L=45n W=215n
Mmp10 Eint n0 VDD VDD g45p1svt M=1 L=45n W=215n
.ENDS

.SUBCKT TLATNCAX20 CK E ECK VDD VSS
Mmn5 net254 E VSS VSS g45n1svt M=1 L=45n W=145n
Mmn6 n0 CKb net254 VSS g45n1svt M=1 L=45n W=145n
Mmn22 ECK ECKb VSS VSS g45n1svt M=1 L=45n W=5.185u
Mmn21 ECKb CKbb net238 VSS g45n1svt M=1 L=45n W=1.3u
Mmn20 net238 Eint VSS VSS g45n1svt M=1 L=45n W=1.3u
Mmn16 n0 CKbb net230 VSS g45n1svt M=1 L=45n W=145n
Mmn15 net230 Eint VSS VSS g45n1svt M=1 L=45n W=145n
Mmn0 CKb CK VSS VSS g45n1svt M=1 L=45n W=145n
Mmn10 Eint n0 VSS VSS g45n1svt M=1 L=45n W=520n
Mmn1 CKbb CKb VSS VSS g45n1svt M=1 L=45n W=145n
Mmp6 n0 CKbb net217 VDD g45p1svt M=1 L=45n W=215n
Mmp5 net217 E VDD VDD g45p1svt M=1 L=45n W=215n
Mmp22 ECK ECKb VDD VDD g45p1svt M=1 L=45n W=7.815u
Mmp16 n0 CKb net205 VDD g45p1svt M=1 L=45n W=215n
Mmp15 net205 Eint VDD VDD g45p1svt M=1 L=45n W=215n
Mmp0 CKb CK VDD VDD g45p1svt M=1 L=45n W=215n
Mmp1 CKbb CKb VDD VDD g45p1svt M=1 L=45n W=215n
Mmp20 ECKb Eint VDD VDD g45p1svt M=1 L=45n W=1.95u
Mmp21 ECKb CKbb VDD VDD g45p1svt M=1 L=45n W=1.95u
Mmp10 Eint n0 VDD VDD g45p1svt M=1 L=45n W=780n
.ENDS

.SUBCKT TLATNCAX16 CK E ECK VDD VSS
Mmn5 net254 E VSS VSS g45n1svt M=1 L=45n W=145n
Mmn6 n0 CKb net254 VSS g45n1svt M=1 L=45n W=145n
Mmn22 ECK ECKb VSS VSS g45n1svt M=1 L=45n W=4.13u
Mmn21 ECKb CKbb net238 VSS g45n1svt M=1 L=45n W=1.04u
Mmn20 net238 Eint VSS VSS g45n1svt M=1 L=45n W=1.04u
Mmn16 n0 CKbb net230 VSS g45n1svt M=1 L=45n W=145n
Mmn15 net230 Eint VSS VSS g45n1svt M=1 L=45n W=145n
Mmn0 CKb CK VSS VSS g45n1svt M=1 L=45n W=145n
Mmn10 Eint n0 VSS VSS g45n1svt M=1 L=45n W=410n
Mmn1 CKbb CKb VSS VSS g45n1svt M=1 L=45n W=145n
Mmp6 n0 CKbb net217 VDD g45p1svt M=1 L=45n W=215n
Mmp5 net217 E VDD VDD g45p1svt M=1 L=45n W=215n
Mmp22 ECK ECKb VDD VDD g45p1svt M=1 L=45n W=6.23u
Mmp16 n0 CKb net205 VDD g45p1svt M=1 L=45n W=215n
Mmp15 net205 Eint VDD VDD g45p1svt M=1 L=45n W=215n
Mmp0 CKb CK VDD VDD g45p1svt M=1 L=45n W=215n
Mmp1 CKbb CKb VDD VDD g45p1svt M=1 L=45n W=215n
Mmp20 ECKb Eint VDD VDD g45p1svt M=1 L=45n W=1.56u
Mmp21 ECKb CKbb VDD VDD g45p1svt M=1 L=45n W=1.56u
Mmp10 Eint n0 VDD VDD g45p1svt M=1 L=45n W=620n
.ENDS

.SUBCKT TLATNCAX12 CK E ECK VDD VSS
Mmn5 net254 E VSS VSS g45n1svt M=1 L=45n W=145n
Mmn6 n0 CKb net254 VSS g45n1svt M=1 L=45n W=145n
Mmn22 ECK ECKb VSS VSS g45n1svt M=1 L=45n W=3.1u
Mmn21 ECKb CKbb net238 VSS g45n1svt M=1 L=45n W=780n
Mmn20 net238 Eint VSS VSS g45n1svt M=1 L=45n W=780n
Mmn16 n0 CKbb net230 VSS g45n1svt M=1 L=45n W=145n
Mmn15 net230 Eint VSS VSS g45n1svt M=1 L=45n W=145n
Mmn0 CKb CK VSS VSS g45n1svt M=1 L=45n W=145n
Mmn10 Eint n0 VSS VSS g45n1svt M=1 L=45n W=260n
Mmn1 CKbb CKb VSS VSS g45n1svt M=1 L=45n W=145n
Mmp6 n0 CKbb net217 VDD g45p1svt M=1 L=45n W=215n
Mmp5 net217 E VDD VDD g45p1svt M=1 L=45n W=215n
Mmp22 ECK ECKb VDD VDD g45p1svt M=1 L=45n W=4.7u
Mmp16 n0 CKb net205 VDD g45p1svt M=1 L=45n W=215n
Mmp15 net205 Eint VDD VDD g45p1svt M=1 L=45n W=215n
Mmp0 CKb CK VDD VDD g45p1svt M=1 L=45n W=215n
Mmp1 CKbb CKb VDD VDD g45p1svt M=1 L=45n W=215n
Mmp20 ECKb Eint VDD VDD g45p1svt M=1 L=45n W=1.17u
Mmp21 ECKb CKbb VDD VDD g45p1svt M=1 L=45n W=1.17u
Mmp10 Eint n0 VDD VDD g45p1svt M=1 L=45n W=390n
.ENDS

.SUBCKT TIELO VDD VSS Y
Mmp0 net25 net25 VDD VDD g45p1svt M=1 L=45n W=390n
Mmn0 Y net25 VSS VSS g45n1svt M=1 L=45n W=260n
.ENDS

.SUBCKT TIEHI VDD VSS Y
Mmp0 Y net25 VDD VDD g45p1svt M=1 L=45n W=390n
Mmn0 net25 net25 VSS VSS g45n1svt M=1 L=45n W=260n
.ENDS

.SUBCKT TBUFXL A OE VDD VSS Y
Mmn5 Y non VSS VSS g45n1svt M=1 L=45n W=145n
Mmn3 net144 A VSS VSS g45n1svt M=1 L=45n W=145n
Mmn0 OEb OE VSS VSS g45n1svt M=1 L=45n W=145n
Mmn4 pon OE net144 VSS g45n1svt M=1 L=45n W=145n
Mmn2 non OEb VSS VSS g45n1svt M=1 L=45n W=145n
Mmn1 non A VSS VSS g45n1svt M=1 L=45n W=145n
Mmp2 non OEb net127 VDD g45p1svt M=1 L=45n W=215n
Mmp1 net127 A VDD VDD g45p1svt M=1 L=45n W=215n
Mmp5 Y pon VDD VDD g45p1svt M=1 L=45n W=215n
Mmp3 pon A VDD VDD g45p1svt M=1 L=45n W=215n
Mmp4 pon OE VDD VDD g45p1svt M=1 L=45n W=215n
Mmp0 OEb OE VDD VDD g45p1svt M=1 L=45n W=215n
.ENDS

.SUBCKT TBUFX8 A OE VDD VSS Y
Mmn5 Y non VSS VSS g45n1svt M=1 L=45n W=2.08u
Mmn3 net144 A VSS VSS g45n1svt M=1 L=45n W=515n
Mmn0 OEb OE VSS VSS g45n1svt M=1 L=45n W=145n
Mmn4 pon OE net144 VSS g45n1svt M=1 L=45n W=515n
Mmn2 non OEb VSS VSS g45n1svt M=1 L=45n W=515n
Mmn1 non A VSS VSS g45n1svt M=1 L=45n W=515n
Mmp2 non OEb net127 VDD g45p1svt M=1 L=45n W=780n
Mmp1 net127 A VDD VDD g45p1svt M=1 L=45n W=780n
Mmp5 Y pon VDD VDD g45p1svt M=1 L=45n W=3.12u
Mmp3 pon A VDD VDD g45p1svt M=1 L=45n W=780n
Mmp4 pon OE VDD VDD g45p1svt M=1 L=45n W=780n
Mmp0 OEb OE VDD VDD g45p1svt M=1 L=45n W=215n
.ENDS

.SUBCKT TBUFX6 A OE VDD VSS Y
Mmn5 Y non VSS VSS g45n1svt M=1 L=45n W=1.56u
Mmn3 net144 A VSS VSS g45n1svt M=1 L=45n W=515n
Mmn0 OEb OE VSS VSS g45n1svt M=1 L=45n W=145n
Mmn4 pon OE net144 VSS g45n1svt M=1 L=45n W=515n
Mmn2 non OEb VSS VSS g45n1svt M=1 L=45n W=515n
Mmn1 non A VSS VSS g45n1svt M=1 L=45n W=515n
Mmp2 non OEb net127 VDD g45p1svt M=1 L=45n W=780n
Mmp1 net127 A VDD VDD g45p1svt M=1 L=45n W=780n
Mmp5 Y pon VDD VDD g45p1svt M=1 L=45n W=2.34u
Mmp3 pon A VDD VDD g45p1svt M=1 L=45n W=780n
Mmp4 pon OE VDD VDD g45p1svt M=1 L=45n W=780n
Mmp0 OEb OE VDD VDD g45p1svt M=1 L=45n W=215n
.ENDS

.SUBCKT TBUFX4 A OE VDD VSS Y
Mmn5 Y non VSS VSS g45n1svt M=1 L=45n W=1.04u
Mmn3 net144 A VSS VSS g45n1svt M=1 L=45n W=260n
Mmn0 OEb OE VSS VSS g45n1svt M=1 L=45n W=145n
Mmn4 pon OE net144 VSS g45n1svt M=1 L=45n W=260n
Mmn2 non OEb VSS VSS g45n1svt M=1 L=45n W=260n
Mmn1 non A VSS VSS g45n1svt M=1 L=45n W=260n
Mmp2 non OEb net127 VDD g45p1svt M=1 L=45n W=390n
Mmp1 net127 A VDD VDD g45p1svt M=1 L=45n W=390n
Mmp5 Y pon VDD VDD g45p1svt M=1 L=45n W=1.56u
Mmp3 pon A VDD VDD g45p1svt M=1 L=45n W=390n
Mmp4 pon OE VDD VDD g45p1svt M=1 L=45n W=390n
Mmp0 OEb OE VDD VDD g45p1svt M=1 L=45n W=215n
.ENDS

.SUBCKT TBUFX3 A OE VDD VSS Y
Mmn5 Y non VSS VSS g45n1svt M=1 L=45n W=780n
Mmn3 net144 A VSS VSS g45n1svt M=1 L=45n W=260n
Mmn0 OEb OE VSS VSS g45n1svt M=1 L=45n W=145n
Mmn4 pon OE net144 VSS g45n1svt M=1 L=45n W=260n
Mmn2 non OEb VSS VSS g45n1svt M=1 L=45n W=260n
Mmn1 non A VSS VSS g45n1svt M=1 L=45n W=260n
Mmp2 non OEb net127 VDD g45p1svt M=1 L=45n W=390n
Mmp1 net127 A VDD VDD g45p1svt M=1 L=45n W=390n
Mmp5 Y pon VDD VDD g45p1svt M=1 L=45n W=1.17u
Mmp3 pon A VDD VDD g45p1svt M=1 L=45n W=390n
Mmp4 pon OE VDD VDD g45p1svt M=1 L=45n W=390n
Mmp0 OEb OE VDD VDD g45p1svt M=1 L=45n W=215n
.ENDS

.SUBCKT TBUFX2 A OE VDD VSS Y
Mmn5 Y non VSS VSS g45n1svt M=1 L=45n W=520n
Mmn3 net144 A VSS VSS g45n1svt M=1 L=45n W=145n
Mmn0 OEb OE VSS VSS g45n1svt M=1 L=45n W=145n
Mmn4 pon OE net144 VSS g45n1svt M=1 L=45n W=145n
Mmn2 non OEb VSS VSS g45n1svt M=1 L=45n W=145n
Mmn1 non A VSS VSS g45n1svt M=1 L=45n W=145n
Mmp2 non OEb net127 VDD g45p1svt M=1 L=45n W=215n
Mmp1 net127 A VDD VDD g45p1svt M=1 L=45n W=215n
Mmp5 Y pon VDD VDD g45p1svt M=1 L=45n W=780n
Mmp3 pon A VDD VDD g45p1svt M=1 L=45n W=215n
Mmp4 pon OE VDD VDD g45p1svt M=1 L=45n W=215n
Mmp0 OEb OE VDD VDD g45p1svt M=1 L=45n W=215n
.ENDS

.SUBCKT TBUFX20 A OE VDD VSS Y
Mmn5 Y non VSS VSS g45n1svt M=1 L=45n W=5.2u
Mmn3 net144 A VSS VSS g45n1svt M=1 L=45n W=1.29u
Mmn0 OEb OE VSS VSS g45n1svt M=1 L=45n W=520n
Mmn4 pon OE net144 VSS g45n1svt M=1 L=45n W=1.29u
Mmn2 non OEb VSS VSS g45n1svt M=1 L=45n W=1.29u
Mmn1 non A VSS VSS g45n1svt M=1 L=45n W=1.29u
Mmp2 non OEb net127 VDD g45p1svt M=1 L=45n W=1.95u
Mmp1 net127 A VDD VDD g45p1svt M=1 L=45n W=1.95u
Mmp5 Y pon VDD VDD g45p1svt M=1 L=45n W=7.8u
Mmp3 pon A VDD VDD g45p1svt M=1 L=45n W=1.95u
Mmp4 pon OE VDD VDD g45p1svt M=1 L=45n W=1.95u
Mmp0 OEb OE VDD VDD g45p1svt M=1 L=45n W=780n
.ENDS

.SUBCKT TBUFX1 A OE VDD VSS Y
Mmn5 Y non VSS VSS g45n1svt M=1 L=45n W=260n
Mmn3 net144 A VSS VSS g45n1svt M=1 L=45n W=145n
Mmn0 OEb OE VSS VSS g45n1svt M=1 L=45n W=145n
Mmn4 pon OE net144 VSS g45n1svt M=1 L=45n W=145n
Mmn2 non OEb VSS VSS g45n1svt M=1 L=45n W=145n
Mmn1 non A VSS VSS g45n1svt M=1 L=45n W=145n
Mmp2 non OEb net127 VDD g45p1svt M=1 L=45n W=215n
Mmp1 net127 A VDD VDD g45p1svt M=1 L=45n W=215n
Mmp5 Y pon VDD VDD g45p1svt M=1 L=45n W=390n
Mmp3 pon A VDD VDD g45p1svt M=1 L=45n W=215n
Mmp4 pon OE VDD VDD g45p1svt M=1 L=45n W=215n
Mmp0 OEb OE VDD VDD g45p1svt M=1 L=45n W=215n
.ENDS

.SUBCKT TBUFX16 A OE VDD VSS Y
Mmn5 Y non VSS VSS g45n1svt M=1 L=45n W=4.16u
Mmn3 net144 A VSS VSS g45n1svt M=1 L=45n W=1.025u
Mmn0 OEb OE VSS VSS g45n1svt M=1 L=45n W=260n
Mmn4 pon OE net144 VSS g45n1svt M=1 L=45n W=1.025u
Mmn2 non OEb VSS VSS g45n1svt M=1 L=45n W=1.025u
Mmn1 non A VSS VSS g45n1svt M=1 L=45n W=1.025u
Mmp2 non OEb net127 VDD g45p1svt M=1 L=45n W=1.55u
Mmp1 net127 A VDD VDD g45p1svt M=1 L=45n W=1.55u
Mmp5 Y pon VDD VDD g45p1svt M=1 L=45n W=6.24u
Mmp3 pon A VDD VDD g45p1svt M=1 L=45n W=1.55u
Mmp4 pon OE VDD VDD g45p1svt M=1 L=45n W=1.55u
Mmp0 OEb OE VDD VDD g45p1svt M=1 L=45n W=390n
.ENDS

.SUBCKT TBUFX12 A OE VDD VSS Y
Mmn5 Y non VSS VSS g45n1svt M=1 L=45n W=3.12u
Mmn3 net144 A VSS VSS g45n1svt M=1 L=45n W=770n
Mmn0 OEb OE VSS VSS g45n1svt M=1 L=45n W=260n
Mmn4 pon OE net144 VSS g45n1svt M=1 L=45n W=770n
Mmn2 non OEb VSS VSS g45n1svt M=1 L=45n W=770n
Mmn1 non A VSS VSS g45n1svt M=1 L=45n W=770n
Mmp2 non OEb net127 VDD g45p1svt M=1 L=45n W=1.17u
Mmp1 net127 A VDD VDD g45p1svt M=1 L=45n W=1.17u
Mmp5 Y pon VDD VDD g45p1svt M=1 L=45n W=4.68u
Mmp3 pon A VDD VDD g45p1svt M=1 L=45n W=1.17u
Mmp4 pon OE VDD VDD g45p1svt M=1 L=45n W=1.17u
Mmp0 OEb OE VDD VDD g45p1svt M=1 L=45n W=390n
.ENDS

.SUBCKT SRDFFX1 CK D ExtVDD Q QN RT SE SI VDD VSS
MNM3 net0134 qbint VSS VSS g45n1svt M=1 L=45n W=145n
MNM2 n35g RT net0134 VSS g45n1svt M=1 L=45n W=145n
MNM1 RTb RT VSS VSS g45n1svt M=1 L=45n W=145n
MNM0 n35g RTb n35 VSS g45n1svt M=1 L=45n W=145n
Mmn13 n2 SI VSS VSS g45n1svt M=1 L=45n W=145n
Mmn14 Db SE n2 VSS g45n1svt M=1 L=45n W=145n
Mmn12 Db SEb n0 VSS g45n1svt M=1 L=45n W=145n
Mmn11 n0 D VSS VSS g45n1svt M=1 L=45n W=145n
Mmn57 QN net573 VSS VSS g45n1svt M=1 L=45n W=260n
Mmn55 Q qbint VSS VSS g45n1svt M=1 L=45n W=260n
Mmn35 n6 mout VSS VSS g45n1svt M=1 L=45n W=145n
Mmn36 n20 CKbb n6 VSS g45n1svt M=1 L=45n W=145n
Mmn20 CKb CK VSS VSS g45n1svt M=1 L=45n W=145n
Mmn10 SEb SE VSS VSS g45n1svt M=1 L=45n W=145n
Mmn56 net573 qbint VSS VSS g45n1svt M=1 L=45n W=145n
Mmn25 Db CKb n20 VSS g45n1svt M=1 L=45n W=145n
Mmn32 mout n20 VSS VSS g45n1svt M=1 L=45n W=145n
Mmn53 n35 CKb net0118 VSS g45n1svt M=1 L=45n W=145n
Mmn40 n35 CKbb mout VSS g45n1svt M=1 L=45n W=145n
Mmn21 CKbb CKb VSS VSS g45n1svt M=1 L=45n W=145n
Mmn52 net0118 qbint VSS VSS g45n1svt M=1 L=45n W=145n
Mmn45 qbint n35g VSS VSS g45n1svt M=1 L=45n W=145n
MPM3 n35g RTb net234 ExtVDD g45p1svt M=1 L=45n W=215n
MPM2 net234 qbint ExtVDD ExtVDD g45p1svt M=1 L=45n W=215n
MPM1 RTb RT ExtVDD ExtVDD g45p1svt M=1 L=45n W=215n
MPM0 n35g RT n35 ExtVDD g45p1svt M=1 L=45n W=215n
Mmp14 Db SEb n3 VDD g45p1svt M=1 L=45n W=215n
Mmp13 n3 SI VDD VDD g45p1svt M=1 L=45n W=215n
Mmp12 Db SE n1 VDD g45p1svt M=1 L=45n W=215n
Mmp11 n1 D VDD VDD g45p1svt M=1 L=45n W=215n
Mmp52 net0110 qbint VDD VDD g45p1svt M=1 L=45n W=215n
Mmp57 QN net573 VDD VDD g45p1svt M=1 L=45n W=390n
Mmp55 Q qbint VDD VDD g45p1svt M=1 L=45n W=390n
Mmp36 n20 CKb n7 VDD g45p1svt M=1 L=45n W=215n
Mmp35 n7 mout VDD VDD g45p1svt M=1 L=45n W=215n
Mmp32 mout n20 VDD VDD g45p1svt M=1 L=45n W=215n
Mmp20 CKb CK VDD VDD g45p1svt M=1 L=45n W=215n
Mmp21 CKbb CKb VDD VDD g45p1svt M=1 L=45n W=215n
Mmp45 qbint n35g ExtVDD ExtVDD g45p1svt M=1 L=45n W=215n
Mmp25 n20 CKbb Db VDD g45p1svt M=1 L=45n W=215n
Mmp56 net573 qbint VDD VDD g45p1svt M=1 L=45n W=215n
Mmp40 n35 CKb mout VDD g45p1svt M=1 L=45n W=215n
Mmp53 n35 CKbb net0110 VDD g45p1svt M=1 L=45n W=215n
Mmp10 SEb SE VDD VDD g45p1svt M=1 L=45n W=215n
.ENDS

.SUBCKT SRDFFSX1 CK D ExtVDD Q QN RT SE SI SN VDD VSS
MNM3 net0134 qbint VSS VSS g45n1svt M=1 L=45n W=145n
MNM2 n35g RT net0134 VSS g45n1svt M=1 L=45n W=145n
MNM1 RTb RT VSS VSS g45n1svt M=1 L=45n W=145n
MNM0 n35g RTb n35 VSS g45n1svt M=1 L=45n W=145n
Mmn13 n2 SI VSS VSS g45n1svt M=1 L=45n W=145n
Mmn14 Db SE n2 VSS g45n1svt M=1 L=45n W=145n
Mmn12 Db SEb n0 VSS g45n1svt M=1 L=45n W=145n
Mmn11 n0 D VSS VSS g45n1svt M=1 L=45n W=145n
Mmn57 QN net573 VSS VSS g45n1svt M=1 L=45n W=260n
Mmn55 Q qbint VSS VSS g45n1svt M=1 L=45n W=260n
Mmn35 n6 mout VSS VSS g45n1svt M=1 L=45n W=145n
Mmn36 n20 CKbb n6 VSS g45n1svt M=1 L=45n W=145n
Mmn20 CKb CK VSS VSS g45n1svt M=1 L=45n W=145n
Mmn10 SEb SE VSS VSS g45n1svt M=1 L=45n W=145n
Mmn56 net573 qbint VSS VSS g45n1svt M=1 L=45n W=145n
Mmn25 Db CKb n20 VSS g45n1svt M=1 L=45n W=145n
Mmn32 mout n20 net0119 VSS g45n1svt M=1 L=45n W=145n
Mmn53 n35 CKb net0118 VSS g45n1svt M=1 L=45n W=145n
Mmn30 net0119 SN VSS VSS g45n1svt M=1 L=45n W=145n
Mmn50 net0116 SN VSS VSS g45n1svt M=1 L=45n W=145n
Mmn40 n35 CKbb mout VSS g45n1svt M=1 L=45n W=145n
Mmn21 CKbb CKb VSS VSS g45n1svt M=1 L=45n W=145n
Mmn52 net0118 qbint net0116 VSS g45n1svt M=1 L=45n W=145n
Mmn45 qbint n35g VSS VSS g45n1svt M=1 L=45n W=145n
MPM3 n35g RTb net234 ExtVDD g45p1svt M=1 L=45n W=215n
MPM2 net234 qbint ExtVDD ExtVDD g45p1svt M=1 L=45n W=215n
MPM1 RTb RT ExtVDD ExtVDD g45p1svt M=1 L=45n W=215n
MPM0 n35g RT n35 ExtVDD g45p1svt M=1 L=45n W=215n
Mmp14 Db SEb n3 VDD g45p1svt M=1 L=45n W=215n
Mmp13 n3 SI VDD VDD g45p1svt M=1 L=45n W=215n
Mmp12 Db SE n1 VDD g45p1svt M=1 L=45n W=215n
Mmp11 n1 D VDD VDD g45p1svt M=1 L=45n W=215n
Mmp52 n11 qbint VDD VDD g45p1svt M=1 L=45n W=215n
Mmp57 QN net573 VDD VDD g45p1svt M=1 L=45n W=390n
Mmp55 Q qbint VDD VDD g45p1svt M=1 L=45n W=390n
Mmp36 n20 CKb n7 VDD g45p1svt M=1 L=45n W=215n
Mmp35 n7 mout VDD VDD g45p1svt M=1 L=45n W=215n
Mmp32 mout n20 VDD VDD g45p1svt M=1 L=45n W=215n
Mmp20 CKb CK VDD VDD g45p1svt M=1 L=45n W=215n
Mmp21 CKbb CKb VDD VDD g45p1svt M=1 L=45n W=215n
Mmp45 qbint n35g ExtVDD ExtVDD g45p1svt M=1 L=45n W=215n
Mmp30 mout SN VDD VDD g45p1svt M=1 L=45n W=215n
Mmp25 n20 CKbb Db VDD g45p1svt M=1 L=45n W=215n
Mmp56 net573 qbint VDD VDD g45p1svt M=1 L=45n W=215n
Mmp40 n35 CKb mout VDD g45p1svt M=1 L=45n W=215n
Mmp53 n35 CKbb n11 VDD g45p1svt M=1 L=45n W=215n
Mmp50 n11 SN VDD VDD g45p1svt M=1 L=45n W=215n
Mmp10 SEb SE VDD VDD g45p1svt M=1 L=45n W=215n
.ENDS

.SUBCKT SRDFFSRX1 CK D ExtVDD Q QN RN RT SE SI SN VDD VSS
MNM3 net0134 qbint VSS VSS g45n1svt M=1 L=45n W=145n
MNM2 n35g RT net0134 VSS g45n1svt M=1 L=45n W=145n
MNM1 RTb RT VSS VSS g45n1svt M=1 L=45n W=145n
MNM0 n35g RTb n35 VSS g45n1svt M=1 L=45n W=145n
Mmn13 n2 SI VSS VSS g45n1svt M=1 L=45n W=145n
Mmn14 Db SE n2 VSS g45n1svt M=1 L=45n W=145n
Mmn12 Db SEb n0 VSS g45n1svt M=1 L=45n W=145n
Mmn11 n0 D VSS VSS g45n1svt M=1 L=45n W=145n
Mmn57 QN net573 VSS VSS g45n1svt M=1 L=45n W=260n
Mmn55 Q qbint VSS VSS g45n1svt M=1 L=45n W=260n
Mmn35 n6 mout VSS VSS g45n1svt M=1 L=45n W=145n
Mmn36 n20 CKbb n6 VSS g45n1svt M=1 L=45n W=145n
Mmn22 RNb RN VSS VSS g45n1svt M=1 L=45n W=145n
Mmn20 CKb CK VSS VSS g45n1svt M=1 L=45n W=145n
Mmn10 SEb SE VSS VSS g45n1svt M=1 L=45n W=145n
Mmn56 net573 qbint VSS VSS g45n1svt M=1 L=45n W=145n
Mmn25 Db CKb n20 VSS g45n1svt M=1 L=45n W=145n
Mmn32 mout n20 n4 VSS g45n1svt M=1 L=45n W=145n
Mmn53 n35 CKb n10 VSS g45n1svt M=1 L=45n W=145n
Mmn30 n4 SN VSS VSS g45n1svt M=1 L=45n W=145n
Mmn50 n8 SN VSS VSS g45n1svt M=1 L=45n W=145n
Mmn51 n10 RNb n8 VSS g45n1svt M=1 L=45n W=145n
Mmn40 n35 CKbb mout VSS g45n1svt M=1 L=45n W=145n
Mmn31 mout RNb n4 VSS g45n1svt M=1 L=45n W=145n
Mmn21 CKbb CKb VSS VSS g45n1svt M=1 L=45n W=145n
Mmn52 n10 qbint n8 VSS g45n1svt M=1 L=45n W=145n
Mmn45 qbint n35g VSS VSS g45n1svt M=1 L=45n W=145n
MPM3 n35g RTb net234 ExtVDD g45p1svt M=1 L=45n W=215n
MPM2 net234 qbint ExtVDD ExtVDD g45p1svt M=1 L=45n W=215n
MPM1 RTb RT ExtVDD ExtVDD g45p1svt M=1 L=45n W=215n
MPM0 n35g RT n35 ExtVDD g45p1svt M=1 L=45n W=215n
Mmp14 Db SEb n3 VDD g45p1svt M=1 L=45n W=215n
Mmp13 n3 SI VDD VDD g45p1svt M=1 L=45n W=215n
Mmp12 Db SE n1 VDD g45p1svt M=1 L=45n W=215n
Mmp11 n1 D VDD VDD g45p1svt M=1 L=45n W=215n
Mmp52 n11 qbint n9 VDD g45p1svt M=1 L=45n W=215n
Mmp51 n9 RNb VDD VDD g45p1svt M=1 L=45n W=215n
Mmp57 QN net573 VDD VDD g45p1svt M=1 L=45n W=390n
Mmp55 Q qbint VDD VDD g45p1svt M=1 L=45n W=390n
Mmp36 n20 CKb n7 VDD g45p1svt M=1 L=45n W=215n
Mmp35 n7 mout VDD VDD g45p1svt M=1 L=45n W=215n
Mmp32 mout n20 n5 VDD g45p1svt M=1 L=45n W=215n
Mmp31 n5 RNb VDD VDD g45p1svt M=1 L=45n W=215n
Mmp22 RNb RN VDD VDD g45p1svt M=1 L=45n W=215n
Mmp20 CKb CK VDD VDD g45p1svt M=1 L=45n W=215n
Mmp21 CKbb CKb VDD VDD g45p1svt M=1 L=45n W=215n
Mmp45 qbint n35g ExtVDD ExtVDD g45p1svt M=1 L=45n W=215n
Mmp30 mout SN VDD VDD g45p1svt M=1 L=45n W=215n
Mmp25 n20 CKbb Db VDD g45p1svt M=1 L=45n W=215n
Mmp56 net573 qbint VDD VDD g45p1svt M=1 L=45n W=215n
Mmp40 n35 CKb mout VDD g45p1svt M=1 L=45n W=215n
Mmp53 n35 CKbb n11 VDD g45p1svt M=1 L=45n W=215n
Mmp50 n11 SN VDD VDD g45p1svt M=1 L=45n W=215n
Mmp10 SEb SE VDD VDD g45p1svt M=1 L=45n W=215n
.ENDS

.SUBCKT SRDFFSRQX1 CK D ExtVDD Q RN RT SE SI SN VDD VSS
MNM3 net0134 qbint VSS VSS g45n1svt M=1 L=45n W=145n
MNM2 n35g RT net0134 VSS g45n1svt M=1 L=45n W=145n
MNM1 RTb RT VSS VSS g45n1svt M=1 L=45n W=145n
MNM0 n35g RTb n35 VSS g45n1svt M=1 L=45n W=145n
Mmn13 n2 SI VSS VSS g45n1svt M=1 L=45n W=145n
Mmn14 Db SE n2 VSS g45n1svt M=1 L=45n W=145n
Mmn12 Db SEb n0 VSS g45n1svt M=1 L=45n W=145n
Mmn11 n0 D VSS VSS g45n1svt M=1 L=45n W=145n
Mmn55 Q qbint VSS VSS g45n1svt M=1 L=45n W=260n
Mmn35 n6 mout VSS VSS g45n1svt M=1 L=45n W=145n
Mmn36 n20 CKbb n6 VSS g45n1svt M=1 L=45n W=145n
Mmn22 RNb RN VSS VSS g45n1svt M=1 L=45n W=145n
Mmn20 CKb CK VSS VSS g45n1svt M=1 L=45n W=145n
Mmn10 SEb SE VSS VSS g45n1svt M=1 L=45n W=145n
Mmn25 Db CKb n20 VSS g45n1svt M=1 L=45n W=145n
Mmn32 mout n20 n4 VSS g45n1svt M=1 L=45n W=145n
Mmn53 n35 CKb n10 VSS g45n1svt M=1 L=45n W=145n
Mmn30 n4 SN VSS VSS g45n1svt M=1 L=45n W=145n
Mmn50 n8 SN VSS VSS g45n1svt M=1 L=45n W=145n
Mmn51 n10 RNb n8 VSS g45n1svt M=1 L=45n W=145n
Mmn40 n35 CKbb mout VSS g45n1svt M=1 L=45n W=145n
Mmn31 mout RNb n4 VSS g45n1svt M=1 L=45n W=145n
Mmn21 CKbb CKb VSS VSS g45n1svt M=1 L=45n W=145n
Mmn52 n10 qbint n8 VSS g45n1svt M=1 L=45n W=145n
Mmn45 qbint n35g VSS VSS g45n1svt M=1 L=45n W=145n
MPM3 n35g RTb net234 ExtVDD g45p1svt M=1 L=45n W=215n
MPM2 net234 qbint ExtVDD ExtVDD g45p1svt M=1 L=45n W=215n
MPM1 RTb RT ExtVDD ExtVDD g45p1svt M=1 L=45n W=215n
MPM0 n35g RT n35 ExtVDD g45p1svt M=1 L=45n W=215n
Mmp14 Db SEb n3 VDD g45p1svt M=1 L=45n W=215n
Mmp13 n3 SI VDD VDD g45p1svt M=1 L=45n W=215n
Mmp12 Db SE n1 VDD g45p1svt M=1 L=45n W=215n
Mmp11 n1 D VDD VDD g45p1svt M=1 L=45n W=215n
Mmp52 n11 qbint n9 VDD g45p1svt M=1 L=45n W=215n
Mmp51 n9 RNb VDD VDD g45p1svt M=1 L=45n W=215n
Mmp55 Q qbint VDD VDD g45p1svt M=1 L=45n W=390n
Mmp36 n20 CKb n7 VDD g45p1svt M=1 L=45n W=215n
Mmp35 n7 mout VDD VDD g45p1svt M=1 L=45n W=215n
Mmp32 mout n20 n5 VDD g45p1svt M=1 L=45n W=215n
Mmp31 n5 RNb VDD VDD g45p1svt M=1 L=45n W=215n
Mmp22 RNb RN VDD VDD g45p1svt M=1 L=45n W=215n
Mmp20 CKb CK VDD VDD g45p1svt M=1 L=45n W=215n
Mmp21 CKbb CKb VDD VDD g45p1svt M=1 L=45n W=215n
Mmp45 qbint n35g ExtVDD ExtVDD g45p1svt M=1 L=45n W=215n
Mmp30 mout SN VDD VDD g45p1svt M=1 L=45n W=215n
Mmp25 n20 CKbb Db VDD g45p1svt M=1 L=45n W=215n
Mmp40 n35 CKb mout VDD g45p1svt M=1 L=45n W=215n
Mmp53 n35 CKbb n11 VDD g45p1svt M=1 L=45n W=215n
Mmp50 n11 SN VDD VDD g45p1svt M=1 L=45n W=215n
Mmp10 SEb SE VDD VDD g45p1svt M=1 L=45n W=215n
.ENDS

.SUBCKT SRDFFSQX1 CK D ExtVDD Q RT SE SI SN VDD VSS
MNM3 net0134 qbint VSS VSS g45n1svt M=1 L=45n W=145n
MNM2 n35g RT net0134 VSS g45n1svt M=1 L=45n W=145n
MNM1 RTb RT VSS VSS g45n1svt M=1 L=45n W=145n
MNM0 n35g RTb n35 VSS g45n1svt M=1 L=45n W=145n
Mmn13 n2 SI VSS VSS g45n1svt M=1 L=45n W=145n
Mmn14 Db SE n2 VSS g45n1svt M=1 L=45n W=145n
Mmn12 Db SEb n0 VSS g45n1svt M=1 L=45n W=145n
Mmn11 n0 D VSS VSS g45n1svt M=1 L=45n W=145n
Mmn55 Q qbint VSS VSS g45n1svt M=1 L=45n W=260n
Mmn35 n6 mout VSS VSS g45n1svt M=1 L=45n W=145n
Mmn36 n20 CKbb n6 VSS g45n1svt M=1 L=45n W=145n
Mmn20 CKb CK VSS VSS g45n1svt M=1 L=45n W=145n
Mmn10 SEb SE VSS VSS g45n1svt M=1 L=45n W=145n
Mmn25 Db CKb n20 VSS g45n1svt M=1 L=45n W=145n
Mmn32 mout n20 net0119 VSS g45n1svt M=1 L=45n W=145n
Mmn53 n35 CKb net0118 VSS g45n1svt M=1 L=45n W=145n
Mmn30 net0119 SN VSS VSS g45n1svt M=1 L=45n W=145n
Mmn50 net0116 SN VSS VSS g45n1svt M=1 L=45n W=145n
Mmn40 n35 CKbb mout VSS g45n1svt M=1 L=45n W=145n
Mmn21 CKbb CKb VSS VSS g45n1svt M=1 L=45n W=145n
Mmn52 net0118 qbint net0116 VSS g45n1svt M=1 L=45n W=145n
Mmn45 qbint n35g VSS VSS g45n1svt M=1 L=45n W=145n
MPM3 n35g RTb net234 ExtVDD g45p1svt M=1 L=45n W=215n
MPM2 net234 qbint ExtVDD ExtVDD g45p1svt M=1 L=45n W=215n
MPM1 RTb RT ExtVDD ExtVDD g45p1svt M=1 L=45n W=215n
MPM0 n35g RT n35 ExtVDD g45p1svt M=1 L=45n W=215n
Mmp14 Db SEb n3 VDD g45p1svt M=1 L=45n W=215n
Mmp13 n3 SI VDD VDD g45p1svt M=1 L=45n W=215n
Mmp12 Db SE n1 VDD g45p1svt M=1 L=45n W=215n
Mmp11 n1 D VDD VDD g45p1svt M=1 L=45n W=215n
Mmp52 n11 qbint VDD VDD g45p1svt M=1 L=45n W=215n
Mmp55 Q qbint VDD VDD g45p1svt M=1 L=45n W=390n
Mmp36 n20 CKb n7 VDD g45p1svt M=1 L=45n W=215n
Mmp35 n7 mout VDD VDD g45p1svt M=1 L=45n W=215n
Mmp32 mout n20 VDD VDD g45p1svt M=1 L=45n W=215n
Mmp20 CKb CK VDD VDD g45p1svt M=1 L=45n W=215n
Mmp21 CKbb CKb VDD VDD g45p1svt M=1 L=45n W=215n
Mmp45 qbint n35g ExtVDD ExtVDD g45p1svt M=1 L=45n W=215n
Mmp30 mout SN VDD VDD g45p1svt M=1 L=45n W=215n
Mmp25 n20 CKbb Db VDD g45p1svt M=1 L=45n W=215n
Mmp40 n35 CKb mout VDD g45p1svt M=1 L=45n W=215n
Mmp53 n35 CKbb n11 VDD g45p1svt M=1 L=45n W=215n
Mmp50 n11 SN VDD VDD g45p1svt M=1 L=45n W=215n
Mmp10 SEb SE VDD VDD g45p1svt M=1 L=45n W=215n
.ENDS

.SUBCKT SRDFFRX1 CK D ExtVDD Q QN RN RT SE SI VDD VSS
MNM3 net0134 qbint VSS VSS g45n1svt M=1 L=45n W=145n
MNM2 n35g RT net0134 VSS g45n1svt M=1 L=45n W=145n
MNM1 RTb RT VSS VSS g45n1svt M=1 L=45n W=145n
MNM0 n35g RTb n35 VSS g45n1svt M=1 L=45n W=145n
Mmn13 n2 SI VSS VSS g45n1svt M=1 L=45n W=145n
Mmn14 Db SE n2 VSS g45n1svt M=1 L=45n W=145n
Mmn12 Db SEb n0 VSS g45n1svt M=1 L=45n W=145n
Mmn11 n0 D VSS VSS g45n1svt M=1 L=45n W=145n
Mmn57 QN net573 VSS VSS g45n1svt M=1 L=45n W=260n
Mmn55 Q qbint VSS VSS g45n1svt M=1 L=45n W=260n
Mmn35 n6 mout VSS VSS g45n1svt M=1 L=45n W=145n
Mmn36 n20 CKbb n6 VSS g45n1svt M=1 L=45n W=145n
Mmn22 RNb RN VSS VSS g45n1svt M=1 L=45n W=145n
Mmn20 CKb CK VSS VSS g45n1svt M=1 L=45n W=145n
Mmn10 SEb SE VSS VSS g45n1svt M=1 L=45n W=145n
Mmn56 net573 qbint VSS VSS g45n1svt M=1 L=45n W=145n
Mmn25 Db CKb n20 VSS g45n1svt M=1 L=45n W=145n
Mmn32 mout n20 VSS VSS g45n1svt M=1 L=45n W=145n
Mmn53 n35 CKb n10 VSS g45n1svt M=1 L=45n W=145n
Mmn51 n10 RNb VSS VSS g45n1svt M=1 L=45n W=145n
Mmn40 n35 CKbb mout VSS g45n1svt M=1 L=45n W=145n
Mmn31 mout RNb VSS VSS g45n1svt M=1 L=45n W=145n
Mmn21 CKbb CKb VSS VSS g45n1svt M=1 L=45n W=145n
Mmn52 n10 qbint VSS VSS g45n1svt M=1 L=45n W=145n
Mmn45 qbint n35g VSS VSS g45n1svt M=1 L=45n W=145n
MPM3 n35g RTb net234 ExtVDD g45p1svt M=1 L=45n W=215n
MPM2 net234 qbint ExtVDD ExtVDD g45p1svt M=1 L=45n W=215n
MPM1 RTb RT ExtVDD ExtVDD g45p1svt M=1 L=45n W=215n
MPM0 n35g RT n35 ExtVDD g45p1svt M=1 L=45n W=215n
Mmp14 Db SEb n3 VDD g45p1svt M=1 L=45n W=215n
Mmp13 n3 SI VDD VDD g45p1svt M=1 L=45n W=215n
Mmp12 Db SE n1 VDD g45p1svt M=1 L=45n W=215n
Mmp11 n1 D VDD VDD g45p1svt M=1 L=45n W=215n
Mmp52 n11 qbint n9 VDD g45p1svt M=1 L=45n W=215n
Mmp51 n9 RNb VDD VDD g45p1svt M=1 L=45n W=215n
Mmp57 QN net573 VDD VDD g45p1svt M=1 L=45n W=390n
Mmp55 Q qbint VDD VDD g45p1svt M=1 L=45n W=390n
Mmp36 n20 CKb n7 VDD g45p1svt M=1 L=45n W=215n
Mmp35 n7 mout VDD VDD g45p1svt M=1 L=45n W=215n
Mmp32 mout n20 n5 VDD g45p1svt M=1 L=45n W=215n
Mmp31 n5 RNb VDD VDD g45p1svt M=1 L=45n W=215n
Mmp22 RNb RN VDD VDD g45p1svt M=1 L=45n W=215n
Mmp20 CKb CK VDD VDD g45p1svt M=1 L=45n W=215n
Mmp21 CKbb CKb VDD VDD g45p1svt M=1 L=45n W=215n
Mmp45 qbint n35g ExtVDD ExtVDD g45p1svt M=1 L=45n W=215n
Mmp25 n20 CKbb Db VDD g45p1svt M=1 L=45n W=215n
Mmp56 net573 qbint VDD VDD g45p1svt M=1 L=45n W=215n
Mmp40 n35 CKb mout VDD g45p1svt M=1 L=45n W=215n
Mmp53 n35 CKbb n11 VDD g45p1svt M=1 L=45n W=215n
Mmp10 SEb SE VDD VDD g45p1svt M=1 L=45n W=215n
.ENDS

.SUBCKT SRDFFRQX1 CK D ExtVDD Q RN RT SE SI VDD VSS
MNM3 net0134 qbint VSS VSS g45n1svt M=1 L=45n W=145n
MNM2 n35g RT net0134 VSS g45n1svt M=1 L=45n W=145n
MNM1 RTb RT VSS VSS g45n1svt M=1 L=45n W=145n
MNM0 n35g RTb n35 VSS g45n1svt M=1 L=45n W=145n
Mmn13 n2 SI VSS VSS g45n1svt M=1 L=45n W=145n
Mmn14 Db SE n2 VSS g45n1svt M=1 L=45n W=145n
Mmn12 Db SEb n0 VSS g45n1svt M=1 L=45n W=145n
Mmn11 n0 D VSS VSS g45n1svt M=1 L=45n W=145n
Mmn55 Q qbint VSS VSS g45n1svt M=1 L=45n W=260n
Mmn35 n6 mout VSS VSS g45n1svt M=1 L=45n W=145n
Mmn36 n20 CKbb n6 VSS g45n1svt M=1 L=45n W=145n
Mmn22 RNb RN VSS VSS g45n1svt M=1 L=45n W=145n
Mmn20 CKb CK VSS VSS g45n1svt M=1 L=45n W=145n
Mmn10 SEb SE VSS VSS g45n1svt M=1 L=45n W=145n
Mmn25 Db CKb n20 VSS g45n1svt M=1 L=45n W=145n
Mmn32 mout n20 VSS VSS g45n1svt M=1 L=45n W=145n
Mmn53 n35 CKb n10 VSS g45n1svt M=1 L=45n W=145n
Mmn51 n10 RNb VSS VSS g45n1svt M=1 L=45n W=145n
Mmn40 n35 CKbb mout VSS g45n1svt M=1 L=45n W=145n
Mmn31 mout RNb VSS VSS g45n1svt M=1 L=45n W=145n
Mmn21 CKbb CKb VSS VSS g45n1svt M=1 L=45n W=145n
Mmn52 n10 qbint VSS VSS g45n1svt M=1 L=45n W=145n
Mmn45 qbint n35g VSS VSS g45n1svt M=1 L=45n W=145n
MPM3 n35g RTb net234 ExtVDD g45p1svt M=1 L=45n W=215n
MPM2 net234 qbint ExtVDD ExtVDD g45p1svt M=1 L=45n W=215n
MPM1 RTb RT ExtVDD ExtVDD g45p1svt M=1 L=45n W=215n
MPM0 n35g RT n35 ExtVDD g45p1svt M=1 L=45n W=215n
Mmp14 Db SEb n3 VDD g45p1svt M=1 L=45n W=215n
Mmp13 n3 SI VDD VDD g45p1svt M=1 L=45n W=215n
Mmp12 Db SE n1 VDD g45p1svt M=1 L=45n W=215n
Mmp11 n1 D VDD VDD g45p1svt M=1 L=45n W=215n
Mmp52 n11 qbint n9 VDD g45p1svt M=1 L=45n W=215n
Mmp51 n9 RNb VDD VDD g45p1svt M=1 L=45n W=215n
Mmp55 Q qbint VDD VDD g45p1svt M=1 L=45n W=390n
Mmp36 n20 CKb n7 VDD g45p1svt M=1 L=45n W=215n
Mmp35 n7 mout VDD VDD g45p1svt M=1 L=45n W=215n
Mmp32 mout n20 n5 VDD g45p1svt M=1 L=45n W=215n
Mmp31 n5 RNb VDD VDD g45p1svt M=1 L=45n W=215n
Mmp22 RNb RN VDD VDD g45p1svt M=1 L=45n W=215n
Mmp20 CKb CK VDD VDD g45p1svt M=1 L=45n W=215n
Mmp21 CKbb CKb VDD VDD g45p1svt M=1 L=45n W=215n
Mmp45 qbint n35g ExtVDD ExtVDD g45p1svt M=1 L=45n W=215n
Mmp25 n20 CKbb Db VDD g45p1svt M=1 L=45n W=215n
Mmp40 n35 CKb mout VDD g45p1svt M=1 L=45n W=215n
Mmp53 n35 CKbb n11 VDD g45p1svt M=1 L=45n W=215n
Mmp10 SEb SE VDD VDD g45p1svt M=1 L=45n W=215n
.ENDS

.SUBCKT SRDFFQX1 CK D ExtVDD Q RT SE SI VDD VSS
MNM3 net0134 qbint VSS VSS g45n1svt M=1 L=45n W=145n
MNM2 n35g RT net0134 VSS g45n1svt M=1 L=45n W=145n
MNM1 RTb RT VSS VSS g45n1svt M=1 L=45n W=145n
MNM0 n35g RTb n35 VSS g45n1svt M=1 L=45n W=145n
Mmn13 n2 SI VSS VSS g45n1svt M=1 L=45n W=145n
Mmn14 Db SE n2 VSS g45n1svt M=1 L=45n W=145n
Mmn12 Db SEb n0 VSS g45n1svt M=1 L=45n W=145n
Mmn11 n0 D VSS VSS g45n1svt M=1 L=45n W=145n
Mmn55 Q qbint VSS VSS g45n1svt M=1 L=45n W=260n
Mmn35 n6 mout VSS VSS g45n1svt M=1 L=45n W=145n
Mmn36 n20 CKbb n6 VSS g45n1svt M=1 L=45n W=145n
Mmn20 CKb CK VSS VSS g45n1svt M=1 L=45n W=145n
Mmn10 SEb SE VSS VSS g45n1svt M=1 L=45n W=145n
Mmn25 Db CKb n20 VSS g45n1svt M=1 L=45n W=145n
Mmn32 mout n20 VSS VSS g45n1svt M=1 L=45n W=145n
Mmn53 n35 CKb net0118 VSS g45n1svt M=1 L=45n W=145n
Mmn40 n35 CKbb mout VSS g45n1svt M=1 L=45n W=145n
Mmn21 CKbb CKb VSS VSS g45n1svt M=1 L=45n W=145n
Mmn52 net0118 qbint VSS VSS g45n1svt M=1 L=45n W=145n
Mmn45 qbint n35g VSS VSS g45n1svt M=1 L=45n W=145n
MPM3 n35g RTb net234 ExtVDD g45p1svt M=1 L=45n W=215n
MPM2 net234 qbint ExtVDD ExtVDD g45p1svt M=1 L=45n W=215n
MPM1 RTb RT ExtVDD ExtVDD g45p1svt M=1 L=45n W=215n
MPM0 n35g RT n35 ExtVDD g45p1svt M=1 L=45n W=215n
Mmp14 Db SEb n3 VDD g45p1svt M=1 L=45n W=215n
Mmp13 n3 SI VDD VDD g45p1svt M=1 L=45n W=215n
Mmp12 Db SE n1 VDD g45p1svt M=1 L=45n W=215n
Mmp11 n1 D VDD VDD g45p1svt M=1 L=45n W=215n
Mmp52 net0110 qbint VDD VDD g45p1svt M=1 L=45n W=215n
Mmp55 Q qbint VDD VDD g45p1svt M=1 L=45n W=390n
Mmp36 n20 CKb n7 VDD g45p1svt M=1 L=45n W=215n
Mmp35 n7 mout VDD VDD g45p1svt M=1 L=45n W=215n
Mmp32 mout n20 VDD VDD g45p1svt M=1 L=45n W=215n
Mmp20 CKb CK VDD VDD g45p1svt M=1 L=45n W=215n
Mmp21 CKbb CKb VDD VDD g45p1svt M=1 L=45n W=215n
Mmp45 qbint n35g ExtVDD ExtVDD g45p1svt M=1 L=45n W=215n
Mmp25 n20 CKbb Db VDD g45p1svt M=1 L=45n W=215n
Mmp40 n35 CKb mout VDD g45p1svt M=1 L=45n W=215n
Mmp53 n35 CKbb net0110 VDD g45p1svt M=1 L=45n W=215n
Mmp10 SEb SE VDD VDD g45p1svt M=1 L=45n W=215n
.ENDS

.SUBCKT SRDFFNX1 CKN D ExtVDD Q QN RT SE SI VDD VSS
MNM3 net0134 qbint VSS VSS g45n1svt M=1 L=45n W=145n
MNM2 n35g RT net0134 VSS g45n1svt M=1 L=45n W=145n
MNM1 RTb RT VSS VSS g45n1svt M=1 L=45n W=145n
MNM0 n35g RTb n35 VSS g45n1svt M=1 L=45n W=145n
Mmn13 n2 SI VSS VSS g45n1svt M=1 L=45n W=145n
Mmn14 Db SE n2 VSS g45n1svt M=1 L=45n W=145n
Mmn12 Db SEb n0 VSS g45n1svt M=1 L=45n W=145n
Mmn11 n0 D VSS VSS g45n1svt M=1 L=45n W=145n
Mmn57 QN net573 VSS VSS g45n1svt M=1 L=45n W=260n
Mmn55 Q qbint VSS VSS g45n1svt M=1 L=45n W=260n
Mmn35 n6 mout VSS VSS g45n1svt M=1 L=45n W=145n
Mmn36 n20 CKNb n6 VSS g45n1svt M=1 L=45n W=145n
Mmn20 CKNb CKN VSS VSS g45n1svt M=1 L=45n W=145n
Mmn10 SEb SE VSS VSS g45n1svt M=1 L=45n W=145n
Mmn56 net573 qbint VSS VSS g45n1svt M=1 L=45n W=145n
Mmn25 Db CKNbb n20 VSS g45n1svt M=1 L=45n W=145n
Mmn32 mout n20 VSS VSS g45n1svt M=1 L=45n W=145n
Mmn53 n35 CKNbb net0119 VSS g45n1svt M=1 L=45n W=145n
Mmn40 n35 CKNb mout VSS g45n1svt M=1 L=45n W=145n
Mmn21 CKNbb CKNb VSS VSS g45n1svt M=1 L=45n W=145n
Mmn52 net0119 qbint VSS VSS g45n1svt M=1 L=45n W=145n
Mmn45 qbint n35g VSS VSS g45n1svt M=1 L=45n W=145n
MPM3 n35g RTb net234 ExtVDD g45p1svt M=1 L=45n W=215n
MPM2 net234 qbint ExtVDD ExtVDD g45p1svt M=1 L=45n W=215n
MPM1 RTb RT ExtVDD ExtVDD g45p1svt M=1 L=45n W=215n
MPM0 n35g RT n35 ExtVDD g45p1svt M=1 L=45n W=215n
Mmp14 Db SEb n3 VDD g45p1svt M=1 L=45n W=215n
Mmp13 n3 SI VDD VDD g45p1svt M=1 L=45n W=215n
Mmp12 Db SE n1 VDD g45p1svt M=1 L=45n W=215n
Mmp11 n1 D VDD VDD g45p1svt M=1 L=45n W=215n
Mmp52 net0107 qbint VDD VDD g45p1svt M=1 L=45n W=215n
Mmp57 QN net573 VDD VDD g45p1svt M=1 L=45n W=390n
Mmp55 Q qbint VDD VDD g45p1svt M=1 L=45n W=390n
Mmp36 n20 CKNbb n7 VDD g45p1svt M=1 L=45n W=215n
Mmp35 n7 mout VDD VDD g45p1svt M=1 L=45n W=215n
Mmp32 mout n20 VDD VDD g45p1svt M=1 L=45n W=215n
Mmp20 CKNb CKN VDD VDD g45p1svt M=1 L=45n W=215n
Mmp21 CKNbb CKNb VDD VDD g45p1svt M=1 L=45n W=215n
Mmp45 qbint n35g ExtVDD ExtVDD g45p1svt M=1 L=45n W=215n
Mmp25 n20 CKNb Db VDD g45p1svt M=1 L=45n W=215n
Mmp56 net573 qbint VDD VDD g45p1svt M=1 L=45n W=215n
Mmp40 n35 CKNbb mout VDD g45p1svt M=1 L=45n W=215n
Mmp53 n35 CKNb net0107 VDD g45p1svt M=1 L=45n W=215n
Mmp10 SEb SE VDD VDD g45p1svt M=1 L=45n W=215n
.ENDS

.SUBCKT SRDFFNSX1 CKN D ExtVDD Q QN RT SE SI SN VDD VSS
MNM3 net0134 qbint VSS VSS g45n1svt M=1 L=45n W=145n
MNM2 n35g RT net0134 VSS g45n1svt M=1 L=45n W=145n
MNM1 RTb RT VSS VSS g45n1svt M=1 L=45n W=145n
MNM0 n35g RTb n35 VSS g45n1svt M=1 L=45n W=145n
Mmn13 n2 SI VSS VSS g45n1svt M=1 L=45n W=145n
Mmn14 Db SE n2 VSS g45n1svt M=1 L=45n W=145n
Mmn12 Db SEb n0 VSS g45n1svt M=1 L=45n W=145n
Mmn11 n0 D VSS VSS g45n1svt M=1 L=45n W=145n
Mmn57 QN net573 VSS VSS g45n1svt M=1 L=45n W=260n
Mmn55 Q qbint VSS VSS g45n1svt M=1 L=45n W=260n
Mmn35 n6 mout VSS VSS g45n1svt M=1 L=45n W=145n
Mmn36 n20 CKNb n6 VSS g45n1svt M=1 L=45n W=145n
Mmn20 CKNb CKN VSS VSS g45n1svt M=1 L=45n W=145n
Mmn10 SEb SE VSS VSS g45n1svt M=1 L=45n W=145n
Mmn56 net573 qbint VSS VSS g45n1svt M=1 L=45n W=145n
Mmn25 Db CKNbb n20 VSS g45n1svt M=1 L=45n W=145n
Mmn32 mout n20 net0118 VSS g45n1svt M=1 L=45n W=145n
Mmn53 n35 CKNbb net0119 VSS g45n1svt M=1 L=45n W=145n
Mmn30 net0118 SN VSS VSS g45n1svt M=1 L=45n W=145n
Mmn50 net0117 SN VSS VSS g45n1svt M=1 L=45n W=145n
Mmn40 n35 CKNb mout VSS g45n1svt M=1 L=45n W=145n
Mmn21 CKNbb CKNb VSS VSS g45n1svt M=1 L=45n W=145n
Mmn52 net0119 qbint net0117 VSS g45n1svt M=1 L=45n W=145n
Mmn45 qbint n35g VSS VSS g45n1svt M=1 L=45n W=145n
MPM3 n35g RTb net234 ExtVDD g45p1svt M=1 L=45n W=215n
MPM2 net234 qbint ExtVDD ExtVDD g45p1svt M=1 L=45n W=215n
MPM1 RTb RT ExtVDD ExtVDD g45p1svt M=1 L=45n W=215n
MPM0 n35g RT n35 ExtVDD g45p1svt M=1 L=45n W=215n
Mmp14 Db SEb n3 VDD g45p1svt M=1 L=45n W=215n
Mmp13 n3 SI VDD VDD g45p1svt M=1 L=45n W=215n
Mmp12 Db SE n1 VDD g45p1svt M=1 L=45n W=215n
Mmp11 n1 D VDD VDD g45p1svt M=1 L=45n W=215n
Mmp52 n11 qbint VDD VDD g45p1svt M=1 L=45n W=215n
Mmp57 QN net573 VDD VDD g45p1svt M=1 L=45n W=390n
Mmp55 Q qbint VDD VDD g45p1svt M=1 L=45n W=390n
Mmp36 n20 CKNbb n7 VDD g45p1svt M=1 L=45n W=215n
Mmp35 n7 mout VDD VDD g45p1svt M=1 L=45n W=215n
Mmp32 mout n20 VDD VDD g45p1svt M=1 L=45n W=215n
Mmp20 CKNb CKN VDD VDD g45p1svt M=1 L=45n W=215n
Mmp21 CKNbb CKNb VDD VDD g45p1svt M=1 L=45n W=215n
Mmp45 qbint n35g ExtVDD ExtVDD g45p1svt M=1 L=45n W=215n
Mmp30 mout SN VDD VDD g45p1svt M=1 L=45n W=215n
Mmp25 n20 CKNb Db VDD g45p1svt M=1 L=45n W=215n
Mmp56 net573 qbint VDD VDD g45p1svt M=1 L=45n W=215n
Mmp40 n35 CKNbb mout VDD g45p1svt M=1 L=45n W=215n
Mmp53 n35 CKNb n11 VDD g45p1svt M=1 L=45n W=215n
Mmp50 n11 SN VDD VDD g45p1svt M=1 L=45n W=215n
Mmp10 SEb SE VDD VDD g45p1svt M=1 L=45n W=215n
.ENDS

.SUBCKT SRDFFNSRX1 CKN D ExtVDD Q QN RN RT SE SI SN VDD VSS
MNM3 net0134 qbint VSS VSS g45n1svt M=1 L=45n W=145n
MNM2 n35g RT net0134 VSS g45n1svt M=1 L=45n W=145n
MNM1 RTb RT VSS VSS g45n1svt M=1 L=45n W=145n
MNM0 n35g RTb n35 VSS g45n1svt M=1 L=45n W=145n
Mmn13 n2 SI VSS VSS g45n1svt M=1 L=45n W=145n
Mmn14 Db SE n2 VSS g45n1svt M=1 L=45n W=145n
Mmn12 Db SEb n0 VSS g45n1svt M=1 L=45n W=145n
Mmn11 n0 D VSS VSS g45n1svt M=1 L=45n W=145n
Mmn57 QN net573 VSS VSS g45n1svt M=1 L=45n W=260n
Mmn55 Q qbint VSS VSS g45n1svt M=1 L=45n W=260n
Mmn35 n6 mout VSS VSS g45n1svt M=1 L=45n W=145n
Mmn36 n20 CKNb n6 VSS g45n1svt M=1 L=45n W=145n
Mmn22 RNb RN VSS VSS g45n1svt M=1 L=45n W=145n
Mmn20 CKNb CKN VSS VSS g45n1svt M=1 L=45n W=145n
Mmn10 SEb SE VSS VSS g45n1svt M=1 L=45n W=145n
Mmn56 net573 qbint VSS VSS g45n1svt M=1 L=45n W=145n
Mmn25 Db CKNbb n20 VSS g45n1svt M=1 L=45n W=145n
Mmn32 mout n20 n4 VSS g45n1svt M=1 L=45n W=145n
Mmn53 n35 CKNbb n10 VSS g45n1svt M=1 L=45n W=145n
Mmn30 n4 SN VSS VSS g45n1svt M=1 L=45n W=145n
Mmn50 n8 SN VSS VSS g45n1svt M=1 L=45n W=145n
Mmn51 n10 RNb n8 VSS g45n1svt M=1 L=45n W=145n
Mmn40 n35 CKNb mout VSS g45n1svt M=1 L=45n W=145n
Mmn31 mout RNb n4 VSS g45n1svt M=1 L=45n W=145n
Mmn21 CKNbb CKNb VSS VSS g45n1svt M=1 L=45n W=145n
Mmn52 n10 qbint n8 VSS g45n1svt M=1 L=45n W=145n
Mmn45 qbint n35g VSS VSS g45n1svt M=1 L=45n W=145n
MPM3 n35g RTb net234 ExtVDD g45p1svt M=1 L=45n W=215n
MPM2 net234 qbint ExtVDD ExtVDD g45p1svt M=1 L=45n W=215n
MPM1 RTb RT ExtVDD ExtVDD g45p1svt M=1 L=45n W=215n
MPM0 n35g RT n35 ExtVDD g45p1svt M=1 L=45n W=215n
Mmp14 Db SEb n3 VDD g45p1svt M=1 L=45n W=215n
Mmp13 n3 SI VDD VDD g45p1svt M=1 L=45n W=215n
Mmp12 Db SE n1 VDD g45p1svt M=1 L=45n W=215n
Mmp11 n1 D VDD VDD g45p1svt M=1 L=45n W=215n
Mmp52 n11 qbint n9 VDD g45p1svt M=1 L=45n W=215n
Mmp51 n9 RNb VDD VDD g45p1svt M=1 L=45n W=215n
Mmp57 QN net573 VDD VDD g45p1svt M=1 L=45n W=390n
Mmp55 Q qbint VDD VDD g45p1svt M=1 L=45n W=390n
Mmp36 n20 CKNbb n7 VDD g45p1svt M=1 L=45n W=215n
Mmp35 n7 mout VDD VDD g45p1svt M=1 L=45n W=215n
Mmp32 mout n20 n5 VDD g45p1svt M=1 L=45n W=215n
Mmp31 n5 RNb VDD VDD g45p1svt M=1 L=45n W=215n
Mmp22 RNb RN VDD VDD g45p1svt M=1 L=45n W=215n
Mmp20 CKNb CKN VDD VDD g45p1svt M=1 L=45n W=215n
Mmp21 CKNbb CKNb VDD VDD g45p1svt M=1 L=45n W=215n
Mmp45 qbint n35g ExtVDD ExtVDD g45p1svt M=1 L=45n W=215n
Mmp30 mout SN VDD VDD g45p1svt M=1 L=45n W=215n
Mmp25 n20 CKNb Db VDD g45p1svt M=1 L=45n W=215n
Mmp56 net573 qbint VDD VDD g45p1svt M=1 L=45n W=215n
Mmp40 n35 CKNbb mout VDD g45p1svt M=1 L=45n W=215n
Mmp53 n35 CKNb n11 VDD g45p1svt M=1 L=45n W=215n
Mmp50 n11 SN VDD VDD g45p1svt M=1 L=45n W=215n
Mmp10 SEb SE VDD VDD g45p1svt M=1 L=45n W=215n
.ENDS

.SUBCKT SRDFFNSRQX1 CKN D ExtVDD Q RN RT SE SI SN VDD VSS
MNM3 net0134 qbint VSS VSS g45n1svt M=1 L=45n W=145n
MNM2 n35g RT net0134 VSS g45n1svt M=1 L=45n W=145n
MNM1 RTb RT VSS VSS g45n1svt M=1 L=45n W=145n
MNM0 n35g RTb n35 VSS g45n1svt M=1 L=45n W=145n
Mmn13 n2 SI VSS VSS g45n1svt M=1 L=45n W=145n
Mmn14 Db SE n2 VSS g45n1svt M=1 L=45n W=145n
Mmn12 Db SEb n0 VSS g45n1svt M=1 L=45n W=145n
Mmn11 n0 D VSS VSS g45n1svt M=1 L=45n W=145n
Mmn55 Q qbint VSS VSS g45n1svt M=1 L=45n W=260n
Mmn35 n6 mout VSS VSS g45n1svt M=1 L=45n W=145n
Mmn36 n20 CKNb n6 VSS g45n1svt M=1 L=45n W=145n
Mmn22 RNb RN VSS VSS g45n1svt M=1 L=45n W=145n
Mmn20 CKNb CKN VSS VSS g45n1svt M=1 L=45n W=145n
Mmn10 SEb SE VSS VSS g45n1svt M=1 L=45n W=145n
Mmn25 Db CKNbb n20 VSS g45n1svt M=1 L=45n W=145n
Mmn32 mout n20 n4 VSS g45n1svt M=1 L=45n W=145n
Mmn53 n35 CKNbb n10 VSS g45n1svt M=1 L=45n W=145n
Mmn30 n4 SN VSS VSS g45n1svt M=1 L=45n W=145n
Mmn50 n8 SN VSS VSS g45n1svt M=1 L=45n W=145n
Mmn51 n10 RNb n8 VSS g45n1svt M=1 L=45n W=145n
Mmn40 n35 CKNb mout VSS g45n1svt M=1 L=45n W=145n
Mmn31 mout RNb n4 VSS g45n1svt M=1 L=45n W=145n
Mmn21 CKNbb CKNb VSS VSS g45n1svt M=1 L=45n W=145n
Mmn52 n10 qbint n8 VSS g45n1svt M=1 L=45n W=145n
Mmn45 qbint n35g VSS VSS g45n1svt M=1 L=45n W=145n
MPM3 n35g RTb net234 ExtVDD g45p1svt M=1 L=45n W=215n
MPM2 net234 qbint ExtVDD ExtVDD g45p1svt M=1 L=45n W=215n
MPM1 RTb RT ExtVDD ExtVDD g45p1svt M=1 L=45n W=215n
MPM0 n35g RT n35 ExtVDD g45p1svt M=1 L=45n W=215n
Mmp14 Db SEb n3 VDD g45p1svt M=1 L=45n W=215n
Mmp13 n3 SI VDD VDD g45p1svt M=1 L=45n W=215n
Mmp12 Db SE n1 VDD g45p1svt M=1 L=45n W=215n
Mmp11 n1 D VDD VDD g45p1svt M=1 L=45n W=215n
Mmp52 n11 qbint n9 VDD g45p1svt M=1 L=45n W=215n
Mmp51 n9 RNb VDD VDD g45p1svt M=1 L=45n W=215n
Mmp55 Q qbint VDD VDD g45p1svt M=1 L=45n W=390n
Mmp36 n20 CKNbb n7 VDD g45p1svt M=1 L=45n W=215n
Mmp35 n7 mout VDD VDD g45p1svt M=1 L=45n W=215n
Mmp32 mout n20 n5 VDD g45p1svt M=1 L=45n W=215n
Mmp31 n5 RNb VDD VDD g45p1svt M=1 L=45n W=215n
Mmp22 RNb RN VDD VDD g45p1svt M=1 L=45n W=215n
Mmp20 CKNb CKN VDD VDD g45p1svt M=1 L=45n W=215n
Mmp21 CKNbb CKNb VDD VDD g45p1svt M=1 L=45n W=215n
Mmp45 qbint n35g ExtVDD ExtVDD g45p1svt M=1 L=45n W=215n
Mmp30 mout SN VDD VDD g45p1svt M=1 L=45n W=215n
Mmp25 n20 CKNb Db VDD g45p1svt M=1 L=45n W=215n
Mmp40 n35 CKNbb mout VDD g45p1svt M=1 L=45n W=215n
Mmp53 n35 CKNb n11 VDD g45p1svt M=1 L=45n W=215n
Mmp50 n11 SN VDD VDD g45p1svt M=1 L=45n W=215n
Mmp10 SEb SE VDD VDD g45p1svt M=1 L=45n W=215n
.ENDS

.SUBCKT SRDFFNSQX1 CKN D ExtVDD Q RT SE SI SN VDD VSS
MNM3 net0134 qbint VSS VSS g45n1svt M=1 L=45n W=145n
MNM2 n35g RT net0134 VSS g45n1svt M=1 L=45n W=145n
MNM1 RTb RT VSS VSS g45n1svt M=1 L=45n W=145n
MNM0 n35g RTb n35 VSS g45n1svt M=1 L=45n W=145n
Mmn13 n2 SI VSS VSS g45n1svt M=1 L=45n W=145n
Mmn14 Db SE n2 VSS g45n1svt M=1 L=45n W=145n
Mmn12 Db SEb n0 VSS g45n1svt M=1 L=45n W=145n
Mmn11 n0 D VSS VSS g45n1svt M=1 L=45n W=145n
Mmn55 Q qbint VSS VSS g45n1svt M=1 L=45n W=260n
Mmn35 n6 mout VSS VSS g45n1svt M=1 L=45n W=145n
Mmn36 n20 CKNb n6 VSS g45n1svt M=1 L=45n W=145n
Mmn20 CKNb CKN VSS VSS g45n1svt M=1 L=45n W=145n
Mmn10 SEb SE VSS VSS g45n1svt M=1 L=45n W=145n
Mmn25 Db CKNbb n20 VSS g45n1svt M=1 L=45n W=145n
Mmn32 mout n20 net0118 VSS g45n1svt M=1 L=45n W=145n
Mmn53 n35 CKNbb net0119 VSS g45n1svt M=1 L=45n W=145n
Mmn30 net0118 SN VSS VSS g45n1svt M=1 L=45n W=145n
Mmn50 net0117 SN VSS VSS g45n1svt M=1 L=45n W=145n
Mmn40 n35 CKNb mout VSS g45n1svt M=1 L=45n W=145n
Mmn21 CKNbb CKNb VSS VSS g45n1svt M=1 L=45n W=145n
Mmn52 net0119 qbint net0117 VSS g45n1svt M=1 L=45n W=145n
Mmn45 qbint n35g VSS VSS g45n1svt M=1 L=45n W=145n
MPM3 n35g RTb net234 ExtVDD g45p1svt M=1 L=45n W=215n
MPM2 net234 qbint ExtVDD ExtVDD g45p1svt M=1 L=45n W=215n
MPM1 RTb RT ExtVDD ExtVDD g45p1svt M=1 L=45n W=215n
MPM0 n35g RT n35 ExtVDD g45p1svt M=1 L=45n W=215n
Mmp14 Db SEb n3 VDD g45p1svt M=1 L=45n W=215n
Mmp13 n3 SI VDD VDD g45p1svt M=1 L=45n W=215n
Mmp12 Db SE n1 VDD g45p1svt M=1 L=45n W=215n
Mmp11 n1 D VDD VDD g45p1svt M=1 L=45n W=215n
Mmp52 n11 qbint VDD VDD g45p1svt M=1 L=45n W=215n
Mmp55 Q qbint VDD VDD g45p1svt M=1 L=45n W=390n
Mmp36 n20 CKNbb n7 VDD g45p1svt M=1 L=45n W=215n
Mmp35 n7 mout VDD VDD g45p1svt M=1 L=45n W=215n
Mmp32 mout n20 VDD VDD g45p1svt M=1 L=45n W=215n
Mmp20 CKNb CKN VDD VDD g45p1svt M=1 L=45n W=215n
Mmp21 CKNbb CKNb VDD VDD g45p1svt M=1 L=45n W=215n
Mmp45 qbint n35g ExtVDD ExtVDD g45p1svt M=1 L=45n W=215n
Mmp30 mout SN VDD VDD g45p1svt M=1 L=45n W=215n
Mmp25 n20 CKNb Db VDD g45p1svt M=1 L=45n W=215n
Mmp40 n35 CKNbb mout VDD g45p1svt M=1 L=45n W=215n
Mmp53 n35 CKNb n11 VDD g45p1svt M=1 L=45n W=215n
Mmp50 n11 SN VDD VDD g45p1svt M=1 L=45n W=215n
Mmp10 SEb SE VDD VDD g45p1svt M=1 L=45n W=215n
.ENDS

.SUBCKT SRDFFNRX1 CKN D ExtVDD Q QN RN RT SE SI VDD VSS
MNM3 net0134 qbint VSS VSS g45n1svt M=1 L=45n W=145n
MNM2 n35g RT net0134 VSS g45n1svt M=1 L=45n W=145n
MNM1 RTb RT VSS VSS g45n1svt M=1 L=45n W=145n
MNM0 n35g RTb n35 VSS g45n1svt M=1 L=45n W=145n
Mmn13 n2 SI VSS VSS g45n1svt M=1 L=45n W=145n
Mmn14 Db SE n2 VSS g45n1svt M=1 L=45n W=145n
Mmn12 Db SEb n0 VSS g45n1svt M=1 L=45n W=145n
Mmn11 n0 D VSS VSS g45n1svt M=1 L=45n W=145n
Mmn57 QN net573 VSS VSS g45n1svt M=1 L=45n W=260n
Mmn55 Q qbint VSS VSS g45n1svt M=1 L=45n W=260n
Mmn35 n6 mout VSS VSS g45n1svt M=1 L=45n W=145n
Mmn36 n20 CKNb n6 VSS g45n1svt M=1 L=45n W=145n
Mmn22 RNb RN VSS VSS g45n1svt M=1 L=45n W=145n
Mmn20 CKNb CKN VSS VSS g45n1svt M=1 L=45n W=145n
Mmn10 SEb SE VSS VSS g45n1svt M=1 L=45n W=145n
Mmn56 net573 qbint VSS VSS g45n1svt M=1 L=45n W=145n
Mmn25 Db CKNbb n20 VSS g45n1svt M=1 L=45n W=145n
Mmn32 mout n20 VSS VSS g45n1svt M=1 L=45n W=145n
Mmn53 n35 CKNbb n10 VSS g45n1svt M=1 L=45n W=145n
Mmn51 n10 RNb VSS VSS g45n1svt M=1 L=45n W=145n
Mmn40 n35 CKNb mout VSS g45n1svt M=1 L=45n W=145n
Mmn31 mout RNb VSS VSS g45n1svt M=1 L=45n W=145n
Mmn21 CKNbb CKNb VSS VSS g45n1svt M=1 L=45n W=145n
Mmn52 n10 qbint VSS VSS g45n1svt M=1 L=45n W=145n
Mmn45 qbint n35g VSS VSS g45n1svt M=1 L=45n W=145n
MPM3 n35g RTb net234 ExtVDD g45p1svt M=1 L=45n W=215n
MPM2 net234 qbint ExtVDD ExtVDD g45p1svt M=1 L=45n W=215n
MPM1 RTb RT ExtVDD ExtVDD g45p1svt M=1 L=45n W=215n
MPM0 n35g RT n35 ExtVDD g45p1svt M=1 L=45n W=215n
Mmp14 Db SEb n3 VDD g45p1svt M=1 L=45n W=215n
Mmp13 n3 SI VDD VDD g45p1svt M=1 L=45n W=215n
Mmp12 Db SE n1 VDD g45p1svt M=1 L=45n W=215n
Mmp11 n1 D VDD VDD g45p1svt M=1 L=45n W=215n
Mmp52 n11 qbint n9 VDD g45p1svt M=1 L=45n W=215n
Mmp51 n9 RNb VDD VDD g45p1svt M=1 L=45n W=215n
Mmp57 QN net573 VDD VDD g45p1svt M=1 L=45n W=390n
Mmp55 Q qbint VDD VDD g45p1svt M=1 L=45n W=390n
Mmp36 n20 CKNbb n7 VDD g45p1svt M=1 L=45n W=215n
Mmp35 n7 mout VDD VDD g45p1svt M=1 L=45n W=215n
Mmp32 mout n20 n5 VDD g45p1svt M=1 L=45n W=215n
Mmp31 n5 RNb VDD VDD g45p1svt M=1 L=45n W=215n
Mmp22 RNb RN VDD VDD g45p1svt M=1 L=45n W=215n
Mmp20 CKNb CKN VDD VDD g45p1svt M=1 L=45n W=215n
Mmp21 CKNbb CKNb VDD VDD g45p1svt M=1 L=45n W=215n
Mmp45 qbint n35g ExtVDD ExtVDD g45p1svt M=1 L=45n W=215n
Mmp25 n20 CKNb Db VDD g45p1svt M=1 L=45n W=215n
Mmp56 net573 qbint VDD VDD g45p1svt M=1 L=45n W=215n
Mmp40 n35 CKNbb mout VDD g45p1svt M=1 L=45n W=215n
Mmp53 n35 CKNb n11 VDD g45p1svt M=1 L=45n W=215n
Mmp10 SEb SE VDD VDD g45p1svt M=1 L=45n W=215n
.ENDS

.SUBCKT SRDFFNRQX1 CKN D ExtVDD Q RN RT SE SI VDD VSS
MNM3 net0134 qbint VSS VSS g45n1svt M=1 L=45n W=145n
MNM2 n35g RT net0134 VSS g45n1svt M=1 L=45n W=145n
MNM1 RTb RT VSS VSS g45n1svt M=1 L=45n W=145n
MNM0 n35g RTb n35 VSS g45n1svt M=1 L=45n W=145n
Mmn13 n2 SI VSS VSS g45n1svt M=1 L=45n W=145n
Mmn14 Db SE n2 VSS g45n1svt M=1 L=45n W=145n
Mmn12 Db SEb n0 VSS g45n1svt M=1 L=45n W=145n
Mmn11 n0 D VSS VSS g45n1svt M=1 L=45n W=145n
Mmn55 Q qbint VSS VSS g45n1svt M=1 L=45n W=260n
Mmn35 n6 mout VSS VSS g45n1svt M=1 L=45n W=145n
Mmn36 n20 CKNb n6 VSS g45n1svt M=1 L=45n W=145n
Mmn22 RNb RN VSS VSS g45n1svt M=1 L=45n W=145n
Mmn20 CKNb CKN VSS VSS g45n1svt M=1 L=45n W=145n
Mmn10 SEb SE VSS VSS g45n1svt M=1 L=45n W=145n
Mmn25 Db CKNbb n20 VSS g45n1svt M=1 L=45n W=145n
Mmn32 mout n20 VSS VSS g45n1svt M=1 L=45n W=145n
Mmn53 n35 CKNbb n10 VSS g45n1svt M=1 L=45n W=145n
Mmn51 n10 RNb VSS VSS g45n1svt M=1 L=45n W=145n
Mmn40 n35 CKNb mout VSS g45n1svt M=1 L=45n W=145n
Mmn31 mout RNb VSS VSS g45n1svt M=1 L=45n W=145n
Mmn21 CKNbb CKNb VSS VSS g45n1svt M=1 L=45n W=145n
Mmn52 n10 qbint VSS VSS g45n1svt M=1 L=45n W=145n
Mmn45 qbint n35g VSS VSS g45n1svt M=1 L=45n W=145n
MPM3 n35g RTb net234 ExtVDD g45p1svt M=1 L=45n W=215n
MPM2 net234 qbint ExtVDD ExtVDD g45p1svt M=1 L=45n W=215n
MPM1 RTb RT ExtVDD ExtVDD g45p1svt M=1 L=45n W=215n
MPM0 n35g RT n35 ExtVDD g45p1svt M=1 L=45n W=215n
Mmp14 Db SEb n3 VDD g45p1svt M=1 L=45n W=215n
Mmp13 n3 SI VDD VDD g45p1svt M=1 L=45n W=215n
Mmp12 Db SE n1 VDD g45p1svt M=1 L=45n W=215n
Mmp11 n1 D VDD VDD g45p1svt M=1 L=45n W=215n
Mmp52 n11 qbint n9 VDD g45p1svt M=1 L=45n W=215n
Mmp51 n9 RNb VDD VDD g45p1svt M=1 L=45n W=215n
Mmp55 Q qbint VDD VDD g45p1svt M=1 L=45n W=390n
Mmp36 n20 CKNbb n7 VDD g45p1svt M=1 L=45n W=215n
Mmp35 n7 mout VDD VDD g45p1svt M=1 L=45n W=215n
Mmp32 mout n20 n5 VDD g45p1svt M=1 L=45n W=215n
Mmp31 n5 RNb VDD VDD g45p1svt M=1 L=45n W=215n
Mmp22 RNb RN VDD VDD g45p1svt M=1 L=45n W=215n
Mmp20 CKNb CKN VDD VDD g45p1svt M=1 L=45n W=215n
Mmp21 CKNbb CKNb VDD VDD g45p1svt M=1 L=45n W=215n
Mmp45 qbint n35g ExtVDD ExtVDD g45p1svt M=1 L=45n W=215n
Mmp25 n20 CKNb Db VDD g45p1svt M=1 L=45n W=215n
Mmp40 n35 CKNbb mout VDD g45p1svt M=1 L=45n W=215n
Mmp53 n35 CKNb n11 VDD g45p1svt M=1 L=45n W=215n
Mmp10 SEb SE VDD VDD g45p1svt M=1 L=45n W=215n
.ENDS

.SUBCKT SRDFFNQX1 CKN D ExtVDD Q RT SE SI VDD VSS
MNM3 net0134 qbint VSS VSS g45n1svt M=1 L=45n W=145n
MNM2 n35g RT net0134 VSS g45n1svt M=1 L=45n W=145n
MNM1 RTb RT VSS VSS g45n1svt M=1 L=45n W=145n
MNM0 n35g RTb n35 VSS g45n1svt M=1 L=45n W=145n
Mmn13 n2 SI VSS VSS g45n1svt M=1 L=45n W=145n
Mmn14 Db SE n2 VSS g45n1svt M=1 L=45n W=145n
Mmn12 Db SEb n0 VSS g45n1svt M=1 L=45n W=145n
Mmn11 n0 D VSS VSS g45n1svt M=1 L=45n W=145n
Mmn55 Q qbint VSS VSS g45n1svt M=1 L=45n W=260n
Mmn35 n6 mout VSS VSS g45n1svt M=1 L=45n W=145n
Mmn36 n20 CKNb n6 VSS g45n1svt M=1 L=45n W=145n
Mmn20 CKNb CKN VSS VSS g45n1svt M=1 L=45n W=145n
Mmn10 SEb SE VSS VSS g45n1svt M=1 L=45n W=145n
Mmn25 Db CKNbb n20 VSS g45n1svt M=1 L=45n W=145n
Mmn32 mout n20 VSS VSS g45n1svt M=1 L=45n W=145n
Mmn53 n35 CKNbb net0119 VSS g45n1svt M=1 L=45n W=145n
Mmn40 n35 CKNb mout VSS g45n1svt M=1 L=45n W=145n
Mmn21 CKNbb CKNb VSS VSS g45n1svt M=1 L=45n W=145n
Mmn52 net0119 qbint VSS VSS g45n1svt M=1 L=45n W=145n
Mmn45 qbint n35g VSS VSS g45n1svt M=1 L=45n W=145n
MPM3 n35g RTb net234 ExtVDD g45p1svt M=1 L=45n W=215n
MPM2 net234 qbint ExtVDD ExtVDD g45p1svt M=1 L=45n W=215n
MPM1 RTb RT ExtVDD ExtVDD g45p1svt M=1 L=45n W=215n
MPM0 n35g RT n35 ExtVDD g45p1svt M=1 L=45n W=215n
Mmp14 Db SEb n3 VDD g45p1svt M=1 L=45n W=215n
Mmp13 n3 SI VDD VDD g45p1svt M=1 L=45n W=215n
Mmp12 Db SE n1 VDD g45p1svt M=1 L=45n W=215n
Mmp11 n1 D VDD VDD g45p1svt M=1 L=45n W=215n
Mmp52 net0107 qbint VDD VDD g45p1svt M=1 L=45n W=215n
Mmp55 Q qbint VDD VDD g45p1svt M=1 L=45n W=390n
Mmp36 n20 CKNbb n7 VDD g45p1svt M=1 L=45n W=215n
Mmp35 n7 mout VDD VDD g45p1svt M=1 L=45n W=215n
Mmp32 mout n20 VDD VDD g45p1svt M=1 L=45n W=215n
Mmp20 CKNb CKN VDD VDD g45p1svt M=1 L=45n W=215n
Mmp21 CKNbb CKNb VDD VDD g45p1svt M=1 L=45n W=215n
Mmp45 qbint n35g ExtVDD ExtVDD g45p1svt M=1 L=45n W=215n
Mmp25 n20 CKNb Db VDD g45p1svt M=1 L=45n W=215n
Mmp40 n35 CKNbb mout VDD g45p1svt M=1 L=45n W=215n
Mmp53 n35 CKNb net0107 VDD g45p1svt M=1 L=45n W=215n
Mmp10 SEb SE VDD VDD g45p1svt M=1 L=45n W=215n
.ENDS

.SUBCKT SPDFF4RX2 CK D1 D2 D3 D4 Q1 Q1N Q2 Q2N Q3 Q3N Q4 Q4N RN SE SI1 SI2 SI3 SI4
+ VDD VSS
MNM55 SEb_4 SE VSS VSS g45n1svt M=1 L=45n W=145n
MNM54 n1_4 D4 VSS VSS g45n1svt M=1 L=45n W=145n
MNM53 Db_4 SEb_4 n1_4 VSS g45n1svt M=1 L=45n W=145n
MNM52 Db_4 SE n3_4 VSS g45n1svt M=1 L=45n W=145n
MNM51 n3_4 SI4 VSS VSS g45n1svt M=1 L=45n W=145n
MNM50 Db_4 CKb n20_4 VSS g45n1svt M=1 L=45n W=145n
MNM49 mout_4 n20_4 VSS VSS g45n1svt M=1 L=45n W=145n
MNM48 n20_4 Ckbb n5_4 VSS g45n1svt M=1 L=45n W=145n
MNM47 n7_4 RN VSS VSS g45n1svt M=1 L=45n W=145n
MNM46 n5_4 mout_4 n7_4 VSS g45n1svt M=1 L=45n W=145n
MNM45 mout_4 Ckbb n30_4 VSS g45n1svt M=1 L=45n W=145n
MNM44 qbint_4 n30_4 n9_4 VSS g45n1svt M=1 L=45n W=205n
MNM43 n9_4 RN VSS VSS g45n1svt M=1 L=45n W=205n
MNM42 n11_4 qbint_4 VSS VSS g45n1svt M=1 L=45n W=145n
MNM41 n30_4 CKb n11_4 VSS g45n1svt M=1 L=45n W=145n
MNM40 Q4 qbint_4 VSS VSS g45n1svt M=1 L=45n W=520n
MNM39 qint_4 qbint_4 VSS VSS g45n1svt M=1 L=45n W=145n
MNM38 Q4N qint_4 VSS VSS g45n1svt M=1 L=45n W=520n
MNM37 Q3N qint_3 VSS VSS g45n1svt M=1 L=45n W=520n
MNM36 qint_3 qbint_3 VSS VSS g45n1svt M=1 L=45n W=145n
MNM35 Q3 qbint_3 VSS VSS g45n1svt M=1 L=45n W=520n
MNM34 n30_3 CKb n11_3 VSS g45n1svt M=1 L=45n W=145n
MNM33 n11_3 qbint_3 VSS VSS g45n1svt M=1 L=45n W=145n
MNM32 n9_3 RN VSS VSS g45n1svt M=1 L=45n W=205n
MNM31 qbint_3 n30_3 n9_3 VSS g45n1svt M=1 L=45n W=205n
MNM30 mout_3 Ckbb n30_3 VSS g45n1svt M=1 L=45n W=145n
MNM29 n5_3 mout_3 n7_3 VSS g45n1svt M=1 L=45n W=145n
MNM28 n7_3 RN VSS VSS g45n1svt M=1 L=45n W=145n
MNM27 n20_3 Ckbb n5_3 VSS g45n1svt M=1 L=45n W=145n
MNM26 mout_3 n20_3 VSS VSS g45n1svt M=1 L=45n W=145n
MNM25 Db_3 CKb n20_3 VSS g45n1svt M=1 L=45n W=145n
MNM24 n3_3 SI3 VSS VSS g45n1svt M=1 L=45n W=145n
MNM19 Q2N qint_2 VSS VSS g45n1svt M=1 L=45n W=520n
MNM18 qint_2 qbint_2 VSS VSS g45n1svt M=1 L=45n W=145n
MNM17 Q2 qbint_2 VSS VSS g45n1svt M=1 L=45n W=520n
MNM16 n30_2 CKb n11_2 VSS g45n1svt M=1 L=45n W=145n
MNM15 n11_2 qbint_2 VSS VSS g45n1svt M=1 L=45n W=145n
MNM14 n9_2 RN VSS VSS g45n1svt M=1 L=45n W=205n
MNM13 qbint_2 n30_2 n9_2 VSS g45n1svt M=1 L=45n W=205n
MNM12 mout_2 Ckbb n30_2 VSS g45n1svt M=1 L=45n W=145n
MNM11 n5_2 mout_2 n7_2 VSS g45n1svt M=1 L=45n W=145n
MNM10 n7_2 RN VSS VSS g45n1svt M=1 L=45n W=145n
MNM9 n20_2 Ckbb n5_2 VSS g45n1svt M=1 L=45n W=145n
MNM8 mout_2 n20_2 VSS VSS g45n1svt M=1 L=45n W=145n
MNM7 Db_2 CKb n20_2 VSS g45n1svt M=1 L=45n W=145n
MNM20 SEb_3 SE VSS VSS g45n1svt M=1 L=45n W=145n
MNM4 n3_2 SI2 VSS VSS g45n1svt M=1 L=45n W=145n
MNM3 Db_2 SE n3_2 VSS g45n1svt M=1 L=45n W=145n
MNM2 Db_2 SEb_2 n1_2 VSS g45n1svt M=1 L=45n W=145n
MNM1 n1_2 D2 VSS VSS g45n1svt M=1 L=45n W=145n
MNM0 SEb_2 SE VSS VSS g45n1svt M=1 L=45n W=145n
MNM23 Db_3 SE n3_3 VSS g45n1svt M=1 L=45n W=145n
MNM22 Db_3 SEb_3 n1_3 VSS g45n1svt M=1 L=45n W=145n
MNM21 n1_3 D3 VSS VSS g45n1svt M=1 L=45n W=145n
Mmn36 n5 mout n7 VSS g45n1svt M=1 L=45n W=145n
Mmn35 n7 RN VSS VSS g45n1svt M=1 L=45n W=145n
Mmn37 n20 Ckbb n5 VSS g45n1svt M=1 L=45n W=145n
Mmn13 n3 SI1 VSS VSS g45n1svt M=1 L=45n W=145n
Mmn14 Db SE n3 VSS g45n1svt M=1 L=45n W=145n
Mmn12 Db SEb n1 VSS g45n1svt M=1 L=45n W=145n
Mmn11 n1 D1 VSS VSS g45n1svt M=1 L=45n W=145n
Mmn57 Q1N qint VSS VSS g45n1svt M=1 L=45n W=520n
Mmn55 Q1 qbint VSS VSS g45n1svt M=1 L=45n W=520n
Mmn45 n9 RN VSS VSS g45n1svt M=1 L=45n W=205n
Mmn46 qbint n30 n9 VSS g45n1svt M=1 L=45n W=205n
Mmn51 n30 CKb n11 VSS g45n1svt M=1 L=45n W=145n
Mmn50 n11 qbint VSS VSS g45n1svt M=1 L=45n W=145n
Mmn20 CKb CK VSS VSS g45n1svt M=1 L=45n W=145n
Mmn56 qint qbint VSS VSS g45n1svt M=1 L=45n W=145n
Mmn40 mout Ckbb n30 VSS g45n1svt M=1 L=45n W=145n
Mmn30 mout n20 VSS VSS g45n1svt M=1 L=45n W=145n
Mmn21 Ckbb CKb VSS VSS g45n1svt M=1 L=45n W=145n
Mmn10 SEb SE VSS VSS g45n1svt M=1 L=45n W=145n
Mmn25 Db CKb n20 VSS g45n1svt M=1 L=45n W=145n
MPM55 SEb_4 SE VDD VDD g45p1svt M=1 L=45n W=215n
MPM54 n2_4 D4 VDD VDD g45p1svt M=1 L=45n W=215n
MPM53 Db_4 SE n2_4 VDD g45p1svt M=1 L=45n W=215n
MPM52 n4_4 SI4 VDD VDD g45p1svt M=1 L=45n W=215n
MPM51 Db_4 SEb_4 n4_4 VDD g45p1svt M=1 L=45n W=215n
MPM50 n20_4 Ckbb Db_4 VDD g45p1svt M=1 L=45n W=215n
MPM49 mout_4 n20_4 VDD VDD g45p1svt M=1 L=45n W=215n
MPM48 n6_4 RN VDD VDD g45p1svt M=1 L=45n W=215n
MPM47 n20_4 CKb n6_4 VDD g45p1svt M=1 L=45n W=215n
MPM46 n6_4 mout_4 VDD VDD g45p1svt M=1 L=45n W=215n
MPM45 n30_4 CKb mout_4 VDD g45p1svt M=1 L=45n W=215n
MPM44 qbint_4 RN VDD VDD g45p1svt M=1 L=45n W=310n
MPM43 qbint_4 n30_4 VDD VDD g45p1svt M=1 L=45n W=310n
MPM42 n8_4 qbint_4 VDD VDD g45p1svt M=1 L=45n W=215n
MPM41 n30_4 Ckbb n8_4 VDD g45p1svt M=1 L=45n W=215n
MPM40 Q4 qbint_4 VDD VDD g45p1svt M=1 L=45n W=780n
MPM39 qint_4 qbint_4 VDD VDD g45p1svt M=1 L=45n W=215n
MPM38 Q4N qint_4 VDD VDD g45p1svt M=1 L=45n W=780n
MPM37 Q3N qint_3 VDD VDD g45p1svt M=1 L=45n W=780n
MPM36 qint_3 qbint_3 VDD VDD g45p1svt M=1 L=45n W=215n
MPM35 Q3 qbint_3 VDD VDD g45p1svt M=1 L=45n W=780n
MPM34 n30_3 Ckbb n8_3 VDD g45p1svt M=1 L=45n W=215n
MPM33 n8_3 qbint_3 VDD VDD g45p1svt M=1 L=45n W=215n
MPM32 qbint_3 n30_3 VDD VDD g45p1svt M=1 L=45n W=310n
MPM31 qbint_3 RN VDD VDD g45p1svt M=1 L=45n W=310n
MPM30 n30_3 CKb mout_3 VDD g45p1svt M=1 L=45n W=215n
MPM29 n6_3 mout_3 VDD VDD g45p1svt M=1 L=45n W=215n
MPM28 n20_3 CKb n6_3 VDD g45p1svt M=1 L=45n W=215n
MPM27 n6_3 RN VDD VDD g45p1svt M=1 L=45n W=215n
MPM26 mout_3 n20_3 VDD VDD g45p1svt M=1 L=45n W=215n
MPM25 n20_3 Ckbb Db_3 VDD g45p1svt M=1 L=45n W=215n
MPM19 Q2N qint_2 VDD VDD g45p1svt M=1 L=45n W=780n
MPM18 qint_2 qbint_2 VDD VDD g45p1svt M=1 L=45n W=215n
MPM17 Q2 qbint_2 VDD VDD g45p1svt M=1 L=45n W=780n
MPM16 n30_2 Ckbb n8_2 VDD g45p1svt M=1 L=45n W=215n
MPM15 n8_2 qbint_2 VDD VDD g45p1svt M=1 L=45n W=215n
MPM14 qbint_2 n30_2 VDD VDD g45p1svt M=1 L=45n W=310n
MPM13 qbint_2 RN VDD VDD g45p1svt M=1 L=45n W=310n
MPM12 n30_2 CKb mout_2 VDD g45p1svt M=1 L=45n W=215n
MPM11 n6_2 mout_2 VDD VDD g45p1svt M=1 L=45n W=215n
MPM10 n20_2 CKb n6_2 VDD g45p1svt M=1 L=45n W=215n
MPM9 n6_2 RN VDD VDD g45p1svt M=1 L=45n W=215n
MPM8 mout_2 n20_2 VDD VDD g45p1svt M=1 L=45n W=215n
MPM7 n20_2 Ckbb Db_2 VDD g45p1svt M=1 L=45n W=215n
MPM20 SEb_3 SE VDD VDD g45p1svt M=1 L=45n W=215n
MPM22 Db_3 SE n2_3 VDD g45p1svt M=1 L=45n W=215n
MPM21 n2_3 D3 VDD VDD g45p1svt M=1 L=45n W=215n
MPM4 Db_2 SEb_2 n4_2 VDD g45p1svt M=1 L=45n W=215n
MPM3 n4_2 SI2 VDD VDD g45p1svt M=1 L=45n W=215n
MPM2 Db_2 SE n2_2 VDD g45p1svt M=1 L=45n W=215n
MPM1 n2_2 D2 VDD VDD g45p1svt M=1 L=45n W=215n
MPM0 SEb_2 SE VDD VDD g45p1svt M=1 L=45n W=215n
MPM23 n4_3 SI3 VDD VDD g45p1svt M=1 L=45n W=215n
MPM24 Db_3 SEb_3 n4_3 VDD g45p1svt M=1 L=45n W=215n
Mmp14 Db SEb n4 VDD g45p1svt M=1 L=45n W=215n
Mmp13 n4 SI1 VDD VDD g45p1svt M=1 L=45n W=215n
Mmp12 Db SE n2 VDD g45p1svt M=1 L=45n W=215n
Mmp11 n2 D1 VDD VDD g45p1svt M=1 L=45n W=215n
Mmp51 n30 Ckbb n8 VDD g45p1svt M=1 L=45n W=215n
Mmp50 n8 qbint VDD VDD g45p1svt M=1 L=45n W=215n
Mmp55 Q1 qbint VDD VDD g45p1svt M=1 L=45n W=780n
Mmp20 CKb CK VDD VDD g45p1svt M=1 L=45n W=215n
Mmp46 qbint n30 VDD VDD g45p1svt M=1 L=45n W=310n
Mmp56 qint qbint VDD VDD g45p1svt M=1 L=45n W=215n
Mmp45 qbint RN VDD VDD g45p1svt M=1 L=45n W=310n
Mmp35 n6 RN VDD VDD g45p1svt M=1 L=45n W=215n
Mmp36 n6 mout VDD VDD g45p1svt M=1 L=45n W=215n
Mmp37 n20 CKb n6 VDD g45p1svt M=1 L=45n W=215n
Mmp40 n30 CKb mout VDD g45p1svt M=1 L=45n W=215n
Mmp30 mout n20 VDD VDD g45p1svt M=1 L=45n W=215n
Mmp21 Ckbb CKb VDD VDD g45p1svt M=1 L=45n W=215n
Mmp25 n20 Ckbb Db VDD g45p1svt M=1 L=45n W=215n
Mmp10 SEb SE VDD VDD g45p1svt M=1 L=45n W=215n
Mmp57 Q1N qint VDD VDD g45p1svt M=1 L=45n W=780n
.ENDS

.SUBCKT SPDFF4RX1 CK D1 D2 D3 D4 Q1 Q1N Q2 Q2N Q3 Q3N Q4 Q4N RN SE SI1 SI2 SI3 SI4
+ VDD VSS
MNM55 SEb_4 SE VSS VSS g45n1svt M=1 L=45n W=145n
MNM54 n1_4 D4 VSS VSS g45n1svt M=1 L=45n W=145n
MNM53 Db_4 SEb_4 n1_4 VSS g45n1svt M=1 L=45n W=145n
MNM52 Db_4 SE n3_4 VSS g45n1svt M=1 L=45n W=145n
MNM51 n3_4 SI4 VSS VSS g45n1svt M=1 L=45n W=145n
MNM50 Db_4 CKb n20_4 VSS g45n1svt M=1 L=45n W=145n
MNM49 mout_4 n20_4 VSS VSS g45n1svt M=1 L=45n W=145n
MNM48 n20_4 Ckbb n5_4 VSS g45n1svt M=1 L=45n W=145n
MNM47 n7_4 RN VSS VSS g45n1svt M=1 L=45n W=145n
MNM46 n5_4 mout_4 n7_4 VSS g45n1svt M=1 L=45n W=145n
MNM45 mout_4 Ckbb n30_4 VSS g45n1svt M=1 L=45n W=145n
MNM44 qbint_4 n30_4 n9_4 VSS g45n1svt M=1 L=45n W=145n
MNM43 n9_4 RN VSS VSS g45n1svt M=1 L=45n W=145n
MNM42 n11_4 qbint_4 VSS VSS g45n1svt M=1 L=45n W=145n
MNM41 n30_4 CKb n11_4 VSS g45n1svt M=1 L=45n W=145n
MNM40 Q4 qbint_4 VSS VSS g45n1svt M=1 L=45n W=260n
MNM39 qint_4 qbint_4 VSS VSS g45n1svt M=1 L=45n W=145n
MNM38 Q4N qint_4 VSS VSS g45n1svt M=1 L=45n W=260n
MNM37 Q3N qint_3 VSS VSS g45n1svt M=1 L=45n W=260n
MNM36 qint_3 qbint_3 VSS VSS g45n1svt M=1 L=45n W=145n
MNM35 Q3 qbint_3 VSS VSS g45n1svt M=1 L=45n W=260n
MNM34 n30_3 CKb n11_3 VSS g45n1svt M=1 L=45n W=145n
MNM33 n11_3 qbint_3 VSS VSS g45n1svt M=1 L=45n W=145n
MNM32 n9_3 RN VSS VSS g45n1svt M=1 L=45n W=145n
MNM31 qbint_3 n30_3 n9_3 VSS g45n1svt M=1 L=45n W=145n
MNM30 mout_3 Ckbb n30_3 VSS g45n1svt M=1 L=45n W=145n
MNM29 n5_3 mout_3 n7_3 VSS g45n1svt M=1 L=45n W=145n
MNM28 n7_3 RN VSS VSS g45n1svt M=1 L=45n W=145n
MNM27 n20_3 Ckbb n5_3 VSS g45n1svt M=1 L=45n W=145n
MNM26 mout_3 n20_3 VSS VSS g45n1svt M=1 L=45n W=145n
MNM25 Db_3 CKb n20_3 VSS g45n1svt M=1 L=45n W=145n
MNM24 n3_3 SI3 VSS VSS g45n1svt M=1 L=45n W=145n
MNM23 Db_3 SE n3_3 VSS g45n1svt M=1 L=45n W=145n
MNM19 Q2N qint_2 VSS VSS g45n1svt M=1 L=45n W=260n
MNM18 qint_2 qbint_2 VSS VSS g45n1svt M=1 L=45n W=145n
MNM17 Q2 qbint_2 VSS VSS g45n1svt M=1 L=45n W=260n
MNM16 n30_2 CKb n11_2 VSS g45n1svt M=1 L=45n W=145n
MNM15 n11_2 qbint_2 VSS VSS g45n1svt M=1 L=45n W=145n
MNM14 n9_2 RN VSS VSS g45n1svt M=1 L=45n W=145n
MNM13 qbint_2 n30_2 n9_2 VSS g45n1svt M=1 L=45n W=145n
MNM12 mout_2 Ckbb n30_2 VSS g45n1svt M=1 L=45n W=145n
MNM11 n5_2 mout_2 n7_2 VSS g45n1svt M=1 L=45n W=145n
MNM10 n7_2 RN VSS VSS g45n1svt M=1 L=45n W=145n
MNM9 n20_2 Ckbb n5_2 VSS g45n1svt M=1 L=45n W=145n
MNM8 mout_2 n20_2 VSS VSS g45n1svt M=1 L=45n W=145n
MNM7 Db_2 CKb n20_2 VSS g45n1svt M=1 L=45n W=145n
MNM20 SEb_3 SE VSS VSS g45n1svt M=1 L=45n W=145n
MNM4 n3_2 SI2 VSS VSS g45n1svt M=1 L=45n W=145n
MNM3 Db_2 SE n3_2 VSS g45n1svt M=1 L=45n W=145n
MNM2 Db_2 SEb_2 n1_2 VSS g45n1svt M=1 L=45n W=145n
MNM1 n1_2 D2 VSS VSS g45n1svt M=1 L=45n W=145n
MNM0 SEb_2 SE VSS VSS g45n1svt M=1 L=45n W=145n
MNM21 n1_3 D3 VSS VSS g45n1svt M=1 L=45n W=145n
MNM22 Db_3 SEb_3 n1_3 VSS g45n1svt M=1 L=45n W=145n
Mmn36 n5 mout n7 VSS g45n1svt M=1 L=45n W=145n
Mmn35 n7 RN VSS VSS g45n1svt M=1 L=45n W=145n
Mmn37 n20 Ckbb n5 VSS g45n1svt M=1 L=45n W=145n
Mmn13 n3 SI1 VSS VSS g45n1svt M=1 L=45n W=145n
Mmn14 Db SE n3 VSS g45n1svt M=1 L=45n W=145n
Mmn12 Db SEb n1 VSS g45n1svt M=1 L=45n W=145n
Mmn11 n1 D1 VSS VSS g45n1svt M=1 L=45n W=145n
Mmn57 Q1N qint VSS VSS g45n1svt M=1 L=45n W=260n
Mmn55 Q1 qbint VSS VSS g45n1svt M=1 L=45n W=260n
Mmn45 n9 RN VSS VSS g45n1svt M=1 L=45n W=145n
Mmn46 qbint n30 n9 VSS g45n1svt M=1 L=45n W=145n
Mmn51 n30 CKb n11 VSS g45n1svt M=1 L=45n W=145n
Mmn50 n11 qbint VSS VSS g45n1svt M=1 L=45n W=145n
Mmn20 CKb CK VSS VSS g45n1svt M=1 L=45n W=145n
Mmn56 qint qbint VSS VSS g45n1svt M=1 L=45n W=145n
Mmn40 mout Ckbb n30 VSS g45n1svt M=1 L=45n W=145n
Mmn30 mout n20 VSS VSS g45n1svt M=1 L=45n W=145n
Mmn21 Ckbb CKb VSS VSS g45n1svt M=1 L=45n W=145n
Mmn10 SEb SE VSS VSS g45n1svt M=1 L=45n W=145n
Mmn25 Db CKb n20 VSS g45n1svt M=1 L=45n W=145n
MPM55 SEb_4 SE VDD VDD g45p1svt M=1 L=45n W=215n
MPM54 n2_4 D4 VDD VDD g45p1svt M=1 L=45n W=215n
MPM53 Db_4 SE n2_4 VDD g45p1svt M=1 L=45n W=215n
MPM52 n4_4 SI4 VDD VDD g45p1svt M=1 L=45n W=215n
MPM51 Db_4 SEb_4 n4_4 VDD g45p1svt M=1 L=45n W=215n
MPM50 n20_4 Ckbb Db_4 VDD g45p1svt M=1 L=45n W=215n
MPM49 mout_4 n20_4 VDD VDD g45p1svt M=1 L=45n W=215n
MPM48 n6_4 RN VDD VDD g45p1svt M=1 L=45n W=215n
MPM47 n20_4 CKb n6_4 VDD g45p1svt M=1 L=45n W=215n
MPM46 n6_4 mout_4 VDD VDD g45p1svt M=1 L=45n W=215n
MPM45 n30_4 CKb mout_4 VDD g45p1svt M=1 L=45n W=215n
MPM44 qbint_4 RN VDD VDD g45p1svt M=1 L=45n W=215n
MPM43 qbint_4 n30_4 VDD VDD g45p1svt M=1 L=45n W=215n
MPM42 n8_4 qbint_4 VDD VDD g45p1svt M=1 L=45n W=215n
MPM41 n30_4 Ckbb n8_4 VDD g45p1svt M=1 L=45n W=215n
MPM40 Q4 qbint_4 VDD VDD g45p1svt M=1 L=45n W=390n
MPM39 qint_4 qbint_4 VDD VDD g45p1svt M=1 L=45n W=215n
MPM38 Q4N qint_4 VDD VDD g45p1svt M=1 L=45n W=390n
MPM37 Q3N qint_3 VDD VDD g45p1svt M=1 L=45n W=390n
MPM36 qint_3 qbint_3 VDD VDD g45p1svt M=1 L=45n W=215n
MPM35 Q3 qbint_3 VDD VDD g45p1svt M=1 L=45n W=390n
MPM34 n30_3 Ckbb n8_3 VDD g45p1svt M=1 L=45n W=215n
MPM33 n8_3 qbint_3 VDD VDD g45p1svt M=1 L=45n W=215n
MPM32 qbint_3 n30_3 VDD VDD g45p1svt M=1 L=45n W=215n
MPM31 qbint_3 RN VDD VDD g45p1svt M=1 L=45n W=215n
MPM30 n30_3 CKb mout_3 VDD g45p1svt M=1 L=45n W=215n
MPM29 n6_3 mout_3 VDD VDD g45p1svt M=1 L=45n W=215n
MPM28 n20_3 CKb n6_3 VDD g45p1svt M=1 L=45n W=215n
MPM27 n6_3 RN VDD VDD g45p1svt M=1 L=45n W=215n
MPM26 mout_3 n20_3 VDD VDD g45p1svt M=1 L=45n W=215n
MPM25 n20_3 Ckbb Db_3 VDD g45p1svt M=1 L=45n W=215n
MPM24 Db_3 SEb_3 n4_3 VDD g45p1svt M=1 L=45n W=215n
MPM19 Q2N qint_2 VDD VDD g45p1svt M=1 L=45n W=390n
MPM18 qint_2 qbint_2 VDD VDD g45p1svt M=1 L=45n W=215n
MPM17 Q2 qbint_2 VDD VDD g45p1svt M=1 L=45n W=390n
MPM16 n30_2 Ckbb n8_2 VDD g45p1svt M=1 L=45n W=215n
MPM15 n8_2 qbint_2 VDD VDD g45p1svt M=1 L=45n W=215n
MPM14 qbint_2 n30_2 VDD VDD g45p1svt M=1 L=45n W=215n
MPM13 qbint_2 RN VDD VDD g45p1svt M=1 L=45n W=215n
MPM12 n30_2 CKb mout_2 VDD g45p1svt M=1 L=45n W=215n
MPM11 n6_2 mout_2 VDD VDD g45p1svt M=1 L=45n W=215n
MPM10 n20_2 CKb n6_2 VDD g45p1svt M=1 L=45n W=215n
MPM9 n6_2 RN VDD VDD g45p1svt M=1 L=45n W=215n
MPM8 mout_2 n20_2 VDD VDD g45p1svt M=1 L=45n W=215n
MPM7 n20_2 Ckbb Db_2 VDD g45p1svt M=1 L=45n W=215n
MPM20 SEb_3 SE VDD VDD g45p1svt M=1 L=45n W=215n
MPM4 Db_2 SEb_2 n4_2 VDD g45p1svt M=1 L=45n W=215n
MPM3 n4_2 SI2 VDD VDD g45p1svt M=1 L=45n W=215n
MPM2 Db_2 SE n2_2 VDD g45p1svt M=1 L=45n W=215n
MPM1 n2_2 D2 VDD VDD g45p1svt M=1 L=45n W=215n
MPM0 SEb_2 SE VDD VDD g45p1svt M=1 L=45n W=215n
MPM21 n2_3 D3 VDD VDD g45p1svt M=1 L=45n W=215n
MPM22 Db_3 SE n2_3 VDD g45p1svt M=1 L=45n W=215n
MPM23 n4_3 SI3 VDD VDD g45p1svt M=1 L=45n W=215n
Mmp14 Db SEb n4 VDD g45p1svt M=1 L=45n W=215n
Mmp13 n4 SI1 VDD VDD g45p1svt M=1 L=45n W=215n
Mmp12 Db SE n2 VDD g45p1svt M=1 L=45n W=215n
Mmp11 n2 D1 VDD VDD g45p1svt M=1 L=45n W=215n
Mmp51 n30 Ckbb n8 VDD g45p1svt M=1 L=45n W=215n
Mmp50 n8 qbint VDD VDD g45p1svt M=1 L=45n W=215n
Mmp55 Q1 qbint VDD VDD g45p1svt M=1 L=45n W=390n
Mmp20 CKb CK VDD VDD g45p1svt M=1 L=45n W=215n
Mmp46 qbint n30 VDD VDD g45p1svt M=1 L=45n W=215n
Mmp56 qint qbint VDD VDD g45p1svt M=1 L=45n W=215n
Mmp45 qbint RN VDD VDD g45p1svt M=1 L=45n W=215n
Mmp35 n6 RN VDD VDD g45p1svt M=1 L=45n W=215n
Mmp36 n6 mout VDD VDD g45p1svt M=1 L=45n W=215n
Mmp37 n20 CKb n6 VDD g45p1svt M=1 L=45n W=215n
Mmp40 n30 CKb mout VDD g45p1svt M=1 L=45n W=215n
Mmp30 mout n20 VDD VDD g45p1svt M=1 L=45n W=215n
Mmp21 Ckbb CKb VDD VDD g45p1svt M=1 L=45n W=215n
Mmp25 n20 Ckbb Db VDD g45p1svt M=1 L=45n W=215n
Mmp10 SEb SE VDD VDD g45p1svt M=1 L=45n W=215n
Mmp57 Q1N qint VDD VDD g45p1svt M=1 L=45n W=390n
.ENDS

.SUBCKT SPDFF2RX2 CK D1 D2 Q1 Q1N Q2 Q2N RN SE SI1 SI2 VDD VSS
MNM19 Q2N qint_2 VSS VSS g45n1svt M=1 L=45n W=520n
MNM18 qint_2 qbint_2 VSS VSS g45n1svt M=1 L=45n W=145n
MNM17 Q2 qbint_2 VSS VSS g45n1svt M=1 L=45n W=520n
MNM16 n30_2 CKb n11_2 VSS g45n1svt M=1 L=45n W=145n
MNM15 n11_2 qbint_2 VSS VSS g45n1svt M=1 L=45n W=145n
MNM14 n9_2 RN VSS VSS g45n1svt M=1 L=45n W=205n
MNM13 qbint_2 n30_2 n9_2 VSS g45n1svt M=1 L=45n W=205n
MNM12 mout_2 Ckbb n30_2 VSS g45n1svt M=1 L=45n W=145n
MNM11 n5_2 mout_2 n7_2 VSS g45n1svt M=1 L=45n W=145n
MNM10 n7_2 RN VSS VSS g45n1svt M=1 L=45n W=145n
MNM9 n20_2 Ckbb n5_2 VSS g45n1svt M=1 L=45n W=145n
MNM8 mout_2 n20_2 VSS VSS g45n1svt M=1 L=45n W=145n
MNM7 Db_2 CKb n20_2 VSS g45n1svt M=1 L=45n W=145n
MNM4 n3_2 SI2 VSS VSS g45n1svt M=1 L=45n W=145n
MNM3 Db_2 SE n3_2 VSS g45n1svt M=1 L=45n W=145n
MNM2 Db_2 SEb_2 n1_2 VSS g45n1svt M=1 L=45n W=145n
MNM1 n1_2 D2 VSS VSS g45n1svt M=1 L=45n W=145n
MNM0 SEb_2 SE VSS VSS g45n1svt M=1 L=45n W=145n
Mmn36 n5 mout n7 VSS g45n1svt M=1 L=45n W=145n
Mmn35 n7 RN VSS VSS g45n1svt M=1 L=45n W=145n
Mmn37 n20 Ckbb n5 VSS g45n1svt M=1 L=45n W=145n
Mmn13 n3 SI1 VSS VSS g45n1svt M=1 L=45n W=145n
Mmn14 Db SE n3 VSS g45n1svt M=1 L=45n W=145n
Mmn12 Db SEb n1 VSS g45n1svt M=1 L=45n W=145n
Mmn11 n1 D1 VSS VSS g45n1svt M=1 L=45n W=145n
Mmn57 Q1N qint VSS VSS g45n1svt M=1 L=45n W=520n
Mmn55 Q1 qbint VSS VSS g45n1svt M=1 L=45n W=520n
Mmn45 n9 RN VSS VSS g45n1svt M=1 L=45n W=205n
Mmn46 qbint n30 n9 VSS g45n1svt M=1 L=45n W=205n
Mmn51 n30 CKb n11 VSS g45n1svt M=1 L=45n W=145n
Mmn50 n11 qbint VSS VSS g45n1svt M=1 L=45n W=145n
Mmn20 CKb CK VSS VSS g45n1svt M=1 L=45n W=145n
Mmn56 qint qbint VSS VSS g45n1svt M=1 L=45n W=145n
Mmn40 mout Ckbb n30 VSS g45n1svt M=1 L=45n W=145n
Mmn30 mout n20 VSS VSS g45n1svt M=1 L=45n W=145n
Mmn21 Ckbb CKb VSS VSS g45n1svt M=1 L=45n W=145n
Mmn10 SEb SE VSS VSS g45n1svt M=1 L=45n W=145n
Mmn25 Db CKb n20 VSS g45n1svt M=1 L=45n W=145n
MPM19 Q2N qint_2 VDD VDD g45p1svt M=1 L=45n W=780n
MPM18 qint_2 qbint_2 VDD VDD g45p1svt M=1 L=45n W=215n
MPM17 Q2 qbint_2 VDD VDD g45p1svt M=1 L=45n W=780n
MPM16 n30_2 Ckbb n8_2 VDD g45p1svt M=1 L=45n W=215n
MPM15 n8_2 qbint_2 VDD VDD g45p1svt M=1 L=45n W=215n
MPM14 qbint_2 n30_2 VDD VDD g45p1svt M=1 L=45n W=310n
MPM13 qbint_2 RN VDD VDD g45p1svt M=1 L=45n W=310n
MPM12 n30_2 CKb mout_2 VDD g45p1svt M=1 L=45n W=215n
MPM11 n6_2 mout_2 VDD VDD g45p1svt M=1 L=45n W=215n
MPM10 n20_2 CKb n6_2 VDD g45p1svt M=1 L=45n W=215n
MPM9 n6_2 RN VDD VDD g45p1svt M=1 L=45n W=215n
MPM8 mout_2 n20_2 VDD VDD g45p1svt M=1 L=45n W=215n
MPM7 n20_2 Ckbb Db_2 VDD g45p1svt M=1 L=45n W=215n
MPM4 Db_2 SEb_2 n4_2 VDD g45p1svt M=1 L=45n W=215n
MPM3 n4_2 SI2 VDD VDD g45p1svt M=1 L=45n W=215n
MPM2 Db_2 SE n2_2 VDD g45p1svt M=1 L=45n W=215n
MPM1 n2_2 D2 VDD VDD g45p1svt M=1 L=45n W=215n
MPM0 SEb_2 SE VDD VDD g45p1svt M=1 L=45n W=215n
Mmp14 Db SEb n4 VDD g45p1svt M=1 L=45n W=215n
Mmp13 n4 SI1 VDD VDD g45p1svt M=1 L=45n W=215n
Mmp12 Db SE n2 VDD g45p1svt M=1 L=45n W=215n
Mmp11 n2 D1 VDD VDD g45p1svt M=1 L=45n W=215n
Mmp51 n30 Ckbb n8 VDD g45p1svt M=1 L=45n W=215n
Mmp50 n8 qbint VDD VDD g45p1svt M=1 L=45n W=215n
Mmp55 Q1 qbint VDD VDD g45p1svt M=1 L=45n W=780n
Mmp20 CKb CK VDD VDD g45p1svt M=1 L=45n W=215n
Mmp46 qbint n30 VDD VDD g45p1svt M=1 L=45n W=310n
Mmp56 qint qbint VDD VDD g45p1svt M=1 L=45n W=215n
Mmp45 qbint RN VDD VDD g45p1svt M=1 L=45n W=310n
Mmp35 n6 RN VDD VDD g45p1svt M=1 L=45n W=215n
Mmp36 n6 mout VDD VDD g45p1svt M=1 L=45n W=215n
Mmp37 n20 CKb n6 VDD g45p1svt M=1 L=45n W=215n
Mmp40 n30 CKb mout VDD g45p1svt M=1 L=45n W=215n
Mmp30 mout n20 VDD VDD g45p1svt M=1 L=45n W=215n
Mmp21 Ckbb CKb VDD VDD g45p1svt M=1 L=45n W=215n
Mmp25 n20 Ckbb Db VDD g45p1svt M=1 L=45n W=215n
Mmp10 SEb SE VDD VDD g45p1svt M=1 L=45n W=215n
Mmp57 Q1N qint VDD VDD g45p1svt M=1 L=45n W=780n
.ENDS

.SUBCKT SPDFF2RX1 CK D1 D2 Q1 Q1N Q2 Q2N RN SE SI1 SI2 VDD VSS
MNM19 Q2N qint_2 VSS VSS g45n1svt M=1 L=45n W=260n
MNM18 qint_2 qbint_2 VSS VSS g45n1svt M=1 L=45n W=145n
MNM17 Q2 qbint_2 VSS VSS g45n1svt M=1 L=45n W=260n
MNM16 n30_2 CKb n11_2 VSS g45n1svt M=1 L=45n W=145n
MNM15 n11_2 qbint_2 VSS VSS g45n1svt M=1 L=45n W=145n
MNM14 n9_2 RN VSS VSS g45n1svt M=1 L=45n W=145n
MNM13 qbint_2 n30_2 n9_2 VSS g45n1svt M=1 L=45n W=145n
MNM12 mout_2 Ckbb n30_2 VSS g45n1svt M=1 L=45n W=145n
MNM11 n5_2 mout_2 n7_2 VSS g45n1svt M=1 L=45n W=145n
MNM10 n7_2 RN VSS VSS g45n1svt M=1 L=45n W=145n
MNM9 n20_2 Ckbb n5_2 VSS g45n1svt M=1 L=45n W=145n
MNM8 mout_2 n20_2 VSS VSS g45n1svt M=1 L=45n W=145n
MNM7 Db_2 CKb n20_2 VSS g45n1svt M=1 L=45n W=145n
MNM4 n3_2 SI2 VSS VSS g45n1svt M=1 L=45n W=145n
MNM3 Db_2 SE n3_2 VSS g45n1svt M=1 L=45n W=145n
MNM2 Db_2 SEb_2 n1_2 VSS g45n1svt M=1 L=45n W=145n
MNM1 n1_2 D2 VSS VSS g45n1svt M=1 L=45n W=145n
MNM0 SEb_2 SE VSS VSS g45n1svt M=1 L=45n W=145n
Mmn36 n5 mout n7 VSS g45n1svt M=1 L=45n W=145n
Mmn35 n7 RN VSS VSS g45n1svt M=1 L=45n W=145n
Mmn37 n20 Ckbb n5 VSS g45n1svt M=1 L=45n W=145n
Mmn13 n3 SI1 VSS VSS g45n1svt M=1 L=45n W=145n
Mmn14 Db SE n3 VSS g45n1svt M=1 L=45n W=145n
Mmn12 Db SEb n1 VSS g45n1svt M=1 L=45n W=145n
Mmn11 n1 D1 VSS VSS g45n1svt M=1 L=45n W=145n
Mmn57 Q1N qint VSS VSS g45n1svt M=1 L=45n W=260n
Mmn55 Q1 qbint VSS VSS g45n1svt M=1 L=45n W=260n
Mmn45 n9 RN VSS VSS g45n1svt M=1 L=45n W=145n
Mmn46 qbint n30 n9 VSS g45n1svt M=1 L=45n W=145n
Mmn51 n30 CKb n11 VSS g45n1svt M=1 L=45n W=145n
Mmn50 n11 qbint VSS VSS g45n1svt M=1 L=45n W=145n
Mmn20 CKb CK VSS VSS g45n1svt M=1 L=45n W=145n
Mmn56 qint qbint VSS VSS g45n1svt M=1 L=45n W=145n
Mmn40 mout Ckbb n30 VSS g45n1svt M=1 L=45n W=145n
Mmn30 mout n20 VSS VSS g45n1svt M=1 L=45n W=145n
Mmn21 Ckbb CKb VSS VSS g45n1svt M=1 L=45n W=145n
Mmn10 SEb SE VSS VSS g45n1svt M=1 L=45n W=145n
Mmn25 Db CKb n20 VSS g45n1svt M=1 L=45n W=145n
MPM19 Q2N qint_2 VDD VDD g45p1svt M=1 L=45n W=390n
MPM18 qint_2 qbint_2 VDD VDD g45p1svt M=1 L=45n W=215n
MPM17 Q2 qbint_2 VDD VDD g45p1svt M=1 L=45n W=390n
MPM16 n30_2 Ckbb n8_2 VDD g45p1svt M=1 L=45n W=215n
MPM15 n8_2 qbint_2 VDD VDD g45p1svt M=1 L=45n W=215n
MPM14 qbint_2 n30_2 VDD VDD g45p1svt M=1 L=45n W=215n
MPM13 qbint_2 RN VDD VDD g45p1svt M=1 L=45n W=215n
MPM12 n30_2 CKb mout_2 VDD g45p1svt M=1 L=45n W=215n
MPM11 n6_2 mout_2 VDD VDD g45p1svt M=1 L=45n W=215n
MPM10 n20_2 CKb n6_2 VDD g45p1svt M=1 L=45n W=215n
MPM9 n6_2 RN VDD VDD g45p1svt M=1 L=45n W=215n
MPM8 mout_2 n20_2 VDD VDD g45p1svt M=1 L=45n W=215n
MPM7 n20_2 Ckbb Db_2 VDD g45p1svt M=1 L=45n W=215n
MPM4 Db_2 SEb_2 n4_2 VDD g45p1svt M=1 L=45n W=215n
MPM3 n4_2 SI2 VDD VDD g45p1svt M=1 L=45n W=215n
MPM2 Db_2 SE n2_2 VDD g45p1svt M=1 L=45n W=215n
MPM1 n2_2 D2 VDD VDD g45p1svt M=1 L=45n W=215n
MPM0 SEb_2 SE VDD VDD g45p1svt M=1 L=45n W=215n
Mmp14 Db SEb n4 VDD g45p1svt M=1 L=45n W=215n
Mmp13 n4 SI1 VDD VDD g45p1svt M=1 L=45n W=215n
Mmp12 Db SE n2 VDD g45p1svt M=1 L=45n W=215n
Mmp11 n2 D1 VDD VDD g45p1svt M=1 L=45n W=215n
Mmp51 n30 Ckbb n8 VDD g45p1svt M=1 L=45n W=215n
Mmp50 n8 qbint VDD VDD g45p1svt M=1 L=45n W=215n
Mmp55 Q1 qbint VDD VDD g45p1svt M=1 L=45n W=390n
Mmp20 CKb CK VDD VDD g45p1svt M=1 L=45n W=215n
Mmp46 qbint n30 VDD VDD g45p1svt M=1 L=45n W=215n
Mmp56 qint qbint VDD VDD g45p1svt M=1 L=45n W=215n
Mmp45 qbint RN VDD VDD g45p1svt M=1 L=45n W=215n
Mmp35 n6 RN VDD VDD g45p1svt M=1 L=45n W=215n
Mmp36 n6 mout VDD VDD g45p1svt M=1 L=45n W=215n
Mmp37 n20 CKb n6 VDD g45p1svt M=1 L=45n W=215n
Mmp40 n30 CKb mout VDD g45p1svt M=1 L=45n W=215n
Mmp30 mout n20 VDD VDD g45p1svt M=1 L=45n W=215n
Mmp21 Ckbb CKb VDD VDD g45p1svt M=1 L=45n W=215n
Mmp25 n20 Ckbb Db VDD g45p1svt M=1 L=45n W=215n
Mmp10 SEb SE VDD VDD g45p1svt M=1 L=45n W=215n
Mmp57 Q1N qint VDD VDD g45p1svt M=1 L=45n W=390n
.ENDS

.SUBCKT SMDFFHQX8 CK D0 D1 Q S0 SE SI VDD VSS
Mmn3 net510 D1 VSS VSS g45n1svt M=1 L=45n W=260n
Mmn4 db S0 net510 VSS g45n1svt M=1 L=45n W=260n
Mmn2 db S0b net498 VSS g45n1svt M=1 L=45n W=260n
Mmn1 net498 D0 VSS VSS g45n1svt M=1 L=45n W=260n
Mmn13 dbp SE net490 VSS g45n1svt M=1 L=45n W=260n
Mmn12 net490 SI VSS VSS g45n1svt M=1 L=45n W=260n
Mmn55 Q qbint VSS VSS g45n1svt M=1 L=45n W=2.065u
Mmn50 net482 qbint VSS VSS g45n1svt M=1 L=45n W=205n
Mmn51 n30 CKb net482 VSS g45n1svt M=1 L=45n W=205n
Mmn35 net474 mout VSS VSS g45n1svt M=1 L=45n W=205n
Mmn36 n20 CKbb net474 VSS g45n1svt M=1 L=45n W=205n
Mmn20 CKb CK VSS VSS g45n1svt M=1 L=45n W=145n
Mmn45 qbint n30 VSS VSS g45n1svt M=1 L=45n W=780n
Mmn10 SEb SE VSS VSS g45n1svt M=1 L=45n W=145n
Mmn0 S0b S0 VSS VSS g45n1svt M=1 L=45n W=145n
Mmn11 db SEb dbp VSS g45n1svt M=1 L=45n W=260n
Mmn40 mout CKbb n30 VSS g45n1svt M=1 L=45n W=205n
Mmn25 dbp CKb n20 VSS g45n1svt M=1 L=45n W=205n
Mmn30 mout n20 VSS VSS g45n1svt M=1 L=45n W=205n
Mmn21 CKbb CKb VSS VSS g45n1svt M=1 L=45n W=145n
Mmp3 net429 D1 VDD VDD g45p1svt M=1 L=45n W=390n
Mmp4 db S0b net429 VDD g45p1svt M=1 L=45n W=390n
Mmp2 db S0 net425 VDD g45p1svt M=1 L=45n W=390n
Mmp1 net425 D0 VDD VDD g45p1svt M=1 L=45n W=390n
Mmp13 dbp SEb net417 VDD g45p1svt M=1 L=45n W=390n
Mmp12 net417 SI VDD VDD g45p1svt M=1 L=45n W=390n
Mmp51 n30 CKbb net409 VDD g45p1svt M=1 L=45n W=310n
Mmp50 net409 qbint VDD VDD g45p1svt M=1 L=45n W=310n
Mmp55 Q qbint VDD VDD g45p1svt M=1 L=45n W=3.115u
Mmp35 net393 mout VDD VDD g45p1svt M=1 L=45n W=310n
Mmp36 n20 CKb net393 VDD g45p1svt M=1 L=45n W=310n
Mmp20 CKb CK VDD VDD g45p1svt M=1 L=45n W=215n
Mmp45 qbint n30 VDD VDD g45p1svt M=1 L=45n W=1.17u
Mmp0 S0b S0 VDD VDD g45p1svt M=1 L=45n W=215n
Mmp40 n30 CKb mout VDD g45p1svt M=1 L=45n W=310n
Mmp21 CKbb CKb VDD VDD g45p1svt M=1 L=45n W=215n
Mmp30 mout n20 VDD VDD g45p1svt M=1 L=45n W=310n
Mmp10 SEb SE VDD VDD g45p1svt M=1 L=45n W=215n
Mmp11 dbp SE db VDD g45p1svt M=1 L=45n W=390n
Mmp25 n20 CKbb dbp VDD g45p1svt M=1 L=45n W=310n
.ENDS

.SUBCKT SMDFFHQX4 CK D0 D1 Q S0 SE SI VDD VSS
Mmn3 net510 D1 VSS VSS g45n1svt M=1 L=45n W=260n
Mmn4 db S0 net510 VSS g45n1svt M=1 L=45n W=260n
Mmn2 db S0b net498 VSS g45n1svt M=1 L=45n W=260n
Mmn1 net498 D0 VSS VSS g45n1svt M=1 L=45n W=260n
Mmn13 dbp SE net490 VSS g45n1svt M=1 L=45n W=260n
Mmn12 net490 SI VSS VSS g45n1svt M=1 L=45n W=260n
Mmn55 Q qbint VSS VSS g45n1svt M=1 L=45n W=1.04u
Mmn50 net482 qbint VSS VSS g45n1svt M=1 L=45n W=205n
Mmn51 n30 CKb net482 VSS g45n1svt M=1 L=45n W=205n
Mmn35 net474 mout VSS VSS g45n1svt M=1 L=45n W=205n
Mmn36 n20 CKbb net474 VSS g45n1svt M=1 L=45n W=205n
Mmn20 CKb CK VSS VSS g45n1svt M=1 L=45n W=145n
Mmn45 qbint n30 VSS VSS g45n1svt M=1 L=45n W=410n
Mmn10 SEb SE VSS VSS g45n1svt M=1 L=45n W=145n
Mmn0 S0b S0 VSS VSS g45n1svt M=1 L=45n W=145n
Mmn11 db SEb dbp VSS g45n1svt M=1 L=45n W=260n
Mmn40 mout CKbb n30 VSS g45n1svt M=1 L=45n W=205n
Mmn25 dbp CKb n20 VSS g45n1svt M=1 L=45n W=205n
Mmn30 mout n20 VSS VSS g45n1svt M=1 L=45n W=205n
Mmn21 CKbb CKb VSS VSS g45n1svt M=1 L=45n W=145n
Mmp3 net429 D1 VDD VDD g45p1svt M=1 L=45n W=390n
Mmp4 db S0b net429 VDD g45p1svt M=1 L=45n W=390n
Mmp2 db S0 net425 VDD g45p1svt M=1 L=45n W=390n
Mmp1 net425 D0 VDD VDD g45p1svt M=1 L=45n W=390n
Mmp13 dbp SEb net417 VDD g45p1svt M=1 L=45n W=390n
Mmp12 net417 SI VDD VDD g45p1svt M=1 L=45n W=390n
Mmp51 n30 CKbb net409 VDD g45p1svt M=1 L=45n W=310n
Mmp50 net409 qbint VDD VDD g45p1svt M=1 L=45n W=310n
Mmp55 Q qbint VDD VDD g45p1svt M=1 L=45n W=1.56u
Mmp35 net393 mout VDD VDD g45p1svt M=1 L=45n W=310n
Mmp36 n20 CKb net393 VDD g45p1svt M=1 L=45n W=310n
Mmp20 CKb CK VDD VDD g45p1svt M=1 L=45n W=215n
Mmp45 qbint n30 VDD VDD g45p1svt M=1 L=45n W=620n
Mmp0 S0b S0 VDD VDD g45p1svt M=1 L=45n W=215n
Mmp40 n30 CKb mout VDD g45p1svt M=1 L=45n W=310n
Mmp21 CKbb CKb VDD VDD g45p1svt M=1 L=45n W=215n
Mmp30 mout n20 VDD VDD g45p1svt M=1 L=45n W=310n
Mmp10 SEb SE VDD VDD g45p1svt M=1 L=45n W=215n
Mmp11 dbp SE db VDD g45p1svt M=1 L=45n W=390n
Mmp25 n20 CKbb dbp VDD g45p1svt M=1 L=45n W=310n
.ENDS

.SUBCKT SMDFFHQX2 CK D0 D1 Q S0 SE SI VDD VSS
Mmn3 net510 D1 VSS VSS g45n1svt M=1 L=45n W=260n
Mmn4 db S0 net510 VSS g45n1svt M=1 L=45n W=260n
Mmn2 db S0b net498 VSS g45n1svt M=1 L=45n W=260n
Mmn1 net498 D0 VSS VSS g45n1svt M=1 L=45n W=260n
Mmn13 dbp SE net490 VSS g45n1svt M=1 L=45n W=260n
Mmn12 net490 SI VSS VSS g45n1svt M=1 L=45n W=260n
Mmn55 Q qbint VSS VSS g45n1svt M=1 L=45n W=520n
Mmn50 net482 qbint VSS VSS g45n1svt M=1 L=45n W=205n
Mmn51 n30 CKb net482 VSS g45n1svt M=1 L=45n W=205n
Mmn35 net474 mout VSS VSS g45n1svt M=1 L=45n W=205n
Mmn36 n20 CKbb net474 VSS g45n1svt M=1 L=45n W=205n
Mmn20 CKb CK VSS VSS g45n1svt M=1 L=45n W=145n
Mmn45 qbint n30 VSS VSS g45n1svt M=1 L=45n W=260n
Mmn10 SEb SE VSS VSS g45n1svt M=1 L=45n W=145n
Mmn0 S0b S0 VSS VSS g45n1svt M=1 L=45n W=145n
Mmn11 db SEb dbp VSS g45n1svt M=1 L=45n W=260n
Mmn40 mout CKbb n30 VSS g45n1svt M=1 L=45n W=205n
Mmn25 dbp CKb n20 VSS g45n1svt M=1 L=45n W=205n
Mmn30 mout n20 VSS VSS g45n1svt M=1 L=45n W=205n
Mmn21 CKbb CKb VSS VSS g45n1svt M=1 L=45n W=145n
Mmp3 net429 D1 VDD VDD g45p1svt M=1 L=45n W=390n
Mmp4 db S0b net429 VDD g45p1svt M=1 L=45n W=390n
Mmp2 db S0 net425 VDD g45p1svt M=1 L=45n W=390n
Mmp1 net425 D0 VDD VDD g45p1svt M=1 L=45n W=390n
Mmp13 dbp SEb net417 VDD g45p1svt M=1 L=45n W=390n
Mmp12 net417 SI VDD VDD g45p1svt M=1 L=45n W=390n
Mmp51 n30 CKbb net409 VDD g45p1svt M=1 L=45n W=310n
Mmp50 net409 qbint VDD VDD g45p1svt M=1 L=45n W=310n
Mmp55 Q qbint VDD VDD g45p1svt M=1 L=45n W=780n
Mmp35 net393 mout VDD VDD g45p1svt M=1 L=45n W=310n
Mmp36 n20 CKb net393 VDD g45p1svt M=1 L=45n W=310n
Mmp20 CKb CK VDD VDD g45p1svt M=1 L=45n W=215n
Mmp45 qbint n30 VDD VDD g45p1svt M=1 L=45n W=390n
Mmp0 S0b S0 VDD VDD g45p1svt M=1 L=45n W=215n
Mmp40 n30 CKb mout VDD g45p1svt M=1 L=45n W=310n
Mmp21 CKbb CKb VDD VDD g45p1svt M=1 L=45n W=215n
Mmp30 mout n20 VDD VDD g45p1svt M=1 L=45n W=310n
Mmp10 SEb SE VDD VDD g45p1svt M=1 L=45n W=215n
Mmp11 dbp SE db VDD g45p1svt M=1 L=45n W=390n
Mmp25 n20 CKbb dbp VDD g45p1svt M=1 L=45n W=310n
.ENDS

.SUBCKT SMDFFHQX1 CK D0 D1 Q S0 SE SI VDD VSS
Mmn3 net510 D1 VSS VSS g45n1svt M=1 L=45n W=260n
Mmn4 db S0 net510 VSS g45n1svt M=1 L=45n W=260n
Mmn2 db S0b net498 VSS g45n1svt M=1 L=45n W=260n
Mmn1 net498 D0 VSS VSS g45n1svt M=1 L=45n W=260n
Mmn13 dbp SE net490 VSS g45n1svt M=1 L=45n W=260n
Mmn12 net490 SI VSS VSS g45n1svt M=1 L=45n W=260n
Mmn55 Q qbint VSS VSS g45n1svt M=1 L=45n W=260n
Mmn50 net482 qbint VSS VSS g45n1svt M=1 L=45n W=205n
Mmn51 n30 CKb net482 VSS g45n1svt M=1 L=45n W=205n
Mmn35 net474 mout VSS VSS g45n1svt M=1 L=45n W=205n
Mmn36 n20 CKbb net474 VSS g45n1svt M=1 L=45n W=205n
Mmn20 CKb CK VSS VSS g45n1svt M=1 L=45n W=145n
Mmn45 qbint n30 VSS VSS g45n1svt M=1 L=45n W=205n
Mmn10 SEb SE VSS VSS g45n1svt M=1 L=45n W=145n
Mmn0 S0b S0 VSS VSS g45n1svt M=1 L=45n W=145n
Mmn11 db SEb dbp VSS g45n1svt M=1 L=45n W=260n
Mmn40 mout CKbb n30 VSS g45n1svt M=1 L=45n W=205n
Mmn25 dbp CKb n20 VSS g45n1svt M=1 L=45n W=205n
Mmn30 mout n20 VSS VSS g45n1svt M=1 L=45n W=205n
Mmn21 CKbb CKb VSS VSS g45n1svt M=1 L=45n W=145n
Mmp3 net429 D1 VDD VDD g45p1svt M=1 L=45n W=390n
Mmp4 db S0b net429 VDD g45p1svt M=1 L=45n W=390n
Mmp2 db S0 net425 VDD g45p1svt M=1 L=45n W=390n
Mmp1 net425 D0 VDD VDD g45p1svt M=1 L=45n W=390n
Mmp13 dbp SEb net417 VDD g45p1svt M=1 L=45n W=390n
Mmp12 net417 SI VDD VDD g45p1svt M=1 L=45n W=390n
Mmp51 n30 CKbb net409 VDD g45p1svt M=1 L=45n W=310n
Mmp50 net409 qbint VDD VDD g45p1svt M=1 L=45n W=310n
Mmp55 Q qbint VDD VDD g45p1svt M=1 L=45n W=390n
Mmp35 net393 mout VDD VDD g45p1svt M=1 L=45n W=310n
Mmp36 n20 CKb net393 VDD g45p1svt M=1 L=45n W=310n
Mmp20 CKb CK VDD VDD g45p1svt M=1 L=45n W=215n
Mmp45 qbint n30 VDD VDD g45p1svt M=1 L=45n W=310n
Mmp0 S0b S0 VDD VDD g45p1svt M=1 L=45n W=215n
Mmp40 n30 CKb mout VDD g45p1svt M=1 L=45n W=310n
Mmp21 CKbb CKb VDD VDD g45p1svt M=1 L=45n W=215n
Mmp30 mout n20 VDD VDD g45p1svt M=1 L=45n W=310n
Mmp10 SEb SE VDD VDD g45p1svt M=1 L=45n W=215n
Mmp11 dbp SE db VDD g45p1svt M=1 L=45n W=390n
Mmp25 n20 CKbb dbp VDD g45p1svt M=1 L=45n W=310n
.ENDS

.SUBCKT SEDFFXL CK D E Q QN SE SI VDD VSS
Mmn4 Db E net554 VSS g45n1svt M=1 L=45n W=145n
Mmn3 net554 D VSS VSS g45n1svt M=1 L=45n W=145n
Mmn13 Dbp SE net546 VSS g45n1svt M=1 L=45n W=145n
Mmn12 net546 SI VSS VSS g45n1svt M=1 L=45n W=145n
Mmn57 QN net502 VSS VSS g45n1svt M=1 L=45n W=145n
Mmn55 Q net536 VSS VSS g45n1svt M=1 L=45n W=145n
Mmn50 net534 net536 VSS VSS g45n1svt M=1 L=45n W=145n
Mmn51 n30 CKb net534 VSS g45n1svt M=1 L=45n W=145n
Mmn35 net526 mout VSS VSS g45n1svt M=1 L=45n W=145n
Mmn36 n20 CKbb net526 VSS g45n1svt M=1 L=45n W=145n
Mmn20 CKb CK VSS VSS g45n1svt M=1 L=45n W=145n
Mmn1 net514 net502 VSS VSS g45n1svt M=1 L=45n W=145n
Mmn2 Db Eb net514 VSS g45n1svt M=1 L=45n W=145n
Mmn45 net536 n30 VSS VSS g45n1svt M=1 L=45n W=145n
Mmn56 net502 net536 VSS VSS g45n1svt M=1 L=45n W=145n
Mmn21 CKbb CKb VSS VSS g45n1svt M=1 L=45n W=145n
Mmn40 mout CKbb n30 VSS g45n1svt M=1 L=45n W=145n
Mmn10 SEb SE VSS VSS g45n1svt M=1 L=45n W=145n
Mmn30 mout n20 VSS VSS g45n1svt M=1 L=45n W=145n
Mmn0 Eb E VSS VSS g45n1svt M=1 L=45n W=145n
Mmn25 Dbp CKb n20 VSS g45n1svt M=1 L=45n W=145n
Mmn11 Db SEb Dbp VSS g45n1svt M=1 L=45n W=145n
Mmp4 Db Eb net473 VDD g45p1svt M=1 L=45n W=215n
Mmp3 net473 D VDD VDD g45p1svt M=1 L=45n W=215n
Mmp13 Dbp SEb net465 VDD g45p1svt M=1 L=45n W=215n
Mmp12 net465 SI VDD VDD g45p1svt M=1 L=45n W=215n
Mmp51 n30 CKbb net457 VDD g45p1svt M=1 L=45n W=215n
Mmp50 net457 net536 VDD VDD g45p1svt M=1 L=45n W=215n
Mmp57 QN net502 VDD VDD g45p1svt M=1 L=45n W=215n
Mmp55 Q net536 VDD VDD g45p1svt M=1 L=45n W=215n
Mmp35 net437 mout VDD VDD g45p1svt M=1 L=45n W=215n
Mmp36 n20 CKb net437 VDD g45p1svt M=1 L=45n W=215n
Mmp20 CKb CK VDD VDD g45p1svt M=1 L=45n W=215n
Mmp1 net425 net502 VDD VDD g45p1svt M=1 L=45n W=215n
Mmp2 Db E net425 VDD g45p1svt M=1 L=45n W=215n
Mmp45 net536 n30 VDD VDD g45p1svt M=1 L=45n W=215n
Mmp56 net502 net536 VDD VDD g45p1svt M=1 L=45n W=215n
Mmp21 CKbb CKb VDD VDD g45p1svt M=1 L=45n W=215n
Mmp40 n30 CKb mout VDD g45p1svt M=1 L=45n W=215n
Mmp30 mout n20 VDD VDD g45p1svt M=1 L=45n W=215n
Mmp0 Eb E VDD VDD g45p1svt M=1 L=45n W=215n
Mmp25 n20 CKbb Dbp VDD g45p1svt M=1 L=45n W=215n
Mmp11 Dbp SE Db VDD g45p1svt M=1 L=45n W=215n
Mmp10 SEb SE VDD VDD g45p1svt M=1 L=45n W=215n
.ENDS

.SUBCKT SEDFFX4 CK D E Q QN SE SI VDD VSS
Mmn4 Db E net554 VSS g45n1svt M=1 L=45n W=145n
Mmn3 net554 D VSS VSS g45n1svt M=1 L=45n W=145n
Mmn13 Dbp SE net546 VSS g45n1svt M=1 L=45n W=145n
Mmn12 net546 SI VSS VSS g45n1svt M=1 L=45n W=145n
Mmn57 QN net502 VSS VSS g45n1svt M=1 L=45n W=1.04u
Mmn55 Q net536 VSS VSS g45n1svt M=1 L=45n W=1.04u
Mmn50 net534 net536 VSS VSS g45n1svt M=1 L=45n W=145n
Mmn51 n30 CKb net534 VSS g45n1svt M=1 L=45n W=145n
Mmn35 net526 mout VSS VSS g45n1svt M=1 L=45n W=145n
Mmn36 n20 CKbb net526 VSS g45n1svt M=1 L=45n W=145n
Mmn20 CKb CK VSS VSS g45n1svt M=1 L=45n W=145n
Mmn1 net514 net502 VSS VSS g45n1svt M=1 L=45n W=145n
Mmn2 Db Eb net514 VSS g45n1svt M=1 L=45n W=145n
Mmn45 net536 n30 VSS VSS g45n1svt M=1 L=45n W=410n
Mmn56 net502 net536 VSS VSS g45n1svt M=1 L=45n W=260n
Mmn21 CKbb CKb VSS VSS g45n1svt M=1 L=45n W=145n
Mmn40 mout CKbb n30 VSS g45n1svt M=1 L=45n W=145n
Mmn10 SEb SE VSS VSS g45n1svt M=1 L=45n W=145n
Mmn30 mout n20 VSS VSS g45n1svt M=1 L=45n W=145n
Mmn0 Eb E VSS VSS g45n1svt M=1 L=45n W=145n
Mmn25 Dbp CKb n20 VSS g45n1svt M=1 L=45n W=145n
Mmn11 Db SEb Dbp VSS g45n1svt M=1 L=45n W=145n
Mmp4 Db Eb net473 VDD g45p1svt M=1 L=45n W=215n
Mmp3 net473 D VDD VDD g45p1svt M=1 L=45n W=215n
Mmp13 Dbp SEb net465 VDD g45p1svt M=1 L=45n W=215n
Mmp12 net465 SI VDD VDD g45p1svt M=1 L=45n W=215n
Mmp51 n30 CKbb net457 VDD g45p1svt M=1 L=45n W=215n
Mmp50 net457 net536 VDD VDD g45p1svt M=1 L=45n W=215n
Mmp57 QN net502 VDD VDD g45p1svt M=1 L=45n W=1.56u
Mmp55 Q net536 VDD VDD g45p1svt M=1 L=45n W=1.56u
Mmp35 net437 mout VDD VDD g45p1svt M=1 L=45n W=215n
Mmp36 n20 CKb net437 VDD g45p1svt M=1 L=45n W=215n
Mmp20 CKb CK VDD VDD g45p1svt M=1 L=45n W=215n
Mmp1 net425 net502 VDD VDD g45p1svt M=1 L=45n W=215n
Mmp2 Db E net425 VDD g45p1svt M=1 L=45n W=215n
Mmp45 net536 n30 VDD VDD g45p1svt M=1 L=45n W=620n
Mmp56 net502 net536 VDD VDD g45p1svt M=1 L=45n W=390n
Mmp21 CKbb CKb VDD VDD g45p1svt M=1 L=45n W=215n
Mmp40 n30 CKb mout VDD g45p1svt M=1 L=45n W=215n
Mmp30 mout n20 VDD VDD g45p1svt M=1 L=45n W=215n
Mmp0 Eb E VDD VDD g45p1svt M=1 L=45n W=215n
Mmp25 n20 CKbb Dbp VDD g45p1svt M=1 L=45n W=215n
Mmp11 Dbp SE Db VDD g45p1svt M=1 L=45n W=215n
Mmp10 SEb SE VDD VDD g45p1svt M=1 L=45n W=215n
.ENDS

.SUBCKT SEDFFX2 CK D E Q QN SE SI VDD VSS
Mmn4 Db E net554 VSS g45n1svt M=1 L=45n W=145n
Mmn3 net554 D VSS VSS g45n1svt M=1 L=45n W=145n
Mmn13 Dbp SE net546 VSS g45n1svt M=1 L=45n W=145n
Mmn12 net546 SI VSS VSS g45n1svt M=1 L=45n W=145n
Mmn57 QN net502 VSS VSS g45n1svt M=1 L=45n W=520n
Mmn55 Q net536 VSS VSS g45n1svt M=1 L=45n W=520n
Mmn50 net534 net536 VSS VSS g45n1svt M=1 L=45n W=145n
Mmn51 n30 CKb net534 VSS g45n1svt M=1 L=45n W=145n
Mmn35 net526 mout VSS VSS g45n1svt M=1 L=45n W=145n
Mmn36 n20 CKbb net526 VSS g45n1svt M=1 L=45n W=145n
Mmn20 CKb CK VSS VSS g45n1svt M=1 L=45n W=145n
Mmn1 net514 net502 VSS VSS g45n1svt M=1 L=45n W=145n
Mmn2 Db Eb net514 VSS g45n1svt M=1 L=45n W=145n
Mmn45 net536 n30 VSS VSS g45n1svt M=1 L=45n W=205n
Mmn56 net502 net536 VSS VSS g45n1svt M=1 L=45n W=145n
Mmn21 CKbb CKb VSS VSS g45n1svt M=1 L=45n W=145n
Mmn40 mout CKbb n30 VSS g45n1svt M=1 L=45n W=145n
Mmn10 SEb SE VSS VSS g45n1svt M=1 L=45n W=145n
Mmn30 mout n20 VSS VSS g45n1svt M=1 L=45n W=145n
Mmn0 Eb E VSS VSS g45n1svt M=1 L=45n W=145n
Mmn25 Dbp CKb n20 VSS g45n1svt M=1 L=45n W=145n
Mmn11 Db SEb Dbp VSS g45n1svt M=1 L=45n W=145n
Mmp4 Db Eb net473 VDD g45p1svt M=1 L=45n W=215n
Mmp3 net473 D VDD VDD g45p1svt M=1 L=45n W=215n
Mmp13 Dbp SEb net465 VDD g45p1svt M=1 L=45n W=215n
Mmp12 net465 SI VDD VDD g45p1svt M=1 L=45n W=215n
Mmp51 n30 CKbb net457 VDD g45p1svt M=1 L=45n W=215n
Mmp50 net457 net536 VDD VDD g45p1svt M=1 L=45n W=215n
Mmp57 QN net502 VDD VDD g45p1svt M=1 L=45n W=780n
Mmp55 Q net536 VDD VDD g45p1svt M=1 L=45n W=780n
Mmp35 net437 mout VDD VDD g45p1svt M=1 L=45n W=215n
Mmp36 n20 CKb net437 VDD g45p1svt M=1 L=45n W=215n
Mmp20 CKb CK VDD VDD g45p1svt M=1 L=45n W=215n
Mmp1 net425 net502 VDD VDD g45p1svt M=1 L=45n W=215n
Mmp2 Db E net425 VDD g45p1svt M=1 L=45n W=215n
Mmp45 net536 n30 VDD VDD g45p1svt M=1 L=45n W=310n
Mmp56 net502 net536 VDD VDD g45p1svt M=1 L=45n W=215n
Mmp21 CKbb CKb VDD VDD g45p1svt M=1 L=45n W=215n
Mmp40 n30 CKb mout VDD g45p1svt M=1 L=45n W=215n
Mmp30 mout n20 VDD VDD g45p1svt M=1 L=45n W=215n
Mmp0 Eb E VDD VDD g45p1svt M=1 L=45n W=215n
Mmp25 n20 CKbb Dbp VDD g45p1svt M=1 L=45n W=215n
Mmp11 Dbp SE Db VDD g45p1svt M=1 L=45n W=215n
Mmp10 SEb SE VDD VDD g45p1svt M=1 L=45n W=215n
.ENDS

.SUBCKT SEDFFX1 CK D E Q QN SE SI VDD VSS
Mmn4 Db E net554 VSS g45n1svt M=1 L=45n W=145n
Mmn3 net554 D VSS VSS g45n1svt M=1 L=45n W=145n
Mmn13 Dbp SE net546 VSS g45n1svt M=1 L=45n W=145n
Mmn12 net546 SI VSS VSS g45n1svt M=1 L=45n W=145n
Mmn57 QN net502 VSS VSS g45n1svt M=1 L=45n W=260n
Mmn55 Q net536 VSS VSS g45n1svt M=1 L=45n W=260n
Mmn50 net534 net536 VSS VSS g45n1svt M=1 L=45n W=145n
Mmn51 n30 CKb net534 VSS g45n1svt M=1 L=45n W=145n
Mmn35 net526 mout VSS VSS g45n1svt M=1 L=45n W=145n
Mmn36 n20 CKbb net526 VSS g45n1svt M=1 L=45n W=145n
Mmn20 CKb CK VSS VSS g45n1svt M=1 L=45n W=145n
Mmn1 net514 net502 VSS VSS g45n1svt M=1 L=45n W=145n
Mmn2 Db Eb net514 VSS g45n1svt M=1 L=45n W=145n
Mmn45 net536 n30 VSS VSS g45n1svt M=1 L=45n W=145n
Mmn56 net502 net536 VSS VSS g45n1svt M=1 L=45n W=145n
Mmn21 CKbb CKb VSS VSS g45n1svt M=1 L=45n W=145n
Mmn40 mout CKbb n30 VSS g45n1svt M=1 L=45n W=145n
Mmn10 SEb SE VSS VSS g45n1svt M=1 L=45n W=145n
Mmn30 mout n20 VSS VSS g45n1svt M=1 L=45n W=145n
Mmn0 Eb E VSS VSS g45n1svt M=1 L=45n W=145n
Mmn25 Dbp CKb n20 VSS g45n1svt M=1 L=45n W=145n
Mmn11 Db SEb Dbp VSS g45n1svt M=1 L=45n W=145n
Mmp4 Db Eb net473 VDD g45p1svt M=1 L=45n W=215n
Mmp3 net473 D VDD VDD g45p1svt M=1 L=45n W=215n
Mmp13 Dbp SEb net465 VDD g45p1svt M=1 L=45n W=215n
Mmp12 net465 SI VDD VDD g45p1svt M=1 L=45n W=215n
Mmp51 n30 CKbb net457 VDD g45p1svt M=1 L=45n W=215n
Mmp50 net457 net536 VDD VDD g45p1svt M=1 L=45n W=215n
Mmp57 QN net502 VDD VDD g45p1svt M=1 L=45n W=390n
Mmp55 Q net536 VDD VDD g45p1svt M=1 L=45n W=390n
Mmp35 net437 mout VDD VDD g45p1svt M=1 L=45n W=215n
Mmp36 n20 CKb net437 VDD g45p1svt M=1 L=45n W=215n
Mmp20 CKb CK VDD VDD g45p1svt M=1 L=45n W=215n
Mmp1 net425 net502 VDD VDD g45p1svt M=1 L=45n W=215n
Mmp2 Db E net425 VDD g45p1svt M=1 L=45n W=215n
Mmp45 net536 n30 VDD VDD g45p1svt M=1 L=45n W=215n
Mmp56 net502 net536 VDD VDD g45p1svt M=1 L=45n W=215n
Mmp21 CKbb CKb VDD VDD g45p1svt M=1 L=45n W=215n
Mmp40 n30 CKb mout VDD g45p1svt M=1 L=45n W=215n
Mmp30 mout n20 VDD VDD g45p1svt M=1 L=45n W=215n
Mmp0 Eb E VDD VDD g45p1svt M=1 L=45n W=215n
Mmp25 n20 CKbb Dbp VDD g45p1svt M=1 L=45n W=215n
Mmp11 Dbp SE Db VDD g45p1svt M=1 L=45n W=215n
Mmp10 SEb SE VDD VDD g45p1svt M=1 L=45n W=215n
.ENDS

.SUBCKT SEDFFTRXL CK D E Q QN RN SE SI VDD VSS
Mmn14 Dpb SE net658 VSS g45n1svt M=1 L=45n W=145n
Mmn13 net658 SI VSS VSS g45n1svt M=1 L=45n W=145n
Mmn12 Dpb SEb net650 VSS g45n1svt M=1 L=45n W=145n
Mmn11 net650 Dp VSS VSS g45n1svt M=1 L=45n W=145n
Mmn1 Db D VSS VSS g45n1svt M=1 L=45n W=145n
Mmn7 Dp Db net638 VSS g45n1svt M=1 L=45n W=145n
Mmn6 net638 E VSS VSS g45n1svt M=1 L=45n W=145n
Mmn4 net634 Eb VSS VSS g45n1svt M=1 L=45n W=145n
Mmn5 Dp qbint net634 VSS g45n1svt M=1 L=45n W=145n
Mmn57 QN net582 VSS VSS g45n1svt M=1 L=45n W=145n
Mmn55 Q qbint VSS VSS g45n1svt M=1 L=45n W=145n
Mmn50 net618 qbint VSS VSS g45n1svt M=1 L=45n W=145n
Mmn51 n30 CKb net618 VSS g45n1svt M=1 L=45n W=145n
Mmn36 n20 CKbb net606 VSS g45n1svt M=1 L=45n W=145n
Mmn35 net606 mout VSS VSS g45n1svt M=1 L=45n W=145n
Mmn20 CKb CK VSS VSS g45n1svt M=1 L=45n W=145n
Mmn2 RNb RN VSS VSS g45n1svt M=1 L=45n W=145n
Mmn10 SEb SE VSS VSS g45n1svt M=1 L=45n W=145n
Mmn0 Eb E VSS VSS g45n1svt M=1 L=45n W=145n
Mmn3 Dp RNb VSS VSS g45n1svt M=1 L=45n W=145n
Mmn56 net582 qbint VSS VSS g45n1svt M=1 L=45n W=145n
Mmn45 qbint n30 VSS VSS g45n1svt M=1 L=45n W=145n
Mmn30 mout n20 VSS VSS g45n1svt M=1 L=45n W=145n
Mmn25 n20 CKb Dpb VSS g45n1svt M=1 L=45n W=145n
Mmn40 n30 CKbb mout VSS g45n1svt M=1 L=45n W=145n
Mmn21 CKbb CKb VSS VSS g45n1svt M=1 L=45n W=145n
Mmp13 net557 SI VDD VDD g45p1svt M=1 L=45n W=215n
Mmp14 Dpb SEb net557 VDD g45p1svt M=1 L=45n W=215n
Mmp11 net549 Dp VDD VDD g45p1svt M=1 L=45n W=215n
Mmp12 Dpb SE net549 VDD g45p1svt M=1 L=45n W=215n
Mmp1 Db D VDD VDD g45p1svt M=1 L=45n W=215n
Mmp57 QN net582 VDD VDD g45p1svt M=1 L=45n W=215n
Mmp55 Q qbint VDD VDD g45p1svt M=1 L=45n W=215n
Mmp50 net529 qbint VDD VDD g45p1svt M=1 L=45n W=215n
Mmp51 n30 CKbb net529 VDD g45p1svt M=1 L=45n W=215n
Mmp35 net521 mout VDD VDD g45p1svt M=1 L=45n W=215n
Mmp36 n20 CKb net521 VDD g45p1svt M=1 L=45n W=215n
Mmp20 CKb CK VDD VDD g45p1svt M=1 L=45n W=215n
Mmp2 RNb RN VDD VDD g45p1svt M=1 L=45n W=215n
Mmp7 Dp Db net505 VDD g45p1svt M=1 L=45n W=215n
Mmp6 Dp E net505 VDD g45p1svt M=1 L=45n W=215n
Mmp10 SEb SE VDD VDD g45p1svt M=1 L=45n W=215n
Mmp0 Eb E VDD VDD g45p1svt M=1 L=45n W=215n
Mmp4 net505 Eb net493 VDD g45p1svt M=1 L=45n W=215n
Mmp5 net505 qbint net493 VDD g45p1svt M=1 L=45n W=215n
Mmp3 net493 RNb VDD VDD g45p1svt M=1 L=45n W=215n
Mmp56 net582 qbint VDD VDD g45p1svt M=1 L=45n W=215n
Mmp45 qbint n30 VDD VDD g45p1svt M=1 L=45n W=215n
Mmp30 mout n20 VDD VDD g45p1svt M=1 L=45n W=215n
Mmp40 n30 CKb mout VDD g45p1svt M=1 L=45n W=215n
Mmp21 CKbb CKb VDD VDD g45p1svt M=1 L=45n W=215n
Mmp25 n20 CKbb Dpb VDD g45p1svt M=1 L=45n W=215n
.ENDS

.SUBCKT SEDFFTRX4 CK D E Q QN RN SE SI VDD VSS
Mmn14 Dpb SE net658 VSS g45n1svt M=1 L=45n W=145n
Mmn13 net658 SI VSS VSS g45n1svt M=1 L=45n W=145n
Mmn12 Dpb SEb net650 VSS g45n1svt M=1 L=45n W=145n
Mmn11 net650 Dp VSS VSS g45n1svt M=1 L=45n W=145n
Mmn1 Db D VSS VSS g45n1svt M=1 L=45n W=145n
Mmn7 Dp Db net638 VSS g45n1svt M=1 L=45n W=145n
Mmn6 net638 E VSS VSS g45n1svt M=1 L=45n W=145n
Mmn4 net634 Eb VSS VSS g45n1svt M=1 L=45n W=145n
Mmn5 Dp qbint net634 VSS g45n1svt M=1 L=45n W=145n
Mmn57 QN net582 VSS VSS g45n1svt M=1 L=45n W=1.04u
Mmn55 Q qbint VSS VSS g45n1svt M=1 L=45n W=1.04u
Mmn50 net618 qbint VSS VSS g45n1svt M=1 L=45n W=145n
Mmn51 n30 CKb net618 VSS g45n1svt M=1 L=45n W=145n
Mmn36 n20 CKbb net606 VSS g45n1svt M=1 L=45n W=145n
Mmn35 net606 mout VSS VSS g45n1svt M=1 L=45n W=145n
Mmn20 CKb CK VSS VSS g45n1svt M=1 L=45n W=145n
Mmn2 RNb RN VSS VSS g45n1svt M=1 L=45n W=145n
Mmn10 SEb SE VSS VSS g45n1svt M=1 L=45n W=145n
Mmn0 Eb E VSS VSS g45n1svt M=1 L=45n W=145n
Mmn3 Dp RNb VSS VSS g45n1svt M=1 L=45n W=145n
Mmn56 net582 qbint VSS VSS g45n1svt M=1 L=45n W=260n
Mmn45 qbint n30 VSS VSS g45n1svt M=1 L=45n W=410n
Mmn30 mout n20 VSS VSS g45n1svt M=1 L=45n W=145n
Mmn25 n20 CKb Dpb VSS g45n1svt M=1 L=45n W=145n
Mmn40 n30 CKbb mout VSS g45n1svt M=1 L=45n W=145n
Mmn21 CKbb CKb VSS VSS g45n1svt M=1 L=45n W=145n
Mmp13 net557 SI VDD VDD g45p1svt M=1 L=45n W=215n
Mmp14 Dpb SEb net557 VDD g45p1svt M=1 L=45n W=215n
Mmp11 net549 Dp VDD VDD g45p1svt M=1 L=45n W=215n
Mmp12 Dpb SE net549 VDD g45p1svt M=1 L=45n W=215n
Mmp1 Db D VDD VDD g45p1svt M=1 L=45n W=215n
Mmp57 QN net582 VDD VDD g45p1svt M=1 L=45n W=1.56u
Mmp55 Q qbint VDD VDD g45p1svt M=1 L=45n W=1.56u
Mmp50 net529 qbint VDD VDD g45p1svt M=1 L=45n W=215n
Mmp51 n30 CKbb net529 VDD g45p1svt M=1 L=45n W=215n
Mmp35 net521 mout VDD VDD g45p1svt M=1 L=45n W=215n
Mmp36 n20 CKb net521 VDD g45p1svt M=1 L=45n W=215n
Mmp20 CKb CK VDD VDD g45p1svt M=1 L=45n W=215n
Mmp2 RNb RN VDD VDD g45p1svt M=1 L=45n W=215n
Mmp7 Dp Db net505 VDD g45p1svt M=1 L=45n W=215n
Mmp6 Dp E net505 VDD g45p1svt M=1 L=45n W=215n
Mmp10 SEb SE VDD VDD g45p1svt M=1 L=45n W=215n
Mmp0 Eb E VDD VDD g45p1svt M=1 L=45n W=215n
Mmp4 net505 Eb net493 VDD g45p1svt M=1 L=45n W=215n
Mmp5 net505 qbint net493 VDD g45p1svt M=1 L=45n W=215n
Mmp3 net493 RNb VDD VDD g45p1svt M=1 L=45n W=215n
Mmp56 net582 qbint VDD VDD g45p1svt M=1 L=45n W=390n
Mmp45 qbint n30 VDD VDD g45p1svt M=1 L=45n W=620n
Mmp30 mout n20 VDD VDD g45p1svt M=1 L=45n W=215n
Mmp40 n30 CKb mout VDD g45p1svt M=1 L=45n W=215n
Mmp21 CKbb CKb VDD VDD g45p1svt M=1 L=45n W=215n
Mmp25 n20 CKbb Dpb VDD g45p1svt M=1 L=45n W=215n
.ENDS

.SUBCKT SEDFFTRX2 CK D E Q QN RN SE SI VDD VSS
Mmn14 Dpb SE net658 VSS g45n1svt M=1 L=45n W=145n
Mmn13 net658 SI VSS VSS g45n1svt M=1 L=45n W=145n
Mmn12 Dpb SEb net650 VSS g45n1svt M=1 L=45n W=145n
Mmn11 net650 Dp VSS VSS g45n1svt M=1 L=45n W=145n
Mmn1 Db D VSS VSS g45n1svt M=1 L=45n W=145n
Mmn7 Dp Db net638 VSS g45n1svt M=1 L=45n W=145n
Mmn6 net638 E VSS VSS g45n1svt M=1 L=45n W=145n
Mmn4 net634 Eb VSS VSS g45n1svt M=1 L=45n W=145n
Mmn5 Dp qbint net634 VSS g45n1svt M=1 L=45n W=145n
Mmn57 QN net582 VSS VSS g45n1svt M=1 L=45n W=520n
Mmn55 Q qbint VSS VSS g45n1svt M=1 L=45n W=520n
Mmn50 net618 qbint VSS VSS g45n1svt M=1 L=45n W=145n
Mmn51 n30 CKb net618 VSS g45n1svt M=1 L=45n W=145n
Mmn36 n20 CKbb net606 VSS g45n1svt M=1 L=45n W=145n
Mmn35 net606 mout VSS VSS g45n1svt M=1 L=45n W=145n
Mmn20 CKb CK VSS VSS g45n1svt M=1 L=45n W=145n
Mmn2 RNb RN VSS VSS g45n1svt M=1 L=45n W=145n
Mmn10 SEb SE VSS VSS g45n1svt M=1 L=45n W=145n
Mmn0 Eb E VSS VSS g45n1svt M=1 L=45n W=145n
Mmn3 Dp RNb VSS VSS g45n1svt M=1 L=45n W=145n
Mmn56 net582 qbint VSS VSS g45n1svt M=1 L=45n W=145n
Mmn45 qbint n30 VSS VSS g45n1svt M=1 L=45n W=205n
Mmn30 mout n20 VSS VSS g45n1svt M=1 L=45n W=145n
Mmn25 n20 CKb Dpb VSS g45n1svt M=1 L=45n W=145n
Mmn40 n30 CKbb mout VSS g45n1svt M=1 L=45n W=145n
Mmn21 CKbb CKb VSS VSS g45n1svt M=1 L=45n W=145n
Mmp13 net557 SI VDD VDD g45p1svt M=1 L=45n W=215n
Mmp14 Dpb SEb net557 VDD g45p1svt M=1 L=45n W=215n
Mmp11 net549 Dp VDD VDD g45p1svt M=1 L=45n W=215n
Mmp12 Dpb SE net549 VDD g45p1svt M=1 L=45n W=215n
Mmp1 Db D VDD VDD g45p1svt M=1 L=45n W=215n
Mmp57 QN net582 VDD VDD g45p1svt M=1 L=45n W=780n
Mmp55 Q qbint VDD VDD g45p1svt M=1 L=45n W=780n
Mmp50 net529 qbint VDD VDD g45p1svt M=1 L=45n W=215n
Mmp51 n30 CKbb net529 VDD g45p1svt M=1 L=45n W=215n
Mmp35 net521 mout VDD VDD g45p1svt M=1 L=45n W=215n
Mmp36 n20 CKb net521 VDD g45p1svt M=1 L=45n W=215n
Mmp20 CKb CK VDD VDD g45p1svt M=1 L=45n W=215n
Mmp2 RNb RN VDD VDD g45p1svt M=1 L=45n W=215n
Mmp7 Dp Db net505 VDD g45p1svt M=1 L=45n W=215n
Mmp6 Dp E net505 VDD g45p1svt M=1 L=45n W=215n
Mmp10 SEb SE VDD VDD g45p1svt M=1 L=45n W=215n
Mmp0 Eb E VDD VDD g45p1svt M=1 L=45n W=215n
Mmp4 net505 Eb net493 VDD g45p1svt M=1 L=45n W=215n
Mmp5 net505 qbint net493 VDD g45p1svt M=1 L=45n W=215n
Mmp3 net493 RNb VDD VDD g45p1svt M=1 L=45n W=215n
Mmp56 net582 qbint VDD VDD g45p1svt M=1 L=45n W=215n
Mmp45 qbint n30 VDD VDD g45p1svt M=1 L=45n W=310n
Mmp30 mout n20 VDD VDD g45p1svt M=1 L=45n W=215n
Mmp40 n30 CKb mout VDD g45p1svt M=1 L=45n W=215n
Mmp21 CKbb CKb VDD VDD g45p1svt M=1 L=45n W=215n
Mmp25 n20 CKbb Dpb VDD g45p1svt M=1 L=45n W=215n
.ENDS

.SUBCKT SEDFFTRX1 CK D E Q QN RN SE SI VDD VSS
Mmn14 Dpb SE net658 VSS g45n1svt M=1 L=45n W=145n
Mmn13 net658 SI VSS VSS g45n1svt M=1 L=45n W=145n
Mmn12 Dpb SEb net650 VSS g45n1svt M=1 L=45n W=145n
Mmn11 net650 Dp VSS VSS g45n1svt M=1 L=45n W=145n
Mmn1 Db D VSS VSS g45n1svt M=1 L=45n W=145n
Mmn7 Dp Db net638 VSS g45n1svt M=1 L=45n W=145n
Mmn6 net638 E VSS VSS g45n1svt M=1 L=45n W=145n
Mmn4 net634 Eb VSS VSS g45n1svt M=1 L=45n W=145n
Mmn5 Dp qbint net634 VSS g45n1svt M=1 L=45n W=145n
Mmn57 QN net582 VSS VSS g45n1svt M=1 L=45n W=260n
Mmn55 Q qbint VSS VSS g45n1svt M=1 L=45n W=260n
Mmn50 net618 qbint VSS VSS g45n1svt M=1 L=45n W=145n
Mmn51 n30 CKb net618 VSS g45n1svt M=1 L=45n W=145n
Mmn36 n20 CKbb net606 VSS g45n1svt M=1 L=45n W=145n
Mmn35 net606 mout VSS VSS g45n1svt M=1 L=45n W=145n
Mmn20 CKb CK VSS VSS g45n1svt M=1 L=45n W=145n
Mmn2 RNb RN VSS VSS g45n1svt M=1 L=45n W=145n
Mmn10 SEb SE VSS VSS g45n1svt M=1 L=45n W=145n
Mmn0 Eb E VSS VSS g45n1svt M=1 L=45n W=145n
Mmn3 Dp RNb VSS VSS g45n1svt M=1 L=45n W=145n
Mmn56 net582 qbint VSS VSS g45n1svt M=1 L=45n W=145n
Mmn45 qbint n30 VSS VSS g45n1svt M=1 L=45n W=145n
Mmn30 mout n20 VSS VSS g45n1svt M=1 L=45n W=145n
Mmn25 n20 CKb Dpb VSS g45n1svt M=1 L=45n W=145n
Mmn40 n30 CKbb mout VSS g45n1svt M=1 L=45n W=145n
Mmn21 CKbb CKb VSS VSS g45n1svt M=1 L=45n W=145n
Mmp13 net557 SI VDD VDD g45p1svt M=1 L=45n W=215n
Mmp14 Dpb SEb net557 VDD g45p1svt M=1 L=45n W=215n
Mmp11 net549 Dp VDD VDD g45p1svt M=1 L=45n W=215n
Mmp12 Dpb SE net549 VDD g45p1svt M=1 L=45n W=215n
Mmp1 Db D VDD VDD g45p1svt M=1 L=45n W=215n
Mmp57 QN net582 VDD VDD g45p1svt M=1 L=45n W=390n
Mmp55 Q qbint VDD VDD g45p1svt M=1 L=45n W=390n
Mmp50 net529 qbint VDD VDD g45p1svt M=1 L=45n W=215n
Mmp51 n30 CKbb net529 VDD g45p1svt M=1 L=45n W=215n
Mmp35 net521 mout VDD VDD g45p1svt M=1 L=45n W=215n
Mmp36 n20 CKb net521 VDD g45p1svt M=1 L=45n W=215n
Mmp20 CKb CK VDD VDD g45p1svt M=1 L=45n W=215n
Mmp2 RNb RN VDD VDD g45p1svt M=1 L=45n W=215n
Mmp7 Dp Db net505 VDD g45p1svt M=1 L=45n W=215n
Mmp6 Dp E net505 VDD g45p1svt M=1 L=45n W=215n
Mmp10 SEb SE VDD VDD g45p1svt M=1 L=45n W=215n
Mmp0 Eb E VDD VDD g45p1svt M=1 L=45n W=215n
Mmp4 net505 Eb net493 VDD g45p1svt M=1 L=45n W=215n
Mmp5 net505 qbint net493 VDD g45p1svt M=1 L=45n W=215n
Mmp3 net493 RNb VDD VDD g45p1svt M=1 L=45n W=215n
Mmp56 net582 qbint VDD VDD g45p1svt M=1 L=45n W=215n
Mmp45 qbint n30 VDD VDD g45p1svt M=1 L=45n W=215n
Mmp30 mout n20 VDD VDD g45p1svt M=1 L=45n W=215n
Mmp40 n30 CKb mout VDD g45p1svt M=1 L=45n W=215n
Mmp21 CKbb CKb VDD VDD g45p1svt M=1 L=45n W=215n
Mmp25 n20 CKbb Dpb VDD g45p1svt M=1 L=45n W=215n
.ENDS

.SUBCKT SEDFFHQX8 CK D E Q SE SI VDD VSS
Mmn4 Db E net526 VSS g45n1svt M=1 L=45n W=260n
Mmn3 net526 D VSS VSS g45n1svt M=1 L=45n W=260n
Mmn13 Dbp SE net518 VSS g45n1svt M=1 L=45n W=260n
Mmn12 net518 SI VSS VSS g45n1svt M=1 L=45n W=260n
Mmn55 Q qbint VSS VSS g45n1svt M=1 L=45n W=2.065u
Mmn50 net509 qbint VSS VSS g45n1svt M=1 L=45n W=205n
Mmn51 n30 CKb net509 VSS g45n1svt M=1 L=45n W=205n
Mmn35 net501 mout VSS VSS g45n1svt M=1 L=45n W=205n
Mmn36 n20 Ckbb net501 VSS g45n1svt M=1 L=45n W=205n
Mmn1 net494 qint VSS VSS g45n1svt M=1 L=45n W=260n
Mmn2 Db Eb net494 VSS g45n1svt M=1 L=45n W=260n
Mmn45 qbint n30 VSS VSS g45n1svt M=1 L=45n W=780n
Mmn56 qint qbint VSS VSS g45n1svt M=1 L=45n W=520n
Mmn21 Ckbb CKb VSS VSS g45n1svt M=1 L=45n W=145n
Mmn40 n30 Ckbb mout VSS g45n1svt M=1 L=45n W=205n
Mmn30 mout n20 VSS VSS g45n1svt M=1 L=45n W=205n
Mmn10 SEb SE VSS VSS g45n1svt M=1 L=45n W=145n
Mmn0 Eb E VSS VSS g45n1svt M=1 L=45n W=145n
Mmn25 n20 CKb Dbp VSS g45n1svt M=1 L=45n W=205n
Mmn20 CKb CK VSS VSS g45n1svt M=1 L=45n W=145n
Mmn11 Db SEb Dbp VSS g45n1svt M=1 L=45n W=260n
Mmp4 Db Eb net449 VDD g45p1svt M=1 L=45n W=390n
Mmp3 net449 D VDD VDD g45p1svt M=1 L=45n W=390n
Mmp13 Dbp SEb net441 VDD g45p1svt M=1 L=45n W=390n
Mmp12 net441 SI VDD VDD g45p1svt M=1 L=45n W=390n
Mmp51 n30 Ckbb net426 VDD g45p1svt M=1 L=45n W=310n
Mmp50 net426 qbint VDD VDD g45p1svt M=1 L=45n W=310n
Mmp55 Q qbint VDD VDD g45p1svt M=1 L=45n W=3.115u
Mmp35 net417 mout VDD VDD g45p1svt M=1 L=45n W=310n
Mmp36 n20 CKb net417 VDD g45p1svt M=1 L=45n W=310n
Mmp20 CKb CK VDD VDD g45p1svt M=1 L=45n W=215n
Mmp1 net405 qint VDD VDD g45p1svt M=1 L=45n W=390n
Mmp2 Db E net405 VDD g45p1svt M=1 L=45n W=390n
Mmp45 qbint n30 VDD VDD g45p1svt M=1 L=45n W=1.17u
Mmp56 qint qbint VDD VDD g45p1svt M=1 L=45n W=780n
Mmp21 Ckbb CKb VDD VDD g45p1svt M=1 L=45n W=215n
Mmp40 n30 CKb mout VDD g45p1svt M=1 L=45n W=310n
Mmp30 mout n20 VDD VDD g45p1svt M=1 L=45n W=310n
Mmp11 Db SE Dbp VDD g45p1svt M=1 L=45n W=390n
Mmp10 SEb SE VDD VDD g45p1svt M=1 L=45n W=215n
Mmp0 Eb E VDD VDD g45p1svt M=1 L=45n W=215n
Mmp25 n20 Ckbb Dbp VDD g45p1svt M=1 L=45n W=310n
.ENDS

.SUBCKT SEDFFHQX4 CK D E Q SE SI VDD VSS
Mmn4 Db E net526 VSS g45n1svt M=1 L=45n W=260n
Mmn3 net526 D VSS VSS g45n1svt M=1 L=45n W=260n
Mmn13 Dbp SE net518 VSS g45n1svt M=1 L=45n W=260n
Mmn12 net518 SI VSS VSS g45n1svt M=1 L=45n W=260n
Mmn55 Q qbint VSS VSS g45n1svt M=1 L=45n W=1.04u
Mmn50 net509 qbint VSS VSS g45n1svt M=1 L=45n W=205n
Mmn51 n30 CKb net509 VSS g45n1svt M=1 L=45n W=205n
Mmn35 net501 mout VSS VSS g45n1svt M=1 L=45n W=205n
Mmn36 n20 Ckbb net501 VSS g45n1svt M=1 L=45n W=205n
Mmn1 net494 qint VSS VSS g45n1svt M=1 L=45n W=260n
Mmn2 Db Eb net494 VSS g45n1svt M=1 L=45n W=260n
Mmn45 qbint n30 VSS VSS g45n1svt M=1 L=45n W=410n
Mmn56 qint qbint VSS VSS g45n1svt M=1 L=45n W=260n
Mmn21 Ckbb CKb VSS VSS g45n1svt M=1 L=45n W=145n
Mmn40 n30 Ckbb mout VSS g45n1svt M=1 L=45n W=205n
Mmn30 mout n20 VSS VSS g45n1svt M=1 L=45n W=205n
Mmn10 SEb SE VSS VSS g45n1svt M=1 L=45n W=145n
Mmn0 Eb E VSS VSS g45n1svt M=1 L=45n W=145n
Mmn25 n20 CKb Dbp VSS g45n1svt M=1 L=45n W=205n
Mmn20 CKb CK VSS VSS g45n1svt M=1 L=45n W=145n
Mmn11 Db SEb Dbp VSS g45n1svt M=1 L=45n W=260n
Mmp4 Db Eb net449 VDD g45p1svt M=1 L=45n W=390n
Mmp3 net449 D VDD VDD g45p1svt M=1 L=45n W=390n
Mmp13 Dbp SEb net441 VDD g45p1svt M=1 L=45n W=390n
Mmp12 net441 SI VDD VDD g45p1svt M=1 L=45n W=390n
Mmp51 n30 Ckbb net426 VDD g45p1svt M=1 L=45n W=310n
Mmp50 net426 qbint VDD VDD g45p1svt M=1 L=45n W=310n
Mmp55 Q qbint VDD VDD g45p1svt M=1 L=45n W=1.56u
Mmp35 net417 mout VDD VDD g45p1svt M=1 L=45n W=310n
Mmp36 n20 CKb net417 VDD g45p1svt M=1 L=45n W=310n
Mmp20 CKb CK VDD VDD g45p1svt M=1 L=45n W=215n
Mmp1 net405 qint VDD VDD g45p1svt M=1 L=45n W=390n
Mmp2 Db E net405 VDD g45p1svt M=1 L=45n W=390n
Mmp45 qbint n30 VDD VDD g45p1svt M=1 L=45n W=620n
Mmp56 qint qbint VDD VDD g45p1svt M=1 L=45n W=390n
Mmp21 Ckbb CKb VDD VDD g45p1svt M=1 L=45n W=215n
Mmp40 n30 CKb mout VDD g45p1svt M=1 L=45n W=310n
Mmp30 mout n20 VDD VDD g45p1svt M=1 L=45n W=310n
Mmp11 Db SE Dbp VDD g45p1svt M=1 L=45n W=390n
Mmp10 SEb SE VDD VDD g45p1svt M=1 L=45n W=215n
Mmp0 Eb E VDD VDD g45p1svt M=1 L=45n W=215n
Mmp25 n20 Ckbb Dbp VDD g45p1svt M=1 L=45n W=310n
.ENDS

.SUBCKT SEDFFHQX2 CK D E Q SE SI VDD VSS
Mmn4 Db E net526 VSS g45n1svt M=1 L=45n W=260n
Mmn3 net526 D VSS VSS g45n1svt M=1 L=45n W=260n
Mmn13 Dbp SE net518 VSS g45n1svt M=1 L=45n W=260n
Mmn12 net518 SI VSS VSS g45n1svt M=1 L=45n W=260n
Mmn55 Q qbint VSS VSS g45n1svt M=1 L=45n W=520n
Mmn50 net509 qbint VSS VSS g45n1svt M=1 L=45n W=205n
Mmn51 n30 CKb net509 VSS g45n1svt M=1 L=45n W=205n
Mmn35 net501 mout VSS VSS g45n1svt M=1 L=45n W=205n
Mmn36 n20 Ckbb net501 VSS g45n1svt M=1 L=45n W=205n
Mmn1 net494 qint VSS VSS g45n1svt M=1 L=45n W=260n
Mmn2 Db Eb net494 VSS g45n1svt M=1 L=45n W=260n
Mmn45 qbint n30 VSS VSS g45n1svt M=1 L=45n W=260n
Mmn56 qint qbint VSS VSS g45n1svt M=1 L=45n W=205n
Mmn21 Ckbb CKb VSS VSS g45n1svt M=1 L=45n W=145n
Mmn40 n30 Ckbb mout VSS g45n1svt M=1 L=45n W=205n
Mmn30 mout n20 VSS VSS g45n1svt M=1 L=45n W=205n
Mmn10 SEb SE VSS VSS g45n1svt M=1 L=45n W=145n
Mmn0 Eb E VSS VSS g45n1svt M=1 L=45n W=145n
Mmn25 n20 CKb Dbp VSS g45n1svt M=1 L=45n W=205n
Mmn20 CKb CK VSS VSS g45n1svt M=1 L=45n W=145n
Mmn11 Db SEb Dbp VSS g45n1svt M=1 L=45n W=260n
Mmp4 Db Eb net449 VDD g45p1svt M=1 L=45n W=390n
Mmp3 net449 D VDD VDD g45p1svt M=1 L=45n W=390n
Mmp13 Dbp SEb net441 VDD g45p1svt M=1 L=45n W=390n
Mmp12 net441 SI VDD VDD g45p1svt M=1 L=45n W=390n
Mmp51 n30 Ckbb net426 VDD g45p1svt M=1 L=45n W=310n
Mmp50 net426 qbint VDD VDD g45p1svt M=1 L=45n W=310n
Mmp55 Q qbint VDD VDD g45p1svt M=1 L=45n W=780n
Mmp35 net417 mout VDD VDD g45p1svt M=1 L=45n W=310n
Mmp36 n20 CKb net417 VDD g45p1svt M=1 L=45n W=310n
Mmp20 CKb CK VDD VDD g45p1svt M=1 L=45n W=215n
Mmp1 net405 qint VDD VDD g45p1svt M=1 L=45n W=390n
Mmp2 Db E net405 VDD g45p1svt M=1 L=45n W=390n
Mmp45 qbint n30 VDD VDD g45p1svt M=1 L=45n W=390n
Mmp56 qint qbint VDD VDD g45p1svt M=1 L=45n W=310n
Mmp21 Ckbb CKb VDD VDD g45p1svt M=1 L=45n W=215n
Mmp40 n30 CKb mout VDD g45p1svt M=1 L=45n W=310n
Mmp30 mout n20 VDD VDD g45p1svt M=1 L=45n W=310n
Mmp11 Db SE Dbp VDD g45p1svt M=1 L=45n W=390n
Mmp10 SEb SE VDD VDD g45p1svt M=1 L=45n W=215n
Mmp0 Eb E VDD VDD g45p1svt M=1 L=45n W=215n
Mmp25 n20 Ckbb Dbp VDD g45p1svt M=1 L=45n W=310n
.ENDS

.SUBCKT SEDFFHQX1 CK D E Q SE SI VDD VSS
Mmn4 Db E net526 VSS g45n1svt M=1 L=45n W=260n
Mmn3 net526 D VSS VSS g45n1svt M=1 L=45n W=260n
Mmn13 Dbp SE net518 VSS g45n1svt M=1 L=45n W=260n
Mmn12 net518 SI VSS VSS g45n1svt M=1 L=45n W=260n
Mmn55 Q qbint VSS VSS g45n1svt M=1 L=45n W=260n
Mmn50 net509 qbint VSS VSS g45n1svt M=1 L=45n W=205n
Mmn51 n30 CKb net509 VSS g45n1svt M=1 L=45n W=205n
Mmn35 net501 mout VSS VSS g45n1svt M=1 L=45n W=205n
Mmn36 n20 Ckbb net501 VSS g45n1svt M=1 L=45n W=205n
Mmn1 net494 qint VSS VSS g45n1svt M=1 L=45n W=260n
Mmn2 Db Eb net494 VSS g45n1svt M=1 L=45n W=260n
Mmn45 qbint n30 VSS VSS g45n1svt M=1 L=45n W=205n
Mmn56 qint qbint VSS VSS g45n1svt M=1 L=45n W=205n
Mmn21 Ckbb CKb VSS VSS g45n1svt M=1 L=45n W=145n
Mmn40 n30 Ckbb mout VSS g45n1svt M=1 L=45n W=205n
Mmn30 mout n20 VSS VSS g45n1svt M=1 L=45n W=205n
Mmn10 SEb SE VSS VSS g45n1svt M=1 L=45n W=145n
Mmn0 Eb E VSS VSS g45n1svt M=1 L=45n W=145n
Mmn25 n20 CKb Dbp VSS g45n1svt M=1 L=45n W=205n
Mmn20 CKb CK VSS VSS g45n1svt M=1 L=45n W=145n
Mmn11 Db SEb Dbp VSS g45n1svt M=1 L=45n W=260n
Mmp4 Db Eb net449 VDD g45p1svt M=1 L=45n W=390n
Mmp3 net449 D VDD VDD g45p1svt M=1 L=45n W=390n
Mmp13 Dbp SEb net441 VDD g45p1svt M=1 L=45n W=390n
Mmp12 net441 SI VDD VDD g45p1svt M=1 L=45n W=390n
Mmp51 n30 Ckbb net426 VDD g45p1svt M=1 L=45n W=310n
Mmp50 net426 qbint VDD VDD g45p1svt M=1 L=45n W=310n
Mmp55 Q qbint VDD VDD g45p1svt M=1 L=45n W=390n
Mmp35 net417 mout VDD VDD g45p1svt M=1 L=45n W=310n
Mmp36 n20 CKb net417 VDD g45p1svt M=1 L=45n W=310n
Mmp20 CKb CK VDD VDD g45p1svt M=1 L=45n W=215n
Mmp1 net405 qint VDD VDD g45p1svt M=1 L=45n W=390n
Mmp2 Db E net405 VDD g45p1svt M=1 L=45n W=390n
Mmp45 qbint n30 VDD VDD g45p1svt M=1 L=45n W=310n
Mmp56 qint qbint VDD VDD g45p1svt M=1 L=45n W=310n
Mmp21 Ckbb CKb VDD VDD g45p1svt M=1 L=45n W=215n
Mmp40 n30 CKb mout VDD g45p1svt M=1 L=45n W=310n
Mmp30 mout n20 VDD VDD g45p1svt M=1 L=45n W=310n
Mmp11 Db SE Dbp VDD g45p1svt M=1 L=45n W=390n
Mmp10 SEb SE VDD VDD g45p1svt M=1 L=45n W=215n
Mmp0 Eb E VDD VDD g45p1svt M=1 L=45n W=215n
Mmp25 n20 Ckbb Dbp VDD g45p1svt M=1 L=45n W=310n
.ENDS

.SUBCKT SDFFXL CK D Q QN SE SI VDD VSS
Mmn13 net461 SI VSS VSS g45n1svt M=1 L=45n W=145n
Mmn14 Db SE net461 VSS g45n1svt M=1 L=45n W=145n
Mmn12 Db SEb net449 VSS g45n1svt M=1 L=45n W=145n
Mmn11 net449 D VSS VSS g45n1svt M=1 L=45n W=145n
Mmn57 QN net367 VSS VSS g45n1svt M=1 L=45n W=145n
Mmn55 Q qbint VSS VSS g45n1svt M=1 L=45n W=145n
Mmn50 net436 qbint VSS VSS g45n1svt M=1 L=45n W=145n
Mmn51 n30 CKb net436 VSS g45n1svt M=1 L=45n W=145n
Mmn35 net429 mout VSS VSS g45n1svt M=1 L=45n W=145n
Mmn36 n20 CKbb net429 VSS g45n1svt M=1 L=45n W=145n
Mmn20 CKb CK VSS VSS g45n1svt M=1 L=45n W=145n
Mmn45 qbint n30 VSS VSS g45n1svt M=1 L=45n W=145n
Mmn56 net367 qbint VSS VSS g45n1svt M=1 L=45n W=145n
Mmn21 CKbb CKb VSS VSS g45n1svt M=1 L=45n W=145n
Mmn40 n30 CKbb mout VSS g45n1svt M=1 L=45n W=145n
Mmn30 mout n20 VSS VSS g45n1svt M=1 L=45n W=145n
Mmn10 SEb SE VSS VSS g45n1svt M=1 L=45n W=145n
Mmn25 n20 CKb Db VSS g45n1svt M=1 L=45n W=145n
Mmp14 Db SEb net392 VDD g45p1svt M=1 L=45n W=215n
Mmp13 net392 SI VDD VDD g45p1svt M=1 L=45n W=215n
Mmp12 Db SE net384 VDD g45p1svt M=1 L=45n W=215n
Mmp11 net384 D VDD VDD g45p1svt M=1 L=45n W=215n
Mmp51 n30 CKbb net376 VDD g45p1svt M=1 L=45n W=215n
Mmp50 net376 qbint VDD VDD g45p1svt M=1 L=45n W=215n
Mmp57 QN net367 VDD VDD g45p1svt M=1 L=45n W=215n
Mmp55 Q qbint VDD VDD g45p1svt M=1 L=45n W=215n
Mmp35 net356 mout VDD VDD g45p1svt M=1 L=45n W=215n
Mmp36 n20 CKb net356 VDD g45p1svt M=1 L=45n W=215n
Mmp20 CKb CK VDD VDD g45p1svt M=1 L=45n W=215n
Mmp45 qbint n30 VDD VDD g45p1svt M=1 L=45n W=215n
Mmp56 net367 qbint VDD VDD g45p1svt M=1 L=45n W=215n
Mmp21 CKbb CKb VDD VDD g45p1svt M=1 L=45n W=215n
Mmp40 n30 CKb mout VDD g45p1svt M=1 L=45n W=215n
Mmp30 mout n20 VDD VDD g45p1svt M=1 L=45n W=215n
Mmp25 n20 CKbb Db VDD g45p1svt M=1 L=45n W=215n
Mmp10 SEb SE VDD VDD g45p1svt M=1 L=45n W=215n
.ENDS

.SUBCKT SDFFX4 CK D Q QN SE SI VDD VSS
Mmn13 net461 SI VSS VSS g45n1svt M=1 L=45n W=145n
Mmn14 Db SE net461 VSS g45n1svt M=1 L=45n W=145n
Mmn12 Db SEb net449 VSS g45n1svt M=1 L=45n W=145n
Mmn11 net449 D VSS VSS g45n1svt M=1 L=45n W=145n
Mmn57 QN net367 VSS VSS g45n1svt M=1 L=45n W=1.04u
Mmn55 Q qbint VSS VSS g45n1svt M=1 L=45n W=1.04u
Mmn50 net436 qbint VSS VSS g45n1svt M=1 L=45n W=145n
Mmn51 n30 CKb net436 VSS g45n1svt M=1 L=45n W=145n
Mmn35 net429 mout VSS VSS g45n1svt M=1 L=45n W=145n
Mmn36 n20 CKbb net429 VSS g45n1svt M=1 L=45n W=145n
Mmn20 CKb CK VSS VSS g45n1svt M=1 L=45n W=145n
Mmn45 qbint n30 VSS VSS g45n1svt M=1 L=45n W=410n
Mmn56 net367 qbint VSS VSS g45n1svt M=1 L=45n W=260n
Mmn21 CKbb CKb VSS VSS g45n1svt M=1 L=45n W=145n
Mmn40 n30 CKbb mout VSS g45n1svt M=1 L=45n W=145n
Mmn30 mout n20 VSS VSS g45n1svt M=1 L=45n W=145n
Mmn10 SEb SE VSS VSS g45n1svt M=1 L=45n W=145n
Mmn25 n20 CKb Db VSS g45n1svt M=1 L=45n W=145n
Mmp14 Db SEb net392 VDD g45p1svt M=1 L=45n W=215n
Mmp13 net392 SI VDD VDD g45p1svt M=1 L=45n W=215n
Mmp12 Db SE net384 VDD g45p1svt M=1 L=45n W=215n
Mmp11 net384 D VDD VDD g45p1svt M=1 L=45n W=215n
Mmp51 n30 CKbb net376 VDD g45p1svt M=1 L=45n W=215n
Mmp50 net376 qbint VDD VDD g45p1svt M=1 L=45n W=215n
Mmp57 QN net367 VDD VDD g45p1svt M=1 L=45n W=1.56u
Mmp55 Q qbint VDD VDD g45p1svt M=1 L=45n W=1.56u
Mmp35 net356 mout VDD VDD g45p1svt M=1 L=45n W=215n
Mmp36 n20 CKb net356 VDD g45p1svt M=1 L=45n W=215n
Mmp20 CKb CK VDD VDD g45p1svt M=1 L=45n W=215n
Mmp45 qbint n30 VDD VDD g45p1svt M=1 L=45n W=620n
Mmp56 net367 qbint VDD VDD g45p1svt M=1 L=45n W=390n
Mmp21 CKbb CKb VDD VDD g45p1svt M=1 L=45n W=215n
Mmp40 n30 CKb mout VDD g45p1svt M=1 L=45n W=215n
Mmp30 mout n20 VDD VDD g45p1svt M=1 L=45n W=215n
Mmp25 n20 CKbb Db VDD g45p1svt M=1 L=45n W=215n
Mmp10 SEb SE VDD VDD g45p1svt M=1 L=45n W=215n
.ENDS

.SUBCKT SDFFX2 CK D Q QN SE SI VDD VSS
Mmn13 net461 SI VSS VSS g45n1svt M=1 L=45n W=145n
Mmn14 Db SE net461 VSS g45n1svt M=1 L=45n W=145n
Mmn12 Db SEb net449 VSS g45n1svt M=1 L=45n W=145n
Mmn11 net449 D VSS VSS g45n1svt M=1 L=45n W=145n
Mmn57 QN net367 VSS VSS g45n1svt M=1 L=45n W=520n
Mmn55 Q qbint VSS VSS g45n1svt M=1 L=45n W=520n
Mmn50 net436 qbint VSS VSS g45n1svt M=1 L=45n W=145n
Mmn51 n30 CKb net436 VSS g45n1svt M=1 L=45n W=145n
Mmn35 net429 mout VSS VSS g45n1svt M=1 L=45n W=145n
Mmn36 n20 CKbb net429 VSS g45n1svt M=1 L=45n W=145n
Mmn20 CKb CK VSS VSS g45n1svt M=1 L=45n W=145n
Mmn45 qbint n30 VSS VSS g45n1svt M=1 L=45n W=205n
Mmn56 net367 qbint VSS VSS g45n1svt M=1 L=45n W=145n
Mmn21 CKbb CKb VSS VSS g45n1svt M=1 L=45n W=145n
Mmn40 n30 CKbb mout VSS g45n1svt M=1 L=45n W=145n
Mmn30 mout n20 VSS VSS g45n1svt M=1 L=45n W=145n
Mmn10 SEb SE VSS VSS g45n1svt M=1 L=45n W=145n
Mmn25 n20 CKb Db VSS g45n1svt M=1 L=45n W=145n
Mmp14 Db SEb net392 VDD g45p1svt M=1 L=45n W=215n
Mmp13 net392 SI VDD VDD g45p1svt M=1 L=45n W=215n
Mmp12 Db SE net384 VDD g45p1svt M=1 L=45n W=215n
Mmp11 net384 D VDD VDD g45p1svt M=1 L=45n W=215n
Mmp51 n30 CKbb net376 VDD g45p1svt M=1 L=45n W=215n
Mmp50 net376 qbint VDD VDD g45p1svt M=1 L=45n W=215n
Mmp57 QN net367 VDD VDD g45p1svt M=1 L=45n W=780n
Mmp55 Q qbint VDD VDD g45p1svt M=1 L=45n W=780n
Mmp35 net356 mout VDD VDD g45p1svt M=1 L=45n W=215n
Mmp36 n20 CKb net356 VDD g45p1svt M=1 L=45n W=215n
Mmp20 CKb CK VDD VDD g45p1svt M=1 L=45n W=215n
Mmp45 qbint n30 VDD VDD g45p1svt M=1 L=45n W=310n
Mmp56 net367 qbint VDD VDD g45p1svt M=1 L=45n W=215n
Mmp21 CKbb CKb VDD VDD g45p1svt M=1 L=45n W=215n
Mmp40 n30 CKb mout VDD g45p1svt M=1 L=45n W=215n
Mmp30 mout n20 VDD VDD g45p1svt M=1 L=45n W=215n
Mmp25 n20 CKbb Db VDD g45p1svt M=1 L=45n W=215n
Mmp10 SEb SE VDD VDD g45p1svt M=1 L=45n W=215n
.ENDS

.SUBCKT SDFFX1 CK D Q QN SE SI VDD VSS
Mmn13 net461 SI VSS VSS g45n1svt M=1 L=45n W=145n
Mmn14 Db SE net461 VSS g45n1svt M=1 L=45n W=145n
Mmn12 Db SEb net449 VSS g45n1svt M=1 L=45n W=145n
Mmn11 net449 D VSS VSS g45n1svt M=1 L=45n W=145n
Mmn57 QN net367 VSS VSS g45n1svt M=1 L=45n W=260n
Mmn55 Q qbint VSS VSS g45n1svt M=1 L=45n W=260n
Mmn50 net436 qbint VSS VSS g45n1svt M=1 L=45n W=145n
Mmn51 n30 CKb net436 VSS g45n1svt M=1 L=45n W=145n
Mmn35 net429 mout VSS VSS g45n1svt M=1 L=45n W=145n
Mmn36 n20 CKbb net429 VSS g45n1svt M=1 L=45n W=145n
Mmn20 CKb CK VSS VSS g45n1svt M=1 L=45n W=145n
Mmn45 qbint n30 VSS VSS g45n1svt M=1 L=45n W=145n
Mmn56 net367 qbint VSS VSS g45n1svt M=1 L=45n W=145n
Mmn21 CKbb CKb VSS VSS g45n1svt M=1 L=45n W=145n
Mmn40 n30 CKbb mout VSS g45n1svt M=1 L=45n W=145n
Mmn30 mout n20 VSS VSS g45n1svt M=1 L=45n W=145n
Mmn10 SEb SE VSS VSS g45n1svt M=1 L=45n W=145n
Mmn25 n20 CKb Db VSS g45n1svt M=1 L=45n W=145n
Mmp14 Db SEb net392 VDD g45p1svt M=1 L=45n W=215n
Mmp13 net392 SI VDD VDD g45p1svt M=1 L=45n W=215n
Mmp12 Db SE net384 VDD g45p1svt M=1 L=45n W=215n
Mmp11 net384 D VDD VDD g45p1svt M=1 L=45n W=215n
Mmp51 n30 CKbb net376 VDD g45p1svt M=1 L=45n W=215n
Mmp50 net376 qbint VDD VDD g45p1svt M=1 L=45n W=215n
Mmp57 QN net367 VDD VDD g45p1svt M=1 L=45n W=390n
Mmp55 Q qbint VDD VDD g45p1svt M=1 L=45n W=390n
Mmp35 net356 mout VDD VDD g45p1svt M=1 L=45n W=215n
Mmp36 n20 CKb net356 VDD g45p1svt M=1 L=45n W=215n
Mmp20 CKb CK VDD VDD g45p1svt M=1 L=45n W=215n
Mmp45 qbint n30 VDD VDD g45p1svt M=1 L=45n W=215n
Mmp56 net367 qbint VDD VDD g45p1svt M=1 L=45n W=215n
Mmp21 CKbb CKb VDD VDD g45p1svt M=1 L=45n W=215n
Mmp40 n30 CKb mout VDD g45p1svt M=1 L=45n W=215n
Mmp30 mout n20 VDD VDD g45p1svt M=1 L=45n W=215n
Mmp25 n20 CKbb Db VDD g45p1svt M=1 L=45n W=215n
Mmp10 SEb SE VDD VDD g45p1svt M=1 L=45n W=215n
.ENDS

.SUBCKT SDFFTRXL CK D Q QN RN SE SI VDD VSS
Mmn12 net484 SI VSS VSS g45n1svt M=1 L=45n W=145n
Mmn13 Dbp SE net484 VSS g45n1svt M=1 L=45n W=145n
Mmn0 net476 RN VSS VSS g45n1svt M=1 L=45n W=145n
Mmn1 Db D net476 VSS g45n1svt M=1 L=45n W=145n
Mmn57 QN net436 VSS VSS g45n1svt M=1 L=45n W=145n
Mmn55 Q qbint VSS VSS g45n1svt M=1 L=45n W=145n
Mmn50 net460 qbint VSS VSS g45n1svt M=1 L=45n W=145n
Mmn51 n30 CKb net460 VSS g45n1svt M=1 L=45n W=145n
Mmn35 net452 mout VSS VSS g45n1svt M=1 L=45n W=145n
Mmn36 n20 CKbb net452 VSS g45n1svt M=1 L=45n W=145n
Mmn20 CKb CK VSS VSS g45n1svt M=1 L=45n W=145n
Mmn45 qbint n30 VSS VSS g45n1svt M=1 L=45n W=145n
Mmn56 net436 qbint VSS VSS g45n1svt M=1 L=45n W=145n
Mmn11 Db SEb Dbp VSS g45n1svt M=1 L=45n W=145n
Mmn21 CKbb CKb VSS VSS g45n1svt M=1 L=45n W=145n
Mmn30 mout n20 VSS VSS g45n1svt M=1 L=45n W=145n
Mmn10 SEb SE VSS VSS g45n1svt M=1 L=45n W=145n
Mmn25 Dbp CKb n20 VSS g45n1svt M=1 L=45n W=145n
Mmn40 n30 CKbb mout VSS g45n1svt M=1 L=45n W=145n
Mmp13 Dbp SEb net411 VDD g45p1svt M=1 L=45n W=215n
Mmp12 net411 SI VDD VDD g45p1svt M=1 L=45n W=215n
Mmp1 Db D VDD VDD g45p1svt M=1 L=45n W=215n
Mmp0 Db RN VDD VDD g45p1svt M=1 L=45n W=215n
Mmp51 n30 CKbb net395 VDD g45p1svt M=1 L=45n W=215n
Mmp50 net395 qbint VDD VDD g45p1svt M=1 L=45n W=215n
Mmp57 QN net436 VDD VDD g45p1svt M=1 L=45n W=215n
Mmp55 Q qbint VDD VDD g45p1svt M=1 L=45n W=215n
Mmp35 net375 mout VDD VDD g45p1svt M=1 L=45n W=215n
Mmp36 n20 CKb net375 VDD g45p1svt M=1 L=45n W=215n
Mmp20 CKb CK VDD VDD g45p1svt M=1 L=45n W=215n
Mmp45 qbint n30 VDD VDD g45p1svt M=1 L=45n W=215n
Mmp56 net436 qbint VDD VDD g45p1svt M=1 L=45n W=215n
Mmp25 n20 CKbb Dbp VDD g45p1svt M=1 L=45n W=215n
Mmp11 Dbp SE Db VDD g45p1svt M=1 L=45n W=215n
Mmp10 SEb SE VDD VDD g45p1svt M=1 L=45n W=215n
Mmp21 CKbb CKb VDD VDD g45p1svt M=1 L=45n W=215n
Mmp30 mout n20 VDD VDD g45p1svt M=1 L=45n W=215n
Mmp40 n30 CKb mout VDD g45p1svt M=1 L=45n W=215n
.ENDS

.SUBCKT SDFFTRX4 CK D Q QN RN SE SI VDD VSS
Mmn12 net484 SI VSS VSS g45n1svt M=1 L=45n W=145n
Mmn13 Dbp SE net484 VSS g45n1svt M=1 L=45n W=145n
Mmn0 net476 RN VSS VSS g45n1svt M=1 L=45n W=145n
Mmn1 Db D net476 VSS g45n1svt M=1 L=45n W=145n
Mmn57 QN net436 VSS VSS g45n1svt M=1 L=45n W=1.04u
Mmn55 Q qbint VSS VSS g45n1svt M=1 L=45n W=1.04u
Mmn50 net460 qbint VSS VSS g45n1svt M=1 L=45n W=145n
Mmn51 n30 CKb net460 VSS g45n1svt M=1 L=45n W=145n
Mmn35 net452 mout VSS VSS g45n1svt M=1 L=45n W=145n
Mmn36 n20 CKbb net452 VSS g45n1svt M=1 L=45n W=145n
Mmn20 CKb CK VSS VSS g45n1svt M=1 L=45n W=145n
Mmn45 qbint n30 VSS VSS g45n1svt M=1 L=45n W=410n
Mmn56 net436 qbint VSS VSS g45n1svt M=1 L=45n W=260n
Mmn11 Db SEb Dbp VSS g45n1svt M=1 L=45n W=145n
Mmn21 CKbb CKb VSS VSS g45n1svt M=1 L=45n W=145n
Mmn30 mout n20 VSS VSS g45n1svt M=1 L=45n W=145n
Mmn10 SEb SE VSS VSS g45n1svt M=1 L=45n W=145n
Mmn25 Dbp CKb n20 VSS g45n1svt M=1 L=45n W=145n
Mmn40 n30 CKbb mout VSS g45n1svt M=1 L=45n W=145n
Mmp13 Dbp SEb net411 VDD g45p1svt M=1 L=45n W=215n
Mmp12 net411 SI VDD VDD g45p1svt M=1 L=45n W=215n
Mmp1 Db D VDD VDD g45p1svt M=1 L=45n W=215n
Mmp0 Db RN VDD VDD g45p1svt M=1 L=45n W=215n
Mmp51 n30 CKbb net395 VDD g45p1svt M=1 L=45n W=215n
Mmp50 net395 qbint VDD VDD g45p1svt M=1 L=45n W=215n
Mmp57 QN net436 VDD VDD g45p1svt M=1 L=45n W=1.56u
Mmp55 Q qbint VDD VDD g45p1svt M=1 L=45n W=1.56u
Mmp35 net375 mout VDD VDD g45p1svt M=1 L=45n W=215n
Mmp36 n20 CKb net375 VDD g45p1svt M=1 L=45n W=215n
Mmp20 CKb CK VDD VDD g45p1svt M=1 L=45n W=215n
Mmp45 qbint n30 VDD VDD g45p1svt M=1 L=45n W=620n
Mmp56 net436 qbint VDD VDD g45p1svt M=1 L=45n W=390n
Mmp25 n20 CKbb Dbp VDD g45p1svt M=1 L=45n W=215n
Mmp11 Dbp SE Db VDD g45p1svt M=1 L=45n W=215n
Mmp10 SEb SE VDD VDD g45p1svt M=1 L=45n W=215n
Mmp21 CKbb CKb VDD VDD g45p1svt M=1 L=45n W=215n
Mmp30 mout n20 VDD VDD g45p1svt M=1 L=45n W=215n
Mmp40 n30 CKb mout VDD g45p1svt M=1 L=45n W=215n
.ENDS

.SUBCKT SDFFTRX2 CK D Q QN RN SE SI VDD VSS
Mmn12 net484 SI VSS VSS g45n1svt M=1 L=45n W=145n
Mmn13 Dbp SE net484 VSS g45n1svt M=1 L=45n W=145n
Mmn0 net476 RN VSS VSS g45n1svt M=1 L=45n W=145n
Mmn1 Db D net476 VSS g45n1svt M=1 L=45n W=145n
Mmn57 QN net436 VSS VSS g45n1svt M=1 L=45n W=520n
Mmn55 Q qbint VSS VSS g45n1svt M=1 L=45n W=520n
Mmn50 net460 qbint VSS VSS g45n1svt M=1 L=45n W=145n
Mmn51 n30 CKb net460 VSS g45n1svt M=1 L=45n W=145n
Mmn35 net452 mout VSS VSS g45n1svt M=1 L=45n W=145n
Mmn36 n20 CKbb net452 VSS g45n1svt M=1 L=45n W=145n
Mmn20 CKb CK VSS VSS g45n1svt M=1 L=45n W=145n
Mmn45 qbint n30 VSS VSS g45n1svt M=1 L=45n W=205n
Mmn56 net436 qbint VSS VSS g45n1svt M=1 L=45n W=145n
Mmn11 Db SEb Dbp VSS g45n1svt M=1 L=45n W=145n
Mmn21 CKbb CKb VSS VSS g45n1svt M=1 L=45n W=145n
Mmn30 mout n20 VSS VSS g45n1svt M=1 L=45n W=145n
Mmn10 SEb SE VSS VSS g45n1svt M=1 L=45n W=145n
Mmn25 Dbp CKb n20 VSS g45n1svt M=1 L=45n W=145n
Mmn40 n30 CKbb mout VSS g45n1svt M=1 L=45n W=145n
Mmp13 Dbp SEb net411 VDD g45p1svt M=1 L=45n W=215n
Mmp12 net411 SI VDD VDD g45p1svt M=1 L=45n W=215n
Mmp1 Db D VDD VDD g45p1svt M=1 L=45n W=215n
Mmp0 Db RN VDD VDD g45p1svt M=1 L=45n W=215n
Mmp51 n30 CKbb net395 VDD g45p1svt M=1 L=45n W=215n
Mmp50 net395 qbint VDD VDD g45p1svt M=1 L=45n W=215n
Mmp57 QN net436 VDD VDD g45p1svt M=1 L=45n W=780n
Mmp55 Q qbint VDD VDD g45p1svt M=1 L=45n W=780n
Mmp35 net375 mout VDD VDD g45p1svt M=1 L=45n W=215n
Mmp36 n20 CKb net375 VDD g45p1svt M=1 L=45n W=215n
Mmp20 CKb CK VDD VDD g45p1svt M=1 L=45n W=215n
Mmp45 qbint n30 VDD VDD g45p1svt M=1 L=45n W=310n
Mmp56 net436 qbint VDD VDD g45p1svt M=1 L=45n W=215n
Mmp25 n20 CKbb Dbp VDD g45p1svt M=1 L=45n W=215n
Mmp11 Dbp SE Db VDD g45p1svt M=1 L=45n W=215n
Mmp10 SEb SE VDD VDD g45p1svt M=1 L=45n W=215n
Mmp21 CKbb CKb VDD VDD g45p1svt M=1 L=45n W=215n
Mmp30 mout n20 VDD VDD g45p1svt M=1 L=45n W=215n
Mmp40 n30 CKb mout VDD g45p1svt M=1 L=45n W=215n
.ENDS

.SUBCKT SDFFTRX1 CK D Q QN RN SE SI VDD VSS
Mmn12 net484 SI VSS VSS g45n1svt M=1 L=45n W=145n
Mmn13 Dbp SE net484 VSS g45n1svt M=1 L=45n W=145n
Mmn0 net476 RN VSS VSS g45n1svt M=1 L=45n W=145n
Mmn1 Db D net476 VSS g45n1svt M=1 L=45n W=145n
Mmn57 QN net436 VSS VSS g45n1svt M=1 L=45n W=260n
Mmn55 Q qbint VSS VSS g45n1svt M=1 L=45n W=260n
Mmn50 net460 qbint VSS VSS g45n1svt M=1 L=45n W=145n
Mmn51 n30 CKb net460 VSS g45n1svt M=1 L=45n W=145n
Mmn35 net452 mout VSS VSS g45n1svt M=1 L=45n W=145n
Mmn36 n20 CKbb net452 VSS g45n1svt M=1 L=45n W=145n
Mmn20 CKb CK VSS VSS g45n1svt M=1 L=45n W=145n
Mmn45 qbint n30 VSS VSS g45n1svt M=1 L=45n W=145n
Mmn56 net436 qbint VSS VSS g45n1svt M=1 L=45n W=145n
Mmn11 Db SEb Dbp VSS g45n1svt M=1 L=45n W=145n
Mmn21 CKbb CKb VSS VSS g45n1svt M=1 L=45n W=145n
Mmn30 mout n20 VSS VSS g45n1svt M=1 L=45n W=145n
Mmn10 SEb SE VSS VSS g45n1svt M=1 L=45n W=145n
Mmn25 Dbp CKb n20 VSS g45n1svt M=1 L=45n W=145n
Mmn40 n30 CKbb mout VSS g45n1svt M=1 L=45n W=145n
Mmp13 Dbp SEb net411 VDD g45p1svt M=1 L=45n W=215n
Mmp12 net411 SI VDD VDD g45p1svt M=1 L=45n W=215n
Mmp1 Db D VDD VDD g45p1svt M=1 L=45n W=215n
Mmp0 Db RN VDD VDD g45p1svt M=1 L=45n W=215n
Mmp51 n30 CKbb net395 VDD g45p1svt M=1 L=45n W=215n
Mmp50 net395 qbint VDD VDD g45p1svt M=1 L=45n W=215n
Mmp57 QN net436 VDD VDD g45p1svt M=1 L=45n W=390n
Mmp55 Q qbint VDD VDD g45p1svt M=1 L=45n W=390n
Mmp35 net375 mout VDD VDD g45p1svt M=1 L=45n W=215n
Mmp36 n20 CKb net375 VDD g45p1svt M=1 L=45n W=215n
Mmp20 CKb CK VDD VDD g45p1svt M=1 L=45n W=215n
Mmp45 qbint n30 VDD VDD g45p1svt M=1 L=45n W=215n
Mmp56 net436 qbint VDD VDD g45p1svt M=1 L=45n W=215n
Mmp25 n20 CKbb Dbp VDD g45p1svt M=1 L=45n W=215n
Mmp11 Dbp SE Db VDD g45p1svt M=1 L=45n W=215n
Mmp10 SEb SE VDD VDD g45p1svt M=1 L=45n W=215n
Mmp21 CKbb CKb VDD VDD g45p1svt M=1 L=45n W=215n
Mmp30 mout n20 VDD VDD g45p1svt M=1 L=45n W=215n
Mmp40 n30 CKb mout VDD g45p1svt M=1 L=45n W=215n
.ENDS

.SUBCKT SDFFSXL CK D Q QN SE SI SN VDD VSS
Mmn51 net518 qbint net521 VSS g45n1svt M=1 L=45n W=145n
Mmn52 n35 CKb net518 VSS g45n1svt M=1 L=45n W=145n
Mmn50 net521 SN VSS VSS g45n1svt M=1 L=45n W=145n
Mmn13 net506 SI VSS VSS g45n1svt M=1 L=45n W=145n
Mmn14 Db SE net506 VSS g45n1svt M=1 L=45n W=145n
Mmn12 Db SEb net494 VSS g45n1svt M=1 L=45n W=145n
Mmn11 net494 D VSS VSS g45n1svt M=1 L=45n W=145n
Mmn57 QN net492 VSS VSS g45n1svt M=1 L=45n W=145n
Mmn55 Q qbint VSS VSS g45n1svt M=1 L=45n W=145n
Mmn31 mout n20 net442 VSS g45n1svt M=1 L=45n W=145n
Mmn35 net478 mout VSS VSS g45n1svt M=1 L=45n W=145n
Mmn36 n20 CKbb net478 VSS g45n1svt M=1 L=45n W=145n
Mmn20 CKb CK VSS VSS g45n1svt M=1 L=45n W=145n
Mmn45 qbint n35 VSS VSS g45n1svt M=1 L=45n W=145n
Mmn56 net492 qbint VSS VSS g45n1svt M=1 L=45n W=145n
Mmn21 CKbb CKb VSS VSS g45n1svt M=1 L=45n W=145n
Mmn40 n35 CKbb mout VSS g45n1svt M=1 L=45n W=145n
Mmn10 SEb SE VSS VSS g45n1svt M=1 L=45n W=145n
Mmn25 Db CKb n20 VSS g45n1svt M=1 L=45n W=145n
Mmn30 net442 SN VSS VSS g45n1svt M=1 L=45n W=145n
Mmp14 Db SEb net441 VDD g45p1svt M=1 L=45n W=215n
Mmp13 net441 SI VDD VDD g45p1svt M=1 L=45n W=215n
Mmp12 Db SE net433 VDD g45p1svt M=1 L=45n W=215n
Mmp11 net433 D VDD VDD g45p1svt M=1 L=45n W=215n
Mmp57 QN net492 VDD VDD g45p1svt M=1 L=45n W=215n
Mmp55 Q qbint VDD VDD g45p1svt M=1 L=45n W=215n
Mmp36 n20 CKb net417 VDD g45p1svt M=1 L=45n W=215n
Mmp35 net417 mout VDD VDD g45p1svt M=1 L=45n W=215n
Mmp20 CKb CK VDD VDD g45p1svt M=1 L=45n W=215n
Mmp52 n35 CKbb net405 VDD g45p1svt M=1 L=45n W=215n
Mmp51 net405 qbint VDD VDD g45p1svt M=1 L=45n W=215n
Mmp50 net405 SN VDD VDD g45p1svt M=1 L=45n W=215n
Mmp45 qbint n35 VDD VDD g45p1svt M=1 L=45n W=215n
Mmp56 net492 qbint VDD VDD g45p1svt M=1 L=45n W=215n
Mmp21 CKbb CKb VDD VDD g45p1svt M=1 L=45n W=215n
Mmp40 n35 CKb mout VDD g45p1svt M=1 L=45n W=215n
Mmp30 mout SN VDD VDD g45p1svt M=1 L=45n W=215n
Mmp31 mout n20 VDD VDD g45p1svt M=1 L=45n W=215n
Mmp25 n20 CKbb Db VDD g45p1svt M=1 L=45n W=215n
Mmp10 SEb SE VDD VDD g45p1svt M=1 L=45n W=215n
.ENDS

.SUBCKT SDFFSX4 CK D Q QN SE SI SN VDD VSS
Mmn51 net518 qbint net521 VSS g45n1svt M=1 L=45n W=145n
Mmn52 n35 CKb net518 VSS g45n1svt M=1 L=45n W=145n
Mmn50 net521 SN VSS VSS g45n1svt M=1 L=45n W=145n
Mmn13 net506 SI VSS VSS g45n1svt M=1 L=45n W=145n
Mmn14 Db SE net506 VSS g45n1svt M=1 L=45n W=145n
Mmn12 Db SEb net494 VSS g45n1svt M=1 L=45n W=145n
Mmn11 net494 D VSS VSS g45n1svt M=1 L=45n W=145n
Mmn57 QN net492 VSS VSS g45n1svt M=1 L=45n W=1.04u
Mmn55 Q qbint VSS VSS g45n1svt M=1 L=45n W=1.04u
Mmn31 mout n20 net442 VSS g45n1svt M=1 L=45n W=145n
Mmn35 net478 mout VSS VSS g45n1svt M=1 L=45n W=145n
Mmn36 n20 CKbb net478 VSS g45n1svt M=1 L=45n W=145n
Mmn20 CKb CK VSS VSS g45n1svt M=1 L=45n W=145n
Mmn45 qbint n35 VSS VSS g45n1svt M=1 L=45n W=410n
Mmn56 net492 qbint VSS VSS g45n1svt M=1 L=45n W=260n
Mmn21 CKbb CKb VSS VSS g45n1svt M=1 L=45n W=145n
Mmn40 n35 CKbb mout VSS g45n1svt M=1 L=45n W=145n
Mmn10 SEb SE VSS VSS g45n1svt M=1 L=45n W=145n
Mmn25 Db CKb n20 VSS g45n1svt M=1 L=45n W=145n
Mmn30 net442 SN VSS VSS g45n1svt M=1 L=45n W=145n
Mmp14 Db SEb net441 VDD g45p1svt M=1 L=45n W=215n
Mmp13 net441 SI VDD VDD g45p1svt M=1 L=45n W=215n
Mmp12 Db SE net433 VDD g45p1svt M=1 L=45n W=215n
Mmp11 net433 D VDD VDD g45p1svt M=1 L=45n W=215n
Mmp57 QN net492 VDD VDD g45p1svt M=1 L=45n W=1.56u
Mmp55 Q qbint VDD VDD g45p1svt M=1 L=45n W=1.56u
Mmp36 n20 CKb net417 VDD g45p1svt M=1 L=45n W=215n
Mmp35 net417 mout VDD VDD g45p1svt M=1 L=45n W=215n
Mmp20 CKb CK VDD VDD g45p1svt M=1 L=45n W=215n
Mmp52 n35 CKbb net405 VDD g45p1svt M=1 L=45n W=215n
Mmp51 net405 qbint VDD VDD g45p1svt M=1 L=45n W=215n
Mmp50 net405 SN VDD VDD g45p1svt M=1 L=45n W=215n
Mmp45 qbint n35 VDD VDD g45p1svt M=1 L=45n W=620n
Mmp56 net492 qbint VDD VDD g45p1svt M=1 L=45n W=390n
Mmp21 CKbb CKb VDD VDD g45p1svt M=1 L=45n W=215n
Mmp40 n35 CKb mout VDD g45p1svt M=1 L=45n W=215n
Mmp30 mout SN VDD VDD g45p1svt M=1 L=45n W=215n
Mmp31 mout n20 VDD VDD g45p1svt M=1 L=45n W=215n
Mmp25 n20 CKbb Db VDD g45p1svt M=1 L=45n W=215n
Mmp10 SEb SE VDD VDD g45p1svt M=1 L=45n W=215n
.ENDS

.SUBCKT SDFFSX2 CK D Q QN SE SI SN VDD VSS
Mmn51 net518 qbint net521 VSS g45n1svt M=1 L=45n W=145n
Mmn52 n35 CKb net518 VSS g45n1svt M=1 L=45n W=145n
Mmn50 net521 SN VSS VSS g45n1svt M=1 L=45n W=145n
Mmn13 net506 SI VSS VSS g45n1svt M=1 L=45n W=145n
Mmn14 Db SE net506 VSS g45n1svt M=1 L=45n W=145n
Mmn12 Db SEb net494 VSS g45n1svt M=1 L=45n W=145n
Mmn11 net494 D VSS VSS g45n1svt M=1 L=45n W=145n
Mmn57 QN net492 VSS VSS g45n1svt M=1 L=45n W=520n
Mmn55 Q qbint VSS VSS g45n1svt M=1 L=45n W=520n
Mmn31 mout n20 net442 VSS g45n1svt M=1 L=45n W=145n
Mmn35 net478 mout VSS VSS g45n1svt M=1 L=45n W=145n
Mmn36 n20 CKbb net478 VSS g45n1svt M=1 L=45n W=145n
Mmn20 CKb CK VSS VSS g45n1svt M=1 L=45n W=145n
Mmn45 qbint n35 VSS VSS g45n1svt M=1 L=45n W=205n
Mmn56 net492 qbint VSS VSS g45n1svt M=1 L=45n W=145n
Mmn21 CKbb CKb VSS VSS g45n1svt M=1 L=45n W=145n
Mmn40 n35 CKbb mout VSS g45n1svt M=1 L=45n W=145n
Mmn10 SEb SE VSS VSS g45n1svt M=1 L=45n W=145n
Mmn25 Db CKb n20 VSS g45n1svt M=1 L=45n W=145n
Mmn30 net442 SN VSS VSS g45n1svt M=1 L=45n W=145n
Mmp14 Db SEb net441 VDD g45p1svt M=1 L=45n W=215n
Mmp13 net441 SI VDD VDD g45p1svt M=1 L=45n W=215n
Mmp12 Db SE net433 VDD g45p1svt M=1 L=45n W=215n
Mmp11 net433 D VDD VDD g45p1svt M=1 L=45n W=215n
Mmp57 QN net492 VDD VDD g45p1svt M=1 L=45n W=780n
Mmp55 Q qbint VDD VDD g45p1svt M=1 L=45n W=780n
Mmp36 n20 CKb net417 VDD g45p1svt M=1 L=45n W=215n
Mmp35 net417 mout VDD VDD g45p1svt M=1 L=45n W=215n
Mmp20 CKb CK VDD VDD g45p1svt M=1 L=45n W=215n
Mmp52 n35 CKbb net405 VDD g45p1svt M=1 L=45n W=215n
Mmp51 net405 qbint VDD VDD g45p1svt M=1 L=45n W=215n
Mmp50 net405 SN VDD VDD g45p1svt M=1 L=45n W=215n
Mmp45 qbint n35 VDD VDD g45p1svt M=1 L=45n W=310n
Mmp56 net492 qbint VDD VDD g45p1svt M=1 L=45n W=215n
Mmp21 CKbb CKb VDD VDD g45p1svt M=1 L=45n W=215n
Mmp40 n35 CKb mout VDD g45p1svt M=1 L=45n W=215n
Mmp30 mout SN VDD VDD g45p1svt M=1 L=45n W=215n
Mmp31 mout n20 VDD VDD g45p1svt M=1 L=45n W=215n
Mmp25 n20 CKbb Db VDD g45p1svt M=1 L=45n W=215n
Mmp10 SEb SE VDD VDD g45p1svt M=1 L=45n W=215n
.ENDS

.SUBCKT SDFFSX1 CK D Q QN SE SI SN VDD VSS
Mmn51 net518 qbint net521 VSS g45n1svt M=1 L=45n W=145n
Mmn52 n35 CKb net518 VSS g45n1svt M=1 L=45n W=145n
Mmn50 net521 SN VSS VSS g45n1svt M=1 L=45n W=145n
Mmn13 net506 SI VSS VSS g45n1svt M=1 L=45n W=145n
Mmn14 Db SE net506 VSS g45n1svt M=1 L=45n W=145n
Mmn12 Db SEb net494 VSS g45n1svt M=1 L=45n W=145n
Mmn11 net494 D VSS VSS g45n1svt M=1 L=45n W=145n
Mmn57 QN net492 VSS VSS g45n1svt M=1 L=45n W=260n
Mmn55 Q qbint VSS VSS g45n1svt M=1 L=45n W=260n
Mmn31 mout n20 net442 VSS g45n1svt M=1 L=45n W=145n
Mmn35 net478 mout VSS VSS g45n1svt M=1 L=45n W=145n
Mmn36 n20 CKbb net478 VSS g45n1svt M=1 L=45n W=145n
Mmn20 CKb CK VSS VSS g45n1svt M=1 L=45n W=145n
Mmn45 qbint n35 VSS VSS g45n1svt M=1 L=45n W=145n
Mmn56 net492 qbint VSS VSS g45n1svt M=1 L=45n W=145n
Mmn21 CKbb CKb VSS VSS g45n1svt M=1 L=45n W=145n
Mmn40 n35 CKbb mout VSS g45n1svt M=1 L=45n W=145n
Mmn10 SEb SE VSS VSS g45n1svt M=1 L=45n W=145n
Mmn25 Db CKb n20 VSS g45n1svt M=1 L=45n W=145n
Mmn30 net442 SN VSS VSS g45n1svt M=1 L=45n W=145n
Mmp14 Db SEb net441 VDD g45p1svt M=1 L=45n W=215n
Mmp13 net441 SI VDD VDD g45p1svt M=1 L=45n W=215n
Mmp12 Db SE net433 VDD g45p1svt M=1 L=45n W=215n
Mmp11 net433 D VDD VDD g45p1svt M=1 L=45n W=215n
Mmp57 QN net492 VDD VDD g45p1svt M=1 L=45n W=390n
Mmp55 Q qbint VDD VDD g45p1svt M=1 L=45n W=390n
Mmp36 n20 CKb net417 VDD g45p1svt M=1 L=45n W=215n
Mmp35 net417 mout VDD VDD g45p1svt M=1 L=45n W=215n
Mmp20 CKb CK VDD VDD g45p1svt M=1 L=45n W=215n
Mmp52 n35 CKbb net405 VDD g45p1svt M=1 L=45n W=215n
Mmp51 net405 qbint VDD VDD g45p1svt M=1 L=45n W=215n
Mmp50 net405 SN VDD VDD g45p1svt M=1 L=45n W=215n
Mmp45 qbint n35 VDD VDD g45p1svt M=1 L=45n W=215n
Mmp56 net492 qbint VDD VDD g45p1svt M=1 L=45n W=215n
Mmp21 CKbb CKb VDD VDD g45p1svt M=1 L=45n W=215n
Mmp40 n35 CKb mout VDD g45p1svt M=1 L=45n W=215n
Mmp30 mout SN VDD VDD g45p1svt M=1 L=45n W=215n
Mmp31 mout n20 VDD VDD g45p1svt M=1 L=45n W=215n
Mmp25 n20 CKbb Db VDD g45p1svt M=1 L=45n W=215n
Mmp10 SEb SE VDD VDD g45p1svt M=1 L=45n W=215n
.ENDS

.SUBCKT SDFFSRXL CK D Q QN RN SE SI SN VDD VSS
Mmn13 n2 SI VSS VSS g45n1svt M=1 L=45n W=145n
Mmn14 Db SE n2 VSS g45n1svt M=1 L=45n W=145n
Mmn12 Db SEb n0 VSS g45n1svt M=1 L=45n W=145n
Mmn11 n0 D VSS VSS g45n1svt M=1 L=45n W=145n
Mmn57 QN net573 VSS VSS g45n1svt M=1 L=45n W=145n
Mmn55 Q qbint VSS VSS g45n1svt M=1 L=45n W=145n
Mmn35 n6 mout VSS VSS g45n1svt M=1 L=45n W=145n
Mmn36 n20 CKbb n6 VSS g45n1svt M=1 L=45n W=145n
Mmn22 RNb RN VSS VSS g45n1svt M=1 L=45n W=145n
Mmn20 CKb CK VSS VSS g45n1svt M=1 L=45n W=145n
Mmn10 SEb SE VSS VSS g45n1svt M=1 L=45n W=145n
Mmn56 net573 qbint VSS VSS g45n1svt M=1 L=45n W=145n
Mmn25 Db CKb n20 VSS g45n1svt M=1 L=45n W=145n
Mmn32 mout n20 n4 VSS g45n1svt M=1 L=45n W=145n
Mmn53 n35 CKb n10 VSS g45n1svt M=1 L=45n W=145n
Mmn30 n4 SN VSS VSS g45n1svt M=1 L=45n W=145n
Mmn50 n8 SN VSS VSS g45n1svt M=1 L=45n W=145n
Mmn51 n10 RNb n8 VSS g45n1svt M=1 L=45n W=145n
Mmn40 n35 CKbb mout VSS g45n1svt M=1 L=45n W=145n
Mmn31 mout RNb n4 VSS g45n1svt M=1 L=45n W=145n
Mmn21 CKbb CKb VSS VSS g45n1svt M=1 L=45n W=145n
Mmn52 n10 qbint n8 VSS g45n1svt M=1 L=45n W=145n
Mmn45 qbint n35 VSS VSS g45n1svt M=1 L=45n W=145n
Mmp14 Db SEb n3 VDD g45p1svt M=1 L=45n W=215n
Mmp13 n3 SI VDD VDD g45p1svt M=1 L=45n W=215n
Mmp12 Db SE n1 VDD g45p1svt M=1 L=45n W=215n
Mmp11 n1 D VDD VDD g45p1svt M=1 L=45n W=215n
Mmp52 n11 qbint n9 VDD g45p1svt M=1 L=45n W=215n
Mmp51 n9 RNb VDD VDD g45p1svt M=1 L=45n W=215n
Mmp57 QN net573 VDD VDD g45p1svt M=1 L=45n W=215n
Mmp55 Q qbint VDD VDD g45p1svt M=1 L=45n W=215n
Mmp36 n20 CKb n7 VDD g45p1svt M=1 L=45n W=215n
Mmp35 n7 mout VDD VDD g45p1svt M=1 L=45n W=215n
Mmp32 mout n20 n5 VDD g45p1svt M=1 L=45n W=215n
Mmp31 n5 RNb VDD VDD g45p1svt M=1 L=45n W=215n
Mmp22 RNb RN VDD VDD g45p1svt M=1 L=45n W=215n
Mmp20 CKb CK VDD VDD g45p1svt M=1 L=45n W=215n
Mmp21 CKbb CKb VDD VDD g45p1svt M=1 L=45n W=215n
Mmp45 qbint n35 VDD VDD g45p1svt M=1 L=45n W=215n
Mmp30 mout SN VDD VDD g45p1svt M=1 L=45n W=215n
Mmp25 n20 CKbb Db VDD g45p1svt M=1 L=45n W=215n
Mmp56 net573 qbint VDD VDD g45p1svt M=1 L=45n W=215n
Mmp40 n35 CKb mout VDD g45p1svt M=1 L=45n W=215n
Mmp53 n35 CKbb n11 VDD g45p1svt M=1 L=45n W=215n
Mmp50 n11 SN VDD VDD g45p1svt M=1 L=45n W=215n
Mmp10 SEb SE VDD VDD g45p1svt M=1 L=45n W=215n
.ENDS

.SUBCKT SDFFSRX4 CK D Q QN RN SE SI SN VDD VSS
Mmn13 n2 SI VSS VSS g45n1svt M=1 L=45n W=145n
Mmn14 Db SE n2 VSS g45n1svt M=1 L=45n W=145n
Mmn12 Db SEb n0 VSS g45n1svt M=1 L=45n W=145n
Mmn11 n0 D VSS VSS g45n1svt M=1 L=45n W=145n
Mmn57 QN net573 VSS VSS g45n1svt M=1 L=45n W=1.04u
Mmn55 Q qbint VSS VSS g45n1svt M=1 L=45n W=1.04u
Mmn35 n6 mout VSS VSS g45n1svt M=1 L=45n W=145n
Mmn36 n20 CKbb n6 VSS g45n1svt M=1 L=45n W=145n
Mmn22 RNb RN VSS VSS g45n1svt M=1 L=45n W=145n
Mmn20 CKb CK VSS VSS g45n1svt M=1 L=45n W=145n
Mmn10 SEb SE VSS VSS g45n1svt M=1 L=45n W=145n
Mmn56 net573 qbint VSS VSS g45n1svt M=1 L=45n W=260n
Mmn25 Db CKb n20 VSS g45n1svt M=1 L=45n W=145n
Mmn32 mout n20 n4 VSS g45n1svt M=1 L=45n W=145n
Mmn53 n35 CKb n10 VSS g45n1svt M=1 L=45n W=145n
Mmn30 n4 SN VSS VSS g45n1svt M=1 L=45n W=145n
Mmn50 n8 SN VSS VSS g45n1svt M=1 L=45n W=145n
Mmn51 n10 RNb n8 VSS g45n1svt M=1 L=45n W=145n
Mmn40 n35 CKbb mout VSS g45n1svt M=1 L=45n W=145n
Mmn31 mout RNb n4 VSS g45n1svt M=1 L=45n W=145n
Mmn21 CKbb CKb VSS VSS g45n1svt M=1 L=45n W=145n
Mmn52 n10 qbint n8 VSS g45n1svt M=1 L=45n W=145n
Mmn45 qbint n35 VSS VSS g45n1svt M=1 L=45n W=410n
Mmp14 Db SEb n3 VDD g45p1svt M=1 L=45n W=215n
Mmp13 n3 SI VDD VDD g45p1svt M=1 L=45n W=215n
Mmp12 Db SE n1 VDD g45p1svt M=1 L=45n W=215n
Mmp11 n1 D VDD VDD g45p1svt M=1 L=45n W=215n
Mmp52 n11 qbint n9 VDD g45p1svt M=1 L=45n W=215n
Mmp51 n9 RNb VDD VDD g45p1svt M=1 L=45n W=215n
Mmp57 QN net573 VDD VDD g45p1svt M=1 L=45n W=1.56u
Mmp55 Q qbint VDD VDD g45p1svt M=1 L=45n W=1.56u
Mmp36 n20 CKb n7 VDD g45p1svt M=1 L=45n W=215n
Mmp35 n7 mout VDD VDD g45p1svt M=1 L=45n W=215n
Mmp32 mout n20 n5 VDD g45p1svt M=1 L=45n W=215n
Mmp31 n5 RNb VDD VDD g45p1svt M=1 L=45n W=215n
Mmp22 RNb RN VDD VDD g45p1svt M=1 L=45n W=215n
Mmp20 CKb CK VDD VDD g45p1svt M=1 L=45n W=215n
Mmp21 CKbb CKb VDD VDD g45p1svt M=1 L=45n W=215n
Mmp45 qbint n35 VDD VDD g45p1svt M=1 L=45n W=620n
Mmp30 mout SN VDD VDD g45p1svt M=1 L=45n W=215n
Mmp25 n20 CKbb Db VDD g45p1svt M=1 L=45n W=215n
Mmp56 net573 qbint VDD VDD g45p1svt M=1 L=45n W=390n
Mmp40 n35 CKb mout VDD g45p1svt M=1 L=45n W=215n
Mmp53 n35 CKbb n11 VDD g45p1svt M=1 L=45n W=215n
Mmp50 n11 SN VDD VDD g45p1svt M=1 L=45n W=215n
Mmp10 SEb SE VDD VDD g45p1svt M=1 L=45n W=215n
.ENDS

.SUBCKT SDFFSRX2 CK D Q QN RN SE SI SN VDD VSS
Mmn13 n2 SI VSS VSS g45n1svt M=1 L=45n W=145n
Mmn14 Db SE n2 VSS g45n1svt M=1 L=45n W=145n
Mmn12 Db SEb n0 VSS g45n1svt M=1 L=45n W=145n
Mmn11 n0 D VSS VSS g45n1svt M=1 L=45n W=145n
Mmn57 QN net573 VSS VSS g45n1svt M=1 L=45n W=520n
Mmn55 Q qbint VSS VSS g45n1svt M=1 L=45n W=520n
Mmn35 n6 mout VSS VSS g45n1svt M=1 L=45n W=145n
Mmn36 n20 CKbb n6 VSS g45n1svt M=1 L=45n W=145n
Mmn22 RNb RN VSS VSS g45n1svt M=1 L=45n W=145n
Mmn20 CKb CK VSS VSS g45n1svt M=1 L=45n W=145n
Mmn10 SEb SE VSS VSS g45n1svt M=1 L=45n W=145n
Mmn56 net573 qbint VSS VSS g45n1svt M=1 L=45n W=145n
Mmn25 Db CKb n20 VSS g45n1svt M=1 L=45n W=145n
Mmn32 mout n20 n4 VSS g45n1svt M=1 L=45n W=145n
Mmn53 n35 CKb n10 VSS g45n1svt M=1 L=45n W=145n
Mmn30 n4 SN VSS VSS g45n1svt M=1 L=45n W=145n
Mmn50 n8 SN VSS VSS g45n1svt M=1 L=45n W=145n
Mmn51 n10 RNb n8 VSS g45n1svt M=1 L=45n W=145n
Mmn40 n35 CKbb mout VSS g45n1svt M=1 L=45n W=145n
Mmn31 mout RNb n4 VSS g45n1svt M=1 L=45n W=145n
Mmn21 CKbb CKb VSS VSS g45n1svt M=1 L=45n W=145n
Mmn52 n10 qbint n8 VSS g45n1svt M=1 L=45n W=145n
Mmn45 qbint n35 VSS VSS g45n1svt M=1 L=45n W=205n
Mmp14 Db SEb n3 VDD g45p1svt M=1 L=45n W=215n
Mmp13 n3 SI VDD VDD g45p1svt M=1 L=45n W=215n
Mmp12 Db SE n1 VDD g45p1svt M=1 L=45n W=215n
Mmp11 n1 D VDD VDD g45p1svt M=1 L=45n W=215n
Mmp52 n11 qbint n9 VDD g45p1svt M=1 L=45n W=215n
Mmp51 n9 RNb VDD VDD g45p1svt M=1 L=45n W=215n
Mmp57 QN net573 VDD VDD g45p1svt M=1 L=45n W=780n
Mmp55 Q qbint VDD VDD g45p1svt M=1 L=45n W=780n
Mmp36 n20 CKb n7 VDD g45p1svt M=1 L=45n W=215n
Mmp35 n7 mout VDD VDD g45p1svt M=1 L=45n W=215n
Mmp32 mout n20 n5 VDD g45p1svt M=1 L=45n W=215n
Mmp31 n5 RNb VDD VDD g45p1svt M=1 L=45n W=215n
Mmp22 RNb RN VDD VDD g45p1svt M=1 L=45n W=215n
Mmp20 CKb CK VDD VDD g45p1svt M=1 L=45n W=215n
Mmp21 CKbb CKb VDD VDD g45p1svt M=1 L=45n W=215n
Mmp45 qbint n35 VDD VDD g45p1svt M=1 L=45n W=310n
Mmp30 mout SN VDD VDD g45p1svt M=1 L=45n W=215n
Mmp25 n20 CKbb Db VDD g45p1svt M=1 L=45n W=215n
Mmp56 net573 qbint VDD VDD g45p1svt M=1 L=45n W=215n
Mmp40 n35 CKb mout VDD g45p1svt M=1 L=45n W=215n
Mmp53 n35 CKbb n11 VDD g45p1svt M=1 L=45n W=215n
Mmp50 n11 SN VDD VDD g45p1svt M=1 L=45n W=215n
Mmp10 SEb SE VDD VDD g45p1svt M=1 L=45n W=215n
.ENDS

.SUBCKT SDFFSRX1 CK D Q QN RN SE SI SN VDD VSS
Mmn13 n2 SI VSS VSS g45n1svt M=1 L=45n W=145n
Mmn14 Db SE n2 VSS g45n1svt M=1 L=45n W=145n
Mmn12 Db SEb n0 VSS g45n1svt M=1 L=45n W=145n
Mmn11 n0 D VSS VSS g45n1svt M=1 L=45n W=145n
Mmn57 QN net573 VSS VSS g45n1svt M=1 L=45n W=260n
Mmn55 Q qbint VSS VSS g45n1svt M=1 L=45n W=260n
Mmn35 n6 mout VSS VSS g45n1svt M=1 L=45n W=145n
Mmn36 n20 CKbb n6 VSS g45n1svt M=1 L=45n W=145n
Mmn22 RNb RN VSS VSS g45n1svt M=1 L=45n W=145n
Mmn20 CKb CK VSS VSS g45n1svt M=1 L=45n W=145n
Mmn10 SEb SE VSS VSS g45n1svt M=1 L=45n W=145n
Mmn56 net573 qbint VSS VSS g45n1svt M=1 L=45n W=145n
Mmn25 Db CKb n20 VSS g45n1svt M=1 L=45n W=145n
Mmn32 mout n20 n4 VSS g45n1svt M=1 L=45n W=145n
Mmn53 n35 CKb n10 VSS g45n1svt M=1 L=45n W=145n
Mmn30 n4 SN VSS VSS g45n1svt M=1 L=45n W=145n
Mmn50 n8 SN VSS VSS g45n1svt M=1 L=45n W=145n
Mmn51 n10 RNb n8 VSS g45n1svt M=1 L=45n W=145n
Mmn40 n35 CKbb mout VSS g45n1svt M=1 L=45n W=145n
Mmn31 mout RNb n4 VSS g45n1svt M=1 L=45n W=145n
Mmn21 CKbb CKb VSS VSS g45n1svt M=1 L=45n W=145n
Mmn52 n10 qbint n8 VSS g45n1svt M=1 L=45n W=145n
Mmn45 qbint n35 VSS VSS g45n1svt M=1 L=45n W=145n
Mmp14 Db SEb n3 VDD g45p1svt M=1 L=45n W=215n
Mmp13 n3 SI VDD VDD g45p1svt M=1 L=45n W=215n
Mmp12 Db SE n1 VDD g45p1svt M=1 L=45n W=215n
Mmp11 n1 D VDD VDD g45p1svt M=1 L=45n W=215n
Mmp52 n11 qbint n9 VDD g45p1svt M=1 L=45n W=215n
Mmp51 n9 RNb VDD VDD g45p1svt M=1 L=45n W=215n
Mmp57 QN net573 VDD VDD g45p1svt M=1 L=45n W=390n
Mmp55 Q qbint VDD VDD g45p1svt M=1 L=45n W=390n
Mmp36 n20 CKb n7 VDD g45p1svt M=1 L=45n W=215n
Mmp35 n7 mout VDD VDD g45p1svt M=1 L=45n W=215n
Mmp32 mout n20 n5 VDD g45p1svt M=1 L=45n W=215n
Mmp31 n5 RNb VDD VDD g45p1svt M=1 L=45n W=215n
Mmp22 RNb RN VDD VDD g45p1svt M=1 L=45n W=215n
Mmp20 CKb CK VDD VDD g45p1svt M=1 L=45n W=215n
Mmp21 CKbb CKb VDD VDD g45p1svt M=1 L=45n W=215n
Mmp45 qbint n35 VDD VDD g45p1svt M=1 L=45n W=215n
Mmp30 mout SN VDD VDD g45p1svt M=1 L=45n W=215n
Mmp25 n20 CKbb Db VDD g45p1svt M=1 L=45n W=215n
Mmp56 net573 qbint VDD VDD g45p1svt M=1 L=45n W=215n
Mmp40 n35 CKb mout VDD g45p1svt M=1 L=45n W=215n
Mmp53 n35 CKbb n11 VDD g45p1svt M=1 L=45n W=215n
Mmp50 n11 SN VDD VDD g45p1svt M=1 L=45n W=215n
Mmp10 SEb SE VDD VDD g45p1svt M=1 L=45n W=215n
.ENDS

.SUBCKT SDFFSRHQX8 CK D Q RN SE SI SN VDD VSS
Mmn13 net534 SI VSS VSS g45n1svt M=1 L=45n W=260n
Mmn14 Db SE net534 VSS g45n1svt M=1 L=45n W=260n
Mmn12 Db SEb net522 VSS g45n1svt M=1 L=45n W=260n
Mmn11 net522 D VSS VSS g45n1svt M=1 L=45n W=260n
Mmn55 Q qbint VSS VSS g45n1svt M=1 L=45n W=2.065u
Mmn35 net514 mout VSS VSS g45n1svt M=1 L=45n W=205n
Mmn36 n20 CKbb net514 VSS g45n1svt M=1 L=45n W=205n
Mmn22 RNb RN VSS VSS g45n1svt M=1 L=45n W=145n
Mmn20 CKb CK VSS VSS g45n1svt M=1 L=45n W=145n
Mmn45 qbint n35 VSS VSS g45n1svt M=1 L=45n W=780n
Mmn52 net490 qbint net486 VSS g45n1svt M=1 L=45n W=205n
Mmn51 net490 RNb net486 VSS g45n1svt M=1 L=45n W=205n
Mmn50 net486 SN VSS VSS g45n1svt M=1 L=45n W=205n
Mmn53 n35 CKb net490 VSS g45n1svt M=1 L=45n W=205n
Mmn10 SEb SE VSS VSS g45n1svt M=1 L=45n W=145n
Mmn25 Db CKb n20 VSS g45n1svt M=1 L=45n W=205n
Mmn30 net469 SN VSS VSS g45n1svt M=1 L=45n W=205n
Mmn32 mout n20 net469 VSS g45n1svt M=1 L=45n W=205n
Mmn31 mout RNb net469 VSS g45n1svt M=1 L=45n W=205n
Mmn40 n35 CKbb mout VSS g45n1svt M=1 L=45n W=205n
Mmn21 CKbb CKb VSS VSS g45n1svt M=1 L=45n W=145n
Mmp14 Db SEb net453 VDD g45p1svt M=1 L=45n W=390n
Mmp13 net453 SI VDD VDD g45p1svt M=1 L=45n W=390n
Mmp12 Db SE net445 VDD g45p1svt M=1 L=45n W=390n
Mmp11 net445 D VDD VDD g45p1svt M=1 L=45n W=390n
Mmp52 net394 qbint net437 VDD g45p1svt M=1 L=45n W=310n
Mmp51 net437 RNb VDD VDD g45p1svt M=1 L=45n W=310n
Mmp55 Q qbint VDD VDD g45p1svt M=1 L=45n W=3.115u
Mmp36 n20 CKb net425 VDD g45p1svt M=1 L=45n W=310n
Mmp35 net425 mout VDD VDD g45p1svt M=1 L=45n W=310n
Mmp32 mout n20 net417 VDD g45p1svt M=1 L=45n W=310n
Mmp31 net417 RNb VDD VDD g45p1svt M=1 L=45n W=310n
Mmp22 RNb RN VDD VDD g45p1svt M=1 L=45n W=215n
Mmp20 CKb CK VDD VDD g45p1svt M=1 L=45n W=215n
Mmp53 n35 CKbb net394 VDD g45p1svt M=1 L=45n W=310n
Mmp50 net394 SN VDD VDD g45p1svt M=1 L=45n W=310n
Mmp45 qbint n35 VDD VDD g45p1svt M=1 L=45n W=1.17u
Mmp25 n20 CKbb Db VDD g45p1svt M=1 L=45n W=310n
Mmp30 mout SN VDD VDD g45p1svt M=1 L=45n W=310n
Mmp40 n35 CKb mout VDD g45p1svt M=1 L=45n W=310n
Mmp21 CKbb CKb VDD VDD g45p1svt M=1 L=45n W=215n
Mmp10 SEb SE VDD VDD g45p1svt M=1 L=45n W=215n
.ENDS

.SUBCKT SDFFSRHQX4 CK D Q RN SE SI SN VDD VSS
Mmn13 net534 SI VSS VSS g45n1svt M=1 L=45n W=260n
Mmn14 Db SE net534 VSS g45n1svt M=1 L=45n W=260n
Mmn12 Db SEb net522 VSS g45n1svt M=1 L=45n W=260n
Mmn11 net522 D VSS VSS g45n1svt M=1 L=45n W=260n
Mmn55 Q qbint VSS VSS g45n1svt M=1 L=45n W=1.04u
Mmn35 net514 mout VSS VSS g45n1svt M=1 L=45n W=205n
Mmn36 n20 CKbb net514 VSS g45n1svt M=1 L=45n W=205n
Mmn22 RNb RN VSS VSS g45n1svt M=1 L=45n W=145n
Mmn20 CKb CK VSS VSS g45n1svt M=1 L=45n W=145n
Mmn45 qbint n35 VSS VSS g45n1svt M=1 L=45n W=410n
Mmn52 net490 qbint net486 VSS g45n1svt M=1 L=45n W=205n
Mmn51 net490 RNb net486 VSS g45n1svt M=1 L=45n W=205n
Mmn50 net486 SN VSS VSS g45n1svt M=1 L=45n W=205n
Mmn53 n35 CKb net490 VSS g45n1svt M=1 L=45n W=205n
Mmn10 SEb SE VSS VSS g45n1svt M=1 L=45n W=145n
Mmn25 Db CKb n20 VSS g45n1svt M=1 L=45n W=205n
Mmn30 net469 SN VSS VSS g45n1svt M=1 L=45n W=205n
Mmn32 mout n20 net469 VSS g45n1svt M=1 L=45n W=205n
Mmn31 mout RNb net469 VSS g45n1svt M=1 L=45n W=205n
Mmn40 n35 CKbb mout VSS g45n1svt M=1 L=45n W=205n
Mmn21 CKbb CKb VSS VSS g45n1svt M=1 L=45n W=145n
Mmp14 Db SEb net453 VDD g45p1svt M=1 L=45n W=390n
Mmp13 net453 SI VDD VDD g45p1svt M=1 L=45n W=390n
Mmp12 Db SE net445 VDD g45p1svt M=1 L=45n W=390n
Mmp11 net445 D VDD VDD g45p1svt M=1 L=45n W=390n
Mmp52 net394 qbint net437 VDD g45p1svt M=1 L=45n W=310n
Mmp51 net437 RNb VDD VDD g45p1svt M=1 L=45n W=310n
Mmp55 Q qbint VDD VDD g45p1svt M=1 L=45n W=1.56u
Mmp36 n20 CKb net425 VDD g45p1svt M=1 L=45n W=310n
Mmp35 net425 mout VDD VDD g45p1svt M=1 L=45n W=310n
Mmp32 mout n20 net417 VDD g45p1svt M=1 L=45n W=310n
Mmp31 net417 RNb VDD VDD g45p1svt M=1 L=45n W=310n
Mmp22 RNb RN VDD VDD g45p1svt M=1 L=45n W=215n
Mmp20 CKb CK VDD VDD g45p1svt M=1 L=45n W=215n
Mmp53 n35 CKbb net394 VDD g45p1svt M=1 L=45n W=310n
Mmp50 net394 SN VDD VDD g45p1svt M=1 L=45n W=310n
Mmp45 qbint n35 VDD VDD g45p1svt M=1 L=45n W=620n
Mmp25 n20 CKbb Db VDD g45p1svt M=1 L=45n W=310n
Mmp30 mout SN VDD VDD g45p1svt M=1 L=45n W=310n
Mmp40 n35 CKb mout VDD g45p1svt M=1 L=45n W=310n
Mmp21 CKbb CKb VDD VDD g45p1svt M=1 L=45n W=215n
Mmp10 SEb SE VDD VDD g45p1svt M=1 L=45n W=215n
.ENDS

.SUBCKT SDFFSRHQX2 CK D Q RN SE SI SN VDD VSS
Mmn13 net534 SI VSS VSS g45n1svt M=1 L=45n W=260n
Mmn14 Db SE net534 VSS g45n1svt M=1 L=45n W=260n
Mmn12 Db SEb net522 VSS g45n1svt M=1 L=45n W=260n
Mmn11 net522 D VSS VSS g45n1svt M=1 L=45n W=260n
Mmn55 Q qbint VSS VSS g45n1svt M=1 L=45n W=520n
Mmn35 net514 mout VSS VSS g45n1svt M=1 L=45n W=205n
Mmn36 n20 CKbb net514 VSS g45n1svt M=1 L=45n W=205n
Mmn22 RNb RN VSS VSS g45n1svt M=1 L=45n W=145n
Mmn20 CKb CK VSS VSS g45n1svt M=1 L=45n W=145n
Mmn45 qbint n35 VSS VSS g45n1svt M=1 L=45n W=205n
Mmn52 net490 qbint net486 VSS g45n1svt M=1 L=45n W=205n
Mmn51 net490 RNb net486 VSS g45n1svt M=1 L=45n W=205n
Mmn50 net486 SN VSS VSS g45n1svt M=1 L=45n W=205n
Mmn53 n35 CKb net490 VSS g45n1svt M=1 L=45n W=205n
Mmn10 SEb SE VSS VSS g45n1svt M=1 L=45n W=145n
Mmn25 Db CKb n20 VSS g45n1svt M=1 L=45n W=205n
Mmn30 net469 SN VSS VSS g45n1svt M=1 L=45n W=205n
Mmn32 mout n20 net469 VSS g45n1svt M=1 L=45n W=205n
Mmn31 mout RNb net469 VSS g45n1svt M=1 L=45n W=205n
Mmn40 n35 CKbb mout VSS g45n1svt M=1 L=45n W=205n
Mmn21 CKbb CKb VSS VSS g45n1svt M=1 L=45n W=145n
Mmp14 Db SEb net453 VDD g45p1svt M=1 L=45n W=390n
Mmp13 net453 SI VDD VDD g45p1svt M=1 L=45n W=390n
Mmp12 Db SE net445 VDD g45p1svt M=1 L=45n W=390n
Mmp11 net445 D VDD VDD g45p1svt M=1 L=45n W=390n
Mmp52 net394 qbint net437 VDD g45p1svt M=1 L=45n W=310n
Mmp51 net437 RNb VDD VDD g45p1svt M=1 L=45n W=310n
Mmp55 Q qbint VDD VDD g45p1svt M=1 L=45n W=780n
Mmp36 n20 CKb net425 VDD g45p1svt M=1 L=45n W=310n
Mmp35 net425 mout VDD VDD g45p1svt M=1 L=45n W=310n
Mmp32 mout n20 net417 VDD g45p1svt M=1 L=45n W=310n
Mmp31 net417 RNb VDD VDD g45p1svt M=1 L=45n W=310n
Mmp22 RNb RN VDD VDD g45p1svt M=1 L=45n W=215n
Mmp20 CKb CK VDD VDD g45p1svt M=1 L=45n W=215n
Mmp53 n35 CKbb net394 VDD g45p1svt M=1 L=45n W=310n
Mmp50 net394 SN VDD VDD g45p1svt M=1 L=45n W=310n
Mmp45 qbint n35 VDD VDD g45p1svt M=1 L=45n W=310n
Mmp25 n20 CKbb Db VDD g45p1svt M=1 L=45n W=310n
Mmp30 mout SN VDD VDD g45p1svt M=1 L=45n W=310n
Mmp40 n35 CKb mout VDD g45p1svt M=1 L=45n W=310n
Mmp21 CKbb CKb VDD VDD g45p1svt M=1 L=45n W=215n
Mmp10 SEb SE VDD VDD g45p1svt M=1 L=45n W=215n
.ENDS

.SUBCKT SDFFSRHQX1 CK D Q RN SE SI SN VDD VSS
Mmn13 net534 SI VSS VSS g45n1svt M=1 L=45n W=260n
Mmn14 Db SE net534 VSS g45n1svt M=1 L=45n W=260n
Mmn12 Db SEb net522 VSS g45n1svt M=1 L=45n W=260n
Mmn11 net522 D VSS VSS g45n1svt M=1 L=45n W=260n
Mmn55 Q qbint VSS VSS g45n1svt M=1 L=45n W=260n
Mmn35 net514 mout VSS VSS g45n1svt M=1 L=45n W=205n
Mmn36 n20 CKbb net514 VSS g45n1svt M=1 L=45n W=205n
Mmn22 RNb RN VSS VSS g45n1svt M=1 L=45n W=145n
Mmn20 CKb CK VSS VSS g45n1svt M=1 L=45n W=145n
Mmn45 qbint n35 VSS VSS g45n1svt M=1 L=45n W=205n
Mmn52 net490 qbint net486 VSS g45n1svt M=1 L=45n W=205n
Mmn51 net490 RNb net486 VSS g45n1svt M=1 L=45n W=205n
Mmn50 net486 SN VSS VSS g45n1svt M=1 L=45n W=205n
Mmn53 n35 CKb net490 VSS g45n1svt M=1 L=45n W=205n
Mmn10 SEb SE VSS VSS g45n1svt M=1 L=45n W=145n
Mmn25 Db CKb n20 VSS g45n1svt M=1 L=45n W=205n
Mmn30 net469 SN VSS VSS g45n1svt M=1 L=45n W=205n
Mmn32 mout n20 net469 VSS g45n1svt M=1 L=45n W=205n
Mmn31 mout RNb net469 VSS g45n1svt M=1 L=45n W=205n
Mmn40 n35 CKbb mout VSS g45n1svt M=1 L=45n W=205n
Mmn21 CKbb CKb VSS VSS g45n1svt M=1 L=45n W=145n
Mmp14 Db SEb net453 VDD g45p1svt M=1 L=45n W=390n
Mmp13 net453 SI VDD VDD g45p1svt M=1 L=45n W=390n
Mmp12 Db SE net445 VDD g45p1svt M=1 L=45n W=390n
Mmp11 net445 D VDD VDD g45p1svt M=1 L=45n W=390n
Mmp52 net394 qbint net437 VDD g45p1svt M=1 L=45n W=310n
Mmp51 net437 RNb VDD VDD g45p1svt M=1 L=45n W=310n
Mmp55 Q qbint VDD VDD g45p1svt M=1 L=45n W=390n
Mmp36 n20 CKb net425 VDD g45p1svt M=1 L=45n W=310n
Mmp35 net425 mout VDD VDD g45p1svt M=1 L=45n W=310n
Mmp32 mout n20 net417 VDD g45p1svt M=1 L=45n W=310n
Mmp31 net417 RNb VDD VDD g45p1svt M=1 L=45n W=310n
Mmp22 RNb RN VDD VDD g45p1svt M=1 L=45n W=215n
Mmp20 CKb CK VDD VDD g45p1svt M=1 L=45n W=215n
Mmp53 n35 CKbb net394 VDD g45p1svt M=1 L=45n W=310n
Mmp50 net394 SN VDD VDD g45p1svt M=1 L=45n W=310n
Mmp45 qbint n35 VDD VDD g45p1svt M=1 L=45n W=310n
Mmp25 n20 CKbb Db VDD g45p1svt M=1 L=45n W=310n
Mmp30 mout SN VDD VDD g45p1svt M=1 L=45n W=310n
Mmp40 n35 CKb mout VDD g45p1svt M=1 L=45n W=310n
Mmp21 CKbb CKb VDD VDD g45p1svt M=1 L=45n W=215n
Mmp10 SEb SE VDD VDD g45p1svt M=1 L=45n W=215n
.ENDS

.SUBCKT SDFFSHQX8 CK D Q SE SI SN VDD VSS
Mmn51 net467 qbint net459 VSS g45n1svt M=1 L=45n W=205n
Mmn52 n30 CKb net467 VSS g45n1svt M=1 L=45n W=205n
Mmn50 net459 SN VSS VSS g45n1svt M=1 L=45n W=205n
Mmn13 net455 SI VSS VSS g45n1svt M=1 L=45n W=260n
Mmn14 Db SE net455 VSS g45n1svt M=1 L=45n W=260n
Mmn12 Db SEb net443 VSS g45n1svt M=1 L=45n W=260n
Mmn11 net443 D VSS VSS g45n1svt M=1 L=45n W=260n
Mmn55 Q qbint VSS VSS g45n1svt M=1 L=45n W=2.065u
Mmn30 net435 SN VSS VSS g45n1svt M=1 L=45n W=205n
Mmn31 mout n20 net435 VSS g45n1svt M=1 L=45n W=205n
Mmn35 net427 mout VSS VSS g45n1svt M=1 L=45n W=205n
Mmn36 n20 CKbb net427 VSS g45n1svt M=1 L=45n W=205n
Mmn20 CKb CK VSS VSS g45n1svt M=1 L=45n W=145n
Mmn10 SEb SE VSS VSS g45n1svt M=1 L=45n W=145n
Mmn25 n20 CKb Db VSS g45n1svt M=1 L=45n W=205n
Mmn40 n30 CKbb mout VSS g45n1svt M=1 L=45n W=205n
Mmn45 qbint n30 VSS VSS g45n1svt M=1 L=45n W=780n
Mmn21 CKbb CKb VSS VSS g45n1svt M=1 L=45n W=145n
Mmp14 Db SEb net398 VDD g45p1svt M=1 L=45n W=390n
Mmp13 net398 SI VDD VDD g45p1svt M=1 L=45n W=390n
Mmp12 Db SE net390 VDD g45p1svt M=1 L=45n W=390n
Mmp11 net390 D VDD VDD g45p1svt M=1 L=45n W=390n
Mmp55 Q qbint VDD VDD g45p1svt M=1 L=45n W=3.115u
Mmp36 n20 CKb net378 VDD g45p1svt M=1 L=45n W=310n
Mmp35 net378 mout VDD VDD g45p1svt M=1 L=45n W=310n
Mmp20 CKb CK VDD VDD g45p1svt M=1 L=45n W=215n
Mmp52 n30 CKbb net355 VDD g45p1svt M=1 L=45n W=310n
Mmp51 net355 qbint VDD VDD g45p1svt M=1 L=45n W=310n
Mmp50 net355 SN VDD VDD g45p1svt M=1 L=45n W=310n
Mmp21 CKbb CKb VDD VDD g45p1svt M=1 L=45n W=215n
Mmp31 mout n20 VDD VDD g45p1svt M=1 L=45n W=310n
Mmp45 qbint n30 VDD VDD g45p1svt M=1 L=45n W=1.17u
Mmp30 mout SN VDD VDD g45p1svt M=1 L=45n W=310n
Mmp25 n20 CKbb Db VDD g45p1svt M=1 L=45n W=310n
Mmp40 n30 CKb mout VDD g45p1svt M=1 L=45n W=310n
Mmp10 SEb SE VDD VDD g45p1svt M=1 L=45n W=215n
.ENDS

.SUBCKT SDFFSHQX4 CK D Q SE SI SN VDD VSS
Mmn51 net467 qbint net459 VSS g45n1svt M=1 L=45n W=205n
Mmn52 n30 CKb net467 VSS g45n1svt M=1 L=45n W=205n
Mmn50 net459 SN VSS VSS g45n1svt M=1 L=45n W=205n
Mmn13 net455 SI VSS VSS g45n1svt M=1 L=45n W=260n
Mmn14 Db SE net455 VSS g45n1svt M=1 L=45n W=260n
Mmn12 Db SEb net443 VSS g45n1svt M=1 L=45n W=260n
Mmn11 net443 D VSS VSS g45n1svt M=1 L=45n W=260n
Mmn55 Q qbint VSS VSS g45n1svt M=1 L=45n W=1.04u
Mmn30 net435 SN VSS VSS g45n1svt M=1 L=45n W=205n
Mmn31 mout n20 net435 VSS g45n1svt M=1 L=45n W=205n
Mmn35 net427 mout VSS VSS g45n1svt M=1 L=45n W=205n
Mmn36 n20 CKbb net427 VSS g45n1svt M=1 L=45n W=205n
Mmn20 CKb CK VSS VSS g45n1svt M=1 L=45n W=145n
Mmn10 SEb SE VSS VSS g45n1svt M=1 L=45n W=145n
Mmn25 n20 CKb Db VSS g45n1svt M=1 L=45n W=205n
Mmn40 n30 CKbb mout VSS g45n1svt M=1 L=45n W=205n
Mmn45 qbint n30 VSS VSS g45n1svt M=1 L=45n W=410n
Mmn21 CKbb CKb VSS VSS g45n1svt M=1 L=45n W=145n
Mmp14 Db SEb net398 VDD g45p1svt M=1 L=45n W=390n
Mmp13 net398 SI VDD VDD g45p1svt M=1 L=45n W=390n
Mmp12 Db SE net390 VDD g45p1svt M=1 L=45n W=390n
Mmp11 net390 D VDD VDD g45p1svt M=1 L=45n W=390n
Mmp55 Q qbint VDD VDD g45p1svt M=1 L=45n W=1.56u
Mmp36 n20 CKb net378 VDD g45p1svt M=1 L=45n W=310n
Mmp35 net378 mout VDD VDD g45p1svt M=1 L=45n W=310n
Mmp20 CKb CK VDD VDD g45p1svt M=1 L=45n W=215n
Mmp52 n30 CKbb net355 VDD g45p1svt M=1 L=45n W=310n
Mmp51 net355 qbint VDD VDD g45p1svt M=1 L=45n W=310n
Mmp50 net355 SN VDD VDD g45p1svt M=1 L=45n W=310n
Mmp21 CKbb CKb VDD VDD g45p1svt M=1 L=45n W=215n
Mmp31 mout n20 VDD VDD g45p1svt M=1 L=45n W=310n
Mmp45 qbint n30 VDD VDD g45p1svt M=1 L=45n W=620n
Mmp30 mout SN VDD VDD g45p1svt M=1 L=45n W=310n
Mmp25 n20 CKbb Db VDD g45p1svt M=1 L=45n W=310n
Mmp40 n30 CKb mout VDD g45p1svt M=1 L=45n W=310n
Mmp10 SEb SE VDD VDD g45p1svt M=1 L=45n W=215n
.ENDS

.SUBCKT SDFFSHQX2 CK D Q SE SI SN VDD VSS
Mmn51 net467 qbint net459 VSS g45n1svt M=1 L=45n W=205n
Mmn52 n30 CKb net467 VSS g45n1svt M=1 L=45n W=205n
Mmn50 net459 SN VSS VSS g45n1svt M=1 L=45n W=205n
Mmn13 net455 SI VSS VSS g45n1svt M=1 L=45n W=260n
Mmn14 Db SE net455 VSS g45n1svt M=1 L=45n W=260n
Mmn12 Db SEb net443 VSS g45n1svt M=1 L=45n W=260n
Mmn11 net443 D VSS VSS g45n1svt M=1 L=45n W=260n
Mmn55 Q qbint VSS VSS g45n1svt M=1 L=45n W=520n
Mmn30 net435 SN VSS VSS g45n1svt M=1 L=45n W=205n
Mmn31 mout n20 net435 VSS g45n1svt M=1 L=45n W=205n
Mmn35 net427 mout VSS VSS g45n1svt M=1 L=45n W=205n
Mmn36 n20 CKbb net427 VSS g45n1svt M=1 L=45n W=205n
Mmn20 CKb CK VSS VSS g45n1svt M=1 L=45n W=145n
Mmn10 SEb SE VSS VSS g45n1svt M=1 L=45n W=145n
Mmn25 n20 CKb Db VSS g45n1svt M=1 L=45n W=205n
Mmn40 n30 CKbb mout VSS g45n1svt M=1 L=45n W=205n
Mmn45 qbint n30 VSS VSS g45n1svt M=1 L=45n W=205n
Mmn21 CKbb CKb VSS VSS g45n1svt M=1 L=45n W=145n
Mmp14 Db SEb net398 VDD g45p1svt M=1 L=45n W=390n
Mmp13 net398 SI VDD VDD g45p1svt M=1 L=45n W=390n
Mmp12 Db SE net390 VDD g45p1svt M=1 L=45n W=390n
Mmp11 net390 D VDD VDD g45p1svt M=1 L=45n W=390n
Mmp55 Q qbint VDD VDD g45p1svt M=1 L=45n W=780n
Mmp36 n20 CKb net378 VDD g45p1svt M=1 L=45n W=310n
Mmp35 net378 mout VDD VDD g45p1svt M=1 L=45n W=310n
Mmp20 CKb CK VDD VDD g45p1svt M=1 L=45n W=215n
Mmp52 n30 CKbb net355 VDD g45p1svt M=1 L=45n W=310n
Mmp51 net355 qbint VDD VDD g45p1svt M=1 L=45n W=310n
Mmp50 net355 SN VDD VDD g45p1svt M=1 L=45n W=310n
Mmp21 CKbb CKb VDD VDD g45p1svt M=1 L=45n W=215n
Mmp31 mout n20 VDD VDD g45p1svt M=1 L=45n W=310n
Mmp45 qbint n30 VDD VDD g45p1svt M=1 L=45n W=310n
Mmp30 mout SN VDD VDD g45p1svt M=1 L=45n W=310n
Mmp25 n20 CKbb Db VDD g45p1svt M=1 L=45n W=310n
Mmp40 n30 CKb mout VDD g45p1svt M=1 L=45n W=310n
Mmp10 SEb SE VDD VDD g45p1svt M=1 L=45n W=215n
.ENDS

.SUBCKT SDFFSHQX1 CK D Q SE SI SN VDD VSS
Mmn51 net467 qbint net459 VSS g45n1svt M=1 L=45n W=205n
Mmn52 n30 CKb net467 VSS g45n1svt M=1 L=45n W=205n
Mmn50 net459 SN VSS VSS g45n1svt M=1 L=45n W=205n
Mmn13 net455 SI VSS VSS g45n1svt M=1 L=45n W=260n
Mmn14 Db SE net455 VSS g45n1svt M=1 L=45n W=260n
Mmn12 Db SEb net443 VSS g45n1svt M=1 L=45n W=260n
Mmn11 net443 D VSS VSS g45n1svt M=1 L=45n W=260n
Mmn55 Q qbint VSS VSS g45n1svt M=1 L=45n W=260n
Mmn30 net435 SN VSS VSS g45n1svt M=1 L=45n W=205n
Mmn31 mout n20 net435 VSS g45n1svt M=1 L=45n W=205n
Mmn35 net427 mout VSS VSS g45n1svt M=1 L=45n W=205n
Mmn36 n20 CKbb net427 VSS g45n1svt M=1 L=45n W=205n
Mmn20 CKb CK VSS VSS g45n1svt M=1 L=45n W=145n
Mmn10 SEb SE VSS VSS g45n1svt M=1 L=45n W=145n
Mmn25 n20 CKb Db VSS g45n1svt M=1 L=45n W=205n
Mmn40 n30 CKbb mout VSS g45n1svt M=1 L=45n W=205n
Mmn45 qbint n30 VSS VSS g45n1svt M=1 L=45n W=205n
Mmn21 CKbb CKb VSS VSS g45n1svt M=1 L=45n W=145n
Mmp14 Db SEb net398 VDD g45p1svt M=1 L=45n W=390n
Mmp13 net398 SI VDD VDD g45p1svt M=1 L=45n W=390n
Mmp12 Db SE net390 VDD g45p1svt M=1 L=45n W=390n
Mmp11 net390 D VDD VDD g45p1svt M=1 L=45n W=390n
Mmp55 Q qbint VDD VDD g45p1svt M=1 L=45n W=390n
Mmp36 n20 CKb net378 VDD g45p1svt M=1 L=45n W=310n
Mmp35 net378 mout VDD VDD g45p1svt M=1 L=45n W=310n
Mmp20 CKb CK VDD VDD g45p1svt M=1 L=45n W=215n
Mmp52 n30 CKbb net355 VDD g45p1svt M=1 L=45n W=310n
Mmp51 net355 qbint VDD VDD g45p1svt M=1 L=45n W=310n
Mmp50 net355 SN VDD VDD g45p1svt M=1 L=45n W=310n
Mmp21 CKbb CKb VDD VDD g45p1svt M=1 L=45n W=215n
Mmp31 mout n20 VDD VDD g45p1svt M=1 L=45n W=310n
Mmp45 qbint n30 VDD VDD g45p1svt M=1 L=45n W=310n
Mmp30 mout SN VDD VDD g45p1svt M=1 L=45n W=310n
Mmp25 n20 CKbb Db VDD g45p1svt M=1 L=45n W=310n
Mmp40 n30 CKb mout VDD g45p1svt M=1 L=45n W=310n
Mmp10 SEb SE VDD VDD g45p1svt M=1 L=45n W=215n
.ENDS

.SUBCKT SDFFRXL CK D Q QN RN SE SI VDD VSS
Mmn36 n5 mout n7 VSS g45n1svt M=1 L=45n W=145n
Mmn35 n7 RN VSS VSS g45n1svt M=1 L=45n W=145n
Mmn37 n20 Ckbb n5 VSS g45n1svt M=1 L=45n W=145n
Mmn13 n3 SI VSS VSS g45n1svt M=1 L=45n W=145n
Mmn14 Db SE n3 VSS g45n1svt M=1 L=45n W=145n
Mmn12 Db SEb n1 VSS g45n1svt M=1 L=45n W=145n
Mmn11 n1 D VSS VSS g45n1svt M=1 L=45n W=145n
Mmn57 QN qint VSS VSS g45n1svt M=1 L=45n W=145n
Mmn55 Q qbint VSS VSS g45n1svt M=1 L=45n W=145n
Mmn45 n9 RN VSS VSS g45n1svt M=1 L=45n W=145n
Mmn46 qbint n30 n9 VSS g45n1svt M=1 L=45n W=145n
Mmn51 n30 CKb n11 VSS g45n1svt M=1 L=45n W=145n
Mmn50 n11 qbint VSS VSS g45n1svt M=1 L=45n W=145n
Mmn20 CKb CK VSS VSS g45n1svt M=1 L=45n W=145n
Mmn56 qint qbint VSS VSS g45n1svt M=1 L=45n W=145n
Mmn40 mout Ckbb n30 VSS g45n1svt M=1 L=45n W=145n
Mmn30 mout n20 VSS VSS g45n1svt M=1 L=45n W=145n
Mmn21 Ckbb CKb VSS VSS g45n1svt M=1 L=45n W=145n
Mmn10 SEb SE VSS VSS g45n1svt M=1 L=45n W=145n
Mmn25 Db CKb n20 VSS g45n1svt M=1 L=45n W=145n
Mmp14 Db SEb n4 VDD g45p1svt M=1 L=45n W=215n
Mmp13 n4 SI VDD VDD g45p1svt M=1 L=45n W=215n
Mmp12 Db SE n2 VDD g45p1svt M=1 L=45n W=215n
Mmp11 n2 D VDD VDD g45p1svt M=1 L=45n W=215n
Mmp51 n30 Ckbb n8 VDD g45p1svt M=1 L=45n W=215n
Mmp50 n8 qbint VDD VDD g45p1svt M=1 L=45n W=215n
Mmp55 Q qbint VDD VDD g45p1svt M=1 L=45n W=215n
Mmp20 CKb CK VDD VDD g45p1svt M=1 L=45n W=215n
Mmp46 qbint n30 VDD VDD g45p1svt M=1 L=45n W=215n
Mmp56 qint qbint VDD VDD g45p1svt M=1 L=45n W=215n
Mmp45 qbint RN VDD VDD g45p1svt M=1 L=45n W=215n
Mmp35 n6 RN VDD VDD g45p1svt M=1 L=45n W=215n
Mmp36 n6 mout VDD VDD g45p1svt M=1 L=45n W=215n
Mmp37 n20 CKb n6 VDD g45p1svt M=1 L=45n W=215n
Mmp40 n30 CKb mout VDD g45p1svt M=1 L=45n W=215n
Mmp30 mout n20 VDD VDD g45p1svt M=1 L=45n W=215n
Mmp21 Ckbb CKb VDD VDD g45p1svt M=1 L=45n W=215n
Mmp25 n20 Ckbb Db VDD g45p1svt M=1 L=45n W=215n
Mmp10 SEb SE VDD VDD g45p1svt M=1 L=45n W=215n
Mmp57 QN qint VDD VDD g45p1svt M=1 L=45n W=215n
.ENDS

.SUBCKT SDFFRX4 CK D Q QN RN SE SI VDD VSS
Mmn36 n5 mout n7 VSS g45n1svt M=1 L=45n W=145n
Mmn35 n7 RN VSS VSS g45n1svt M=1 L=45n W=145n
Mmn37 n20 Ckbb n5 VSS g45n1svt M=1 L=45n W=145n
Mmn13 n3 SI VSS VSS g45n1svt M=1 L=45n W=145n
Mmn14 Db SE n3 VSS g45n1svt M=1 L=45n W=145n
Mmn12 Db SEb n1 VSS g45n1svt M=1 L=45n W=145n
Mmn11 n1 D VSS VSS g45n1svt M=1 L=45n W=145n
Mmn57 QN qint VSS VSS g45n1svt M=1 L=45n W=1.04u
Mmn55 Q qbint VSS VSS g45n1svt M=1 L=45n W=1.04u
Mmn45 n9 RN VSS VSS g45n1svt M=1 L=45n W=410n
Mmn46 qbint n30 n9 VSS g45n1svt M=1 L=45n W=410n
Mmn51 n30 CKb n11 VSS g45n1svt M=1 L=45n W=145n
Mmn50 n11 qbint VSS VSS g45n1svt M=1 L=45n W=145n
Mmn20 CKb CK VSS VSS g45n1svt M=1 L=45n W=145n
Mmn56 qint qbint VSS VSS g45n1svt M=1 L=45n W=260n
Mmn40 mout Ckbb n30 VSS g45n1svt M=1 L=45n W=145n
Mmn30 mout n20 VSS VSS g45n1svt M=1 L=45n W=145n
Mmn21 Ckbb CKb VSS VSS g45n1svt M=1 L=45n W=145n
Mmn10 SEb SE VSS VSS g45n1svt M=1 L=45n W=145n
Mmn25 Db CKb n20 VSS g45n1svt M=1 L=45n W=145n
Mmp14 Db SEb n4 VDD g45p1svt M=1 L=45n W=215n
Mmp13 n4 SI VDD VDD g45p1svt M=1 L=45n W=215n
Mmp12 Db SE n2 VDD g45p1svt M=1 L=45n W=215n
Mmp11 n2 D VDD VDD g45p1svt M=1 L=45n W=215n
Mmp51 n30 Ckbb n8 VDD g45p1svt M=1 L=45n W=215n
Mmp50 n8 qbint VDD VDD g45p1svt M=1 L=45n W=215n
Mmp55 Q qbint VDD VDD g45p1svt M=1 L=45n W=1.56u
Mmp20 CKb CK VDD VDD g45p1svt M=1 L=45n W=215n
Mmp46 qbint n30 VDD VDD g45p1svt M=1 L=45n W=620n
Mmp56 qint qbint VDD VDD g45p1svt M=1 L=45n W=390n
Mmp45 qbint RN VDD VDD g45p1svt M=1 L=45n W=620n
Mmp35 n6 RN VDD VDD g45p1svt M=1 L=45n W=215n
Mmp36 n6 mout VDD VDD g45p1svt M=1 L=45n W=215n
Mmp37 n20 CKb n6 VDD g45p1svt M=1 L=45n W=215n
Mmp40 n30 CKb mout VDD g45p1svt M=1 L=45n W=215n
Mmp30 mout n20 VDD VDD g45p1svt M=1 L=45n W=215n
Mmp21 Ckbb CKb VDD VDD g45p1svt M=1 L=45n W=215n
Mmp25 n20 Ckbb Db VDD g45p1svt M=1 L=45n W=215n
Mmp10 SEb SE VDD VDD g45p1svt M=1 L=45n W=215n
Mmp57 QN qint VDD VDD g45p1svt M=1 L=45n W=1.56u
.ENDS

.SUBCKT SDFFRX2 CK D Q QN RN SE SI VDD VSS
Mmn36 n5 mout n7 VSS g45n1svt M=1 L=45n W=145n
Mmn35 n7 RN VSS VSS g45n1svt M=1 L=45n W=145n
Mmn37 n20 Ckbb n5 VSS g45n1svt M=1 L=45n W=145n
Mmn13 n3 SI VSS VSS g45n1svt M=1 L=45n W=145n
Mmn14 Db SE n3 VSS g45n1svt M=1 L=45n W=145n
Mmn12 Db SEb n1 VSS g45n1svt M=1 L=45n W=145n
Mmn11 n1 D VSS VSS g45n1svt M=1 L=45n W=145n
Mmn57 QN qint VSS VSS g45n1svt M=1 L=45n W=520n
Mmn55 Q qbint VSS VSS g45n1svt M=1 L=45n W=520n
Mmn45 n9 RN VSS VSS g45n1svt M=1 L=45n W=205n
Mmn46 qbint n30 n9 VSS g45n1svt M=1 L=45n W=205n
Mmn51 n30 CKb n11 VSS g45n1svt M=1 L=45n W=145n
Mmn50 n11 qbint VSS VSS g45n1svt M=1 L=45n W=145n
Mmn20 CKb CK VSS VSS g45n1svt M=1 L=45n W=145n
Mmn56 qint qbint VSS VSS g45n1svt M=1 L=45n W=145n
Mmn40 mout Ckbb n30 VSS g45n1svt M=1 L=45n W=145n
Mmn30 mout n20 VSS VSS g45n1svt M=1 L=45n W=145n
Mmn21 Ckbb CKb VSS VSS g45n1svt M=1 L=45n W=145n
Mmn10 SEb SE VSS VSS g45n1svt M=1 L=45n W=145n
Mmn25 Db CKb n20 VSS g45n1svt M=1 L=45n W=145n
Mmp14 Db SEb n4 VDD g45p1svt M=1 L=45n W=215n
Mmp13 n4 SI VDD VDD g45p1svt M=1 L=45n W=215n
Mmp12 Db SE n2 VDD g45p1svt M=1 L=45n W=215n
Mmp11 n2 D VDD VDD g45p1svt M=1 L=45n W=215n
Mmp51 n30 Ckbb n8 VDD g45p1svt M=1 L=45n W=215n
Mmp50 n8 qbint VDD VDD g45p1svt M=1 L=45n W=215n
Mmp55 Q qbint VDD VDD g45p1svt M=1 L=45n W=780n
Mmp20 CKb CK VDD VDD g45p1svt M=1 L=45n W=215n
Mmp46 qbint n30 VDD VDD g45p1svt M=1 L=45n W=310n
Mmp56 qint qbint VDD VDD g45p1svt M=1 L=45n W=215n
Mmp45 qbint RN VDD VDD g45p1svt M=1 L=45n W=310n
Mmp35 n6 RN VDD VDD g45p1svt M=1 L=45n W=215n
Mmp36 n6 mout VDD VDD g45p1svt M=1 L=45n W=215n
Mmp37 n20 CKb n6 VDD g45p1svt M=1 L=45n W=215n
Mmp40 n30 CKb mout VDD g45p1svt M=1 L=45n W=215n
Mmp30 mout n20 VDD VDD g45p1svt M=1 L=45n W=215n
Mmp21 Ckbb CKb VDD VDD g45p1svt M=1 L=45n W=215n
Mmp25 n20 Ckbb Db VDD g45p1svt M=1 L=45n W=215n
Mmp10 SEb SE VDD VDD g45p1svt M=1 L=45n W=215n
Mmp57 QN qint VDD VDD g45p1svt M=1 L=45n W=780n
.ENDS

.SUBCKT SDFFRX1 CK D Q QN RN SE SI VDD VSS
Mmn36 n5 mout n7 VSS g45n1svt M=1 L=45n W=145n
Mmn35 n7 RN VSS VSS g45n1svt M=1 L=45n W=145n
Mmn37 n20 Ckbb n5 VSS g45n1svt M=1 L=45n W=145n
Mmn13 n3 SI VSS VSS g45n1svt M=1 L=45n W=145n
Mmn14 Db SE n3 VSS g45n1svt M=1 L=45n W=145n
Mmn12 Db SEb n1 VSS g45n1svt M=1 L=45n W=145n
Mmn11 n1 D VSS VSS g45n1svt M=1 L=45n W=145n
Mmn57 QN qint VSS VSS g45n1svt M=1 L=45n W=260n
Mmn55 Q qbint VSS VSS g45n1svt M=1 L=45n W=260n
Mmn45 n9 RN VSS VSS g45n1svt M=1 L=45n W=145n
Mmn46 qbint n30 n9 VSS g45n1svt M=1 L=45n W=145n
Mmn51 n30 CKb n11 VSS g45n1svt M=1 L=45n W=145n
Mmn50 n11 qbint VSS VSS g45n1svt M=1 L=45n W=145n
Mmn20 CKb CK VSS VSS g45n1svt M=1 L=45n W=145n
Mmn56 qint qbint VSS VSS g45n1svt M=1 L=45n W=145n
Mmn40 mout Ckbb n30 VSS g45n1svt M=1 L=45n W=145n
Mmn30 mout n20 VSS VSS g45n1svt M=1 L=45n W=145n
Mmn21 Ckbb CKb VSS VSS g45n1svt M=1 L=45n W=145n
Mmn10 SEb SE VSS VSS g45n1svt M=1 L=45n W=145n
Mmn25 Db CKb n20 VSS g45n1svt M=1 L=45n W=145n
Mmp14 Db SEb n4 VDD g45p1svt M=1 L=45n W=215n
Mmp13 n4 SI VDD VDD g45p1svt M=1 L=45n W=215n
Mmp12 Db SE n2 VDD g45p1svt M=1 L=45n W=215n
Mmp11 n2 D VDD VDD g45p1svt M=1 L=45n W=215n
Mmp51 n30 Ckbb n8 VDD g45p1svt M=1 L=45n W=215n
Mmp50 n8 qbint VDD VDD g45p1svt M=1 L=45n W=215n
Mmp55 Q qbint VDD VDD g45p1svt M=1 L=45n W=390n
Mmp20 CKb CK VDD VDD g45p1svt M=1 L=45n W=215n
Mmp46 qbint n30 VDD VDD g45p1svt M=1 L=45n W=215n
Mmp56 qint qbint VDD VDD g45p1svt M=1 L=45n W=215n
Mmp45 qbint RN VDD VDD g45p1svt M=1 L=45n W=215n
Mmp35 n6 RN VDD VDD g45p1svt M=1 L=45n W=215n
Mmp36 n6 mout VDD VDD g45p1svt M=1 L=45n W=215n
Mmp37 n20 CKb n6 VDD g45p1svt M=1 L=45n W=215n
Mmp40 n30 CKb mout VDD g45p1svt M=1 L=45n W=215n
Mmp30 mout n20 VDD VDD g45p1svt M=1 L=45n W=215n
Mmp21 Ckbb CKb VDD VDD g45p1svt M=1 L=45n W=215n
Mmp25 n20 Ckbb Db VDD g45p1svt M=1 L=45n W=215n
Mmp10 SEb SE VDD VDD g45p1svt M=1 L=45n W=215n
Mmp57 QN qint VDD VDD g45p1svt M=1 L=45n W=390n
.ENDS

.SUBCKT SDFFRHQX8 CK D Q RN SE SI VDD VSS
Mmn36 net422 mout net426 VSS g45n1svt M=1 L=45n W=205n
Mmn35 net426 RN VSS VSS g45n1svt M=1 L=45n W=205n
Mmn37 n20 CKbb net422 VSS g45n1svt M=1 L=45n W=205n
Mmn13 net442 SI VSS VSS g45n1svt M=1 L=45n W=260n
Mmn14 Db SE net442 VSS g45n1svt M=1 L=45n W=260n
Mmn12 Db SEb net450 VSS g45n1svt M=1 L=45n W=260n
Mmn11 net450 D VSS VSS g45n1svt M=1 L=45n W=260n
Mmn55 Q qbint VSS VSS g45n1svt M=1 L=45n W=2.065u
Mmn45 net337 RN VSS VSS g45n1svt M=1 L=45n W=780n
Mmn46 qbint n30 net337 VSS g45n1svt M=1 L=45n W=780n
Mmn51 n30 CKb net405 VSS g45n1svt M=1 L=45n W=205n
Mmn50 net405 qbint VSS VSS g45n1svt M=1 L=45n W=205n
Mmn20 CKb CK VSS VSS g45n1svt M=1 L=45n W=145n
Mmn40 n30 CKbb mout VSS g45n1svt M=1 L=45n W=205n
Mmn30 mout n20 VSS VSS g45n1svt M=1 L=45n W=205n
Mmn21 CKbb CKb VSS VSS g45n1svt M=1 L=45n W=145n
Mmn10 SEb SE VSS VSS g45n1svt M=1 L=45n W=145n
Mmn25 n20 CKb Db VSS g45n1svt M=1 L=45n W=205n
Mmp14 Db SEb net373 VDD g45p1svt M=1 L=45n W=390n
Mmp13 net373 SI VDD VDD g45p1svt M=1 L=45n W=390n
Mmp12 Db SE net381 VDD g45p1svt M=1 L=45n W=390n
Mmp11 net381 D VDD VDD g45p1svt M=1 L=45n W=390n
Mmp51 n30 CKbb net326 VDD g45p1svt M=1 L=45n W=310n
Mmp50 net326 qbint VDD VDD g45p1svt M=1 L=45n W=310n
Mmp55 Q qbint VDD VDD g45p1svt M=1 L=45n W=3.115u
Mmp20 CKb CK VDD VDD g45p1svt M=1 L=45n W=215n
Mmp46 qbint n30 VDD VDD g45p1svt M=1 L=45n W=1.17u
Mmp45 VDD RN qbint VDD g45p1svt M=1 L=45n W=1.17u
Mmp35 net349 RN VDD VDD g45p1svt M=1 L=45n W=310n
Mmp36 net349 mout VDD VDD g45p1svt M=1 L=45n W=310n
Mmp37 n20 CKb net349 VDD g45p1svt M=1 L=45n W=310n
Mmp40 n30 CKb mout VDD g45p1svt M=1 L=45n W=310n
Mmp30 mout n20 VDD VDD g45p1svt M=1 L=45n W=310n
Mmp21 CKbb CKb VDD VDD g45p1svt M=1 L=45n W=215n
Mmp25 n20 CKbb Db VDD g45p1svt M=1 L=45n W=310n
Mmp10 SEb SE VDD VDD g45p1svt M=1 L=45n W=215n
.ENDS

.SUBCKT SDFFRHQX4 CK D Q RN SE SI VDD VSS
Mmn36 net422 mout net426 VSS g45n1svt M=1 L=45n W=205n
Mmn35 net426 RN VSS VSS g45n1svt M=1 L=45n W=205n
Mmn37 n20 CKbb net422 VSS g45n1svt M=1 L=45n W=205n
Mmn13 net442 SI VSS VSS g45n1svt M=1 L=45n W=260n
Mmn14 Db SE net442 VSS g45n1svt M=1 L=45n W=260n
Mmn12 Db SEb net450 VSS g45n1svt M=1 L=45n W=260n
Mmn11 net450 D VSS VSS g45n1svt M=1 L=45n W=260n
Mmn55 Q qbint VSS VSS g45n1svt M=1 L=45n W=1.04u
Mmn45 net337 RN VSS VSS g45n1svt M=1 L=45n W=410n
Mmn46 qbint n30 net337 VSS g45n1svt M=1 L=45n W=410n
Mmn51 n30 CKb net405 VSS g45n1svt M=1 L=45n W=205n
Mmn50 net405 qbint VSS VSS g45n1svt M=1 L=45n W=205n
Mmn20 CKb CK VSS VSS g45n1svt M=1 L=45n W=145n
Mmn40 n30 CKbb mout VSS g45n1svt M=1 L=45n W=205n
Mmn30 mout n20 VSS VSS g45n1svt M=1 L=45n W=205n
Mmn21 CKbb CKb VSS VSS g45n1svt M=1 L=45n W=145n
Mmn10 SEb SE VSS VSS g45n1svt M=1 L=45n W=145n
Mmn25 n20 CKb Db VSS g45n1svt M=1 L=45n W=205n
Mmp14 Db SEb net373 VDD g45p1svt M=1 L=45n W=390n
Mmp13 net373 SI VDD VDD g45p1svt M=1 L=45n W=390n
Mmp12 Db SE net381 VDD g45p1svt M=1 L=45n W=390n
Mmp11 net381 D VDD VDD g45p1svt M=1 L=45n W=390n
Mmp51 n30 CKbb net326 VDD g45p1svt M=1 L=45n W=310n
Mmp50 net326 qbint VDD VDD g45p1svt M=1 L=45n W=310n
Mmp55 Q qbint VDD VDD g45p1svt M=1 L=45n W=1.56u
Mmp20 CKb CK VDD VDD g45p1svt M=1 L=45n W=215n
Mmp46 qbint n30 VDD VDD g45p1svt M=1 L=45n W=620n
Mmp45 VDD RN qbint VDD g45p1svt M=1 L=45n W=620n
Mmp35 net349 RN VDD VDD g45p1svt M=1 L=45n W=310n
Mmp36 net349 mout VDD VDD g45p1svt M=1 L=45n W=310n
Mmp37 n20 CKb net349 VDD g45p1svt M=1 L=45n W=310n
Mmp40 n30 CKb mout VDD g45p1svt M=1 L=45n W=310n
Mmp30 mout n20 VDD VDD g45p1svt M=1 L=45n W=310n
Mmp21 CKbb CKb VDD VDD g45p1svt M=1 L=45n W=215n
Mmp25 n20 CKbb Db VDD g45p1svt M=1 L=45n W=310n
Mmp10 SEb SE VDD VDD g45p1svt M=1 L=45n W=215n
.ENDS

.SUBCKT SDFFRHQX2 CK D Q RN SE SI VDD VSS
Mmn36 net422 mout net426 VSS g45n1svt M=1 L=45n W=205n
Mmn35 net426 RN VSS VSS g45n1svt M=1 L=45n W=205n
Mmn37 n20 CKbb net422 VSS g45n1svt M=1 L=45n W=205n
Mmn13 net442 SI VSS VSS g45n1svt M=1 L=45n W=260n
Mmn14 Db SE net442 VSS g45n1svt M=1 L=45n W=260n
Mmn12 Db SEb net450 VSS g45n1svt M=1 L=45n W=260n
Mmn11 net450 D VSS VSS g45n1svt M=1 L=45n W=260n
Mmn55 Q qbint VSS VSS g45n1svt M=1 L=45n W=520n
Mmn45 net337 RN VSS VSS g45n1svt M=1 L=45n W=205n
Mmn46 qbint n30 net337 VSS g45n1svt M=1 L=45n W=205n
Mmn51 n30 CKb net405 VSS g45n1svt M=1 L=45n W=205n
Mmn50 net405 qbint VSS VSS g45n1svt M=1 L=45n W=205n
Mmn20 CKb CK VSS VSS g45n1svt M=1 L=45n W=145n
Mmn40 n30 CKbb mout VSS g45n1svt M=1 L=45n W=205n
Mmn30 mout n20 VSS VSS g45n1svt M=1 L=45n W=205n
Mmn21 CKbb CKb VSS VSS g45n1svt M=1 L=45n W=145n
Mmn10 SEb SE VSS VSS g45n1svt M=1 L=45n W=145n
Mmn25 n20 CKb Db VSS g45n1svt M=1 L=45n W=205n
Mmp14 Db SEb net373 VDD g45p1svt M=1 L=45n W=390n
Mmp13 net373 SI VDD VDD g45p1svt M=1 L=45n W=390n
Mmp12 Db SE net381 VDD g45p1svt M=1 L=45n W=390n
Mmp11 net381 D VDD VDD g45p1svt M=1 L=45n W=390n
Mmp51 n30 CKbb net326 VDD g45p1svt M=1 L=45n W=310n
Mmp50 net326 qbint VDD VDD g45p1svt M=1 L=45n W=310n
Mmp55 Q qbint VDD VDD g45p1svt M=1 L=45n W=780n
Mmp20 CKb CK VDD VDD g45p1svt M=1 L=45n W=215n
Mmp46 qbint n30 VDD VDD g45p1svt M=1 L=45n W=310n
Mmp45 VDD RN qbint VDD g45p1svt M=1 L=45n W=310n
Mmp35 net349 RN VDD VDD g45p1svt M=1 L=45n W=310n
Mmp36 net349 mout VDD VDD g45p1svt M=1 L=45n W=310n
Mmp37 n20 CKb net349 VDD g45p1svt M=1 L=45n W=310n
Mmp40 n30 CKb mout VDD g45p1svt M=1 L=45n W=310n
Mmp30 mout n20 VDD VDD g45p1svt M=1 L=45n W=310n
Mmp21 CKbb CKb VDD VDD g45p1svt M=1 L=45n W=215n
Mmp25 n20 CKbb Db VDD g45p1svt M=1 L=45n W=310n
Mmp10 SEb SE VDD VDD g45p1svt M=1 L=45n W=215n
.ENDS

.SUBCKT SDFFRHQX1 CK D Q RN SE SI VDD VSS
Mmn36 net422 mout net426 VSS g45n1svt M=1 L=45n W=205n
Mmn35 net426 RN VSS VSS g45n1svt M=1 L=45n W=205n
Mmn37 n20 CKbb net422 VSS g45n1svt M=1 L=45n W=205n
Mmn13 net442 SI VSS VSS g45n1svt M=1 L=45n W=260n
Mmn14 Db SE net442 VSS g45n1svt M=1 L=45n W=260n
Mmn12 Db SEb net450 VSS g45n1svt M=1 L=45n W=260n
Mmn11 net450 D VSS VSS g45n1svt M=1 L=45n W=260n
Mmn55 Q qbint VSS VSS g45n1svt M=1 L=45n W=260n
Mmn45 net337 RN VSS VSS g45n1svt M=1 L=45n W=205n
Mmn46 qbint n30 net337 VSS g45n1svt M=1 L=45n W=205n
Mmn51 n30 CKb net405 VSS g45n1svt M=1 L=45n W=205n
Mmn50 net405 qbint VSS VSS g45n1svt M=1 L=45n W=205n
Mmn20 CKb CK VSS VSS g45n1svt M=1 L=45n W=145n
Mmn40 n30 CKbb mout VSS g45n1svt M=1 L=45n W=205n
Mmn30 mout n20 VSS VSS g45n1svt M=1 L=45n W=205n
Mmn21 CKbb CKb VSS VSS g45n1svt M=1 L=45n W=145n
Mmn10 SEb SE VSS VSS g45n1svt M=1 L=45n W=145n
Mmn25 n20 CKb Db VSS g45n1svt M=1 L=45n W=205n
Mmp14 Db SEb net373 VDD g45p1svt M=1 L=45n W=390n
Mmp13 net373 SI VDD VDD g45p1svt M=1 L=45n W=390n
Mmp12 Db SE net381 VDD g45p1svt M=1 L=45n W=390n
Mmp11 net381 D VDD VDD g45p1svt M=1 L=45n W=390n
Mmp51 n30 CKbb net326 VDD g45p1svt M=1 L=45n W=310n
Mmp50 net326 qbint VDD VDD g45p1svt M=1 L=45n W=310n
Mmp55 Q qbint VDD VDD g45p1svt M=1 L=45n W=390n
Mmp20 CKb CK VDD VDD g45p1svt M=1 L=45n W=215n
Mmp46 qbint n30 VDD VDD g45p1svt M=1 L=45n W=310n
Mmp45 VDD RN qbint VDD g45p1svt M=1 L=45n W=310n
Mmp35 net349 RN VDD VDD g45p1svt M=1 L=45n W=310n
Mmp36 net349 mout VDD VDD g45p1svt M=1 L=45n W=310n
Mmp37 n20 CKb net349 VDD g45p1svt M=1 L=45n W=310n
Mmp40 n30 CKb mout VDD g45p1svt M=1 L=45n W=310n
Mmp30 mout n20 VDD VDD g45p1svt M=1 L=45n W=310n
Mmp21 CKbb CKb VDD VDD g45p1svt M=1 L=45n W=215n
Mmp25 n20 CKbb Db VDD g45p1svt M=1 L=45n W=310n
Mmp10 SEb SE VDD VDD g45p1svt M=1 L=45n W=215n
.ENDS

.SUBCKT SDFFQXL CK D Q SE SI VDD VSS
Mmn13 n3 SI VSS VSS g45n1svt M=1 L=45n W=145n
Mmn14 Db SE n3 VSS g45n1svt M=1 L=45n W=145n
Mmn12 Db SEb n1 VSS g45n1svt M=1 L=45n W=145n
Mmn11 n1 D VSS VSS g45n1svt M=1 L=45n W=145n
Mmn55 Q qbint VSS VSS g45n1svt M=1 L=45n W=145n
Mmn50 n7 qbint VSS VSS g45n1svt M=1 L=45n W=145n
Mmn10 SEb SE VSS VSS g45n1svt M=1 L=45n W=145n
Mmn40 mout CKbb n30 VSS g45n1svt M=1 L=45n W=145n
Mmn35 n20 CKbb n5 VSS g45n1svt M=1 L=45n W=145n
Mmn36 n5 mout VSS VSS g45n1svt M=1 L=45n W=145n
Mmn20 CKb CK VSS VSS g45n1svt M=1 L=45n W=145n
Mmn51 n30 CKb n7 VSS g45n1svt M=1 L=45n W=145n
Mmn21 CKbb CKb VSS VSS g45n1svt M=1 L=45n W=145n
Mmn45 qbint n30 VSS VSS g45n1svt M=1 L=45n W=145n
Mmn25 Db CKb n20 VSS g45n1svt M=1 L=45n W=145n
Mmn30 mout n20 VSS VSS g45n1svt M=1 L=45n W=145n
Mmp14 Db SEb n4 VDD g45p1svt M=1 L=45n W=215n
Mmp13 n4 SI VDD VDD g45p1svt M=1 L=45n W=215n
Mmp12 Db SE n2 VDD g45p1svt M=1 L=45n W=215n
Mmp11 n2 D VDD VDD g45p1svt M=1 L=45n W=215n
Mmp51 n30 CKbb n8 VDD g45p1svt M=1 L=45n W=215n
Mmp50 n8 qbint VDD VDD g45p1svt M=1 L=45n W=215n
Mmp55 Q qbint VDD VDD g45p1svt M=1 L=45n W=215n
Mmp35 n6 mout VDD VDD g45p1svt M=1 L=45n W=215n
Mmp25 n20 CKbb Db VDD g45p1svt M=1 L=45n W=215n
Mmp21 CKbb CKb VDD VDD g45p1svt M=1 L=45n W=215n
Mmp30 mout n20 VDD VDD g45p1svt M=1 L=45n W=215n
Mmp36 n20 CKb n6 VDD g45p1svt M=1 L=45n W=215n
Mmp40 n30 CKb mout VDD g45p1svt M=1 L=45n W=215n
Mmp10 SEb SE VDD VDD g45p1svt M=1 L=45n W=215n
Mmp45 qbint n30 VDD VDD g45p1svt M=1 L=45n W=215n
Mmp20 CKb CK VDD VDD g45p1svt M=1 L=45n W=215n
.ENDS

.SUBCKT SDFFQX4 CK D Q SE SI VDD VSS
Mmn13 n3 SI VSS VSS g45n1svt M=1 L=45n W=145n
Mmn14 Db SE n3 VSS g45n1svt M=1 L=45n W=145n
Mmn12 Db SEb n1 VSS g45n1svt M=1 L=45n W=145n
Mmn11 n1 D VSS VSS g45n1svt M=1 L=45n W=145n
Mmn55 Q qbint VSS VSS g45n1svt M=1 L=45n W=1.04u
Mmn50 n7 qbint VSS VSS g45n1svt M=1 L=45n W=145n
Mmn10 SEb SE VSS VSS g45n1svt M=1 L=45n W=145n
Mmn40 mout CKbb n30 VSS g45n1svt M=1 L=45n W=145n
Mmn35 n20 CKbb n5 VSS g45n1svt M=1 L=45n W=145n
Mmn36 n5 mout VSS VSS g45n1svt M=1 L=45n W=145n
Mmn20 CKb CK VSS VSS g45n1svt M=1 L=45n W=145n
Mmn51 n30 CKb n7 VSS g45n1svt M=1 L=45n W=145n
Mmn21 CKbb CKb VSS VSS g45n1svt M=1 L=45n W=145n
Mmn45 qbint n30 VSS VSS g45n1svt M=1 L=45n W=410n
Mmn25 Db CKb n20 VSS g45n1svt M=1 L=45n W=145n
Mmn30 mout n20 VSS VSS g45n1svt M=1 L=45n W=145n
Mmp14 Db SEb n4 VDD g45p1svt M=1 L=45n W=215n
Mmp13 n4 SI VDD VDD g45p1svt M=1 L=45n W=215n
Mmp12 Db SE n2 VDD g45p1svt M=1 L=45n W=215n
Mmp11 n2 D VDD VDD g45p1svt M=1 L=45n W=215n
Mmp51 n30 CKbb n8 VDD g45p1svt M=1 L=45n W=215n
Mmp50 n8 qbint VDD VDD g45p1svt M=1 L=45n W=215n
Mmp55 Q qbint VDD VDD g45p1svt M=1 L=45n W=1.56u
Mmp35 n6 mout VDD VDD g45p1svt M=1 L=45n W=215n
Mmp25 n20 CKbb Db VDD g45p1svt M=1 L=45n W=215n
Mmp21 CKbb CKb VDD VDD g45p1svt M=1 L=45n W=215n
Mmp30 mout n20 VDD VDD g45p1svt M=1 L=45n W=215n
Mmp36 n20 CKb n6 VDD g45p1svt M=1 L=45n W=215n
Mmp40 n30 CKb mout VDD g45p1svt M=1 L=45n W=215n
Mmp10 SEb SE VDD VDD g45p1svt M=1 L=45n W=215n
Mmp45 qbint n30 VDD VDD g45p1svt M=1 L=45n W=620n
Mmp20 CKb CK VDD VDD g45p1svt M=1 L=45n W=215n
.ENDS

.SUBCKT SDFFQX2 CK D Q SE SI VDD VSS
Mmn13 n3 SI VSS VSS g45n1svt M=1 L=45n W=145n
Mmn14 Db SE n3 VSS g45n1svt M=1 L=45n W=145n
Mmn12 Db SEb n1 VSS g45n1svt M=1 L=45n W=145n
Mmn11 n1 D VSS VSS g45n1svt M=1 L=45n W=145n
Mmn55 Q qbint VSS VSS g45n1svt M=1 L=45n W=520n
Mmn50 n7 qbint VSS VSS g45n1svt M=1 L=45n W=145n
Mmn10 SEb SE VSS VSS g45n1svt M=1 L=45n W=145n
Mmn40 mout CKbb n30 VSS g45n1svt M=1 L=45n W=145n
Mmn35 n20 CKbb n5 VSS g45n1svt M=1 L=45n W=145n
Mmn36 n5 mout VSS VSS g45n1svt M=1 L=45n W=145n
Mmn20 CKb CK VSS VSS g45n1svt M=1 L=45n W=145n
Mmn51 n30 CKb n7 VSS g45n1svt M=1 L=45n W=145n
Mmn21 CKbb CKb VSS VSS g45n1svt M=1 L=45n W=145n
Mmn45 qbint n30 VSS VSS g45n1svt M=1 L=45n W=205n
Mmn25 Db CKb n20 VSS g45n1svt M=1 L=45n W=145n
Mmn30 mout n20 VSS VSS g45n1svt M=1 L=45n W=145n
Mmp14 Db SEb n4 VDD g45p1svt M=1 L=45n W=215n
Mmp13 n4 SI VDD VDD g45p1svt M=1 L=45n W=215n
Mmp12 Db SE n2 VDD g45p1svt M=1 L=45n W=215n
Mmp11 n2 D VDD VDD g45p1svt M=1 L=45n W=215n
Mmp51 n30 CKbb n8 VDD g45p1svt M=1 L=45n W=215n
Mmp50 n8 qbint VDD VDD g45p1svt M=1 L=45n W=215n
Mmp55 Q qbint VDD VDD g45p1svt M=1 L=45n W=780n
Mmp35 n6 mout VDD VDD g45p1svt M=1 L=45n W=215n
Mmp25 n20 CKbb Db VDD g45p1svt M=1 L=45n W=215n
Mmp21 CKbb CKb VDD VDD g45p1svt M=1 L=45n W=215n
Mmp30 mout n20 VDD VDD g45p1svt M=1 L=45n W=215n
Mmp36 n20 CKb n6 VDD g45p1svt M=1 L=45n W=215n
Mmp40 n30 CKb mout VDD g45p1svt M=1 L=45n W=215n
Mmp10 SEb SE VDD VDD g45p1svt M=1 L=45n W=215n
Mmp45 qbint n30 VDD VDD g45p1svt M=1 L=45n W=310n
Mmp20 CKb CK VDD VDD g45p1svt M=1 L=45n W=215n
.ENDS

.SUBCKT SDFFQX1 CK D Q SE SI VDD VSS
Mmn13 n3 SI VSS VSS g45n1svt M=1 L=45n W=145n
Mmn14 Db SE n3 VSS g45n1svt M=1 L=45n W=145n
Mmn12 Db SEb n1 VSS g45n1svt M=1 L=45n W=145n
Mmn11 n1 D VSS VSS g45n1svt M=1 L=45n W=145n
Mmn55 Q qbint VSS VSS g45n1svt M=1 L=45n W=260n
Mmn50 n7 qbint VSS VSS g45n1svt M=1 L=45n W=145n
Mmn10 SEb SE VSS VSS g45n1svt M=1 L=45n W=145n
Mmn40 mout CKbb n30 VSS g45n1svt M=1 L=45n W=145n
Mmn35 n20 CKbb n5 VSS g45n1svt M=1 L=45n W=145n
Mmn36 n5 mout VSS VSS g45n1svt M=1 L=45n W=145n
Mmn20 CKb CK VSS VSS g45n1svt M=1 L=45n W=145n
Mmn51 n30 CKb n7 VSS g45n1svt M=1 L=45n W=145n
Mmn21 CKbb CKb VSS VSS g45n1svt M=1 L=45n W=145n
Mmn45 qbint n30 VSS VSS g45n1svt M=1 L=45n W=145n
Mmn25 Db CKb n20 VSS g45n1svt M=1 L=45n W=145n
Mmn30 mout n20 VSS VSS g45n1svt M=1 L=45n W=145n
Mmp14 Db SEb n4 VDD g45p1svt M=1 L=45n W=215n
Mmp13 n4 SI VDD VDD g45p1svt M=1 L=45n W=215n
Mmp12 Db SE n2 VDD g45p1svt M=1 L=45n W=215n
Mmp11 n2 D VDD VDD g45p1svt M=1 L=45n W=215n
Mmp51 n30 CKbb n8 VDD g45p1svt M=1 L=45n W=215n
Mmp50 n8 qbint VDD VDD g45p1svt M=1 L=45n W=215n
Mmp55 Q qbint VDD VDD g45p1svt M=1 L=45n W=390n
Mmp35 n6 mout VDD VDD g45p1svt M=1 L=45n W=215n
Mmp25 n20 CKbb Db VDD g45p1svt M=1 L=45n W=215n
Mmp21 CKbb CKb VDD VDD g45p1svt M=1 L=45n W=215n
Mmp30 mout n20 VDD VDD g45p1svt M=1 L=45n W=215n
Mmp36 n20 CKb n6 VDD g45p1svt M=1 L=45n W=215n
Mmp40 n30 CKb mout VDD g45p1svt M=1 L=45n W=215n
Mmp10 SEb SE VDD VDD g45p1svt M=1 L=45n W=215n
Mmp45 qbint n30 VDD VDD g45p1svt M=1 L=45n W=215n
Mmp20 CKb CK VDD VDD g45p1svt M=1 L=45n W=215n
.ENDS

.SUBCKT SDFFNSRXL CKN D Q QN RN SE SI SN VDD VSS
Mmn13 net538 SI VSS VSS g45n1svt M=1 L=45n W=145n
Mmn14 Db SE net538 VSS g45n1svt M=1 L=45n W=145n
Mmn12 Db SEb net546 VSS g45n1svt M=1 L=45n W=145n
Mmn11 net546 D VSS VSS g45n1svt M=1 L=45n W=145n
Mmn57 QN qint VSS VSS g45n1svt M=1 L=45n W=145n
Mmn55 Q qbint VSS VSS g45n1svt M=1 L=45n W=145n
Mmn36 n20 CKNb net582 VSS g45n1svt M=1 L=45n W=145n
Mmn35 net582 mout VSS VSS g45n1svt M=1 L=45n W=145n
Mmn22 RNb RN VSS VSS g45n1svt M=1 L=45n W=145n
Mmn20 CKNb CKN VSS VSS g45n1svt M=1 L=45n W=145n
Mmn10 SEb SE VSS VSS g45n1svt M=1 L=45n W=145n
Mmn31 mout RNb net521 VSS g45n1svt M=1 L=45n W=145n
Mmn51 net0363 RNb net498 VSS g45n1svt M=1 L=45n W=145n
Mmn25 Db CKNbb n20 VSS g45n1svt M=1 L=45n W=145n
Mmn30 net521 SN VSS VSS g45n1svt M=1 L=45n W=145n
Mmn21 CKNbb CKNb VSS VSS g45n1svt M=1 L=45n W=145n
Mmn45 qbint n35 VSS VSS g45n1svt M=1 L=45n W=145n
Mmn50 net498 SN VSS VSS g45n1svt M=1 L=45n W=145n
Mmn32 mout n20 net521 VSS g45n1svt M=1 L=45n W=145n
Mmn56 qint qbint VSS VSS g45n1svt M=1 L=45n W=145n
Mmn53 n35 CKNbb net0363 VSS g45n1svt M=1 L=45n W=145n
Mmn52 net0363 qbint net498 VSS g45n1svt M=1 L=45n W=145n
Mmn40 mout CKNb n35 VSS g45n1svt M=1 L=45n W=145n
Mmp14 Db SEb net453 VDD g45p1svt M=1 L=45n W=215n
Mmp13 net453 SI VDD VDD g45p1svt M=1 L=45n W=215n
Mmp12 Db SE net461 VDD g45p1svt M=1 L=45n W=215n
Mmp11 net461 D VDD VDD g45p1svt M=1 L=45n W=215n
Mmp52 net566 qbint net414 VDD g45p1svt M=1 L=45n W=215n
Mmp51 net414 RNb VDD VDD g45p1svt M=1 L=45n W=215n
Mmp57 QN qint VDD VDD g45p1svt M=1 L=45n W=215n
Mmp55 Q qbint VDD VDD g45p1svt M=1 L=45n W=215n
Mmp36 n20 CKNbb net486 VDD g45p1svt M=1 L=45n W=215n
Mmp35 net486 mout VDD VDD g45p1svt M=1 L=45n W=215n
Mmp32 mout n20 net478 VDD g45p1svt M=1 L=45n W=215n
Mmp31 net478 RNb VDD VDD g45p1svt M=1 L=45n W=215n
Mmp22 RNb RN VDD VDD g45p1svt M=1 L=45n W=215n
Mmp20 CKNb CKN VDD VDD g45p1svt M=1 L=45n W=215n
Mmp53 n35 CKNb net566 VDD g45p1svt M=1 L=45n W=215n
Mmp56 qint qbint VDD VDD g45p1svt M=1 L=45n W=215n
Mmp21 CKNbb CKNb VDD VDD g45p1svt M=1 L=45n W=215n
Mmp25 n20 CKNb Db VDD g45p1svt M=1 L=45n W=215n
Mmp50 net566 SN VDD VDD g45p1svt M=1 L=45n W=215n
Mmp10 SEb SE VDD VDD g45p1svt M=1 L=45n W=215n
Mmp45 qbint n35 VDD VDD g45p1svt M=1 L=45n W=215n
Mmp40 n35 CKNbb mout VDD g45p1svt M=1 L=45n W=215n
Mmp30 mout SN VDD VDD g45p1svt M=1 L=45n W=215n
.ENDS

.SUBCKT SDFFNSRX4 CKN D Q QN RN SE SI SN VDD VSS
Mmn13 net538 SI VSS VSS g45n1svt M=1 L=45n W=145n
Mmn14 Db SE net538 VSS g45n1svt M=1 L=45n W=145n
Mmn12 Db SEb net546 VSS g45n1svt M=1 L=45n W=145n
Mmn11 net546 D VSS VSS g45n1svt M=1 L=45n W=145n
Mmn57 QN qint VSS VSS g45n1svt M=1 L=45n W=1.04u
Mmn55 Q qbint VSS VSS g45n1svt M=1 L=45n W=1.04u
Mmn36 n20 CKNb net582 VSS g45n1svt M=1 L=45n W=145n
Mmn35 net582 mout VSS VSS g45n1svt M=1 L=45n W=145n
Mmn22 RNb RN VSS VSS g45n1svt M=1 L=45n W=145n
Mmn20 CKNb CKN VSS VSS g45n1svt M=1 L=45n W=145n
Mmn10 SEb SE VSS VSS g45n1svt M=1 L=45n W=145n
Mmn31 mout RNb net521 VSS g45n1svt M=1 L=45n W=145n
Mmn51 net0363 RNb net498 VSS g45n1svt M=1 L=45n W=145n
Mmn25 Db CKNbb n20 VSS g45n1svt M=1 L=45n W=145n
Mmn30 net521 SN VSS VSS g45n1svt M=1 L=45n W=145n
Mmn21 CKNbb CKNb VSS VSS g45n1svt M=1 L=45n W=145n
Mmn45 qbint n35 VSS VSS g45n1svt M=1 L=45n W=410n
Mmn50 net498 SN VSS VSS g45n1svt M=1 L=45n W=145n
Mmn32 mout n20 net521 VSS g45n1svt M=1 L=45n W=145n
Mmn56 qint qbint VSS VSS g45n1svt M=1 L=45n W=260n
Mmn53 n35 CKNbb net0363 VSS g45n1svt M=1 L=45n W=145n
Mmn52 net0363 qbint net498 VSS g45n1svt M=1 L=45n W=145n
Mmn40 mout CKNb n35 VSS g45n1svt M=1 L=45n W=145n
Mmp14 Db SEb net453 VDD g45p1svt M=1 L=45n W=215n
Mmp13 net453 SI VDD VDD g45p1svt M=1 L=45n W=215n
Mmp12 Db SE net461 VDD g45p1svt M=1 L=45n W=215n
Mmp11 net461 D VDD VDD g45p1svt M=1 L=45n W=215n
Mmp52 net566 qbint net414 VDD g45p1svt M=1 L=45n W=215n
Mmp51 net414 RNb VDD VDD g45p1svt M=1 L=45n W=215n
Mmp57 QN qint VDD VDD g45p1svt M=1 L=45n W=1.56u
Mmp55 Q qbint VDD VDD g45p1svt M=1 L=45n W=1.56u
Mmp36 n20 CKNbb net486 VDD g45p1svt M=1 L=45n W=215n
Mmp35 net486 mout VDD VDD g45p1svt M=1 L=45n W=215n
Mmp32 mout n20 net478 VDD g45p1svt M=1 L=45n W=215n
Mmp31 net478 RNb VDD VDD g45p1svt M=1 L=45n W=215n
Mmp22 RNb RN VDD VDD g45p1svt M=1 L=45n W=215n
Mmp20 CKNb CKN VDD VDD g45p1svt M=1 L=45n W=215n
Mmp53 n35 CKNb net566 VDD g45p1svt M=1 L=45n W=215n
Mmp56 qint qbint VDD VDD g45p1svt M=1 L=45n W=390n
Mmp21 CKNbb CKNb VDD VDD g45p1svt M=1 L=45n W=215n
Mmp25 n20 CKNb Db VDD g45p1svt M=1 L=45n W=215n
Mmp50 net566 SN VDD VDD g45p1svt M=1 L=45n W=215n
Mmp10 SEb SE VDD VDD g45p1svt M=1 L=45n W=215n
Mmp45 qbint n35 VDD VDD g45p1svt M=1 L=45n W=620n
Mmp40 n35 CKNbb mout VDD g45p1svt M=1 L=45n W=215n
Mmp30 mout SN VDD VDD g45p1svt M=1 L=45n W=215n
.ENDS

.SUBCKT SDFFNSRX2 CKN D Q QN RN SE SI SN VDD VSS
Mmn13 net538 SI VSS VSS g45n1svt M=1 L=45n W=145n
Mmn14 Db SE net538 VSS g45n1svt M=1 L=45n W=145n
Mmn12 Db SEb net546 VSS g45n1svt M=1 L=45n W=145n
Mmn11 net546 D VSS VSS g45n1svt M=1 L=45n W=145n
Mmn57 QN qint VSS VSS g45n1svt M=1 L=45n W=520n
Mmn55 Q qbint VSS VSS g45n1svt M=1 L=45n W=520n
Mmn36 n20 CKNb net582 VSS g45n1svt M=1 L=45n W=145n
Mmn35 net582 mout VSS VSS g45n1svt M=1 L=45n W=145n
Mmn22 RNb RN VSS VSS g45n1svt M=1 L=45n W=145n
Mmn20 CKNb CKN VSS VSS g45n1svt M=1 L=45n W=145n
Mmn10 SEb SE VSS VSS g45n1svt M=1 L=45n W=145n
Mmn31 mout RNb net521 VSS g45n1svt M=1 L=45n W=145n
Mmn51 net0363 RNb net498 VSS g45n1svt M=1 L=45n W=145n
Mmn25 Db CKNbb n20 VSS g45n1svt M=1 L=45n W=145n
Mmn30 net521 SN VSS VSS g45n1svt M=1 L=45n W=145n
Mmn21 CKNbb CKNb VSS VSS g45n1svt M=1 L=45n W=145n
Mmn45 qbint n35 VSS VSS g45n1svt M=1 L=45n W=205n
Mmn50 net498 SN VSS VSS g45n1svt M=1 L=45n W=145n
Mmn32 mout n20 net521 VSS g45n1svt M=1 L=45n W=145n
Mmn56 qint qbint VSS VSS g45n1svt M=1 L=45n W=145n
Mmn53 n35 CKNbb net0363 VSS g45n1svt M=1 L=45n W=145n
Mmn52 net0363 qbint net498 VSS g45n1svt M=1 L=45n W=145n
Mmn40 mout CKNb n35 VSS g45n1svt M=1 L=45n W=145n
Mmp14 Db SEb net453 VDD g45p1svt M=1 L=45n W=215n
Mmp13 net453 SI VDD VDD g45p1svt M=1 L=45n W=215n
Mmp12 Db SE net461 VDD g45p1svt M=1 L=45n W=215n
Mmp11 net461 D VDD VDD g45p1svt M=1 L=45n W=215n
Mmp52 net566 qbint net414 VDD g45p1svt M=1 L=45n W=215n
Mmp51 net414 RNb VDD VDD g45p1svt M=1 L=45n W=215n
Mmp57 QN qint VDD VDD g45p1svt M=1 L=45n W=780n
Mmp55 Q qbint VDD VDD g45p1svt M=1 L=45n W=780n
Mmp36 n20 CKNbb net486 VDD g45p1svt M=1 L=45n W=215n
Mmp35 net486 mout VDD VDD g45p1svt M=1 L=45n W=215n
Mmp32 mout n20 net478 VDD g45p1svt M=1 L=45n W=215n
Mmp31 net478 RNb VDD VDD g45p1svt M=1 L=45n W=215n
Mmp22 RNb RN VDD VDD g45p1svt M=1 L=45n W=215n
Mmp20 CKNb CKN VDD VDD g45p1svt M=1 L=45n W=215n
Mmp53 n35 CKNb net566 VDD g45p1svt M=1 L=45n W=215n
Mmp56 qint qbint VDD VDD g45p1svt M=1 L=45n W=215n
Mmp21 CKNbb CKNb VDD VDD g45p1svt M=1 L=45n W=215n
Mmp25 n20 CKNb Db VDD g45p1svt M=1 L=45n W=215n
Mmp50 net566 SN VDD VDD g45p1svt M=1 L=45n W=215n
Mmp10 SEb SE VDD VDD g45p1svt M=1 L=45n W=215n
Mmp45 qbint n35 VDD VDD g45p1svt M=1 L=45n W=310n
Mmp40 n35 CKNbb mout VDD g45p1svt M=1 L=45n W=215n
Mmp30 mout SN VDD VDD g45p1svt M=1 L=45n W=215n
.ENDS

.SUBCKT SDFFNSRX1 CKN D Q QN RN SE SI SN VDD VSS
Mmn13 net538 SI VSS VSS g45n1svt M=1 L=45n W=145n
Mmn14 Db SE net538 VSS g45n1svt M=1 L=45n W=145n
Mmn12 Db SEb net546 VSS g45n1svt M=1 L=45n W=145n
Mmn11 net546 D VSS VSS g45n1svt M=1 L=45n W=145n
Mmn57 QN qint VSS VSS g45n1svt M=1 L=45n W=260n
Mmn55 Q qbint VSS VSS g45n1svt M=1 L=45n W=260n
Mmn36 n20 CKNb net582 VSS g45n1svt M=1 L=45n W=145n
Mmn35 net582 mout VSS VSS g45n1svt M=1 L=45n W=145n
Mmn22 RNb RN VSS VSS g45n1svt M=1 L=45n W=145n
Mmn20 CKNb CKN VSS VSS g45n1svt M=1 L=45n W=145n
Mmn10 SEb SE VSS VSS g45n1svt M=1 L=45n W=145n
Mmn31 mout RNb net521 VSS g45n1svt M=1 L=45n W=145n
Mmn51 net0363 RNb net498 VSS g45n1svt M=1 L=45n W=145n
Mmn25 Db CKNbb n20 VSS g45n1svt M=1 L=45n W=145n
Mmn30 net521 SN VSS VSS g45n1svt M=1 L=45n W=145n
Mmn21 CKNbb CKNb VSS VSS g45n1svt M=1 L=45n W=145n
Mmn45 qbint n35 VSS VSS g45n1svt M=1 L=45n W=145n
Mmn50 net498 SN VSS VSS g45n1svt M=1 L=45n W=145n
Mmn32 mout n20 net521 VSS g45n1svt M=1 L=45n W=145n
Mmn56 qint qbint VSS VSS g45n1svt M=1 L=45n W=145n
Mmn53 n35 CKNbb net0363 VSS g45n1svt M=1 L=45n W=145n
Mmn52 net0363 qbint net498 VSS g45n1svt M=1 L=45n W=145n
Mmn40 mout CKNb n35 VSS g45n1svt M=1 L=45n W=145n
Mmp14 Db SEb net453 VDD g45p1svt M=1 L=45n W=215n
Mmp13 net453 SI VDD VDD g45p1svt M=1 L=45n W=215n
Mmp12 Db SE net461 VDD g45p1svt M=1 L=45n W=215n
Mmp11 net461 D VDD VDD g45p1svt M=1 L=45n W=215n
Mmp52 net566 qbint net414 VDD g45p1svt M=1 L=45n W=215n
Mmp51 net414 RNb VDD VDD g45p1svt M=1 L=45n W=215n
Mmp57 QN qint VDD VDD g45p1svt M=1 L=45n W=390n
Mmp55 Q qbint VDD VDD g45p1svt M=1 L=45n W=390n
Mmp36 n20 CKNbb net486 VDD g45p1svt M=1 L=45n W=215n
Mmp35 net486 mout VDD VDD g45p1svt M=1 L=45n W=215n
Mmp32 mout n20 net478 VDD g45p1svt M=1 L=45n W=215n
Mmp31 net478 RNb VDD VDD g45p1svt M=1 L=45n W=215n
Mmp22 RNb RN VDD VDD g45p1svt M=1 L=45n W=215n
Mmp20 CKNb CKN VDD VDD g45p1svt M=1 L=45n W=215n
Mmp53 n35 CKNb net566 VDD g45p1svt M=1 L=45n W=215n
Mmp56 qint qbint VDD VDD g45p1svt M=1 L=45n W=215n
Mmp21 CKNbb CKNb VDD VDD g45p1svt M=1 L=45n W=215n
Mmp25 n20 CKNb Db VDD g45p1svt M=1 L=45n W=215n
Mmp50 net566 SN VDD VDD g45p1svt M=1 L=45n W=215n
Mmp10 SEb SE VDD VDD g45p1svt M=1 L=45n W=215n
Mmp45 qbint n35 VDD VDD g45p1svt M=1 L=45n W=215n
Mmp40 n35 CKNbb mout VDD g45p1svt M=1 L=45n W=215n
Mmp30 mout SN VDD VDD g45p1svt M=1 L=45n W=215n
.ENDS

.SUBCKT SDFFHQX8 CK D Q SE SI VDD VSS
Mmn13 net411 SI VSS VSS g45n1svt M=1 L=45n W=260n
Mmn14 Db SE net411 VSS g45n1svt M=1 L=45n W=260n
Mmn12 Db SEb net399 VSS g45n1svt M=1 L=45n W=260n
Mmn11 net399 D VSS VSS g45n1svt M=1 L=45n W=260n
Mmn55 Q qbint VSS VSS g45n1svt M=1 L=45n W=2.065u
Mmn50 net391 qbint VSS VSS g45n1svt M=1 L=45n W=205n
Mmn10 SEb SE VSS VSS g45n1svt M=1 L=45n W=145n
Mmn40 mout CKbb n30 VSS g45n1svt M=1 L=45n W=205n
Mmn35 net378 mout VSS VSS g45n1svt M=1 L=45n W=205n
Mmn36 n20 CKbb net378 VSS g45n1svt M=1 L=45n W=205n
Mmn20 CKb CK VSS VSS g45n1svt M=1 L=45n W=145n
Mmn51 n30 CKb net391 VSS g45n1svt M=1 L=45n W=205n
Mmn21 CKbb CKb VSS VSS g45n1svt M=1 L=45n W=145n
Mmn45 qbint n30 VSS VSS g45n1svt M=1 L=45n W=780n
Mmn25 n20 CKb Db VSS g45n1svt M=1 L=45n W=205n
Mmn30 mout n20 VSS VSS g45n1svt M=1 L=45n W=205n
Mmp14 Db SEb net350 VDD g45p1svt M=1 L=45n W=390n
Mmp13 net350 SI VDD VDD g45p1svt M=1 L=45n W=390n
Mmp12 Db SE net342 VDD g45p1svt M=1 L=45n W=390n
Mmp11 net342 D VDD VDD g45p1svt M=1 L=45n W=390n
Mmp51 n30 CKbb net334 VDD g45p1svt M=1 L=45n W=310n
Mmp50 net334 qbint VDD VDD g45p1svt M=1 L=45n W=310n
Mmp55 Q qbint VDD VDD g45p1svt M=1 L=45n W=3.115u
Mmp35 net319 mout VDD VDD g45p1svt M=1 L=45n W=310n
Mmp25 Db CKbb n20 VDD g45p1svt M=1 L=45n W=310n
Mmp21 CKbb CKb VDD VDD g45p1svt M=1 L=45n W=215n
Mmp30 mout n20 VDD VDD g45p1svt M=1 L=45n W=310n
Mmp36 n20 CKb net319 VDD g45p1svt M=1 L=45n W=310n
Mmp40 n30 CKb mout VDD g45p1svt M=1 L=45n W=310n
Mmp10 SEb SE VDD VDD g45p1svt M=1 L=45n W=215n
Mmp45 qbint n30 VDD VDD g45p1svt M=1 L=45n W=1.17u
Mmp20 CKb CK VDD VDD g45p1svt M=1 L=45n W=215n
.ENDS

.SUBCKT SDFFHQX4 CK D Q SE SI VDD VSS
Mmn13 net411 SI VSS VSS g45n1svt M=1 L=45n W=260n
Mmn14 Db SE net411 VSS g45n1svt M=1 L=45n W=260n
Mmn12 Db SEb net399 VSS g45n1svt M=1 L=45n W=260n
Mmn11 net399 D VSS VSS g45n1svt M=1 L=45n W=260n
Mmn55 Q qbint VSS VSS g45n1svt M=1 L=45n W=1.04u
Mmn50 net391 qbint VSS VSS g45n1svt M=1 L=45n W=205n
Mmn10 SEb SE VSS VSS g45n1svt M=1 L=45n W=145n
Mmn40 mout CKbb n30 VSS g45n1svt M=1 L=45n W=205n
Mmn35 net378 mout VSS VSS g45n1svt M=1 L=45n W=205n
Mmn36 n20 CKbb net378 VSS g45n1svt M=1 L=45n W=205n
Mmn20 CKb CK VSS VSS g45n1svt M=1 L=45n W=145n
Mmn51 n30 CKb net391 VSS g45n1svt M=1 L=45n W=205n
Mmn21 CKbb CKb VSS VSS g45n1svt M=1 L=45n W=145n
Mmn45 qbint n30 VSS VSS g45n1svt M=1 L=45n W=410n
Mmn25 n20 CKb Db VSS g45n1svt M=1 L=45n W=205n
Mmn30 mout n20 VSS VSS g45n1svt M=1 L=45n W=205n
Mmp14 Db SEb net350 VDD g45p1svt M=1 L=45n W=390n
Mmp13 net350 SI VDD VDD g45p1svt M=1 L=45n W=390n
Mmp12 Db SE net342 VDD g45p1svt M=1 L=45n W=390n
Mmp11 net342 D VDD VDD g45p1svt M=1 L=45n W=390n
Mmp51 n30 CKbb net334 VDD g45p1svt M=1 L=45n W=310n
Mmp50 net334 qbint VDD VDD g45p1svt M=1 L=45n W=310n
Mmp55 Q qbint VDD VDD g45p1svt M=1 L=45n W=1.56u
Mmp35 net319 mout VDD VDD g45p1svt M=1 L=45n W=310n
Mmp25 Db CKbb n20 VDD g45p1svt M=1 L=45n W=310n
Mmp21 CKbb CKb VDD VDD g45p1svt M=1 L=45n W=215n
Mmp30 mout n20 VDD VDD g45p1svt M=1 L=45n W=310n
Mmp36 n20 CKb net319 VDD g45p1svt M=1 L=45n W=310n
Mmp40 n30 CKb mout VDD g45p1svt M=1 L=45n W=310n
Mmp10 SEb SE VDD VDD g45p1svt M=1 L=45n W=215n
Mmp45 qbint n30 VDD VDD g45p1svt M=1 L=45n W=620n
Mmp20 CKb CK VDD VDD g45p1svt M=1 L=45n W=215n
.ENDS

.SUBCKT SDFFHQX2 CK D Q SE SI VDD VSS
Mmn13 net411 SI VSS VSS g45n1svt M=1 L=45n W=260n
Mmn14 Db SE net411 VSS g45n1svt M=1 L=45n W=260n
Mmn12 Db SEb net399 VSS g45n1svt M=1 L=45n W=260n
Mmn11 net399 D VSS VSS g45n1svt M=1 L=45n W=260n
Mmn55 Q qbint VSS VSS g45n1svt M=1 L=45n W=520n
Mmn50 net391 qbint VSS VSS g45n1svt M=1 L=45n W=205n
Mmn10 SEb SE VSS VSS g45n1svt M=1 L=45n W=145n
Mmn40 mout CKbb n30 VSS g45n1svt M=1 L=45n W=205n
Mmn35 net378 mout VSS VSS g45n1svt M=1 L=45n W=205n
Mmn36 n20 CKbb net378 VSS g45n1svt M=1 L=45n W=205n
Mmn20 CKb CK VSS VSS g45n1svt M=1 L=45n W=145n
Mmn51 n30 CKb net391 VSS g45n1svt M=1 L=45n W=205n
Mmn21 CKbb CKb VSS VSS g45n1svt M=1 L=45n W=145n
Mmn45 qbint n30 VSS VSS g45n1svt M=1 L=45n W=205n
Mmn25 n20 CKb Db VSS g45n1svt M=1 L=45n W=205n
Mmn30 mout n20 VSS VSS g45n1svt M=1 L=45n W=205n
Mmp14 Db SEb net350 VDD g45p1svt M=1 L=45n W=390n
Mmp13 net350 SI VDD VDD g45p1svt M=1 L=45n W=390n
Mmp12 Db SE net342 VDD g45p1svt M=1 L=45n W=390n
Mmp11 net342 D VDD VDD g45p1svt M=1 L=45n W=390n
Mmp51 n30 CKbb net334 VDD g45p1svt M=1 L=45n W=310n
Mmp50 net334 qbint VDD VDD g45p1svt M=1 L=45n W=310n
Mmp55 Q qbint VDD VDD g45p1svt M=1 L=45n W=780n
Mmp35 net319 mout VDD VDD g45p1svt M=1 L=45n W=310n
Mmp25 Db CKbb n20 VDD g45p1svt M=1 L=45n W=310n
Mmp21 CKbb CKb VDD VDD g45p1svt M=1 L=45n W=215n
Mmp30 mout n20 VDD VDD g45p1svt M=1 L=45n W=310n
Mmp36 n20 CKb net319 VDD g45p1svt M=1 L=45n W=310n
Mmp40 n30 CKb mout VDD g45p1svt M=1 L=45n W=310n
Mmp10 SEb SE VDD VDD g45p1svt M=1 L=45n W=215n
Mmp45 qbint n30 VDD VDD g45p1svt M=1 L=45n W=310n
Mmp20 CKb CK VDD VDD g45p1svt M=1 L=45n W=215n
.ENDS

.SUBCKT SDFFHQX1 CK D Q SE SI VDD VSS
Mmn13 net411 SI VSS VSS g45n1svt M=1 L=45n W=260n
Mmn14 Db SE net411 VSS g45n1svt M=1 L=45n W=260n
Mmn12 Db SEb net399 VSS g45n1svt M=1 L=45n W=260n
Mmn11 net399 D VSS VSS g45n1svt M=1 L=45n W=260n
Mmn55 Q qbint VSS VSS g45n1svt M=1 L=45n W=260n
Mmn50 net391 qbint VSS VSS g45n1svt M=1 L=45n W=205n
Mmn10 SEb SE VSS VSS g45n1svt M=1 L=45n W=145n
Mmn40 mout CKbb n30 VSS g45n1svt M=1 L=45n W=205n
Mmn35 net378 mout VSS VSS g45n1svt M=1 L=45n W=205n
Mmn36 n20 CKbb net378 VSS g45n1svt M=1 L=45n W=205n
Mmn20 CKb CK VSS VSS g45n1svt M=1 L=45n W=145n
Mmn51 n30 CKb net391 VSS g45n1svt M=1 L=45n W=205n
Mmn21 CKbb CKb VSS VSS g45n1svt M=1 L=45n W=145n
Mmn45 qbint n30 VSS VSS g45n1svt M=1 L=45n W=205n
Mmn25 n20 CKb Db VSS g45n1svt M=1 L=45n W=205n
Mmn30 mout n20 VSS VSS g45n1svt M=1 L=45n W=205n
Mmp14 Db SEb net350 VDD g45p1svt M=1 L=45n W=390n
Mmp13 net350 SI VDD VDD g45p1svt M=1 L=45n W=390n
Mmp12 Db SE net342 VDD g45p1svt M=1 L=45n W=390n
Mmp11 net342 D VDD VDD g45p1svt M=1 L=45n W=390n
Mmp51 n30 CKbb net334 VDD g45p1svt M=1 L=45n W=310n
Mmp50 net334 qbint VDD VDD g45p1svt M=1 L=45n W=310n
Mmp55 Q qbint VDD VDD g45p1svt M=1 L=45n W=390n
Mmp35 net319 mout VDD VDD g45p1svt M=1 L=45n W=310n
Mmp25 Db CKbb n20 VDD g45p1svt M=1 L=45n W=310n
Mmp21 CKbb CKb VDD VDD g45p1svt M=1 L=45n W=215n
Mmp30 mout n20 VDD VDD g45p1svt M=1 L=45n W=310n
Mmp36 n20 CKb net319 VDD g45p1svt M=1 L=45n W=310n
Mmp40 n30 CKb mout VDD g45p1svt M=1 L=45n W=310n
Mmp10 SEb SE VDD VDD g45p1svt M=1 L=45n W=215n
Mmp45 qbint n30 VDD VDD g45p1svt M=1 L=45n W=310n
Mmp20 CKb CK VDD VDD g45p1svt M=1 L=45n W=215n
.ENDS

.SUBCKT SDFF4RX2 CK D1 D2 D3 D4 Q1 Q1N Q2 Q2N Q3 Q3N Q4 Q4N RN SE SI VDD VSS
MNM55 SEb_4 SE VSS VSS g45n1svt M=1 L=45n W=145n
MNM54 n1_4 D4 VSS VSS g45n1svt M=1 L=45n W=145n
MNM53 Db_4 SEb_4 n1_4 VSS g45n1svt M=1 L=45n W=145n
MNM52 Db_4 SE n3_4 VSS g45n1svt M=1 L=45n W=145n
MNM51 n3_4 Q3 VSS VSS g45n1svt M=1 L=45n W=145n
MNM50 Db_4 CKb n20_4 VSS g45n1svt M=1 L=45n W=145n
MNM49 mout_4 n20_4 VSS VSS g45n1svt M=1 L=45n W=145n
MNM48 n20_4 Ckbb n5_4 VSS g45n1svt M=1 L=45n W=145n
MNM47 n7_4 RN VSS VSS g45n1svt M=1 L=45n W=145n
MNM46 n5_4 mout_4 n7_4 VSS g45n1svt M=1 L=45n W=145n
MNM45 mout_4 Ckbb n30_4 VSS g45n1svt M=1 L=45n W=145n
MNM44 qbint_4 n30_4 n9_4 VSS g45n1svt M=1 L=45n W=205n
MNM43 n9_4 RN VSS VSS g45n1svt M=1 L=45n W=205n
MNM42 n11_4 qbint_4 VSS VSS g45n1svt M=1 L=45n W=145n
MNM41 n30_4 CKb n11_4 VSS g45n1svt M=1 L=45n W=145n
MNM40 Q4 qbint_4 VSS VSS g45n1svt M=1 L=45n W=520n
MNM39 qint_4 qbint_4 VSS VSS g45n1svt M=1 L=45n W=145n
MNM38 Q4N qint_4 VSS VSS g45n1svt M=1 L=45n W=520n
MNM37 Q3N qint_3 VSS VSS g45n1svt M=1 L=45n W=520n
MNM36 qint_3 qbint_3 VSS VSS g45n1svt M=1 L=45n W=145n
MNM35 Q3 qbint_3 VSS VSS g45n1svt M=1 L=45n W=520n
MNM34 n30_3 CKb n11_3 VSS g45n1svt M=1 L=45n W=145n
MNM33 n11_3 qbint_3 VSS VSS g45n1svt M=1 L=45n W=145n
MNM32 n9_3 RN VSS VSS g45n1svt M=1 L=45n W=205n
MNM31 qbint_3 n30_3 n9_3 VSS g45n1svt M=1 L=45n W=205n
MNM30 mout_3 Ckbb n30_3 VSS g45n1svt M=1 L=45n W=145n
MNM29 n5_3 mout_3 n7_3 VSS g45n1svt M=1 L=45n W=145n
MNM28 n7_3 RN VSS VSS g45n1svt M=1 L=45n W=145n
MNM27 n20_3 Ckbb n5_3 VSS g45n1svt M=1 L=45n W=145n
MNM26 mout_3 n20_3 VSS VSS g45n1svt M=1 L=45n W=145n
MNM25 Db_3 CKb n20_3 VSS g45n1svt M=1 L=45n W=145n
MNM24 n3_3 Q2 VSS VSS g45n1svt M=1 L=45n W=145n
MNM19 Q2N qint_2 VSS VSS g45n1svt M=1 L=45n W=520n
MNM18 qint_2 qbint_2 VSS VSS g45n1svt M=1 L=45n W=145n
MNM17 Q2 qbint_2 VSS VSS g45n1svt M=1 L=45n W=520n
MNM16 n30_2 CKb n11_2 VSS g45n1svt M=1 L=45n W=145n
MNM15 n11_2 qbint_2 VSS VSS g45n1svt M=1 L=45n W=145n
MNM14 n9_2 RN VSS VSS g45n1svt M=1 L=45n W=205n
MNM13 qbint_2 n30_2 n9_2 VSS g45n1svt M=1 L=45n W=205n
MNM12 mout_2 Ckbb n30_2 VSS g45n1svt M=1 L=45n W=145n
MNM11 n5_2 mout_2 n7_2 VSS g45n1svt M=1 L=45n W=145n
MNM10 n7_2 RN VSS VSS g45n1svt M=1 L=45n W=145n
MNM9 n20_2 Ckbb n5_2 VSS g45n1svt M=1 L=45n W=145n
MNM8 mout_2 n20_2 VSS VSS g45n1svt M=1 L=45n W=145n
MNM7 Db_2 CKb n20_2 VSS g45n1svt M=1 L=45n W=145n
MNM20 SEb_3 SE VSS VSS g45n1svt M=1 L=45n W=145n
MNM4 n3_2 Q1 VSS VSS g45n1svt M=1 L=45n W=145n
MNM3 Db_2 SE n3_2 VSS g45n1svt M=1 L=45n W=145n
MNM2 Db_2 SEb_2 n1_2 VSS g45n1svt M=1 L=45n W=145n
MNM1 n1_2 D2 VSS VSS g45n1svt M=1 L=45n W=145n
MNM0 SEb_2 SE VSS VSS g45n1svt M=1 L=45n W=145n
MNM23 Db_3 SE n3_3 VSS g45n1svt M=1 L=45n W=145n
MNM22 Db_3 SEb_3 n1_3 VSS g45n1svt M=1 L=45n W=145n
MNM21 n1_3 D3 VSS VSS g45n1svt M=1 L=45n W=145n
Mmn36 n5 mout n7 VSS g45n1svt M=1 L=45n W=145n
Mmn35 n7 RN VSS VSS g45n1svt M=1 L=45n W=145n
Mmn37 n20 Ckbb n5 VSS g45n1svt M=1 L=45n W=145n
Mmn13 n3 SI VSS VSS g45n1svt M=1 L=45n W=145n
Mmn14 Db SE n3 VSS g45n1svt M=1 L=45n W=145n
Mmn12 Db SEb n1 VSS g45n1svt M=1 L=45n W=145n
Mmn11 n1 D1 VSS VSS g45n1svt M=1 L=45n W=145n
Mmn57 Q1N qint VSS VSS g45n1svt M=1 L=45n W=520n
Mmn55 Q1 qbint VSS VSS g45n1svt M=1 L=45n W=520n
Mmn45 n9 RN VSS VSS g45n1svt M=1 L=45n W=205n
Mmn46 qbint n30 n9 VSS g45n1svt M=1 L=45n W=205n
Mmn51 n30 CKb n11 VSS g45n1svt M=1 L=45n W=145n
Mmn50 n11 qbint VSS VSS g45n1svt M=1 L=45n W=145n
Mmn20 CKb CK VSS VSS g45n1svt M=1 L=45n W=145n
Mmn56 qint qbint VSS VSS g45n1svt M=1 L=45n W=145n
Mmn40 mout Ckbb n30 VSS g45n1svt M=1 L=45n W=145n
Mmn30 mout n20 VSS VSS g45n1svt M=1 L=45n W=145n
Mmn21 Ckbb CKb VSS VSS g45n1svt M=1 L=45n W=145n
Mmn10 SEb SE VSS VSS g45n1svt M=1 L=45n W=145n
Mmn25 Db CKb n20 VSS g45n1svt M=1 L=45n W=145n
MPM55 SEb_4 SE VDD VDD g45p1svt M=1 L=45n W=215n
MPM54 n2_4 D4 VDD VDD g45p1svt M=1 L=45n W=215n
MPM53 Db_4 SE n2_4 VDD g45p1svt M=1 L=45n W=215n
MPM52 n4_4 Q3 VDD VDD g45p1svt M=1 L=45n W=215n
MPM51 Db_4 SEb_4 n4_4 VDD g45p1svt M=1 L=45n W=215n
MPM50 n20_4 Ckbb Db_4 VDD g45p1svt M=1 L=45n W=215n
MPM49 mout_4 n20_4 VDD VDD g45p1svt M=1 L=45n W=215n
MPM48 n6_4 RN VDD VDD g45p1svt M=1 L=45n W=215n
MPM47 n20_4 CKb n6_4 VDD g45p1svt M=1 L=45n W=215n
MPM46 n6_4 mout_4 VDD VDD g45p1svt M=1 L=45n W=215n
MPM45 n30_4 CKb mout_4 VDD g45p1svt M=1 L=45n W=215n
MPM44 qbint_4 RN VDD VDD g45p1svt M=1 L=45n W=310n
MPM43 qbint_4 n30_4 VDD VDD g45p1svt M=1 L=45n W=310n
MPM42 n8_4 qbint_4 VDD VDD g45p1svt M=1 L=45n W=215n
MPM41 n30_4 Ckbb n8_4 VDD g45p1svt M=1 L=45n W=215n
MPM40 Q4 qbint_4 VDD VDD g45p1svt M=1 L=45n W=780n
MPM39 qint_4 qbint_4 VDD VDD g45p1svt M=1 L=45n W=215n
MPM38 Q4N qint_4 VDD VDD g45p1svt M=1 L=45n W=780n
MPM37 Q3N qint_3 VDD VDD g45p1svt M=1 L=45n W=780n
MPM36 qint_3 qbint_3 VDD VDD g45p1svt M=1 L=45n W=215n
MPM35 Q3 qbint_3 VDD VDD g45p1svt M=1 L=45n W=780n
MPM34 n30_3 Ckbb n8_3 VDD g45p1svt M=1 L=45n W=215n
MPM33 n8_3 qbint_3 VDD VDD g45p1svt M=1 L=45n W=215n
MPM32 qbint_3 n30_3 VDD VDD g45p1svt M=1 L=45n W=310n
MPM31 qbint_3 RN VDD VDD g45p1svt M=1 L=45n W=310n
MPM30 n30_3 CKb mout_3 VDD g45p1svt M=1 L=45n W=215n
MPM29 n6_3 mout_3 VDD VDD g45p1svt M=1 L=45n W=215n
MPM28 n20_3 CKb n6_3 VDD g45p1svt M=1 L=45n W=215n
MPM27 n6_3 RN VDD VDD g45p1svt M=1 L=45n W=215n
MPM26 mout_3 n20_3 VDD VDD g45p1svt M=1 L=45n W=215n
MPM25 n20_3 Ckbb Db_3 VDD g45p1svt M=1 L=45n W=215n
MPM19 Q2N qint_2 VDD VDD g45p1svt M=1 L=45n W=780n
MPM18 qint_2 qbint_2 VDD VDD g45p1svt M=1 L=45n W=215n
MPM17 Q2 qbint_2 VDD VDD g45p1svt M=1 L=45n W=780n
MPM16 n30_2 Ckbb n8_2 VDD g45p1svt M=1 L=45n W=215n
MPM15 n8_2 qbint_2 VDD VDD g45p1svt M=1 L=45n W=215n
MPM14 qbint_2 n30_2 VDD VDD g45p1svt M=1 L=45n W=310n
MPM13 qbint_2 RN VDD VDD g45p1svt M=1 L=45n W=310n
MPM12 n30_2 CKb mout_2 VDD g45p1svt M=1 L=45n W=215n
MPM11 n6_2 mout_2 VDD VDD g45p1svt M=1 L=45n W=215n
MPM10 n20_2 CKb n6_2 VDD g45p1svt M=1 L=45n W=215n
MPM9 n6_2 RN VDD VDD g45p1svt M=1 L=45n W=215n
MPM8 mout_2 n20_2 VDD VDD g45p1svt M=1 L=45n W=215n
MPM7 n20_2 Ckbb Db_2 VDD g45p1svt M=1 L=45n W=215n
MPM20 SEb_3 SE VDD VDD g45p1svt M=1 L=45n W=215n
MPM22 Db_3 SE n2_3 VDD g45p1svt M=1 L=45n W=215n
MPM21 n2_3 D3 VDD VDD g45p1svt M=1 L=45n W=215n
MPM4 Db_2 SEb_2 n4_2 VDD g45p1svt M=1 L=45n W=215n
MPM3 n4_2 Q1 VDD VDD g45p1svt M=1 L=45n W=215n
MPM2 Db_2 SE n2_2 VDD g45p1svt M=1 L=45n W=215n
MPM1 n2_2 D2 VDD VDD g45p1svt M=1 L=45n W=215n
MPM0 SEb_2 SE VDD VDD g45p1svt M=1 L=45n W=215n
MPM23 n4_3 Q2 VDD VDD g45p1svt M=1 L=45n W=215n
MPM24 Db_3 SEb_3 n4_3 VDD g45p1svt M=1 L=45n W=215n
Mmp14 Db SEb n4 VDD g45p1svt M=1 L=45n W=215n
Mmp13 n4 SI VDD VDD g45p1svt M=1 L=45n W=215n
Mmp12 Db SE n2 VDD g45p1svt M=1 L=45n W=215n
Mmp11 n2 D1 VDD VDD g45p1svt M=1 L=45n W=215n
Mmp51 n30 Ckbb n8 VDD g45p1svt M=1 L=45n W=215n
Mmp50 n8 qbint VDD VDD g45p1svt M=1 L=45n W=215n
Mmp55 Q1 qbint VDD VDD g45p1svt M=1 L=45n W=780n
Mmp20 CKb CK VDD VDD g45p1svt M=1 L=45n W=215n
Mmp46 qbint n30 VDD VDD g45p1svt M=1 L=45n W=310n
Mmp56 qint qbint VDD VDD g45p1svt M=1 L=45n W=215n
Mmp45 qbint RN VDD VDD g45p1svt M=1 L=45n W=310n
Mmp35 n6 RN VDD VDD g45p1svt M=1 L=45n W=215n
Mmp36 n6 mout VDD VDD g45p1svt M=1 L=45n W=215n
Mmp37 n20 CKb n6 VDD g45p1svt M=1 L=45n W=215n
Mmp40 n30 CKb mout VDD g45p1svt M=1 L=45n W=215n
Mmp30 mout n20 VDD VDD g45p1svt M=1 L=45n W=215n
Mmp21 Ckbb CKb VDD VDD g45p1svt M=1 L=45n W=215n
Mmp25 n20 Ckbb Db VDD g45p1svt M=1 L=45n W=215n
Mmp10 SEb SE VDD VDD g45p1svt M=1 L=45n W=215n
Mmp57 Q1N qint VDD VDD g45p1svt M=1 L=45n W=780n
.ENDS

.SUBCKT SDFF4RX1 CK D1 D2 D3 D4 Q1 Q1N Q2 Q2N Q3 Q3N Q4 Q4N RN SE SI VDD VSS
MNM55 SEb_4 SE VSS VSS g45n1svt M=1 L=45n W=145n
MNM54 n1_4 D4 VSS VSS g45n1svt M=1 L=45n W=145n
MNM53 Db_4 SEb_4 n1_4 VSS g45n1svt M=1 L=45n W=145n
MNM52 Db_4 SE n3_4 VSS g45n1svt M=1 L=45n W=145n
MNM51 n3_4 Q3 VSS VSS g45n1svt M=1 L=45n W=145n
MNM50 Db_4 CKb n20_4 VSS g45n1svt M=1 L=45n W=145n
MNM49 mout_4 n20_4 VSS VSS g45n1svt M=1 L=45n W=145n
MNM48 n20_4 Ckbb n5_4 VSS g45n1svt M=1 L=45n W=145n
MNM47 n7_4 RN VSS VSS g45n1svt M=1 L=45n W=145n
MNM46 n5_4 mout_4 n7_4 VSS g45n1svt M=1 L=45n W=145n
MNM45 mout_4 Ckbb n30_4 VSS g45n1svt M=1 L=45n W=145n
MNM44 qbint_4 n30_4 n9_4 VSS g45n1svt M=1 L=45n W=145n
MNM43 n9_4 RN VSS VSS g45n1svt M=1 L=45n W=145n
MNM42 n11_4 qbint_4 VSS VSS g45n1svt M=1 L=45n W=145n
MNM41 n30_4 CKb n11_4 VSS g45n1svt M=1 L=45n W=145n
MNM40 Q4 qbint_4 VSS VSS g45n1svt M=1 L=45n W=260n
MNM39 qint_4 qbint_4 VSS VSS g45n1svt M=1 L=45n W=145n
MNM38 Q4N qint_4 VSS VSS g45n1svt M=1 L=45n W=260n
MNM37 Q3N qint_3 VSS VSS g45n1svt M=1 L=45n W=260n
MNM36 qint_3 qbint_3 VSS VSS g45n1svt M=1 L=45n W=145n
MNM35 Q3 qbint_3 VSS VSS g45n1svt M=1 L=45n W=260n
MNM34 n30_3 CKb n11_3 VSS g45n1svt M=1 L=45n W=145n
MNM33 n11_3 qbint_3 VSS VSS g45n1svt M=1 L=45n W=145n
MNM32 n9_3 RN VSS VSS g45n1svt M=1 L=45n W=145n
MNM31 qbint_3 n30_3 n9_3 VSS g45n1svt M=1 L=45n W=145n
MNM30 mout_3 Ckbb n30_3 VSS g45n1svt M=1 L=45n W=145n
MNM29 n5_3 mout_3 n7_3 VSS g45n1svt M=1 L=45n W=145n
MNM28 n7_3 RN VSS VSS g45n1svt M=1 L=45n W=145n
MNM27 n20_3 Ckbb n5_3 VSS g45n1svt M=1 L=45n W=145n
MNM26 mout_3 n20_3 VSS VSS g45n1svt M=1 L=45n W=145n
MNM25 Db_3 CKb n20_3 VSS g45n1svt M=1 L=45n W=145n
MNM24 n3_3 Q2 VSS VSS g45n1svt M=1 L=45n W=145n
MNM23 Db_3 SE n3_3 VSS g45n1svt M=1 L=45n W=145n
MNM19 Q2N qint_2 VSS VSS g45n1svt M=1 L=45n W=260n
MNM18 qint_2 qbint_2 VSS VSS g45n1svt M=1 L=45n W=145n
MNM17 Q2 qbint_2 VSS VSS g45n1svt M=1 L=45n W=260n
MNM16 n30_2 CKb n11_2 VSS g45n1svt M=1 L=45n W=145n
MNM15 n11_2 qbint_2 VSS VSS g45n1svt M=1 L=45n W=145n
MNM14 n9_2 RN VSS VSS g45n1svt M=1 L=45n W=145n
MNM13 qbint_2 n30_2 n9_2 VSS g45n1svt M=1 L=45n W=145n
MNM12 mout_2 Ckbb n30_2 VSS g45n1svt M=1 L=45n W=145n
MNM11 n5_2 mout_2 n7_2 VSS g45n1svt M=1 L=45n W=145n
MNM10 n7_2 RN VSS VSS g45n1svt M=1 L=45n W=145n
MNM9 n20_2 Ckbb n5_2 VSS g45n1svt M=1 L=45n W=145n
MNM8 mout_2 n20_2 VSS VSS g45n1svt M=1 L=45n W=145n
MNM7 Db_2 CKb n20_2 VSS g45n1svt M=1 L=45n W=145n
MNM20 SEb_3 SE VSS VSS g45n1svt M=1 L=45n W=145n
MNM4 n3_2 Q1 VSS VSS g45n1svt M=1 L=45n W=145n
MNM3 Db_2 SE n3_2 VSS g45n1svt M=1 L=45n W=145n
MNM2 Db_2 SEb_2 n1_2 VSS g45n1svt M=1 L=45n W=145n
MNM1 n1_2 D2 VSS VSS g45n1svt M=1 L=45n W=145n
MNM0 SEb_2 SE VSS VSS g45n1svt M=1 L=45n W=145n
MNM21 n1_3 D3 VSS VSS g45n1svt M=1 L=45n W=145n
MNM22 Db_3 SEb_3 n1_3 VSS g45n1svt M=1 L=45n W=145n
Mmn36 n5 mout n7 VSS g45n1svt M=1 L=45n W=145n
Mmn35 n7 RN VSS VSS g45n1svt M=1 L=45n W=145n
Mmn37 n20 Ckbb n5 VSS g45n1svt M=1 L=45n W=145n
Mmn13 n3 SI VSS VSS g45n1svt M=1 L=45n W=145n
Mmn14 Db SE n3 VSS g45n1svt M=1 L=45n W=145n
Mmn12 Db SEb n1 VSS g45n1svt M=1 L=45n W=145n
Mmn11 n1 D1 VSS VSS g45n1svt M=1 L=45n W=145n
Mmn57 Q1N qint VSS VSS g45n1svt M=1 L=45n W=260n
Mmn55 Q1 qbint VSS VSS g45n1svt M=1 L=45n W=260n
Mmn45 n9 RN VSS VSS g45n1svt M=1 L=45n W=145n
Mmn46 qbint n30 n9 VSS g45n1svt M=1 L=45n W=145n
Mmn51 n30 CKb n11 VSS g45n1svt M=1 L=45n W=145n
Mmn50 n11 qbint VSS VSS g45n1svt M=1 L=45n W=145n
Mmn20 CKb CK VSS VSS g45n1svt M=1 L=45n W=145n
Mmn56 qint qbint VSS VSS g45n1svt M=1 L=45n W=145n
Mmn40 mout Ckbb n30 VSS g45n1svt M=1 L=45n W=145n
Mmn30 mout n20 VSS VSS g45n1svt M=1 L=45n W=145n
Mmn21 Ckbb CKb VSS VSS g45n1svt M=1 L=45n W=145n
Mmn10 SEb SE VSS VSS g45n1svt M=1 L=45n W=145n
Mmn25 Db CKb n20 VSS g45n1svt M=1 L=45n W=145n
MPM55 SEb_4 SE VDD VDD g45p1svt M=1 L=45n W=215n
MPM54 n2_4 D4 VDD VDD g45p1svt M=1 L=45n W=215n
MPM53 Db_4 SE n2_4 VDD g45p1svt M=1 L=45n W=215n
MPM52 n4_4 Q3 VDD VDD g45p1svt M=1 L=45n W=215n
MPM51 Db_4 SEb_4 n4_4 VDD g45p1svt M=1 L=45n W=215n
MPM50 n20_4 Ckbb Db_4 VDD g45p1svt M=1 L=45n W=215n
MPM49 mout_4 n20_4 VDD VDD g45p1svt M=1 L=45n W=215n
MPM48 n6_4 RN VDD VDD g45p1svt M=1 L=45n W=215n
MPM47 n20_4 CKb n6_4 VDD g45p1svt M=1 L=45n W=215n
MPM46 n6_4 mout_4 VDD VDD g45p1svt M=1 L=45n W=215n
MPM45 n30_4 CKb mout_4 VDD g45p1svt M=1 L=45n W=215n
MPM44 qbint_4 RN VDD VDD g45p1svt M=1 L=45n W=215n
MPM43 qbint_4 n30_4 VDD VDD g45p1svt M=1 L=45n W=215n
MPM42 n8_4 qbint_4 VDD VDD g45p1svt M=1 L=45n W=215n
MPM41 n30_4 Ckbb n8_4 VDD g45p1svt M=1 L=45n W=215n
MPM40 Q4 qbint_4 VDD VDD g45p1svt M=1 L=45n W=390n
MPM39 qint_4 qbint_4 VDD VDD g45p1svt M=1 L=45n W=215n
MPM38 Q4N qint_4 VDD VDD g45p1svt M=1 L=45n W=390n
MPM37 Q3N qint_3 VDD VDD g45p1svt M=1 L=45n W=390n
MPM36 qint_3 qbint_3 VDD VDD g45p1svt M=1 L=45n W=215n
MPM35 Q3 qbint_3 VDD VDD g45p1svt M=1 L=45n W=390n
MPM34 n30_3 Ckbb n8_3 VDD g45p1svt M=1 L=45n W=215n
MPM33 n8_3 qbint_3 VDD VDD g45p1svt M=1 L=45n W=215n
MPM32 qbint_3 n30_3 VDD VDD g45p1svt M=1 L=45n W=215n
MPM31 qbint_3 RN VDD VDD g45p1svt M=1 L=45n W=215n
MPM30 n30_3 CKb mout_3 VDD g45p1svt M=1 L=45n W=215n
MPM29 n6_3 mout_3 VDD VDD g45p1svt M=1 L=45n W=215n
MPM28 n20_3 CKb n6_3 VDD g45p1svt M=1 L=45n W=215n
MPM27 n6_3 RN VDD VDD g45p1svt M=1 L=45n W=215n
MPM26 mout_3 n20_3 VDD VDD g45p1svt M=1 L=45n W=215n
MPM25 n20_3 Ckbb Db_3 VDD g45p1svt M=1 L=45n W=215n
MPM24 Db_3 SEb_3 n4_3 VDD g45p1svt M=1 L=45n W=215n
MPM19 Q2N qint_2 VDD VDD g45p1svt M=1 L=45n W=390n
MPM18 qint_2 qbint_2 VDD VDD g45p1svt M=1 L=45n W=215n
MPM17 Q2 qbint_2 VDD VDD g45p1svt M=1 L=45n W=390n
MPM16 n30_2 Ckbb n8_2 VDD g45p1svt M=1 L=45n W=215n
MPM15 n8_2 qbint_2 VDD VDD g45p1svt M=1 L=45n W=215n
MPM14 qbint_2 n30_2 VDD VDD g45p1svt M=1 L=45n W=215n
MPM13 qbint_2 RN VDD VDD g45p1svt M=1 L=45n W=215n
MPM12 n30_2 CKb mout_2 VDD g45p1svt M=1 L=45n W=215n
MPM11 n6_2 mout_2 VDD VDD g45p1svt M=1 L=45n W=215n
MPM10 n20_2 CKb n6_2 VDD g45p1svt M=1 L=45n W=215n
MPM9 n6_2 RN VDD VDD g45p1svt M=1 L=45n W=215n
MPM8 mout_2 n20_2 VDD VDD g45p1svt M=1 L=45n W=215n
MPM7 n20_2 Ckbb Db_2 VDD g45p1svt M=1 L=45n W=215n
MPM20 SEb_3 SE VDD VDD g45p1svt M=1 L=45n W=215n
MPM4 Db_2 SEb_2 n4_2 VDD g45p1svt M=1 L=45n W=215n
MPM3 n4_2 Q1 VDD VDD g45p1svt M=1 L=45n W=215n
MPM2 Db_2 SE n2_2 VDD g45p1svt M=1 L=45n W=215n
MPM1 n2_2 D2 VDD VDD g45p1svt M=1 L=45n W=215n
MPM0 SEb_2 SE VDD VDD g45p1svt M=1 L=45n W=215n
MPM21 n2_3 D3 VDD VDD g45p1svt M=1 L=45n W=215n
MPM22 Db_3 SE n2_3 VDD g45p1svt M=1 L=45n W=215n
MPM23 n4_3 Q2 VDD VDD g45p1svt M=1 L=45n W=215n
Mmp14 Db SEb n4 VDD g45p1svt M=1 L=45n W=215n
Mmp13 n4 SI VDD VDD g45p1svt M=1 L=45n W=215n
Mmp12 Db SE n2 VDD g45p1svt M=1 L=45n W=215n
Mmp11 n2 D1 VDD VDD g45p1svt M=1 L=45n W=215n
Mmp51 n30 Ckbb n8 VDD g45p1svt M=1 L=45n W=215n
Mmp50 n8 qbint VDD VDD g45p1svt M=1 L=45n W=215n
Mmp55 Q1 qbint VDD VDD g45p1svt M=1 L=45n W=390n
Mmp20 CKb CK VDD VDD g45p1svt M=1 L=45n W=215n
Mmp46 qbint n30 VDD VDD g45p1svt M=1 L=45n W=215n
Mmp56 qint qbint VDD VDD g45p1svt M=1 L=45n W=215n
Mmp45 qbint RN VDD VDD g45p1svt M=1 L=45n W=215n
Mmp35 n6 RN VDD VDD g45p1svt M=1 L=45n W=215n
Mmp36 n6 mout VDD VDD g45p1svt M=1 L=45n W=215n
Mmp37 n20 CKb n6 VDD g45p1svt M=1 L=45n W=215n
Mmp40 n30 CKb mout VDD g45p1svt M=1 L=45n W=215n
Mmp30 mout n20 VDD VDD g45p1svt M=1 L=45n W=215n
Mmp21 Ckbb CKb VDD VDD g45p1svt M=1 L=45n W=215n
Mmp25 n20 Ckbb Db VDD g45p1svt M=1 L=45n W=215n
Mmp10 SEb SE VDD VDD g45p1svt M=1 L=45n W=215n
Mmp57 Q1N qint VDD VDD g45p1svt M=1 L=45n W=390n
.ENDS

.SUBCKT SDFF2RX2 CK D1 D2 Q1 Q1N Q2 Q2N RN SE SI VDD VSS
MNM19 Q2N qint_2 VSS VSS g45n1svt M=1 L=45n W=520n
MNM18 qint_2 qbint_2 VSS VSS g45n1svt M=1 L=45n W=145n
MNM17 Q2 qbint_2 VSS VSS g45n1svt M=1 L=45n W=520n
MNM16 n30_2 CKb n11_2 VSS g45n1svt M=1 L=45n W=145n
MNM15 n11_2 qbint_2 VSS VSS g45n1svt M=1 L=45n W=145n
MNM14 n9_2 RN VSS VSS g45n1svt M=1 L=45n W=205n
MNM13 qbint_2 n30_2 n9_2 VSS g45n1svt M=1 L=45n W=205n
MNM12 mout_2 Ckbb n30_2 VSS g45n1svt M=1 L=45n W=145n
MNM11 n5_2 mout_2 n7_2 VSS g45n1svt M=1 L=45n W=145n
MNM10 n7_2 RN VSS VSS g45n1svt M=1 L=45n W=145n
MNM9 n20_2 Ckbb n5_2 VSS g45n1svt M=1 L=45n W=145n
MNM8 mout_2 n20_2 VSS VSS g45n1svt M=1 L=45n W=145n
MNM7 Db_2 CKb n20_2 VSS g45n1svt M=1 L=45n W=145n
MNM4 n3_2 Q1 VSS VSS g45n1svt M=1 L=45n W=145n
MNM3 Db_2 SE n3_2 VSS g45n1svt M=1 L=45n W=145n
MNM2 Db_2 SEb_2 n1_2 VSS g45n1svt M=1 L=45n W=145n
MNM1 n1_2 D2 VSS VSS g45n1svt M=1 L=45n W=145n
MNM0 SEb_2 SE VSS VSS g45n1svt M=1 L=45n W=145n
Mmn36 n5 mout n7 VSS g45n1svt M=1 L=45n W=145n
Mmn35 n7 RN VSS VSS g45n1svt M=1 L=45n W=145n
Mmn37 n20 Ckbb n5 VSS g45n1svt M=1 L=45n W=145n
Mmn13 n3 SI VSS VSS g45n1svt M=1 L=45n W=145n
Mmn14 Db SE n3 VSS g45n1svt M=1 L=45n W=145n
Mmn12 Db SEb n1 VSS g45n1svt M=1 L=45n W=145n
Mmn11 n1 D1 VSS VSS g45n1svt M=1 L=45n W=145n
Mmn57 Q1N qint VSS VSS g45n1svt M=1 L=45n W=520n
Mmn55 Q1 qbint VSS VSS g45n1svt M=1 L=45n W=520n
Mmn45 n9 RN VSS VSS g45n1svt M=1 L=45n W=205n
Mmn46 qbint n30 n9 VSS g45n1svt M=1 L=45n W=205n
Mmn51 n30 CKb n11 VSS g45n1svt M=1 L=45n W=145n
Mmn50 n11 qbint VSS VSS g45n1svt M=1 L=45n W=145n
Mmn20 CKb CK VSS VSS g45n1svt M=1 L=45n W=145n
Mmn56 qint qbint VSS VSS g45n1svt M=1 L=45n W=145n
Mmn40 mout Ckbb n30 VSS g45n1svt M=1 L=45n W=145n
Mmn30 mout n20 VSS VSS g45n1svt M=1 L=45n W=145n
Mmn21 Ckbb CKb VSS VSS g45n1svt M=1 L=45n W=145n
Mmn10 SEb SE VSS VSS g45n1svt M=1 L=45n W=145n
Mmn25 Db CKb n20 VSS g45n1svt M=1 L=45n W=145n
MPM19 Q2N qint_2 VDD VDD g45p1svt M=1 L=45n W=780n
MPM18 qint_2 qbint_2 VDD VDD g45p1svt M=1 L=45n W=215n
MPM17 Q2 qbint_2 VDD VDD g45p1svt M=1 L=45n W=780n
MPM16 n30_2 Ckbb n8_2 VDD g45p1svt M=1 L=45n W=215n
MPM15 n8_2 qbint_2 VDD VDD g45p1svt M=1 L=45n W=215n
MPM14 qbint_2 n30_2 VDD VDD g45p1svt M=1 L=45n W=310n
MPM13 qbint_2 RN VDD VDD g45p1svt M=1 L=45n W=310n
MPM12 n30_2 CKb mout_2 VDD g45p1svt M=1 L=45n W=215n
MPM11 n6_2 mout_2 VDD VDD g45p1svt M=1 L=45n W=215n
MPM10 n20_2 CKb n6_2 VDD g45p1svt M=1 L=45n W=215n
MPM9 n6_2 RN VDD VDD g45p1svt M=1 L=45n W=215n
MPM8 mout_2 n20_2 VDD VDD g45p1svt M=1 L=45n W=215n
MPM7 n20_2 Ckbb Db_2 VDD g45p1svt M=1 L=45n W=215n
MPM4 Db_2 SEb_2 n4_2 VDD g45p1svt M=1 L=45n W=215n
MPM3 n4_2 Q1 VDD VDD g45p1svt M=1 L=45n W=215n
MPM2 Db_2 SE n2_2 VDD g45p1svt M=1 L=45n W=215n
MPM1 n2_2 D2 VDD VDD g45p1svt M=1 L=45n W=215n
MPM0 SEb_2 SE VDD VDD g45p1svt M=1 L=45n W=215n
Mmp14 Db SEb n4 VDD g45p1svt M=1 L=45n W=215n
Mmp13 n4 SI VDD VDD g45p1svt M=1 L=45n W=215n
Mmp12 Db SE n2 VDD g45p1svt M=1 L=45n W=215n
Mmp11 n2 D1 VDD VDD g45p1svt M=1 L=45n W=215n
Mmp51 n30 Ckbb n8 VDD g45p1svt M=1 L=45n W=215n
Mmp50 n8 qbint VDD VDD g45p1svt M=1 L=45n W=215n
Mmp55 Q1 qbint VDD VDD g45p1svt M=1 L=45n W=780n
Mmp20 CKb CK VDD VDD g45p1svt M=1 L=45n W=215n
Mmp46 qbint n30 VDD VDD g45p1svt M=1 L=45n W=310n
Mmp56 qint qbint VDD VDD g45p1svt M=1 L=45n W=215n
Mmp45 qbint RN VDD VDD g45p1svt M=1 L=45n W=310n
Mmp35 n6 RN VDD VDD g45p1svt M=1 L=45n W=215n
Mmp36 n6 mout VDD VDD g45p1svt M=1 L=45n W=215n
Mmp37 n20 CKb n6 VDD g45p1svt M=1 L=45n W=215n
Mmp40 n30 CKb mout VDD g45p1svt M=1 L=45n W=215n
Mmp30 mout n20 VDD VDD g45p1svt M=1 L=45n W=215n
Mmp21 Ckbb CKb VDD VDD g45p1svt M=1 L=45n W=215n
Mmp25 n20 Ckbb Db VDD g45p1svt M=1 L=45n W=215n
Mmp10 SEb SE VDD VDD g45p1svt M=1 L=45n W=215n
Mmp57 Q1N qint VDD VDD g45p1svt M=1 L=45n W=780n
.ENDS

.SUBCKT SDFF2RX1 CK D1 D2 Q1 Q1N Q2 Q2N RN SE SI VDD VSS
MNM19 Q2N qint_2 VSS VSS g45n1svt M=1 L=45n W=260n
MNM18 qint_2 qbint_2 VSS VSS g45n1svt M=1 L=45n W=145n
MNM17 Q2 qbint_2 VSS VSS g45n1svt M=1 L=45n W=260n
MNM16 n30_2 CKb n11_2 VSS g45n1svt M=1 L=45n W=145n
MNM15 n11_2 qbint_2 VSS VSS g45n1svt M=1 L=45n W=145n
MNM14 n9_2 RN VSS VSS g45n1svt M=1 L=45n W=145n
MNM13 qbint_2 n30_2 n9_2 VSS g45n1svt M=1 L=45n W=145n
MNM12 mout_2 Ckbb n30_2 VSS g45n1svt M=1 L=45n W=145n
MNM11 n5_2 mout_2 n7_2 VSS g45n1svt M=1 L=45n W=145n
MNM10 n7_2 RN VSS VSS g45n1svt M=1 L=45n W=145n
MNM9 n20_2 Ckbb n5_2 VSS g45n1svt M=1 L=45n W=145n
MNM8 mout_2 n20_2 VSS VSS g45n1svt M=1 L=45n W=145n
MNM7 Db_2 CKb n20_2 VSS g45n1svt M=1 L=45n W=145n
MNM4 n3_2 Q1 VSS VSS g45n1svt M=1 L=45n W=145n
MNM3 Db_2 SE n3_2 VSS g45n1svt M=1 L=45n W=145n
MNM2 Db_2 SEb_2 n1_2 VSS g45n1svt M=1 L=45n W=145n
MNM1 n1_2 D2 VSS VSS g45n1svt M=1 L=45n W=145n
MNM0 SEb_2 SE VSS VSS g45n1svt M=1 L=45n W=145n
Mmn36 n5 mout n7 VSS g45n1svt M=1 L=45n W=145n
Mmn35 n7 RN VSS VSS g45n1svt M=1 L=45n W=145n
Mmn37 n20 Ckbb n5 VSS g45n1svt M=1 L=45n W=145n
Mmn13 n3 SI VSS VSS g45n1svt M=1 L=45n W=145n
Mmn14 Db SE n3 VSS g45n1svt M=1 L=45n W=145n
Mmn12 Db SEb n1 VSS g45n1svt M=1 L=45n W=145n
Mmn11 n1 D1 VSS VSS g45n1svt M=1 L=45n W=145n
Mmn57 Q1N qint VSS VSS g45n1svt M=1 L=45n W=260n
Mmn55 Q1 qbint VSS VSS g45n1svt M=1 L=45n W=260n
Mmn45 n9 RN VSS VSS g45n1svt M=1 L=45n W=145n
Mmn46 qbint n30 n9 VSS g45n1svt M=1 L=45n W=145n
Mmn51 n30 CKb n11 VSS g45n1svt M=1 L=45n W=145n
Mmn50 n11 qbint VSS VSS g45n1svt M=1 L=45n W=145n
Mmn20 CKb CK VSS VSS g45n1svt M=1 L=45n W=145n
Mmn56 qint qbint VSS VSS g45n1svt M=1 L=45n W=145n
Mmn40 mout Ckbb n30 VSS g45n1svt M=1 L=45n W=145n
Mmn30 mout n20 VSS VSS g45n1svt M=1 L=45n W=145n
Mmn21 Ckbb CKb VSS VSS g45n1svt M=1 L=45n W=145n
Mmn10 SEb SE VSS VSS g45n1svt M=1 L=45n W=145n
Mmn25 Db CKb n20 VSS g45n1svt M=1 L=45n W=145n
MPM19 Q2N qint_2 VDD VDD g45p1svt M=1 L=45n W=390n
MPM18 qint_2 qbint_2 VDD VDD g45p1svt M=1 L=45n W=215n
MPM17 Q2 qbint_2 VDD VDD g45p1svt M=1 L=45n W=390n
MPM16 n30_2 Ckbb n8_2 VDD g45p1svt M=1 L=45n W=215n
MPM15 n8_2 qbint_2 VDD VDD g45p1svt M=1 L=45n W=215n
MPM14 qbint_2 n30_2 VDD VDD g45p1svt M=1 L=45n W=215n
MPM13 qbint_2 RN VDD VDD g45p1svt M=1 L=45n W=215n
MPM12 n30_2 CKb mout_2 VDD g45p1svt M=1 L=45n W=215n
MPM11 n6_2 mout_2 VDD VDD g45p1svt M=1 L=45n W=215n
MPM10 n20_2 CKb n6_2 VDD g45p1svt M=1 L=45n W=215n
MPM9 n6_2 RN VDD VDD g45p1svt M=1 L=45n W=215n
MPM8 mout_2 n20_2 VDD VDD g45p1svt M=1 L=45n W=215n
MPM7 n20_2 Ckbb Db_2 VDD g45p1svt M=1 L=45n W=215n
MPM4 Db_2 SEb_2 n4_2 VDD g45p1svt M=1 L=45n W=215n
MPM3 n4_2 Q1 VDD VDD g45p1svt M=1 L=45n W=215n
MPM2 Db_2 SE n2_2 VDD g45p1svt M=1 L=45n W=215n
MPM1 n2_2 D2 VDD VDD g45p1svt M=1 L=45n W=215n
MPM0 SEb_2 SE VDD VDD g45p1svt M=1 L=45n W=215n
Mmp14 Db SEb n4 VDD g45p1svt M=1 L=45n W=215n
Mmp13 n4 SI VDD VDD g45p1svt M=1 L=45n W=215n
Mmp12 Db SE n2 VDD g45p1svt M=1 L=45n W=215n
Mmp11 n2 D1 VDD VDD g45p1svt M=1 L=45n W=215n
Mmp51 n30 Ckbb n8 VDD g45p1svt M=1 L=45n W=215n
Mmp50 n8 qbint VDD VDD g45p1svt M=1 L=45n W=215n
Mmp55 Q1 qbint VDD VDD g45p1svt M=1 L=45n W=390n
Mmp20 CKb CK VDD VDD g45p1svt M=1 L=45n W=215n
Mmp46 qbint n30 VDD VDD g45p1svt M=1 L=45n W=215n
Mmp56 qint qbint VDD VDD g45p1svt M=1 L=45n W=215n
Mmp45 qbint RN VDD VDD g45p1svt M=1 L=45n W=215n
Mmp35 n6 RN VDD VDD g45p1svt M=1 L=45n W=215n
Mmp36 n6 mout VDD VDD g45p1svt M=1 L=45n W=215n
Mmp37 n20 CKb n6 VDD g45p1svt M=1 L=45n W=215n
Mmp40 n30 CKb mout VDD g45p1svt M=1 L=45n W=215n
Mmp30 mout n20 VDD VDD g45p1svt M=1 L=45n W=215n
Mmp21 Ckbb CKb VDD VDD g45p1svt M=1 L=45n W=215n
Mmp25 n20 Ckbb Db VDD g45p1svt M=1 L=45n W=215n
Mmp10 SEb SE VDD VDD g45p1svt M=1 L=45n W=215n
Mmp57 Q1N qint VDD VDD g45p1svt M=1 L=45n W=390n
.ENDS

.SUBCKT RTLATX1 D ExtVDD G Q QN RT VDD VSS
MNM3 net093 Qint VSS VSS g45n1svt M=1 L=45n W=145n
MNM2 n0g RT net093 VSS g45n1svt M=1 L=45n W=145n
Mmn11 Qint n0g VSS VSS g45n1svt M=1 L=45n W=145n
MNM0 n0g RTb n0 VSS g45n1svt M=1 L=45n W=145n
Mmn45 RTb RT VSS VSS g45n1svt M=1 L=45n W=145n
Mmn5 net257 D VSS VSS g45n1svt M=1 L=45n W=145n
Mmn6 n0 Gbb net257 VSS g45n1svt M=1 L=45n W=145n
Mmn16 net095 Gb net245 VSS g45n1svt M=1 L=45n W=145n
Mmn15 net245 Qint VSS VSS g45n1svt M=1 L=45n W=145n
Mmn22 QN Qint VSS VSS g45n1svt M=1 L=45n W=260n
Mmn21 Q Qbint VSS VSS g45n1svt M=1 L=45n W=260n
Mmn0 Gb G VSS VSS g45n1svt M=1 L=45n W=145n
Mmn20 Qbint Qint VSS VSS g45n1svt M=1 L=45n W=260n
Mmn1 Gbb Gb VSS VSS g45n1svt M=1 L=45n W=145n
MPM3 n0g RTb net145 ExtVDD g45p1svt M=1 L=45n W=215n
MPM2 net145 Qint ExtVDD ExtVDD g45p1svt M=1 L=45n W=215n
Mmp11 Qint n0g ExtVDD ExtVDD g45p1svt M=1 L=45n W=215n
MPM0 n0g RT n0 ExtVDD g45p1svt M=1 L=45n W=215n
Mmp6 n0 Gb net220 VDD g45p1svt M=1 L=45n W=215n
Mmp5 net220 D VDD VDD g45p1svt M=1 L=45n W=215n
Mmp16 net095 Gbb net212 VDD g45p1svt M=1 L=45n W=215n
Mmp15 net212 Qint VDD VDD g45p1svt M=1 L=45n W=215n
Mmp22 QN Qint VDD VDD g45p1svt M=1 L=45n W=390n
Mmp21 Q Qbint VDD VDD g45p1svt M=1 L=45n W=390n
Mmp0 Gb G VDD VDD g45p1svt M=1 L=45n W=215n
Mmp1 Gbb Gb VDD VDD g45p1svt M=1 L=45n W=215n
Mmp45 RTb RT ExtVDD ExtVDD g45p1svt M=1 L=45n W=215n
Mmp20 Qbint Qint VDD VDD g45p1svt M=1 L=45n W=390n
.ENDS

.SUBCKT RTLATSRX1 D ExtVDD G Q QN RN RT SN VDD VSS
MNM3 net094 Qint VSS VSS g45n1svt M=1 L=45n W=145n
MNM2 n5g RT net094 VSS g45n1svt M=1 L=45n W=145n
MNM0 n5g RTb n5 VSS g45n1svt M=1 L=45n W=145n
Mmn45 RTb RT VSS VSS g45n1svt M=1 L=45n W=145n
Mmn5 net191 D VSS VSS g45n1svt M=1 L=45n W=145n
Mmn6 n5 Gbb net191 VSS g45n1svt M=1 L=45n W=145n
Mmn10 net183 SN VSS VSS g45n1svt M=1 L=45n W=145n
Mmn11 Qint n5g net183 VSS g45n1svt M=1 L=45n W=145n
Mmn17 n5 Gb net171 VSS g45n1svt M=1 L=45n W=145n
Mmn16 net171 Qint net167 VSS g45n1svt M=1 L=45n W=145n
Mmn15 net167 RN VSS VSS g45n1svt M=1 L=45n W=145n
Mmn1 Gb G net159 VSS g45n1svt M=1 L=45n W=145n
Mmn0 net159 RN VSS VSS g45n1svt M=1 L=45n W=145n
Mmn22 QN Qint VSS VSS g45n1svt M=1 L=45n W=260n
Mmn21 Q Qbint VSS VSS g45n1svt M=1 L=45n W=260n
Mmn2 Gbb Gb VSS VSS g45n1svt M=1 L=45n W=145n
Mmn20 Qbint Qint VSS VSS g45n1svt M=1 L=45n W=260n
MPM3 n5g RTb net94 ExtVDD g45p1svt M=1 L=45n W=215n
MPM2 net94 Qint ExtVDD ExtVDD g45p1svt M=1 L=45n W=215n
MPM0 n5g RT n5 ExtVDD g45p1svt M=1 L=45n W=215n
Mmp45 RTb RT ExtVDD ExtVDD g45p1svt M=1 L=45n W=215n
Mmp6 n5 Gb net142 VDD g45p1svt M=1 L=45n W=215n
Mmp5 net142 D VDD VDD g45p1svt M=1 L=45n W=215n
Mmp10 Qint SN ExtVDD ExtVDD g45p1svt M=1 L=45n W=215n
Mmp1 Gb G VDD VDD g45p1svt M=1 L=45n W=215n
Mmp22 QN Qint VDD VDD g45p1svt M=1 L=45n W=390n
Mmp21 Q Qbint VDD VDD g45p1svt M=1 L=45n W=390n
Mmp2 Gbb Gb VDD VDD g45p1svt M=1 L=45n W=215n
Mmp17 n5 Gbb net103 VDD g45p1svt M=1 L=45n W=215n
Mmp16 net103 Qint VDD VDD g45p1svt M=1 L=45n W=215n
Mmp15 net103 RN VDD VDD g45p1svt M=1 L=45n W=215n
Mmp0 Gb RN VDD VDD g45p1svt M=1 L=45n W=215n
Mmp20 Qbint Qint VDD VDD g45p1svt M=1 L=45n W=390n
Mmp11 Qint n5g ExtVDD ExtVDD g45p1svt M=1 L=45n W=215n
.ENDS

.SUBCKT RTLATRX1 D ExtVDD G Q QN RN RT VDD VSS
MNM3 net094 Qint VSS VSS g45n1svt M=1 L=45n W=145n
MNM2 n5g RT net094 VSS g45n1svt M=1 L=45n W=145n
MNM0 n5g RTb n5 VSS g45n1svt M=1 L=45n W=145n
Mmn45 RTb RT VSS VSS g45n1svt M=1 L=45n W=145n
Mmn5 net191 D VSS VSS g45n1svt M=1 L=45n W=145n
Mmn6 n5 Gbb net191 VSS g45n1svt M=1 L=45n W=145n
Mmn11 Qint n5g VSS VSS g45n1svt M=1 L=45n W=145n
Mmn17 n5 Gb net171 VSS g45n1svt M=1 L=45n W=145n
Mmn16 net171 Qint net167 VSS g45n1svt M=1 L=45n W=145n
Mmn15 net167 RN VSS VSS g45n1svt M=1 L=45n W=145n
Mmn1 Gb G net159 VSS g45n1svt M=1 L=45n W=145n
Mmn0 net159 RN VSS VSS g45n1svt M=1 L=45n W=145n
Mmn22 QN Qint VSS VSS g45n1svt M=1 L=45n W=260n
Mmn21 Q Qbint VSS VSS g45n1svt M=1 L=45n W=260n
Mmn2 Gbb Gb VSS VSS g45n1svt M=1 L=45n W=145n
Mmn20 Qbint Qint VSS VSS g45n1svt M=1 L=45n W=260n
MPM3 n5g RTb net94 ExtVDD g45p1svt M=1 L=45n W=215n
MPM2 net94 Qint ExtVDD ExtVDD g45p1svt M=1 L=45n W=215n
MPM0 n5g RT n5 ExtVDD g45p1svt M=1 L=45n W=215n
Mmp45 RTb RT ExtVDD ExtVDD g45p1svt M=1 L=45n W=215n
Mmp6 n5 Gb net142 VDD g45p1svt M=1 L=45n W=215n
Mmp5 net142 D VDD VDD g45p1svt M=1 L=45n W=215n
Mmp1 Gb G VDD VDD g45p1svt M=1 L=45n W=215n
Mmp22 QN Qint VDD VDD g45p1svt M=1 L=45n W=390n
Mmp21 Q Qbint VDD VDD g45p1svt M=1 L=45n W=390n
Mmp2 Gbb Gb VDD VDD g45p1svt M=1 L=45n W=215n
Mmp17 n5 Gbb net103 VDD g45p1svt M=1 L=45n W=215n
Mmp16 net103 Qint VDD VDD g45p1svt M=1 L=45n W=215n
Mmp15 net103 RN VDD VDD g45p1svt M=1 L=45n W=215n
Mmp0 Gb RN VDD VDD g45p1svt M=1 L=45n W=215n
Mmp20 Qbint Qint VDD VDD g45p1svt M=1 L=45n W=390n
Mmp11 Qint n5g ExtVDD ExtVDD g45p1svt M=1 L=45n W=215n
.ENDS

.SUBCKT RDFFX1 CK D ExtVDD Q QN RT VDD VSS
MNM3 net0121 qbint VSS VSS g45n1svt M=1 L=45n W=145n
MNM2 n35g RT net0121 VSS g45n1svt M=1 L=45n W=145n
MNM1 qbint n35g VSS VSS g45n1svt M=1 L=45n W=145n
MNM0 n35g RTb n35 VSS g45n1svt M=1 L=45n W=145n
Mmn26 n20 CKb n21 VSS g45n1svt M=1 L=45n W=145n
Mmn25 n21 D VSS VSS g45n1svt M=1 L=45n W=145n
Mmn57 QN qint VSS VSS g45n1svt M=1 L=45n W=260n
Mmn55 Q qbint VSS VSS g45n1svt M=1 L=45n W=260n
Mmn35 n30 mout VSS VSS g45n1svt M=1 L=45n W=145n
Mmn36 n20 CKbb n30 VSS g45n1svt M=1 L=45n W=145n
Mmn20 CKb CK VSS VSS g45n1svt M=1 L=45n W=145n
Mmn45 RTb RT VSS VSS g45n1svt M=1 L=45n W=145n
Mmn56 qint qbint VSS VSS g45n1svt M=1 L=45n W=145n
Mmn52 net095 qbint VSS VSS g45n1svt M=1 L=45n W=145n
Mmn53 n35 CKb net095 VSS g45n1svt M=1 L=45n W=145n
Mmn21 CKbb CKb VSS VSS g45n1svt M=1 L=45n W=145n
Mmn32 mout n20 VSS VSS g45n1svt M=1 L=45n W=145n
Mmn40 n35 CKbb mout VSS g45n1svt M=1 L=45n W=145n
MPM3 n35g RTb net205 ExtVDD g45p1svt M=1 L=45n W=215n
MPM2 net205 qbint ExtVDD ExtVDD g45p1svt M=1 L=45n W=215n
MPM1 qbint n35g ExtVDD ExtVDD g45p1svt M=1 L=45n W=215n
MPM0 n35g RT n35 ExtVDD g45p1svt M=1 L=45n W=215n
Mmp26 n20 CKbb n22 VDD g45p1svt M=1 L=45n W=215n
Mmp25 n22 D VDD VDD g45p1svt M=1 L=45n W=215n
Mmp52 net084 qbint VDD VDD g45p1svt M=1 L=45n W=215n
Mmp57 QN qint VDD VDD g45p1svt M=1 L=45n W=390n
Mmp55 Q qbint VDD VDD g45p1svt M=1 L=45n W=390n
Mmp36 n20 CKb n31 VDD g45p1svt M=1 L=45n W=215n
Mmp35 n31 mout VDD VDD g45p1svt M=1 L=45n W=215n
Mmp32 mout n20 VDD VDD g45p1svt M=1 L=45n W=215n
Mmp20 CKb CK VDD VDD g45p1svt M=1 L=45n W=215n
Mmp53 n35 CKbb net084 VDD g45p1svt M=1 L=45n W=215n
Mmp45 RTb RT ExtVDD ExtVDD g45p1svt M=1 L=45n W=215n
Mmp56 qint qbint VDD VDD g45p1svt M=1 L=45n W=215n
Mmp21 CKbb CKb VDD VDD g45p1svt M=1 L=45n W=215n
Mmp40 n35 CKb mout VDD g45p1svt M=1 L=45n W=215n
.ENDS

.SUBCKT RDFFSX1 CK D ExtVDD Q QN RT SN VDD VSS
MNM3 net0121 qbint VSS VSS g45n1svt M=1 L=45n W=145n
MNM2 n35g RT net0121 VSS g45n1svt M=1 L=45n W=145n
MNM1 qbint n35g VSS VSS g45n1svt M=1 L=45n W=145n
MNM0 n35g RTb n35 VSS g45n1svt M=1 L=45n W=145n
Mmn26 n20 CKb n21 VSS g45n1svt M=1 L=45n W=145n
Mmn25 n21 D VSS VSS g45n1svt M=1 L=45n W=145n
Mmn57 QN qint VSS VSS g45n1svt M=1 L=45n W=260n
Mmn55 Q qbint VSS VSS g45n1svt M=1 L=45n W=260n
Mmn35 n30 mout VSS VSS g45n1svt M=1 L=45n W=145n
Mmn36 n20 CKbb n30 VSS g45n1svt M=1 L=45n W=145n
Mmn20 CKb CK VSS VSS g45n1svt M=1 L=45n W=145n
Mmn45 RTb RT VSS VSS g45n1svt M=1 L=45n W=145n
Mmn56 qint qbint VSS VSS g45n1svt M=1 L=45n W=145n
Mmn52 net095 qbint n42 VSS g45n1svt M=1 L=45n W=145n
Mmn50 n42 SN VSS VSS g45n1svt M=1 L=45n W=145n
Mmn53 n35 CKb net095 VSS g45n1svt M=1 L=45n W=145n
Mmn21 CKbb CKb VSS VSS g45n1svt M=1 L=45n W=145n
Mmn32 mout n20 net426 VSS g45n1svt M=1 L=45n W=145n
Mmn40 n35 CKbb mout VSS g45n1svt M=1 L=45n W=145n
Mmn30 net426 SN VSS VSS g45n1svt M=1 L=45n W=145n
MPM3 n35g RTb net205 ExtVDD g45p1svt M=1 L=45n W=215n
MPM2 net205 qbint ExtVDD ExtVDD g45p1svt M=1 L=45n W=215n
MPM1 qbint n35g ExtVDD ExtVDD g45p1svt M=1 L=45n W=215n
MPM0 n35g RT n35 ExtVDD g45p1svt M=1 L=45n W=215n
Mmp26 n20 CKbb n22 VDD g45p1svt M=1 L=45n W=215n
Mmp25 n22 D VDD VDD g45p1svt M=1 L=45n W=215n
Mmp52 n41 qbint VDD VDD g45p1svt M=1 L=45n W=215n
Mmp57 QN qint VDD VDD g45p1svt M=1 L=45n W=390n
Mmp55 Q qbint VDD VDD g45p1svt M=1 L=45n W=390n
Mmp36 n20 CKb n31 VDD g45p1svt M=1 L=45n W=215n
Mmp35 n31 mout VDD VDD g45p1svt M=1 L=45n W=215n
Mmp32 mout n20 VDD VDD g45p1svt M=1 L=45n W=215n
Mmp20 CKb CK VDD VDD g45p1svt M=1 L=45n W=215n
Mmp53 n35 CKbb n41 VDD g45p1svt M=1 L=45n W=215n
Mmp50 n41 SN VDD VDD g45p1svt M=1 L=45n W=215n
Mmp45 RTb RT ExtVDD ExtVDD g45p1svt M=1 L=45n W=215n
Mmp56 qint qbint VDD VDD g45p1svt M=1 L=45n W=215n
Mmp21 CKbb CKb VDD VDD g45p1svt M=1 L=45n W=215n
Mmp30 mout SN VDD VDD g45p1svt M=1 L=45n W=215n
Mmp40 n35 CKb mout VDD g45p1svt M=1 L=45n W=215n
.ENDS

.SUBCKT RDFFSRX1 CK D ExtVDD Q QN RN RT SN VDD VSS
MNM3 net0121 qbint VSS VSS g45n1svt M=1 L=45n W=145n
MNM2 n35g RT net0121 VSS g45n1svt M=1 L=45n W=145n
MNM1 qbint n35g VSS VSS g45n1svt M=1 L=45n W=145n
MNM0 n35g RTb n35 VSS g45n1svt M=1 L=45n W=145n
Mmn26 n20 CKb n21 VSS g45n1svt M=1 L=45n W=145n
Mmn25 n21 D VSS VSS g45n1svt M=1 L=45n W=145n
Mmn57 QN qint VSS VSS g45n1svt M=1 L=45n W=260n
Mmn55 Q qbint VSS VSS g45n1svt M=1 L=45n W=260n
Mmn35 n30 mout VSS VSS g45n1svt M=1 L=45n W=145n
Mmn36 n20 CKbb n30 VSS g45n1svt M=1 L=45n W=145n
Mmn22 RNb RN VSS VSS g45n1svt M=1 L=45n W=145n
Mmn20 CKb CK VSS VSS g45n1svt M=1 L=45n W=145n
Mmn45 RTb RT VSS VSS g45n1svt M=1 L=45n W=145n
Mmn56 qint qbint VSS VSS g45n1svt M=1 L=45n W=145n
Mmn52 n40 qbint n42 VSS g45n1svt M=1 L=45n W=145n
Mmn51 n40 RNb n42 VSS g45n1svt M=1 L=45n W=145n
Mmn50 n42 SN VSS VSS g45n1svt M=1 L=45n W=145n
Mmn53 n35 CKb n40 VSS g45n1svt M=1 L=45n W=145n
Mmn21 CKbb CKb VSS VSS g45n1svt M=1 L=45n W=145n
Mmn32 mout n20 net426 VSS g45n1svt M=1 L=45n W=145n
Mmn31 mout RNb net426 VSS g45n1svt M=1 L=45n W=145n
Mmn40 n35 CKbb mout VSS g45n1svt M=1 L=45n W=145n
Mmn30 net426 SN VSS VSS g45n1svt M=1 L=45n W=145n
MPM3 n35g RTb net205 ExtVDD g45p1svt M=1 L=45n W=215n
MPM2 net205 qbint ExtVDD ExtVDD g45p1svt M=1 L=45n W=215n
MPM1 qbint n35g ExtVDD ExtVDD g45p1svt M=1 L=45n W=215n
MPM0 n35g RT n35 ExtVDD g45p1svt M=1 L=45n W=215n
Mmp26 n20 CKbb n22 VDD g45p1svt M=1 L=45n W=215n
Mmp25 n22 D VDD VDD g45p1svt M=1 L=45n W=215n
Mmp52 n41 qbint n43 VDD g45p1svt M=1 L=45n W=215n
Mmp51 n43 RNb VDD VDD g45p1svt M=1 L=45n W=215n
Mmp57 QN qint VDD VDD g45p1svt M=1 L=45n W=390n
Mmp55 Q qbint VDD VDD g45p1svt M=1 L=45n W=390n
Mmp36 n20 CKb n31 VDD g45p1svt M=1 L=45n W=215n
Mmp35 n31 mout VDD VDD g45p1svt M=1 L=45n W=215n
Mmp32 mout n20 net402 VDD g45p1svt M=1 L=45n W=215n
Mmp31 net402 RNb VDD VDD g45p1svt M=1 L=45n W=215n
Mmp22 RNb RN VDD VDD g45p1svt M=1 L=45n W=215n
Mmp20 CKb CK VDD VDD g45p1svt M=1 L=45n W=215n
Mmp53 n35 CKbb n41 VDD g45p1svt M=1 L=45n W=215n
Mmp50 n41 SN VDD VDD g45p1svt M=1 L=45n W=215n
Mmp45 RTb RT ExtVDD ExtVDD g45p1svt M=1 L=45n W=215n
Mmp56 qint qbint VDD VDD g45p1svt M=1 L=45n W=215n
Mmp21 CKbb CKb VDD VDD g45p1svt M=1 L=45n W=215n
Mmp30 mout SN VDD VDD g45p1svt M=1 L=45n W=215n
Mmp40 n35 CKb mout VDD g45p1svt M=1 L=45n W=215n
.ENDS

.SUBCKT RDFFSRQX1 CK D ExtVDD Q RN RT SN VDD VSS
MNM3 net0121 qbint VSS VSS g45n1svt M=1 L=45n W=145n
MNM2 n35g RT net0121 VSS g45n1svt M=1 L=45n W=145n
MNM1 qbint n35g VSS VSS g45n1svt M=1 L=45n W=145n
MNM0 n35g RTb n35 VSS g45n1svt M=1 L=45n W=145n
Mmn26 n20 CKb n21 VSS g45n1svt M=1 L=45n W=145n
Mmn25 n21 D VSS VSS g45n1svt M=1 L=45n W=145n
Mmn55 Q qbint VSS VSS g45n1svt M=1 L=45n W=260n
Mmn35 n30 mout VSS VSS g45n1svt M=1 L=45n W=145n
Mmn36 n20 CKbb n30 VSS g45n1svt M=1 L=45n W=145n
Mmn22 RNb RN VSS VSS g45n1svt M=1 L=45n W=145n
Mmn20 CKb CK VSS VSS g45n1svt M=1 L=45n W=145n
Mmn45 RTb RT VSS VSS g45n1svt M=1 L=45n W=145n
Mmn52 n40 qbint n42 VSS g45n1svt M=1 L=45n W=145n
Mmn51 n40 RNb n42 VSS g45n1svt M=1 L=45n W=145n
Mmn50 n42 SN VSS VSS g45n1svt M=1 L=45n W=145n
Mmn53 n35 CKb n40 VSS g45n1svt M=1 L=45n W=145n
Mmn21 CKbb CKb VSS VSS g45n1svt M=1 L=45n W=145n
Mmn32 mout n20 net426 VSS g45n1svt M=1 L=45n W=145n
Mmn31 mout RNb net426 VSS g45n1svt M=1 L=45n W=145n
Mmn40 n35 CKbb mout VSS g45n1svt M=1 L=45n W=145n
Mmn30 net426 SN VSS VSS g45n1svt M=1 L=45n W=145n
MPM3 n35g RTb net205 ExtVDD g45p1svt M=1 L=45n W=215n
MPM2 net205 qbint ExtVDD ExtVDD g45p1svt M=1 L=45n W=215n
MPM1 qbint n35g ExtVDD ExtVDD g45p1svt M=1 L=45n W=215n
MPM0 n35g RT n35 ExtVDD g45p1svt M=1 L=45n W=215n
Mmp26 n20 CKbb n22 VDD g45p1svt M=1 L=45n W=215n
Mmp25 n22 D VDD VDD g45p1svt M=1 L=45n W=215n
Mmp52 n41 qbint n43 VDD g45p1svt M=1 L=45n W=215n
Mmp51 n43 RNb VDD VDD g45p1svt M=1 L=45n W=215n
Mmp55 Q qbint VDD VDD g45p1svt M=1 L=45n W=390n
Mmp36 n20 CKb n31 VDD g45p1svt M=1 L=45n W=215n
Mmp35 n31 mout VDD VDD g45p1svt M=1 L=45n W=215n
Mmp32 mout n20 net402 VDD g45p1svt M=1 L=45n W=215n
Mmp31 net402 RNb VDD VDD g45p1svt M=1 L=45n W=215n
Mmp22 RNb RN VDD VDD g45p1svt M=1 L=45n W=215n
Mmp20 CKb CK VDD VDD g45p1svt M=1 L=45n W=215n
Mmp53 n35 CKbb n41 VDD g45p1svt M=1 L=45n W=215n
Mmp50 n41 SN VDD VDD g45p1svt M=1 L=45n W=215n
Mmp45 RTb RT ExtVDD ExtVDD g45p1svt M=1 L=45n W=215n
Mmp21 CKbb CKb VDD VDD g45p1svt M=1 L=45n W=215n
Mmp30 mout SN VDD VDD g45p1svt M=1 L=45n W=215n
Mmp40 n35 CKb mout VDD g45p1svt M=1 L=45n W=215n
.ENDS

.SUBCKT RDFFSQX1 CK D ExtVDD Q RT SN VDD VSS
MNM3 net0121 qbint VSS VSS g45n1svt M=1 L=45n W=145n
MNM2 n35g RT net0121 VSS g45n1svt M=1 L=45n W=145n
MNM1 qbint n35g VSS VSS g45n1svt M=1 L=45n W=145n
MNM0 n35g RTb n35 VSS g45n1svt M=1 L=45n W=145n
Mmn26 n20 CKb n21 VSS g45n1svt M=1 L=45n W=145n
Mmn25 n21 D VSS VSS g45n1svt M=1 L=45n W=145n
Mmn55 Q qbint VSS VSS g45n1svt M=1 L=45n W=260n
Mmn35 n30 mout VSS VSS g45n1svt M=1 L=45n W=145n
Mmn36 n20 CKbb n30 VSS g45n1svt M=1 L=45n W=145n
Mmn20 CKb CK VSS VSS g45n1svt M=1 L=45n W=145n
Mmn45 RTb RT VSS VSS g45n1svt M=1 L=45n W=145n
Mmn52 net095 qbint n42 VSS g45n1svt M=1 L=45n W=145n
Mmn50 n42 SN VSS VSS g45n1svt M=1 L=45n W=145n
Mmn53 n35 CKb net095 VSS g45n1svt M=1 L=45n W=145n
Mmn21 CKbb CKb VSS VSS g45n1svt M=1 L=45n W=145n
Mmn32 mout n20 net426 VSS g45n1svt M=1 L=45n W=145n
Mmn40 n35 CKbb mout VSS g45n1svt M=1 L=45n W=145n
Mmn30 net426 SN VSS VSS g45n1svt M=1 L=45n W=145n
MPM3 n35g RTb net205 ExtVDD g45p1svt M=1 L=45n W=215n
MPM2 net205 qbint ExtVDD ExtVDD g45p1svt M=1 L=45n W=215n
MPM1 qbint n35g ExtVDD ExtVDD g45p1svt M=1 L=45n W=215n
MPM0 n35g RT n35 ExtVDD g45p1svt M=1 L=45n W=215n
Mmp26 n20 CKbb n22 VDD g45p1svt M=1 L=45n W=215n
Mmp25 n22 D VDD VDD g45p1svt M=1 L=45n W=215n
Mmp52 n41 qbint VDD VDD g45p1svt M=1 L=45n W=215n
Mmp55 Q qbint VDD VDD g45p1svt M=1 L=45n W=390n
Mmp36 n20 CKb n31 VDD g45p1svt M=1 L=45n W=215n
Mmp35 n31 mout VDD VDD g45p1svt M=1 L=45n W=215n
Mmp32 mout n20 VDD VDD g45p1svt M=1 L=45n W=215n
Mmp20 CKb CK VDD VDD g45p1svt M=1 L=45n W=215n
Mmp53 n35 CKbb n41 VDD g45p1svt M=1 L=45n W=215n
Mmp50 n41 SN VDD VDD g45p1svt M=1 L=45n W=215n
Mmp45 RTb RT ExtVDD ExtVDD g45p1svt M=1 L=45n W=215n
Mmp21 CKbb CKb VDD VDD g45p1svt M=1 L=45n W=215n
Mmp30 mout SN VDD VDD g45p1svt M=1 L=45n W=215n
Mmp40 n35 CKb mout VDD g45p1svt M=1 L=45n W=215n
.ENDS

.SUBCKT RDFFRX1 CK D ExtVDD Q QN RN RT VDD VSS
MNM3 net0121 qbint VSS VSS g45n1svt M=1 L=45n W=145n
MNM2 n35g RT net0121 VSS g45n1svt M=1 L=45n W=145n
MNM1 qbint n35g VSS VSS g45n1svt M=1 L=45n W=145n
MNM0 n35g RTb n35 VSS g45n1svt M=1 L=45n W=145n
Mmn26 n20 CKb n21 VSS g45n1svt M=1 L=45n W=145n
Mmn25 n21 D VSS VSS g45n1svt M=1 L=45n W=145n
Mmn57 QN qint VSS VSS g45n1svt M=1 L=45n W=260n
Mmn55 Q qbint VSS VSS g45n1svt M=1 L=45n W=260n
Mmn35 n30 mout VSS VSS g45n1svt M=1 L=45n W=145n
Mmn36 n20 CKbb n30 VSS g45n1svt M=1 L=45n W=145n
Mmn22 RNb RN VSS VSS g45n1svt M=1 L=45n W=145n
Mmn20 CKb CK VSS VSS g45n1svt M=1 L=45n W=145n
Mmn45 RTb RT VSS VSS g45n1svt M=1 L=45n W=145n
Mmn56 qint qbint VSS VSS g45n1svt M=1 L=45n W=145n
Mmn52 n40 qbint VSS VSS g45n1svt M=1 L=45n W=145n
Mmn51 n40 RNb VSS VSS g45n1svt M=1 L=45n W=145n
Mmn53 n35 CKb n40 VSS g45n1svt M=1 L=45n W=145n
Mmn21 CKbb CKb VSS VSS g45n1svt M=1 L=45n W=145n
Mmn32 mout n20 VSS VSS g45n1svt M=1 L=45n W=145n
Mmn31 mout RNb VSS VSS g45n1svt M=1 L=45n W=145n
Mmn40 n35 CKbb mout VSS g45n1svt M=1 L=45n W=145n
MPM3 n35g RTb net205 ExtVDD g45p1svt M=1 L=45n W=215n
MPM2 net205 qbint ExtVDD ExtVDD g45p1svt M=1 L=45n W=215n
MPM1 qbint n35g ExtVDD ExtVDD g45p1svt M=1 L=45n W=215n
MPM0 n35g RT n35 ExtVDD g45p1svt M=1 L=45n W=215n
Mmp26 n20 CKbb n22 VDD g45p1svt M=1 L=45n W=215n
Mmp25 n22 D VDD VDD g45p1svt M=1 L=45n W=215n
Mmp52 net097 qbint n43 VDD g45p1svt M=1 L=45n W=215n
Mmp51 n43 RNb VDD VDD g45p1svt M=1 L=45n W=215n
Mmp57 QN qint VDD VDD g45p1svt M=1 L=45n W=390n
Mmp55 Q qbint VDD VDD g45p1svt M=1 L=45n W=390n
Mmp36 n20 CKb n31 VDD g45p1svt M=1 L=45n W=215n
Mmp35 n31 mout VDD VDD g45p1svt M=1 L=45n W=215n
Mmp32 mout n20 net402 VDD g45p1svt M=1 L=45n W=215n
Mmp31 net402 RNb VDD VDD g45p1svt M=1 L=45n W=215n
Mmp22 RNb RN VDD VDD g45p1svt M=1 L=45n W=215n
Mmp20 CKb CK VDD VDD g45p1svt M=1 L=45n W=215n
Mmp53 n35 CKbb net097 VDD g45p1svt M=1 L=45n W=215n
Mmp45 RTb RT ExtVDD ExtVDD g45p1svt M=1 L=45n W=215n
Mmp56 qint qbint VDD VDD g45p1svt M=1 L=45n W=215n
Mmp21 CKbb CKb VDD VDD g45p1svt M=1 L=45n W=215n
Mmp40 n35 CKb mout VDD g45p1svt M=1 L=45n W=215n
.ENDS

.SUBCKT RDFFRQX1 CK D ExtVDD Q RN RT VDD VSS
MNM3 net0121 qbint VSS VSS g45n1svt M=1 L=45n W=145n
MNM2 n35g RT net0121 VSS g45n1svt M=1 L=45n W=145n
MNM1 qbint n35g VSS VSS g45n1svt M=1 L=45n W=145n
MNM0 n35g RTb n35 VSS g45n1svt M=1 L=45n W=145n
Mmn26 n20 CKb n21 VSS g45n1svt M=1 L=45n W=145n
Mmn25 n21 D VSS VSS g45n1svt M=1 L=45n W=145n
Mmn55 Q qbint VSS VSS g45n1svt M=1 L=45n W=260n
Mmn35 n30 mout VSS VSS g45n1svt M=1 L=45n W=145n
Mmn36 n20 CKbb n30 VSS g45n1svt M=1 L=45n W=145n
Mmn22 RNb RN VSS VSS g45n1svt M=1 L=45n W=145n
Mmn20 CKb CK VSS VSS g45n1svt M=1 L=45n W=145n
Mmn45 RTb RT VSS VSS g45n1svt M=1 L=45n W=145n
Mmn52 n40 qbint VSS VSS g45n1svt M=1 L=45n W=145n
Mmn51 n40 RNb VSS VSS g45n1svt M=1 L=45n W=145n
Mmn53 n35 CKb n40 VSS g45n1svt M=1 L=45n W=145n
Mmn21 CKbb CKb VSS VSS g45n1svt M=1 L=45n W=145n
Mmn32 mout n20 VSS VSS g45n1svt M=1 L=45n W=145n
Mmn31 mout RNb VSS VSS g45n1svt M=1 L=45n W=145n
Mmn40 n35 CKbb mout VSS g45n1svt M=1 L=45n W=145n
MPM3 n35g RTb net205 ExtVDD g45p1svt M=1 L=45n W=215n
MPM2 net205 qbint ExtVDD ExtVDD g45p1svt M=1 L=45n W=215n
MPM1 qbint n35g ExtVDD ExtVDD g45p1svt M=1 L=45n W=215n
MPM0 n35g RT n35 ExtVDD g45p1svt M=1 L=45n W=215n
Mmp26 n20 CKbb n22 VDD g45p1svt M=1 L=45n W=215n
Mmp25 n22 D VDD VDD g45p1svt M=1 L=45n W=215n
Mmp52 net097 qbint n43 VDD g45p1svt M=1 L=45n W=215n
Mmp51 n43 RNb VDD VDD g45p1svt M=1 L=45n W=215n
Mmp55 Q qbint VDD VDD g45p1svt M=1 L=45n W=390n
Mmp36 n20 CKb n31 VDD g45p1svt M=1 L=45n W=215n
Mmp35 n31 mout VDD VDD g45p1svt M=1 L=45n W=215n
Mmp32 mout n20 net402 VDD g45p1svt M=1 L=45n W=215n
Mmp31 net402 RNb VDD VDD g45p1svt M=1 L=45n W=215n
Mmp22 RNb RN VDD VDD g45p1svt M=1 L=45n W=215n
Mmp20 CKb CK VDD VDD g45p1svt M=1 L=45n W=215n
Mmp53 n35 CKbb net097 VDD g45p1svt M=1 L=45n W=215n
Mmp45 RTb RT ExtVDD ExtVDD g45p1svt M=1 L=45n W=215n
Mmp21 CKbb CKb VDD VDD g45p1svt M=1 L=45n W=215n
Mmp40 n35 CKb mout VDD g45p1svt M=1 L=45n W=215n
.ENDS

.SUBCKT RDFFQX1 CK D ExtVDD Q RT VDD VSS
MNM3 net0121 qbint VSS VSS g45n1svt M=1 L=45n W=145n
MNM2 n35g RT net0121 VSS g45n1svt M=1 L=45n W=145n
MNM1 qbint n35g VSS VSS g45n1svt M=1 L=45n W=145n
MNM0 n35g RTb n35 VSS g45n1svt M=1 L=45n W=145n
Mmn26 n20 CKb n21 VSS g45n1svt M=1 L=45n W=145n
Mmn25 n21 D VSS VSS g45n1svt M=1 L=45n W=145n
Mmn55 Q qbint VSS VSS g45n1svt M=1 L=45n W=260n
Mmn35 n30 mout VSS VSS g45n1svt M=1 L=45n W=145n
Mmn36 n20 CKbb n30 VSS g45n1svt M=1 L=45n W=145n
Mmn20 CKb CK VSS VSS g45n1svt M=1 L=45n W=145n
Mmn45 RTb RT VSS VSS g45n1svt M=1 L=45n W=145n
Mmn52 net095 qbint VSS VSS g45n1svt M=1 L=45n W=145n
Mmn53 n35 CKb net095 VSS g45n1svt M=1 L=45n W=145n
Mmn21 CKbb CKb VSS VSS g45n1svt M=1 L=45n W=145n
Mmn32 mout n20 VSS VSS g45n1svt M=1 L=45n W=145n
Mmn40 n35 CKbb mout VSS g45n1svt M=1 L=45n W=145n
MPM3 n35g RTb net205 ExtVDD g45p1svt M=1 L=45n W=215n
MPM2 net205 qbint ExtVDD ExtVDD g45p1svt M=1 L=45n W=215n
MPM1 qbint n35g ExtVDD ExtVDD g45p1svt M=1 L=45n W=215n
MPM0 n35g RT n35 ExtVDD g45p1svt M=1 L=45n W=215n
Mmp26 n20 CKbb n22 VDD g45p1svt M=1 L=45n W=215n
Mmp25 n22 D VDD VDD g45p1svt M=1 L=45n W=215n
Mmp52 net084 qbint VDD VDD g45p1svt M=1 L=45n W=215n
Mmp55 Q qbint VDD VDD g45p1svt M=1 L=45n W=390n
Mmp36 n20 CKb n31 VDD g45p1svt M=1 L=45n W=215n
Mmp35 n31 mout VDD VDD g45p1svt M=1 L=45n W=215n
Mmp32 mout n20 VDD VDD g45p1svt M=1 L=45n W=215n
Mmp20 CKb CK VDD VDD g45p1svt M=1 L=45n W=215n
Mmp53 n35 CKbb net084 VDD g45p1svt M=1 L=45n W=215n
Mmp45 RTb RT ExtVDD ExtVDD g45p1svt M=1 L=45n W=215n
Mmp21 CKbb CKb VDD VDD g45p1svt M=1 L=45n W=215n
Mmp40 n35 CKb mout VDD g45p1svt M=1 L=45n W=215n
.ENDS

.SUBCKT RDFFNX1 CKN D ExtVDD Q QN RT VDD VSS
MNM3 net0121 qbint VSS VSS g45n1svt M=1 L=45n W=145n
MNM2 n35g RT net0121 VSS g45n1svt M=1 L=45n W=145n
MNM1 qbint n35g VSS VSS g45n1svt M=1 L=45n W=145n
MNM0 n35g RTb n35 VSS g45n1svt M=1 L=45n W=145n
Mmn26 n20 CKNbb n21 VSS g45n1svt M=1 L=45n W=145n
Mmn25 n21 D VSS VSS g45n1svt M=1 L=45n W=145n
Mmn57 QN qint VSS VSS g45n1svt M=1 L=45n W=260n
Mmn55 Q qbint VSS VSS g45n1svt M=1 L=45n W=260n
Mmn35 n30 mout VSS VSS g45n1svt M=1 L=45n W=145n
Mmn36 n20 CKNb n30 VSS g45n1svt M=1 L=45n W=145n
Mmn20 CKNb CKN VSS VSS g45n1svt M=1 L=45n W=145n
Mmn45 RTb RT VSS VSS g45n1svt M=1 L=45n W=145n
Mmn56 qint qbint VSS VSS g45n1svt M=1 L=45n W=145n
Mmn52 net095 qbint VSS VSS g45n1svt M=1 L=45n W=145n
Mmn53 n35 CKNbb net095 VSS g45n1svt M=1 L=45n W=145n
Mmn21 CKNbb CKNb VSS VSS g45n1svt M=1 L=45n W=145n
Mmn32 mout n20 VSS VSS g45n1svt M=1 L=45n W=145n
Mmn40 n35 CKNb mout VSS g45n1svt M=1 L=45n W=145n
MPM3 n35g RTb net205 ExtVDD g45p1svt M=1 L=45n W=215n
MPM2 net205 qbint ExtVDD ExtVDD g45p1svt M=1 L=45n W=215n
MPM1 qbint n35g ExtVDD ExtVDD g45p1svt M=1 L=45n W=215n
MPM0 n35g RT n35 ExtVDD g45p1svt M=1 L=45n W=215n
Mmp26 n20 CKNb n22 VDD g45p1svt M=1 L=45n W=215n
Mmp25 n22 D VDD VDD g45p1svt M=1 L=45n W=215n
Mmp52 net082 qbint VDD VDD g45p1svt M=1 L=45n W=215n
Mmp57 QN qint VDD VDD g45p1svt M=1 L=45n W=390n
Mmp55 Q qbint VDD VDD g45p1svt M=1 L=45n W=390n
Mmp36 n20 CKNbb n31 VDD g45p1svt M=1 L=45n W=215n
Mmp35 n31 mout VDD VDD g45p1svt M=1 L=45n W=215n
Mmp32 mout n20 VDD VDD g45p1svt M=1 L=45n W=215n
Mmp20 CKNb CKN VDD VDD g45p1svt M=1 L=45n W=215n
Mmp53 n35 CKNb net082 VDD g45p1svt M=1 L=45n W=215n
Mmp45 RTb RT ExtVDD ExtVDD g45p1svt M=1 L=45n W=215n
Mmp56 qint qbint VDD VDD g45p1svt M=1 L=45n W=215n
Mmp21 CKNbb CKNb VDD VDD g45p1svt M=1 L=45n W=215n
Mmp40 n35 CKNbb mout VDD g45p1svt M=1 L=45n W=215n
.ENDS

.SUBCKT RDFFNSX1 CKN D ExtVDD Q QN RT SN VDD VSS
MNM3 net0121 qbint VSS VSS g45n1svt M=1 L=45n W=145n
MNM2 n35g RT net0121 VSS g45n1svt M=1 L=45n W=145n
MNM1 qbint n35g VSS VSS g45n1svt M=1 L=45n W=145n
MNM0 n35g RTb n35 VSS g45n1svt M=1 L=45n W=145n
Mmn26 n20 CKNbb n21 VSS g45n1svt M=1 L=45n W=145n
Mmn25 n21 D VSS VSS g45n1svt M=1 L=45n W=145n
Mmn57 QN qint VSS VSS g45n1svt M=1 L=45n W=260n
Mmn55 Q qbint VSS VSS g45n1svt M=1 L=45n W=260n
Mmn35 n30 mout VSS VSS g45n1svt M=1 L=45n W=145n
Mmn36 n20 CKNb n30 VSS g45n1svt M=1 L=45n W=145n
Mmn20 CKNb CKN VSS VSS g45n1svt M=1 L=45n W=145n
Mmn45 RTb RT VSS VSS g45n1svt M=1 L=45n W=145n
Mmn56 qint qbint VSS VSS g45n1svt M=1 L=45n W=145n
Mmn52 net095 qbint n42 VSS g45n1svt M=1 L=45n W=145n
Mmn50 n42 SN VSS VSS g45n1svt M=1 L=45n W=145n
Mmn53 n35 CKNbb net095 VSS g45n1svt M=1 L=45n W=145n
Mmn21 CKNbb CKNb VSS VSS g45n1svt M=1 L=45n W=145n
Mmn32 mout n20 net426 VSS g45n1svt M=1 L=45n W=145n
Mmn40 n35 CKNb mout VSS g45n1svt M=1 L=45n W=145n
Mmn30 net426 SN VSS VSS g45n1svt M=1 L=45n W=145n
MPM3 n35g RTb net205 ExtVDD g45p1svt M=1 L=45n W=215n
MPM2 net205 qbint ExtVDD ExtVDD g45p1svt M=1 L=45n W=215n
MPM1 qbint n35g ExtVDD ExtVDD g45p1svt M=1 L=45n W=215n
MPM0 n35g RT n35 ExtVDD g45p1svt M=1 L=45n W=215n
Mmp26 n20 CKNb n22 VDD g45p1svt M=1 L=45n W=215n
Mmp25 n22 D VDD VDD g45p1svt M=1 L=45n W=215n
Mmp52 n41 qbint VDD VDD g45p1svt M=1 L=45n W=215n
Mmp57 QN qint VDD VDD g45p1svt M=1 L=45n W=390n
Mmp55 Q qbint VDD VDD g45p1svt M=1 L=45n W=390n
Mmp36 n20 CKNbb n31 VDD g45p1svt M=1 L=45n W=215n
Mmp35 n31 mout VDD VDD g45p1svt M=1 L=45n W=215n
Mmp32 mout n20 VDD VDD g45p1svt M=1 L=45n W=215n
Mmp20 CKNb CKN VDD VDD g45p1svt M=1 L=45n W=215n
Mmp53 n35 CKNb n41 VDD g45p1svt M=1 L=45n W=215n
Mmp50 n41 SN VDD VDD g45p1svt M=1 L=45n W=215n
Mmp45 RTb RT ExtVDD ExtVDD g45p1svt M=1 L=45n W=215n
Mmp56 qint qbint VDD VDD g45p1svt M=1 L=45n W=215n
Mmp21 CKNbb CKNb VDD VDD g45p1svt M=1 L=45n W=215n
Mmp30 mout SN VDD VDD g45p1svt M=1 L=45n W=215n
Mmp40 n35 CKNbb mout VDD g45p1svt M=1 L=45n W=215n
.ENDS

.SUBCKT RDFFNSRX1 CKN D ExtVDD Q QN RN RT SN VDD VSS
MNM3 net0121 qbint VSS VSS g45n1svt M=1 L=45n W=145n
MNM2 n35g RT net0121 VSS g45n1svt M=1 L=45n W=145n
MNM1 qbint n35g VSS VSS g45n1svt M=1 L=45n W=145n
MNM0 n35g RTb n35 VSS g45n1svt M=1 L=45n W=145n
Mmn26 n20 CKNbb n21 VSS g45n1svt M=1 L=45n W=145n
Mmn25 n21 D VSS VSS g45n1svt M=1 L=45n W=145n
Mmn57 QN qint VSS VSS g45n1svt M=1 L=45n W=260n
Mmn55 Q qbint VSS VSS g45n1svt M=1 L=45n W=260n
Mmn35 n30 mout VSS VSS g45n1svt M=1 L=45n W=145n
Mmn36 n20 CKNb n30 VSS g45n1svt M=1 L=45n W=145n
Mmn22 RNb RN VSS VSS g45n1svt M=1 L=45n W=145n
Mmn20 CKNb CKN VSS VSS g45n1svt M=1 L=45n W=145n
Mmn45 RTb RT VSS VSS g45n1svt M=1 L=45n W=145n
Mmn56 qint qbint VSS VSS g45n1svt M=1 L=45n W=145n
Mmn52 n40 qbint n42 VSS g45n1svt M=1 L=45n W=145n
Mmn51 n40 RNb n42 VSS g45n1svt M=1 L=45n W=145n
Mmn50 n42 SN VSS VSS g45n1svt M=1 L=45n W=145n
Mmn53 n35 CKNbb n40 VSS g45n1svt M=1 L=45n W=145n
Mmn21 CKNbb CKNb VSS VSS g45n1svt M=1 L=45n W=145n
Mmn32 mout n20 net426 VSS g45n1svt M=1 L=45n W=145n
Mmn31 mout RNb net426 VSS g45n1svt M=1 L=45n W=145n
Mmn40 n35 CKNb mout VSS g45n1svt M=1 L=45n W=145n
Mmn30 net426 SN VSS VSS g45n1svt M=1 L=45n W=145n
MPM3 n35g RTb net205 ExtVDD g45p1svt M=1 L=45n W=215n
MPM2 net205 qbint ExtVDD ExtVDD g45p1svt M=1 L=45n W=215n
MPM1 qbint n35g ExtVDD ExtVDD g45p1svt M=1 L=45n W=215n
MPM0 n35g RT n35 ExtVDD g45p1svt M=1 L=45n W=215n
Mmp26 n20 CKNb n22 VDD g45p1svt M=1 L=45n W=215n
Mmp25 n22 D VDD VDD g45p1svt M=1 L=45n W=215n
Mmp52 n41 qbint n43 VDD g45p1svt M=1 L=45n W=215n
Mmp51 n43 RNb VDD VDD g45p1svt M=1 L=45n W=215n
Mmp57 QN qint VDD VDD g45p1svt M=1 L=45n W=390n
Mmp55 Q qbint VDD VDD g45p1svt M=1 L=45n W=390n
Mmp36 n20 CKNbb n31 VDD g45p1svt M=1 L=45n W=215n
Mmp35 n31 mout VDD VDD g45p1svt M=1 L=45n W=215n
Mmp32 mout n20 net402 VDD g45p1svt M=1 L=45n W=215n
Mmp31 net402 RNb VDD VDD g45p1svt M=1 L=45n W=215n
Mmp22 RNb RN VDD VDD g45p1svt M=1 L=45n W=215n
Mmp20 CKNb CKN VDD VDD g45p1svt M=1 L=45n W=215n
Mmp53 n35 CKNb n41 VDD g45p1svt M=1 L=45n W=215n
Mmp50 n41 SN VDD VDD g45p1svt M=1 L=45n W=215n
Mmp45 RTb RT ExtVDD ExtVDD g45p1svt M=1 L=45n W=215n
Mmp56 qint qbint VDD VDD g45p1svt M=1 L=45n W=215n
Mmp21 CKNbb CKNb VDD VDD g45p1svt M=1 L=45n W=215n
Mmp30 mout SN VDD VDD g45p1svt M=1 L=45n W=215n
Mmp40 n35 CKNbb mout VDD g45p1svt M=1 L=45n W=215n
.ENDS

.SUBCKT RDFFNSRQX1 CKN D ExtVDD Q RN RT SN VDD VSS
MNM3 net0121 qbint VSS VSS g45n1svt M=1 L=45n W=145n
MNM2 n35g RT net0121 VSS g45n1svt M=1 L=45n W=145n
MNM1 qbint n35g VSS VSS g45n1svt M=1 L=45n W=145n
MNM0 n35g RTb n35 VSS g45n1svt M=1 L=45n W=145n
Mmn26 n20 CKNbb n21 VSS g45n1svt M=1 L=45n W=145n
Mmn25 n21 D VSS VSS g45n1svt M=1 L=45n W=145n
Mmn55 Q qbint VSS VSS g45n1svt M=1 L=45n W=260n
Mmn35 n30 mout VSS VSS g45n1svt M=1 L=45n W=145n
Mmn36 n20 CKNb n30 VSS g45n1svt M=1 L=45n W=145n
Mmn22 RNb RN VSS VSS g45n1svt M=1 L=45n W=145n
Mmn20 CKNb CKN VSS VSS g45n1svt M=1 L=45n W=145n
Mmn45 RTb RT VSS VSS g45n1svt M=1 L=45n W=145n
Mmn52 n40 qbint n42 VSS g45n1svt M=1 L=45n W=145n
Mmn51 n40 RNb n42 VSS g45n1svt M=1 L=45n W=145n
Mmn50 n42 SN VSS VSS g45n1svt M=1 L=45n W=145n
Mmn53 n35 CKNbb n40 VSS g45n1svt M=1 L=45n W=145n
Mmn21 CKNbb CKNb VSS VSS g45n1svt M=1 L=45n W=145n
Mmn32 mout n20 net426 VSS g45n1svt M=1 L=45n W=145n
Mmn31 mout RNb net426 VSS g45n1svt M=1 L=45n W=145n
Mmn40 n35 CKNb mout VSS g45n1svt M=1 L=45n W=145n
Mmn30 net426 SN VSS VSS g45n1svt M=1 L=45n W=145n
MPM3 n35g RTb net205 ExtVDD g45p1svt M=1 L=45n W=215n
MPM2 net205 qbint ExtVDD ExtVDD g45p1svt M=1 L=45n W=215n
MPM1 qbint n35g ExtVDD ExtVDD g45p1svt M=1 L=45n W=215n
MPM0 n35g RT n35 ExtVDD g45p1svt M=1 L=45n W=215n
Mmp26 n20 CKNb n22 VDD g45p1svt M=1 L=45n W=215n
Mmp25 n22 D VDD VDD g45p1svt M=1 L=45n W=215n
Mmp52 n41 qbint n43 VDD g45p1svt M=1 L=45n W=215n
Mmp51 n43 RNb VDD VDD g45p1svt M=1 L=45n W=215n
Mmp55 Q qbint VDD VDD g45p1svt M=1 L=45n W=390n
Mmp36 n20 CKNbb n31 VDD g45p1svt M=1 L=45n W=215n
Mmp35 n31 mout VDD VDD g45p1svt M=1 L=45n W=215n
Mmp32 mout n20 net402 VDD g45p1svt M=1 L=45n W=215n
Mmp31 net402 RNb VDD VDD g45p1svt M=1 L=45n W=215n
Mmp22 RNb RN VDD VDD g45p1svt M=1 L=45n W=215n
Mmp20 CKNb CKN VDD VDD g45p1svt M=1 L=45n W=215n
Mmp53 n35 CKNb n41 VDD g45p1svt M=1 L=45n W=215n
Mmp50 n41 SN VDD VDD g45p1svt M=1 L=45n W=215n
Mmp45 RTb RT ExtVDD ExtVDD g45p1svt M=1 L=45n W=215n
Mmp21 CKNbb CKNb VDD VDD g45p1svt M=1 L=45n W=215n
Mmp30 mout SN VDD VDD g45p1svt M=1 L=45n W=215n
Mmp40 n35 CKNbb mout VDD g45p1svt M=1 L=45n W=215n
.ENDS

.SUBCKT RDFFNSQX1 CKN D ExtVDD Q RT SN VDD VSS
MNM3 net0121 qbint VSS VSS g45n1svt M=1 L=45n W=145n
MNM2 n35g RT net0121 VSS g45n1svt M=1 L=45n W=145n
MNM1 qbint n35g VSS VSS g45n1svt M=1 L=45n W=145n
MNM0 n35g RTb n35 VSS g45n1svt M=1 L=45n W=145n
Mmn26 n20 CKNbb n21 VSS g45n1svt M=1 L=45n W=145n
Mmn25 n21 D VSS VSS g45n1svt M=1 L=45n W=145n
Mmn55 Q qbint VSS VSS g45n1svt M=1 L=45n W=260n
Mmn35 n30 mout VSS VSS g45n1svt M=1 L=45n W=145n
Mmn36 n20 CKNb n30 VSS g45n1svt M=1 L=45n W=145n
Mmn20 CKNb CKN VSS VSS g45n1svt M=1 L=45n W=145n
Mmn45 RTb RT VSS VSS g45n1svt M=1 L=45n W=145n
Mmn52 net095 qbint n42 VSS g45n1svt M=1 L=45n W=145n
Mmn50 n42 SN VSS VSS g45n1svt M=1 L=45n W=145n
Mmn53 n35 CKNbb net095 VSS g45n1svt M=1 L=45n W=145n
Mmn21 CKNbb CKNb VSS VSS g45n1svt M=1 L=45n W=145n
Mmn32 mout n20 net426 VSS g45n1svt M=1 L=45n W=145n
Mmn40 n35 CKNb mout VSS g45n1svt M=1 L=45n W=145n
Mmn30 net426 SN VSS VSS g45n1svt M=1 L=45n W=145n
MPM3 n35g RTb net205 ExtVDD g45p1svt M=1 L=45n W=215n
MPM2 net205 qbint ExtVDD ExtVDD g45p1svt M=1 L=45n W=215n
MPM1 qbint n35g ExtVDD ExtVDD g45p1svt M=1 L=45n W=215n
MPM0 n35g RT n35 ExtVDD g45p1svt M=1 L=45n W=215n
Mmp26 n20 CKNb n22 VDD g45p1svt M=1 L=45n W=215n
Mmp25 n22 D VDD VDD g45p1svt M=1 L=45n W=215n
Mmp52 n41 qbint VDD VDD g45p1svt M=1 L=45n W=215n
Mmp55 Q qbint VDD VDD g45p1svt M=1 L=45n W=390n
Mmp36 n20 CKNbb n31 VDD g45p1svt M=1 L=45n W=215n
Mmp35 n31 mout VDD VDD g45p1svt M=1 L=45n W=215n
Mmp32 mout n20 VDD VDD g45p1svt M=1 L=45n W=215n
Mmp20 CKNb CKN VDD VDD g45p1svt M=1 L=45n W=215n
Mmp53 n35 CKNb n41 VDD g45p1svt M=1 L=45n W=215n
Mmp50 n41 SN VDD VDD g45p1svt M=1 L=45n W=215n
Mmp45 RTb RT ExtVDD ExtVDD g45p1svt M=1 L=45n W=215n
Mmp21 CKNbb CKNb VDD VDD g45p1svt M=1 L=45n W=215n
Mmp30 mout SN VDD VDD g45p1svt M=1 L=45n W=215n
Mmp40 n35 CKNbb mout VDD g45p1svt M=1 L=45n W=215n
.ENDS

.SUBCKT RDFFNRX1 CKN D ExtVDD Q QN RN RT VDD VSS
MNM3 net0121 qbint VSS VSS g45n1svt M=1 L=45n W=145n
MNM2 n35g RT net0121 VSS g45n1svt M=1 L=45n W=145n
MNM1 qbint n35g VSS VSS g45n1svt M=1 L=45n W=145n
MNM0 n35g RTb n35 VSS g45n1svt M=1 L=45n W=145n
Mmn26 n20 CKNbb n21 VSS g45n1svt M=1 L=45n W=145n
Mmn25 n21 D VSS VSS g45n1svt M=1 L=45n W=145n
Mmn57 QN qint VSS VSS g45n1svt M=1 L=45n W=260n
Mmn55 Q qbint VSS VSS g45n1svt M=1 L=45n W=260n
Mmn35 n30 mout VSS VSS g45n1svt M=1 L=45n W=145n
Mmn36 n20 CKNb n30 VSS g45n1svt M=1 L=45n W=145n
Mmn22 RNb RN VSS VSS g45n1svt M=1 L=45n W=145n
Mmn20 CKNb CKN VSS VSS g45n1svt M=1 L=45n W=145n
Mmn45 RTb RT VSS VSS g45n1svt M=1 L=45n W=145n
Mmn56 qint qbint VSS VSS g45n1svt M=1 L=45n W=145n
Mmn52 n40 qbint VSS VSS g45n1svt M=1 L=45n W=145n
Mmn51 n40 RNb VSS VSS g45n1svt M=1 L=45n W=145n
Mmn53 n35 CKNbb n40 VSS g45n1svt M=1 L=45n W=145n
Mmn21 CKNbb CKNb VSS VSS g45n1svt M=1 L=45n W=145n
Mmn32 mout n20 VSS VSS g45n1svt M=1 L=45n W=145n
Mmn31 mout RNb VSS VSS g45n1svt M=1 L=45n W=145n
Mmn40 n35 CKNb mout VSS g45n1svt M=1 L=45n W=145n
MPM3 n35g RTb net205 ExtVDD g45p1svt M=1 L=45n W=215n
MPM2 net205 qbint ExtVDD ExtVDD g45p1svt M=1 L=45n W=215n
MPM1 qbint n35g ExtVDD ExtVDD g45p1svt M=1 L=45n W=215n
MPM0 n35g RT n35 ExtVDD g45p1svt M=1 L=45n W=215n
Mmp26 n20 CKNb n22 VDD g45p1svt M=1 L=45n W=215n
Mmp25 n22 D VDD VDD g45p1svt M=1 L=45n W=215n
Mmp52 net098 qbint n43 VDD g45p1svt M=1 L=45n W=215n
Mmp51 n43 RNb VDD VDD g45p1svt M=1 L=45n W=215n
Mmp57 QN qint VDD VDD g45p1svt M=1 L=45n W=390n
Mmp55 Q qbint VDD VDD g45p1svt M=1 L=45n W=390n
Mmp36 n20 CKNbb n31 VDD g45p1svt M=1 L=45n W=215n
Mmp35 n31 mout VDD VDD g45p1svt M=1 L=45n W=215n
Mmp32 mout n20 net402 VDD g45p1svt M=1 L=45n W=215n
Mmp31 net402 RNb VDD VDD g45p1svt M=1 L=45n W=215n
Mmp22 RNb RN VDD VDD g45p1svt M=1 L=45n W=215n
Mmp20 CKNb CKN VDD VDD g45p1svt M=1 L=45n W=215n
Mmp53 n35 CKNb net098 VDD g45p1svt M=1 L=45n W=215n
Mmp45 RTb RT ExtVDD ExtVDD g45p1svt M=1 L=45n W=215n
Mmp56 qint qbint VDD VDD g45p1svt M=1 L=45n W=215n
Mmp21 CKNbb CKNb VDD VDD g45p1svt M=1 L=45n W=215n
Mmp40 n35 CKNbb mout VDD g45p1svt M=1 L=45n W=215n
.ENDS

.SUBCKT RDFFNRQX1 CKN D ExtVDD Q RN RT VDD VSS
MNM3 net0121 qbint VSS VSS g45n1svt M=1 L=45n W=145n
MNM2 n35g RT net0121 VSS g45n1svt M=1 L=45n W=145n
MNM1 qbint n35g VSS VSS g45n1svt M=1 L=45n W=145n
MNM0 n35g RTb n35 VSS g45n1svt M=1 L=45n W=145n
Mmn26 n20 CKNbb n21 VSS g45n1svt M=1 L=45n W=145n
Mmn25 n21 D VSS VSS g45n1svt M=1 L=45n W=145n
Mmn55 Q qbint VSS VSS g45n1svt M=1 L=45n W=260n
Mmn35 n30 mout VSS VSS g45n1svt M=1 L=45n W=145n
Mmn36 n20 CKNb n30 VSS g45n1svt M=1 L=45n W=145n
Mmn22 RNb RN VSS VSS g45n1svt M=1 L=45n W=145n
Mmn20 CKNb CKN VSS VSS g45n1svt M=1 L=45n W=145n
Mmn45 RTb RT VSS VSS g45n1svt M=1 L=45n W=145n
Mmn52 n40 qbint VSS VSS g45n1svt M=1 L=45n W=145n
Mmn51 n40 RNb VSS VSS g45n1svt M=1 L=45n W=145n
Mmn53 n35 CKNbb n40 VSS g45n1svt M=1 L=45n W=145n
Mmn21 CKNbb CKNb VSS VSS g45n1svt M=1 L=45n W=145n
Mmn32 mout n20 VSS VSS g45n1svt M=1 L=45n W=145n
Mmn31 mout RNb VSS VSS g45n1svt M=1 L=45n W=145n
Mmn40 n35 CKNb mout VSS g45n1svt M=1 L=45n W=145n
MPM3 n35g RTb net205 ExtVDD g45p1svt M=1 L=45n W=215n
MPM2 net205 qbint ExtVDD ExtVDD g45p1svt M=1 L=45n W=215n
MPM1 qbint n35g ExtVDD ExtVDD g45p1svt M=1 L=45n W=215n
MPM0 n35g RT n35 ExtVDD g45p1svt M=1 L=45n W=215n
Mmp26 n20 CKNb n22 VDD g45p1svt M=1 L=45n W=215n
Mmp25 n22 D VDD VDD g45p1svt M=1 L=45n W=215n
Mmp52 net098 qbint n43 VDD g45p1svt M=1 L=45n W=215n
Mmp51 n43 RNb VDD VDD g45p1svt M=1 L=45n W=215n
Mmp55 Q qbint VDD VDD g45p1svt M=1 L=45n W=390n
Mmp36 n20 CKNbb n31 VDD g45p1svt M=1 L=45n W=215n
Mmp35 n31 mout VDD VDD g45p1svt M=1 L=45n W=215n
Mmp32 mout n20 net402 VDD g45p1svt M=1 L=45n W=215n
Mmp31 net402 RNb VDD VDD g45p1svt M=1 L=45n W=215n
Mmp22 RNb RN VDD VDD g45p1svt M=1 L=45n W=215n
Mmp20 CKNb CKN VDD VDD g45p1svt M=1 L=45n W=215n
Mmp53 n35 CKNb net098 VDD g45p1svt M=1 L=45n W=215n
Mmp45 RTb RT ExtVDD ExtVDD g45p1svt M=1 L=45n W=215n
Mmp21 CKNbb CKNb VDD VDD g45p1svt M=1 L=45n W=215n
Mmp40 n35 CKNbb mout VDD g45p1svt M=1 L=45n W=215n
.ENDS

.SUBCKT RDFFNQX1 CKN D ExtVDD Q RT VDD VSS
MNM3 net0121 qbint VSS VSS g45n1svt M=1 L=45n W=145n
MNM2 n35g RT net0121 VSS g45n1svt M=1 L=45n W=145n
MNM1 qbint n35g VSS VSS g45n1svt M=1 L=45n W=145n
MNM0 n35g RTb n35 VSS g45n1svt M=1 L=45n W=145n
Mmn26 n20 CKNbb n21 VSS g45n1svt M=1 L=45n W=145n
Mmn25 n21 D VSS VSS g45n1svt M=1 L=45n W=145n
Mmn55 Q qbint VSS VSS g45n1svt M=1 L=45n W=260n
Mmn35 n30 mout VSS VSS g45n1svt M=1 L=45n W=145n
Mmn36 n20 CKNb n30 VSS g45n1svt M=1 L=45n W=145n
Mmn20 CKNb CKN VSS VSS g45n1svt M=1 L=45n W=145n
Mmn45 RTb RT VSS VSS g45n1svt M=1 L=45n W=145n
Mmn52 net095 qbint VSS VSS g45n1svt M=1 L=45n W=145n
Mmn53 n35 CKNbb net095 VSS g45n1svt M=1 L=45n W=145n
Mmn21 CKNbb CKNb VSS VSS g45n1svt M=1 L=45n W=145n
Mmn32 mout n20 VSS VSS g45n1svt M=1 L=45n W=145n
Mmn40 n35 CKNb mout VSS g45n1svt M=1 L=45n W=145n
MPM3 n35g RTb net205 ExtVDD g45p1svt M=1 L=45n W=215n
MPM2 net205 qbint ExtVDD ExtVDD g45p1svt M=1 L=45n W=215n
MPM1 qbint n35g ExtVDD ExtVDD g45p1svt M=1 L=45n W=215n
MPM0 n35g RT n35 ExtVDD g45p1svt M=1 L=45n W=215n
Mmp26 n20 CKNb n22 VDD g45p1svt M=1 L=45n W=215n
Mmp25 n22 D VDD VDD g45p1svt M=1 L=45n W=215n
Mmp52 net082 qbint VDD VDD g45p1svt M=1 L=45n W=215n
Mmp55 Q qbint VDD VDD g45p1svt M=1 L=45n W=390n
Mmp36 n20 CKNbb n31 VDD g45p1svt M=1 L=45n W=215n
Mmp35 n31 mout VDD VDD g45p1svt M=1 L=45n W=215n
Mmp32 mout n20 VDD VDD g45p1svt M=1 L=45n W=215n
Mmp20 CKNb CKN VDD VDD g45p1svt M=1 L=45n W=215n
Mmp53 n35 CKNb net082 VDD g45p1svt M=1 L=45n W=215n
Mmp45 RTb RT ExtVDD ExtVDD g45p1svt M=1 L=45n W=215n
Mmp21 CKNbb CKNb VDD VDD g45p1svt M=1 L=45n W=215n
Mmp40 n35 CKNbb mout VDD g45p1svt M=1 L=45n W=215n
.ENDS

.SUBCKT PINVX1 A ExtVDD VDD VSS Y
Mmp0 Y A ExtVDD ExtVDD g45p1svt M=1 L=45n W=390n
Mmn0 Y A VSS VSS g45n1svt M=1 L=45n W=260n
.ENDS

.SUBCKT PBUFX2 A ExtVDD VDD VSS Y
Mmn1 Y n0 VSS VSS g45n1svt M=1 L=45n W=520n
Mmn0 n0 A VSS VSS g45n1svt M=1 L=45n W=145n
Mmp1 Y n0 ExtVDD ExtVDD g45p1svt M=1 L=45n W=780n
Mmp0 n0 A ExtVDD ExtVDD g45p1svt M=1 L=45n W=215n
.ENDS

.SUBCKT OR4XL A B C D VDD VSS Y
Mmn4 Y n0 VSS VSS g45n1svt M=1 L=45n W=145n
Mmn3 n0 D VSS VSS g45n1svt M=1 L=45n W=145n
Mmn0 n0 A VSS VSS g45n1svt M=1 L=45n W=145n
Mmn2 n0 C VSS VSS g45n1svt M=1 L=45n W=145n
Mmn1 n0 B VSS VSS g45n1svt M=1 L=45n W=145n
Mmp4 Y n0 VDD VDD g45p1svt M=1 L=45n W=215n
Mmp0 n1 A VDD VDD g45p1svt M=1 L=45n W=215n
Mmp3 n0 D n3 VDD g45p1svt M=1 L=45n W=215n
Mmp1 n2 B n1 VDD g45p1svt M=1 L=45n W=215n
Mmp2 n3 C n2 VDD g45p1svt M=1 L=45n W=215n
.ENDS

.SUBCKT OR4X8 A B C D VDD VSS Y
Mmn4 Y n0 VSS VSS g45n1svt M=1 L=45n W=2.065u
Mmn3 n0 D VSS VSS g45n1svt M=1 L=45n W=520n
Mmn0 n0 A VSS VSS g45n1svt M=1 L=45n W=520n
Mmn2 n0 C VSS VSS g45n1svt M=1 L=45n W=520n
Mmn1 n0 B VSS VSS g45n1svt M=1 L=45n W=520n
Mmp4 Y n0 VDD VDD g45p1svt M=1 L=45n W=3.115u
Mmp0 n1 A VDD VDD g45p1svt M=1 L=45n W=780n
Mmp3 n0 D n3 VDD g45p1svt M=1 L=45n W=780n
Mmp1 n2 B n1 VDD g45p1svt M=1 L=45n W=780n
Mmp2 n3 C n2 VDD g45p1svt M=1 L=45n W=780n
.ENDS

.SUBCKT OR4X6 A B C D VDD VSS Y
Mmn4 Y n0 VSS VSS g45n1svt M=1 L=45n W=1.55u
Mmn3 n0 D VSS VSS g45n1svt M=1 L=45n W=520n
Mmn0 n0 A VSS VSS g45n1svt M=1 L=45n W=520n
Mmn2 n0 C VSS VSS g45n1svt M=1 L=45n W=520n
Mmn1 n0 B VSS VSS g45n1svt M=1 L=45n W=520n
Mmp4 Y n0 VDD VDD g45p1svt M=1 L=45n W=2.35u
Mmp0 n1 A VDD VDD g45p1svt M=1 L=45n W=780n
Mmp3 n0 D n3 VDD g45p1svt M=1 L=45n W=780n
Mmp1 n2 B n1 VDD g45p1svt M=1 L=45n W=780n
Mmp2 n3 C n2 VDD g45p1svt M=1 L=45n W=780n
.ENDS

.SUBCKT OR4X4 A B C D VDD VSS Y
Mmn4 Y n0 VSS VSS g45n1svt M=1 L=45n W=1.04u
Mmn3 n0 D VSS VSS g45n1svt M=1 L=45n W=260n
Mmn0 n0 A VSS VSS g45n1svt M=1 L=45n W=260n
Mmn2 n0 C VSS VSS g45n1svt M=1 L=45n W=260n
Mmn1 n0 B VSS VSS g45n1svt M=1 L=45n W=260n
Mmp4 Y n0 VDD VDD g45p1svt M=1 L=45n W=1.56u
Mmp0 n1 A VDD VDD g45p1svt M=1 L=45n W=390n
Mmp3 n0 D n3 VDD g45p1svt M=1 L=45n W=390n
Mmp1 n2 B n1 VDD g45p1svt M=1 L=45n W=390n
Mmp2 n3 C n2 VDD g45p1svt M=1 L=45n W=390n
.ENDS

.SUBCKT OR4X2 A B C D VDD VSS Y
Mmn4 Y n0 VSS VSS g45n1svt M=1 L=45n W=520n
Mmn3 n0 D VSS VSS g45n1svt M=1 L=45n W=145n
Mmn0 n0 A VSS VSS g45n1svt M=1 L=45n W=145n
Mmn2 n0 C VSS VSS g45n1svt M=1 L=45n W=145n
Mmn1 n0 B VSS VSS g45n1svt M=1 L=45n W=145n
Mmp4 Y n0 VDD VDD g45p1svt M=1 L=45n W=780n
Mmp0 n1 A VDD VDD g45p1svt M=1 L=45n W=215n
Mmp3 n0 D n3 VDD g45p1svt M=1 L=45n W=215n
Mmp1 n2 B n1 VDD g45p1svt M=1 L=45n W=215n
Mmp2 n3 C n2 VDD g45p1svt M=1 L=45n W=215n
.ENDS

.SUBCKT OR4X1 A B C D VDD VSS Y
Mmn4 Y n0 VSS VSS g45n1svt M=1 L=45n W=260n
Mmn3 n0 D VSS VSS g45n1svt M=1 L=45n W=145n
Mmn0 n0 A VSS VSS g45n1svt M=1 L=45n W=145n
Mmn2 n0 C VSS VSS g45n1svt M=1 L=45n W=145n
Mmn1 n0 B VSS VSS g45n1svt M=1 L=45n W=145n
Mmp4 Y n0 VDD VDD g45p1svt M=1 L=45n W=390n
Mmp0 n1 A VDD VDD g45p1svt M=1 L=45n W=215n
Mmp3 n0 D n3 VDD g45p1svt M=1 L=45n W=215n
Mmp1 n2 B n1 VDD g45p1svt M=1 L=45n W=215n
Mmp2 n3 C n2 VDD g45p1svt M=1 L=45n W=215n
.ENDS

.SUBCKT OR3XL A B C VDD VSS Y
Mmn3 Y n0 VSS VSS g45n1svt M=1 L=45n W=145n
Mmn0 n0 A VSS VSS g45n1svt M=1 L=45n W=145n
Mmn1 n0 B VSS VSS g45n1svt M=1 L=45n W=145n
Mmn2 n0 C VSS VSS g45n1svt M=1 L=45n W=145n
Mmp3 Y n0 VDD VDD g45p1svt M=1 L=45n W=215n
Mmp1 n2 B n1 VDD g45p1svt M=1 L=45n W=215n
Mmp2 n0 C n2 VDD g45p1svt M=1 L=45n W=215n
Mmp0 n1 A VDD VDD g45p1svt M=1 L=45n W=215n
.ENDS

.SUBCKT OR3X8 A B C VDD VSS Y
Mmn3 Y n0 VSS VSS g45n1svt M=1 L=45n W=2.065u
Mmn0 n0 A VSS VSS g45n1svt M=1 L=45n W=520n
Mmn1 n0 B VSS VSS g45n1svt M=1 L=45n W=520n
Mmn2 n0 C VSS VSS g45n1svt M=1 L=45n W=520n
Mmp3 Y n0 VDD VDD g45p1svt M=1 L=45n W=3.115u
Mmp1 n2 B n1 VDD g45p1svt M=1 L=45n W=780n
Mmp2 n0 C n2 VDD g45p1svt M=1 L=45n W=780n
Mmp0 n1 A VDD VDD g45p1svt M=1 L=45n W=780n
.ENDS

.SUBCKT OR3X6 A B C VDD VSS Y
Mmn3 Y n0 VSS VSS g45n1svt M=1 L=45n W=1.55u
Mmn0 n0 A VSS VSS g45n1svt M=1 L=45n W=520n
Mmn1 n0 B VSS VSS g45n1svt M=1 L=45n W=520n
Mmn2 n0 C VSS VSS g45n1svt M=1 L=45n W=520n
Mmp3 Y n0 VDD VDD g45p1svt M=1 L=45n W=2.35u
Mmp1 n2 B n1 VDD g45p1svt M=1 L=45n W=780n
Mmp2 n0 C n2 VDD g45p1svt M=1 L=45n W=780n
Mmp0 n1 A VDD VDD g45p1svt M=1 L=45n W=780n
.ENDS

.SUBCKT OR3X4 A B C VDD VSS Y
Mmn3 Y n0 VSS VSS g45n1svt M=1 L=45n W=1.04u
Mmn0 n0 A VSS VSS g45n1svt M=1 L=45n W=260n
Mmn1 n0 B VSS VSS g45n1svt M=1 L=45n W=260n
Mmn2 n0 C VSS VSS g45n1svt M=1 L=45n W=260n
Mmp3 Y n0 VDD VDD g45p1svt M=1 L=45n W=1.56u
Mmp1 n2 B n1 VDD g45p1svt M=1 L=45n W=390n
Mmp2 n0 C n2 VDD g45p1svt M=1 L=45n W=390n
Mmp0 n1 A VDD VDD g45p1svt M=1 L=45n W=390n
.ENDS

.SUBCKT OR3X2 A B C VDD VSS Y
Mmn3 Y n0 VSS VSS g45n1svt M=1 L=45n W=520n
Mmn0 n0 A VSS VSS g45n1svt M=1 L=45n W=145n
Mmn1 n0 B VSS VSS g45n1svt M=1 L=45n W=145n
Mmn2 n0 C VSS VSS g45n1svt M=1 L=45n W=145n
Mmp3 Y n0 VDD VDD g45p1svt M=1 L=45n W=780n
Mmp1 n2 B n1 VDD g45p1svt M=1 L=45n W=215n
Mmp2 n0 C n2 VDD g45p1svt M=1 L=45n W=215n
Mmp0 n1 A VDD VDD g45p1svt M=1 L=45n W=215n
.ENDS

.SUBCKT OR3X1 A B C VDD VSS Y
Mmn3 Y n0 VSS VSS g45n1svt M=1 L=45n W=260n
Mmn0 n0 A VSS VSS g45n1svt M=1 L=45n W=145n
Mmn1 n0 B VSS VSS g45n1svt M=1 L=45n W=145n
Mmn2 n0 C VSS VSS g45n1svt M=1 L=45n W=145n
Mmp3 Y n0 VDD VDD g45p1svt M=1 L=45n W=390n
Mmp1 n2 B n1 VDD g45p1svt M=1 L=45n W=215n
Mmp2 n0 C n2 VDD g45p1svt M=1 L=45n W=215n
Mmp0 n1 A VDD VDD g45p1svt M=1 L=45n W=215n
.ENDS

.SUBCKT OR2XL A B VDD VSS Y
Mmn2 Y n0 VSS VSS g45n1svt M=1 L=45n W=145n
Mmn0 n0 A VSS VSS g45n1svt M=1 L=45n W=145n
Mmn1 n0 B VSS VSS g45n1svt M=1 L=45n W=145n
Mmp1 n0 B n1 VDD g45p1svt M=1 L=45n W=215n
Mmp2 Y n0 VDD VDD g45p1svt M=1 L=45n W=215n
Mmp0 n1 A VDD VDD g45p1svt M=1 L=45n W=215n
.ENDS

.SUBCKT OR2X8 A B VDD VSS Y
Mmn2 Y n0 VSS VSS g45n1svt M=1 L=45n W=2.1u
Mmn0 n0 A VSS VSS g45n1svt M=1 L=45n W=520n
Mmn1 n0 B VSS VSS g45n1svt M=1 L=45n W=520n
Mmp1 n0 B n1 VDD g45p1svt M=1 L=45n W=780n
Mmp2 Y n0 VDD VDD g45p1svt M=1 L=45n W=3.15u
Mmp0 n1 A VDD VDD g45p1svt M=1 L=45n W=780n
.ENDS

.SUBCKT OR2X6 A B VDD VSS Y
Mmn2 Y n0 VSS VSS g45n1svt M=1 L=45n W=1.55u
Mmn0 n0 A VSS VSS g45n1svt M=1 L=45n W=520n
Mmn1 n0 B VSS VSS g45n1svt M=1 L=45n W=520n
Mmp1 n0 B n1 VDD g45p1svt M=1 L=45n W=780n
Mmp2 Y n0 VDD VDD g45p1svt M=1 L=45n W=2.35u
Mmp0 n1 A VDD VDD g45p1svt M=1 L=45n W=780n
.ENDS

.SUBCKT OR2X4 A B VDD VSS Y
Mmn2 Y n0 VSS VSS g45n1svt M=1 L=45n W=1.04u
Mmn0 n0 A VSS VSS g45n1svt M=1 L=45n W=260n
Mmn1 n0 B VSS VSS g45n1svt M=1 L=45n W=260n
Mmp1 n0 B n1 VDD g45p1svt M=1 L=45n W=390n
Mmp2 Y n0 VDD VDD g45p1svt M=1 L=45n W=1.56u
Mmp0 n1 A VDD VDD g45p1svt M=1 L=45n W=390n
.ENDS

.SUBCKT OR2X2 A B VDD VSS Y
Mmn2 Y n0 VSS VSS g45n1svt M=1 L=45n W=520n
Mmn0 n0 A VSS VSS g45n1svt M=1 L=45n W=145n
Mmn1 n0 B VSS VSS g45n1svt M=1 L=45n W=145n
Mmp1 n0 B n1 VDD g45p1svt M=1 L=45n W=215n
Mmp2 Y n0 VDD VDD g45p1svt M=1 L=45n W=780n
Mmp0 n1 A VDD VDD g45p1svt M=1 L=45n W=215n
.ENDS

.SUBCKT OAI33XL A0 A1 A2 B0 B1 B2 VDD VSS Y
Mmn0 no A0 VSS VSS g45n1svt M=1 L=45n W=145n
Mmn4 Y B0 no VSS g45n1svt M=1 L=45n W=145n
Mmn3 Y B1 no VSS g45n1svt M=1 L=45n W=145n
Mmn1 no A1 VSS VSS g45n1svt M=1 L=45n W=145n
Mmn2 no A2 VSS VSS g45n1svt M=1 L=45n W=145n
Mmn5 Y B2 no VSS g45n1svt M=1 L=45n W=145n
Mmp1 n2 A1 n1 VDD g45p1svt M=1 L=45n W=215n
Mmp4 n4 B0 n3 VDD g45p1svt M=1 L=45n W=215n
Mmp3 n3 B1 VDD VDD g45p1svt M=1 L=45n W=215n
Mmp5 Y B2 n4 VDD g45p1svt M=1 L=45n W=215n
Mmp0 n1 A0 VDD VDD g45p1svt M=1 L=45n W=215n
Mmp2 Y A2 n2 VDD g45p1svt M=1 L=45n W=215n
.ENDS

.SUBCKT OAI33X4 A0 A1 A2 B0 B1 B2 VDD VSS Y
Mmn0 no A0 VSS VSS g45n1svt M=1 L=45n W=1.04u
Mmn4 Y B0 no VSS g45n1svt M=1 L=45n W=1.04u
Mmn3 Y B1 no VSS g45n1svt M=1 L=45n W=1.04u
Mmn1 no A1 VSS VSS g45n1svt M=1 L=45n W=1.04u
Mmn2 no A2 VSS VSS g45n1svt M=1 L=45n W=1.04u
Mmn5 Y B2 no VSS g45n1svt M=1 L=45n W=1.04u
Mmp1 n2 A1 n1 VDD g45p1svt M=1 L=45n W=1.56u
Mmp4 n4 B0 n3 VDD g45p1svt M=1 L=45n W=1.56u
Mmp3 n3 B1 VDD VDD g45p1svt M=1 L=45n W=1.56u
Mmp5 Y B2 n4 VDD g45p1svt M=1 L=45n W=1.56u
Mmp0 n1 A0 VDD VDD g45p1svt M=1 L=45n W=1.56u
Mmp2 Y A2 n2 VDD g45p1svt M=1 L=45n W=1.56u
.ENDS

.SUBCKT OAI33X2 A0 A1 A2 B0 B1 B2 VDD VSS Y
Mmn0 n0 A0 VSS VSS g45n1svt M=1 L=45n W=520n
Mmn4 Y B0 n0 VSS g45n1svt M=1 L=45n W=520n
Mmn3 Y B1 n0 VSS g45n1svt M=1 L=45n W=520n
Mmn1 n0 A1 VSS VSS g45n1svt M=1 L=45n W=520n
Mmn2 n0 A2 VSS VSS g45n1svt M=1 L=45n W=520n
Mmn5 Y B2 n0 VSS g45n1svt M=1 L=45n W=520n
Mmp1 n2 A1 n1 VDD g45p1svt M=1 L=45n W=790n
Mmp4 n4 B0 n3 VDD g45p1svt M=1 L=45n W=790n
Mmp3 n3 B1 VDD VDD g45p1svt M=1 L=45n W=790n
Mmp5 Y B2 n4 VDD g45p1svt M=1 L=45n W=790n
Mmp0 n1 A0 VDD VDD g45p1svt M=1 L=45n W=790n
Mmp2 Y A2 n2 VDD g45p1svt M=1 L=45n W=790n
.ENDS

.SUBCKT OAI33X1 A0 A1 A2 B0 B1 B2 VDD VSS Y
Mmn0 no A0 VSS VSS g45n1svt M=1 L=45n W=260n
Mmn4 Y B0 no VSS g45n1svt M=1 L=45n W=260n
Mmn3 Y B1 no VSS g45n1svt M=1 L=45n W=260n
Mmn1 no A1 VSS VSS g45n1svt M=1 L=45n W=260n
Mmn2 no A2 VSS VSS g45n1svt M=1 L=45n W=260n
Mmn5 Y B2 no VSS g45n1svt M=1 L=45n W=260n
Mmp1 n2 A1 n1 VDD g45p1svt M=1 L=45n W=390n
Mmp4 n4 B0 n3 VDD g45p1svt M=1 L=45n W=390n
Mmp3 n3 B1 VDD VDD g45p1svt M=1 L=45n W=390n
Mmp5 Y B2 n4 VDD g45p1svt M=1 L=45n W=390n
Mmp0 n1 A0 VDD VDD g45p1svt M=1 L=45n W=390n
Mmp2 Y A2 n2 VDD g45p1svt M=1 L=45n W=390n
.ENDS

.SUBCKT OAI32XL A0 A1 A2 B0 B1 VDD VSS Y
Mmn3 Y B0 n0 VSS g45n1svt M=1 L=45n W=145n
Mmn4 Y B1 n0 VSS g45n1svt M=1 L=45n W=145n
Mmn2 n0 A2 VSS VSS g45n1svt M=1 L=45n W=145n
Mmn0 n0 A0 VSS VSS g45n1svt M=1 L=45n W=145n
Mmn1 n0 A1 VSS VSS g45n1svt M=1 L=45n W=145n
Mmp2 Y A2 n2 VDD g45p1svt M=1 L=45n W=215n
Mmp3 n4 B0 VDD VDD g45p1svt M=1 L=45n W=215n
Mmp0 n1 A0 VDD VDD g45p1svt M=1 L=45n W=215n
Mmp4 Y B1 n4 VDD g45p1svt M=1 L=45n W=215n
Mmp1 n2 A1 n1 VDD g45p1svt M=1 L=45n W=215n
.ENDS

.SUBCKT OAI32X4 A0 A1 A2 B0 B1 VDD VSS Y
Mmn3 Y B0 n0 VSS g45n1svt M=1 L=45n W=1.04u
Mmn4 Y B1 n0 VSS g45n1svt M=1 L=45n W=1.04u
Mmn2 n0 A2 VSS VSS g45n1svt M=1 L=45n W=1.04u
Mmn0 n0 A0 VSS VSS g45n1svt M=1 L=45n W=1.04u
Mmn1 n0 A1 VSS VSS g45n1svt M=1 L=45n W=1.04u
Mmp2 Y A2 n2 VDD g45p1svt M=1 L=45n W=1.56u
Mmp3 n4 B0 VDD VDD g45p1svt M=1 L=45n W=1.56u
Mmp0 n1 A0 VDD VDD g45p1svt M=1 L=45n W=1.56u
Mmp4 Y B1 n4 VDD g45p1svt M=1 L=45n W=1.56u
Mmp1 n2 A1 n1 VDD g45p1svt M=1 L=45n W=1.56u
.ENDS

.SUBCKT OAI32X2 A0 A1 A2 B0 B1 VDD VSS Y
Mmn3 Y B0 n0 VSS g45n1svt M=1 L=45n W=520n
Mmn4 Y B1 n0 VSS g45n1svt M=1 L=45n W=520n
Mmn2 n0 A2 VSS VSS g45n1svt M=1 L=45n W=520n
Mmn0 n0 A0 VSS VSS g45n1svt M=1 L=45n W=520n
Mmn1 n0 A1 VSS VSS g45n1svt M=1 L=45n W=520n
Mmp2 Y A2 n2 VDD g45p1svt M=1 L=45n W=780n
Mmp3 n4 B0 VDD VDD g45p1svt M=1 L=45n W=780n
Mmp0 n1 A0 VDD VDD g45p1svt M=1 L=45n W=780n
Mmp4 Y B1 n4 VDD g45p1svt M=1 L=45n W=780n
Mmp1 n2 A1 n1 VDD g45p1svt M=1 L=45n W=780n
.ENDS

.SUBCKT OAI32X1 A0 A1 A2 B0 B1 VDD VSS Y
Mmn3 Y B0 n0 VSS g45n1svt M=1 L=45n W=260n
Mmn4 Y B1 n0 VSS g45n1svt M=1 L=45n W=260n
Mmn2 n0 A2 VSS VSS g45n1svt M=1 L=45n W=260n
Mmn0 n0 A0 VSS VSS g45n1svt M=1 L=45n W=260n
Mmn1 n0 A1 VSS VSS g45n1svt M=1 L=45n W=260n
Mmp2 Y A2 n2 VDD g45p1svt M=1 L=45n W=390n
Mmp3 n4 B0 VDD VDD g45p1svt M=1 L=45n W=390n
Mmp0 n1 A0 VDD VDD g45p1svt M=1 L=45n W=390n
Mmp4 Y B1 n4 VDD g45p1svt M=1 L=45n W=390n
Mmp1 n2 A1 n1 VDD g45p1svt M=1 L=45n W=390n
.ENDS

.SUBCKT OAI31XL A0 A1 A2 B0 VDD VSS Y
Mmn3 Y B0 n0 VSS g45n1svt M=1 L=45n W=145n
Mmn0 n0 A0 VSS VSS g45n1svt M=1 L=45n W=145n
Mmn2 n0 A2 VSS VSS g45n1svt M=1 L=45n W=145n
Mmn1 n0 A1 VSS VSS g45n1svt M=1 L=45n W=145n
Mmp2 Y A2 n2 VDD g45p1svt M=1 L=45n W=215n
Mmp1 n2 A1 n1 VDD g45p1svt M=1 L=45n W=215n
Mmp3 Y B0 VDD VDD g45p1svt M=1 L=45n W=215n
Mmp0 n1 A0 VDD VDD g45p1svt M=1 L=45n W=215n
.ENDS

.SUBCKT OAI31X4 A0 A1 A2 B0 VDD VSS Y
Mmn3 Y B0 n0 VSS g45n1svt M=1 L=45n W=1.04u
Mmn0 n0 A0 VSS VSS g45n1svt M=1 L=45n W=1.04u
Mmn2 n0 A2 VSS VSS g45n1svt M=1 L=45n W=1.04u
Mmn1 n0 A1 VSS VSS g45n1svt M=1 L=45n W=1.04u
Mmp2 Y A2 n2 VDD g45p1svt M=1 L=45n W=1.56u
Mmp1 n2 A1 n1 VDD g45p1svt M=1 L=45n W=1.56u
Mmp3 Y B0 VDD VDD g45p1svt M=1 L=45n W=1.56u
Mmp0 n1 A0 VDD VDD g45p1svt M=1 L=45n W=1.56u
.ENDS

.SUBCKT OAI31X2 A0 A1 A2 B0 VDD VSS Y
Mmn3 Y B0 n0 VSS g45n1svt M=1 L=45n W=520n
Mmn0 n0 A0 VSS VSS g45n1svt M=1 L=45n W=520n
Mmn2 n0 A2 VSS VSS g45n1svt M=1 L=45n W=520n
Mmn1 n0 A1 VSS VSS g45n1svt M=1 L=45n W=520n
Mmp2 Y A2 n2 VDD g45p1svt M=1 L=45n W=780n
Mmp1 n2 A1 n1 VDD g45p1svt M=1 L=45n W=780n
Mmp3 Y B0 VDD VDD g45p1svt M=1 L=45n W=780n
Mmp0 n1 A0 VDD VDD g45p1svt M=1 L=45n W=780n
.ENDS

.SUBCKT OAI31X1 A0 A1 A2 B0 VDD VSS Y
Mmn3 Y B0 n0 VSS g45n1svt M=1 L=45n W=260n
Mmn0 n0 A0 VSS VSS g45n1svt M=1 L=45n W=260n
Mmn2 n0 A2 VSS VSS g45n1svt M=1 L=45n W=260n
Mmn1 n0 A1 VSS VSS g45n1svt M=1 L=45n W=260n
Mmp2 Y A2 n2 VDD g45p1svt M=1 L=45n W=390n
Mmp1 n2 A1 n1 VDD g45p1svt M=1 L=45n W=390n
Mmp3 Y B0 VDD VDD g45p1svt M=1 L=45n W=390n
Mmp0 n1 A0 VDD VDD g45p1svt M=1 L=45n W=390n
.ENDS

.SUBCKT OAI2BB2XL A0N A1N B0 B1 VDD VSS Y
Mmn5 Y B1 n4 VSS g45n1svt M=1 L=45n W=145n
Mmn4 Y B0 n4 VSS g45n1svt M=1 L=45n W=145n
Mmn2 n4 n0 VSS VSS g45n1svt M=1 L=45n W=145n
Mmn0 n0 A0N VSS VSS g45n1svt M=1 L=45n W=145n
Mmn1 n1 A1N VSS VSS g45n1svt M=1 L=45n W=145n
Mmn3 n4 n1 VSS VSS g45n1svt M=1 L=45n W=145n
Mmp5 Y B1 n3 VDD g45p1svt M=1 L=45n W=215n
Mmp4 n3 B0 VDD VDD g45p1svt M=1 L=45n W=215n
Mmp0 n0 A0N VDD VDD g45p1svt M=1 L=45n W=215n
Mmp2 n2 n0 VDD VDD g45p1svt M=1 L=45n W=215n
Mmp1 n1 A1N VDD VDD g45p1svt M=1 L=45n W=215n
Mmp3 Y n1 n2 VDD g45p1svt M=1 L=45n W=215n
.ENDS

.SUBCKT OAI2BB2X4 A0N A1N B0 B1 VDD VSS Y
Mmn5 Y B1 n4 VSS g45n1svt M=1 L=45n W=1.04u
Mmn4 Y B0 n4 VSS g45n1svt M=1 L=45n W=1.04u
Mmn2 n4 n0 VSS VSS g45n1svt M=1 L=45n W=1.04u
Mmn0 n0 A0N VSS VSS g45n1svt M=1 L=45n W=260n
Mmn1 n1 A1N VSS VSS g45n1svt M=1 L=45n W=260n
Mmn3 n4 n1 VSS VSS g45n1svt M=1 L=45n W=1.04u
Mmp5 Y B1 n3 VDD g45p1svt M=1 L=45n W=1.56u
Mmp4 n3 B0 VDD VDD g45p1svt M=1 L=45n W=1.56u
Mmp0 n0 A0N VDD VDD g45p1svt M=1 L=45n W=390n
Mmp2 n2 n0 VDD VDD g45p1svt M=1 L=45n W=1.56u
Mmp1 n1 A1N VDD VDD g45p1svt M=1 L=45n W=390n
Mmp3 Y n1 n2 VDD g45p1svt M=1 L=45n W=1.56u
.ENDS

.SUBCKT OAI2BB2X2 A0N A1N B0 B1 VDD VSS Y
Mmn5 Y B1 n4 VSS g45n1svt M=1 L=45n W=520n
Mmn4 Y B0 n4 VSS g45n1svt M=1 L=45n W=520n
Mmn2 n4 n0 VSS VSS g45n1svt M=1 L=45n W=520n
Mmn0 n0 A0N VSS VSS g45n1svt M=1 L=45n W=145n
Mmn1 n1 A1N VSS VSS g45n1svt M=1 L=45n W=145n
Mmn3 n4 n1 VSS VSS g45n1svt M=1 L=45n W=520n
Mmp5 Y B1 n3 VDD g45p1svt M=1 L=45n W=780n
Mmp4 n3 B0 VDD VDD g45p1svt M=1 L=45n W=780n
Mmp0 n0 A0N VDD VDD g45p1svt M=1 L=45n W=215n
Mmp2 n2 n0 VDD VDD g45p1svt M=1 L=45n W=780n
Mmp1 n1 A1N VDD VDD g45p1svt M=1 L=45n W=215n
Mmp3 Y n1 n2 VDD g45p1svt M=1 L=45n W=780n
.ENDS

.SUBCKT OAI2BB2X1 A0N A1N B0 B1 VDD VSS Y
Mmn5 Y B1 n4 VSS g45n1svt M=1 L=45n W=260n
Mmn4 Y B0 n4 VSS g45n1svt M=1 L=45n W=260n
Mmn2 n4 n0 VSS VSS g45n1svt M=1 L=45n W=260n
Mmn0 n0 A0N VSS VSS g45n1svt M=1 L=45n W=145n
Mmn1 n1 A1N VSS VSS g45n1svt M=1 L=45n W=145n
Mmn3 n4 n1 VSS VSS g45n1svt M=1 L=45n W=260n
Mmp5 Y B1 n3 VDD g45p1svt M=1 L=45n W=390n
Mmp4 n3 B0 VDD VDD g45p1svt M=1 L=45n W=390n
Mmp0 n0 A0N VDD VDD g45p1svt M=1 L=45n W=215n
Mmp2 n2 n0 VDD VDD g45p1svt M=1 L=45n W=390n
Mmp1 n1 A1N VDD VDD g45p1svt M=1 L=45n W=215n
Mmp3 Y n1 n2 VDD g45p1svt M=1 L=45n W=390n
.ENDS

.SUBCKT OAI2BB1XL A0N A1N B0 VDD VSS Y
Mmn3 Y n0 n2 VSS g45n1svt M=1 L=45n W=145n
Mmn2 n2 B0 VSS VSS g45n1svt M=1 L=45n W=145n
Mmn0 n1 A0N VSS VSS g45n1svt M=1 L=45n W=145n
Mmn1 n0 A1N n1 VSS g45n1svt M=1 L=45n W=145n
Mmp2 Y B0 VDD VDD g45p1svt M=1 L=45n W=215n
Mmp1 n0 A1N VDD VDD g45p1svt M=1 L=45n W=215n
Mmp0 n0 A0N VDD VDD g45p1svt M=1 L=45n W=215n
Mmp3 Y n0 VDD VDD g45p1svt M=1 L=45n W=215n
.ENDS

.SUBCKT OAI2BB1X4 A0N A1N B0 VDD VSS Y
Mmn3 Y n0 n2 VSS g45n1svt M=1 L=45n W=1.04u
Mmn2 n2 B0 VSS VSS g45n1svt M=1 L=45n W=1.04u
Mmn0 n1 A0N VSS VSS g45n1svt M=1 L=45n W=260n
Mmn1 n0 A1N n1 VSS g45n1svt M=1 L=45n W=260n
Mmp2 Y B0 VDD VDD g45p1svt M=1 L=45n W=1.56u
Mmp1 n0 A1N VDD VDD g45p1svt M=1 L=45n W=390n
Mmp0 n0 A0N VDD VDD g45p1svt M=1 L=45n W=390n
Mmp3 Y n0 VDD VDD g45p1svt M=1 L=45n W=1.56u
.ENDS

.SUBCKT OAI2BB1X2 A0N A1N B0 VDD VSS Y
Mmn3 Y n0 n2 VSS g45n1svt M=1 L=45n W=520n
Mmn2 n2 B0 VSS VSS g45n1svt M=1 L=45n W=520n
Mmn0 n1 A0N VSS VSS g45n1svt M=1 L=45n W=145n
Mmn1 n0 A1N n1 VSS g45n1svt M=1 L=45n W=145n
Mmp2 Y B0 VDD VDD g45p1svt M=1 L=45n W=780n
Mmp1 n0 A1N VDD VDD g45p1svt M=1 L=45n W=215n
Mmp0 n0 A0N VDD VDD g45p1svt M=1 L=45n W=215n
Mmp3 Y n0 VDD VDD g45p1svt M=1 L=45n W=780n
.ENDS

.SUBCKT OAI2BB1X1 A0N A1N B0 VDD VSS Y
Mmn3 Y n0 n2 VSS g45n1svt M=1 L=45n W=260n
Mmn2 n2 B0 VSS VSS g45n1svt M=1 L=45n W=260n
Mmn0 n1 A0N VSS VSS g45n1svt M=1 L=45n W=145n
Mmn1 n0 A1N n1 VSS g45n1svt M=1 L=45n W=145n
Mmp2 Y B0 VDD VDD g45p1svt M=1 L=45n W=390n
Mmp1 n0 A1N VDD VDD g45p1svt M=1 L=45n W=215n
Mmp0 n0 A0N VDD VDD g45p1svt M=1 L=45n W=215n
Mmp3 Y n0 VDD VDD g45p1svt M=1 L=45n W=390n
.ENDS

.SUBCKT OAI22XL A0 A1 B0 B1 VDD VSS Y
Mmn0 net102 A0 VSS VSS g45n1svt M=1 L=45n W=145n
Mmn3 Y B1 net102 VSS g45n1svt M=1 L=45n W=145n
Mmn1 net102 A1 VSS VSS g45n1svt M=1 L=45n W=145n
Mmn2 Y B0 net102 VSS g45n1svt M=1 L=45n W=145n
Mmp3 Y B1 net85 VDD g45p1svt M=1 L=45n W=215n
Mmp1 Y A1 net93 VDD g45p1svt M=1 L=45n W=215n
Mmp0 net93 A0 VDD VDD g45p1svt M=1 L=45n W=215n
Mmp2 net85 B0 VDD VDD g45p1svt M=1 L=45n W=215n
.ENDS

.SUBCKT OAI22X4 A0 A1 B0 B1 VDD VSS Y
Mmn0 net102 A0 VSS VSS g45n1svt M=1 L=45n W=1.04u
Mmn3 Y B1 net102 VSS g45n1svt M=1 L=45n W=1.04u
Mmn1 net102 A1 VSS VSS g45n1svt M=1 L=45n W=1.04u
Mmn2 Y B0 net102 VSS g45n1svt M=1 L=45n W=1.04u
Mmp3 Y B1 net85 VDD g45p1svt M=1 L=45n W=1.56u
Mmp1 Y A1 net93 VDD g45p1svt M=1 L=45n W=1.56u
Mmp0 net93 A0 VDD VDD g45p1svt M=1 L=45n W=1.56u
Mmp2 net85 B0 VDD VDD g45p1svt M=1 L=45n W=1.56u
.ENDS

.SUBCKT OAI22X2 A0 A1 B0 B1 VDD VSS Y
Mmn0 net102 A0 VSS VSS g45n1svt M=1 L=45n W=520n
Mmn3 Y B1 net102 VSS g45n1svt M=1 L=45n W=520n
Mmn1 net102 A1 VSS VSS g45n1svt M=1 L=45n W=520n
Mmn2 Y B0 net102 VSS g45n1svt M=1 L=45n W=520n
Mmp3 Y B1 net85 VDD g45p1svt M=1 L=45n W=780n
Mmp1 Y A1 net93 VDD g45p1svt M=1 L=45n W=780n
Mmp0 net93 A0 VDD VDD g45p1svt M=1 L=45n W=780n
Mmp2 net85 B0 VDD VDD g45p1svt M=1 L=45n W=780n
.ENDS

.SUBCKT OAI22X1 A0 A1 B0 B1 VDD VSS Y
Mmn0 net102 A0 VSS VSS g45n1svt M=1 L=45n W=260n
Mmn3 Y B1 net102 VSS g45n1svt M=1 L=45n W=260n
Mmn1 net102 A1 VSS VSS g45n1svt M=1 L=45n W=260n
Mmn2 Y B0 net102 VSS g45n1svt M=1 L=45n W=260n
Mmp3 Y B1 net85 VDD g45p1svt M=1 L=45n W=390n
Mmp1 Y A1 net93 VDD g45p1svt M=1 L=45n W=390n
Mmp0 net93 A0 VDD VDD g45p1svt M=1 L=45n W=390n
Mmp2 net85 B0 VDD VDD g45p1svt M=1 L=45n W=390n
.ENDS

.SUBCKT OAI222XL A0 A1 B0 B1 C0 C1 VDD VSS Y
Mmn5 Y C1 n0 VSS g45n1svt M=1 L=45n W=145n
Mmn4 Y C0 n0 VSS g45n1svt M=1 L=45n W=145n
Mmn3 n0 B1 n1 VSS g45n1svt M=1 L=45n W=145n
Mmn2 n0 B0 n1 VSS g45n1svt M=1 L=45n W=145n
Mmn0 n1 A0 VSS VSS g45n1svt M=1 L=45n W=145n
Mmn1 n1 A1 VSS VSS g45n1svt M=1 L=45n W=145n
Mmp5 Y C1 n4 VDD g45p1svt M=1 L=45n W=215n
Mmp4 n4 C0 VDD VDD g45p1svt M=1 L=45n W=215n
Mmp3 Y B1 n3 VDD g45p1svt M=1 L=45n W=215n
Mmp2 n3 B0 VDD VDD g45p1svt M=1 L=45n W=215n
Mmp1 Y A1 n2 VDD g45p1svt M=1 L=45n W=215n
Mmp0 n2 A0 VDD VDD g45p1svt M=1 L=45n W=215n
.ENDS

.SUBCKT OAI222X4 A0 A1 B0 B1 C0 C1 VDD VSS Y
Mmn5 Y C1 n0 VSS g45n1svt M=1 L=45n W=1.04u
Mmn4 Y C0 n0 VSS g45n1svt M=1 L=45n W=1.04u
Mmn3 n0 B1 n1 VSS g45n1svt M=1 L=45n W=1.04u
Mmn2 n0 B0 n1 VSS g45n1svt M=1 L=45n W=1.04u
Mmn0 n1 A0 VSS VSS g45n1svt M=1 L=45n W=1.04u
Mmn1 n1 A1 VSS VSS g45n1svt M=1 L=45n W=1.04u
Mmp5 Y C1 n4 VDD g45p1svt M=1 L=45n W=1.56u
Mmp4 n4 C0 VDD VDD g45p1svt M=1 L=45n W=1.56u
Mmp3 Y B1 n3 VDD g45p1svt M=1 L=45n W=1.56u
Mmp2 n3 B0 VDD VDD g45p1svt M=1 L=45n W=1.56u
Mmp1 Y A1 n2 VDD g45p1svt M=1 L=45n W=1.56u
Mmp0 n2 A0 VDD VDD g45p1svt M=1 L=45n W=1.56u
.ENDS

.SUBCKT OAI222X2 A0 A1 B0 B1 C0 C1 VDD VSS Y
Mmn5 Y C1 n0 VSS g45n1svt M=1 L=45n W=520n
Mmn4 Y C0 n0 VSS g45n1svt M=1 L=45n W=520n
Mmn3 n0 B1 n1 VSS g45n1svt M=1 L=45n W=520n
Mmn2 n0 B0 n1 VSS g45n1svt M=1 L=45n W=520n
Mmn0 n1 A0 VSS VSS g45n1svt M=1 L=45n W=520n
Mmn1 n1 A1 VSS VSS g45n1svt M=1 L=45n W=520n
Mmp5 Y C1 n4 VDD g45p1svt M=1 L=45n W=780n
Mmp4 n4 C0 VDD VDD g45p1svt M=1 L=45n W=780n
Mmp3 Y B1 n3 VDD g45p1svt M=1 L=45n W=780n
Mmp2 n3 B0 VDD VDD g45p1svt M=1 L=45n W=780n
Mmp1 Y A1 n2 VDD g45p1svt M=1 L=45n W=780n
Mmp0 n2 A0 VDD VDD g45p1svt M=1 L=45n W=780n
.ENDS

.SUBCKT OAI222X1 A0 A1 B0 B1 C0 C1 VDD VSS Y
Mmn5 Y C1 n0 VSS g45n1svt M=1 L=45n W=260n
Mmn4 Y C0 n0 VSS g45n1svt M=1 L=45n W=260n
Mmn3 n0 B1 n1 VSS g45n1svt M=1 L=45n W=260n
Mmn2 n0 B0 n1 VSS g45n1svt M=1 L=45n W=260n
Mmn0 n1 A0 VSS VSS g45n1svt M=1 L=45n W=260n
Mmn1 n1 A1 VSS VSS g45n1svt M=1 L=45n W=260n
Mmp5 Y C1 n4 VDD g45p1svt M=1 L=45n W=390n
Mmp4 n4 C0 VDD VDD g45p1svt M=1 L=45n W=390n
Mmp3 Y B1 n3 VDD g45p1svt M=1 L=45n W=390n
Mmp2 n3 B0 VDD VDD g45p1svt M=1 L=45n W=390n
Mmp1 Y A1 n2 VDD g45p1svt M=1 L=45n W=390n
Mmp0 n2 A0 VDD VDD g45p1svt M=1 L=45n W=390n
.ENDS

.SUBCKT OAI221XL A0 A1 B0 B1 C0 VDD VSS Y
Mmn4 Y C0 net132 VSS g45n1svt M=1 L=45n W=145n
Mmn0 net128 A0 VSS VSS g45n1svt M=1 L=45n W=145n
Mmn1 net128 A1 VSS VSS g45n1svt M=1 L=45n W=145n
Mmn2 net132 B0 net128 VSS g45n1svt M=1 L=45n W=145n
Mmn3 net132 B1 net128 VSS g45n1svt M=1 L=45n W=145n
Mmp3 Y B1 net123 VDD g45p1svt M=1 L=45n W=215n
Mmp0 net115 A0 VDD VDD g45p1svt M=1 L=45n W=215n
Mmp1 Y A1 net115 VDD g45p1svt M=1 L=45n W=215n
Mmp2 net123 B0 VDD VDD g45p1svt M=1 L=45n W=215n
Mmp4 Y C0 VDD VDD g45p1svt M=1 L=45n W=215n
.ENDS

.SUBCKT OAI221X4 A0 A1 B0 B1 C0 VDD VSS Y
Mmn4 Y C0 net132 VSS g45n1svt M=1 L=45n W=1.04u
Mmn0 net128 A0 VSS VSS g45n1svt M=1 L=45n W=1.04u
Mmn1 net128 A1 VSS VSS g45n1svt M=1 L=45n W=1.04u
Mmn2 net132 B0 net128 VSS g45n1svt M=1 L=45n W=1.04u
Mmn3 net132 B1 net128 VSS g45n1svt M=1 L=45n W=1.04u
Mmp3 Y B1 net123 VDD g45p1svt M=1 L=45n W=1.56u
Mmp0 net115 A0 VDD VDD g45p1svt M=1 L=45n W=1.56u
Mmp1 Y A1 net115 VDD g45p1svt M=1 L=45n W=1.56u
Mmp2 net123 B0 VDD VDD g45p1svt M=1 L=45n W=1.56u
Mmp4 Y C0 VDD VDD g45p1svt M=1 L=45n W=1.56u
.ENDS

.SUBCKT OAI221X2 A0 A1 B0 B1 C0 VDD VSS Y
Mmn4 Y C0 net132 VSS g45n1svt M=1 L=45n W=520n
Mmn0 net128 A0 VSS VSS g45n1svt M=1 L=45n W=520n
Mmn1 net128 A1 VSS VSS g45n1svt M=1 L=45n W=520n
Mmn2 net132 B0 net128 VSS g45n1svt M=1 L=45n W=520n
Mmn3 net132 B1 net128 VSS g45n1svt M=1 L=45n W=520n
Mmp3 Y B1 net123 VDD g45p1svt M=1 L=45n W=780n
Mmp0 net115 A0 VDD VDD g45p1svt M=1 L=45n W=780n
Mmp1 Y A1 net115 VDD g45p1svt M=1 L=45n W=780n
Mmp2 net123 B0 VDD VDD g45p1svt M=1 L=45n W=780n
Mmp4 Y C0 VDD VDD g45p1svt M=1 L=45n W=780n
.ENDS

.SUBCKT OAI221X1 A0 A1 B0 B1 C0 VDD VSS Y
Mmn4 Y C0 net132 VSS g45n1svt M=1 L=45n W=260n
Mmn0 net128 A0 VSS VSS g45n1svt M=1 L=45n W=260n
Mmn1 net128 A1 VSS VSS g45n1svt M=1 L=45n W=260n
Mmn2 net132 B0 net128 VSS g45n1svt M=1 L=45n W=260n
Mmn3 net132 B1 net128 VSS g45n1svt M=1 L=45n W=260n
Mmp3 Y B1 net123 VDD g45p1svt M=1 L=45n W=390n
Mmp0 net115 A0 VDD VDD g45p1svt M=1 L=45n W=390n
Mmp1 Y A1 net115 VDD g45p1svt M=1 L=45n W=390n
Mmp2 net123 B0 VDD VDD g45p1svt M=1 L=45n W=390n
Mmp4 Y C0 VDD VDD g45p1svt M=1 L=45n W=390n
.ENDS

.SUBCKT OAI21XL A0 A1 B0 VDD VSS Y
Mmn2 Y B0 n0 VSS g45n1svt M=1 L=45n W=145n
Mmn1 n0 A1 VSS VSS g45n1svt M=1 L=45n W=145n
Mmn0 n0 A0 VSS VSS g45n1svt M=1 L=45n W=145n
Mmp0 n1 A0 VDD VDD g45p1svt M=1 L=45n W=215n
Mmp2 Y B0 VDD VDD g45p1svt M=1 L=45n W=215n
Mmp1 Y A1 n1 VDD g45p1svt M=1 L=45n W=215n
.ENDS

.SUBCKT OAI21X4 A0 A1 B0 VDD VSS Y
Mmn2 Y B0 n0 VSS g45n1svt M=1 L=45n W=1.04u
Mmn1 n0 A1 VSS VSS g45n1svt M=1 L=45n W=1.04u
Mmn0 n0 A0 VSS VSS g45n1svt M=1 L=45n W=1.04u
Mmp0 n1 A0 VDD VDD g45p1svt M=1 L=45n W=1.56u
Mmp2 Y B0 VDD VDD g45p1svt M=1 L=45n W=1.56u
Mmp1 Y A1 n1 VDD g45p1svt M=1 L=45n W=1.56u
.ENDS

.SUBCKT OAI21X2 A0 A1 B0 VDD VSS Y
Mmn2 Y B0 n0 VSS g45n1svt M=1 L=45n W=520n
Mmn1 n0 A1 VSS VSS g45n1svt M=1 L=45n W=520n
Mmn0 n0 A0 VSS VSS g45n1svt M=1 L=45n W=520n
Mmp0 n1 A0 VDD VDD g45p1svt M=1 L=45n W=780n
Mmp2 Y B0 VDD VDD g45p1svt M=1 L=45n W=780n
Mmp1 Y A1 n1 VDD g45p1svt M=1 L=45n W=780n
.ENDS

.SUBCKT OAI21X1 A0 A1 B0 VDD VSS Y
Mmn2 Y B0 n0 VSS g45n1svt M=1 L=45n W=260n
Mmn1 n0 A1 VSS VSS g45n1svt M=1 L=45n W=260n
Mmn0 n0 A0 VSS VSS g45n1svt M=1 L=45n W=260n
Mmp0 n1 A0 VDD VDD g45p1svt M=1 L=45n W=390n
Mmp2 Y B0 VDD VDD g45p1svt M=1 L=45n W=390n
Mmp1 Y A1 n1 VDD g45p1svt M=1 L=45n W=390n
.ENDS

.SUBCKT OAI211XL A0 A1 B0 C0 VDD VSS Y
Mmn1 n0 A1 VSS VSS g45n1svt M=1 L=45n W=145n
Mmn0 n0 A0 VSS VSS g45n1svt M=1 L=45n W=145n
Mmn2 n1 B0 n0 VSS g45n1svt M=1 L=45n W=145n
Mmn3 Y C0 n1 VSS g45n1svt M=1 L=45n W=145n
Mmp1 Y A1 n2 VDD g45p1svt M=1 L=45n W=215n
Mmp0 n2 A0 VDD VDD g45p1svt M=1 L=45n W=215n
Mmp3 Y C0 VDD VDD g45p1svt M=1 L=45n W=215n
Mmp2 Y B0 VDD VDD g45p1svt M=1 L=45n W=215n
.ENDS

.SUBCKT OAI211X4 A0 A1 B0 C0 VDD VSS Y
Mmn1 n0 A1 VSS VSS g45n1svt M=1 L=45n W=1.04u
Mmn0 n0 A0 VSS VSS g45n1svt M=1 L=45n W=1.04u
Mmn2 n1 B0 n0 VSS g45n1svt M=1 L=45n W=1.04u
Mmn3 Y C0 n1 VSS g45n1svt M=1 L=45n W=1.04u
Mmp1 Y A1 n2 VDD g45p1svt M=1 L=45n W=1.56u
Mmp0 n2 A0 VDD VDD g45p1svt M=1 L=45n W=1.56u
Mmp3 Y C0 VDD VDD g45p1svt M=1 L=45n W=1.56u
Mmp2 Y B0 VDD VDD g45p1svt M=1 L=45n W=1.56u
.ENDS

.SUBCKT OAI211X2 A0 A1 B0 C0 VDD VSS Y
Mmn1 n0 A1 VSS VSS g45n1svt M=1 L=45n W=520n
Mmn0 n0 A0 VSS VSS g45n1svt M=1 L=45n W=520n
Mmn2 n1 B0 n0 VSS g45n1svt M=1 L=45n W=520n
Mmn3 Y C0 n1 VSS g45n1svt M=1 L=45n W=520n
Mmp1 Y A1 n2 VDD g45p1svt M=1 L=45n W=780n
Mmp0 n2 A0 VDD VDD g45p1svt M=1 L=45n W=780n
Mmp3 Y C0 VDD VDD g45p1svt M=1 L=45n W=780n
Mmp2 Y B0 VDD VDD g45p1svt M=1 L=45n W=780n
.ENDS

.SUBCKT OAI211X1 A0 A1 B0 C0 VDD VSS Y
Mmn1 n0 A1 VSS VSS g45n1svt M=1 L=45n W=260n
Mmn0 n0 A0 VSS VSS g45n1svt M=1 L=45n W=260n
Mmn2 n1 B0 n0 VSS g45n1svt M=1 L=45n W=260n
Mmn3 Y C0 n1 VSS g45n1svt M=1 L=45n W=260n
Mmp1 Y A1 n2 VDD g45p1svt M=1 L=45n W=390n
Mmp0 n2 A0 VDD VDD g45p1svt M=1 L=45n W=390n
Mmp3 Y C0 VDD VDD g45p1svt M=1 L=45n W=390n
Mmp2 Y B0 VDD VDD g45p1svt M=1 L=45n W=390n
.ENDS

.SUBCKT OA22XL A0 A1 B0 B1 VDD VSS Y
Mmn3 net128 B1 net124 VSS g45n1svt M=1 L=45n W=145n
Mmn2 net128 B0 net124 VSS g45n1svt M=1 L=45n W=145n
Mmn1 net124 A1 VSS VSS g45n1svt M=1 L=45n W=145n
Mmn0 net124 A0 VSS VSS g45n1svt M=1 L=45n W=145n
Mmn4 Y net128 VSS VSS g45n1svt M=1 L=45n W=145n
Mmp3 net128 B1 net115 VDD g45p1svt M=1 L=45n W=215n
Mmp2 net115 B0 VDD VDD g45p1svt M=1 L=45n W=215n
Mmp1 net128 A1 net119 VDD g45p1svt M=1 L=45n W=215n
Mmp0 net119 A0 VDD VDD g45p1svt M=1 L=45n W=215n
Mmp4 Y net128 VDD VDD g45p1svt M=1 L=45n W=215n
.ENDS

.SUBCKT OA22X4 A0 A1 B0 B1 VDD VSS Y
Mmn3 net128 B1 net124 VSS g45n1svt M=1 L=45n W=260n
Mmn2 net128 B0 net124 VSS g45n1svt M=1 L=45n W=260n
Mmn1 net124 A1 VSS VSS g45n1svt M=1 L=45n W=260n
Mmn0 net124 A0 VSS VSS g45n1svt M=1 L=45n W=260n
Mmn4 Y net128 VSS VSS g45n1svt M=1 L=45n W=1.04u
Mmp3 net128 B1 net115 VDD g45p1svt M=1 L=45n W=390n
Mmp2 net115 B0 VDD VDD g45p1svt M=1 L=45n W=390n
Mmp1 net128 A1 net119 VDD g45p1svt M=1 L=45n W=390n
Mmp0 net119 A0 VDD VDD g45p1svt M=1 L=45n W=390n
Mmp4 Y net128 VDD VDD g45p1svt M=1 L=45n W=1.56u
.ENDS

.SUBCKT OA22X2 A0 A1 B0 B1 VDD VSS Y
Mmn3 net128 B1 net124 VSS g45n1svt M=1 L=45n W=145n
Mmn2 net128 B0 net124 VSS g45n1svt M=1 L=45n W=145n
Mmn1 net124 A1 VSS VSS g45n1svt M=1 L=45n W=145n
Mmn0 net124 A0 VSS VSS g45n1svt M=1 L=45n W=145n
Mmn4 Y net128 VSS VSS g45n1svt M=1 L=45n W=520n
Mmp3 net128 B1 net115 VDD g45p1svt M=1 L=45n W=215n
Mmp2 net115 B0 VDD VDD g45p1svt M=1 L=45n W=215n
Mmp1 net128 A1 net119 VDD g45p1svt M=1 L=45n W=215n
Mmp0 net119 A0 VDD VDD g45p1svt M=1 L=45n W=215n
Mmp4 Y net128 VDD VDD g45p1svt M=1 L=45n W=780n
.ENDS

.SUBCKT OA22X1 A0 A1 B0 B1 VDD VSS Y
Mmn3 net128 B1 net124 VSS g45n1svt M=1 L=45n W=145n
Mmn2 net128 B0 net124 VSS g45n1svt M=1 L=45n W=145n
Mmn1 net124 A1 VSS VSS g45n1svt M=1 L=45n W=145n
Mmn0 net124 A0 VSS VSS g45n1svt M=1 L=45n W=145n
Mmn4 Y net128 VSS VSS g45n1svt M=1 L=45n W=260n
Mmp3 net128 B1 net115 VDD g45p1svt M=1 L=45n W=215n
Mmp2 net115 B0 VDD VDD g45p1svt M=1 L=45n W=215n
Mmp1 net128 A1 net119 VDD g45p1svt M=1 L=45n W=215n
Mmp0 net119 A0 VDD VDD g45p1svt M=1 L=45n W=215n
Mmp4 Y net128 VDD VDD g45p1svt M=1 L=45n W=390n
.ENDS

.SUBCKT OA21XL A0 A1 B0 VDD VSS Y
Mmn1 net107 A1 VSS VSS g45n1svt M=1 L=45n W=145n
Mmn0 net107 A0 VSS VSS g45n1svt M=1 L=45n W=145n
Mmn3 Y net95 VSS VSS g45n1svt M=1 L=45n W=145n
Mmn2 net95 B0 net107 VSS g45n1svt M=1 L=45n W=145n
Mmp1 net95 A1 net98 VDD g45p1svt M=1 L=45n W=215n
Mmp0 net98 A0 VDD VDD g45p1svt M=1 L=45n W=215n
Mmp3 Y net95 VDD VDD g45p1svt M=1 L=45n W=215n
Mmp2 net95 B0 VDD VDD g45p1svt M=1 L=45n W=215n
.ENDS

.SUBCKT OA21X4 A0 A1 B0 VDD VSS Y
Mmn1 net107 A1 VSS VSS g45n1svt M=1 L=45n W=260n
Mmn0 net107 A0 VSS VSS g45n1svt M=1 L=45n W=260n
Mmn3 Y net95 VSS VSS g45n1svt M=1 L=45n W=1.04u
Mmn2 net95 B0 net107 VSS g45n1svt M=1 L=45n W=260n
Mmp1 net95 A1 net98 VDD g45p1svt M=1 L=45n W=390n
Mmp0 net98 A0 VDD VDD g45p1svt M=1 L=45n W=390n
Mmp3 Y net95 VDD VDD g45p1svt M=1 L=45n W=1.56u
Mmp2 net95 B0 VDD VDD g45p1svt M=1 L=45n W=390n
.ENDS

.SUBCKT OA21X2 A0 A1 B0 VDD VSS Y
Mmn1 net107 A1 VSS VSS g45n1svt M=1 L=45n W=145n
Mmn0 net107 A0 VSS VSS g45n1svt M=1 L=45n W=145n
Mmn3 Y net95 VSS VSS g45n1svt M=1 L=45n W=520n
Mmn2 net95 B0 net107 VSS g45n1svt M=1 L=45n W=145n
Mmp1 net95 A1 net98 VDD g45p1svt M=1 L=45n W=215n
Mmp0 net98 A0 VDD VDD g45p1svt M=1 L=45n W=215n
Mmp3 Y net95 VDD VDD g45p1svt M=1 L=45n W=780n
Mmp2 net95 B0 VDD VDD g45p1svt M=1 L=45n W=215n
.ENDS

.SUBCKT OA21X1 A0 A1 B0 VDD VSS Y
Mmn1 net107 A1 VSS VSS g45n1svt M=1 L=45n W=145n
Mmn0 net107 A0 VSS VSS g45n1svt M=1 L=45n W=145n
Mmn3 Y net95 VSS VSS g45n1svt M=1 L=45n W=260n
Mmn2 net95 B0 net107 VSS g45n1svt M=1 L=45n W=145n
Mmp1 net95 A1 net98 VDD g45p1svt M=1 L=45n W=215n
Mmp0 net98 A0 VDD VDD g45p1svt M=1 L=45n W=215n
Mmp3 Y net95 VDD VDD g45p1svt M=1 L=45n W=390n
Mmp2 net95 B0 VDD VDD g45p1svt M=1 L=45n W=215n
.ENDS

.SUBCKT NOR4XL A B C D VDD VSS Y
Mmn2 Y C VSS VSS g45n1svt M=1 L=45n W=145n
Mmn3 Y D VSS VSS g45n1svt M=1 L=45n W=145n
Mmn0 Y A VSS VSS g45n1svt M=1 L=45n W=145n
Mmn1 Y B VSS VSS g45n1svt M=1 L=45n W=145n
Mmp1 n1 B n0 VDD g45p1svt M=1 L=45n W=215n
Mmp3 Y D n2 VDD g45p1svt M=1 L=45n W=215n
Mmp2 n2 C n1 VDD g45p1svt M=1 L=45n W=215n
Mmp0 n0 A VDD VDD g45p1svt M=1 L=45n W=215n
.ENDS

.SUBCKT NOR4X8 A B C D VDD VSS Y
Mmn2 Y C VSS VSS g45n1svt M=1 L=45n W=2.065u
Mmn3 Y D VSS VSS g45n1svt M=1 L=45n W=2.065u
Mmn0 Y A VSS VSS g45n1svt M=1 L=45n W=2.065u
Mmn1 Y B VSS VSS g45n1svt M=1 L=45n W=2.065u
Mmp1 n1 B n0 VDD g45p1svt M=1 L=45n W=3.115u
Mmp3 Y D n2 VDD g45p1svt M=1 L=45n W=3.115u
Mmp2 n2 C n1 VDD g45p1svt M=1 L=45n W=3.115u
Mmp0 n0 A VDD VDD g45p1svt M=1 L=45n W=3.115u
.ENDS

.SUBCKT NOR4X6 A B C D VDD VSS Y
Mmn2 Y C VSS VSS g45n1svt M=1 L=45n W=1.55u
Mmn3 Y D VSS VSS g45n1svt M=1 L=45n W=1.55u
Mmn0 Y A VSS VSS g45n1svt M=1 L=45n W=1.55u
Mmn1 Y B VSS VSS g45n1svt M=1 L=45n W=1.55u
Mmp1 n1 B n0 VDD g45p1svt M=1 L=45n W=2.35u
Mmp3 Y D n2 VDD g45p1svt M=1 L=45n W=2.35u
Mmp2 n2 C n1 VDD g45p1svt M=1 L=45n W=2.35u
Mmp0 n0 A VDD VDD g45p1svt M=1 L=45n W=2.35u
.ENDS

.SUBCKT NOR4X4 A B C D VDD VSS Y
Mmn2 Y C VSS VSS g45n1svt M=1 L=45n W=1.04u
Mmn3 Y D VSS VSS g45n1svt M=1 L=45n W=1.04u
Mmn0 Y A VSS VSS g45n1svt M=1 L=45n W=1.04u
Mmn1 Y B VSS VSS g45n1svt M=1 L=45n W=1.04u
Mmp1 n1 B n0 VDD g45p1svt M=1 L=45n W=1.56u
Mmp3 Y D n2 VDD g45p1svt M=1 L=45n W=1.56u
Mmp2 n2 C n1 VDD g45p1svt M=1 L=45n W=1.56u
Mmp0 n0 A VDD VDD g45p1svt M=1 L=45n W=1.56u
.ENDS

.SUBCKT NOR4X2 A B C D VDD VSS Y
Mmn2 Y C VSS VSS g45n1svt M=1 L=45n W=520n
Mmn3 Y D VSS VSS g45n1svt M=1 L=45n W=520n
Mmn0 Y A VSS VSS g45n1svt M=1 L=45n W=520n
Mmn1 Y B VSS VSS g45n1svt M=1 L=45n W=520n
Mmp1 n1 B n0 VDD g45p1svt M=1 L=45n W=780n
Mmp3 Y D n2 VDD g45p1svt M=1 L=45n W=780n
Mmp2 n2 C n1 VDD g45p1svt M=1 L=45n W=780n
Mmp0 n0 A VDD VDD g45p1svt M=1 L=45n W=780n
.ENDS

.SUBCKT NOR4X1 A B C D VDD VSS Y
Mmn2 Y C VSS VSS g45n1svt M=1 L=45n W=260n
Mmn3 Y D VSS VSS g45n1svt M=1 L=45n W=260n
Mmn0 Y A VSS VSS g45n1svt M=1 L=45n W=260n
Mmn1 Y B VSS VSS g45n1svt M=1 L=45n W=260n
Mmp1 n1 B n0 VDD g45p1svt M=1 L=45n W=390n
Mmp3 Y D n2 VDD g45p1svt M=1 L=45n W=390n
Mmp2 n2 C n1 VDD g45p1svt M=1 L=45n W=390n
Mmp0 n0 A VDD VDD g45p1svt M=1 L=45n W=390n
.ENDS

.SUBCKT NOR4BXL AN B C D VDD VSS Y
Mmn4 Y D VSS VSS g45n1svt M=1 L=45n W=145n
Mmn1 Y n0 VSS VSS g45n1svt M=1 L=45n W=145n
Mmn3 Y C VSS VSS g45n1svt M=1 L=45n W=145n
Mmn0 n0 AN VSS VSS g45n1svt M=1 L=45n W=145n
Mmn2 Y B VSS VSS g45n1svt M=1 L=45n W=145n
Mmp4 Y D n3 VDD g45p1svt M=1 L=45n W=215n
Mmp0 n0 AN VDD VDD g45p1svt M=1 L=45n W=215n
Mmp3 n3 C n2 VDD g45p1svt M=1 L=45n W=215n
Mmp2 n2 B n1 VDD g45p1svt M=1 L=45n W=215n
Mmp1 n1 n0 VDD VDD g45p1svt M=1 L=45n W=215n
.ENDS

.SUBCKT NOR4BX4 AN B C D VDD VSS Y
Mmn4 Y D VSS VSS g45n1svt M=1 L=45n W=1.04u
Mmn1 Y n0 VSS VSS g45n1svt M=1 L=45n W=1.04u
Mmn3 Y C VSS VSS g45n1svt M=1 L=45n W=1.04u
Mmn0 n0 AN VSS VSS g45n1svt M=1 L=45n W=260n
Mmn2 Y B VSS VSS g45n1svt M=1 L=45n W=1.04u
Mmp4 Y D n3 VDD g45p1svt M=1 L=45n W=1.56u
Mmp0 n0 AN VDD VDD g45p1svt M=1 L=45n W=390n
Mmp3 n3 C n2 VDD g45p1svt M=1 L=45n W=1.56u
Mmp2 n2 B n1 VDD g45p1svt M=1 L=45n W=1.56u
Mmp1 n1 n0 VDD VDD g45p1svt M=1 L=45n W=1.56u
.ENDS

.SUBCKT NOR4BX2 AN B C D VDD VSS Y
Mmn4 Y D VSS VSS g45n1svt M=1 L=45n W=520n
Mmn1 Y n0 VSS VSS g45n1svt M=1 L=45n W=520n
Mmn3 Y C VSS VSS g45n1svt M=1 L=45n W=520n
Mmn0 n0 AN VSS VSS g45n1svt M=1 L=45n W=145n
Mmn2 Y B VSS VSS g45n1svt M=1 L=45n W=520n
Mmp4 Y D n3 VDD g45p1svt M=1 L=45n W=780n
Mmp0 n0 AN VDD VDD g45p1svt M=1 L=45n W=215n
Mmp3 n3 C n2 VDD g45p1svt M=1 L=45n W=780n
Mmp2 n2 B n1 VDD g45p1svt M=1 L=45n W=780n
Mmp1 n1 n0 VDD VDD g45p1svt M=1 L=45n W=780n
.ENDS

.SUBCKT NOR4BX1 AN B C D VDD VSS Y
Mmn4 Y D VSS VSS g45n1svt M=1 L=45n W=260n
Mmn1 Y n0 VSS VSS g45n1svt M=1 L=45n W=260n
Mmn3 Y C VSS VSS g45n1svt M=1 L=45n W=260n
Mmn0 n0 AN VSS VSS g45n1svt M=1 L=45n W=145n
Mmn2 Y B VSS VSS g45n1svt M=1 L=45n W=260n
Mmp4 Y D n3 VDD g45p1svt M=1 L=45n W=390n
Mmp0 n0 AN VDD VDD g45p1svt M=1 L=45n W=215n
Mmp3 n3 C n2 VDD g45p1svt M=1 L=45n W=390n
Mmp2 n2 B n1 VDD g45p1svt M=1 L=45n W=390n
Mmp1 n1 n0 VDD VDD g45p1svt M=1 L=45n W=390n
.ENDS

.SUBCKT NOR4BBXL AN BN C D VDD VSS Y
Mmn2 Y n0 VSS VSS g45n1svt M=1 L=45n W=145n
Mmn1 n1 BN VSS VSS g45n1svt M=1 L=45n W=145n
Mmn3 Y n1 VSS VSS g45n1svt M=1 L=45n W=145n
Mmn5 Y D VSS VSS g45n1svt M=1 L=45n W=145n
Mmn4 Y C VSS VSS g45n1svt M=1 L=45n W=145n
Mmn0 n0 AN VSS VSS g45n1svt M=1 L=45n W=145n
Mmp0 n0 AN VDD VDD g45p1svt M=1 L=45n W=215n
Mmp5 Y D n4 VDD g45p1svt M=1 L=45n W=215n
Mmp4 n4 C n3 VDD g45p1svt M=1 L=45n W=215n
Mmp1 n1 BN VDD VDD g45p1svt M=1 L=45n W=215n
Mmp3 n3 n1 n2 VDD g45p1svt M=1 L=45n W=215n
Mmp2 n2 n0 VDD VDD g45p1svt M=1 L=45n W=215n
.ENDS

.SUBCKT NOR4BBX4 AN BN C D VDD VSS Y
Mmn2 Y n0 VSS VSS g45n1svt M=1 L=45n W=1.04u
Mmn1 n1 BN VSS VSS g45n1svt M=1 L=45n W=260n
Mmn3 Y n1 VSS VSS g45n1svt M=1 L=45n W=1.04u
Mmn5 Y D VSS VSS g45n1svt M=1 L=45n W=1.04u
Mmn4 Y C VSS VSS g45n1svt M=1 L=45n W=1.04u
Mmn0 n0 AN VSS VSS g45n1svt M=1 L=45n W=260n
Mmp0 n0 AN VDD VDD g45p1svt M=1 L=45n W=390n
Mmp5 Y D n4 VDD g45p1svt M=1 L=45n W=1.56u
Mmp4 n4 C n3 VDD g45p1svt M=1 L=45n W=1.56u
Mmp1 n1 BN VDD VDD g45p1svt M=1 L=45n W=390n
Mmp3 n3 n1 n2 VDD g45p1svt M=1 L=45n W=1.56u
Mmp2 n2 n0 VDD VDD g45p1svt M=1 L=45n W=1.56u
.ENDS

.SUBCKT NOR4BBX2 AN BN C D VDD VSS Y
Mmn2 Y n0 VSS VSS g45n1svt M=1 L=45n W=520n
Mmn1 n1 BN VSS VSS g45n1svt M=1 L=45n W=145n
Mmn3 Y n1 VSS VSS g45n1svt M=1 L=45n W=520n
Mmn5 Y D VSS VSS g45n1svt M=1 L=45n W=520n
Mmn4 Y C VSS VSS g45n1svt M=1 L=45n W=520n
Mmn0 n0 AN VSS VSS g45n1svt M=1 L=45n W=145n
Mmp0 n0 AN VDD VDD g45p1svt M=1 L=45n W=215n
Mmp5 Y D n4 VDD g45p1svt M=1 L=45n W=780n
Mmp4 n4 C n3 VDD g45p1svt M=1 L=45n W=780n
Mmp1 n1 BN VDD VDD g45p1svt M=1 L=45n W=215n
Mmp3 n3 n1 n2 VDD g45p1svt M=1 L=45n W=780n
Mmp2 n2 n0 VDD VDD g45p1svt M=1 L=45n W=780n
.ENDS

.SUBCKT NOR4BBX1 AN BN C D VDD VSS Y
Mmn2 Y n0 VSS VSS g45n1svt M=1 L=45n W=260n
Mmn1 n1 BN VSS VSS g45n1svt M=1 L=45n W=145n
Mmn3 Y n1 VSS VSS g45n1svt M=1 L=45n W=260n
Mmn5 Y D VSS VSS g45n1svt M=1 L=45n W=260n
Mmn4 Y C VSS VSS g45n1svt M=1 L=45n W=260n
Mmn0 n0 AN VSS VSS g45n1svt M=1 L=45n W=145n
Mmp0 n0 AN VDD VDD g45p1svt M=1 L=45n W=215n
Mmp5 Y D n4 VDD g45p1svt M=1 L=45n W=390n
Mmp4 n4 C n3 VDD g45p1svt M=1 L=45n W=390n
Mmp1 n1 BN VDD VDD g45p1svt M=1 L=45n W=215n
Mmp3 n3 n1 n2 VDD g45p1svt M=1 L=45n W=390n
Mmp2 n2 n0 VDD VDD g45p1svt M=1 L=45n W=390n
.ENDS

.SUBCKT NOR3XL A B C VDD VSS Y
Mmn0 Y A VSS VSS g45n1svt M=1 L=45n W=145n
Mmn1 Y B VSS VSS g45n1svt M=1 L=45n W=145n
Mmn2 Y C VSS VSS g45n1svt M=1 L=45n W=145n
Mmp1 n1 B n0 VDD g45p1svt M=1 L=45n W=215n
Mmp2 Y C n1 VDD g45p1svt M=1 L=45n W=215n
Mmp0 n0 A VDD VDD g45p1svt M=1 L=45n W=215n
.ENDS

.SUBCKT NOR3X8 A B C VDD VSS Y
Mmn0 Y A VSS VSS g45n1svt M=1 L=45n W=2.065u
Mmn1 Y B VSS VSS g45n1svt M=1 L=45n W=2.065u
Mmn2 Y C VSS VSS g45n1svt M=1 L=45n W=2.065u
Mmp1 n1 B n0 VDD g45p1svt M=1 L=45n W=3.115u
Mmp2 Y C n1 VDD g45p1svt M=1 L=45n W=3.115u
Mmp0 n0 A VDD VDD g45p1svt M=1 L=45n W=3.115u
.ENDS

.SUBCKT NOR3X6 A B C VDD VSS Y
Mmn0 Y A VSS VSS g45n1svt M=1 L=45n W=1.55u
Mmn1 Y B VSS VSS g45n1svt M=1 L=45n W=1.55u
Mmn2 Y C VSS VSS g45n1svt M=1 L=45n W=1.55u
Mmp1 n1 B n0 VDD g45p1svt M=1 L=45n W=2.34u
Mmp2 Y C n1 VDD g45p1svt M=1 L=45n W=2.34u
Mmp0 n0 A VDD VDD g45p1svt M=1 L=45n W=2.34u
.ENDS

.SUBCKT NOR3X4 A B C VDD VSS Y
Mmn0 Y A VSS VSS g45n1svt M=1 L=45n W=1.04u
Mmn1 Y B VSS VSS g45n1svt M=1 L=45n W=1.04u
Mmn2 Y C VSS VSS g45n1svt M=1 L=45n W=1.04u
Mmp1 n1 B n0 VDD g45p1svt M=1 L=45n W=1.56u
Mmp2 Y C n1 VDD g45p1svt M=1 L=45n W=1.56u
Mmp0 n0 A VDD VDD g45p1svt M=1 L=45n W=1.56u
.ENDS

.SUBCKT NOR3X2 A B C VDD VSS Y
Mmn0 Y A VSS VSS g45n1svt M=1 L=45n W=520n
Mmn1 Y B VSS VSS g45n1svt M=1 L=45n W=520n
Mmn2 Y C VSS VSS g45n1svt M=1 L=45n W=520n
Mmp1 n1 B n0 VDD g45p1svt M=1 L=45n W=780n
Mmp2 Y C n1 VDD g45p1svt M=1 L=45n W=780n
Mmp0 n0 A VDD VDD g45p1svt M=1 L=45n W=780n
.ENDS

.SUBCKT NOR3X1 A B C VDD VSS Y
Mmn0 Y A VSS VSS g45n1svt M=1 L=45n W=260n
Mmn1 Y B VSS VSS g45n1svt M=1 L=45n W=260n
Mmn2 Y C VSS VSS g45n1svt M=1 L=45n W=260n
Mmp1 n1 B n0 VDD g45p1svt M=1 L=45n W=390n
Mmp2 Y C n1 VDD g45p1svt M=1 L=45n W=390n
Mmp0 n0 A VDD VDD g45p1svt M=1 L=45n W=390n
.ENDS

.SUBCKT NOR3BXL AN B C VDD VSS Y
Mmn1 Y net91 VSS VSS g45n1svt M=1 L=45n W=145n
Mmn3 Y C VSS VSS g45n1svt M=1 L=45n W=145n
Mmn0 net91 AN VSS VSS g45n1svt M=1 L=45n W=145n
Mmn2 Y B VSS VSS g45n1svt M=1 L=45n W=145n
Mmp3 Y C net90 VDD g45p1svt M=1 L=45n W=215n
Mmp0 net91 AN VDD VDD g45p1svt M=1 L=45n W=215n
Mmp1 net86 net91 VDD VDD g45p1svt M=1 L=45n W=215n
Mmp2 net90 B net86 VDD g45p1svt M=1 L=45n W=215n
.ENDS

.SUBCKT NOR3BX4 AN B C VDD VSS Y
Mmn1 Y net91 VSS VSS g45n1svt M=1 L=45n W=1.04u
Mmn3 Y C VSS VSS g45n1svt M=1 L=45n W=1.04u
Mmn0 net91 AN VSS VSS g45n1svt M=1 L=45n W=260n
Mmn2 Y B VSS VSS g45n1svt M=1 L=45n W=1.04u
Mmp3 Y C net90 VDD g45p1svt M=1 L=45n W=1.56u
Mmp0 net91 AN VDD VDD g45p1svt M=1 L=45n W=390n
Mmp1 net86 net91 VDD VDD g45p1svt M=1 L=45n W=1.56u
Mmp2 net90 B net86 VDD g45p1svt M=1 L=45n W=1.56u
.ENDS

.SUBCKT NOR3BX2 AN B C VDD VSS Y
Mmn1 Y net91 VSS VSS g45n1svt M=1 L=45n W=520n
Mmn3 Y C VSS VSS g45n1svt M=1 L=45n W=520n
Mmn0 net91 AN VSS VSS g45n1svt M=1 L=45n W=145n
Mmn2 Y B VSS VSS g45n1svt M=1 L=45n W=520n
Mmp3 Y C net90 VDD g45p1svt M=1 L=45n W=780n
Mmp0 net91 AN VDD VDD g45p1svt M=1 L=45n W=215n
Mmp1 net86 net91 VDD VDD g45p1svt M=1 L=45n W=780n
Mmp2 net90 B net86 VDD g45p1svt M=1 L=45n W=780n
.ENDS

.SUBCKT NOR3BX1 AN B C VDD VSS Y
Mmn1 Y net91 VSS VSS g45n1svt M=1 L=45n W=260n
Mmn3 Y C VSS VSS g45n1svt M=1 L=45n W=260n
Mmn0 net91 AN VSS VSS g45n1svt M=1 L=45n W=145n
Mmn2 Y B VSS VSS g45n1svt M=1 L=45n W=260n
Mmp3 Y C net90 VDD g45p1svt M=1 L=45n W=390n
Mmp0 net91 AN VDD VDD g45p1svt M=1 L=45n W=215n
Mmp1 net86 net91 VDD VDD g45p1svt M=1 L=45n W=390n
Mmp2 net90 B net86 VDD g45p1svt M=1 L=45n W=390n
.ENDS

.SUBCKT NOR2XL A B VDD VSS Y
Mmn1 Y B VSS VSS g45n1svt M=1 L=45n W=145n
Mmn0 Y A VSS VSS g45n1svt M=1 L=45n W=145n
Mmp1 Y B net41 VDD g45p1svt M=1 L=45n W=215n
Mmp0 net41 A VDD VDD g45p1svt M=1 L=45n W=215n
.ENDS

.SUBCKT NOR2X8 A B VDD VSS Y
Mmn1 Y B VSS VSS g45n1svt M=1 L=45n W=2.065u
Mmn0 Y A VSS VSS g45n1svt M=1 L=45n W=2.065u
Mmp1 Y B net41 VDD g45p1svt M=1 L=45n W=3.115u
Mmp0 net41 A VDD VDD g45p1svt M=1 L=45n W=3.115u
.ENDS

.SUBCKT NOR2X6 A B VDD VSS Y
Mmn1 Y B VSS VSS g45n1svt M=1 L=45n W=1.55u
Mmn0 Y A VSS VSS g45n1svt M=1 L=45n W=1.55u
Mmp1 Y B net41 VDD g45p1svt M=1 L=45n W=2.34u
Mmp0 net41 A VDD VDD g45p1svt M=1 L=45n W=2.34u
.ENDS

.SUBCKT NOR2X4 A B VDD VSS Y
Mmn1 Y B VSS VSS g45n1svt M=1 L=45n W=1.04u
Mmn0 Y A VSS VSS g45n1svt M=1 L=45n W=1.04u
Mmp1 Y B net41 VDD g45p1svt M=1 L=45n W=1.56u
Mmp0 net41 A VDD VDD g45p1svt M=1 L=45n W=1.56u
.ENDS

.SUBCKT NOR2X2 A B VDD VSS Y
Mmn1 Y B VSS VSS g45n1svt M=1 L=45n W=520n
Mmn0 Y A VSS VSS g45n1svt M=1 L=45n W=520n
Mmp1 Y B net41 VDD g45p1svt M=1 L=45n W=780n
Mmp0 net41 A VDD VDD g45p1svt M=1 L=45n W=780n
.ENDS

.SUBCKT NOR2BXL AN B VDD VSS Y
Mmn1 Y net76 VSS VSS g45n1svt M=1 L=45n W=145n
Mmn2 Y B VSS VSS g45n1svt M=1 L=45n W=145n
Mmn0 net76 AN VSS VSS g45n1svt M=1 L=45n W=145n
Mmp2 Y B net59 VDD g45p1svt M=1 L=45n W=215n
Mmp1 net59 net76 VDD VDD g45p1svt M=1 L=45n W=215n
Mmp0 net76 AN VDD VDD g45p1svt M=1 L=45n W=215n
.ENDS

.SUBCKT NOR2BX4 AN B VDD VSS Y
Mmn1 Y net76 VSS VSS g45n1svt M=1 L=45n W=1.04u
Mmn2 Y B VSS VSS g45n1svt M=1 L=45n W=1.04u
Mmn0 net76 AN VSS VSS g45n1svt M=1 L=45n W=145n
Mmp2 Y B net59 VDD g45p1svt M=1 L=45n W=1.56u
Mmp1 net59 net76 VDD VDD g45p1svt M=1 L=45n W=1.56u
Mmp0 net76 AN VDD VDD g45p1svt M=1 L=45n W=215n
.ENDS

.SUBCKT NOR2BX2 AN B VDD VSS Y
Mmn1 Y net76 VSS VSS g45n1svt M=1 L=45n W=520n
Mmn2 Y B VSS VSS g45n1svt M=1 L=45n W=520n
Mmn0 net76 AN VSS VSS g45n1svt M=1 L=45n W=145n
Mmp2 Y B net59 VDD g45p1svt M=1 L=45n W=780n
Mmp1 net59 net76 VDD VDD g45p1svt M=1 L=45n W=780n
Mmp0 net76 AN VDD VDD g45p1svt M=1 L=45n W=215n
.ENDS

.SUBCKT NOR2BX1 AN B VDD VSS Y
Mmn1 Y net76 VSS VSS g45n1svt M=1 L=45n W=260n
Mmn2 Y B VSS VSS g45n1svt M=1 L=45n W=260n
Mmn0 net76 AN VSS VSS g45n1svt M=1 L=45n W=145n
Mmp2 Y B net59 VDD g45p1svt M=1 L=45n W=390n
Mmp1 net59 net76 VDD VDD g45p1svt M=1 L=45n W=390n
Mmp0 net76 AN VDD VDD g45p1svt M=1 L=45n W=215n
.ENDS

.SUBCKT NAND4XL A B C D VDD VSS Y
Mmn1 n1 B n2 VSS g45n1svt M=1 L=45n W=145n
Mmn3 Y D n0 VSS g45n1svt M=1 L=45n W=145n
Mmn2 n0 C n1 VSS g45n1svt M=1 L=45n W=145n
Mmn0 n2 A VSS VSS g45n1svt M=1 L=45n W=145n
Mmp3 Y D VDD VDD g45p1svt M=1 L=45n W=215n
Mmp2 Y C VDD VDD g45p1svt M=1 L=45n W=215n
Mmp1 Y B VDD VDD g45p1svt M=1 L=45n W=215n
Mmp0 Y A VDD VDD g45p1svt M=1 L=45n W=215n
.ENDS

.SUBCKT NAND4X8 A B C D VDD VSS Y
Mmn1 n1 B n2 VSS g45n1svt M=1 L=45n W=2.065u
Mmn3 Y D n0 VSS g45n1svt M=1 L=45n W=2.065u
Mmn2 n0 C n1 VSS g45n1svt M=1 L=45n W=2.065u
Mmn0 n2 A VSS VSS g45n1svt M=1 L=45n W=2.065u
Mmp3 Y D VDD VDD g45p1svt M=1 L=45n W=3.115u
Mmp2 Y C VDD VDD g45p1svt M=1 L=45n W=3.115u
Mmp1 Y B VDD VDD g45p1svt M=1 L=45n W=3.115u
Mmp0 Y A VDD VDD g45p1svt M=1 L=45n W=3.115u
.ENDS

.SUBCKT NAND4X6 A B C D VDD VSS Y
Mmn1 n1 B n2 VSS g45n1svt M=1 L=45n W=1.55u
Mmn3 Y D n0 VSS g45n1svt M=1 L=45n W=1.55u
Mmn2 n0 C n1 VSS g45n1svt M=1 L=45n W=1.55u
Mmn0 n2 A VSS VSS g45n1svt M=1 L=45n W=1.55u
Mmp3 Y D VDD VDD g45p1svt M=1 L=45n W=2.35u
Mmp2 Y C VDD VDD g45p1svt M=1 L=45n W=2.35u
Mmp1 Y B VDD VDD g45p1svt M=1 L=45n W=2.35u
Mmp0 Y A VDD VDD g45p1svt M=1 L=45n W=2.35u
.ENDS

.SUBCKT NAND4X4 A B C D VDD VSS Y
Mmn1 n1 B n2 VSS g45n1svt M=1 L=45n W=1.04u
Mmn3 Y D n0 VSS g45n1svt M=1 L=45n W=1.04u
Mmn2 n0 C n1 VSS g45n1svt M=1 L=45n W=1.04u
Mmn0 n2 A VSS VSS g45n1svt M=1 L=45n W=1.04u
Mmp3 Y D VDD VDD g45p1svt M=1 L=45n W=1.56u
Mmp2 Y C VDD VDD g45p1svt M=1 L=45n W=1.56u
Mmp1 Y B VDD VDD g45p1svt M=1 L=45n W=1.56u
Mmp0 Y A VDD VDD g45p1svt M=1 L=45n W=1.56u
.ENDS

.SUBCKT NAND4X2 A B C D VDD VSS Y
Mmn1 n1 B n2 VSS g45n1svt M=1 L=45n W=520n
Mmn3 Y D n0 VSS g45n1svt M=1 L=45n W=520n
Mmn2 n0 C n1 VSS g45n1svt M=1 L=45n W=520n
Mmn0 n2 A VSS VSS g45n1svt M=1 L=45n W=520n
Mmp3 Y D VDD VDD g45p1svt M=1 L=45n W=780n
Mmp2 Y C VDD VDD g45p1svt M=1 L=45n W=780n
Mmp1 Y B VDD VDD g45p1svt M=1 L=45n W=780n
Mmp0 Y A VDD VDD g45p1svt M=1 L=45n W=780n
.ENDS

.SUBCKT NAND4X1 A B C D VDD VSS Y
Mmn1 n1 B n2 VSS g45n1svt M=1 L=45n W=260n
Mmn3 Y D n0 VSS g45n1svt M=1 L=45n W=260n
Mmn2 n0 C n1 VSS g45n1svt M=1 L=45n W=260n
Mmn0 n2 A VSS VSS g45n1svt M=1 L=45n W=260n
Mmp3 Y D VDD VDD g45p1svt M=1 L=45n W=390n
Mmp2 Y C VDD VDD g45p1svt M=1 L=45n W=390n
Mmp1 Y B VDD VDD g45p1svt M=1 L=45n W=390n
Mmp0 Y A VDD VDD g45p1svt M=1 L=45n W=390n
.ENDS

.SUBCKT NAND4BXL AN B C D VDD VSS Y
Mmn4 Y D net130 VSS g45n1svt M=1 L=45n W=145n
Mmn2 net126 B net122 VSS g45n1svt M=1 L=45n W=145n
Mmn1 net122 net118 VSS VSS g45n1svt M=1 L=45n W=145n
Mmn0 net118 AN VSS VSS g45n1svt M=1 L=45n W=145n
Mmn3 net130 C net126 VSS g45n1svt M=1 L=45n W=145n
Mmp4 Y D VDD VDD g45p1svt M=1 L=45n W=215n
Mmp1 Y net118 VDD VDD g45p1svt M=1 L=45n W=215n
Mmp2 Y B VDD VDD g45p1svt M=1 L=45n W=215n
Mmp0 net118 AN VDD VDD g45p1svt M=1 L=45n W=215n
Mmp3 Y C VDD VDD g45p1svt M=1 L=45n W=215n
.ENDS

.SUBCKT NAND4BX4 AN B C D VDD VSS Y
Mmn4 Y D net130 VSS g45n1svt M=1 L=45n W=1.04u
Mmn2 net126 B net122 VSS g45n1svt M=1 L=45n W=1.04u
Mmn1 net122 net118 VSS VSS g45n1svt M=1 L=45n W=1.04u
Mmn0 net118 AN VSS VSS g45n1svt M=1 L=45n W=260n
Mmn3 net130 C net126 VSS g45n1svt M=1 L=45n W=1.04u
Mmp4 Y D VDD VDD g45p1svt M=1 L=45n W=1.56u
Mmp1 Y net118 VDD VDD g45p1svt M=1 L=45n W=1.56u
Mmp2 Y B VDD VDD g45p1svt M=1 L=45n W=1.56u
Mmp0 net118 AN VDD VDD g45p1svt M=1 L=45n W=390n
Mmp3 Y C VDD VDD g45p1svt M=1 L=45n W=1.56u
.ENDS

.SUBCKT NAND4BX2 AN B C D VDD VSS Y
Mmn4 Y D net130 VSS g45n1svt M=1 L=45n W=520n
Mmn2 net126 B net122 VSS g45n1svt M=1 L=45n W=520n
Mmn1 net122 net118 VSS VSS g45n1svt M=1 L=45n W=520n
Mmn0 net118 AN VSS VSS g45n1svt M=1 L=45n W=145n
Mmn3 net130 C net126 VSS g45n1svt M=1 L=45n W=520n
Mmp4 Y D VDD VDD g45p1svt M=1 L=45n W=780n
Mmp1 Y net118 VDD VDD g45p1svt M=1 L=45n W=780n
Mmp2 Y B VDD VDD g45p1svt M=1 L=45n W=780n
Mmp0 net118 AN VDD VDD g45p1svt M=1 L=45n W=215n
Mmp3 Y C VDD VDD g45p1svt M=1 L=45n W=780n
.ENDS

.SUBCKT NAND4BX1 AN B C D VDD VSS Y
Mmn4 Y D net130 VSS g45n1svt M=1 L=45n W=260n
Mmn2 net126 B net122 VSS g45n1svt M=1 L=45n W=260n
Mmn1 net122 net118 VSS VSS g45n1svt M=1 L=45n W=260n
Mmn0 net118 AN VSS VSS g45n1svt M=1 L=45n W=145n
Mmn3 net130 C net126 VSS g45n1svt M=1 L=45n W=260n
Mmp4 Y D VDD VDD g45p1svt M=1 L=45n W=390n
Mmp1 Y net118 VDD VDD g45p1svt M=1 L=45n W=390n
Mmp2 Y B VDD VDD g45p1svt M=1 L=45n W=390n
Mmp0 net118 AN VDD VDD g45p1svt M=1 L=45n W=215n
Mmp3 Y C VDD VDD g45p1svt M=1 L=45n W=390n
.ENDS

.SUBCKT NAND4BBXL AN BN C D VDD VSS Y
Mmn1 n1 BN VSS VSS g45n1svt M=1 L=45n W=145n
Mmn2 n4 n0 VSS VSS g45n1svt M=1 L=45n W=145n
Mmn4 n2 C n3 VSS g45n1svt M=1 L=45n W=145n
Mmn5 Y D n2 VSS g45n1svt M=1 L=45n W=145n
Mmn0 n0 AN VSS VSS g45n1svt M=1 L=45n W=145n
Mmn3 n3 n1 n4 VSS g45n1svt M=1 L=45n W=145n
Mmp2 Y n0 VDD VDD g45p1svt M=1 L=45n W=215n
Mmp0 n0 AN VDD VDD g45p1svt M=1 L=45n W=215n
Mmp5 Y D VDD VDD g45p1svt M=1 L=45n W=215n
Mmp4 Y C VDD VDD g45p1svt M=1 L=45n W=215n
Mmp1 n1 BN VDD VDD g45p1svt M=1 L=45n W=215n
Mmp3 Y n1 VDD VDD g45p1svt M=1 L=45n W=215n
.ENDS

.SUBCKT NAND4BBX4 AN BN C D VDD VSS Y
Mmn1 n1 BN VSS VSS g45n1svt M=1 L=45n W=260n
Mmn2 n4 n0 VSS VSS g45n1svt M=1 L=45n W=1.04u
Mmn4 n2 C n3 VSS g45n1svt M=1 L=45n W=1.04u
Mmn5 Y D n2 VSS g45n1svt M=1 L=45n W=1.04u
Mmn0 n0 AN VSS VSS g45n1svt M=1 L=45n W=260n
Mmn3 n3 n1 n4 VSS g45n1svt M=1 L=45n W=1.04u
Mmp2 Y n0 VDD VDD g45p1svt M=1 L=45n W=1.56u
Mmp0 n0 AN VDD VDD g45p1svt M=1 L=45n W=390n
Mmp5 Y D VDD VDD g45p1svt M=1 L=45n W=1.56u
Mmp4 Y C VDD VDD g45p1svt M=1 L=45n W=1.56u
Mmp1 n1 BN VDD VDD g45p1svt M=1 L=45n W=390n
Mmp3 Y n1 VDD VDD g45p1svt M=1 L=45n W=1.56u
.ENDS

.SUBCKT NAND4BBX2 AN BN C D VDD VSS Y
Mmn1 n1 BN VSS VSS g45n1svt M=1 L=45n W=145n
Mmn2 n4 n0 VSS VSS g45n1svt M=1 L=45n W=520n
Mmn4 n2 C n3 VSS g45n1svt M=1 L=45n W=520n
Mmn5 Y D n2 VSS g45n1svt M=1 L=45n W=520n
Mmn0 n0 AN VSS VSS g45n1svt M=1 L=45n W=145n
Mmn3 n3 n1 n4 VSS g45n1svt M=1 L=45n W=520n
Mmp2 Y n0 VDD VDD g45p1svt M=1 L=45n W=780n
Mmp0 n0 AN VDD VDD g45p1svt M=1 L=45n W=215n
Mmp5 Y D VDD VDD g45p1svt M=1 L=45n W=780n
Mmp4 Y C VDD VDD g45p1svt M=1 L=45n W=780n
Mmp1 n1 BN VDD VDD g45p1svt M=1 L=45n W=215n
Mmp3 Y n1 VDD VDD g45p1svt M=1 L=45n W=780n
.ENDS

.SUBCKT NAND4BBX1 AN BN C D VDD VSS Y
Mmn1 n1 BN VSS VSS g45n1svt M=1 L=45n W=145n
Mmn2 n4 n0 VSS VSS g45n1svt M=1 L=45n W=260n
Mmn4 n2 C n3 VSS g45n1svt M=1 L=45n W=260n
Mmn5 Y D n2 VSS g45n1svt M=1 L=45n W=260n
Mmn0 n0 AN VSS VSS g45n1svt M=1 L=45n W=145n
Mmn3 n3 n1 n4 VSS g45n1svt M=1 L=45n W=260n
Mmp2 Y n0 VDD VDD g45p1svt M=1 L=45n W=390n
Mmp0 n0 AN VDD VDD g45p1svt M=1 L=45n W=215n
Mmp5 Y D VDD VDD g45p1svt M=1 L=45n W=390n
Mmp4 Y C VDD VDD g45p1svt M=1 L=45n W=390n
Mmp1 n1 BN VDD VDD g45p1svt M=1 L=45n W=215n
Mmp3 Y n1 VDD VDD g45p1svt M=1 L=45n W=390n
.ENDS

.SUBCKT NAND3XL A B C VDD VSS Y
Mmn1 n0 B n1 VSS g45n1svt M=1 L=45n W=145n
Mmn2 Y C n0 VSS g45n1svt M=1 L=45n W=145n
Mmn0 n1 A VSS VSS g45n1svt M=1 L=45n W=145n
Mmp0 Y A VDD VDD g45p1svt M=1 L=45n W=215n
Mmp1 Y B VDD VDD g45p1svt M=1 L=45n W=215n
Mmp2 Y C VDD VDD g45p1svt M=1 L=45n W=215n
.ENDS

.SUBCKT NAND3X8 A B C VDD VSS Y
Mmn1 n0 B n1 VSS g45n1svt M=1 L=45n W=2.065u
Mmn2 Y C n0 VSS g45n1svt M=1 L=45n W=2.065u
Mmn0 n1 A VSS VSS g45n1svt M=1 L=45n W=2.065u
Mmp0 Y A VDD VDD g45p1svt M=1 L=45n W=3.115u
Mmp1 Y B VDD VDD g45p1svt M=1 L=45n W=3.115u
Mmp2 Y C VDD VDD g45p1svt M=1 L=45n W=3.115u
.ENDS

.SUBCKT NAND3X6 A B C VDD VSS Y
Mmn1 n0 B n1 VSS g45n1svt M=1 L=45n W=1.55u
Mmn2 Y C n0 VSS g45n1svt M=1 L=45n W=1.55u
Mmn0 n1 A VSS VSS g45n1svt M=1 L=45n W=1.55u
Mmp0 Y A VDD VDD g45p1svt M=1 L=45n W=2.34u
Mmp1 Y B VDD VDD g45p1svt M=1 L=45n W=2.34u
Mmp2 Y C VDD VDD g45p1svt M=1 L=45n W=2.34u
.ENDS

.SUBCKT NAND3X4 A B C VDD VSS Y
Mmn1 n0 B n1 VSS g45n1svt M=1 L=45n W=1.04u
Mmn2 Y C n0 VSS g45n1svt M=1 L=45n W=1.04u
Mmn0 n1 A VSS VSS g45n1svt M=1 L=45n W=1.04u
Mmp0 Y A VDD VDD g45p1svt M=1 L=45n W=1.56u
Mmp1 Y B VDD VDD g45p1svt M=1 L=45n W=1.56u
Mmp2 Y C VDD VDD g45p1svt M=1 L=45n W=1.56u
.ENDS

.SUBCKT NAND3X2 A B C VDD VSS Y
Mmn1 n0 B n1 VSS g45n1svt M=1 L=45n W=520n
Mmn2 Y C n0 VSS g45n1svt M=1 L=45n W=520n
Mmn0 n1 A VSS VSS g45n1svt M=1 L=45n W=520n
Mmp0 Y A VDD VDD g45p1svt M=1 L=45n W=780n
Mmp1 Y B VDD VDD g45p1svt M=1 L=45n W=780n
Mmp2 Y C VDD VDD g45p1svt M=1 L=45n W=780n
.ENDS

.SUBCKT NAND3X1 A B C VDD VSS Y
Mmn1 n0 B n1 VSS g45n1svt M=1 L=45n W=260n
Mmn2 Y C n0 VSS g45n1svt M=1 L=45n W=260n
Mmn0 n1 A VSS VSS g45n1svt M=1 L=45n W=260n
Mmp0 Y A VDD VDD g45p1svt M=1 L=45n W=390n
Mmp1 Y B VDD VDD g45p1svt M=1 L=45n W=390n
Mmp2 Y C VDD VDD g45p1svt M=1 L=45n W=390n
.ENDS

.SUBCKT NAND3BXL AN B C VDD VSS Y
Mmn3 Y C n1 VSS g45n1svt M=1 L=45n W=145n
Mmn0 n0 AN VSS VSS g45n1svt M=1 L=45n W=145n
Mmn2 n1 B n2 VSS g45n1svt M=1 L=45n W=145n
Mmn1 n2 n0 VSS VSS g45n1svt M=1 L=45n W=145n
Mmp1 Y n0 VDD VDD g45p1svt M=1 L=45n W=215n
Mmp3 Y C VDD VDD g45p1svt M=1 L=45n W=215n
Mmp0 n0 AN VDD VDD g45p1svt M=1 L=45n W=215n
Mmp2 Y B VDD VDD g45p1svt M=1 L=45n W=215n
.ENDS

.SUBCKT NAND3BX4 AN B C VDD VSS Y
Mmn3 Y C n1 VSS g45n1svt M=1 L=45n W=1.04u
Mmn0 n0 AN VSS VSS g45n1svt M=1 L=45n W=260n
Mmn2 n1 B n2 VSS g45n1svt M=1 L=45n W=1.04u
Mmn1 n2 n0 VSS VSS g45n1svt M=1 L=45n W=1.04u
Mmp1 Y n0 VDD VDD g45p1svt M=1 L=45n W=1.56u
Mmp3 Y C VDD VDD g45p1svt M=1 L=45n W=1.56u
Mmp0 n0 AN VDD VDD g45p1svt M=1 L=45n W=390n
Mmp2 Y B VDD VDD g45p1svt M=1 L=45n W=1.56u
.ENDS

.SUBCKT NAND3BX2 AN B C VDD VSS Y
Mmn3 Y C n1 VSS g45n1svt M=1 L=45n W=520n
Mmn0 n0 AN VSS VSS g45n1svt M=1 L=45n W=145n
Mmn2 n1 B n2 VSS g45n1svt M=1 L=45n W=520n
Mmn1 n2 n0 VSS VSS g45n1svt M=1 L=45n W=520n
Mmp1 Y n0 VDD VDD g45p1svt M=1 L=45n W=780n
Mmp3 Y C VDD VDD g45p1svt M=1 L=45n W=780n
Mmp0 n0 AN VDD VDD g45p1svt M=1 L=45n W=215n
Mmp2 Y B VDD VDD g45p1svt M=1 L=45n W=780n
.ENDS

.SUBCKT NAND3BX1 AN B C VDD VSS Y
Mmn3 Y C n1 VSS g45n1svt M=1 L=45n W=260n
Mmn0 n0 AN VSS VSS g45n1svt M=1 L=45n W=145n
Mmn2 n1 B n2 VSS g45n1svt M=1 L=45n W=260n
Mmn1 n2 n0 VSS VSS g45n1svt M=1 L=45n W=260n
Mmp1 Y n0 VDD VDD g45p1svt M=1 L=45n W=390n
Mmp3 Y C VDD VDD g45p1svt M=1 L=45n W=390n
Mmp0 n0 AN VDD VDD g45p1svt M=1 L=45n W=215n
Mmp2 Y B VDD VDD g45p1svt M=1 L=45n W=390n
.ENDS

.SUBCKT NAND2XL A B VDD VSS Y
Mmn1 Y B n0 VSS g45n1svt M=1 L=45n W=145n
Mmn0 n0 A VSS VSS g45n1svt M=1 L=45n W=145n
Mmp1 Y B VDD VDD g45p1svt M=1 L=45n W=215n
Mmp0 Y A VDD VDD g45p1svt M=1 L=45n W=215n
.ENDS

.SUBCKT NAND2X8 A B VDD VSS Y
Mmn1 Y B n0 VSS g45n1svt M=1 L=45n W=2.065u
Mmn0 n0 A VSS VSS g45n1svt M=1 L=45n W=2.065u
Mmp1 Y B VDD VDD g45p1svt M=1 L=45n W=3.115u
Mmp0 Y A VDD VDD g45p1svt M=1 L=45n W=3.115u
.ENDS

.SUBCKT NAND2X6 A B VDD VSS Y
Mmn1 Y B n0 VSS g45n1svt M=1 L=45n W=1.55u
Mmn0 n0 A VSS VSS g45n1svt M=1 L=45n W=1.55u
Mmp1 Y B VDD VDD g45p1svt M=1 L=45n W=2.34u
Mmp0 Y A VDD VDD g45p1svt M=1 L=45n W=2.34u
.ENDS

.SUBCKT NAND2X4 A B VDD VSS Y
Mmn1 Y B n0 VSS g45n1svt M=1 L=45n W=1.04u
Mmn0 n0 A VSS VSS g45n1svt M=1 L=45n W=1.04u
Mmp1 Y B VDD VDD g45p1svt M=1 L=45n W=1.56u
Mmp0 Y A VDD VDD g45p1svt M=1 L=45n W=1.56u
.ENDS

.SUBCKT NAND2X2 A B VDD VSS Y
Mmn1 Y B n0 VSS g45n1svt M=1 L=45n W=520n
Mmn0 n0 A VSS VSS g45n1svt M=1 L=45n W=520n
Mmp1 Y B VDD VDD g45p1svt M=1 L=45n W=780n
Mmp0 Y A VDD VDD g45p1svt M=1 L=45n W=780n
.ENDS

.SUBCKT NAND2BXL AN B VDD VSS Y
Mmn2 Y B n1 VSS g45n1svt M=1 L=45n W=145n
Mmn0 n0 AN VSS VSS g45n1svt M=1 L=45n W=145n
Mmn1 n1 n0 VSS VSS g45n1svt M=1 L=45n W=145n
Mmp1 Y n0 VDD VDD g45p1svt M=1 L=45n W=215n
Mmp2 Y B VDD VDD g45p1svt M=1 L=45n W=215n
Mmp0 n0 AN VDD VDD g45p1svt M=1 L=45n W=215n
.ENDS

.SUBCKT NAND2BX4 AN B VDD VSS Y
Mmn2 Y B n1 VSS g45n1svt M=1 L=45n W=1.04u
Mmn0 n0 AN VSS VSS g45n1svt M=1 L=45n W=260n
Mmn1 n1 n0 VSS VSS g45n1svt M=1 L=45n W=1.04u
Mmp1 Y n0 VDD VDD g45p1svt M=1 L=45n W=1.56u
Mmp2 Y B VDD VDD g45p1svt M=1 L=45n W=1.56u
Mmp0 n0 AN VDD VDD g45p1svt M=1 L=45n W=390n
.ENDS

.SUBCKT NAND2BX2 AN B VDD VSS Y
Mmn2 Y B n1 VSS g45n1svt M=1 L=45n W=520n
Mmn0 n0 AN VSS VSS g45n1svt M=1 L=45n W=145n
Mmn1 n1 n0 VSS VSS g45n1svt M=1 L=45n W=520n
Mmp1 Y n0 VDD VDD g45p1svt M=1 L=45n W=780n
Mmp2 Y B VDD VDD g45p1svt M=1 L=45n W=780n
Mmp0 n0 AN VDD VDD g45p1svt M=1 L=45n W=215n
.ENDS

.SUBCKT NAND2BX1 AN B VDD VSS Y
Mmn2 Y B n1 VSS g45n1svt M=1 L=45n W=260n
Mmn0 n0 AN VSS VSS g45n1svt M=1 L=45n W=145n
Mmn1 n1 n0 VSS VSS g45n1svt M=1 L=45n W=260n
Mmp1 Y n0 VDD VDD g45p1svt M=1 L=45n W=390n
Mmp2 Y B VDD VDD g45p1svt M=1 L=45n W=390n
Mmp0 n0 AN VDD VDD g45p1svt M=1 L=45n W=215n
.ENDS

.SUBCKT MXI4XL A B C D S0 S1 VDD VSS Y
Mmn8 net377 D VSS VSS g45n1svt M=1 L=45n W=145n
Mmn9 n1 S0 net377 VSS g45n1svt M=1 L=45n W=145n
Mmn6 net369 C VSS VSS g45n1svt M=1 L=45n W=145n
Mmn7 n1 S0b net369 VSS g45n1svt M=1 L=45n W=145n
Mmn4 net361 B VSS VSS g45n1svt M=1 L=45n W=145n
Mmn5 n0 S0 net361 VSS g45n1svt M=1 L=45n W=145n
Mmn3 n0 S0b net349 VSS g45n1svt M=1 L=45n W=145n
Mmn2 net349 A VSS VSS g45n1svt M=1 L=45n W=145n
Mmn12 net345 n1 VSS VSS g45n1svt M=1 L=45n W=145n
Mmn13 n2 S1 net345 VSS g45n1svt M=1 L=45n W=145n
Mmn11 n2 S1b net329 VSS g45n1svt M=1 L=45n W=145n
Mmn1 S1b S1 VSS VSS g45n1svt M=1 L=45n W=145n
Mmn10 net329 n0 VSS VSS g45n1svt M=1 L=45n W=145n
Mmn14 Y n2 VSS VSS g45n1svt M=1 L=45n W=145n
Mmn0 S0b S0 VSS VSS g45n1svt M=1 L=45n W=145n
Mmp9 n1 S0b net320 VDD g45p1svt M=1 L=45n W=215n
Mmp8 net320 D VDD VDD g45p1svt M=1 L=45n W=215n
Mmp7 n1 S0 net312 VDD g45p1svt M=1 L=45n W=215n
Mmp6 net312 C VDD VDD g45p1svt M=1 L=45n W=215n
Mmp5 n0 S0b net304 VDD g45p1svt M=1 L=45n W=215n
Mmp4 net304 B VDD VDD g45p1svt M=1 L=45n W=215n
Mmp3 n0 S0 net296 VDD g45p1svt M=1 L=45n W=215n
Mmp2 net296 A VDD VDD g45p1svt M=1 L=45n W=215n
Mmp12 net284 n1 VDD VDD g45p1svt M=1 L=45n W=215n
Mmp13 n2 S1b net284 VDD g45p1svt M=1 L=45n W=215n
Mmp11 n2 S1 net280 VDD g45p1svt M=1 L=45n W=215n
Mmp10 net280 n0 VDD VDD g45p1svt M=1 L=45n W=215n
Mmp0 S0b S0 VDD VDD g45p1svt M=1 L=45n W=215n
Mmp14 Y n2 VDD VDD g45p1svt M=1 L=45n W=215n
Mmp1 S1b S1 VDD VDD g45p1svt M=1 L=45n W=215n
.ENDS

.SUBCKT MXI4X4 A B C D S0 S1 VDD VSS Y
Mmn8 net377 D VSS VSS g45n1svt M=1 L=45n W=145n
Mmn9 n1 S0 net377 VSS g45n1svt M=1 L=45n W=145n
Mmn6 net369 C VSS VSS g45n1svt M=1 L=45n W=145n
Mmn7 n1 S0b net369 VSS g45n1svt M=1 L=45n W=145n
Mmn4 net361 B VSS VSS g45n1svt M=1 L=45n W=145n
Mmn5 n0 S0 net361 VSS g45n1svt M=1 L=45n W=145n
Mmn3 n0 S0b net349 VSS g45n1svt M=1 L=45n W=145n
Mmn2 net349 A VSS VSS g45n1svt M=1 L=45n W=145n
Mmn12 net345 n1 VSS VSS g45n1svt M=1 L=45n W=205n
Mmn13 n2 S1 net345 VSS g45n1svt M=1 L=45n W=205n
Mmn11 n2 S1b net329 VSS g45n1svt M=1 L=45n W=205n
Mmn1 S1b S1 VSS VSS g45n1svt M=1 L=45n W=145n
Mmn10 net329 n0 VSS VSS g45n1svt M=1 L=45n W=205n
Mmn14 Y n2 VSS VSS g45n1svt M=1 L=45n W=1.04u
Mmn0 S0b S0 VSS VSS g45n1svt M=1 L=45n W=145n
Mmp9 n1 S0b net320 VDD g45p1svt M=1 L=45n W=215n
Mmp8 net320 D VDD VDD g45p1svt M=1 L=45n W=215n
Mmp7 n1 S0 net312 VDD g45p1svt M=1 L=45n W=215n
Mmp6 net312 C VDD VDD g45p1svt M=1 L=45n W=215n
Mmp5 n0 S0b net304 VDD g45p1svt M=1 L=45n W=215n
Mmp4 net304 B VDD VDD g45p1svt M=1 L=45n W=215n
Mmp3 n0 S0 net296 VDD g45p1svt M=1 L=45n W=215n
Mmp2 net296 A VDD VDD g45p1svt M=1 L=45n W=215n
Mmp12 net284 n1 VDD VDD g45p1svt M=1 L=45n W=310n
Mmp13 n2 S1b net284 VDD g45p1svt M=1 L=45n W=310n
Mmp11 n2 S1 net280 VDD g45p1svt M=1 L=45n W=310n
Mmp10 net280 n0 VDD VDD g45p1svt M=1 L=45n W=310n
Mmp0 S0b S0 VDD VDD g45p1svt M=1 L=45n W=215n
Mmp14 Y n2 VDD VDD g45p1svt M=1 L=45n W=1.56u
Mmp1 S1b S1 VDD VDD g45p1svt M=1 L=45n W=215n
.ENDS

.SUBCKT MXI4X2 A B C D S0 S1 VDD VSS Y
Mmn8 net377 D VSS VSS g45n1svt M=1 L=45n W=145n
Mmn9 n1 S0 net377 VSS g45n1svt M=1 L=45n W=145n
Mmn6 net369 C VSS VSS g45n1svt M=1 L=45n W=145n
Mmn7 n1 S0b net369 VSS g45n1svt M=1 L=45n W=145n
Mmn4 net361 B VSS VSS g45n1svt M=1 L=45n W=145n
Mmn5 n0 S0 net361 VSS g45n1svt M=1 L=45n W=145n
Mmn3 n0 S0b net349 VSS g45n1svt M=1 L=45n W=145n
Mmn2 net349 A VSS VSS g45n1svt M=1 L=45n W=145n
Mmn12 net345 n1 VSS VSS g45n1svt M=1 L=45n W=145n
Mmn13 n2 S1 net345 VSS g45n1svt M=1 L=45n W=145n
Mmn11 n2 S1b net329 VSS g45n1svt M=1 L=45n W=145n
Mmn1 S1b S1 VSS VSS g45n1svt M=1 L=45n W=145n
Mmn10 net329 n0 VSS VSS g45n1svt M=1 L=45n W=145n
Mmn14 Y n2 VSS VSS g45n1svt M=1 L=45n W=520n
Mmn0 S0b S0 VSS VSS g45n1svt M=1 L=45n W=145n
Mmp9 n1 S0b net320 VDD g45p1svt M=1 L=45n W=215n
Mmp8 net320 D VDD VDD g45p1svt M=1 L=45n W=215n
Mmp7 n1 S0 net312 VDD g45p1svt M=1 L=45n W=215n
Mmp6 net312 C VDD VDD g45p1svt M=1 L=45n W=215n
Mmp5 n0 S0b net304 VDD g45p1svt M=1 L=45n W=215n
Mmp4 net304 B VDD VDD g45p1svt M=1 L=45n W=215n
Mmp3 n0 S0 net296 VDD g45p1svt M=1 L=45n W=215n
Mmp2 net296 A VDD VDD g45p1svt M=1 L=45n W=215n
Mmp12 net284 n1 VDD VDD g45p1svt M=1 L=45n W=215n
Mmp13 n2 S1b net284 VDD g45p1svt M=1 L=45n W=215n
Mmp11 n2 S1 net280 VDD g45p1svt M=1 L=45n W=215n
Mmp10 net280 n0 VDD VDD g45p1svt M=1 L=45n W=215n
Mmp0 S0b S0 VDD VDD g45p1svt M=1 L=45n W=215n
Mmp14 Y n2 VDD VDD g45p1svt M=1 L=45n W=780n
Mmp1 S1b S1 VDD VDD g45p1svt M=1 L=45n W=215n
.ENDS

.SUBCKT MXI4X1 A B C D S0 S1 VDD VSS Y
Mmn8 net377 D VSS VSS g45n1svt M=1 L=45n W=145n
Mmn9 n1 S0 net377 VSS g45n1svt M=1 L=45n W=145n
Mmn6 net369 C VSS VSS g45n1svt M=1 L=45n W=145n
Mmn7 n1 S0b net369 VSS g45n1svt M=1 L=45n W=145n
Mmn4 net361 B VSS VSS g45n1svt M=1 L=45n W=145n
Mmn5 n0 S0 net361 VSS g45n1svt M=1 L=45n W=145n
Mmn3 n0 S0b net349 VSS g45n1svt M=1 L=45n W=145n
Mmn2 net349 A VSS VSS g45n1svt M=1 L=45n W=145n
Mmn12 net345 n1 VSS VSS g45n1svt M=1 L=45n W=145n
Mmn13 n2 S1 net345 VSS g45n1svt M=1 L=45n W=145n
Mmn11 n2 S1b net329 VSS g45n1svt M=1 L=45n W=145n
Mmn1 S1b S1 VSS VSS g45n1svt M=1 L=45n W=145n
Mmn10 net329 n0 VSS VSS g45n1svt M=1 L=45n W=145n
Mmn14 Y n2 VSS VSS g45n1svt M=1 L=45n W=260n
Mmn0 S0b S0 VSS VSS g45n1svt M=1 L=45n W=145n
Mmp9 n1 S0b net320 VDD g45p1svt M=1 L=45n W=215n
Mmp8 net320 D VDD VDD g45p1svt M=1 L=45n W=215n
Mmp7 n1 S0 net312 VDD g45p1svt M=1 L=45n W=215n
Mmp6 net312 C VDD VDD g45p1svt M=1 L=45n W=215n
Mmp5 n0 S0b net304 VDD g45p1svt M=1 L=45n W=215n
Mmp4 net304 B VDD VDD g45p1svt M=1 L=45n W=215n
Mmp3 n0 S0 net296 VDD g45p1svt M=1 L=45n W=215n
Mmp2 net296 A VDD VDD g45p1svt M=1 L=45n W=215n
Mmp12 net284 n1 VDD VDD g45p1svt M=1 L=45n W=215n
Mmp13 n2 S1b net284 VDD g45p1svt M=1 L=45n W=215n
Mmp11 n2 S1 net280 VDD g45p1svt M=1 L=45n W=215n
Mmp10 net280 n0 VDD VDD g45p1svt M=1 L=45n W=215n
Mmp0 S0b S0 VDD VDD g45p1svt M=1 L=45n W=215n
Mmp14 Y n2 VDD VDD g45p1svt M=1 L=45n W=390n
Mmp1 S1b S1 VDD VDD g45p1svt M=1 L=45n W=215n
.ENDS

.SUBCKT MXI3XL A B C S0 S1 VDD VSS Y
Mmn4 n4 B VSS VSS g45n1svt M=1 L=45n W=145n
Mmn5 n0 S0 n4 VSS g45n1svt M=1 L=45n W=145n
Mmn3 n0 S0b n2 VSS g45n1svt M=1 L=45n W=145n
Mmn2 n2 A VSS VSS g45n1svt M=1 L=45n W=145n
Mmn11 Y n1 VSS VSS g45n1svt M=1 L=45n W=145n
Mmn10 n1 S1 n8 VSS g45n1svt M=1 L=45n W=145n
Mmn9 n8 Cp VSS VSS g45n1svt M=1 L=45n W=145n
Mmn8 n1 S1b n6 VSS g45n1svt M=1 L=45n W=145n
Mmn7 n6 n0 VSS VSS g45n1svt M=1 L=45n W=145n
Mmn6 Cp C VSS VSS g45n1svt M=1 L=45n W=145n
Mmn0 S0b S0 VSS VSS g45n1svt M=1 L=45n W=145n
Mmn1 S1b S1 VSS VSS g45n1svt M=1 L=45n W=145n
Mmp5 n0 S0b n5 VDD g45p1svt M=1 L=45n W=215n
Mmp4 n5 B VDD VDD g45p1svt M=1 L=45n W=215n
Mmp3 n0 S0 n3 VDD g45p1svt M=1 L=45n W=215n
Mmp2 n3 A VDD VDD g45p1svt M=1 L=45n W=215n
Mmp8 n1 S1 n7 VDD g45p1svt M=1 L=45n W=215n
Mmp7 n7 n0 VDD VDD g45p1svt M=1 L=45n W=215n
Mmp11 Y n1 VDD VDD g45p1svt M=1 L=45n W=215n
Mmp9 n9 Cp VDD VDD g45p1svt M=1 L=45n W=215n
Mmp10 n1 S1b n9 VDD g45p1svt M=1 L=45n W=215n
Mmp6 Cp C VDD VDD g45p1svt M=1 L=45n W=215n
Mmp1 S1b S1 VDD VDD g45p1svt M=1 L=45n W=215n
Mmp0 S0b S0 VDD VDD g45p1svt M=1 L=45n W=215n
.ENDS

.SUBCKT MXI3X4 A B C S0 S1 VDD VSS Y
Mmn4 n4 B VSS VSS g45n1svt M=1 L=45n W=145n
Mmn5 n0 S0 n4 VSS g45n1svt M=1 L=45n W=145n
Mmn3 n0 S0b n2 VSS g45n1svt M=1 L=45n W=145n
Mmn2 n2 A VSS VSS g45n1svt M=1 L=45n W=145n
Mmn11 Y n1 VSS VSS g45n1svt M=1 L=45n W=1.04u
Mmn10 n1 S1 n8 VSS g45n1svt M=1 L=45n W=205n
Mmn9 n8 Cp VSS VSS g45n1svt M=1 L=45n W=205n
Mmn8 n1 S1b n6 VSS g45n1svt M=1 L=45n W=205n
Mmn7 n6 n0 VSS VSS g45n1svt M=1 L=45n W=205n
Mmn6 Cp C VSS VSS g45n1svt M=1 L=45n W=145n
Mmn0 S0b S0 VSS VSS g45n1svt M=1 L=45n W=145n
Mmn1 S1b S1 VSS VSS g45n1svt M=1 L=45n W=145n
Mmp5 n0 S0b n5 VDD g45p1svt M=1 L=45n W=215n
Mmp4 n5 B VDD VDD g45p1svt M=1 L=45n W=215n
Mmp3 n0 S0 n3 VDD g45p1svt M=1 L=45n W=215n
Mmp2 n3 A VDD VDD g45p1svt M=1 L=45n W=215n
Mmp8 n1 S1 n7 VDD g45p1svt M=1 L=45n W=310n
Mmp7 n7 n0 VDD VDD g45p1svt M=1 L=45n W=310n
Mmp11 Y n1 VDD VDD g45p1svt M=1 L=45n W=1.56u
Mmp9 n9 Cp VDD VDD g45p1svt M=1 L=45n W=310n
Mmp10 n1 S1b n9 VDD g45p1svt M=1 L=45n W=310n
Mmp6 Cp C VDD VDD g45p1svt M=1 L=45n W=215n
Mmp1 S1b S1 VDD VDD g45p1svt M=1 L=45n W=215n
Mmp0 S0b S0 VDD VDD g45p1svt M=1 L=45n W=215n
.ENDS

.SUBCKT MXI3X2 A B C S0 S1 VDD VSS Y
Mmn4 n4 B VSS VSS g45n1svt M=1 L=45n W=145n
Mmn5 n0 S0 n4 VSS g45n1svt M=1 L=45n W=145n
Mmn3 n0 S0b n2 VSS g45n1svt M=1 L=45n W=145n
Mmn2 n2 A VSS VSS g45n1svt M=1 L=45n W=145n
Mmn11 Y n1 VSS VSS g45n1svt M=1 L=45n W=520n
Mmn10 n1 S1 n8 VSS g45n1svt M=1 L=45n W=145n
Mmn9 n8 Cp VSS VSS g45n1svt M=1 L=45n W=145n
Mmn8 n1 S1b n6 VSS g45n1svt M=1 L=45n W=145n
Mmn7 n6 n0 VSS VSS g45n1svt M=1 L=45n W=145n
Mmn6 Cp C VSS VSS g45n1svt M=1 L=45n W=145n
Mmn0 S0b S0 VSS VSS g45n1svt M=1 L=45n W=145n
Mmn1 S1b S1 VSS VSS g45n1svt M=1 L=45n W=145n
Mmp5 n0 S0b n5 VDD g45p1svt M=1 L=45n W=215n
Mmp4 n5 B VDD VDD g45p1svt M=1 L=45n W=215n
Mmp3 n0 S0 n3 VDD g45p1svt M=1 L=45n W=215n
Mmp2 n3 A VDD VDD g45p1svt M=1 L=45n W=215n
Mmp8 n1 S1 n7 VDD g45p1svt M=1 L=45n W=215n
Mmp7 n7 n0 VDD VDD g45p1svt M=1 L=45n W=215n
Mmp11 Y n1 VDD VDD g45p1svt M=1 L=45n W=780n
Mmp9 n9 Cp VDD VDD g45p1svt M=1 L=45n W=215n
Mmp10 n1 S1b n9 VDD g45p1svt M=1 L=45n W=215n
Mmp6 Cp C VDD VDD g45p1svt M=1 L=45n W=215n
Mmp1 S1b S1 VDD VDD g45p1svt M=1 L=45n W=215n
Mmp0 S0b S0 VDD VDD g45p1svt M=1 L=45n W=215n
.ENDS

.SUBCKT MXI3X1 A B C S0 S1 VDD VSS Y
Mmn4 n4 B VSS VSS g45n1svt M=1 L=45n W=145n
Mmn5 n0 S0 n4 VSS g45n1svt M=1 L=45n W=145n
Mmn3 n0 S0b n2 VSS g45n1svt M=1 L=45n W=145n
Mmn2 n2 A VSS VSS g45n1svt M=1 L=45n W=145n
Mmn11 Y n1 VSS VSS g45n1svt M=1 L=45n W=260n
Mmn10 n1 S1 n8 VSS g45n1svt M=1 L=45n W=145n
Mmn9 n8 Cp VSS VSS g45n1svt M=1 L=45n W=145n
Mmn8 n1 S1b n6 VSS g45n1svt M=1 L=45n W=145n
Mmn7 n6 n0 VSS VSS g45n1svt M=1 L=45n W=145n
Mmn6 Cp C VSS VSS g45n1svt M=1 L=45n W=145n
Mmn0 S0b S0 VSS VSS g45n1svt M=1 L=45n W=145n
Mmn1 S1b S1 VSS VSS g45n1svt M=1 L=45n W=145n
Mmp5 n0 S0b n5 VDD g45p1svt M=1 L=45n W=215n
Mmp4 n5 B VDD VDD g45p1svt M=1 L=45n W=215n
Mmp3 n0 S0 n3 VDD g45p1svt M=1 L=45n W=215n
Mmp2 n3 A VDD VDD g45p1svt M=1 L=45n W=215n
Mmp8 n1 S1 n7 VDD g45p1svt M=1 L=45n W=215n
Mmp7 n7 n0 VDD VDD g45p1svt M=1 L=45n W=215n
Mmp11 Y n1 VDD VDD g45p1svt M=1 L=45n W=390n
Mmp9 n9 Cp VDD VDD g45p1svt M=1 L=45n W=215n
Mmp10 n1 S1b n9 VDD g45p1svt M=1 L=45n W=215n
Mmp6 Cp C VDD VDD g45p1svt M=1 L=45n W=215n
Mmp1 S1b S1 VDD VDD g45p1svt M=1 L=45n W=215n
Mmp0 S0b S0 VDD VDD g45p1svt M=1 L=45n W=215n
.ENDS

.SUBCKT MXI2XL A B S0 VDD VSS Y
Mmn3 n5 B VSS VSS g45n1svt M=1 L=45n W=145n
Mmn4 Y S0 n5 VSS g45n1svt M=1 L=45n W=145n
Mmn2 Y S0b n3 VSS g45n1svt M=1 L=45n W=145n
Mmn1 n3 A VSS VSS g45n1svt M=1 L=45n W=145n
Mmn0 S0b S0 VSS VSS g45n1svt M=1 L=45n W=145n
Mmp4 Y S0b n6 VDD g45p1svt M=1 L=45n W=215n
Mmp3 n6 B VDD VDD g45p1svt M=1 L=45n W=215n
Mmp2 Y S0 n4 VDD g45p1svt M=1 L=45n W=215n
Mmp1 n4 A VDD VDD g45p1svt M=1 L=45n W=215n
Mmp0 S0b S0 VDD VDD g45p1svt M=1 L=45n W=215n
.ENDS

.SUBCKT MXI2X8 A B S0 VDD VSS Y
Mmn3 n5 B VSS VSS g45n1svt M=1 L=45n W=145n
Mmn4 n0 S0 n5 VSS g45n1svt M=1 L=45n W=145n
Mmn2 n0 S0b n3 VSS g45n1svt M=1 L=45n W=145n
Mmn1 n3 A VSS VSS g45n1svt M=1 L=45n W=145n
Mmn5 n1 n0 VSS VSS g45n1svt M=1 L=45n W=520n
Mmn6 Y n1 VSS VSS g45n1svt M=1 L=45n W=2.065u
Mmn0 S0b S0 VSS VSS g45n1svt M=1 L=45n W=145n
Mmp4 n0 S0b n6 VDD g45p1svt M=1 L=45n W=215n
Mmp3 n6 B VDD VDD g45p1svt M=1 L=45n W=215n
Mmp2 n0 S0 n4 VDD g45p1svt M=1 L=45n W=215n
Mmp1 n4 A VDD VDD g45p1svt M=1 L=45n W=215n
Mmp6 Y n1 VDD VDD g45p1svt M=1 L=45n W=3.115u
Mmp5 n1 n0 VDD VDD g45p1svt M=1 L=45n W=780n
Mmp0 S0b S0 VDD VDD g45p1svt M=1 L=45n W=215n
.ENDS

.SUBCKT MXI2X6 A B S0 VDD VSS Y
Mmn3 n5 B VSS VSS g45n1svt M=1 L=45n W=145n
Mmn4 n0 S0 n5 VSS g45n1svt M=1 L=45n W=145n
Mmn2 n0 S0b n3 VSS g45n1svt M=1 L=45n W=145n
Mmn1 n3 A VSS VSS g45n1svt M=1 L=45n W=145n
Mmn5 n1 n0 VSS VSS g45n1svt M=1 L=45n W=520n
Mmn6 Y n1 VSS VSS g45n1svt M=1 L=45n W=1.55u
Mmn0 S0b S0 VSS VSS g45n1svt M=1 L=45n W=145n
Mmp4 n0 S0b n6 VDD g45p1svt M=1 L=45n W=215n
Mmp3 n6 B VDD VDD g45p1svt M=1 L=45n W=215n
Mmp2 n0 S0 n4 VDD g45p1svt M=1 L=45n W=215n
Mmp1 n4 A VDD VDD g45p1svt M=1 L=45n W=215n
Mmp6 Y n1 VDD VDD g45p1svt M=1 L=45n W=2.35u
Mmp5 n1 n0 VDD VDD g45p1svt M=1 L=45n W=780n
Mmp0 S0b S0 VDD VDD g45p1svt M=1 L=45n W=215n
.ENDS

.SUBCKT MXI2X4 A B S0 VDD VSS Y
Mmn3 n5 B VSS VSS g45n1svt M=1 L=45n W=145n
Mmn4 n0 S0 n5 VSS g45n1svt M=1 L=45n W=145n
Mmn2 n0 S0b n3 VSS g45n1svt M=1 L=45n W=145n
Mmn1 n3 A VSS VSS g45n1svt M=1 L=45n W=145n
Mmn5 n1 n0 VSS VSS g45n1svt M=1 L=45n W=260n
Mmn6 Y n1 VSS VSS g45n1svt M=1 L=45n W=1.04u
Mmn0 S0b S0 VSS VSS g45n1svt M=1 L=45n W=145n
Mmp4 n0 S0b n6 VDD g45p1svt M=1 L=45n W=215n
Mmp3 n6 B VDD VDD g45p1svt M=1 L=45n W=215n
Mmp2 n0 S0 n4 VDD g45p1svt M=1 L=45n W=215n
Mmp1 n4 A VDD VDD g45p1svt M=1 L=45n W=215n
Mmp6 Y n1 VDD VDD g45p1svt M=1 L=45n W=1.56u
Mmp5 n1 n0 VDD VDD g45p1svt M=1 L=45n W=390n
Mmp0 S0b S0 VDD VDD g45p1svt M=1 L=45n W=215n
.ENDS

.SUBCKT MXI2X2 A B S0 VDD VSS Y
Mmn3 n5 B VSS VSS g45n1svt M=1 L=45n W=145n
Mmn4 n0 S0 n5 VSS g45n1svt M=1 L=45n W=145n
Mmn2 n0 S0b n3 VSS g45n1svt M=1 L=45n W=145n
Mmn1 n3 A VSS VSS g45n1svt M=1 L=45n W=145n
Mmn5 n1 n0 VSS VSS g45n1svt M=1 L=45n W=145n
Mmn6 Y n1 VSS VSS g45n1svt M=1 L=45n W=520n
Mmn0 S0b S0 VSS VSS g45n1svt M=1 L=45n W=145n
Mmp4 n0 S0b n6 VDD g45p1svt M=1 L=45n W=215n
Mmp3 n6 B VDD VDD g45p1svt M=1 L=45n W=215n
Mmp2 n0 S0 n4 VDD g45p1svt M=1 L=45n W=215n
Mmp1 n4 A VDD VDD g45p1svt M=1 L=45n W=215n
Mmp6 Y n1 VDD VDD g45p1svt M=1 L=45n W=780n
Mmp5 n1 n0 VDD VDD g45p1svt M=1 L=45n W=215n
Mmp0 S0b S0 VDD VDD g45p1svt M=1 L=45n W=215n
.ENDS

.SUBCKT MXI2X1 A B S0 VDD VSS Y
Mmn3 n5 B VSS VSS g45n1svt M=1 L=45n W=260n
Mmn4 Y S0 n5 VSS g45n1svt M=1 L=45n W=260n
Mmn2 Y S0b n3 VSS g45n1svt M=1 L=45n W=260n
Mmn1 n3 A VSS VSS g45n1svt M=1 L=45n W=260n
Mmn0 S0b S0 VSS VSS g45n1svt M=1 L=45n W=145n
Mmp4 Y S0b n6 VDD g45p1svt M=1 L=45n W=390n
Mmp3 n6 B VDD VDD g45p1svt M=1 L=45n W=390n
Mmp2 Y S0 n4 VDD g45p1svt M=1 L=45n W=390n
Mmp1 n4 A VDD VDD g45p1svt M=1 L=45n W=390n
Mmp0 S0b S0 VDD VDD g45p1svt M=1 L=45n W=215n
.ENDS

.SUBCKT MX4XL A B C D S0 S1 VDD VSS Y
Mmn9 n1 S0 n9 VSS g45n1svt M=1 L=45n W=145n
Mmn6 n7 C VSS VSS g45n1svt M=1 L=45n W=145n
Mmn7 n1 S0b n7 VSS g45n1svt M=1 L=45n W=145n
Mmn4 n5 B VSS VSS g45n1svt M=1 L=45n W=145n
Mmn5 n0 S0 n5 VSS g45n1svt M=1 L=45n W=145n
Mmn3 n0 S0b n3 VSS g45n1svt M=1 L=45n W=145n
Mmn2 n3 A VSS VSS g45n1svt M=1 L=45n W=145n
Mmn12 Y n2 VSS VSS g45n1svt M=1 L=45n W=145n
Mmn1 S1b S1 VSS VSS g45n1svt M=1 L=45n W=145n
Mmn11 n2 S1 n1 VSS g45n1svt M=1 L=45n W=145n
Mmn8 n9 D VSS VSS g45n1svt M=1 L=45n W=145n
Mmn10 n2 S1b n0 VSS g45n1svt M=1 L=45n W=145n
Mmn0 S0b S0 VSS VSS g45n1svt M=1 L=45n W=145n
Mmp9 n1 S0b n10 VDD g45p1svt M=1 L=45n W=215n
Mmp8 n10 D VDD VDD g45p1svt M=1 L=45n W=215n
Mmp7 n1 S0 n8 VDD g45p1svt M=1 L=45n W=215n
Mmp6 n8 C VDD VDD g45p1svt M=1 L=45n W=215n
Mmp5 n0 S0b n6 VDD g45p1svt M=1 L=45n W=215n
Mmp4 n6 B VDD VDD g45p1svt M=1 L=45n W=215n
Mmp3 n0 S0 n4 VDD g45p1svt M=1 L=45n W=215n
Mmp2 n4 A VDD VDD g45p1svt M=1 L=45n W=215n
Mmp12 Y n2 VDD VDD g45p1svt M=1 L=45n W=215n
Mmp0 S0b S0 VDD VDD g45p1svt M=1 L=45n W=215n
Mmp10 n2 S1 n0 VDD g45p1svt M=1 L=45n W=215n
Mmp11 n1 S1b n2 VDD g45p1svt M=1 L=45n W=215n
Mmp1 S1b S1 VDD VDD g45p1svt M=1 L=45n W=215n
.ENDS

.SUBCKT MX4X4 A B C D S0 S1 VDD VSS Y
Mmn9 n1 S0 n9 VSS g45n1svt M=1 L=45n W=145n
Mmn6 n7 C VSS VSS g45n1svt M=1 L=45n W=145n
Mmn7 n1 S0b n7 VSS g45n1svt M=1 L=45n W=145n
Mmn4 n5 B VSS VSS g45n1svt M=1 L=45n W=145n
Mmn5 n0 S0 n5 VSS g45n1svt M=1 L=45n W=145n
Mmn3 n0 S0b n3 VSS g45n1svt M=1 L=45n W=145n
Mmn2 n3 A VSS VSS g45n1svt M=1 L=45n W=145n
Mmn12 Y n2 VSS VSS g45n1svt M=1 L=45n W=1.04u
Mmn1 S1b S1 VSS VSS g45n1svt M=1 L=45n W=145n
Mmn11 n2 S1 n1 VSS g45n1svt M=1 L=45n W=260n
Mmn8 n9 D VSS VSS g45n1svt M=1 L=45n W=145n
Mmn10 n2 S1b n0 VSS g45n1svt M=1 L=45n W=260n
Mmn0 S0b S0 VSS VSS g45n1svt M=1 L=45n W=145n
Mmp9 n1 S0b n10 VDD g45p1svt M=1 L=45n W=215n
Mmp8 n10 D VDD VDD g45p1svt M=1 L=45n W=215n
Mmp7 n1 S0 n8 VDD g45p1svt M=1 L=45n W=215n
Mmp6 n8 C VDD VDD g45p1svt M=1 L=45n W=215n
Mmp5 n0 S0b n6 VDD g45p1svt M=1 L=45n W=215n
Mmp4 n6 B VDD VDD g45p1svt M=1 L=45n W=215n
Mmp3 n0 S0 n4 VDD g45p1svt M=1 L=45n W=215n
Mmp2 n4 A VDD VDD g45p1svt M=1 L=45n W=215n
Mmp12 Y n2 VDD VDD g45p1svt M=1 L=45n W=1.56u
Mmp0 S0b S0 VDD VDD g45p1svt M=1 L=45n W=215n
Mmp10 n2 S1 n0 VDD g45p1svt M=1 L=45n W=390n
Mmp11 n1 S1b n2 VDD g45p1svt M=1 L=45n W=390n
Mmp1 S1b S1 VDD VDD g45p1svt M=1 L=45n W=215n
.ENDS

.SUBCKT MX4X2 A B C D S0 S1 VDD VSS Y
Mmn9 n1 S0 n9 VSS g45n1svt M=1 L=45n W=145n
Mmn6 n7 C VSS VSS g45n1svt M=1 L=45n W=145n
Mmn7 n1 S0b n7 VSS g45n1svt M=1 L=45n W=145n
Mmn4 n5 B VSS VSS g45n1svt M=1 L=45n W=145n
Mmn5 n0 S0 n5 VSS g45n1svt M=1 L=45n W=145n
Mmn3 n0 S0b n3 VSS g45n1svt M=1 L=45n W=145n
Mmn2 n3 A VSS VSS g45n1svt M=1 L=45n W=145n
Mmn12 Y n2 VSS VSS g45n1svt M=1 L=45n W=520n
Mmn1 S1b S1 VSS VSS g45n1svt M=1 L=45n W=145n
Mmn11 n2 S1 n1 VSS g45n1svt M=1 L=45n W=145n
Mmn8 n9 D VSS VSS g45n1svt M=1 L=45n W=145n
Mmn10 n2 S1b n0 VSS g45n1svt M=1 L=45n W=145n
Mmn0 S0b S0 VSS VSS g45n1svt M=1 L=45n W=145n
Mmp9 n1 S0b n10 VDD g45p1svt M=1 L=45n W=215n
Mmp8 n10 D VDD VDD g45p1svt M=1 L=45n W=215n
Mmp7 n1 S0 n8 VDD g45p1svt M=1 L=45n W=215n
Mmp6 n8 C VDD VDD g45p1svt M=1 L=45n W=215n
Mmp5 n0 S0b n6 VDD g45p1svt M=1 L=45n W=215n
Mmp4 n6 B VDD VDD g45p1svt M=1 L=45n W=215n
Mmp3 n0 S0 n4 VDD g45p1svt M=1 L=45n W=215n
Mmp2 n4 A VDD VDD g45p1svt M=1 L=45n W=215n
Mmp12 Y n2 VDD VDD g45p1svt M=1 L=45n W=780n
Mmp0 S0b S0 VDD VDD g45p1svt M=1 L=45n W=215n
Mmp10 n2 S1 n0 VDD g45p1svt M=1 L=45n W=215n
Mmp11 n1 S1b n2 VDD g45p1svt M=1 L=45n W=215n
Mmp1 S1b S1 VDD VDD g45p1svt M=1 L=45n W=215n
.ENDS

.SUBCKT MX4X1 A B C D S0 S1 VDD VSS Y
Mmn9 n1 S0 n9 VSS g45n1svt M=1 L=45n W=145n
Mmn6 n7 C VSS VSS g45n1svt M=1 L=45n W=145n
Mmn7 n1 S0b n7 VSS g45n1svt M=1 L=45n W=145n
Mmn4 n5 B VSS VSS g45n1svt M=1 L=45n W=145n
Mmn5 n0 S0 n5 VSS g45n1svt M=1 L=45n W=145n
Mmn3 n0 S0b n3 VSS g45n1svt M=1 L=45n W=145n
Mmn2 n3 A VSS VSS g45n1svt M=1 L=45n W=145n
Mmn12 Y n2 VSS VSS g45n1svt M=1 L=45n W=260n
Mmn1 S1b S1 VSS VSS g45n1svt M=1 L=45n W=145n
Mmn11 n2 S1 n1 VSS g45n1svt M=1 L=45n W=145n
Mmn8 n9 D VSS VSS g45n1svt M=1 L=45n W=145n
Mmn10 n2 S1b n0 VSS g45n1svt M=1 L=45n W=145n
Mmn0 S0b S0 VSS VSS g45n1svt M=1 L=45n W=145n
Mmp9 n1 S0b n10 VDD g45p1svt M=1 L=45n W=215n
Mmp8 n10 D VDD VDD g45p1svt M=1 L=45n W=215n
Mmp7 n1 S0 n8 VDD g45p1svt M=1 L=45n W=215n
Mmp6 n8 C VDD VDD g45p1svt M=1 L=45n W=215n
Mmp5 n0 S0b n6 VDD g45p1svt M=1 L=45n W=215n
Mmp4 n6 B VDD VDD g45p1svt M=1 L=45n W=215n
Mmp3 n0 S0 n4 VDD g45p1svt M=1 L=45n W=215n
Mmp2 n4 A VDD VDD g45p1svt M=1 L=45n W=215n
Mmp12 Y n2 VDD VDD g45p1svt M=1 L=45n W=390n
Mmp0 S0b S0 VDD VDD g45p1svt M=1 L=45n W=215n
Mmp10 n2 S1 n0 VDD g45p1svt M=1 L=45n W=215n
Mmp11 n1 S1b n2 VDD g45p1svt M=1 L=45n W=215n
Mmp1 S1b S1 VDD VDD g45p1svt M=1 L=45n W=215n
.ENDS

.SUBCKT MX3XL A B C S0 S1 VDD VSS Y
Mmn7 net245 C VSS VSS g45n1svt M=1 L=45n W=145n
Mmn8 n1 S1 net245 VSS g45n1svt M=1 L=45n W=145n
Mmn4 net234 B VSS VSS g45n1svt M=1 L=45n W=145n
Mmn5 n0 S0 net234 VSS g45n1svt M=1 L=45n W=145n
Mmn3 n0 S0b net229 VSS g45n1svt M=1 L=45n W=145n
Mmn2 net229 A VSS VSS g45n1svt M=1 L=45n W=145n
Mmn9 Y n1 VSS VSS g45n1svt M=1 L=45n W=145n
Mmn0 S0b S0 VSS VSS g45n1svt M=1 L=45n W=145n
Mmn1 S1b S1 VSS VSS g45n1svt M=1 L=45n W=145n
Mmn6 n1 S1b n0 VSS g45n1svt M=1 L=45n W=145n
Mmp8 n1 S1b net202 VDD g45p1svt M=1 L=45n W=215n
Mmp7 net202 C VDD VDD g45p1svt M=1 L=45n W=215n
Mmp5 n0 S0b net190 VDD g45p1svt M=1 L=45n W=215n
Mmp4 net190 B VDD VDD g45p1svt M=1 L=45n W=215n
Mmp3 n0 S0 net189 VDD g45p1svt M=1 L=45n W=215n
Mmp2 net189 A VDD VDD g45p1svt M=1 L=45n W=215n
Mmp9 Y n1 VDD VDD g45p1svt M=1 L=45n W=215n
Mmp1 S1b S1 VDD VDD g45p1svt M=1 L=45n W=215n
Mmp6 n0 S1 n1 VDD g45p1svt M=1 L=45n W=215n
Mmp0 S0b S0 VDD VDD g45p1svt M=1 L=45n W=215n
.ENDS

.SUBCKT MX3X4 A B C S0 S1 VDD VSS Y
Mmn7 net245 C VSS VSS g45n1svt M=1 L=45n W=260n
Mmn8 n1 S1 net245 VSS g45n1svt M=1 L=45n W=260n
Mmn4 net234 B VSS VSS g45n1svt M=1 L=45n W=145n
Mmn5 n0 S0 net234 VSS g45n1svt M=1 L=45n W=145n
Mmn3 n0 S0b net229 VSS g45n1svt M=1 L=45n W=145n
Mmn2 net229 A VSS VSS g45n1svt M=1 L=45n W=145n
Mmn9 Y n1 VSS VSS g45n1svt M=1 L=45n W=1.04u
Mmn0 S0b S0 VSS VSS g45n1svt M=1 L=45n W=145n
Mmn1 S1b S1 VSS VSS g45n1svt M=1 L=45n W=145n
Mmn6 n1 S1b n0 VSS g45n1svt M=1 L=45n W=260n
Mmp8 n1 S1b net202 VDD g45p1svt M=1 L=45n W=390n
Mmp7 net202 C VDD VDD g45p1svt M=1 L=45n W=390n
Mmp5 n0 S0b net190 VDD g45p1svt M=1 L=45n W=215n
Mmp4 net190 B VDD VDD g45p1svt M=1 L=45n W=215n
Mmp3 n0 S0 net189 VDD g45p1svt M=1 L=45n W=215n
Mmp2 net189 A VDD VDD g45p1svt M=1 L=45n W=215n
Mmp9 Y n1 VDD VDD g45p1svt M=1 L=45n W=1.56u
Mmp1 S1b S1 VDD VDD g45p1svt M=1 L=45n W=215n
Mmp6 n0 S1 n1 VDD g45p1svt M=1 L=45n W=390n
Mmp0 S0b S0 VDD VDD g45p1svt M=1 L=45n W=215n
.ENDS

.SUBCKT MX3X2 A B C S0 S1 VDD VSS Y
Mmn7 net245 C VSS VSS g45n1svt M=1 L=45n W=145n
Mmn8 n1 S1 net245 VSS g45n1svt M=1 L=45n W=145n
Mmn4 net234 B VSS VSS g45n1svt M=1 L=45n W=145n
Mmn5 n0 S0 net234 VSS g45n1svt M=1 L=45n W=145n
Mmn3 n0 S0b net229 VSS g45n1svt M=1 L=45n W=145n
Mmn2 net229 A VSS VSS g45n1svt M=1 L=45n W=145n
Mmn9 Y n1 VSS VSS g45n1svt M=1 L=45n W=520n
Mmn0 S0b S0 VSS VSS g45n1svt M=1 L=45n W=145n
Mmn1 S1b S1 VSS VSS g45n1svt M=1 L=45n W=145n
Mmn6 n1 S1b n0 VSS g45n1svt M=1 L=45n W=145n
Mmp8 n1 S1b net202 VDD g45p1svt M=1 L=45n W=215n
Mmp7 net202 C VDD VDD g45p1svt M=1 L=45n W=215n
Mmp5 n0 S0b net190 VDD g45p1svt M=1 L=45n W=215n
Mmp4 net190 B VDD VDD g45p1svt M=1 L=45n W=215n
Mmp3 n0 S0 net189 VDD g45p1svt M=1 L=45n W=215n
Mmp2 net189 A VDD VDD g45p1svt M=1 L=45n W=215n
Mmp9 Y n1 VDD VDD g45p1svt M=1 L=45n W=780n
Mmp1 S1b S1 VDD VDD g45p1svt M=1 L=45n W=215n
Mmp6 n0 S1 n1 VDD g45p1svt M=1 L=45n W=215n
Mmp0 S0b S0 VDD VDD g45p1svt M=1 L=45n W=215n
.ENDS

.SUBCKT MX3X1 A B C S0 S1 VDD VSS Y
Mmn7 net245 C VSS VSS g45n1svt M=1 L=45n W=145n
Mmn8 n1 S1 net245 VSS g45n1svt M=1 L=45n W=145n
Mmn4 net234 B VSS VSS g45n1svt M=1 L=45n W=145n
Mmn5 n0 S0 net234 VSS g45n1svt M=1 L=45n W=145n
Mmn3 n0 S0b net229 VSS g45n1svt M=1 L=45n W=145n
Mmn2 net229 A VSS VSS g45n1svt M=1 L=45n W=145n
Mmn9 Y n1 VSS VSS g45n1svt M=1 L=45n W=260n
Mmn0 S0b S0 VSS VSS g45n1svt M=1 L=45n W=145n
Mmn1 S1b S1 VSS VSS g45n1svt M=1 L=45n W=145n
Mmn6 n1 S1b n0 VSS g45n1svt M=1 L=45n W=145n
Mmp8 n1 S1b net202 VDD g45p1svt M=1 L=45n W=215n
Mmp7 net202 C VDD VDD g45p1svt M=1 L=45n W=215n
Mmp5 n0 S0b net190 VDD g45p1svt M=1 L=45n W=215n
Mmp4 net190 B VDD VDD g45p1svt M=1 L=45n W=215n
Mmp3 n0 S0 net189 VDD g45p1svt M=1 L=45n W=215n
Mmp2 net189 A VDD VDD g45p1svt M=1 L=45n W=215n
Mmp9 Y n1 VDD VDD g45p1svt M=1 L=45n W=390n
Mmp1 S1b S1 VDD VDD g45p1svt M=1 L=45n W=215n
Mmp6 n0 S1 n1 VDD g45p1svt M=1 L=45n W=215n
Mmp0 S0b S0 VDD VDD g45p1svt M=1 L=45n W=215n
.ENDS

.SUBCKT MX2XL A B S0 VDD VSS Y
Mmn3 n5 B VSS VSS g45n1svt M=1 L=45n W=145n
Mmn4 n0 S0 n5 VSS g45n1svt M=1 L=45n W=145n
Mmn0 S0b S0 VSS VSS g45n1svt M=1 L=45n W=145n
Mmn1 n3 A VSS VSS g45n1svt M=1 L=45n W=145n
Mmn5 Y n0 VSS VSS g45n1svt M=1 L=45n W=145n
Mmn2 n0 S0b n3 VSS g45n1svt M=1 L=45n W=145n
Mmp4 n0 S0b n6 VDD g45p1svt M=1 L=45n W=215n
Mmp3 n6 B VDD VDD g45p1svt M=1 L=45n W=215n
Mmp5 Y n0 VDD VDD g45p1svt M=1 L=45n W=215n
Mmp0 S0b S0 VDD VDD g45p1svt M=1 L=45n W=215n
Mmp2 n0 S0 n4 VDD g45p1svt M=1 L=45n W=215n
Mmp1 n4 A VDD VDD g45p1svt M=1 L=45n W=215n
.ENDS

.SUBCKT MX2X8 A B S0 VDD VSS Y
Mmn3 n5 B VSS VSS g45n1svt M=1 L=45n W=205n
Mmn4 n0 S0 n5 VSS g45n1svt M=1 L=45n W=205n
Mmn0 S0b S0 VSS VSS g45n1svt M=1 L=45n W=145n
Mmn1 n3 A VSS VSS g45n1svt M=1 L=45n W=205n
Mmn5 Y n0 VSS VSS g45n1svt M=1 L=45n W=2.065u
Mmn2 n0 S0b n3 VSS g45n1svt M=1 L=45n W=205n
Mmp4 n0 S0b n6 VDD g45p1svt M=1 L=45n W=310n
Mmp3 n6 B VDD VDD g45p1svt M=1 L=45n W=310n
Mmp5 Y n0 VDD VDD g45p1svt M=1 L=45n W=3.115u
Mmp0 S0b S0 VDD VDD g45p1svt M=1 L=45n W=215n
Mmp2 n0 S0 n4 VDD g45p1svt M=1 L=45n W=310n
Mmp1 n4 A VDD VDD g45p1svt M=1 L=45n W=310n
.ENDS

.SUBCKT MX2X6 A B S0 VDD VSS Y
Mmn3 n5 B VSS VSS g45n1svt M=1 L=45n W=205n
Mmn4 n0 S0 n5 VSS g45n1svt M=1 L=45n W=205n
Mmn0 S0b S0 VSS VSS g45n1svt M=1 L=45n W=145n
Mmn1 n3 A VSS VSS g45n1svt M=1 L=45n W=205n
Mmn5 Y n0 VSS VSS g45n1svt M=1 L=45n W=1.55u
Mmn2 n0 S0b n3 VSS g45n1svt M=1 L=45n W=205n
Mmp4 n0 S0b n6 VDD g45p1svt M=1 L=45n W=310n
Mmp3 n6 B VDD VDD g45p1svt M=1 L=45n W=310n
Mmp5 Y n0 VDD VDD g45p1svt M=1 L=45n W=2.35u
Mmp0 S0b S0 VDD VDD g45p1svt M=1 L=45n W=215n
Mmp2 n0 S0 n4 VDD g45p1svt M=1 L=45n W=310n
Mmp1 n4 A VDD VDD g45p1svt M=1 L=45n W=310n
.ENDS

.SUBCKT MX2X4 A B S0 VDD VSS Y
Mmn3 n5 B VSS VSS g45n1svt M=1 L=45n W=205n
Mmn4 n0 S0 n5 VSS g45n1svt M=1 L=45n W=205n
Mmn0 S0b S0 VSS VSS g45n1svt M=1 L=45n W=145n
Mmn1 n3 A VSS VSS g45n1svt M=1 L=45n W=205n
Mmn5 Y n0 VSS VSS g45n1svt M=1 L=45n W=1.04u
Mmn2 n0 S0b n3 VSS g45n1svt M=1 L=45n W=205n
Mmp4 n0 S0b n6 VDD g45p1svt M=1 L=45n W=310n
Mmp3 n6 B VDD VDD g45p1svt M=1 L=45n W=310n
Mmp5 Y n0 VDD VDD g45p1svt M=1 L=45n W=1.56u
Mmp0 S0b S0 VDD VDD g45p1svt M=1 L=45n W=215n
Mmp2 n0 S0 n4 VDD g45p1svt M=1 L=45n W=310n
Mmp1 n4 A VDD VDD g45p1svt M=1 L=45n W=310n
.ENDS

.SUBCKT MX2X2 A B S0 VDD VSS Y
Mmn3 n5 B VSS VSS g45n1svt M=1 L=45n W=145n
Mmn4 n0 S0 n5 VSS g45n1svt M=1 L=45n W=145n
Mmn0 S0b S0 VSS VSS g45n1svt M=1 L=45n W=145n
Mmn1 n3 A VSS VSS g45n1svt M=1 L=45n W=145n
Mmn5 Y n0 VSS VSS g45n1svt M=1 L=45n W=520n
Mmn2 n0 S0b n3 VSS g45n1svt M=1 L=45n W=145n
Mmp4 n0 S0b n6 VDD g45p1svt M=1 L=45n W=215n
Mmp3 n6 B VDD VDD g45p1svt M=1 L=45n W=215n
Mmp5 Y n0 VDD VDD g45p1svt M=1 L=45n W=780n
Mmp0 S0b S0 VDD VDD g45p1svt M=1 L=45n W=215n
Mmp2 n0 S0 n4 VDD g45p1svt M=1 L=45n W=215n
Mmp1 n4 A VDD VDD g45p1svt M=1 L=45n W=215n
.ENDS

.SUBCKT MX2X1 A B S0 VDD VSS Y
Mmn3 n5 B VSS VSS g45n1svt M=1 L=45n W=145n
Mmn4 n0 S0 n5 VSS g45n1svt M=1 L=45n W=145n
Mmn0 S0b S0 VSS VSS g45n1svt M=1 L=45n W=145n
Mmn1 n3 A VSS VSS g45n1svt M=1 L=45n W=145n
Mmn5 Y n0 VSS VSS g45n1svt M=1 L=45n W=260n
Mmn2 n0 S0b n3 VSS g45n1svt M=1 L=45n W=145n
Mmp4 n0 S0b n6 VDD g45p1svt M=1 L=45n W=215n
Mmp3 n6 B VDD VDD g45p1svt M=1 L=45n W=215n
Mmp5 Y n0 VDD VDD g45p1svt M=1 L=45n W=390n
Mmp0 S0b S0 VDD VDD g45p1svt M=1 L=45n W=215n
Mmp2 n0 S0 n4 VDD g45p1svt M=1 L=45n W=215n
Mmp1 n4 A VDD VDD g45p1svt M=1 L=45n W=215n
.ENDS

.SUBCKT MDFFHQX8 CK D0 D1 Q S0 VDD VSS
Mmn13 n12 D1 VSS VSS g45n1svt M=1 L=45n W=260n
Mmn14 D0b S0 n12 VSS g45n1svt M=1 L=45n W=260n
Mmn12 D0b S0b n10 VSS g45n1svt M=1 L=45n W=260n
Mmn11 n10 D0 VSS VSS g45n1svt M=1 L=45n W=260n
Mmn55 Q qbint VSS VSS g45n1svt M=1 L=45n W=2.065u
Mmn50 n35 qbint VSS VSS g45n1svt M=1 L=45n W=205n
Mmn51 n30 CKb n35 VSS g45n1svt M=1 L=45n W=205n
Mmn10 S0b S0 VSS VSS g45n1svt M=1 L=45n W=145n
Mmn40 mout CKbb n30 VSS g45n1svt M=1 L=45n W=205n
Mmn35 n25 mout VSS VSS g45n1svt M=1 L=45n W=205n
Mmn36 n20 CKbb n25 VSS g45n1svt M=1 L=45n W=205n
Mmn21 CKbb CKb VSS VSS g45n1svt M=1 L=45n W=145n
Mmn45 qbint n30 VSS VSS g45n1svt M=1 L=45n W=780n
Mmn25 D0b CKb n20 VSS g45n1svt M=1 L=45n W=205n
Mmn30 mout n20 VSS VSS g45n1svt M=1 L=45n W=205n
Mmn20 CKb CK VSS VSS g45n1svt M=1 L=45n W=145n
Mmp14 D0b S0b n13 VDD g45p1svt M=1 L=45n W=390n
Mmp13 n13 D1 VDD VDD g45p1svt M=1 L=45n W=390n
Mmp12 D0b S0 n11 VDD g45p1svt M=1 L=45n W=390n
Mmp11 n11 D0 VDD VDD g45p1svt M=1 L=45n W=390n
Mmp51 n30 CKbb n36 VDD g45p1svt M=1 L=45n W=310n
Mmp50 n36 qbint VDD VDD g45p1svt M=1 L=45n W=310n
Mmp55 Q qbint VDD VDD g45p1svt M=1 L=45n W=3.115u
Mmp35 n26 mout VDD VDD g45p1svt M=1 L=45n W=310n
Mmp36 n20 CKb n26 VDD g45p1svt M=1 L=45n W=310n
Mmp25 n20 CKbb D0b VDD g45p1svt M=1 L=45n W=310n
Mmp21 CKbb CKb VDD VDD g45p1svt M=1 L=45n W=215n
Mmp30 mout n20 VDD VDD g45p1svt M=1 L=45n W=310n
Mmp40 n30 CKb mout VDD g45p1svt M=1 L=45n W=310n
Mmp10 S0b S0 VDD VDD g45p1svt M=1 L=45n W=215n
Mmp45 qbint n30 VDD VDD g45p1svt M=1 L=45n W=1.17u
Mmp20 CKb CK VDD VDD g45p1svt M=1 L=45n W=215n
.ENDS

.SUBCKT MDFFHQX4 CK D0 D1 Q S0 VDD VSS
Mmn13 n12 D1 VSS VSS g45n1svt M=1 L=45n W=260n
Mmn14 D0b S0 n12 VSS g45n1svt M=1 L=45n W=260n
Mmn12 D0b S0b n10 VSS g45n1svt M=1 L=45n W=260n
Mmn11 n10 D0 VSS VSS g45n1svt M=1 L=45n W=260n
Mmn55 Q qbint VSS VSS g45n1svt M=1 L=45n W=1.04u
Mmn50 n35 qbint VSS VSS g45n1svt M=1 L=45n W=205n
Mmn51 n30 CKb n35 VSS g45n1svt M=1 L=45n W=205n
Mmn10 S0b S0 VSS VSS g45n1svt M=1 L=45n W=145n
Mmn40 mout CKbb n30 VSS g45n1svt M=1 L=45n W=205n
Mmn35 n25 mout VSS VSS g45n1svt M=1 L=45n W=205n
Mmn36 n20 CKbb n25 VSS g45n1svt M=1 L=45n W=205n
Mmn21 CKbb CKb VSS VSS g45n1svt M=1 L=45n W=145n
Mmn45 qbint n30 VSS VSS g45n1svt M=1 L=45n W=410n
Mmn25 D0b CKb n20 VSS g45n1svt M=1 L=45n W=205n
Mmn30 mout n20 VSS VSS g45n1svt M=1 L=45n W=205n
Mmn20 CKb CK VSS VSS g45n1svt M=1 L=45n W=145n
Mmp14 D0b S0b n13 VDD g45p1svt M=1 L=45n W=390n
Mmp13 n13 D1 VDD VDD g45p1svt M=1 L=45n W=390n
Mmp12 D0b S0 n11 VDD g45p1svt M=1 L=45n W=390n
Mmp11 n11 D0 VDD VDD g45p1svt M=1 L=45n W=390n
Mmp51 n30 CKbb n36 VDD g45p1svt M=1 L=45n W=310n
Mmp50 n36 qbint VDD VDD g45p1svt M=1 L=45n W=310n
Mmp55 Q qbint VDD VDD g45p1svt M=1 L=45n W=1.56u
Mmp35 n26 mout VDD VDD g45p1svt M=1 L=45n W=310n
Mmp36 n20 CKb n26 VDD g45p1svt M=1 L=45n W=310n
Mmp25 n20 CKbb D0b VDD g45p1svt M=1 L=45n W=310n
Mmp21 CKbb CKb VDD VDD g45p1svt M=1 L=45n W=215n
Mmp30 mout n20 VDD VDD g45p1svt M=1 L=45n W=310n
Mmp40 n30 CKb mout VDD g45p1svt M=1 L=45n W=310n
Mmp10 S0b S0 VDD VDD g45p1svt M=1 L=45n W=215n
Mmp45 qbint n30 VDD VDD g45p1svt M=1 L=45n W=620n
Mmp20 CKb CK VDD VDD g45p1svt M=1 L=45n W=215n
.ENDS

.SUBCKT MDFFHQX2 CK D0 D1 Q S0 VDD VSS
Mmn13 n12 D1 VSS VSS g45n1svt M=1 L=45n W=260n
Mmn14 D0b S0 n12 VSS g45n1svt M=1 L=45n W=260n
Mmn12 D0b S0b n10 VSS g45n1svt M=1 L=45n W=260n
Mmn11 n10 D0 VSS VSS g45n1svt M=1 L=45n W=260n
Mmn55 Q qbint VSS VSS g45n1svt M=1 L=45n W=520n
Mmn50 n35 qbint VSS VSS g45n1svt M=1 L=45n W=205n
Mmn51 n30 CKb n35 VSS g45n1svt M=1 L=45n W=205n
Mmn10 S0b S0 VSS VSS g45n1svt M=1 L=45n W=145n
Mmn40 mout CKbb n30 VSS g45n1svt M=1 L=45n W=205n
Mmn35 n25 mout VSS VSS g45n1svt M=1 L=45n W=205n
Mmn36 n20 CKbb n25 VSS g45n1svt M=1 L=45n W=205n
Mmn21 CKbb CKb VSS VSS g45n1svt M=1 L=45n W=145n
Mmn45 qbint n30 VSS VSS g45n1svt M=1 L=45n W=205n
Mmn25 D0b CKb n20 VSS g45n1svt M=1 L=45n W=205n
Mmn30 mout n20 VSS VSS g45n1svt M=1 L=45n W=205n
Mmn20 CKb CK VSS VSS g45n1svt M=1 L=45n W=145n
Mmp14 D0b S0b n13 VDD g45p1svt M=1 L=45n W=390n
Mmp13 n13 D1 VDD VDD g45p1svt M=1 L=45n W=390n
Mmp12 D0b S0 n11 VDD g45p1svt M=1 L=45n W=390n
Mmp11 n11 D0 VDD VDD g45p1svt M=1 L=45n W=390n
Mmp51 n30 CKbb n36 VDD g45p1svt M=1 L=45n W=310n
Mmp50 n36 qbint VDD VDD g45p1svt M=1 L=45n W=310n
Mmp55 Q qbint VDD VDD g45p1svt M=1 L=45n W=780n
Mmp35 n26 mout VDD VDD g45p1svt M=1 L=45n W=310n
Mmp36 n20 CKb n26 VDD g45p1svt M=1 L=45n W=310n
Mmp25 n20 CKbb D0b VDD g45p1svt M=1 L=45n W=310n
Mmp21 CKbb CKb VDD VDD g45p1svt M=1 L=45n W=215n
Mmp30 mout n20 VDD VDD g45p1svt M=1 L=45n W=310n
Mmp40 n30 CKb mout VDD g45p1svt M=1 L=45n W=310n
Mmp10 S0b S0 VDD VDD g45p1svt M=1 L=45n W=215n
Mmp45 qbint n30 VDD VDD g45p1svt M=1 L=45n W=310n
Mmp20 CKb CK VDD VDD g45p1svt M=1 L=45n W=215n
.ENDS

.SUBCKT MDFFHQX1 CK D0 D1 Q S0 VDD VSS
Mmn13 n12 D1 VSS VSS g45n1svt M=1 L=45n W=260n
Mmn14 D0b S0 n12 VSS g45n1svt M=1 L=45n W=260n
Mmn12 D0b S0b n10 VSS g45n1svt M=1 L=45n W=260n
Mmn11 n10 D0 VSS VSS g45n1svt M=1 L=45n W=260n
Mmn55 Q qbint VSS VSS g45n1svt M=1 L=45n W=260n
Mmn50 n35 qbint VSS VSS g45n1svt M=1 L=45n W=205n
Mmn51 n30 CKb n35 VSS g45n1svt M=1 L=45n W=205n
Mmn10 S0b S0 VSS VSS g45n1svt M=1 L=45n W=145n
Mmn40 mout CKbb n30 VSS g45n1svt M=1 L=45n W=205n
Mmn35 n25 mout VSS VSS g45n1svt M=1 L=45n W=205n
Mmn36 n20 CKbb n25 VSS g45n1svt M=1 L=45n W=205n
Mmn21 CKbb CKb VSS VSS g45n1svt M=1 L=45n W=145n
Mmn45 qbint n30 VSS VSS g45n1svt M=1 L=45n W=205n
Mmn25 D0b CKb n20 VSS g45n1svt M=1 L=45n W=205n
Mmn30 mout n20 VSS VSS g45n1svt M=1 L=45n W=205n
Mmn20 CKb CK VSS VSS g45n1svt M=1 L=45n W=145n
Mmp14 D0b S0b n13 VDD g45p1svt M=1 L=45n W=390n
Mmp13 n13 D1 VDD VDD g45p1svt M=1 L=45n W=390n
Mmp12 D0b S0 n11 VDD g45p1svt M=1 L=45n W=390n
Mmp11 n11 D0 VDD VDD g45p1svt M=1 L=45n W=390n
Mmp51 n30 CKbb n36 VDD g45p1svt M=1 L=45n W=310n
Mmp50 n36 qbint VDD VDD g45p1svt M=1 L=45n W=310n
Mmp55 Q qbint VDD VDD g45p1svt M=1 L=45n W=390n
Mmp35 n26 mout VDD VDD g45p1svt M=1 L=45n W=310n
Mmp36 n20 CKb n26 VDD g45p1svt M=1 L=45n W=310n
Mmp25 n20 CKbb D0b VDD g45p1svt M=1 L=45n W=310n
Mmp21 CKbb CKb VDD VDD g45p1svt M=1 L=45n W=215n
Mmp30 mout n20 VDD VDD g45p1svt M=1 L=45n W=310n
Mmp40 n30 CKb mout VDD g45p1svt M=1 L=45n W=310n
Mmp10 S0b S0 VDD VDD g45p1svt M=1 L=45n W=215n
Mmp45 qbint n30 VDD VDD g45p1svt M=1 L=45n W=310n
Mmp20 CKb CK VDD VDD g45p1svt M=1 L=45n W=215n
.ENDS

.SUBCKT LSLHX1_TO A ExtVDD VDD VSS Y
Mmn0 Y Ybint VSS VSS g45n1svt M=1 L=45n W=260n
MNM2 VSS A Ab VSS g45n1svt M=1 L=45n W=145n
MNM0 Ybint A VSS VSS g45n1svt M=1 L=45n W=780n
MNM1 Yint Ab VSS VSS g45n1svt M=1 L=45n W=780n
MPM0 Ybint Yint VDD VDD g45p1svt M=1 L=45n W=215n
MPM1 Yint Ybint VDD VDD g45p1svt M=1 L=45n W=215n
Mmp0 Y Ybint VDD VDD g45p1svt M=1 L=45n W=390n
MPM2 Ab A ExtVDD ExtVDD g45p1svt M=1 L=45n W=215n
.ENDS

.SUBCKT LSLHX1_FROM A ExtVDD VDD VSS Y
Mmn0 Y Ybint VSS VSS g45n1svt M=1 L=45n W=260n
MNM2 VSS A Ab VSS g45n1svt M=1 L=45n W=145n
MNM0 Ybint A VSS VSS g45n1svt M=1 L=45n W=780n
MNM1 Yint Ab VSS VSS g45n1svt M=1 L=45n W=780n
MPM0 Ybint Yint ExtVDD ExtVDD g45p1svt M=1 L=45n W=215n
MPM1 Yint Ybint ExtVDD ExtVDD g45p1svt M=1 L=45n W=215n
Mmp0 Y Ybint ExtVDD ExtVDD g45p1svt M=1 L=45n W=390n
MPM2 Ab A VDD VDD g45p1svt M=1 L=45n W=215n
.ENDS

.SUBCKT LSLH_ISONL_X1_TO_ON A ExtVDD ISOn VDD VSS Y
Mmn0 Y Ybint VSS VSS g45n1svt M=1 L=45n W=260n
MNM3 GatedVSS ISOn VSS VSS g45n1svt M=1 L=45n W=1.04u
MNM2 GatedVSS A Ab VSS g45n1svt M=1 L=45n W=145n
MNM0 Ybint A GatedVSS VSS g45n1svt M=1 L=45n W=780n
MNM1 Yint Ab GatedVSS VSS g45n1svt M=1 L=45n W=780n
MPM0 Ybint Yint VDD VDD g45p1svt M=1 L=45n W=215n
MPM3 Ybint ISOn VDD VDD g45p1svt M=1 L=45n W=215n
MPM1 Yint Ybint VDD VDD g45p1svt M=1 L=45n W=215n
Mmp0 Y Ybint VDD VDD g45p1svt M=1 L=45n W=390n
MPM2 Ab A ExtVDD ExtVDD g45p1svt M=1 L=45n W=215n
.ENDS

.SUBCKT LSLH_ISONL_X1_FROM_OFF A ExtVDD ISOn VDD VSS Y
Mmn0 Y Ybint VSS VSS g45n1svt M=1 L=45n W=260n
MNM3 GatedVSS ISOn VSS VSS g45n1svt M=1 L=45n W=1.04u
MNM2 GatedVSS A Ab VSS g45n1svt M=1 L=45n W=145n
MNM0 Ybint A GatedVSS VSS g45n1svt M=1 L=45n W=780n
MNM1 Yint Ab GatedVSS VSS g45n1svt M=1 L=45n W=780n
MPM0 Ybint Yint ExtVDD ExtVDD g45p1svt M=1 L=45n W=215n
MPM3 Ybint ISOn ExtVDD ExtVDD g45p1svt M=1 L=45n W=215n
MPM1 Yint Ybint ExtVDD ExtVDD g45p1svt M=1 L=45n W=215n
Mmp0 Y Ybint ExtVDD ExtVDD g45p1svt M=1 L=45n W=390n
MPM2 Ab A VDD VDD g45p1svt M=1 L=45n W=215n
.ENDS

.SUBCKT LSLH_ISONH_X1_TO_ON A ExtVDD ISOn VDD VSS Y
Mmn0 Y Ybint GatedVSS VSS g45n1svt M=1 L=45n W=260n
MNM3 GatedVSS ISOn VSS VSS g45n1svt M=1 L=45n W=1.04u
MNM2 GatedVSS A Ab VSS g45n1svt M=1 L=45n W=145n
MNM0 Ybint A GatedVSS VSS g45n1svt M=1 L=45n W=780n
MNM1 Yint Ab GatedVSS VSS g45n1svt M=1 L=45n W=780n
MPM0 Ybint Yint VDD VDD g45p1svt M=1 L=45n W=215n
MPM4 Y ISOn VDD VDD g45p1svt M=1 L=45n W=390n
MPM1 Yint Ybint VDD VDD g45p1svt M=1 L=45n W=215n
Mmp0 Y Ybint VDD VDD g45p1svt M=1 L=45n W=390n
MPM2 Ab A ExtVDD ExtVDD g45p1svt M=1 L=45n W=215n
.ENDS

.SUBCKT LSLH_ISONH_X1_FROM_OFF A ExtVDD ISOn VDD VSS Y
Mmn0 Y Ybint GatedVSS VSS g45n1svt M=1 L=45n W=260n
MNM3 GatedVSS ISOn VSS VSS g45n1svt M=1 L=45n W=1.04u
MNM2 GatedVSS A Ab VSS g45n1svt M=1 L=45n W=145n
MNM0 Ybint A GatedVSS VSS g45n1svt M=1 L=45n W=780n
MNM1 Yint Ab GatedVSS VSS g45n1svt M=1 L=45n W=780n
MPM0 Ybint Yint ExtVDD ExtVDD g45p1svt M=1 L=45n W=215n
MPM4 Y ISOn ExtVDD ExtVDD g45p1svt M=1 L=45n W=390n
MPM1 Yint Ybint ExtVDD ExtVDD g45p1svt M=1 L=45n W=215n
Mmp0 Y Ybint ExtVDD ExtVDD g45p1svt M=1 L=45n W=390n
MPM2 Ab A VDD VDD g45p1svt M=1 L=45n W=215n
.ENDS

.SUBCKT LSLH_ISOL_X1_TO_ON A ExtVDD ISO VDD VSS Y
Mmn0 Y Ybint VSS VSS g45n1svt M=1 L=45n W=260n
MNM3 GatedVSS ison VSS VSS g45n1svt M=1 L=45n W=1.04u
MNM2 GatedVSS A Ab VSS g45n1svt M=1 L=45n W=145n
MNM0 Ybint A GatedVSS VSS g45n1svt M=1 L=45n W=780n
MNM1 Yint Ab GatedVSS VSS g45n1svt M=1 L=45n W=780n
MNM4 VSS ISO ison VSS g45n1svt M=1 L=45n W=145n
MPM0 Ybint Yint VDD VDD g45p1svt M=1 L=45n W=215n
MPM3 Ybint ison VDD VDD g45p1svt M=1 L=45n W=215n
MPM1 Yint Ybint VDD VDD g45p1svt M=1 L=45n W=215n
Mmp0 Y Ybint VDD VDD g45p1svt M=1 L=45n W=390n
MPM5 ison ISO VDD VDD g45p1svt M=1 L=45n W=215n
MPM2 Ab A ExtVDD ExtVDD g45p1svt M=1 L=45n W=215n
.ENDS

.SUBCKT LSLH_ISOL_X1_FROM_OFF A ExtVDD ISO VDD VSS Y
Mmn0 Y Ybint VSS VSS g45n1svt M=1 L=45n W=260n
MNM3 GatedVSS ison VSS VSS g45n1svt M=1 L=45n W=1.04u
MNM2 GatedVSS A Ab VSS g45n1svt M=1 L=45n W=145n
MNM0 Ybint A GatedVSS VSS g45n1svt M=1 L=45n W=780n
MNM1 Yint Ab GatedVSS VSS g45n1svt M=1 L=45n W=780n
MNM4 VSS ISO ison VSS g45n1svt M=1 L=45n W=145n
MPM0 Ybint Yint ExtVDD ExtVDD g45p1svt M=1 L=45n W=215n
MPM3 Ybint ison ExtVDD ExtVDD g45p1svt M=1 L=45n W=215n
MPM1 Yint Ybint ExtVDD ExtVDD g45p1svt M=1 L=45n W=215n
Mmp0 Y Ybint ExtVDD ExtVDD g45p1svt M=1 L=45n W=390n
MPM5 ison ISO ExtVDD ExtVDD g45p1svt M=1 L=45n W=215n
MPM2 Ab A VDD VDD g45p1svt M=1 L=45n W=215n
.ENDS

.SUBCKT LSLH_ISOH_X1_TO_ON A ExtVDD ISO VDD VSS Y
Mmn0 Y Ybint GatedVSS VSS g45n1svt M=1 L=45n W=260n
MNM3 GatedVSS ison VSS VSS g45n1svt M=1 L=45n W=1.04u
MNM2 GatedVSS A Ab VSS g45n1svt M=1 L=45n W=145n
MNM0 Ybint A GatedVSS VSS g45n1svt M=1 L=45n W=780n
MNM1 Yint Ab GatedVSS VSS g45n1svt M=1 L=45n W=780n
MNM4 VSS ISO ison VSS g45n1svt M=1 L=45n W=145n
MPM0 Ybint Yint VDD VDD g45p1svt M=1 L=45n W=215n
MPM4 Y ison VDD VDD g45p1svt M=1 L=45n W=390n
MPM1 Yint Ybint VDD VDD g45p1svt M=1 L=45n W=215n
Mmp0 Y Ybint VDD VDD g45p1svt M=1 L=45n W=390n
MPM5 ison ISO VDD VDD g45p1svt M=1 L=45n W=215n
MPM2 Ab A ExtVDD ExtVDD g45p1svt M=1 L=45n W=215n
.ENDS

.SUBCKT LSLH_ISOH_X1_FROM_OFF A ExtVDD ISO VDD VSS Y
Mmn0 Y Ybint GatedVSS VSS g45n1svt M=1 L=45n W=260n
MNM3 GatedVSS ison VSS VSS g45n1svt M=1 L=45n W=1.04u
MNM2 GatedVSS A Ab VSS g45n1svt M=1 L=45n W=145n
MNM0 Ybint A GatedVSS VSS g45n1svt M=1 L=45n W=780n
MNM1 Yint Ab GatedVSS VSS g45n1svt M=1 L=45n W=780n
MNM4 VSS ISO ison VSS g45n1svt M=1 L=45n W=145n
MPM0 Ybint Yint ExtVDD ExtVDD g45p1svt M=1 L=45n W=215n
MPM4 Y ison ExtVDD ExtVDD g45p1svt M=1 L=45n W=390n
MPM1 Yint Ybint ExtVDD ExtVDD g45p1svt M=1 L=45n W=215n
Mmp0 Y Ybint ExtVDD ExtVDD g45p1svt M=1 L=45n W=390n
MPM2 Ab A VDD VDD g45p1svt M=1 L=45n W=215n
MPM5 ison ISO ExtVDD ExtVDD g45p1svt M=1 L=45n W=215n
.ENDS

.SUBCKT LSHLX1_TO A VDD VSS Y
MNM0 Y n0 VSS VSS g45n1svt M=1 L=45n W=260n
Mmn0 VSS A n0 VSS g45n1svt M=1 L=45n W=145n
MPM0 Y n0 VDD VDD g45p1svt M=1 L=45n W=390n
Mmp0 n0 A VDD VDD g45p1svt M=1 L=45n W=215n
.ENDS

.SUBCKT LSHLX1_FROM A ExtVDD VDD VSS Y
MNM0 Y n0 VSS VSS g45n1svt M=1 L=45n W=260n
Mmn0 n0 A VSS VSS g45n1svt M=1 L=45n W=145n
MPM0 Y n0 ExtVDD ExtVDD g45p1svt M=1 L=45n W=390n
Mmp0 n0 A ExtVDD ExtVDD g45p1svt M=1 L=45n W=215n
.ENDS

.SUBCKT LSHL_ISONL_X1_TO_ON A ISOn VDD VSS Y
MNM3 GatedVSS ISOn VSS VSS g45n1svt M=1 L=45n W=520n
MNM0 Y n0 VSS VSS g45n1svt M=1 L=45n W=260n
Mmn0 GatedVSS A n0 VSS g45n1svt M=1 L=45n W=145n
MPM1 n0 ISOn VDD VDD g45p1svt M=1 L=45n W=215n
MPM0 Y n0 VDD VDD g45p1svt M=1 L=45n W=390n
Mmp0 n0 A VDD VDD g45p1svt M=1 L=45n W=215n
.ENDS

.SUBCKT LSHL_ISONL_X1_FROM_OFF A ExtVDD ISOn VDD VSS Y
MNM3 GatedVSS ISOn VSS VSS g45n1svt M=1 L=45n W=520n
MNM0 Y n0 VSS VSS g45n1svt M=1 L=45n W=260n
Mmn0 GatedVSS A n0 VSS g45n1svt M=1 L=45n W=145n
MPM2 n0 ISOn ExtVDD ExtVDD g45p1svt M=1 L=45n W=215n
MPM0 Y n0 ExtVDD ExtVDD g45p1svt M=1 L=45n W=390n
Mmp0 n0 A ExtVDD ExtVDD g45p1svt M=1 L=45n W=215n
.ENDS

.SUBCKT LSHL_ISONH_X1_TO_ON A ISOn VDD VSS Y
MNM3 gatedVSS ISOn VSS VSS g45n1svt M=1 L=45n W=520n
MNM0 Y n0 gatedVSS VSS g45n1svt M=1 L=45n W=260n
Mmn0 gatedVSS A n0 VSS g45n1svt M=1 L=45n W=145n
MPM4 Y ISOn VDD VDD g45p1svt M=1 L=45n W=390n
MPM0 Y n0 VDD VDD g45p1svt M=1 L=45n W=390n
Mmp0 n0 A VDD VDD g45p1svt M=1 L=45n W=215n
.ENDS

.SUBCKT LSHL_ISONH_X1_FROM_OFF A ExtVDD ISOn VDD VSS Y
MNM3 gatedVSS ISOn VSS VSS g45n1svt M=1 L=45n W=520n
MNM0 Y n0 gatedVSS VSS g45n1svt M=1 L=45n W=260n
Mmn0 gatedVSS A n0 VSS g45n1svt M=1 L=45n W=145n
MPM4 Y ISOn ExtVDD ExtVDD g45p1svt M=1 L=45n W=390n
MPM0 Y n0 ExtVDD ExtVDD g45p1svt M=1 L=45n W=390n
Mmp0 n0 A ExtVDD ExtVDD g45p1svt M=1 L=45n W=215n
.ENDS

.SUBCKT LSHL_ISOL_X1_TO_ON A ISO VDD VSS Y
MNM1 VSS ISO ison VSS g45n1svt M=1 L=45n W=145n
MNM3 GatedVSS ison VSS VSS g45n1svt M=1 L=45n W=520n
MNM0 Y n0 VSS VSS g45n1svt M=1 L=45n W=260n
Mmn0 GatedVSS A n0 VSS g45n1svt M=1 L=45n W=145n
MPM2 ison ISO VDD VDD g45p1svt M=1 L=45n W=215n
MPM1 n0 ison VDD VDD g45p1svt M=1 L=45n W=215n
MPM0 Y n0 VDD VDD g45p1svt M=1 L=45n W=390n
Mmp0 n0 A VDD VDD g45p1svt M=1 L=45n W=215n
.ENDS

.SUBCKT LSHL_ISOL_X1_FROM_OFF A ExtVDD ISO VDD VSS Y
MNM1 VSS ISO ison VSS g45n1svt M=1 L=45n W=145n
MNM3 GatedVSS ison VSS VSS g45n1svt M=1 L=45n W=520n
MNM0 Y n0 VSS VSS g45n1svt M=1 L=45n W=260n
Mmn0 GatedVSS A n0 VSS g45n1svt M=1 L=45n W=145n
MPM1 ison ISO ExtVDD ExtVDD g45p1svt M=1 L=45n W=215n
MPM2 n0 ison ExtVDD ExtVDD g45p1svt M=1 L=45n W=215n
MPM0 Y n0 ExtVDD ExtVDD g45p1svt M=1 L=45n W=390n
Mmp0 n0 A ExtVDD ExtVDD g45p1svt M=1 L=45n W=215n
.ENDS

.SUBCKT LSHL_ISOH_X1_TO_ON A ISO VDD VSS Y
MNM1 VSS ISO ison VSS g45n1svt M=1 L=45n W=145n
MNM3 gatedVSS ison VSS VSS g45n1svt M=1 L=45n W=520n
MNM0 Y n0 gatedVSS VSS g45n1svt M=1 L=45n W=260n
Mmn0 gatedVSS A n0 VSS g45n1svt M=1 L=45n W=145n
MPM1 ison ISO VDD VDD g45p1svt M=1 L=45n W=215n
MPM4 Y ison VDD VDD g45p1svt M=1 L=45n W=390n
MPM0 Y n0 VDD VDD g45p1svt M=1 L=45n W=390n
Mmp0 n0 A VDD VDD g45p1svt M=1 L=45n W=215n
.ENDS

.SUBCKT LSHL_ISOH_X1_FROM_OFF A ExtVDD ISO VDD VSS Y
MNM1 ison ISO VSS VSS g45n1svt M=1 L=45n W=145n
MNM3 VSS ison gatedVSS VSS g45n1svt M=1 L=45n W=520n
MNM0 Y n0 gatedVSS VSS g45n1svt M=1 L=45n W=260n
Mmn0 n0 A gatedVSS VSS g45n1svt M=1 L=45n W=145n
MPM1 ison ISO ExtVDD ExtVDD g45p1svt M=1 L=45n W=215n
MPM4 Y ison ExtVDD ExtVDD g45p1svt M=1 L=45n W=390n
MPM0 Y n0 ExtVDD ExtVDD g45p1svt M=1 L=45n W=390n
Mmp0 n0 A ExtVDD ExtVDD g45p1svt M=1 L=45n W=215n
.ENDS

.SUBCKT ISONLX1_ON A ISOn VDD VSS Y
Mmn2 Y n0 VSS VSS g45n1svt M=1 L=45n W=260n
Mmn0 net127 ISOn VSS VSS g45n1svt M=1 L=45n W=145n
Mmn1 n0 A net127 VSS g45n1svt M=1 L=45n W=145n
Mmp1 n0 ISOn VDD VDD g45p1svt M=1 L=45n W=215n
Mmp0 n0 A VDD VDD g45p1svt M=1 L=45n W=215n
Mmp2 Y n0 VDD VDD g45p1svt M=1 L=45n W=390n
.ENDS

.SUBCKT ISONLX1_OFF A ExtVDD ISOn VDD VSS Y
Mmn2 Y n0 VSS VSS g45n1svt M=1 L=45n W=260n
Mmn0 net127 ISOn VSS VSS g45n1svt M=1 L=45n W=145n
Mmn1 n0 A net127 VSS g45n1svt M=1 L=45n W=145n
Mmp1 n0 ISOn ExtVDD ExtVDD g45p1svt M=1 L=45n W=215n
Mmp0 n0 A ExtVDD ExtVDD g45p1svt M=1 L=45n W=215n
Mmp2 Y n0 ExtVDD ExtVDD g45p1svt M=1 L=45n W=390n
.ENDS

.SUBCKT ISOLX1_ON A ISO VDD VSS Y
MNM1 VSS ISO ison VSS g45n1svt M=1 L=45n W=145n
Mmn2 Y n0 VSS VSS g45n1svt M=1 L=45n W=260n
Mmn0 net127 ison VSS VSS g45n1svt M=1 L=45n W=145n
Mmn1 n0 A net127 VSS g45n1svt M=1 L=45n W=145n
MPM1 ison ISO VDD VDD g45p1svt M=1 L=45n W=215n
Mmp1 n0 ison VDD VDD g45p1svt M=1 L=45n W=215n
Mmp0 n0 A VDD VDD g45p1svt M=1 L=45n W=215n
Mmp2 Y n0 VDD VDD g45p1svt M=1 L=45n W=390n
.ENDS

.SUBCKT ISOLX1_OFF A ExtVDD ISO VDD VSS Y
MNM1 VSS ISO ison VSS g45n1svt M=1 L=45n W=145n
Mmn2 Y n0 VSS VSS g45n1svt M=1 L=45n W=260n
Mmn0 net127 ison VSS VSS g45n1svt M=1 L=45n W=145n
Mmn1 n0 A net127 VSS g45n1svt M=1 L=45n W=145n
MPM1 ison ISO ExtVDD ExtVDD g45p1svt M=1 L=45n W=215n
Mmp1 n0 ison ExtVDD ExtVDD g45p1svt M=1 L=45n W=215n
Mmp0 n0 A ExtVDD ExtVDD g45p1svt M=1 L=45n W=215n
Mmp2 Y n0 ExtVDD ExtVDD g45p1svt M=1 L=45n W=390n
.ENDS

.SUBCKT ISOHX1_ON A ISO VDD VSS Y
Mmn2 Y n0 VSS VSS g45n1svt M=1 L=45n W=260n
Mmn0 n0 A VSS VSS g45n1svt M=1 L=45n W=145n
Mmn1 n0 ISO VSS VSS g45n1svt M=1 L=45n W=145n
Mmp1 n0 ISO n1 VDD g45p1svt M=1 L=45n W=215n
Mmp2 Y n0 VDD VDD g45p1svt M=1 L=45n W=390n
Mmp0 n1 A VDD VDD g45p1svt M=1 L=45n W=215n
.ENDS

.SUBCKT ISOHX1_OFF A ExtVDD ISO VDD VSS Y
Mmn2 Y n0 VSS VSS g45n1svt M=1 L=45n W=260n
Mmn0 n0 A VSS VSS g45n1svt M=1 L=45n W=145n
Mmn1 n0 ISO VSS VSS g45n1svt M=1 L=45n W=145n
Mmp1 n0 ISO n1 ExtVDD g45p1svt M=1 L=45n W=215n
Mmp2 Y n0 ExtVDD ExtVDD g45p1svt M=1 L=45n W=390n
Mmp0 n1 A ExtVDD ExtVDD g45p1svt M=1 L=45n W=215n
.ENDS

.SUBCKT ISOHLDX1_ON D ISO Q VDD VSS
Mmn5 net257 D VSS VSS g45n1svt M=1 L=45n W=145n
Mmn6 n0 GNb net257 VSS g45n1svt M=1 L=45n W=145n
Mmn16 n0 GNbb net245 VSS g45n1svt M=1 L=45n W=145n
Mmn15 net245 Qint VSS VSS g45n1svt M=1 L=45n W=145n
Mmn21 Q Qbint VSS VSS g45n1svt M=1 L=45n W=260n
Mmn0 GNb ISO VSS VSS g45n1svt M=1 L=45n W=145n
Mmn1 GNbb GNb VSS VSS g45n1svt M=1 L=45n W=145n
Mmn10 Qint n0 VSS VSS g45n1svt M=1 L=45n W=145n
Mmn20 Qbint Qint VSS VSS g45n1svt M=1 L=45n W=260n
Mmp6 n0 GNbb net220 VDD g45p1svt M=1 L=45n W=215n
Mmp5 net220 D VDD VDD g45p1svt M=1 L=45n W=215n
Mmp16 n0 GNb net212 VDD g45p1svt M=1 L=45n W=215n
Mmp15 net212 Qint VDD VDD g45p1svt M=1 L=45n W=215n
Mmp21 Q Qbint VDD VDD g45p1svt M=1 L=45n W=390n
Mmp0 GNb ISO VDD VDD g45p1svt M=1 L=45n W=215n
Mmp1 GNbb GNb VDD VDD g45p1svt M=1 L=45n W=215n
Mmp10 Qint n0 VDD VDD g45p1svt M=1 L=45n W=215n
Mmp20 Qbint Qint VDD VDD g45p1svt M=1 L=45n W=390n
.ENDS

.SUBCKT ISOHLDX1_OFF D ExtVDD ISO Q VDD VSS
Mmn5 net257 D VSS VSS g45n1svt M=1 L=45n W=145n
Mmn6 n0 GNb net257 VSS g45n1svt M=1 L=45n W=145n
Mmn16 n0 GNbb net245 VSS g45n1svt M=1 L=45n W=145n
Mmn15 net245 Qint VSS VSS g45n1svt M=1 L=45n W=145n
Mmn21 Q Qbint VSS VSS g45n1svt M=1 L=45n W=260n
Mmn0 GNb ISO VSS VSS g45n1svt M=1 L=45n W=145n
Mmn1 GNbb GNb VSS VSS g45n1svt M=1 L=45n W=145n
Mmn10 Qint n0 VSS VSS g45n1svt M=1 L=45n W=145n
Mmn20 Qbint Qint VSS VSS g45n1svt M=1 L=45n W=260n
Mmp6 n0 GNbb net220 ExtVDD g45p1svt M=1 L=45n W=215n
Mmp5 net220 D ExtVDD ExtVDD g45p1svt M=1 L=45n W=215n
Mmp16 n0 GNb net212 ExtVDD g45p1svt M=1 L=45n W=215n
Mmp15 net212 Qint ExtVDD ExtVDD g45p1svt M=1 L=45n W=215n
Mmp21 Q Qbint ExtVDD ExtVDD g45p1svt M=1 L=45n W=390n
Mmp0 GNb ISO ExtVDD ExtVDD g45p1svt M=1 L=45n W=215n
Mmp1 GNbb GNb ExtVDD ExtVDD g45p1svt M=1 L=45n W=215n
Mmp10 Qint n0 ExtVDD ExtVDD g45p1svt M=1 L=45n W=215n
Mmp20 Qbint Qint ExtVDD ExtVDD g45p1svt M=1 L=45n W=390n
.ENDS

.SUBCKT INVXL A VDD VSS Y
Mmp0 Y A VDD VDD g45p1svt M=1 L=45n W=215n
Mmn0 Y A VSS VSS g45n1svt M=1 L=45n W=145n
.ENDS

.SUBCKT INVX8 A VDD VSS Y
Mmp0 Y A VDD VDD g45p1svt M=1 L=45n W=3.115u
Mmn0 Y A VSS VSS g45n1svt M=1 L=45n W=2.065u
.ENDS

.SUBCKT INVX6 A VDD VSS Y
Mmp0 Y A VDD VDD g45p1svt M=1 L=45n W=2.35u
Mmn0 Y A VSS VSS g45n1svt M=1 L=45n W=1.55u
.ENDS

.SUBCKT INVX4 A VDD VSS Y
Mmp0 Y A VDD VDD g45p1svt M=1 L=45n W=1.56u
Mmn0 Y A VSS VSS g45n1svt M=1 L=45n W=1.04u
.ENDS

.SUBCKT INVX3 A VDD VSS Y
Mmp0 Y A VDD VDD g45p1svt M=1 L=45n W=1.17u
Mmn0 Y A VSS VSS g45n1svt M=1 L=45n W=780n
.ENDS

.SUBCKT INVX2 A VDD VSS Y
Mmp0 Y A VDD VDD g45p1svt M=1 L=45n W=780n
Mmn0 Y A VSS VSS g45n1svt M=1 L=45n W=520n
.ENDS

.SUBCKT INVX20 A VDD VSS Y
Mmp0 Y A VDD VDD g45p1svt M=1 L=45n W=7.82u
Mmn0 Y A VSS VSS g45n1svt M=1 L=45n W=5.185u
.ENDS

.SUBCKT INVX16 A VDD VSS Y
Mmp0 Y A VDD VDD g45p1svt M=1 L=45n W=6.23u
Mmn0 Y A VSS VSS g45n1svt M=1 L=45n W=4.13u
.ENDS

.SUBCKT INVX12 A VDD VSS Y
Mmp0 Y A VDD VDD g45p1svt M=1 L=45n W=4.7u
Mmn0 Y A VSS VSS g45n1svt M=1 L=45n W=3.1u
.ENDS

.SUBCKT HSWX1 ExtVDD PSO PSO_out VDD VSS
MPM2 pson PSO ExtVDD ExtVDD g45p1svt M=1 L=45n W=390n
MPM6 PSO_out pson ExtVDD ExtVDD g45p1svt M=1 L=45n W=390n
MPM1 n0 pson ExtVDD ExtVDD g45p1svt M=1 L=45n W=900n
MNM2 VSS PSO pson VSS g45n1svt M=1 L=45n W=260n
MNM4 PSO_out pson VSS VSS g45n1svt M=1 L=45n W=260n
MNM0 VSS pson n0 VSS g45n1svt M=1 L=45n W=600n
MPM0 VDD n0 ExtVDD ExtVDD g45p1hvt M=20 L=45n W=1.8u
.ENDS

.SUBCKT HSWNX1 ExtVDD PSOn PSOn_out VDD VSS
MPM6 PSOn_out n0 ExtVDD ExtVDD g45p1svt M=2 L=45n W=900n
MPM1 n0 PSOn ExtVDD ExtVDD g45p1svt M=2 L=45n W=450n
MNM4 PSOn_out n0 VSS VSS g45n1svt M=2 L=45n W=600n
MNM0 VSS PSOn n0 VSS g45n1svt M=2 L=45n W=300n
MPM0 VDD n0 ExtVDD ExtVDD g45p1hvt M=20 L=45n W=1.8u
.ENDS

.SUBCKT HSWDX1 ExtVDD PSO1 PSO1_out PSO2 PSO2_out VDD VSS
MPM5 PSO2_out pso2n ExtVDD ExtVDD g45p1svt M=1 L=45n W=390n
MPM2 n2 pso2n ExtVDD ExtVDD g45p1svt M=1 L=45n W=450n
MPM8 pso1n PSO1 ExtVDD ExtVDD g45p1svt M=1 L=45n W=390n
MPM7 pso2n PSO2 ExtVDD ExtVDD g45p1svt M=1 L=45n W=390n
MPM1 n1 pso1n ExtVDD ExtVDD g45p1svt M=1 L=45n W=1.8u
MPM6 PSO1_out pso1n ExtVDD ExtVDD g45p1svt M=1 L=45n W=390n
MNM5 pso1n PSO1 VSS VSS g45n1svt M=1 L=45n W=260n
MNM3 PSO2_out pso2n VSS VSS g45n1svt M=1 L=45n W=260n
MNM1 n2 pso2n VSS VSS g45n1svt M=1 L=45n W=300n
MNM2 pso2n PSO2 VSS VSS g45n1svt M=1 L=45n W=260n
MNM0 n1 pso1n VSS VSS g45n1svt M=1 L=45n W=1.2u
MNM4 PSO1_out pso1n VSS VSS g45n1svt M=1 L=45n W=260n
MPM3 VDD n2 ExtVDD ExtVDD g45p1hvt M=1 L=45n W=450n
MPM0 VDD n1 ExtVDD ExtVDD g45p1hvt M=12 L=45n W=1.8u
.ENDS

.SUBCKT HSWDNX1 ExtVDD PSO1n PSO1n_out PSO2n PSO2n_out VDD VSS
MPM5 PSO2n_out n2 ExtVDD ExtVDD g45p1svt M=1 L=45n W=900n
MPM2 n2 PSO2n ExtVDD ExtVDD g45p1svt M=1 L=45n W=450n
MPM1 n1 PSO1n ExtVDD ExtVDD g45p1svt M=2 L=45n W=900n
MPM6 PSO1n_out n1 ExtVDD ExtVDD g45p1svt M=1 L=45n W=900n
MNM3 VSS n2 PSO2n_out VSS g45n1svt M=1 L=45n W=600n
MNM1 VSS PSO2n n2 VSS g45n1svt M=1 L=45n W=300n
MNM0 VSS PSO1n n1 VSS g45n1svt M=2 L=45n W=600n
MNM4 VSS n1 PSO1n_out VSS g45n1svt M=1 L=45n W=600n
MPM3 VDD n2 ExtVDD ExtVDD g45p1hvt M=1 L=45n W=450n
MPM0 VDD n1 ExtVDD ExtVDD g45p1hvt M=12 L=45n W=1.8u
.ENDS

.SUBCKT HOLDX1 VDD VSS Y
Mmn1 Y n0 n1 VSS g45n1svt M=1 L=45n W=145n
Mmn0 n0 Y VSS VSS g45n1svt M=1 L=45n W=260n
Mmn2 n1 n0 n2 VSS g45n1svt M=1 L=45n W=145n
Mmn3 n2 n0 VSS VSS g45n1svt M=1 L=45n W=145n
Mmp2 p1 n0 p2 VDD g45p1svt M=1 L=45n W=215n
Mmp1 Y n0 p1 VDD g45p1svt M=1 L=45n W=215n
Mmp3 p2 n0 VDD VDD g45p1svt M=1 L=45n W=215n
Mmp0 n0 Y VDD VDD g45p1svt M=1 L=45n W=390n
.ENDS

.SUBCKT FSWX1 ExtVSS PSO PSO_out VDD VSS
MPM1 PSO_out n0 VDD VDD g45p1svt M=1 L=45n W=1.8u
Mmp0 n0 PSO VDD VDD g45p1svt M=1 L=45n W=900n
MNM0 ExtVSS n0 PSO_out ExtVSS g45n1svt M=1 L=45n W=1.2u
Mmn0 ExtVSS PSO n0 ExtVSS g45n1svt M=1 L=45n W=600n
MNM1 ExtVSS n0 VSS ExtVSS g45n1hvt M=20 L=45n W=1.2u
.ENDS

.SUBCKT FSWNX1 ExtVSS PSOn PSOn_out VDD VSS
MPM2 pso PSOn VDD VDD g45p1svt M=1 L=45n W=390n
MPM1 PSOn_out pso VDD VDD g45p1svt M=1 L=45n W=390n
Mmp0 n0 pso VDD VDD g45p1svt M=1 L=45n W=900n
MNM2 ExtVSS PSOn pso ExtVSS g45n1svt M=1 L=45n W=260n
MNM0 ExtVSS pso PSOn_out ExtVSS g45n1svt M=1 L=45n W=260n
Mmn0 ExtVSS pso n0 ExtVSS g45n1svt M=1 L=45n W=600n
MNM1 ExtVSS n0 VSS ExtVSS g45n1hvt M=20 L=45n W=1.2u
.ENDS

.SUBCKT FILL8 VDD VSS
.ENDS

.SUBCKT FILL64 VDD VSS
.ENDS

.SUBCKT FILL4 VDD VSS
.ENDS

.SUBCKT FILL32 VDD VSS
.ENDS

.SUBCKT FILL2 VDD VSS
.ENDS

.SUBCKT FILL1 VDD VSS
.ENDS

.SUBCKT FILL16 VDD VSS
.ENDS

.SUBCKT EDFFXL CK D E Q QN VDD VSS
Mmn3 Db E n0 VSS g45n1svt M=1 L=45n W=145n
Mmn2 n0 D VSS VSS g45n1svt M=1 L=45n W=145n
Mmn57 QN qint VSS VSS g45n1svt M=1 L=45n W=145n
Mmn55 Q qbint VSS VSS g45n1svt M=1 L=45n W=145n
Mmn51 n30 Ckb net415 VSS g45n1svt M=1 L=45n W=145n
Mmn50 net415 qbint VSS VSS g45n1svt M=1 L=45n W=145n
Mmn35 net411 mout VSS VSS g45n1svt M=1 L=45n W=145n
Mmn36 n20 CKbb net411 VSS g45n1svt M=1 L=45n W=145n
Mmn20 Ckb CK VSS VSS g45n1svt M=1 L=45n W=145n
Mmn45 qbint n30 VSS VSS g45n1svt M=1 L=45n W=145n
Mmn56 qint qbint VSS VSS g45n1svt M=1 L=45n W=145n
Mmn0 Eb E VSS VSS g45n1svt M=1 L=45n W=145n
Mmn30 mout n20 VSS VSS g45n1svt M=1 L=45n W=145n
Mmn21 CKbb Ckb VSS VSS g45n1svt M=1 L=45n W=145n
Mmn40 mout CKbb n30 VSS g45n1svt M=1 L=45n W=145n
Mmn1 qbint Eb Db VSS g45n1svt M=1 L=45n W=145n
Mmn25 Db Ckb n20 VSS g45n1svt M=1 L=45n W=145n
Mmp3 Db Eb n1 VDD g45p1svt M=1 L=45n W=215n
Mmp2 n1 D VDD VDD g45p1svt M=1 L=45n W=215n
Mmp51 n30 CKbb net362 VDD g45p1svt M=1 L=45n W=215n
Mmp50 net362 qbint VDD VDD g45p1svt M=1 L=45n W=215n
Mmp57 QN qint VDD VDD g45p1svt M=1 L=45n W=215n
Mmp55 Q qbint VDD VDD g45p1svt M=1 L=45n W=215n
Mmp35 net342 mout VDD VDD g45p1svt M=1 L=45n W=215n
Mmp36 n20 Ckb net342 VDD g45p1svt M=1 L=45n W=215n
Mmp20 Ckb CK VDD VDD g45p1svt M=1 L=45n W=215n
Mmp45 qbint n30 VDD VDD g45p1svt M=1 L=45n W=215n
Mmp56 qint qbint VDD VDD g45p1svt M=1 L=45n W=215n
Mmp21 CKbb Ckb VDD VDD g45p1svt M=1 L=45n W=215n
Mmp40 n30 Ckb mout VDD g45p1svt M=1 L=45n W=215n
Mmp30 mout n20 VDD VDD g45p1svt M=1 L=45n W=215n
Mmp25 n20 CKbb Db VDD g45p1svt M=1 L=45n W=215n
Mmp0 Eb E VDD VDD g45p1svt M=1 L=45n W=215n
Mmp1 qbint E Db VDD g45p1svt M=1 L=45n W=215n
.ENDS

.SUBCKT EDFFX4 CK D E Q QN VDD VSS
Mmn3 Db E n0 VSS g45n1svt M=1 L=45n W=145n
Mmn2 n0 D VSS VSS g45n1svt M=1 L=45n W=145n
Mmn57 QN qint VSS VSS g45n1svt M=1 L=45n W=1.04u
Mmn55 Q qbint VSS VSS g45n1svt M=1 L=45n W=1.04u
Mmn51 n30 Ckb net415 VSS g45n1svt M=1 L=45n W=145n
Mmn50 net415 qbint VSS VSS g45n1svt M=1 L=45n W=145n
Mmn35 net411 mout VSS VSS g45n1svt M=1 L=45n W=145n
Mmn36 n20 CKbb net411 VSS g45n1svt M=1 L=45n W=145n
Mmn20 Ckb CK VSS VSS g45n1svt M=1 L=45n W=145n
Mmn45 qbint n30 VSS VSS g45n1svt M=1 L=45n W=410n
Mmn56 qint qbint VSS VSS g45n1svt M=1 L=45n W=260n
Mmn0 Eb E VSS VSS g45n1svt M=1 L=45n W=145n
Mmn30 mout n20 VSS VSS g45n1svt M=1 L=45n W=145n
Mmn21 CKbb Ckb VSS VSS g45n1svt M=1 L=45n W=145n
Mmn40 mout CKbb n30 VSS g45n1svt M=1 L=45n W=145n
Mmn1 qbint Eb Db VSS g45n1svt M=1 L=45n W=145n
Mmn25 Db Ckb n20 VSS g45n1svt M=1 L=45n W=145n
Mmp3 Db Eb n1 VDD g45p1svt M=1 L=45n W=215n
Mmp2 n1 D VDD VDD g45p1svt M=1 L=45n W=215n
Mmp51 n30 CKbb net362 VDD g45p1svt M=1 L=45n W=215n
Mmp50 net362 qbint VDD VDD g45p1svt M=1 L=45n W=215n
Mmp57 QN qint VDD VDD g45p1svt M=1 L=45n W=1.56u
Mmp55 Q qbint VDD VDD g45p1svt M=1 L=45n W=1.56u
Mmp35 net342 mout VDD VDD g45p1svt M=1 L=45n W=215n
Mmp36 n20 Ckb net342 VDD g45p1svt M=1 L=45n W=215n
Mmp20 Ckb CK VDD VDD g45p1svt M=1 L=45n W=215n
Mmp45 qbint n30 VDD VDD g45p1svt M=1 L=45n W=620n
Mmp56 qint qbint VDD VDD g45p1svt M=1 L=45n W=390n
Mmp21 CKbb Ckb VDD VDD g45p1svt M=1 L=45n W=215n
Mmp40 n30 Ckb mout VDD g45p1svt M=1 L=45n W=215n
Mmp30 mout n20 VDD VDD g45p1svt M=1 L=45n W=215n
Mmp25 n20 CKbb Db VDD g45p1svt M=1 L=45n W=215n
Mmp0 Eb E VDD VDD g45p1svt M=1 L=45n W=215n
Mmp1 qbint E Db VDD g45p1svt M=1 L=45n W=215n
.ENDS

.SUBCKT EDFFX2 CK D E Q QN VDD VSS
Mmn3 Db E n0 VSS g45n1svt M=1 L=45n W=145n
Mmn2 n0 D VSS VSS g45n1svt M=1 L=45n W=145n
Mmn57 QN qint VSS VSS g45n1svt M=1 L=45n W=520n
Mmn55 Q qbint VSS VSS g45n1svt M=1 L=45n W=520n
Mmn51 n30 Ckb net415 VSS g45n1svt M=1 L=45n W=145n
Mmn50 net415 qbint VSS VSS g45n1svt M=1 L=45n W=145n
Mmn35 net411 mout VSS VSS g45n1svt M=1 L=45n W=145n
Mmn36 n20 CKbb net411 VSS g45n1svt M=1 L=45n W=145n
Mmn20 Ckb CK VSS VSS g45n1svt M=1 L=45n W=145n
Mmn45 qbint n30 VSS VSS g45n1svt M=1 L=45n W=260n
Mmn56 qint qbint VSS VSS g45n1svt M=1 L=45n W=145n
Mmn0 Eb E VSS VSS g45n1svt M=1 L=45n W=145n
Mmn30 mout n20 VSS VSS g45n1svt M=1 L=45n W=145n
Mmn21 CKbb Ckb VSS VSS g45n1svt M=1 L=45n W=145n
Mmn40 mout CKbb n30 VSS g45n1svt M=1 L=45n W=145n
Mmn1 qbint Eb Db VSS g45n1svt M=1 L=45n W=145n
Mmn25 Db Ckb n20 VSS g45n1svt M=1 L=45n W=145n
Mmp3 Db Eb n1 VDD g45p1svt M=1 L=45n W=215n
Mmp2 n1 D VDD VDD g45p1svt M=1 L=45n W=215n
Mmp51 n30 CKbb net362 VDD g45p1svt M=1 L=45n W=215n
Mmp50 net362 qbint VDD VDD g45p1svt M=1 L=45n W=215n
Mmp57 QN qint VDD VDD g45p1svt M=1 L=45n W=780n
Mmp55 Q qbint VDD VDD g45p1svt M=1 L=45n W=780n
Mmp35 net342 mout VDD VDD g45p1svt M=1 L=45n W=215n
Mmp36 n20 Ckb net342 VDD g45p1svt M=1 L=45n W=215n
Mmp20 Ckb CK VDD VDD g45p1svt M=1 L=45n W=215n
Mmp45 qbint n30 VDD VDD g45p1svt M=1 L=45n W=390n
Mmp56 qint qbint VDD VDD g45p1svt M=1 L=45n W=215n
Mmp21 CKbb Ckb VDD VDD g45p1svt M=1 L=45n W=215n
Mmp40 n30 Ckb mout VDD g45p1svt M=1 L=45n W=215n
Mmp30 mout n20 VDD VDD g45p1svt M=1 L=45n W=215n
Mmp25 n20 CKbb Db VDD g45p1svt M=1 L=45n W=215n
Mmp0 Eb E VDD VDD g45p1svt M=1 L=45n W=215n
Mmp1 qbint E Db VDD g45p1svt M=1 L=45n W=215n
.ENDS

.SUBCKT EDFFX1 CK D E Q QN VDD VSS
Mmn3 Db E n0 VSS g45n1svt M=1 L=45n W=145n
Mmn2 n0 D VSS VSS g45n1svt M=1 L=45n W=145n
Mmn57 QN qint VSS VSS g45n1svt M=1 L=45n W=260n
Mmn55 Q qbint VSS VSS g45n1svt M=1 L=45n W=260n
Mmn51 n30 Ckb net415 VSS g45n1svt M=1 L=45n W=145n
Mmn50 net415 qbint VSS VSS g45n1svt M=1 L=45n W=145n
Mmn35 net411 mout VSS VSS g45n1svt M=1 L=45n W=145n
Mmn36 n20 CKbb net411 VSS g45n1svt M=1 L=45n W=145n
Mmn20 Ckb CK VSS VSS g45n1svt M=1 L=45n W=145n
Mmn45 qbint n30 VSS VSS g45n1svt M=1 L=45n W=205n
Mmn56 qint qbint VSS VSS g45n1svt M=1 L=45n W=145n
Mmn0 Eb E VSS VSS g45n1svt M=1 L=45n W=145n
Mmn30 mout n20 VSS VSS g45n1svt M=1 L=45n W=145n
Mmn21 CKbb Ckb VSS VSS g45n1svt M=1 L=45n W=145n
Mmn40 mout CKbb n30 VSS g45n1svt M=1 L=45n W=145n
Mmn1 qbint Eb Db VSS g45n1svt M=1 L=45n W=145n
Mmn25 Db Ckb n20 VSS g45n1svt M=1 L=45n W=145n
Mmp3 Db Eb n1 VDD g45p1svt M=1 L=45n W=215n
Mmp2 n1 D VDD VDD g45p1svt M=1 L=45n W=215n
Mmp51 n30 CKbb net362 VDD g45p1svt M=1 L=45n W=215n
Mmp50 net362 qbint VDD VDD g45p1svt M=1 L=45n W=215n
Mmp57 QN qint VDD VDD g45p1svt M=1 L=45n W=390n
Mmp55 Q qbint VDD VDD g45p1svt M=1 L=45n W=390n
Mmp35 net342 mout VDD VDD g45p1svt M=1 L=45n W=215n
Mmp36 n20 Ckb net342 VDD g45p1svt M=1 L=45n W=215n
Mmp20 Ckb CK VDD VDD g45p1svt M=1 L=45n W=215n
Mmp45 qbint n30 VDD VDD g45p1svt M=1 L=45n W=310n
Mmp56 qint qbint VDD VDD g45p1svt M=1 L=45n W=215n
Mmp21 CKbb Ckb VDD VDD g45p1svt M=1 L=45n W=215n
Mmp40 n30 Ckb mout VDD g45p1svt M=1 L=45n W=215n
Mmp30 mout n20 VDD VDD g45p1svt M=1 L=45n W=215n
Mmp25 n20 CKbb Db VDD g45p1svt M=1 L=45n W=215n
Mmp0 Eb E VDD VDD g45p1svt M=1 L=45n W=215n
Mmp1 qbint E Db VDD g45p1svt M=1 L=45n W=215n
.ENDS

.SUBCKT EDFFTRXL CK D E Q QN RN VDD VSS
Mmn35 net516 mout VSS VSS g45n1svt M=1 L=45n W=145n
Mmn36 n20 CKbb net516 VSS g45n1svt M=1 L=45n W=145n
Mmn26 n20 CKb n21 VSS g45n1svt M=1 L=45n W=145n
Mmn25 n21 Dp VSS VSS g45n1svt M=1 L=45n W=145n
Mmn51 n30 CKb net496 VSS g45n1svt M=1 L=45n W=145n
Mmn50 net496 qbint VSS VSS g45n1svt M=1 L=45n W=145n
Mmn57 QN qint VSS VSS g45n1svt M=1 L=45n W=145n
Mmn55 Q qbint VSS VSS g45n1svt M=1 L=45n W=145n
Mmn5 Dp qbint n0 VSS g45n1svt M=1 L=45n W=145n
Mmn4 n0 Eb VSS VSS g45n1svt M=1 L=45n W=145n
Mmn6 n1 E VSS VSS g45n1svt M=1 L=45n W=145n
Mmn7 Dp Db n1 VSS g45n1svt M=1 L=45n W=145n
Mmn20 CKb CK VSS VSS g45n1svt M=1 L=45n W=145n
Mmn2 RNb RN VSS VSS g45n1svt M=1 L=45n W=145n
Mmn1 Db D VSS VSS g45n1svt M=1 L=45n W=145n
Mmn30 mout n20 VSS VSS g45n1svt M=1 L=45n W=145n
Mmn21 CKbb CKb VSS VSS g45n1svt M=1 L=45n W=145n
Mmn40 n30 CKbb mout VSS g45n1svt M=1 L=45n W=145n
Mmn45 qbint n30 VSS VSS g45n1svt M=1 L=45n W=145n
Mmn56 qint qbint VSS VSS g45n1svt M=1 L=45n W=145n
Mmn3 Dp RNb VSS VSS g45n1svt M=1 L=45n W=145n
Mmn0 Eb E VSS VSS g45n1svt M=1 L=45n W=145n
Mmp25 n22 Dp VDD VDD g45p1svt M=1 L=45n W=215n
Mmp26 n20 CKbb n22 VDD g45p1svt M=1 L=45n W=215n
Mmp35 net427 mout VDD VDD g45p1svt M=1 L=45n W=215n
Mmp36 n20 CKb net427 VDD g45p1svt M=1 L=45n W=215n
Mmp51 n30 CKbb net411 VDD g45p1svt M=1 L=45n W=215n
Mmp50 net411 qbint VDD VDD g45p1svt M=1 L=45n W=215n
Mmp57 QN qint VDD VDD g45p1svt M=1 L=45n W=215n
Mmp55 Q qbint VDD VDD g45p1svt M=1 L=45n W=215n
Mmp20 CKb CK VDD VDD g45p1svt M=1 L=45n W=215n
Mmp2 RNb RN VDD VDD g45p1svt M=1 L=45n W=215n
Mmp1 Db D VDD VDD g45p1svt M=1 L=45n W=215n
Mmp7 Dp Db n3 VDD g45p1svt M=1 L=45n W=215n
Mmp6 Dp E n3 VDD g45p1svt M=1 L=45n W=215n
Mmp30 mout n20 VDD VDD g45p1svt M=1 L=45n W=215n
Mmp21 CKbb CKb VDD VDD g45p1svt M=1 L=45n W=215n
Mmp40 n30 CKb mout VDD g45p1svt M=1 L=45n W=215n
Mmp45 qbint n30 VDD VDD g45p1svt M=1 L=45n W=215n
Mmp56 qint qbint VDD VDD g45p1svt M=1 L=45n W=215n
Mmp5 n3 qbint n2 VDD g45p1svt M=1 L=45n W=215n
Mmp0 Eb E VDD VDD g45p1svt M=1 L=45n W=215n
Mmp4 n3 Eb n2 VDD g45p1svt M=1 L=45n W=215n
Mmp3 n2 RNb VDD VDD g45p1svt M=1 L=45n W=215n
.ENDS

.SUBCKT EDFFTRX4 CK D E Q QN RN VDD VSS
Mmn35 net516 mout VSS VSS g45n1svt M=1 L=45n W=145n
Mmn36 n20 CKbb net516 VSS g45n1svt M=1 L=45n W=145n
Mmn26 n20 CKb n21 VSS g45n1svt M=1 L=45n W=145n
Mmn25 n21 Dp VSS VSS g45n1svt M=1 L=45n W=145n
Mmn51 n30 CKb net496 VSS g45n1svt M=1 L=45n W=145n
Mmn50 net496 qbint VSS VSS g45n1svt M=1 L=45n W=145n
Mmn57 QN qint VSS VSS g45n1svt M=1 L=45n W=1.04u
Mmn55 Q qbint VSS VSS g45n1svt M=1 L=45n W=1.04u
Mmn5 Dp qbint n0 VSS g45n1svt M=1 L=45n W=145n
Mmn4 n0 Eb VSS VSS g45n1svt M=1 L=45n W=145n
Mmn6 n1 E VSS VSS g45n1svt M=1 L=45n W=145n
Mmn7 Dp Db n1 VSS g45n1svt M=1 L=45n W=145n
Mmn20 CKb CK VSS VSS g45n1svt M=1 L=45n W=145n
Mmn2 RNb RN VSS VSS g45n1svt M=1 L=45n W=145n
Mmn1 Db D VSS VSS g45n1svt M=1 L=45n W=145n
Mmn30 mout n20 VSS VSS g45n1svt M=1 L=45n W=145n
Mmn21 CKbb CKb VSS VSS g45n1svt M=1 L=45n W=145n
Mmn40 n30 CKbb mout VSS g45n1svt M=1 L=45n W=145n
Mmn45 qbint n30 VSS VSS g45n1svt M=1 L=45n W=410n
Mmn56 qint qbint VSS VSS g45n1svt M=1 L=45n W=260n
Mmn3 Dp RNb VSS VSS g45n1svt M=1 L=45n W=145n
Mmn0 Eb E VSS VSS g45n1svt M=1 L=45n W=145n
Mmp25 n22 Dp VDD VDD g45p1svt M=1 L=45n W=215n
Mmp26 n20 CKbb n22 VDD g45p1svt M=1 L=45n W=215n
Mmp35 net427 mout VDD VDD g45p1svt M=1 L=45n W=215n
Mmp36 n20 CKb net427 VDD g45p1svt M=1 L=45n W=215n
Mmp51 n30 CKbb net411 VDD g45p1svt M=1 L=45n W=215n
Mmp50 net411 qbint VDD VDD g45p1svt M=1 L=45n W=215n
Mmp57 QN qint VDD VDD g45p1svt M=1 L=45n W=1.56u
Mmp55 Q qbint VDD VDD g45p1svt M=1 L=45n W=1.56u
Mmp20 CKb CK VDD VDD g45p1svt M=1 L=45n W=215n
Mmp2 RNb RN VDD VDD g45p1svt M=1 L=45n W=215n
Mmp1 Db D VDD VDD g45p1svt M=1 L=45n W=215n
Mmp7 Dp Db n3 VDD g45p1svt M=1 L=45n W=215n
Mmp6 Dp E n3 VDD g45p1svt M=1 L=45n W=215n
Mmp30 mout n20 VDD VDD g45p1svt M=1 L=45n W=215n
Mmp21 CKbb CKb VDD VDD g45p1svt M=1 L=45n W=215n
Mmp40 n30 CKb mout VDD g45p1svt M=1 L=45n W=215n
Mmp45 qbint n30 VDD VDD g45p1svt M=1 L=45n W=620n
Mmp56 qint qbint VDD VDD g45p1svt M=1 L=45n W=390n
Mmp5 n3 qbint n2 VDD g45p1svt M=1 L=45n W=215n
Mmp0 Eb E VDD VDD g45p1svt M=1 L=45n W=215n
Mmp4 n3 Eb n2 VDD g45p1svt M=1 L=45n W=215n
Mmp3 n2 RNb VDD VDD g45p1svt M=1 L=45n W=215n
.ENDS

.SUBCKT EDFFTRX2 CK D E Q QN RN VDD VSS
Mmn35 net516 mout VSS VSS g45n1svt M=1 L=45n W=145n
Mmn36 n20 CKbb net516 VSS g45n1svt M=1 L=45n W=145n
Mmn26 n20 CKb n21 VSS g45n1svt M=1 L=45n W=145n
Mmn25 n21 Dp VSS VSS g45n1svt M=1 L=45n W=145n
Mmn51 n30 CKb net496 VSS g45n1svt M=1 L=45n W=145n
Mmn50 net496 qbint VSS VSS g45n1svt M=1 L=45n W=145n
Mmn57 QN qint VSS VSS g45n1svt M=1 L=45n W=520n
Mmn55 Q qbint VSS VSS g45n1svt M=1 L=45n W=520n
Mmn5 Dp qbint n0 VSS g45n1svt M=1 L=45n W=145n
Mmn4 n0 Eb VSS VSS g45n1svt M=1 L=45n W=145n
Mmn6 n1 E VSS VSS g45n1svt M=1 L=45n W=145n
Mmn7 Dp Db n1 VSS g45n1svt M=1 L=45n W=145n
Mmn20 CKb CK VSS VSS g45n1svt M=1 L=45n W=145n
Mmn2 RNb RN VSS VSS g45n1svt M=1 L=45n W=145n
Mmn1 Db D VSS VSS g45n1svt M=1 L=45n W=145n
Mmn30 mout n20 VSS VSS g45n1svt M=1 L=45n W=145n
Mmn21 CKbb CKb VSS VSS g45n1svt M=1 L=45n W=145n
Mmn40 n30 CKbb mout VSS g45n1svt M=1 L=45n W=145n
Mmn45 qbint n30 VSS VSS g45n1svt M=1 L=45n W=260n
Mmn56 qint qbint VSS VSS g45n1svt M=1 L=45n W=145n
Mmn3 Dp RNb VSS VSS g45n1svt M=1 L=45n W=145n
Mmn0 Eb E VSS VSS g45n1svt M=1 L=45n W=145n
Mmp25 n22 Dp VDD VDD g45p1svt M=1 L=45n W=215n
Mmp26 n20 CKbb n22 VDD g45p1svt M=1 L=45n W=215n
Mmp35 net427 mout VDD VDD g45p1svt M=1 L=45n W=215n
Mmp36 n20 CKb net427 VDD g45p1svt M=1 L=45n W=215n
Mmp51 n30 CKbb net411 VDD g45p1svt M=1 L=45n W=215n
Mmp50 net411 qbint VDD VDD g45p1svt M=1 L=45n W=215n
Mmp57 QN qint VDD VDD g45p1svt M=1 L=45n W=780n
Mmp55 Q qbint VDD VDD g45p1svt M=1 L=45n W=780n
Mmp20 CKb CK VDD VDD g45p1svt M=1 L=45n W=215n
Mmp2 RNb RN VDD VDD g45p1svt M=1 L=45n W=215n
Mmp1 Db D VDD VDD g45p1svt M=1 L=45n W=215n
Mmp7 Dp Db n3 VDD g45p1svt M=1 L=45n W=215n
Mmp6 Dp E n3 VDD g45p1svt M=1 L=45n W=215n
Mmp30 mout n20 VDD VDD g45p1svt M=1 L=45n W=215n
Mmp21 CKbb CKb VDD VDD g45p1svt M=1 L=45n W=215n
Mmp40 n30 CKb mout VDD g45p1svt M=1 L=45n W=215n
Mmp45 qbint n30 VDD VDD g45p1svt M=1 L=45n W=390n
Mmp56 qint qbint VDD VDD g45p1svt M=1 L=45n W=215n
Mmp5 n3 qbint n2 VDD g45p1svt M=1 L=45n W=215n
Mmp0 Eb E VDD VDD g45p1svt M=1 L=45n W=215n
Mmp4 n3 Eb n2 VDD g45p1svt M=1 L=45n W=215n
Mmp3 n2 RNb VDD VDD g45p1svt M=1 L=45n W=215n
.ENDS

.SUBCKT EDFFTRX1 CK D E Q QN RN VDD VSS
Mmn35 net516 mout VSS VSS g45n1svt M=1 L=45n W=145n
Mmn36 n20 CKbb net516 VSS g45n1svt M=1 L=45n W=145n
Mmn26 n20 CKb n21 VSS g45n1svt M=1 L=45n W=145n
Mmn25 n21 Dp VSS VSS g45n1svt M=1 L=45n W=145n
Mmn51 n30 CKb net496 VSS g45n1svt M=1 L=45n W=145n
Mmn50 net496 qbint VSS VSS g45n1svt M=1 L=45n W=145n
Mmn57 QN qint VSS VSS g45n1svt M=1 L=45n W=260n
Mmn55 Q qbint VSS VSS g45n1svt M=1 L=45n W=260n
Mmn5 Dp qbint n0 VSS g45n1svt M=1 L=45n W=145n
Mmn4 n0 Eb VSS VSS g45n1svt M=1 L=45n W=145n
Mmn6 n1 E VSS VSS g45n1svt M=1 L=45n W=145n
Mmn7 Dp Db n1 VSS g45n1svt M=1 L=45n W=145n
Mmn20 CKb CK VSS VSS g45n1svt M=1 L=45n W=145n
Mmn2 RNb RN VSS VSS g45n1svt M=1 L=45n W=145n
Mmn1 Db D VSS VSS g45n1svt M=1 L=45n W=145n
Mmn30 mout n20 VSS VSS g45n1svt M=1 L=45n W=145n
Mmn21 CKbb CKb VSS VSS g45n1svt M=1 L=45n W=145n
Mmn40 n30 CKbb mout VSS g45n1svt M=1 L=45n W=145n
Mmn45 qbint n30 VSS VSS g45n1svt M=1 L=45n W=205n
Mmn56 qint qbint VSS VSS g45n1svt M=1 L=45n W=145n
Mmn3 Dp RNb VSS VSS g45n1svt M=1 L=45n W=145n
Mmn0 Eb E VSS VSS g45n1svt M=1 L=45n W=145n
Mmp25 n22 Dp VDD VDD g45p1svt M=1 L=45n W=215n
Mmp26 n20 CKbb n22 VDD g45p1svt M=1 L=45n W=215n
Mmp35 net427 mout VDD VDD g45p1svt M=1 L=45n W=215n
Mmp36 n20 CKb net427 VDD g45p1svt M=1 L=45n W=215n
Mmp51 n30 CKbb net411 VDD g45p1svt M=1 L=45n W=215n
Mmp50 net411 qbint VDD VDD g45p1svt M=1 L=45n W=215n
Mmp57 QN qint VDD VDD g45p1svt M=1 L=45n W=390n
Mmp55 Q qbint VDD VDD g45p1svt M=1 L=45n W=390n
Mmp20 CKb CK VDD VDD g45p1svt M=1 L=45n W=215n
Mmp2 RNb RN VDD VDD g45p1svt M=1 L=45n W=215n
Mmp1 Db D VDD VDD g45p1svt M=1 L=45n W=215n
Mmp7 Dp Db n3 VDD g45p1svt M=1 L=45n W=215n
Mmp6 Dp E n3 VDD g45p1svt M=1 L=45n W=215n
Mmp30 mout n20 VDD VDD g45p1svt M=1 L=45n W=215n
Mmp21 CKbb CKb VDD VDD g45p1svt M=1 L=45n W=215n
Mmp40 n30 CKb mout VDD g45p1svt M=1 L=45n W=215n
Mmp45 qbint n30 VDD VDD g45p1svt M=1 L=45n W=310n
Mmp56 qint qbint VDD VDD g45p1svt M=1 L=45n W=215n
Mmp5 n3 qbint n2 VDD g45p1svt M=1 L=45n W=215n
Mmp0 Eb E VDD VDD g45p1svt M=1 L=45n W=215n
Mmp4 n3 Eb n2 VDD g45p1svt M=1 L=45n W=215n
Mmp3 n2 RNb VDD VDD g45p1svt M=1 L=45n W=215n
.ENDS

.SUBCKT EDFFHQX8 CK D E Q VDD VSS
Mmn3 Db E net333 VSS g45n1svt M=1 L=45n W=260n
Mmn2 net333 D VSS VSS g45n1svt M=1 L=45n W=260n
Mmn55 Q qbint VSS VSS g45n1svt M=1 L=45n W=2.065u
Mmn51 n30 CKb net380 VSS g45n1svt M=1 L=45n W=205n
Mmn50 net380 qbint VSS VSS g45n1svt M=1 L=45n W=205n
Mmn35 net340 mout VSS VSS g45n1svt M=1 L=45n W=205n
Mmn20 CKb CK VSS VSS g45n1svt M=1 L=45n W=145n
Mmn45 qbint n30 VSS VSS g45n1svt M=1 L=45n W=780n
Mmn21 CKbb CKb VSS VSS g45n1svt M=1 L=45n W=145n
Mmn40 mout CKbb n30 VSS g45n1svt M=1 L=45n W=205n
Mmn30 mout n20 VSS VSS g45n1svt M=1 L=45n W=205n
Mmn0 Eb E VSS VSS g45n1svt M=1 L=45n W=145n
Mmn1 qbint Eb Db VSS g45n1svt M=1 L=45n W=260n
Mmn25 n20 CKb Db VSS g45n1svt M=1 L=45n W=205n
Mmn36 n20 CKbb net340 VSS g45n1svt M=1 L=45n W=205n
Mmp3 Db Eb net328 VDD g45p1svt M=1 L=45n W=390n
Mmp2 net328 D VDD VDD g45p1svt M=1 L=45n W=390n
Mmp51 n30 CKbb net317 VDD g45p1svt M=1 L=45n W=310n
Mmp50 net317 qbint VDD VDD g45p1svt M=1 L=45n W=310n
Mmp55 Q qbint VDD VDD g45p1svt M=1 L=45n W=3.115u
Mmp35 net309 mout VDD VDD g45p1svt M=1 L=45n W=310n
Mmp36 n20 CKb net309 VDD g45p1svt M=1 L=45n W=310n
Mmp45 qbint n30 VDD VDD g45p1svt M=1 L=45n W=1.17u
Mmp21 CKbb CKb VDD VDD g45p1svt M=1 L=45n W=215n
Mmp40 mout CKb n30 VDD g45p1svt M=1 L=45n W=310n
Mmp30 mout n20 VDD VDD g45p1svt M=1 L=45n W=310n
Mmp1 qbint E Db VDD g45p1svt M=1 L=45n W=390n
Mmp20 CKb CK VDD VDD g45p1svt M=1 L=45n W=215n
Mmp25 n20 CKbb Db VDD g45p1svt M=1 L=45n W=310n
Mmp0 Eb E VDD VDD g45p1svt M=1 L=45n W=215n
.ENDS

.SUBCKT EDFFHQX4 CK D E Q VDD VSS
Mmn3 Db E net333 VSS g45n1svt M=1 L=45n W=260n
Mmn2 net333 D VSS VSS g45n1svt M=1 L=45n W=260n
Mmn55 Q qbint VSS VSS g45n1svt M=1 L=45n W=1.04u
Mmn51 n30 CKb net380 VSS g45n1svt M=1 L=45n W=205n
Mmn50 net380 qbint VSS VSS g45n1svt M=1 L=45n W=205n
Mmn35 net340 mout VSS VSS g45n1svt M=1 L=45n W=205n
Mmn20 CKb CK VSS VSS g45n1svt M=1 L=45n W=145n
Mmn45 qbint n30 VSS VSS g45n1svt M=1 L=45n W=410n
Mmn21 CKbb CKb VSS VSS g45n1svt M=1 L=45n W=145n
Mmn40 mout CKbb n30 VSS g45n1svt M=1 L=45n W=205n
Mmn30 mout n20 VSS VSS g45n1svt M=1 L=45n W=205n
Mmn0 Eb E VSS VSS g45n1svt M=1 L=45n W=145n
Mmn1 qbint Eb Db VSS g45n1svt M=1 L=45n W=260n
Mmn25 n20 CKb Db VSS g45n1svt M=1 L=45n W=205n
Mmn36 n20 CKbb net340 VSS g45n1svt M=1 L=45n W=205n
Mmp3 Db Eb net328 VDD g45p1svt M=1 L=45n W=390n
Mmp2 net328 D VDD VDD g45p1svt M=1 L=45n W=390n
Mmp51 n30 CKbb net317 VDD g45p1svt M=1 L=45n W=310n
Mmp50 net317 qbint VDD VDD g45p1svt M=1 L=45n W=310n
Mmp55 Q qbint VDD VDD g45p1svt M=1 L=45n W=1.56u
Mmp35 net309 mout VDD VDD g45p1svt M=1 L=45n W=310n
Mmp36 n20 CKb net309 VDD g45p1svt M=1 L=45n W=310n
Mmp45 qbint n30 VDD VDD g45p1svt M=1 L=45n W=620n
Mmp21 CKbb CKb VDD VDD g45p1svt M=1 L=45n W=215n
Mmp40 mout CKb n30 VDD g45p1svt M=1 L=45n W=310n
Mmp30 mout n20 VDD VDD g45p1svt M=1 L=45n W=310n
Mmp1 qbint E Db VDD g45p1svt M=1 L=45n W=390n
Mmp20 CKb CK VDD VDD g45p1svt M=1 L=45n W=215n
Mmp25 n20 CKbb Db VDD g45p1svt M=1 L=45n W=310n
Mmp0 Eb E VDD VDD g45p1svt M=1 L=45n W=215n
.ENDS

.SUBCKT EDFFHQX2 CK D E Q VDD VSS
Mmn3 Db E net333 VSS g45n1svt M=1 L=45n W=260n
Mmn2 net333 D VSS VSS g45n1svt M=1 L=45n W=260n
Mmn55 Q qbint VSS VSS g45n1svt M=1 L=45n W=520n
Mmn51 n30 CKb net380 VSS g45n1svt M=1 L=45n W=205n
Mmn50 net380 qbint VSS VSS g45n1svt M=1 L=45n W=205n
Mmn35 net340 mout VSS VSS g45n1svt M=1 L=45n W=205n
Mmn20 CKb CK VSS VSS g45n1svt M=1 L=45n W=145n
Mmn45 qbint n30 VSS VSS g45n1svt M=1 L=45n W=260n
Mmn21 CKbb CKb VSS VSS g45n1svt M=1 L=45n W=145n
Mmn40 mout CKbb n30 VSS g45n1svt M=1 L=45n W=205n
Mmn30 mout n20 VSS VSS g45n1svt M=1 L=45n W=205n
Mmn0 Eb E VSS VSS g45n1svt M=1 L=45n W=145n
Mmn1 qbint Eb Db VSS g45n1svt M=1 L=45n W=260n
Mmn25 n20 CKb Db VSS g45n1svt M=1 L=45n W=205n
Mmn36 n20 CKbb net340 VSS g45n1svt M=1 L=45n W=205n
Mmp3 Db Eb net328 VDD g45p1svt M=1 L=45n W=390n
Mmp2 net328 D VDD VDD g45p1svt M=1 L=45n W=390n
Mmp51 n30 CKbb net317 VDD g45p1svt M=1 L=45n W=310n
Mmp50 net317 qbint VDD VDD g45p1svt M=1 L=45n W=310n
Mmp55 Q qbint VDD VDD g45p1svt M=1 L=45n W=780n
Mmp35 net309 mout VDD VDD g45p1svt M=1 L=45n W=310n
Mmp36 n20 CKb net309 VDD g45p1svt M=1 L=45n W=310n
Mmp45 qbint n30 VDD VDD g45p1svt M=1 L=45n W=390n
Mmp21 CKbb CKb VDD VDD g45p1svt M=1 L=45n W=215n
Mmp40 mout CKb n30 VDD g45p1svt M=1 L=45n W=310n
Mmp30 mout n20 VDD VDD g45p1svt M=1 L=45n W=310n
Mmp1 qbint E Db VDD g45p1svt M=1 L=45n W=390n
Mmp20 CKb CK VDD VDD g45p1svt M=1 L=45n W=215n
Mmp25 n20 CKbb Db VDD g45p1svt M=1 L=45n W=310n
Mmp0 Eb E VDD VDD g45p1svt M=1 L=45n W=215n
.ENDS

.SUBCKT EDFFHQX1 CK D E Q VDD VSS
Mmn3 Db E net333 VSS g45n1svt M=1 L=45n W=260n
Mmn2 net333 D VSS VSS g45n1svt M=1 L=45n W=260n
Mmn55 Q qbint VSS VSS g45n1svt M=1 L=45n W=260n
Mmn51 n30 CKb net380 VSS g45n1svt M=1 L=45n W=205n
Mmn50 net380 qbint VSS VSS g45n1svt M=1 L=45n W=205n
Mmn35 net340 mout VSS VSS g45n1svt M=1 L=45n W=205n
Mmn20 CKb CK VSS VSS g45n1svt M=1 L=45n W=145n
Mmn45 qbint n30 VSS VSS g45n1svt M=1 L=45n W=205n
Mmn21 CKbb CKb VSS VSS g45n1svt M=1 L=45n W=145n
Mmn40 mout CKbb n30 VSS g45n1svt M=1 L=45n W=205n
Mmn30 mout n20 VSS VSS g45n1svt M=1 L=45n W=205n
Mmn0 Eb E VSS VSS g45n1svt M=1 L=45n W=145n
Mmn1 qbint Eb Db VSS g45n1svt M=1 L=45n W=260n
Mmn25 n20 CKb Db VSS g45n1svt M=1 L=45n W=205n
Mmn36 n20 CKbb net340 VSS g45n1svt M=1 L=45n W=205n
Mmp3 Db Eb net328 VDD g45p1svt M=1 L=45n W=390n
Mmp2 net328 D VDD VDD g45p1svt M=1 L=45n W=390n
Mmp51 n30 CKbb net317 VDD g45p1svt M=1 L=45n W=310n
Mmp50 net317 qbint VDD VDD g45p1svt M=1 L=45n W=310n
Mmp55 Q qbint VDD VDD g45p1svt M=1 L=45n W=390n
Mmp35 net309 mout VDD VDD g45p1svt M=1 L=45n W=310n
Mmp36 n20 CKb net309 VDD g45p1svt M=1 L=45n W=310n
Mmp45 qbint n30 VDD VDD g45p1svt M=1 L=45n W=310n
Mmp21 CKbb CKb VDD VDD g45p1svt M=1 L=45n W=215n
Mmp40 mout CKb n30 VDD g45p1svt M=1 L=45n W=310n
Mmp30 mout n20 VDD VDD g45p1svt M=1 L=45n W=310n
Mmp1 qbint E Db VDD g45p1svt M=1 L=45n W=390n
Mmp20 CKb CK VDD VDD g45p1svt M=1 L=45n W=215n
Mmp25 n20 CKbb Db VDD g45p1svt M=1 L=45n W=310n
Mmp0 Eb E VDD VDD g45p1svt M=1 L=45n W=215n
.ENDS

.SUBCKT DLY4X4 A VDD VSS Y
Mmn14 net345 VDD net341 VSS g45n1svt M=1 L=45n W=145n
Mmn13 net341 net353 VSS VSS g45n1svt M=1 L=45n W=145n
Mmn12 net353 VDD net349 VSS g45n1svt M=1 L=45n W=145n
Mmn11 net349 net361 VSS VSS g45n1svt M=1 L=45n W=145n
Mmn10 net361 VDD net357 VSS g45n1svt M=1 L=45n W=145n
Mmn9 net357 net369 VSS VSS g45n1svt M=1 L=45n W=145n
Mmn15 net333 net345 VSS VSS g45n1svt M=1 L=45n W=260n
Mmn6 net377 VDD net373 VSS g45n1svt M=1 L=45n W=145n
Mmn0 net397 A VSS VSS g45n1svt M=1 L=45n W=145n
Mmn4 net385 VDD net381 VSS g45n1svt M=1 L=45n W=145n
Mmn1 net389 net397 VSS VSS g45n1svt M=1 L=45n W=145n
Mmn7 net365 net377 VSS VSS g45n1svt M=1 L=45n W=145n
Mmn16 Y net333 VSS VSS g45n1svt M=1 L=45n W=1.04u
Mmn3 net381 net393 VSS VSS g45n1svt M=1 L=45n W=145n
Mmn2 net393 VDD net389 VSS g45n1svt M=1 L=45n W=145n
Mmn8 net369 VDD net365 VSS g45n1svt M=1 L=45n W=145n
Mmn5 net373 net385 VSS VSS g45n1svt M=1 L=45n W=145n
Mmp8 net369 VSS net300 VDD g45p1svt M=1 L=45n W=215n
Mmp7 net300 net377 VDD VDD g45p1svt M=1 L=45n W=215n
Mmp9 net292 net369 VDD VDD g45p1svt M=1 L=45n W=215n
Mmp10 net361 VSS net292 VDD g45p1svt M=1 L=45n W=215n
Mmp6 net377 VSS net308 VDD g45p1svt M=1 L=45n W=215n
Mmp5 net308 net385 VDD VDD g45p1svt M=1 L=45n W=215n
Mmp4 net385 VSS net316 VDD g45p1svt M=1 L=45n W=215n
Mmp3 net316 net393 VDD VDD g45p1svt M=1 L=45n W=215n
Mmp2 net393 VSS net324 VDD g45p1svt M=1 L=45n W=215n
Mmp1 net324 net397 VDD VDD g45p1svt M=1 L=45n W=215n
Mmp11 net284 net361 VDD VDD g45p1svt M=1 L=45n W=215n
Mmp12 net353 VSS net284 VDD g45p1svt M=1 L=45n W=215n
Mmp13 net276 net353 VDD VDD g45p1svt M=1 L=45n W=215n
Mmp14 net345 VSS net276 VDD g45p1svt M=1 L=45n W=215n
Mmp15 net333 net345 VDD VDD g45p1svt M=1 L=45n W=390n
Mmp0 net397 A VDD VDD g45p1svt M=1 L=45n W=215n
Mmp16 Y net333 VDD VDD g45p1svt M=1 L=45n W=1.56u
.ENDS

.SUBCKT DLY4X1 A VDD VSS Y
Mmn14 net345 VDD net341 VSS g45n1svt M=1 L=45n W=145n
Mmn13 net341 net353 VSS VSS g45n1svt M=1 L=45n W=145n
Mmn12 net353 VDD net349 VSS g45n1svt M=1 L=45n W=145n
Mmn11 net349 net361 VSS VSS g45n1svt M=1 L=45n W=145n
Mmn10 net361 VDD net357 VSS g45n1svt M=1 L=45n W=145n
Mmn9 net357 net369 VSS VSS g45n1svt M=1 L=45n W=145n
Mmn15 net333 net345 VSS VSS g45n1svt M=1 L=45n W=145n
Mmn6 net377 VDD net373 VSS g45n1svt M=1 L=45n W=145n
Mmn0 net397 A VSS VSS g45n1svt M=1 L=45n W=145n
Mmn4 net385 VDD net381 VSS g45n1svt M=1 L=45n W=145n
Mmn1 net389 net397 VSS VSS g45n1svt M=1 L=45n W=145n
Mmn7 net365 net377 VSS VSS g45n1svt M=1 L=45n W=145n
Mmn16 Y net333 VSS VSS g45n1svt M=1 L=45n W=260n
Mmn3 net381 net393 VSS VSS g45n1svt M=1 L=45n W=145n
Mmn2 net393 VDD net389 VSS g45n1svt M=1 L=45n W=145n
Mmn8 net369 VDD net365 VSS g45n1svt M=1 L=45n W=145n
Mmn5 net373 net385 VSS VSS g45n1svt M=1 L=45n W=145n
Mmp8 net369 VSS net300 VDD g45p1svt M=1 L=45n W=215n
Mmp7 net300 net377 VDD VDD g45p1svt M=1 L=45n W=215n
Mmp9 net292 net369 VDD VDD g45p1svt M=1 L=45n W=215n
Mmp10 net361 VSS net292 VDD g45p1svt M=1 L=45n W=215n
Mmp6 net377 VSS net308 VDD g45p1svt M=1 L=45n W=215n
Mmp5 net308 net385 VDD VDD g45p1svt M=1 L=45n W=215n
Mmp4 net385 VSS net316 VDD g45p1svt M=1 L=45n W=215n
Mmp3 net316 net393 VDD VDD g45p1svt M=1 L=45n W=215n
Mmp2 net393 VSS net324 VDD g45p1svt M=1 L=45n W=215n
Mmp1 net324 net397 VDD VDD g45p1svt M=1 L=45n W=215n
Mmp11 net284 net361 VDD VDD g45p1svt M=1 L=45n W=215n
Mmp12 net353 VSS net284 VDD g45p1svt M=1 L=45n W=215n
Mmp13 net276 net353 VDD VDD g45p1svt M=1 L=45n W=215n
Mmp14 net345 VSS net276 VDD g45p1svt M=1 L=45n W=215n
Mmp15 net333 net345 VDD VDD g45p1svt M=1 L=45n W=215n
Mmp0 net397 A VDD VDD g45p1svt M=1 L=45n W=215n
Mmp16 Y net333 VDD VDD g45p1svt M=1 L=45n W=390n
.ENDS

.SUBCKT DLY3X4 A VDD VSS Y
Mmn10 n5 VDD n15 VSS g45n1svt M=1 L=45n W=145n
Mmn9 n15 n4 VSS VSS g45n1svt M=1 L=45n W=145n
Mmn8 n4 VDD n13 VSS g45n1svt M=1 L=45n W=145n
Mmn7 n13 n3 VSS VSS g45n1svt M=1 L=45n W=145n
Mmn6 n3 VDD n11 VSS g45n1svt M=1 L=45n W=145n
Mmn5 n11 n2 VSS VSS g45n1svt M=1 L=45n W=145n
Mmn4 n2 VDD n9 VSS g45n1svt M=1 L=45n W=145n
Mmn3 n9 n1 VSS VSS g45n1svt M=1 L=45n W=145n
Mmn2 n1 VDD n7 VSS g45n1svt M=1 L=45n W=145n
Mmn1 n7 n0 VSS VSS g45n1svt M=1 L=45n W=145n
Mmn11 n6 n5 VSS VSS g45n1svt M=1 L=45n W=260n
Mmn12 Y n6 VSS VSS g45n1svt M=1 L=45n W=1.04u
Mmn0 n0 A VSS VSS g45n1svt M=1 L=45n W=145n
Mmp8 n4 VSS n14 VDD g45p1svt M=1 L=45n W=215n
Mmp7 n14 n3 VDD VDD g45p1svt M=1 L=45n W=215n
Mmp9 n16 n4 VDD VDD g45p1svt M=1 L=45n W=215n
Mmp10 n5 VSS n16 VDD g45p1svt M=1 L=45n W=215n
Mmp6 n3 VSS n12 VDD g45p1svt M=1 L=45n W=215n
Mmp5 n12 n2 VDD VDD g45p1svt M=1 L=45n W=215n
Mmp4 n2 VSS n10 VDD g45p1svt M=1 L=45n W=215n
Mmp3 n10 n1 VDD VDD g45p1svt M=1 L=45n W=215n
Mmp2 n1 VSS n8 VDD g45p1svt M=1 L=45n W=215n
Mmp1 n8 n0 VDD VDD g45p1svt M=1 L=45n W=215n
Mmp12 Y n6 VDD VDD g45p1svt M=1 L=45n W=1.56u
Mmp0 n0 A VDD VDD g45p1svt M=1 L=45n W=215n
Mmp11 n6 n5 VDD VDD g45p1svt M=1 L=45n W=390n
.ENDS

.SUBCKT DLY3X1 A VDD VSS Y
Mmn10 n5 VDD n15 VSS g45n1svt M=1 L=45n W=145n
Mmn9 n15 n4 VSS VSS g45n1svt M=1 L=45n W=145n
Mmn8 n4 VDD n13 VSS g45n1svt M=1 L=45n W=145n
Mmn7 n13 n3 VSS VSS g45n1svt M=1 L=45n W=145n
Mmn6 n3 VDD n11 VSS g45n1svt M=1 L=45n W=145n
Mmn5 n11 n2 VSS VSS g45n1svt M=1 L=45n W=145n
Mmn4 n2 VDD n9 VSS g45n1svt M=1 L=45n W=145n
Mmn3 n9 n1 VSS VSS g45n1svt M=1 L=45n W=145n
Mmn2 n1 VDD n7 VSS g45n1svt M=1 L=45n W=145n
Mmn1 n7 n0 VSS VSS g45n1svt M=1 L=45n W=145n
Mmn11 n6 n5 VSS VSS g45n1svt M=1 L=45n W=145n
Mmn12 Y n6 VSS VSS g45n1svt M=1 L=45n W=260n
Mmn0 n0 A VSS VSS g45n1svt M=1 L=45n W=145n
Mmp8 n4 VSS n14 VDD g45p1svt M=1 L=45n W=215n
Mmp7 n14 n3 VDD VDD g45p1svt M=1 L=45n W=215n
Mmp9 n16 n4 VDD VDD g45p1svt M=1 L=45n W=215n
Mmp10 n5 VSS n16 VDD g45p1svt M=1 L=45n W=215n
Mmp6 n3 VSS n12 VDD g45p1svt M=1 L=45n W=215n
Mmp5 n12 n2 VDD VDD g45p1svt M=1 L=45n W=215n
Mmp4 n2 VSS n10 VDD g45p1svt M=1 L=45n W=215n
Mmp3 n10 n1 VDD VDD g45p1svt M=1 L=45n W=215n
Mmp2 n1 VSS n8 VDD g45p1svt M=1 L=45n W=215n
Mmp1 n8 n0 VDD VDD g45p1svt M=1 L=45n W=215n
Mmp12 Y n6 VDD VDD g45p1svt M=1 L=45n W=390n
Mmp0 n0 A VDD VDD g45p1svt M=1 L=45n W=215n
Mmp11 n6 n5 VDD VDD g45p1svt M=1 L=45n W=215n
.ENDS

.SUBCKT DLY2X4 A VDD VSS Y
Mmn6 n3 VDD n10 VSS g45n1svt M=1 L=45n W=145n
Mmn5 n10 n2 VSS VSS g45n1svt M=1 L=45n W=145n
Mmn8 Y n4 VSS VSS g45n1svt M=1 L=45n W=1.04u
Mmn4 n2 VDD n8 VSS g45n1svt M=1 L=45n W=145n
Mmn3 n8 n1 VSS VSS g45n1svt M=1 L=45n W=145n
Mmn2 n1 VDD n6 VSS g45n1svt M=1 L=45n W=145n
Mmn1 n6 n0 VSS VSS g45n1svt M=1 L=45n W=145n
Mmn7 n4 n3 VSS VSS g45n1svt M=1 L=45n W=260n
Mmn0 n0 A VSS VSS g45n1svt M=1 L=45n W=145n
Mmp6 n3 VSS n11 VDD g45p1svt M=1 L=45n W=215n
Mmp5 n11 n2 VDD VDD g45p1svt M=1 L=45n W=215n
Mmp8 Y n4 VDD VDD g45p1svt M=1 L=45n W=1.56u
Mmp4 n2 VSS n9 VDD g45p1svt M=1 L=45n W=215n
Mmp3 n9 n1 VDD VDD g45p1svt M=1 L=45n W=215n
Mmp2 n1 VSS n7 VDD g45p1svt M=1 L=45n W=215n
Mmp1 n7 n0 VDD VDD g45p1svt M=1 L=45n W=215n
Mmp7 n4 n3 VDD VDD g45p1svt M=1 L=45n W=390n
Mmp0 n0 A VDD VDD g45p1svt M=1 L=45n W=215n
.ENDS

.SUBCKT DLY2X1 A VDD VSS Y
Mmn6 n3 VDD n10 VSS g45n1svt M=1 L=45n W=145n
Mmn5 n10 n2 VSS VSS g45n1svt M=1 L=45n W=145n
Mmn8 Y n4 VSS VSS g45n1svt M=1 L=45n W=260n
Mmn4 n2 VDD n8 VSS g45n1svt M=1 L=45n W=145n
Mmn3 n8 n1 VSS VSS g45n1svt M=1 L=45n W=145n
Mmn2 n1 VDD n6 VSS g45n1svt M=1 L=45n W=145n
Mmn1 n6 n0 VSS VSS g45n1svt M=1 L=45n W=145n
Mmn7 n4 n3 VSS VSS g45n1svt M=1 L=45n W=145n
Mmn0 n0 A VSS VSS g45n1svt M=1 L=45n W=145n
Mmp6 n3 VSS n11 VDD g45p1svt M=1 L=45n W=215n
Mmp5 n11 n2 VDD VDD g45p1svt M=1 L=45n W=215n
Mmp8 Y n4 VDD VDD g45p1svt M=1 L=45n W=390n
Mmp4 n2 VSS n9 VDD g45p1svt M=1 L=45n W=215n
Mmp3 n9 n1 VDD VDD g45p1svt M=1 L=45n W=215n
Mmp2 n1 VSS n7 VDD g45p1svt M=1 L=45n W=215n
Mmp1 n7 n0 VDD VDD g45p1svt M=1 L=45n W=215n
Mmp7 n4 n3 VDD VDD g45p1svt M=1 L=45n W=215n
Mmp0 n0 A VDD VDD g45p1svt M=1 L=45n W=215n
.ENDS

.SUBCKT DLY1X4 A VDD VSS Y
Mmn2 n1 VDD n4 VSS g45n1svt M=1 L=45n W=145n
Mmn1 n4 n0 VSS VSS g45n1svt M=1 L=45n W=145n
Mmn4 Y n2 VSS VSS g45n1svt M=1 L=45n W=1.04u
Mmn0 n0 A VSS VSS g45n1svt M=1 L=45n W=145n
Mmn3 n2 n1 VSS VSS g45n1svt M=1 L=45n W=260n
Mmp2 n1 VSS n5 VDD g45p1svt M=1 L=45n W=215n
Mmp1 n5 n0 VDD VDD g45p1svt M=1 L=45n W=215n
Mmp4 Y n2 VDD VDD g45p1svt M=1 L=45n W=1.56u
Mmp0 n0 A VDD VDD g45p1svt M=1 L=45n W=215n
Mmp3 n2 n1 VDD VDD g45p1svt M=1 L=45n W=390n
.ENDS

.SUBCKT DLY1X1 A VDD VSS Y
Mmn2 n1 VDD n4 VSS g45n1svt M=1 L=45n W=145n
Mmn1 n4 n0 VSS VSS g45n1svt M=1 L=45n W=145n
Mmn4 Y n2 VSS VSS g45n1svt M=1 L=45n W=260n
Mmn0 n0 A VSS VSS g45n1svt M=1 L=45n W=145n
Mmn3 n2 n1 VSS VSS g45n1svt M=1 L=45n W=145n
Mmp2 n1 VSS n5 VDD g45p1svt M=1 L=45n W=215n
Mmp1 n5 n0 VDD VDD g45p1svt M=1 L=45n W=215n
Mmp4 Y n2 VDD VDD g45p1svt M=1 L=45n W=390n
Mmp0 n0 A VDD VDD g45p1svt M=1 L=45n W=215n
Mmp3 n2 n1 VDD VDD g45p1svt M=1 L=45n W=215n
.ENDS

.SUBCKT DFFXL CK D Q QN VDD VSS
Mmn26 n20 CKb n21 VSS g45n1svt M=1 L=45n W=145n
Mmn25 n21 D VSS VSS g45n1svt M=1 L=45n W=145n
Mmn57 QN qint VSS VSS g45n1svt M=1 L=45n W=145n
Mmn55 Q qbint VSS VSS g45n1svt M=1 L=45n W=145n
Mmn50 n35 qbint VSS VSS g45n1svt M=1 L=45n W=145n
Mmn51 n30 CKb n35 VSS g45n1svt M=1 L=45n W=145n
Mmn35 n25 mout VSS VSS g45n1svt M=1 L=45n W=145n
Mmn36 n20 CKbb n25 VSS g45n1svt M=1 L=45n W=145n
Mmn20 CKb CK VSS VSS g45n1svt M=1 L=45n W=145n
Mmn45 qbint n30 VSS VSS g45n1svt M=1 L=45n W=145n
Mmn56 qint qbint VSS VSS g45n1svt M=1 L=45n W=145n
Mmn21 CKbb CKb VSS VSS g45n1svt M=1 L=45n W=145n
Mmn30 mout n20 VSS VSS g45n1svt M=1 L=45n W=145n
Mmn40 n30 CKbb mout VSS g45n1svt M=1 L=45n W=145n
Mmp26 n20 CKbb n22 VDD g45p1svt M=1 L=45n W=215n
Mmp25 n22 D VDD VDD g45p1svt M=1 L=45n W=215n
Mmp51 n30 CKbb n36 VDD g45p1svt M=1 L=45n W=215n
Mmp50 n36 qbint VDD VDD g45p1svt M=1 L=45n W=215n
Mmp57 QN qint VDD VDD g45p1svt M=1 L=45n W=215n
Mmp55 Q qbint VDD VDD g45p1svt M=1 L=45n W=215n
Mmp35 n26 mout VDD VDD g45p1svt M=1 L=45n W=215n
Mmp36 n20 CKb n26 VDD g45p1svt M=1 L=45n W=215n
Mmp20 CKb CK VDD VDD g45p1svt M=1 L=45n W=215n
Mmp45 qbint n30 VDD VDD g45p1svt M=1 L=45n W=215n
Mmp56 qint qbint VDD VDD g45p1svt M=1 L=45n W=215n
Mmp21 CKbb CKb VDD VDD g45p1svt M=1 L=45n W=215n
Mmp40 n30 CKb mout VDD g45p1svt M=1 L=45n W=215n
Mmp30 mout n20 VDD VDD g45p1svt M=1 L=45n W=215n
.ENDS

.SUBCKT DFFX4 CK D Q QN VDD VSS
Mmn26 n20 CKb n21 VSS g45n1svt M=1 L=45n W=145n
Mmn25 n21 D VSS VSS g45n1svt M=1 L=45n W=145n
Mmn57 QN qint VSS VSS g45n1svt M=1 L=45n W=1.04u
Mmn55 Q qbint VSS VSS g45n1svt M=1 L=45n W=1.04u
Mmn50 n35 qbint VSS VSS g45n1svt M=1 L=45n W=145n
Mmn51 n30 CKb n35 VSS g45n1svt M=1 L=45n W=145n
Mmn35 n25 mout VSS VSS g45n1svt M=1 L=45n W=145n
Mmn36 n20 CKbb n25 VSS g45n1svt M=1 L=45n W=145n
Mmn20 CKb CK VSS VSS g45n1svt M=1 L=45n W=145n
Mmn45 qbint n30 VSS VSS g45n1svt M=1 L=45n W=410n
Mmn56 qint qbint VSS VSS g45n1svt M=1 L=45n W=260n
Mmn21 CKbb CKb VSS VSS g45n1svt M=1 L=45n W=145n
Mmn30 mout n20 VSS VSS g45n1svt M=1 L=45n W=145n
Mmn40 n30 CKbb mout VSS g45n1svt M=1 L=45n W=145n
Mmp26 n20 CKbb n22 VDD g45p1svt M=1 L=45n W=215n
Mmp25 n22 D VDD VDD g45p1svt M=1 L=45n W=215n
Mmp51 n30 CKbb n36 VDD g45p1svt M=1 L=45n W=215n
Mmp50 n36 qbint VDD VDD g45p1svt M=1 L=45n W=215n
Mmp57 QN qint VDD VDD g45p1svt M=1 L=45n W=1.56u
Mmp55 Q qbint VDD VDD g45p1svt M=1 L=45n W=1.56u
Mmp35 n26 mout VDD VDD g45p1svt M=1 L=45n W=215n
Mmp36 n20 CKb n26 VDD g45p1svt M=1 L=45n W=215n
Mmp20 CKb CK VDD VDD g45p1svt M=1 L=45n W=215n
Mmp45 qbint n30 VDD VDD g45p1svt M=1 L=45n W=620n
Mmp56 qint qbint VDD VDD g45p1svt M=1 L=45n W=390n
Mmp21 CKbb CKb VDD VDD g45p1svt M=1 L=45n W=215n
Mmp40 n30 CKb mout VDD g45p1svt M=1 L=45n W=215n
Mmp30 mout n20 VDD VDD g45p1svt M=1 L=45n W=215n
.ENDS

.SUBCKT DFFX2 CK D Q QN VDD VSS
Mmn26 n20 CKb n21 VSS g45n1svt M=1 L=45n W=145n
Mmn25 n21 D VSS VSS g45n1svt M=1 L=45n W=145n
Mmn57 QN qint VSS VSS g45n1svt M=1 L=45n W=520n
Mmn55 Q qbint VSS VSS g45n1svt M=1 L=45n W=520n
Mmn50 n35 qbint VSS VSS g45n1svt M=1 L=45n W=145n
Mmn51 n30 CKb n35 VSS g45n1svt M=1 L=45n W=145n
Mmn35 n25 mout VSS VSS g45n1svt M=1 L=45n W=145n
Mmn36 n20 CKbb n25 VSS g45n1svt M=1 L=45n W=145n
Mmn20 CKb CK VSS VSS g45n1svt M=1 L=45n W=145n
Mmn45 qbint n30 VSS VSS g45n1svt M=1 L=45n W=205n
Mmn56 qint qbint VSS VSS g45n1svt M=1 L=45n W=145n
Mmn21 CKbb CKb VSS VSS g45n1svt M=1 L=45n W=145n
Mmn30 mout n20 VSS VSS g45n1svt M=1 L=45n W=145n
Mmn40 n30 CKbb mout VSS g45n1svt M=1 L=45n W=145n
Mmp26 n20 CKbb n22 VDD g45p1svt M=1 L=45n W=215n
Mmp25 n22 D VDD VDD g45p1svt M=1 L=45n W=215n
Mmp51 n30 CKbb n36 VDD g45p1svt M=1 L=45n W=215n
Mmp50 n36 qbint VDD VDD g45p1svt M=1 L=45n W=215n
Mmp57 QN qint VDD VDD g45p1svt M=1 L=45n W=780n
Mmp55 Q qbint VDD VDD g45p1svt M=1 L=45n W=780n
Mmp35 n26 mout VDD VDD g45p1svt M=1 L=45n W=215n
Mmp36 n20 CKb n26 VDD g45p1svt M=1 L=45n W=215n
Mmp20 CKb CK VDD VDD g45p1svt M=1 L=45n W=215n
Mmp45 qbint n30 VDD VDD g45p1svt M=1 L=45n W=310n
Mmp56 qint qbint VDD VDD g45p1svt M=1 L=45n W=215n
Mmp21 CKbb CKb VDD VDD g45p1svt M=1 L=45n W=215n
Mmp40 n30 CKb mout VDD g45p1svt M=1 L=45n W=215n
Mmp30 mout n20 VDD VDD g45p1svt M=1 L=45n W=215n
.ENDS

.SUBCKT DFFX1 CK D Q QN VDD VSS
Mmn26 n20 CKb n21 VSS g45n1svt M=1 L=45n W=145n
Mmn25 n21 D VSS VSS g45n1svt M=1 L=45n W=145n
Mmn57 QN qint VSS VSS g45n1svt M=1 L=45n W=260n
Mmn55 Q qbint VSS VSS g45n1svt M=1 L=45n W=260n
Mmn50 n35 qbint VSS VSS g45n1svt M=1 L=45n W=145n
Mmn51 n30 CKb n35 VSS g45n1svt M=1 L=45n W=145n
Mmn35 n25 mout VSS VSS g45n1svt M=1 L=45n W=145n
Mmn36 n20 CKbb n25 VSS g45n1svt M=1 L=45n W=145n
Mmn20 CKb CK VSS VSS g45n1svt M=1 L=45n W=145n
Mmn45 qbint n30 VSS VSS g45n1svt M=1 L=45n W=145n
Mmn56 qint qbint VSS VSS g45n1svt M=1 L=45n W=145n
Mmn21 CKbb CKb VSS VSS g45n1svt M=1 L=45n W=145n
Mmn30 mout n20 VSS VSS g45n1svt M=1 L=45n W=145n
Mmn40 n30 CKbb mout VSS g45n1svt M=1 L=45n W=145n
Mmp26 n20 CKbb n22 VDD g45p1svt M=1 L=45n W=215n
Mmp25 n22 D VDD VDD g45p1svt M=1 L=45n W=215n
Mmp51 n30 CKbb n36 VDD g45p1svt M=1 L=45n W=215n
Mmp50 n36 qbint VDD VDD g45p1svt M=1 L=45n W=215n
Mmp57 QN qint VDD VDD g45p1svt M=1 L=45n W=390n
Mmp55 Q qbint VDD VDD g45p1svt M=1 L=45n W=390n
Mmp35 n26 mout VDD VDD g45p1svt M=1 L=45n W=215n
Mmp36 n20 CKb n26 VDD g45p1svt M=1 L=45n W=215n
Mmp20 CKb CK VDD VDD g45p1svt M=1 L=45n W=215n
Mmp45 qbint n30 VDD VDD g45p1svt M=1 L=45n W=215n
Mmp56 qint qbint VDD VDD g45p1svt M=1 L=45n W=215n
Mmp21 CKbb CKb VDD VDD g45p1svt M=1 L=45n W=215n
Mmp40 n30 CKb mout VDD g45p1svt M=1 L=45n W=215n
Mmp30 mout n20 VDD VDD g45p1svt M=1 L=45n W=215n
.ENDS

.SUBCKT DFFTRXL CK D Q QN RN VDD VSS
Mmn0 n0 RN VSS VSS g45n1svt M=1 L=45n W=145n
Mmn1 Db D n0 VSS g45n1svt M=1 L=45n W=145n
Mmn57 QN qint VSS VSS g45n1svt M=1 L=45n W=145n
Mmn55 Q qbint VSS VSS g45n1svt M=1 L=45n W=145n
Mmn50 n35 qbint VSS VSS g45n1svt M=1 L=45n W=145n
Mmn51 n30 CKb n35 VSS g45n1svt M=1 L=45n W=145n
Mmn25 n20 CKb Db VSS g45n1svt M=1 L=45n W=145n
Mmn20 CKb CK VSS VSS g45n1svt M=1 L=45n W=145n
Mmn35 n25 mout VSS VSS g45n1svt M=1 L=45n W=145n
Mmn21 CKbb CKb VSS VSS g45n1svt M=1 L=45n W=145n
Mmn36 n20 CKbb n25 VSS g45n1svt M=1 L=45n W=145n
Mmn40 n30 CKbb mout VSS g45n1svt M=1 L=45n W=145n
Mmn30 mout n20 VSS VSS g45n1svt M=1 L=45n W=145n
Mmn56 qint qbint VSS VSS g45n1svt M=1 L=45n W=145n
Mmn45 qbint n30 VSS VSS g45n1svt M=1 L=45n W=145n
Mmp1 Db D VDD VDD g45p1svt M=1 L=45n W=215n
Mmp0 Db RN VDD VDD g45p1svt M=1 L=45n W=215n
Mmp51 n30 CKbb n36 VDD g45p1svt M=1 L=45n W=215n
Mmp50 n36 qbint VDD VDD g45p1svt M=1 L=45n W=215n
Mmp57 QN qint VDD VDD g45p1svt M=1 L=45n W=215n
Mmp55 Q qbint VDD VDD g45p1svt M=1 L=45n W=215n
Mmp35 n26 mout VDD VDD g45p1svt M=1 L=45n W=215n
Mmp56 qint qbint VDD VDD g45p1svt M=1 L=45n W=215n
Mmp20 CKb CK VDD VDD g45p1svt M=1 L=45n W=215n
Mmp36 n20 CKb n26 VDD g45p1svt M=1 L=45n W=215n
Mmp45 qbint n30 VDD VDD g45p1svt M=1 L=45n W=215n
Mmp30 mout n20 VDD VDD g45p1svt M=1 L=45n W=215n
Mmp40 n30 CKb mout VDD g45p1svt M=1 L=45n W=215n
Mmp21 CKbb CKb VDD VDD g45p1svt M=1 L=45n W=215n
Mmp25 n20 CKbb Db VDD g45p1svt M=1 L=45n W=215n
.ENDS

.SUBCKT DFFTRX4 CK D Q QN RN VDD VSS
Mmn0 n0 RN VSS VSS g45n1svt M=1 L=45n W=145n
Mmn1 Db D n0 VSS g45n1svt M=1 L=45n W=145n
Mmn57 QN qint VSS VSS g45n1svt M=1 L=45n W=1.04u
Mmn55 Q qbint VSS VSS g45n1svt M=1 L=45n W=1.04u
Mmn50 n35 qbint VSS VSS g45n1svt M=1 L=45n W=145n
Mmn51 n30 CKb n35 VSS g45n1svt M=1 L=45n W=145n
Mmn25 n20 CKb Db VSS g45n1svt M=1 L=45n W=145n
Mmn20 CKb CK VSS VSS g45n1svt M=1 L=45n W=145n
Mmn35 n25 mout VSS VSS g45n1svt M=1 L=45n W=145n
Mmn21 CKbb CKb VSS VSS g45n1svt M=1 L=45n W=145n
Mmn36 n20 CKbb n25 VSS g45n1svt M=1 L=45n W=145n
Mmn40 n30 CKbb mout VSS g45n1svt M=1 L=45n W=145n
Mmn30 mout n20 VSS VSS g45n1svt M=1 L=45n W=145n
Mmn56 qint qbint VSS VSS g45n1svt M=1 L=45n W=260n
Mmn45 qbint n30 VSS VSS g45n1svt M=1 L=45n W=410n
Mmp1 Db D VDD VDD g45p1svt M=1 L=45n W=215n
Mmp0 Db RN VDD VDD g45p1svt M=1 L=45n W=215n
Mmp51 n30 CKbb n36 VDD g45p1svt M=1 L=45n W=215n
Mmp50 n36 qbint VDD VDD g45p1svt M=1 L=45n W=215n
Mmp57 QN qint VDD VDD g45p1svt M=1 L=45n W=1.56u
Mmp55 Q qbint VDD VDD g45p1svt M=1 L=45n W=1.56u
Mmp35 n26 mout VDD VDD g45p1svt M=1 L=45n W=215n
Mmp56 qint qbint VDD VDD g45p1svt M=1 L=45n W=390n
Mmp20 CKb CK VDD VDD g45p1svt M=1 L=45n W=215n
Mmp36 n20 CKb n26 VDD g45p1svt M=1 L=45n W=215n
Mmp45 qbint n30 VDD VDD g45p1svt M=1 L=45n W=620n
Mmp30 mout n20 VDD VDD g45p1svt M=1 L=45n W=215n
Mmp40 n30 CKb mout VDD g45p1svt M=1 L=45n W=215n
Mmp21 CKbb CKb VDD VDD g45p1svt M=1 L=45n W=215n
Mmp25 n20 CKbb Db VDD g45p1svt M=1 L=45n W=215n
.ENDS

.SUBCKT DFFTRX2 CK D Q QN RN VDD VSS
Mmn0 n0 RN VSS VSS g45n1svt M=1 L=45n W=145n
Mmn1 Db D n0 VSS g45n1svt M=1 L=45n W=145n
Mmn57 QN qint VSS VSS g45n1svt M=1 L=45n W=520n
Mmn55 Q qbint VSS VSS g45n1svt M=1 L=45n W=520n
Mmn50 n35 qbint VSS VSS g45n1svt M=1 L=45n W=145n
Mmn51 n30 CKb n35 VSS g45n1svt M=1 L=45n W=145n
Mmn25 n20 CKb Db VSS g45n1svt M=1 L=45n W=145n
Mmn20 CKb CK VSS VSS g45n1svt M=1 L=45n W=145n
Mmn35 n25 mout VSS VSS g45n1svt M=1 L=45n W=145n
Mmn21 CKbb CKb VSS VSS g45n1svt M=1 L=45n W=145n
Mmn36 n20 CKbb n25 VSS g45n1svt M=1 L=45n W=145n
Mmn40 n30 CKbb mout VSS g45n1svt M=1 L=45n W=145n
Mmn30 mout n20 VSS VSS g45n1svt M=1 L=45n W=145n
Mmn56 qint qbint VSS VSS g45n1svt M=1 L=45n W=145n
Mmn45 qbint n30 VSS VSS g45n1svt M=1 L=45n W=205n
Mmp1 Db D VDD VDD g45p1svt M=1 L=45n W=215n
Mmp0 Db RN VDD VDD g45p1svt M=1 L=45n W=215n
Mmp51 n30 CKbb n36 VDD g45p1svt M=1 L=45n W=215n
Mmp50 n36 qbint VDD VDD g45p1svt M=1 L=45n W=215n
Mmp57 QN qint VDD VDD g45p1svt M=1 L=45n W=780n
Mmp55 Q qbint VDD VDD g45p1svt M=1 L=45n W=780n
Mmp35 n26 mout VDD VDD g45p1svt M=1 L=45n W=215n
Mmp56 qint qbint VDD VDD g45p1svt M=1 L=45n W=215n
Mmp20 CKb CK VDD VDD g45p1svt M=1 L=45n W=215n
Mmp36 n20 CKb n26 VDD g45p1svt M=1 L=45n W=215n
Mmp45 qbint n30 VDD VDD g45p1svt M=1 L=45n W=310n
Mmp30 mout n20 VDD VDD g45p1svt M=1 L=45n W=215n
Mmp40 n30 CKb mout VDD g45p1svt M=1 L=45n W=215n
Mmp21 CKbb CKb VDD VDD g45p1svt M=1 L=45n W=215n
Mmp25 n20 CKbb Db VDD g45p1svt M=1 L=45n W=215n
.ENDS

.SUBCKT DFFTRX1 CK D Q QN RN VDD VSS
Mmn0 n0 RN VSS VSS g45n1svt M=1 L=45n W=145n
Mmn1 Db D n0 VSS g45n1svt M=1 L=45n W=145n
Mmn57 QN qint VSS VSS g45n1svt M=1 L=45n W=260n
Mmn55 Q qbint VSS VSS g45n1svt M=1 L=45n W=260n
Mmn50 n35 qbint VSS VSS g45n1svt M=1 L=45n W=145n
Mmn51 n30 CKb n35 VSS g45n1svt M=1 L=45n W=145n
Mmn25 n20 CKb Db VSS g45n1svt M=1 L=45n W=145n
Mmn20 CKb CK VSS VSS g45n1svt M=1 L=45n W=145n
Mmn35 n25 mout VSS VSS g45n1svt M=1 L=45n W=145n
Mmn21 CKbb CKb VSS VSS g45n1svt M=1 L=45n W=145n
Mmn36 n20 CKbb n25 VSS g45n1svt M=1 L=45n W=145n
Mmn40 n30 CKbb mout VSS g45n1svt M=1 L=45n W=145n
Mmn30 mout n20 VSS VSS g45n1svt M=1 L=45n W=145n
Mmn56 qint qbint VSS VSS g45n1svt M=1 L=45n W=145n
Mmn45 qbint n30 VSS VSS g45n1svt M=1 L=45n W=145n
Mmp1 Db D VDD VDD g45p1svt M=1 L=45n W=215n
Mmp0 Db RN VDD VDD g45p1svt M=1 L=45n W=215n
Mmp51 n30 CKbb n36 VDD g45p1svt M=1 L=45n W=215n
Mmp50 n36 qbint VDD VDD g45p1svt M=1 L=45n W=215n
Mmp57 QN qint VDD VDD g45p1svt M=1 L=45n W=390n
Mmp55 Q qbint VDD VDD g45p1svt M=1 L=45n W=390n
Mmp35 n26 mout VDD VDD g45p1svt M=1 L=45n W=215n
Mmp56 qint qbint VDD VDD g45p1svt M=1 L=45n W=215n
Mmp20 CKb CK VDD VDD g45p1svt M=1 L=45n W=215n
Mmp36 n20 CKb n26 VDD g45p1svt M=1 L=45n W=215n
Mmp45 qbint n30 VDD VDD g45p1svt M=1 L=45n W=215n
Mmp30 mout n20 VDD VDD g45p1svt M=1 L=45n W=215n
Mmp40 n30 CKb mout VDD g45p1svt M=1 L=45n W=215n
Mmp21 CKbb CKb VDD VDD g45p1svt M=1 L=45n W=215n
Mmp25 n20 CKbb Db VDD g45p1svt M=1 L=45n W=215n
.ENDS

.SUBCKT DFFSXL CK D Q QN SN VDD VSS
Mmn51 n40 qbint n42 VSS g45n1svt M=1 L=45n W=145n
Mmn52 n35 CKb n40 VSS g45n1svt M=1 L=45n W=145n
Mmn50 n42 SN VSS VSS g45n1svt M=1 L=45n W=145n
Mmn26 n20 CKb n21 VSS g45n1svt M=1 L=45n W=145n
Mmn25 n21 D VSS VSS g45n1svt M=1 L=45n W=145n
Mmn57 QN net331 VSS VSS g45n1svt M=1 L=45n W=145n
Mmn55 Q qbint VSS VSS g45n1svt M=1 L=45n W=145n
Mmn30 n25 SN VSS VSS g45n1svt M=1 L=45n W=145n
Mmn31 mout n20 n25 VSS g45n1svt M=1 L=45n W=145n
Mmn35 n20 CKbb n30 VSS g45n1svt M=1 L=45n W=145n
Mmn36 n30 mout VSS VSS g45n1svt M=1 L=45n W=145n
Mmn56 net331 qbint VSS VSS g45n1svt M=1 L=45n W=145n
Mmn20 CKb CK VSS VSS g45n1svt M=1 L=45n W=145n
Mmn21 CKbb CKb VSS VSS g45n1svt M=1 L=45n W=145n
Mmn45 qbint n35 VSS VSS g45n1svt M=1 L=45n W=145n
Mmn40 n35 CKbb mout VSS g45n1svt M=1 L=45n W=145n
Mmp26 n20 CKbb n22 VDD g45p1svt M=1 L=45n W=215n
Mmp25 n22 D VDD VDD g45p1svt M=1 L=45n W=215n
Mmp57 QN net331 VDD VDD g45p1svt M=1 L=45n W=215n
Mmp55 Q qbint VDD VDD g45p1svt M=1 L=45n W=215n
Mmp36 n20 CKb n31 VDD g45p1svt M=1 L=45n W=215n
Mmp35 n31 mout VDD VDD g45p1svt M=1 L=45n W=215n
Mmp20 CKb CK VDD VDD g45p1svt M=1 L=45n W=215n
Mmp31 mout n20 VDD VDD g45p1svt M=1 L=45n W=215n
Mmp40 n35 CKb mout VDD g45p1svt M=1 L=45n W=215n
Mmp56 net331 qbint VDD VDD g45p1svt M=1 L=45n W=215n
Mmp45 qbint n35 VDD VDD g45p1svt M=1 L=45n W=215n
Mmp52 n35 CKbb n41 VDD g45p1svt M=1 L=45n W=215n
Mmp21 CKbb CKb VDD VDD g45p1svt M=1 L=45n W=215n
Mmp30 mout SN VDD VDD g45p1svt M=1 L=45n W=215n
Mmp51 n41 qbint VDD VDD g45p1svt M=1 L=45n W=215n
Mmp50 n41 SN VDD VDD g45p1svt M=1 L=45n W=215n
.ENDS

.SUBCKT DFFSX4 CK D Q QN SN VDD VSS
Mmn51 n40 qbint n42 VSS g45n1svt M=1 L=45n W=145n
Mmn52 n35 CKb n40 VSS g45n1svt M=1 L=45n W=145n
Mmn50 n42 SN VSS VSS g45n1svt M=1 L=45n W=145n
Mmn26 n20 CKb n21 VSS g45n1svt M=1 L=45n W=145n
Mmn25 n21 D VSS VSS g45n1svt M=1 L=45n W=145n
Mmn57 QN net331 VSS VSS g45n1svt M=1 L=45n W=1.04u
Mmn55 Q qbint VSS VSS g45n1svt M=1 L=45n W=1.04u
Mmn30 n25 SN VSS VSS g45n1svt M=1 L=45n W=145n
Mmn31 mout n20 n25 VSS g45n1svt M=1 L=45n W=145n
Mmn35 n20 CKbb n30 VSS g45n1svt M=1 L=45n W=145n
Mmn36 n30 mout VSS VSS g45n1svt M=1 L=45n W=145n
Mmn56 net331 qbint VSS VSS g45n1svt M=1 L=45n W=260n
Mmn20 CKb CK VSS VSS g45n1svt M=1 L=45n W=145n
Mmn21 CKbb CKb VSS VSS g45n1svt M=1 L=45n W=145n
Mmn45 qbint n35 VSS VSS g45n1svt M=1 L=45n W=410n
Mmn40 n35 CKbb mout VSS g45n1svt M=1 L=45n W=145n
Mmp26 n20 CKbb n22 VDD g45p1svt M=1 L=45n W=215n
Mmp25 n22 D VDD VDD g45p1svt M=1 L=45n W=215n
Mmp57 QN net331 VDD VDD g45p1svt M=1 L=45n W=1.56u
Mmp55 Q qbint VDD VDD g45p1svt M=1 L=45n W=1.56u
Mmp36 n20 CKb n31 VDD g45p1svt M=1 L=45n W=215n
Mmp35 n31 mout VDD VDD g45p1svt M=1 L=45n W=215n
Mmp20 CKb CK VDD VDD g45p1svt M=1 L=45n W=215n
Mmp31 mout n20 VDD VDD g45p1svt M=1 L=45n W=215n
Mmp40 n35 CKb mout VDD g45p1svt M=1 L=45n W=215n
Mmp56 net331 qbint VDD VDD g45p1svt M=1 L=45n W=390n
Mmp45 qbint n35 VDD VDD g45p1svt M=1 L=45n W=620n
Mmp52 n35 CKbb n41 VDD g45p1svt M=1 L=45n W=215n
Mmp21 CKbb CKb VDD VDD g45p1svt M=1 L=45n W=215n
Mmp30 mout SN VDD VDD g45p1svt M=1 L=45n W=215n
Mmp51 n41 qbint VDD VDD g45p1svt M=1 L=45n W=215n
Mmp50 n41 SN VDD VDD g45p1svt M=1 L=45n W=215n
.ENDS

.SUBCKT DFFSX2 CK D Q QN SN VDD VSS
Mmn51 n40 qbint n42 VSS g45n1svt M=1 L=45n W=145n
Mmn52 n35 CKb n40 VSS g45n1svt M=1 L=45n W=145n
Mmn50 n42 SN VSS VSS g45n1svt M=1 L=45n W=145n
Mmn26 n20 CKb n21 VSS g45n1svt M=1 L=45n W=145n
Mmn25 n21 D VSS VSS g45n1svt M=1 L=45n W=145n
Mmn57 QN net331 VSS VSS g45n1svt M=1 L=45n W=520n
Mmn55 Q qbint VSS VSS g45n1svt M=1 L=45n W=520n
Mmn30 n25 SN VSS VSS g45n1svt M=1 L=45n W=145n
Mmn31 mout n20 n25 VSS g45n1svt M=1 L=45n W=145n
Mmn35 n20 CKbb n30 VSS g45n1svt M=1 L=45n W=145n
Mmn36 n30 mout VSS VSS g45n1svt M=1 L=45n W=145n
Mmn56 net331 qbint VSS VSS g45n1svt M=1 L=45n W=145n
Mmn20 CKb CK VSS VSS g45n1svt M=1 L=45n W=145n
Mmn21 CKbb CKb VSS VSS g45n1svt M=1 L=45n W=145n
Mmn45 qbint n35 VSS VSS g45n1svt M=1 L=45n W=205n
Mmn40 n35 CKbb mout VSS g45n1svt M=1 L=45n W=145n
Mmp26 n20 CKbb n22 VDD g45p1svt M=1 L=45n W=215n
Mmp25 n22 D VDD VDD g45p1svt M=1 L=45n W=215n
Mmp57 QN net331 VDD VDD g45p1svt M=1 L=45n W=780n
Mmp55 Q qbint VDD VDD g45p1svt M=1 L=45n W=780n
Mmp36 n20 CKb n31 VDD g45p1svt M=1 L=45n W=215n
Mmp35 n31 mout VDD VDD g45p1svt M=1 L=45n W=215n
Mmp20 CKb CK VDD VDD g45p1svt M=1 L=45n W=215n
Mmp31 mout n20 VDD VDD g45p1svt M=1 L=45n W=215n
Mmp40 n35 CKb mout VDD g45p1svt M=1 L=45n W=215n
Mmp56 net331 qbint VDD VDD g45p1svt M=1 L=45n W=215n
Mmp45 qbint n35 VDD VDD g45p1svt M=1 L=45n W=310n
Mmp52 n35 CKbb n41 VDD g45p1svt M=1 L=45n W=215n
Mmp21 CKbb CKb VDD VDD g45p1svt M=1 L=45n W=215n
Mmp30 mout SN VDD VDD g45p1svt M=1 L=45n W=215n
Mmp51 n41 qbint VDD VDD g45p1svt M=1 L=45n W=215n
Mmp50 n41 SN VDD VDD g45p1svt M=1 L=45n W=215n
.ENDS

.SUBCKT DFFSX1 CK D Q QN SN VDD VSS
Mmn51 n40 qbint n42 VSS g45n1svt M=1 L=45n W=145n
Mmn52 n35 CKb n40 VSS g45n1svt M=1 L=45n W=145n
Mmn50 n42 SN VSS VSS g45n1svt M=1 L=45n W=145n
Mmn26 n20 CKb n21 VSS g45n1svt M=1 L=45n W=145n
Mmn25 n21 D VSS VSS g45n1svt M=1 L=45n W=145n
Mmn57 QN net331 VSS VSS g45n1svt M=1 L=45n W=260n
Mmn55 Q qbint VSS VSS g45n1svt M=1 L=45n W=260n
Mmn30 n25 SN VSS VSS g45n1svt M=1 L=45n W=145n
Mmn31 mout n20 n25 VSS g45n1svt M=1 L=45n W=145n
Mmn35 n20 CKbb n30 VSS g45n1svt M=1 L=45n W=145n
Mmn36 n30 mout VSS VSS g45n1svt M=1 L=45n W=145n
Mmn56 net331 qbint VSS VSS g45n1svt M=1 L=45n W=145n
Mmn20 CKb CK VSS VSS g45n1svt M=1 L=45n W=145n
Mmn21 CKbb CKb VSS VSS g45n1svt M=1 L=45n W=145n
Mmn45 qbint n35 VSS VSS g45n1svt M=1 L=45n W=145n
Mmn40 n35 CKbb mout VSS g45n1svt M=1 L=45n W=145n
Mmp26 n20 CKbb n22 VDD g45p1svt M=1 L=45n W=215n
Mmp25 n22 D VDD VDD g45p1svt M=1 L=45n W=215n
Mmp57 QN net331 VDD VDD g45p1svt M=1 L=45n W=390n
Mmp55 Q qbint VDD VDD g45p1svt M=1 L=45n W=390n
Mmp36 n20 CKb n31 VDD g45p1svt M=1 L=45n W=215n
Mmp35 n31 mout VDD VDD g45p1svt M=1 L=45n W=215n
Mmp20 CKb CK VDD VDD g45p1svt M=1 L=45n W=215n
Mmp31 mout n20 VDD VDD g45p1svt M=1 L=45n W=215n
Mmp40 n35 CKb mout VDD g45p1svt M=1 L=45n W=215n
Mmp56 net331 qbint VDD VDD g45p1svt M=1 L=45n W=215n
Mmp45 qbint n35 VDD VDD g45p1svt M=1 L=45n W=215n
Mmp52 n35 CKbb n41 VDD g45p1svt M=1 L=45n W=215n
Mmp21 CKbb CKb VDD VDD g45p1svt M=1 L=45n W=215n
Mmp30 mout SN VDD VDD g45p1svt M=1 L=45n W=215n
Mmp51 n41 qbint VDD VDD g45p1svt M=1 L=45n W=215n
Mmp50 n41 SN VDD VDD g45p1svt M=1 L=45n W=215n
.ENDS

.SUBCKT DFFSRXL CK D Q QN RN SN VDD VSS
Mmn26 n20 CKb n21 VSS g45n1svt M=1 L=45n W=145n
Mmn25 n21 D VSS VSS g45n1svt M=1 L=45n W=145n
Mmn57 QN qint VSS VSS g45n1svt M=1 L=45n W=145n
Mmn55 Q qbint VSS VSS g45n1svt M=1 L=45n W=145n
Mmn35 n30 mout VSS VSS g45n1svt M=1 L=45n W=145n
Mmn36 n20 CKbb n30 VSS g45n1svt M=1 L=45n W=145n
Mmn22 RNb RN VSS VSS g45n1svt M=1 L=45n W=145n
Mmn20 CKb CK VSS VSS g45n1svt M=1 L=45n W=145n
Mmn45 qbint n35 VSS VSS g45n1svt M=1 L=45n W=145n
Mmn56 qint qbint VSS VSS g45n1svt M=1 L=45n W=145n
Mmn52 n40 qbint n42 VSS g45n1svt M=1 L=45n W=145n
Mmn51 n40 RNb n42 VSS g45n1svt M=1 L=45n W=145n
Mmn50 n42 SN VSS VSS g45n1svt M=1 L=45n W=145n
Mmn53 n35 CKb n40 VSS g45n1svt M=1 L=45n W=145n
Mmn21 CKbb CKb VSS VSS g45n1svt M=1 L=45n W=145n
Mmn32 mout n20 net426 VSS g45n1svt M=1 L=45n W=145n
Mmn31 mout RNb net426 VSS g45n1svt M=1 L=45n W=145n
Mmn40 n35 CKbb mout VSS g45n1svt M=1 L=45n W=145n
Mmn30 net426 SN VSS VSS g45n1svt M=1 L=45n W=145n
Mmp26 n20 CKbb n22 VDD g45p1svt M=1 L=45n W=215n
Mmp25 n22 D VDD VDD g45p1svt M=1 L=45n W=215n
Mmp52 n41 qbint n43 VDD g45p1svt M=1 L=45n W=215n
Mmp51 n43 RNb VDD VDD g45p1svt M=1 L=45n W=215n
Mmp57 QN qint VDD VDD g45p1svt M=1 L=45n W=215n
Mmp55 Q qbint VDD VDD g45p1svt M=1 L=45n W=215n
Mmp36 n20 CKb n31 VDD g45p1svt M=1 L=45n W=215n
Mmp35 n31 mout VDD VDD g45p1svt M=1 L=45n W=215n
Mmp32 mout n20 net402 VDD g45p1svt M=1 L=45n W=215n
Mmp31 net402 RNb VDD VDD g45p1svt M=1 L=45n W=215n
Mmp22 RNb RN VDD VDD g45p1svt M=1 L=45n W=215n
Mmp20 CKb CK VDD VDD g45p1svt M=1 L=45n W=215n
Mmp53 n35 CKbb n41 VDD g45p1svt M=1 L=45n W=215n
Mmp50 n41 SN VDD VDD g45p1svt M=1 L=45n W=215n
Mmp45 qbint n35 VDD VDD g45p1svt M=1 L=45n W=215n
Mmp56 qint qbint VDD VDD g45p1svt M=1 L=45n W=215n
Mmp21 CKbb CKb VDD VDD g45p1svt M=1 L=45n W=215n
Mmp30 mout SN VDD VDD g45p1svt M=1 L=45n W=215n
Mmp40 n35 CKb mout VDD g45p1svt M=1 L=45n W=215n
.ENDS

.SUBCKT DFFSRX4 CK D Q QN RN SN VDD VSS
Mmn26 n20 CKb n21 VSS g45n1svt M=1 L=45n W=145n
Mmn25 n21 D VSS VSS g45n1svt M=1 L=45n W=145n
Mmn57 QN qint VSS VSS g45n1svt M=1 L=45n W=1.04u
Mmn55 Q qbint VSS VSS g45n1svt M=1 L=45n W=1.04u
Mmn35 n30 mout VSS VSS g45n1svt M=1 L=45n W=145n
Mmn36 n20 CKbb n30 VSS g45n1svt M=1 L=45n W=145n
Mmn22 RNb RN VSS VSS g45n1svt M=1 L=45n W=145n
Mmn20 CKb CK VSS VSS g45n1svt M=1 L=45n W=145n
Mmn45 qbint n35 VSS VSS g45n1svt M=1 L=45n W=410n
Mmn56 qint qbint VSS VSS g45n1svt M=1 L=45n W=260n
Mmn52 n40 qbint n42 VSS g45n1svt M=1 L=45n W=145n
Mmn51 n40 RNb n42 VSS g45n1svt M=1 L=45n W=145n
Mmn50 n42 SN VSS VSS g45n1svt M=1 L=45n W=145n
Mmn53 n35 CKb n40 VSS g45n1svt M=1 L=45n W=145n
Mmn21 CKbb CKb VSS VSS g45n1svt M=1 L=45n W=145n
Mmn32 mout n20 net426 VSS g45n1svt M=1 L=45n W=145n
Mmn31 mout RNb net426 VSS g45n1svt M=1 L=45n W=145n
Mmn40 n35 CKbb mout VSS g45n1svt M=1 L=45n W=145n
Mmn30 net426 SN VSS VSS g45n1svt M=1 L=45n W=145n
Mmp26 n20 CKbb n22 VDD g45p1svt M=1 L=45n W=215n
Mmp25 n22 D VDD VDD g45p1svt M=1 L=45n W=215n
Mmp52 n41 qbint n43 VDD g45p1svt M=1 L=45n W=215n
Mmp51 n43 RNb VDD VDD g45p1svt M=1 L=45n W=215n
Mmp57 QN qint VDD VDD g45p1svt M=1 L=45n W=1.56u
Mmp55 Q qbint VDD VDD g45p1svt M=1 L=45n W=1.56u
Mmp36 n20 CKb n31 VDD g45p1svt M=1 L=45n W=215n
Mmp35 n31 mout VDD VDD g45p1svt M=1 L=45n W=215n
Mmp32 mout n20 net402 VDD g45p1svt M=1 L=45n W=215n
Mmp31 net402 RNb VDD VDD g45p1svt M=1 L=45n W=215n
Mmp22 RNb RN VDD VDD g45p1svt M=1 L=45n W=215n
Mmp20 CKb CK VDD VDD g45p1svt M=1 L=45n W=215n
Mmp53 n35 CKbb n41 VDD g45p1svt M=1 L=45n W=215n
Mmp50 n41 SN VDD VDD g45p1svt M=1 L=45n W=215n
Mmp45 qbint n35 VDD VDD g45p1svt M=1 L=45n W=620n
Mmp56 qint qbint VDD VDD g45p1svt M=1 L=45n W=390n
Mmp21 CKbb CKb VDD VDD g45p1svt M=1 L=45n W=215n
Mmp30 mout SN VDD VDD g45p1svt M=1 L=45n W=215n
Mmp40 n35 CKb mout VDD g45p1svt M=1 L=45n W=215n
.ENDS

.SUBCKT DFFSRX2 CK D Q QN RN SN VDD VSS
Mmn26 n20 CKb n21 VSS g45n1svt M=1 L=45n W=145n
Mmn25 n21 D VSS VSS g45n1svt M=1 L=45n W=145n
Mmn57 QN qint VSS VSS g45n1svt M=1 L=45n W=520n
Mmn55 Q qbint VSS VSS g45n1svt M=1 L=45n W=520n
Mmn35 n30 mout VSS VSS g45n1svt M=1 L=45n W=145n
Mmn36 n20 CKbb n30 VSS g45n1svt M=1 L=45n W=145n
Mmn22 RNb RN VSS VSS g45n1svt M=1 L=45n W=145n
Mmn20 CKb CK VSS VSS g45n1svt M=1 L=45n W=145n
Mmn45 qbint n35 VSS VSS g45n1svt M=1 L=45n W=205n
Mmn56 qint qbint VSS VSS g45n1svt M=1 L=45n W=145n
Mmn52 n40 qbint n42 VSS g45n1svt M=1 L=45n W=145n
Mmn51 n40 RNb n42 VSS g45n1svt M=1 L=45n W=145n
Mmn50 n42 SN VSS VSS g45n1svt M=1 L=45n W=145n
Mmn53 n35 CKb n40 VSS g45n1svt M=1 L=45n W=145n
Mmn21 CKbb CKb VSS VSS g45n1svt M=1 L=45n W=145n
Mmn32 mout n20 net426 VSS g45n1svt M=1 L=45n W=145n
Mmn31 mout RNb net426 VSS g45n1svt M=1 L=45n W=145n
Mmn40 n35 CKbb mout VSS g45n1svt M=1 L=45n W=145n
Mmn30 net426 SN VSS VSS g45n1svt M=1 L=45n W=145n
Mmp26 n20 CKbb n22 VDD g45p1svt M=1 L=45n W=215n
Mmp25 n22 D VDD VDD g45p1svt M=1 L=45n W=215n
Mmp52 n41 qbint n43 VDD g45p1svt M=1 L=45n W=215n
Mmp51 n43 RNb VDD VDD g45p1svt M=1 L=45n W=215n
Mmp57 QN qint VDD VDD g45p1svt M=1 L=45n W=780n
Mmp55 Q qbint VDD VDD g45p1svt M=1 L=45n W=780n
Mmp36 n20 CKb n31 VDD g45p1svt M=1 L=45n W=215n
Mmp35 n31 mout VDD VDD g45p1svt M=1 L=45n W=215n
Mmp32 mout n20 net402 VDD g45p1svt M=1 L=45n W=215n
Mmp31 net402 RNb VDD VDD g45p1svt M=1 L=45n W=215n
Mmp22 RNb RN VDD VDD g45p1svt M=1 L=45n W=215n
Mmp20 CKb CK VDD VDD g45p1svt M=1 L=45n W=215n
Mmp53 n35 CKbb n41 VDD g45p1svt M=1 L=45n W=215n
Mmp50 n41 SN VDD VDD g45p1svt M=1 L=45n W=215n
Mmp45 qbint n35 VDD VDD g45p1svt M=1 L=45n W=310n
Mmp56 qint qbint VDD VDD g45p1svt M=1 L=45n W=215n
Mmp21 CKbb CKb VDD VDD g45p1svt M=1 L=45n W=215n
Mmp30 mout SN VDD VDD g45p1svt M=1 L=45n W=215n
Mmp40 n35 CKb mout VDD g45p1svt M=1 L=45n W=215n
.ENDS

.SUBCKT DFFSRX1 CK D Q QN RN SN VDD VSS
Mmn26 n20 CKb n21 VSS g45n1svt M=1 L=45n W=145n
Mmn25 n21 D VSS VSS g45n1svt M=1 L=45n W=145n
Mmn57 QN qint VSS VSS g45n1svt M=1 L=45n W=260n
Mmn55 Q qbint VSS VSS g45n1svt M=1 L=45n W=260n
Mmn35 n30 mout VSS VSS g45n1svt M=1 L=45n W=145n
Mmn36 n20 CKbb n30 VSS g45n1svt M=1 L=45n W=145n
Mmn22 RNb RN VSS VSS g45n1svt M=1 L=45n W=145n
Mmn20 CKb CK VSS VSS g45n1svt M=1 L=45n W=145n
Mmn45 qbint n35 VSS VSS g45n1svt M=1 L=45n W=145n
Mmn56 qint qbint VSS VSS g45n1svt M=1 L=45n W=145n
Mmn52 n40 qbint n42 VSS g45n1svt M=1 L=45n W=145n
Mmn51 n40 RNb n42 VSS g45n1svt M=1 L=45n W=145n
Mmn50 n42 SN VSS VSS g45n1svt M=1 L=45n W=145n
Mmn53 n35 CKb n40 VSS g45n1svt M=1 L=45n W=145n
Mmn21 CKbb CKb VSS VSS g45n1svt M=1 L=45n W=145n
Mmn32 mout n20 net426 VSS g45n1svt M=1 L=45n W=145n
Mmn31 mout RNb net426 VSS g45n1svt M=1 L=45n W=145n
Mmn40 n35 CKbb mout VSS g45n1svt M=1 L=45n W=145n
Mmn30 net426 SN VSS VSS g45n1svt M=1 L=45n W=145n
Mmp26 n20 CKbb n22 VDD g45p1svt M=1 L=45n W=215n
Mmp25 n22 D VDD VDD g45p1svt M=1 L=45n W=215n
Mmp52 n41 qbint n43 VDD g45p1svt M=1 L=45n W=215n
Mmp51 n43 RNb VDD VDD g45p1svt M=1 L=45n W=215n
Mmp57 QN qint VDD VDD g45p1svt M=1 L=45n W=390n
Mmp55 Q qbint VDD VDD g45p1svt M=1 L=45n W=390n
Mmp36 n20 CKb n31 VDD g45p1svt M=1 L=45n W=215n
Mmp35 n31 mout VDD VDD g45p1svt M=1 L=45n W=215n
Mmp32 mout n20 net402 VDD g45p1svt M=1 L=45n W=215n
Mmp31 net402 RNb VDD VDD g45p1svt M=1 L=45n W=215n
Mmp22 RNb RN VDD VDD g45p1svt M=1 L=45n W=215n
Mmp20 CKb CK VDD VDD g45p1svt M=1 L=45n W=215n
Mmp53 n35 CKbb n41 VDD g45p1svt M=1 L=45n W=215n
Mmp50 n41 SN VDD VDD g45p1svt M=1 L=45n W=215n
Mmp45 qbint n35 VDD VDD g45p1svt M=1 L=45n W=215n
Mmp56 qint qbint VDD VDD g45p1svt M=1 L=45n W=215n
Mmp21 CKbb CKb VDD VDD g45p1svt M=1 L=45n W=215n
Mmp30 mout SN VDD VDD g45p1svt M=1 L=45n W=215n
Mmp40 n35 CKb mout VDD g45p1svt M=1 L=45n W=215n
.ENDS

.SUBCKT DFFSRHQX8 CK D Q RN SN VDD VSS
Mmn26 n20 CKb n21 VSS g45n1svt M=1 L=45n W=205n
Mmn25 n21 D VSS VSS g45n1svt M=1 L=45n W=205n
Mmn55 Q qbint VSS VSS g45n1svt M=1 L=45n W=2.065u
Mmn35 n30 mout VSS VSS g45n1svt M=1 L=45n W=205n
Mmn36 n20 CKbb n30 VSS g45n1svt M=1 L=45n W=205n
Mmn22 RNb RN VSS VSS g45n1svt M=1 L=45n W=145n
Mmn20 CKb CK VSS VSS g45n1svt M=1 L=45n W=145n
Mmn45 qbint n35 VSS VSS g45n1svt M=1 L=45n W=780n
Mmn52 n40 qbint n42 VSS g45n1svt M=1 L=45n W=205n
Mmn51 n40 RNb n42 VSS g45n1svt M=1 L=45n W=205n
Mmn32 mout n20 n25 VSS g45n1svt M=1 L=45n W=205n
Mmn50 n42 SN VSS VSS g45n1svt M=1 L=45n W=205n
Mmn30 n25 SN VSS VSS g45n1svt M=1 L=45n W=205n
Mmn40 n35 CKbb mout VSS g45n1svt M=1 L=45n W=205n
Mmn31 mout RNb n25 VSS g45n1svt M=1 L=45n W=205n
Mmn21 CKbb CKb VSS VSS g45n1svt M=1 L=45n W=145n
Mmn53 n35 CKb n40 VSS g45n1svt M=1 L=45n W=205n
Mmp26 n20 CKbb n22 VDD g45p1svt M=1 L=45n W=310n
Mmp25 n22 D VDD VDD g45p1svt M=1 L=45n W=310n
Mmp52 n43 qbint n41 VDD g45p1svt M=1 L=45n W=310n
Mmp51 n43 RNb VDD VDD g45p1svt M=1 L=45n W=310n
Mmp55 Q qbint VDD VDD g45p1svt M=1 L=45n W=3.115u
Mmp36 n20 CKb n31 VDD g45p1svt M=1 L=45n W=310n
Mmp35 n31 mout VDD VDD g45p1svt M=1 L=45n W=310n
Mmp32 mout n20 n26 VDD g45p1svt M=1 L=45n W=310n
Mmp31 n26 RNb VDD VDD g45p1svt M=1 L=45n W=310n
Mmp22 RNb RN VDD VDD g45p1svt M=1 L=45n W=215n
Mmp20 CKb CK VDD VDD g45p1svt M=1 L=45n W=215n
Mmp53 n35 CKbb n41 VDD g45p1svt M=1 L=45n W=310n
Mmp50 n41 SN VDD VDD g45p1svt M=1 L=45n W=310n
Mmp45 qbint n35 VDD VDD g45p1svt M=1 L=45n W=1.17u
Mmp21 CKbb CKb VDD VDD g45p1svt M=1 L=45n W=215n
Mmp30 mout SN VDD VDD g45p1svt M=1 L=45n W=310n
Mmp40 n35 CKb mout VDD g45p1svt M=1 L=45n W=310n
.ENDS

.SUBCKT DFFSRHQX4 CK D Q RN SN VDD VSS
Mmn26 n20 CKb n21 VSS g45n1svt M=1 L=45n W=205n
Mmn25 n21 D VSS VSS g45n1svt M=1 L=45n W=205n
Mmn55 Q qbint VSS VSS g45n1svt M=1 L=45n W=1.04u
Mmn35 n30 mout VSS VSS g45n1svt M=1 L=45n W=205n
Mmn36 n20 CKbb n30 VSS g45n1svt M=1 L=45n W=205n
Mmn22 RNb RN VSS VSS g45n1svt M=1 L=45n W=145n
Mmn20 CKb CK VSS VSS g45n1svt M=1 L=45n W=145n
Mmn45 qbint n35 VSS VSS g45n1svt M=1 L=45n W=410n
Mmn52 n40 qbint n42 VSS g45n1svt M=1 L=45n W=205n
Mmn51 n40 RNb n42 VSS g45n1svt M=1 L=45n W=205n
Mmn32 mout n20 n25 VSS g45n1svt M=1 L=45n W=205n
Mmn50 n42 SN VSS VSS g45n1svt M=1 L=45n W=205n
Mmn30 n25 SN VSS VSS g45n1svt M=1 L=45n W=205n
Mmn40 n35 CKbb mout VSS g45n1svt M=1 L=45n W=205n
Mmn31 mout RNb n25 VSS g45n1svt M=1 L=45n W=205n
Mmn21 CKbb CKb VSS VSS g45n1svt M=1 L=45n W=145n
Mmn53 n35 CKb n40 VSS g45n1svt M=1 L=45n W=205n
Mmp26 n20 CKbb n22 VDD g45p1svt M=1 L=45n W=310n
Mmp25 n22 D VDD VDD g45p1svt M=1 L=45n W=310n
Mmp52 n43 qbint n41 VDD g45p1svt M=1 L=45n W=310n
Mmp51 n43 RNb VDD VDD g45p1svt M=1 L=45n W=310n
Mmp55 Q qbint VDD VDD g45p1svt M=1 L=45n W=1.56u
Mmp36 n20 CKb n31 VDD g45p1svt M=1 L=45n W=310n
Mmp35 n31 mout VDD VDD g45p1svt M=1 L=45n W=310n
Mmp32 mout n20 n26 VDD g45p1svt M=1 L=45n W=310n
Mmp31 n26 RNb VDD VDD g45p1svt M=1 L=45n W=310n
Mmp22 RNb RN VDD VDD g45p1svt M=1 L=45n W=215n
Mmp20 CKb CK VDD VDD g45p1svt M=1 L=45n W=215n
Mmp53 n35 CKbb n41 VDD g45p1svt M=1 L=45n W=310n
Mmp50 n41 SN VDD VDD g45p1svt M=1 L=45n W=310n
Mmp45 qbint n35 VDD VDD g45p1svt M=1 L=45n W=620n
Mmp21 CKbb CKb VDD VDD g45p1svt M=1 L=45n W=215n
Mmp30 mout SN VDD VDD g45p1svt M=1 L=45n W=310n
Mmp40 n35 CKb mout VDD g45p1svt M=1 L=45n W=310n
.ENDS

.SUBCKT DFFSRHQX2 CK D Q RN SN VDD VSS
Mmn26 n20 CKb n21 VSS g45n1svt M=1 L=45n W=205n
Mmn25 n21 D VSS VSS g45n1svt M=1 L=45n W=205n
Mmn55 Q qbint VSS VSS g45n1svt M=1 L=45n W=520n
Mmn35 n30 mout VSS VSS g45n1svt M=1 L=45n W=205n
Mmn36 n20 CKbb n30 VSS g45n1svt M=1 L=45n W=205n
Mmn22 RNb RN VSS VSS g45n1svt M=1 L=45n W=145n
Mmn20 CKb CK VSS VSS g45n1svt M=1 L=45n W=145n
Mmn45 qbint n35 VSS VSS g45n1svt M=1 L=45n W=205n
Mmn52 n40 qbint n42 VSS g45n1svt M=1 L=45n W=205n
Mmn51 n40 RNb n42 VSS g45n1svt M=1 L=45n W=205n
Mmn32 mout n20 n25 VSS g45n1svt M=1 L=45n W=205n
Mmn50 n42 SN VSS VSS g45n1svt M=1 L=45n W=205n
Mmn30 n25 SN VSS VSS g45n1svt M=1 L=45n W=205n
Mmn40 n35 CKbb mout VSS g45n1svt M=1 L=45n W=205n
Mmn31 mout RNb n25 VSS g45n1svt M=1 L=45n W=205n
Mmn21 CKbb CKb VSS VSS g45n1svt M=1 L=45n W=145n
Mmn53 n35 CKb n40 VSS g45n1svt M=1 L=45n W=205n
Mmp26 n20 CKbb n22 VDD g45p1svt M=1 L=45n W=310n
Mmp25 n22 D VDD VDD g45p1svt M=1 L=45n W=310n
Mmp52 n43 qbint n41 VDD g45p1svt M=1 L=45n W=310n
Mmp51 n43 RNb VDD VDD g45p1svt M=1 L=45n W=310n
Mmp55 Q qbint VDD VDD g45p1svt M=1 L=45n W=780n
Mmp36 n20 CKb n31 VDD g45p1svt M=1 L=45n W=310n
Mmp35 n31 mout VDD VDD g45p1svt M=1 L=45n W=310n
Mmp32 mout n20 n26 VDD g45p1svt M=1 L=45n W=310n
Mmp31 n26 RNb VDD VDD g45p1svt M=1 L=45n W=310n
Mmp22 RNb RN VDD VDD g45p1svt M=1 L=45n W=215n
Mmp20 CKb CK VDD VDD g45p1svt M=1 L=45n W=215n
Mmp53 n35 CKbb n41 VDD g45p1svt M=1 L=45n W=310n
Mmp50 n41 SN VDD VDD g45p1svt M=1 L=45n W=310n
Mmp45 qbint n35 VDD VDD g45p1svt M=1 L=45n W=310n
Mmp21 CKbb CKb VDD VDD g45p1svt M=1 L=45n W=215n
Mmp30 mout SN VDD VDD g45p1svt M=1 L=45n W=310n
Mmp40 n35 CKb mout VDD g45p1svt M=1 L=45n W=310n
.ENDS

.SUBCKT DFFSRHQX1 CK D Q RN SN VDD VSS
Mmn26 n20 CKb n21 VSS g45n1svt M=1 L=45n W=205n
Mmn25 n21 D VSS VSS g45n1svt M=1 L=45n W=205n
Mmn55 Q qbint VSS VSS g45n1svt M=1 L=45n W=260n
Mmn35 n30 mout VSS VSS g45n1svt M=1 L=45n W=205n
Mmn36 n20 CKbb n30 VSS g45n1svt M=1 L=45n W=205n
Mmn22 RNb RN VSS VSS g45n1svt M=1 L=45n W=145n
Mmn20 CKb CK VSS VSS g45n1svt M=1 L=45n W=145n
Mmn45 qbint n35 VSS VSS g45n1svt M=1 L=45n W=205n
Mmn52 n40 qbint n42 VSS g45n1svt M=1 L=45n W=205n
Mmn51 n40 RNb n42 VSS g45n1svt M=1 L=45n W=205n
Mmn32 mout n20 n25 VSS g45n1svt M=1 L=45n W=205n
Mmn50 n42 SN VSS VSS g45n1svt M=1 L=45n W=205n
Mmn30 n25 SN VSS VSS g45n1svt M=1 L=45n W=205n
Mmn40 n35 CKbb mout VSS g45n1svt M=1 L=45n W=205n
Mmn31 mout RNb n25 VSS g45n1svt M=1 L=45n W=205n
Mmn21 CKbb CKb VSS VSS g45n1svt M=1 L=45n W=145n
Mmn53 n35 CKb n40 VSS g45n1svt M=1 L=45n W=205n
Mmp26 n20 CKbb n22 VDD g45p1svt M=1 L=45n W=310n
Mmp25 n22 D VDD VDD g45p1svt M=1 L=45n W=310n
Mmp52 n43 qbint n41 VDD g45p1svt M=1 L=45n W=310n
Mmp51 n43 RNb VDD VDD g45p1svt M=1 L=45n W=310n
Mmp55 Q qbint VDD VDD g45p1svt M=1 L=45n W=390n
Mmp36 n20 CKb n31 VDD g45p1svt M=1 L=45n W=310n
Mmp35 n31 mout VDD VDD g45p1svt M=1 L=45n W=310n
Mmp32 mout n20 n26 VDD g45p1svt M=1 L=45n W=310n
Mmp31 n26 RNb VDD VDD g45p1svt M=1 L=45n W=310n
Mmp22 RNb RN VDD VDD g45p1svt M=1 L=45n W=215n
Mmp20 CKb CK VDD VDD g45p1svt M=1 L=45n W=215n
Mmp53 n35 CKbb n41 VDD g45p1svt M=1 L=45n W=310n
Mmp50 n41 SN VDD VDD g45p1svt M=1 L=45n W=310n
Mmp45 qbint n35 VDD VDD g45p1svt M=1 L=45n W=310n
Mmp21 CKbb CKb VDD VDD g45p1svt M=1 L=45n W=215n
Mmp30 mout SN VDD VDD g45p1svt M=1 L=45n W=310n
Mmp40 n35 CKb mout VDD g45p1svt M=1 L=45n W=310n
.ENDS

.SUBCKT DFFSHQX8 CK D Q SN VDD VSS
Mmn51 n40 qbint n42 VSS g45n1svt M=1 L=45n W=205n
Mmn52 n35 CKb n40 VSS g45n1svt M=1 L=45n W=205n
Mmn50 n42 SN VSS VSS g45n1svt M=1 L=45n W=205n
Mmn26 n20 CKb n21 VSS g45n1svt M=1 L=45n W=205n
Mmn25 n21 D VSS VSS g45n1svt M=1 L=45n W=205n
Mmn55 Q qbint VSS VSS g45n1svt M=1 L=45n W=2.065u
Mmn30 n25 SN VSS VSS g45n1svt M=1 L=45n W=205n
Mmn31 mout n20 n25 VSS g45n1svt M=1 L=45n W=205n
Mmn35 n20 CKbb n30 VSS g45n1svt M=1 L=45n W=205n
Mmn36 n30 mout VSS VSS g45n1svt M=1 L=45n W=205n
Mmn20 CKb CK VSS VSS g45n1svt M=1 L=45n W=145n
Mmn40 n35 CKbb mout VSS g45n1svt M=1 L=45n W=205n
Mmn45 qbint n35 VSS VSS g45n1svt M=1 L=45n W=780n
Mmn21 CKbb CKb VSS VSS g45n1svt M=1 L=45n W=145n
Mmp26 n20 CKbb n22 VDD g45p1svt M=1 L=45n W=310n
Mmp25 n22 D VDD VDD g45p1svt M=1 L=45n W=310n
Mmp55 Q qbint VDD VDD g45p1svt M=1 L=45n W=3.115u
Mmp36 n20 CKb n31 VDD g45p1svt M=1 L=45n W=310n
Mmp35 n31 mout VDD VDD g45p1svt M=1 L=45n W=310n
Mmp20 CKb CK VDD VDD g45p1svt M=1 L=45n W=215n
Mmp52 n35 CKbb n41 VDD g45p1svt M=1 L=45n W=310n
Mmp31 mout n20 VDD VDD g45p1svt M=1 L=45n W=310n
Mmp21 CKbb CKb VDD VDD g45p1svt M=1 L=45n W=215n
Mmp50 n41 SN VDD VDD g45p1svt M=1 L=45n W=310n
Mmp30 mout SN VDD VDD g45p1svt M=1 L=45n W=310n
Mmp45 qbint n35 VDD VDD g45p1svt M=1 L=45n W=1.17u
Mmp51 n41 qbint VDD VDD g45p1svt M=1 L=45n W=310n
Mmp40 n35 CKb mout VDD g45p1svt M=1 L=45n W=310n
.ENDS

.SUBCKT DFFSHQX4 CK D Q SN VDD VSS
Mmn51 n40 qbint n42 VSS g45n1svt M=1 L=45n W=205n
Mmn52 n35 CKb n40 VSS g45n1svt M=1 L=45n W=205n
Mmn50 n42 SN VSS VSS g45n1svt M=1 L=45n W=205n
Mmn26 n20 CKb n21 VSS g45n1svt M=1 L=45n W=205n
Mmn25 n21 D VSS VSS g45n1svt M=1 L=45n W=205n
Mmn55 Q qbint VSS VSS g45n1svt M=1 L=45n W=1.04u
Mmn30 n25 SN VSS VSS g45n1svt M=1 L=45n W=205n
Mmn31 mout n20 n25 VSS g45n1svt M=1 L=45n W=205n
Mmn35 n20 CKbb n30 VSS g45n1svt M=1 L=45n W=205n
Mmn36 n30 mout VSS VSS g45n1svt M=1 L=45n W=205n
Mmn20 CKb CK VSS VSS g45n1svt M=1 L=45n W=145n
Mmn40 n35 CKbb mout VSS g45n1svt M=1 L=45n W=205n
Mmn45 qbint n35 VSS VSS g45n1svt M=1 L=45n W=410n
Mmn21 CKbb CKb VSS VSS g45n1svt M=1 L=45n W=145n
Mmp26 n20 CKbb n22 VDD g45p1svt M=1 L=45n W=310n
Mmp25 n22 D VDD VDD g45p1svt M=1 L=45n W=310n
Mmp55 Q qbint VDD VDD g45p1svt M=1 L=45n W=1.56u
Mmp36 n20 CKb n31 VDD g45p1svt M=1 L=45n W=310n
Mmp35 n31 mout VDD VDD g45p1svt M=1 L=45n W=310n
Mmp20 CKb CK VDD VDD g45p1svt M=1 L=45n W=215n
Mmp52 n35 CKbb n41 VDD g45p1svt M=1 L=45n W=310n
Mmp31 mout n20 VDD VDD g45p1svt M=1 L=45n W=310n
Mmp21 CKbb CKb VDD VDD g45p1svt M=1 L=45n W=215n
Mmp50 n41 SN VDD VDD g45p1svt M=1 L=45n W=310n
Mmp30 mout SN VDD VDD g45p1svt M=1 L=45n W=310n
Mmp45 qbint n35 VDD VDD g45p1svt M=1 L=45n W=620n
Mmp51 n41 qbint VDD VDD g45p1svt M=1 L=45n W=310n
Mmp40 n35 CKb mout VDD g45p1svt M=1 L=45n W=310n
.ENDS

.SUBCKT DFFSHQX2 CK D Q SN VDD VSS
Mmn51 n40 qbint n42 VSS g45n1svt M=1 L=45n W=205n
Mmn52 n35 CKb n40 VSS g45n1svt M=1 L=45n W=205n
Mmn50 n42 SN VSS VSS g45n1svt M=1 L=45n W=205n
Mmn26 n20 CKb n21 VSS g45n1svt M=1 L=45n W=205n
Mmn25 n21 D VSS VSS g45n1svt M=1 L=45n W=205n
Mmn55 Q qbint VSS VSS g45n1svt M=1 L=45n W=520n
Mmn30 n25 SN VSS VSS g45n1svt M=1 L=45n W=205n
Mmn31 mout n20 n25 VSS g45n1svt M=1 L=45n W=205n
Mmn35 n20 CKbb n30 VSS g45n1svt M=1 L=45n W=205n
Mmn36 n30 mout VSS VSS g45n1svt M=1 L=45n W=205n
Mmn20 CKb CK VSS VSS g45n1svt M=1 L=45n W=145n
Mmn40 n35 CKbb mout VSS g45n1svt M=1 L=45n W=205n
Mmn45 qbint n35 VSS VSS g45n1svt M=1 L=45n W=205n
Mmn21 CKbb CKb VSS VSS g45n1svt M=1 L=45n W=145n
Mmp26 n20 CKbb n22 VDD g45p1svt M=1 L=45n W=310n
Mmp25 n22 D VDD VDD g45p1svt M=1 L=45n W=310n
Mmp55 Q qbint VDD VDD g45p1svt M=1 L=45n W=780n
Mmp36 n20 CKb n31 VDD g45p1svt M=1 L=45n W=310n
Mmp35 n31 mout VDD VDD g45p1svt M=1 L=45n W=310n
Mmp20 CKb CK VDD VDD g45p1svt M=1 L=45n W=215n
Mmp52 n35 CKbb n41 VDD g45p1svt M=1 L=45n W=310n
Mmp31 mout n20 VDD VDD g45p1svt M=1 L=45n W=310n
Mmp21 CKbb CKb VDD VDD g45p1svt M=1 L=45n W=215n
Mmp50 n41 SN VDD VDD g45p1svt M=1 L=45n W=310n
Mmp30 mout SN VDD VDD g45p1svt M=1 L=45n W=310n
Mmp45 qbint n35 VDD VDD g45p1svt M=1 L=45n W=310n
Mmp51 n41 qbint VDD VDD g45p1svt M=1 L=45n W=310n
Mmp40 n35 CKb mout VDD g45p1svt M=1 L=45n W=310n
.ENDS

.SUBCKT DFFSHQX1 CK D Q SN VDD VSS
Mmn51 n40 qbint n42 VSS g45n1svt M=1 L=45n W=205n
Mmn52 n35 CKb n40 VSS g45n1svt M=1 L=45n W=205n
Mmn50 n42 SN VSS VSS g45n1svt M=1 L=45n W=205n
Mmn26 n20 CKb n21 VSS g45n1svt M=1 L=45n W=205n
Mmn25 n21 D VSS VSS g45n1svt M=1 L=45n W=205n
Mmn55 Q qbint VSS VSS g45n1svt M=1 L=45n W=260n
Mmn30 n25 SN VSS VSS g45n1svt M=1 L=45n W=205n
Mmn31 mout n20 n25 VSS g45n1svt M=1 L=45n W=205n
Mmn35 n20 CKbb n30 VSS g45n1svt M=1 L=45n W=205n
Mmn36 n30 mout VSS VSS g45n1svt M=1 L=45n W=205n
Mmn20 CKb CK VSS VSS g45n1svt M=1 L=45n W=145n
Mmn40 n35 CKbb mout VSS g45n1svt M=1 L=45n W=205n
Mmn45 qbint n35 VSS VSS g45n1svt M=1 L=45n W=205n
Mmn21 CKbb CKb VSS VSS g45n1svt M=1 L=45n W=145n
Mmp26 n20 CKbb n22 VDD g45p1svt M=1 L=45n W=310n
Mmp25 n22 D VDD VDD g45p1svt M=1 L=45n W=310n
Mmp55 Q qbint VDD VDD g45p1svt M=1 L=45n W=390n
Mmp36 n20 CKb n31 VDD g45p1svt M=1 L=45n W=310n
Mmp35 n31 mout VDD VDD g45p1svt M=1 L=45n W=310n
Mmp20 CKb CK VDD VDD g45p1svt M=1 L=45n W=215n
Mmp52 n35 CKbb n41 VDD g45p1svt M=1 L=45n W=310n
Mmp31 mout n20 VDD VDD g45p1svt M=1 L=45n W=310n
Mmp21 CKbb CKb VDD VDD g45p1svt M=1 L=45n W=215n
Mmp50 n41 SN VDD VDD g45p1svt M=1 L=45n W=310n
Mmp30 mout SN VDD VDD g45p1svt M=1 L=45n W=310n
Mmp45 qbint n35 VDD VDD g45p1svt M=1 L=45n W=310n
Mmp51 n41 qbint VDD VDD g45p1svt M=1 L=45n W=310n
Mmp40 n35 CKb mout VDD g45p1svt M=1 L=45n W=310n
.ENDS

.SUBCKT DFFRXL CK D Q QN RN VDD VSS
Mmn36 n25 mout n27 VSS g45n1svt M=1 L=45n W=145n
Mmn35 n27 RN VSS VSS g45n1svt M=1 L=45n W=145n
Mmn37 n20 CKbb n25 VSS g45n1svt M=1 L=45n W=145n
Mmn26 n20 CKb n21 VSS g45n1svt M=1 L=45n W=145n
Mmn25 n21 D VSS VSS g45n1svt M=1 L=45n W=145n
Mmn57 QN qint VSS VSS g45n1svt M=1 L=45n W=145n
Mmn55 Q qbint VSS VSS g45n1svt M=1 L=45n W=145n
Mmn45 n35 RN VSS VSS g45n1svt M=1 L=45n W=145n
Mmn46 qbint n30 n35 VSS g45n1svt M=1 L=45n W=145n
Mmn51 n30 CKb n40 VSS g45n1svt M=1 L=45n W=145n
Mmn50 n40 qbint VSS VSS g45n1svt M=1 L=45n W=145n
Mmn21 CKbb CKb VSS VSS g45n1svt M=1 L=45n W=145n
Mmn40 n30 CKbb mout VSS g45n1svt M=1 L=45n W=145n
Mmn30 mout n20 VSS VSS g45n1svt M=1 L=45n W=145n
Mmn56 qint qbint VSS VSS g45n1svt M=1 L=45n W=145n
Mmn20 CKb CK VSS VSS g45n1svt M=1 L=45n W=145n
Mmp26 n20 CKbb n22 VDD g45p1svt M=1 L=45n W=215n
Mmp25 n22 D VDD VDD g45p1svt M=1 L=45n W=215n
Mmp51 n30 CKbb n41 VDD g45p1svt M=1 L=45n W=215n
Mmp50 n41 qbint VDD VDD g45p1svt M=1 L=45n W=215n
Mmp57 QN qint VDD VDD g45p1svt M=1 L=45n W=215n
Mmp55 Q qbint VDD VDD g45p1svt M=1 L=45n W=215n
Mmp20 CKb CK VDD VDD g45p1svt M=1 L=45n W=215n
Mmp21 CKbb CKb VDD VDD g45p1svt M=1 L=45n W=215n
Mmp36 n26 mout VDD VDD g45p1svt M=1 L=45n W=215n
Mmp30 mout n20 VDD VDD g45p1svt M=1 L=45n W=215n
Mmp35 n26 RN VDD VDD g45p1svt M=1 L=45n W=215n
Mmp37 n20 CKb n26 VDD g45p1svt M=1 L=45n W=215n
Mmp46 qbint n30 VDD VDD g45p1svt M=1 L=45n W=215n
Mmp40 n30 CKb mout VDD g45p1svt M=1 L=45n W=215n
Mmp45 qbint RN VDD VDD g45p1svt M=1 L=45n W=215n
Mmp56 qint qbint VDD VDD g45p1svt M=1 L=45n W=215n
.ENDS

.SUBCKT DFFRX4 CK D Q QN RN VDD VSS
Mmn36 n25 mout n27 VSS g45n1svt M=1 L=45n W=145n
Mmn35 n27 RN VSS VSS g45n1svt M=1 L=45n W=145n
Mmn37 n20 CKbb n25 VSS g45n1svt M=1 L=45n W=145n
Mmn26 n20 CKb n21 VSS g45n1svt M=1 L=45n W=145n
Mmn25 n21 D VSS VSS g45n1svt M=1 L=45n W=145n
Mmn57 QN qint VSS VSS g45n1svt M=1 L=45n W=1.04u
Mmn55 Q qbint VSS VSS g45n1svt M=1 L=45n W=1.04u
Mmn45 n35 RN VSS VSS g45n1svt M=1 L=45n W=410n
Mmn46 qbint n30 n35 VSS g45n1svt M=1 L=45n W=410n
Mmn51 n30 CKb n40 VSS g45n1svt M=1 L=45n W=145n
Mmn50 n40 qbint VSS VSS g45n1svt M=1 L=45n W=145n
Mmn21 CKbb CKb VSS VSS g45n1svt M=1 L=45n W=145n
Mmn40 n30 CKbb mout VSS g45n1svt M=1 L=45n W=145n
Mmn30 mout n20 VSS VSS g45n1svt M=1 L=45n W=145n
Mmn56 qint qbint VSS VSS g45n1svt M=1 L=45n W=260n
Mmn20 CKb CK VSS VSS g45n1svt M=1 L=45n W=145n
Mmp26 n20 CKbb n22 VDD g45p1svt M=1 L=45n W=215n
Mmp25 n22 D VDD VDD g45p1svt M=1 L=45n W=215n
Mmp51 n30 CKbb n41 VDD g45p1svt M=1 L=45n W=215n
Mmp50 n41 qbint VDD VDD g45p1svt M=1 L=45n W=215n
Mmp57 QN qint VDD VDD g45p1svt M=1 L=45n W=1.56u
Mmp55 Q qbint VDD VDD g45p1svt M=1 L=45n W=1.56u
Mmp20 CKb CK VDD VDD g45p1svt M=1 L=45n W=215n
Mmp21 CKbb CKb VDD VDD g45p1svt M=1 L=45n W=215n
Mmp36 n26 mout VDD VDD g45p1svt M=1 L=45n W=215n
Mmp30 mout n20 VDD VDD g45p1svt M=1 L=45n W=215n
Mmp35 n26 RN VDD VDD g45p1svt M=1 L=45n W=215n
Mmp37 n20 CKb n26 VDD g45p1svt M=1 L=45n W=215n
Mmp46 qbint n30 VDD VDD g45p1svt M=1 L=45n W=620n
Mmp40 n30 CKb mout VDD g45p1svt M=1 L=45n W=215n
Mmp45 qbint RN VDD VDD g45p1svt M=1 L=45n W=620n
Mmp56 qint qbint VDD VDD g45p1svt M=1 L=45n W=390n
.ENDS

.SUBCKT DFFRX2 CK D Q QN RN VDD VSS
Mmn36 n25 mout n27 VSS g45n1svt M=1 L=45n W=145n
Mmn35 n27 RN VSS VSS g45n1svt M=1 L=45n W=145n
Mmn37 n20 CKbb n25 VSS g45n1svt M=1 L=45n W=145n
Mmn26 n20 CKb n21 VSS g45n1svt M=1 L=45n W=145n
Mmn25 n21 D VSS VSS g45n1svt M=1 L=45n W=145n
Mmn57 QN qint VSS VSS g45n1svt M=1 L=45n W=520n
Mmn55 Q qbint VSS VSS g45n1svt M=1 L=45n W=520n
Mmn45 n35 RN VSS VSS g45n1svt M=1 L=45n W=205n
Mmn46 qbint n30 n35 VSS g45n1svt M=1 L=45n W=205n
Mmn51 n30 CKb n40 VSS g45n1svt M=1 L=45n W=145n
Mmn50 n40 qbint VSS VSS g45n1svt M=1 L=45n W=145n
Mmn21 CKbb CKb VSS VSS g45n1svt M=1 L=45n W=145n
Mmn40 n30 CKbb mout VSS g45n1svt M=1 L=45n W=145n
Mmn30 mout n20 VSS VSS g45n1svt M=1 L=45n W=145n
Mmn56 qint qbint VSS VSS g45n1svt M=1 L=45n W=145n
Mmn20 CKb CK VSS VSS g45n1svt M=1 L=45n W=145n
Mmp26 n20 CKbb n22 VDD g45p1svt M=1 L=45n W=215n
Mmp25 n22 D VDD VDD g45p1svt M=1 L=45n W=215n
Mmp51 n30 CKbb n41 VDD g45p1svt M=1 L=45n W=215n
Mmp50 n41 qbint VDD VDD g45p1svt M=1 L=45n W=215n
Mmp57 QN qint VDD VDD g45p1svt M=1 L=45n W=780n
Mmp55 Q qbint VDD VDD g45p1svt M=1 L=45n W=780n
Mmp20 CKb CK VDD VDD g45p1svt M=1 L=45n W=215n
Mmp21 CKbb CKb VDD VDD g45p1svt M=1 L=45n W=215n
Mmp36 n26 mout VDD VDD g45p1svt M=1 L=45n W=215n
Mmp30 mout n20 VDD VDD g45p1svt M=1 L=45n W=215n
Mmp35 n26 RN VDD VDD g45p1svt M=1 L=45n W=215n
Mmp37 n20 CKb n26 VDD g45p1svt M=1 L=45n W=215n
Mmp46 qbint n30 VDD VDD g45p1svt M=1 L=45n W=310n
Mmp40 n30 CKb mout VDD g45p1svt M=1 L=45n W=215n
Mmp45 qbint RN VDD VDD g45p1svt M=1 L=45n W=310n
Mmp56 qint qbint VDD VDD g45p1svt M=1 L=45n W=215n
.ENDS

.SUBCKT DFFRX1 CK D Q QN RN VDD VSS
Mmn36 n25 mout n27 VSS g45n1svt M=1 L=45n W=145n
Mmn35 n27 RN VSS VSS g45n1svt M=1 L=45n W=145n
Mmn37 n20 CKbb n25 VSS g45n1svt M=1 L=45n W=145n
Mmn26 n20 CKb n21 VSS g45n1svt M=1 L=45n W=145n
Mmn25 n21 D VSS VSS g45n1svt M=1 L=45n W=145n
Mmn57 QN qint VSS VSS g45n1svt M=1 L=45n W=260n
Mmn55 Q qbint VSS VSS g45n1svt M=1 L=45n W=260n
Mmn45 n35 RN VSS VSS g45n1svt M=1 L=45n W=145n
Mmn46 qbint n30 n35 VSS g45n1svt M=1 L=45n W=145n
Mmn51 n30 CKb n40 VSS g45n1svt M=1 L=45n W=145n
Mmn50 n40 qbint VSS VSS g45n1svt M=1 L=45n W=145n
Mmn21 CKbb CKb VSS VSS g45n1svt M=1 L=45n W=145n
Mmn40 n30 CKbb mout VSS g45n1svt M=1 L=45n W=145n
Mmn30 mout n20 VSS VSS g45n1svt M=1 L=45n W=145n
Mmn56 qint qbint VSS VSS g45n1svt M=1 L=45n W=145n
Mmn20 CKb CK VSS VSS g45n1svt M=1 L=45n W=145n
Mmp26 n20 CKbb n22 VDD g45p1svt M=1 L=45n W=215n
Mmp25 n22 D VDD VDD g45p1svt M=1 L=45n W=215n
Mmp51 n30 CKbb n41 VDD g45p1svt M=1 L=45n W=215n
Mmp50 n41 qbint VDD VDD g45p1svt M=1 L=45n W=215n
Mmp57 QN qint VDD VDD g45p1svt M=1 L=45n W=390n
Mmp55 Q qbint VDD VDD g45p1svt M=1 L=45n W=390n
Mmp20 CKb CK VDD VDD g45p1svt M=1 L=45n W=215n
Mmp21 CKbb CKb VDD VDD g45p1svt M=1 L=45n W=215n
Mmp36 n26 mout VDD VDD g45p1svt M=1 L=45n W=215n
Mmp30 mout n20 VDD VDD g45p1svt M=1 L=45n W=215n
Mmp35 n26 RN VDD VDD g45p1svt M=1 L=45n W=215n
Mmp37 n20 CKb n26 VDD g45p1svt M=1 L=45n W=215n
Mmp46 qbint n30 VDD VDD g45p1svt M=1 L=45n W=215n
Mmp40 n30 CKb mout VDD g45p1svt M=1 L=45n W=215n
Mmp45 qbint RN VDD VDD g45p1svt M=1 L=45n W=215n
Mmp56 qint qbint VDD VDD g45p1svt M=1 L=45n W=215n
.ENDS

.SUBCKT DFFRHQX8 CK D Q RN VDD VSS
Mmn36 n25 mout n27 VSS g45n1svt M=1 L=45n W=205n
Mmn35 n27 RN VSS VSS g45n1svt M=1 L=45n W=205n
Mmn37 n20 CKbb n25 VSS g45n1svt M=1 L=45n W=205n
Mmn26 n20 CKb n21 VSS g45n1svt M=1 L=45n W=205n
Mmn25 n21 D VSS VSS g45n1svt M=1 L=45n W=205n
Mmn55 Q qbint VSS VSS g45n1svt M=1 L=45n W=2.065u
Mmn45 n35 RN VSS VSS g45n1svt M=1 L=45n W=780n
Mmn46 qbint n30 n35 VSS g45n1svt M=1 L=45n W=780n
Mmn51 n30 CKb n40 VSS g45n1svt M=1 L=45n W=205n
Mmn50 n40 qbint VSS VSS g45n1svt M=1 L=45n W=205n
Mmn20 CKb CK VSS VSS g45n1svt M=1 L=45n W=145n
Mmn21 CKbb CKb VSS VSS g45n1svt M=1 L=45n W=145n
Mmn40 n30 CKbb mout VSS g45n1svt M=1 L=45n W=205n
Mmn30 mout n20 VSS VSS g45n1svt M=1 L=45n W=205n
Mmp26 n20 CKbb n22 VDD g45p1svt M=1 L=45n W=310n
Mmp25 n22 D VDD VDD g45p1svt M=1 L=45n W=310n
Mmp51 n30 CKbb n41 VDD g45p1svt M=1 L=45n W=310n
Mmp50 n41 qbint VDD VDD g45p1svt M=1 L=45n W=310n
Mmp55 Q qbint VDD VDD g45p1svt M=1 L=45n W=3.115u
Mmp20 CKb CK VDD VDD g45p1svt M=1 L=45n W=215n
Mmp46 qbint n30 VDD VDD g45p1svt M=1 L=45n W=1.17u
Mmp45 qbint RN VDD VDD g45p1svt M=1 L=45n W=1.17u
Mmp35 n26 RN VDD VDD g45p1svt M=1 L=45n W=310n
Mmp36 n26 mout VDD VDD g45p1svt M=1 L=45n W=310n
Mmp37 n20 CKb n26 VDD g45p1svt M=1 L=45n W=310n
Mmp40 n30 CKb mout VDD g45p1svt M=1 L=45n W=310n
Mmp30 mout n20 VDD VDD g45p1svt M=1 L=45n W=310n
Mmp21 CKbb CKb VDD VDD g45p1svt M=1 L=45n W=215n
.ENDS

.SUBCKT DFFRHQX4 CK D Q RN VDD VSS
Mmn36 n25 mout n27 VSS g45n1svt M=1 L=45n W=205n
Mmn35 n27 RN VSS VSS g45n1svt M=1 L=45n W=205n
Mmn37 n20 CKbb n25 VSS g45n1svt M=1 L=45n W=205n
Mmn26 n20 CKb n21 VSS g45n1svt M=1 L=45n W=205n
Mmn25 n21 D VSS VSS g45n1svt M=1 L=45n W=205n
Mmn55 Q qbint VSS VSS g45n1svt M=1 L=45n W=1.04u
Mmn45 n35 RN VSS VSS g45n1svt M=1 L=45n W=410n
Mmn46 qbint n30 n35 VSS g45n1svt M=1 L=45n W=410n
Mmn51 n30 CKb n40 VSS g45n1svt M=1 L=45n W=205n
Mmn50 n40 qbint VSS VSS g45n1svt M=1 L=45n W=205n
Mmn20 CKb CK VSS VSS g45n1svt M=1 L=45n W=145n
Mmn21 CKbb CKb VSS VSS g45n1svt M=1 L=45n W=145n
Mmn40 n30 CKbb mout VSS g45n1svt M=1 L=45n W=205n
Mmn30 mout n20 VSS VSS g45n1svt M=1 L=45n W=205n
Mmp26 n20 CKbb n22 VDD g45p1svt M=1 L=45n W=310n
Mmp25 n22 D VDD VDD g45p1svt M=1 L=45n W=310n
Mmp51 n30 CKbb n41 VDD g45p1svt M=1 L=45n W=310n
Mmp50 n41 qbint VDD VDD g45p1svt M=1 L=45n W=310n
Mmp55 Q qbint VDD VDD g45p1svt M=1 L=45n W=1.56u
Mmp20 CKb CK VDD VDD g45p1svt M=1 L=45n W=215n
Mmp46 qbint n30 VDD VDD g45p1svt M=1 L=45n W=620n
Mmp45 qbint RN VDD VDD g45p1svt M=1 L=45n W=620n
Mmp35 n26 RN VDD VDD g45p1svt M=1 L=45n W=310n
Mmp36 n26 mout VDD VDD g45p1svt M=1 L=45n W=310n
Mmp37 n20 CKb n26 VDD g45p1svt M=1 L=45n W=310n
Mmp40 n30 CKb mout VDD g45p1svt M=1 L=45n W=310n
Mmp30 mout n20 VDD VDD g45p1svt M=1 L=45n W=310n
Mmp21 CKbb CKb VDD VDD g45p1svt M=1 L=45n W=215n
.ENDS

.SUBCKT DFFRHQX2 CK D Q RN VDD VSS
Mmn36 n25 mout n27 VSS g45n1svt M=1 L=45n W=205n
Mmn35 n27 RN VSS VSS g45n1svt M=1 L=45n W=205n
Mmn37 n20 CKbb n25 VSS g45n1svt M=1 L=45n W=205n
Mmn26 n20 CKb n21 VSS g45n1svt M=1 L=45n W=205n
Mmn25 n21 D VSS VSS g45n1svt M=1 L=45n W=205n
Mmn55 Q qbint VSS VSS g45n1svt M=1 L=45n W=520n
Mmn45 n35 RN VSS VSS g45n1svt M=1 L=45n W=205n
Mmn46 qbint n30 n35 VSS g45n1svt M=1 L=45n W=205n
Mmn51 n30 CKb n40 VSS g45n1svt M=1 L=45n W=205n
Mmn50 n40 qbint VSS VSS g45n1svt M=1 L=45n W=205n
Mmn20 CKb CK VSS VSS g45n1svt M=1 L=45n W=145n
Mmn21 CKbb CKb VSS VSS g45n1svt M=1 L=45n W=145n
Mmn40 n30 CKbb mout VSS g45n1svt M=1 L=45n W=205n
Mmn30 mout n20 VSS VSS g45n1svt M=1 L=45n W=205n
Mmp26 n20 CKbb n22 VDD g45p1svt M=1 L=45n W=310n
Mmp25 n22 D VDD VDD g45p1svt M=1 L=45n W=310n
Mmp51 n30 CKbb n41 VDD g45p1svt M=1 L=45n W=310n
Mmp50 n41 qbint VDD VDD g45p1svt M=1 L=45n W=310n
Mmp55 Q qbint VDD VDD g45p1svt M=1 L=45n W=780n
Mmp20 CKb CK VDD VDD g45p1svt M=1 L=45n W=215n
Mmp46 qbint n30 VDD VDD g45p1svt M=1 L=45n W=310n
Mmp45 qbint RN VDD VDD g45p1svt M=1 L=45n W=310n
Mmp35 n26 RN VDD VDD g45p1svt M=1 L=45n W=310n
Mmp36 n26 mout VDD VDD g45p1svt M=1 L=45n W=310n
Mmp37 n20 CKb n26 VDD g45p1svt M=1 L=45n W=310n
Mmp40 n30 CKb mout VDD g45p1svt M=1 L=45n W=310n
Mmp30 mout n20 VDD VDD g45p1svt M=1 L=45n W=310n
Mmp21 CKbb CKb VDD VDD g45p1svt M=1 L=45n W=215n
.ENDS

.SUBCKT DFFRHQX1 CK D Q RN VDD VSS
Mmn36 n25 mout n27 VSS g45n1svt M=1 L=45n W=205n
Mmn35 n27 RN VSS VSS g45n1svt M=1 L=45n W=205n
Mmn37 n20 CKbb n25 VSS g45n1svt M=1 L=45n W=205n
Mmn26 n20 CKb n21 VSS g45n1svt M=1 L=45n W=205n
Mmn25 n21 D VSS VSS g45n1svt M=1 L=45n W=205n
Mmn55 Q qbint VSS VSS g45n1svt M=1 L=45n W=260n
Mmn45 n35 RN VSS VSS g45n1svt M=1 L=45n W=205n
Mmn46 qbint n30 n35 VSS g45n1svt M=1 L=45n W=205n
Mmn51 n30 CKb n40 VSS g45n1svt M=1 L=45n W=205n
Mmn50 n40 qbint VSS VSS g45n1svt M=1 L=45n W=205n
Mmn20 CKb CK VSS VSS g45n1svt M=1 L=45n W=145n
Mmn21 CKbb CKb VSS VSS g45n1svt M=1 L=45n W=145n
Mmn40 n30 CKbb mout VSS g45n1svt M=1 L=45n W=205n
Mmn30 mout n20 VSS VSS g45n1svt M=1 L=45n W=205n
Mmp26 n20 CKbb n22 VDD g45p1svt M=1 L=45n W=310n
Mmp25 n22 D VDD VDD g45p1svt M=1 L=45n W=310n
Mmp51 n30 CKbb n41 VDD g45p1svt M=1 L=45n W=310n
Mmp50 n41 qbint VDD VDD g45p1svt M=1 L=45n W=310n
Mmp55 Q qbint VDD VDD g45p1svt M=1 L=45n W=390n
Mmp20 CKb CK VDD VDD g45p1svt M=1 L=45n W=215n
Mmp46 qbint n30 VDD VDD g45p1svt M=1 L=45n W=310n
Mmp45 qbint RN VDD VDD g45p1svt M=1 L=45n W=310n
Mmp35 n26 RN VDD VDD g45p1svt M=1 L=45n W=310n
Mmp36 n26 mout VDD VDD g45p1svt M=1 L=45n W=310n
Mmp37 n20 CKb n26 VDD g45p1svt M=1 L=45n W=310n
Mmp40 n30 CKb mout VDD g45p1svt M=1 L=45n W=310n
Mmp30 mout n20 VDD VDD g45p1svt M=1 L=45n W=310n
Mmp21 CKbb CKb VDD VDD g45p1svt M=1 L=45n W=215n
.ENDS

.SUBCKT DFFQXL CK D Q VDD VSS
Mmn26 n20 CKb n21 VSS g45n1svt M=1 L=45n W=145n
Mmn25 n21 D VSS VSS g45n1svt M=1 L=45n W=145n
Mmn55 Q qbint VSS VSS g45n1svt M=1 L=45n W=145n
Mmn50 n35 qbint VSS VSS g45n1svt M=1 L=45n W=145n
Mmn51 n30 CKb n35 VSS g45n1svt M=1 L=45n W=145n
Mmn35 n25 mout VSS VSS g45n1svt M=1 L=45n W=145n
Mmn30 mout n20 VSS VSS g45n1svt M=1 L=45n W=145n
Mmn40 n30 CKbb mout VSS g45n1svt M=1 L=45n W=145n
Mmn45 qbint n30 VSS VSS g45n1svt M=1 L=45n W=145n
Mmn21 CKbb CKb VSS VSS g45n1svt M=1 L=45n W=145n
Mmn36 n20 CKbb n25 VSS g45n1svt M=1 L=45n W=145n
Mmn20 CKb CK VSS VSS g45n1svt M=1 L=45n W=145n
Mmp26 n20 CKbb n22 VDD g45p1svt M=1 L=45n W=215n
Mmp25 n22 D VDD VDD g45p1svt M=1 L=45n W=215n
Mmp51 n30 CKbb n36 VDD g45p1svt M=1 L=45n W=215n
Mmp50 n36 qbint VDD VDD g45p1svt M=1 L=45n W=215n
Mmp55 Q qbint VDD VDD g45p1svt M=1 L=45n W=215n
Mmp35 n26 mout VDD VDD g45p1svt M=1 L=45n W=215n
Mmp36 n20 CKb n26 VDD g45p1svt M=1 L=45n W=215n
Mmp21 CKbb CKb VDD VDD g45p1svt M=1 L=45n W=215n
Mmp20 CKb CK VDD VDD g45p1svt M=1 L=45n W=215n
Mmp45 qbint n30 VDD VDD g45p1svt M=1 L=45n W=215n
Mmp40 n30 CKb mout VDD g45p1svt M=1 L=45n W=215n
Mmp30 mout n20 VDD VDD g45p1svt M=1 L=45n W=215n
.ENDS

.SUBCKT DFFQX4 CK D Q VDD VSS
Mmn26 n20 CKb n21 VSS g45n1svt M=1 L=45n W=145n
Mmn25 n21 D VSS VSS g45n1svt M=1 L=45n W=145n
Mmn55 Q qbint VSS VSS g45n1svt M=1 L=45n W=1.04u
Mmn50 n35 qbint VSS VSS g45n1svt M=1 L=45n W=145n
Mmn51 n30 CKb n35 VSS g45n1svt M=1 L=45n W=145n
Mmn35 n25 mout VSS VSS g45n1svt M=1 L=45n W=145n
Mmn30 mout n20 VSS VSS g45n1svt M=1 L=45n W=145n
Mmn40 n30 CKbb mout VSS g45n1svt M=1 L=45n W=145n
Mmn45 qbint n30 VSS VSS g45n1svt M=1 L=45n W=410n
Mmn21 CKbb CKb VSS VSS g45n1svt M=1 L=45n W=145n
Mmn36 n20 CKbb n25 VSS g45n1svt M=1 L=45n W=145n
Mmn20 CKb CK VSS VSS g45n1svt M=1 L=45n W=145n
Mmp26 n20 CKbb n22 VDD g45p1svt M=1 L=45n W=215n
Mmp25 n22 D VDD VDD g45p1svt M=1 L=45n W=215n
Mmp51 n30 CKbb n36 VDD g45p1svt M=1 L=45n W=215n
Mmp50 n36 qbint VDD VDD g45p1svt M=1 L=45n W=215n
Mmp55 Q qbint VDD VDD g45p1svt M=1 L=45n W=1.56u
Mmp35 n26 mout VDD VDD g45p1svt M=1 L=45n W=215n
Mmp36 n20 CKb n26 VDD g45p1svt M=1 L=45n W=215n
Mmp21 CKbb CKb VDD VDD g45p1svt M=1 L=45n W=215n
Mmp20 CKb CK VDD VDD g45p1svt M=1 L=45n W=215n
Mmp45 qbint n30 VDD VDD g45p1svt M=1 L=45n W=620n
Mmp40 n30 CKb mout VDD g45p1svt M=1 L=45n W=215n
Mmp30 mout n20 VDD VDD g45p1svt M=1 L=45n W=215n
.ENDS

.SUBCKT DFFQX2 CK D Q VDD VSS
Mmn26 n20 CKb n21 VSS g45n1svt M=1 L=45n W=145n
Mmn25 n21 D VSS VSS g45n1svt M=1 L=45n W=145n
Mmn55 Q qbint VSS VSS g45n1svt M=1 L=45n W=520n
Mmn50 n35 qbint VSS VSS g45n1svt M=1 L=45n W=145n
Mmn51 n30 CKb n35 VSS g45n1svt M=1 L=45n W=145n
Mmn35 n25 mout VSS VSS g45n1svt M=1 L=45n W=145n
Mmn30 mout n20 VSS VSS g45n1svt M=1 L=45n W=145n
Mmn40 n30 CKbb mout VSS g45n1svt M=1 L=45n W=145n
Mmn45 qbint n30 VSS VSS g45n1svt M=1 L=45n W=205n
Mmn21 CKbb CKb VSS VSS g45n1svt M=1 L=45n W=145n
Mmn36 n20 CKbb n25 VSS g45n1svt M=1 L=45n W=145n
Mmn20 CKb CK VSS VSS g45n1svt M=1 L=45n W=145n
Mmp26 n20 CKbb n22 VDD g45p1svt M=1 L=45n W=215n
Mmp25 n22 D VDD VDD g45p1svt M=1 L=45n W=215n
Mmp51 n30 CKbb n36 VDD g45p1svt M=1 L=45n W=215n
Mmp50 n36 qbint VDD VDD g45p1svt M=1 L=45n W=215n
Mmp55 Q qbint VDD VDD g45p1svt M=1 L=45n W=780n
Mmp35 n26 mout VDD VDD g45p1svt M=1 L=45n W=215n
Mmp36 n20 CKb n26 VDD g45p1svt M=1 L=45n W=215n
Mmp21 CKbb CKb VDD VDD g45p1svt M=1 L=45n W=215n
Mmp20 CKb CK VDD VDD g45p1svt M=1 L=45n W=215n
Mmp45 qbint n30 VDD VDD g45p1svt M=1 L=45n W=310n
Mmp40 n30 CKb mout VDD g45p1svt M=1 L=45n W=215n
Mmp30 mout n20 VDD VDD g45p1svt M=1 L=45n W=215n
.ENDS

.SUBCKT DFFQX1 CK D Q VDD VSS
Mmn26 n20 CKb n21 VSS g45n1svt M=1 L=45n W=145n
Mmn25 n21 D VSS VSS g45n1svt M=1 L=45n W=145n
Mmn55 Q qbint VSS VSS g45n1svt M=1 L=45n W=260n
Mmn50 n35 qbint VSS VSS g45n1svt M=1 L=45n W=145n
Mmn51 n30 CKb n35 VSS g45n1svt M=1 L=45n W=145n
Mmn35 n25 mout VSS VSS g45n1svt M=1 L=45n W=145n
Mmn30 mout n20 VSS VSS g45n1svt M=1 L=45n W=145n
Mmn40 n30 CKbb mout VSS g45n1svt M=1 L=45n W=145n
Mmn45 qbint n30 VSS VSS g45n1svt M=1 L=45n W=145n
Mmn21 CKbb CKb VSS VSS g45n1svt M=1 L=45n W=145n
Mmn36 n20 CKbb n25 VSS g45n1svt M=1 L=45n W=145n
Mmn20 CKb CK VSS VSS g45n1svt M=1 L=45n W=145n
Mmp26 n20 CKbb n22 VDD g45p1svt M=1 L=45n W=215n
Mmp25 n22 D VDD VDD g45p1svt M=1 L=45n W=215n
Mmp51 n30 CKbb n36 VDD g45p1svt M=1 L=45n W=215n
Mmp50 n36 qbint VDD VDD g45p1svt M=1 L=45n W=215n
Mmp55 Q qbint VDD VDD g45p1svt M=1 L=45n W=390n
Mmp35 n26 mout VDD VDD g45p1svt M=1 L=45n W=215n
Mmp36 n20 CKb n26 VDD g45p1svt M=1 L=45n W=215n
Mmp21 CKbb CKb VDD VDD g45p1svt M=1 L=45n W=215n
Mmp20 CKb CK VDD VDD g45p1svt M=1 L=45n W=215n
Mmp45 qbint n30 VDD VDD g45p1svt M=1 L=45n W=215n
Mmp40 n30 CKb mout VDD g45p1svt M=1 L=45n W=215n
Mmp30 mout n20 VDD VDD g45p1svt M=1 L=45n W=215n
.ENDS

.SUBCKT DFFNSRXL CKN D Q QN RN SN VDD VSS
Mmn26 n20 CKNbb n21 VSS g45n1svt M=1 L=45n W=145n
Mmn25 n21 D VSS VSS g45n1svt M=1 L=45n W=145n
Mmn57 QN qint VSS VSS g45n1svt M=1 L=45n W=145n
Mmn55 Q qbint VSS VSS g45n1svt M=1 L=45n W=145n
Mmn36 n20 CKNb n30 VSS g45n1svt M=1 L=45n W=145n
Mmn35 n30 mout VSS VSS g45n1svt M=1 L=45n W=145n
Mmn22 RNb RN VSS VSS g45n1svt M=1 L=45n W=145n
Mmn20 CKNb CKN VSS VSS g45n1svt M=1 L=45n W=145n
Mmn45 qbint n35 VSS VSS g45n1svt M=1 L=45n W=145n
Mmn56 qint qbint VSS VSS g45n1svt M=1 L=45n W=145n
Mmn52 n40 qbint n42 VSS g45n1svt M=1 L=45n W=145n
Mmn51 n40 RNb n42 VSS g45n1svt M=1 L=45n W=145n
Mmn50 n42 SN VSS VSS g45n1svt M=1 L=45n W=145n
Mmn53 n40 CKNbb n35 VSS g45n1svt M=1 L=45n W=145n
Mmn21 CKNbb CKNb VSS VSS g45n1svt M=1 L=45n W=145n
Mmn32 mout n20 n25 VSS g45n1svt M=1 L=45n W=145n
Mmn31 n25 RNb mout VSS g45n1svt M=1 L=45n W=145n
Mmn30 n25 SN VSS VSS g45n1svt M=1 L=45n W=145n
Mmn40 n35 CKNb mout VSS g45n1svt M=1 L=45n W=145n
Mmp25 n22 D VDD VDD g45p1svt M=1 L=45n W=215n
Mmp26 n20 CKNb n22 VDD g45p1svt M=1 L=45n W=215n
Mmp51 n43 RNb VDD VDD g45p1svt M=1 L=45n W=215n
Mmp57 QN qint VDD VDD g45p1svt M=1 L=45n W=215n
Mmp55 Q qbint VDD VDD g45p1svt M=1 L=45n W=215n
Mmp36 n20 CKNbb n31 VDD g45p1svt M=1 L=45n W=215n
Mmp35 n31 mout VDD VDD g45p1svt M=1 L=45n W=215n
Mmp32 mout n20 n26 VDD g45p1svt M=1 L=45n W=215n
Mmp31 n26 RNb VDD VDD g45p1svt M=1 L=45n W=215n
Mmp22 RNb RN VDD VDD g45p1svt M=1 L=45n W=215n
Mmp20 CKNb CKN VDD VDD g45p1svt M=1 L=45n W=215n
Mmp53 n41 CKNb n35 VDD g45p1svt M=1 L=45n W=215n
Mmp50 n41 SN VDD VDD g45p1svt M=1 L=45n W=215n
Mmp45 qbint n35 VDD VDD g45p1svt M=1 L=45n W=215n
Mmp56 qint qbint VDD VDD g45p1svt M=1 L=45n W=215n
Mmp21 CKNbb CKNb VDD VDD g45p1svt M=1 L=45n W=215n
Mmp40 n35 CKNbb mout VDD g45p1svt M=1 L=45n W=215n
Mmp52 n41 qbint n43 VDD g45p1svt M=1 L=45n W=215n
Mmp30 mout SN VDD VDD g45p1svt M=1 L=45n W=215n
.ENDS

.SUBCKT DFFNSRX4 CKN D Q QN RN SN VDD VSS
Mmn26 n20 CKNbb n21 VSS g45n1svt M=1 L=45n W=145n
Mmn25 n21 D VSS VSS g45n1svt M=1 L=45n W=145n
Mmn57 QN qint VSS VSS g45n1svt M=1 L=45n W=1.04u
Mmn55 Q qbint VSS VSS g45n1svt M=1 L=45n W=1.04u
Mmn36 n20 CKNb n30 VSS g45n1svt M=1 L=45n W=145n
Mmn35 n30 mout VSS VSS g45n1svt M=1 L=45n W=145n
Mmn22 RNb RN VSS VSS g45n1svt M=1 L=45n W=145n
Mmn20 CKNb CKN VSS VSS g45n1svt M=1 L=45n W=145n
Mmn45 qbint n35 VSS VSS g45n1svt M=1 L=45n W=410n
Mmn56 qint qbint VSS VSS g45n1svt M=1 L=45n W=260n
Mmn52 n40 qbint n42 VSS g45n1svt M=1 L=45n W=145n
Mmn51 n40 RNb n42 VSS g45n1svt M=1 L=45n W=145n
Mmn50 n42 SN VSS VSS g45n1svt M=1 L=45n W=145n
Mmn53 n40 CKNbb n35 VSS g45n1svt M=1 L=45n W=145n
Mmn21 CKNbb CKNb VSS VSS g45n1svt M=1 L=45n W=145n
Mmn32 mout n20 n25 VSS g45n1svt M=1 L=45n W=145n
Mmn31 n25 RNb mout VSS g45n1svt M=1 L=45n W=145n
Mmn30 n25 SN VSS VSS g45n1svt M=1 L=45n W=145n
Mmn40 n35 CKNb mout VSS g45n1svt M=1 L=45n W=145n
Mmp25 n22 D VDD VDD g45p1svt M=1 L=45n W=215n
Mmp26 n20 CKNb n22 VDD g45p1svt M=1 L=45n W=215n
Mmp51 n43 RNb VDD VDD g45p1svt M=1 L=45n W=215n
Mmp57 QN qint VDD VDD g45p1svt M=1 L=45n W=1.56u
Mmp55 Q qbint VDD VDD g45p1svt M=1 L=45n W=1.56u
Mmp36 n20 CKNbb n31 VDD g45p1svt M=1 L=45n W=215n
Mmp35 n31 mout VDD VDD g45p1svt M=1 L=45n W=215n
Mmp32 mout n20 n26 VDD g45p1svt M=1 L=45n W=215n
Mmp31 n26 RNb VDD VDD g45p1svt M=1 L=45n W=215n
Mmp22 RNb RN VDD VDD g45p1svt M=1 L=45n W=215n
Mmp20 CKNb CKN VDD VDD g45p1svt M=1 L=45n W=215n
Mmp53 n41 CKNb n35 VDD g45p1svt M=1 L=45n W=215n
Mmp50 n41 SN VDD VDD g45p1svt M=1 L=45n W=215n
Mmp45 qbint n35 VDD VDD g45p1svt M=1 L=45n W=620n
Mmp56 qint qbint VDD VDD g45p1svt M=1 L=45n W=390n
Mmp21 CKNbb CKNb VDD VDD g45p1svt M=1 L=45n W=215n
Mmp40 n35 CKNbb mout VDD g45p1svt M=1 L=45n W=215n
Mmp52 n41 qbint n43 VDD g45p1svt M=1 L=45n W=215n
Mmp30 mout SN VDD VDD g45p1svt M=1 L=45n W=215n
.ENDS

.SUBCKT DFFNSRX2 CKN D Q QN RN SN VDD VSS
Mmn26 n20 CKNbb n21 VSS g45n1svt M=1 L=45n W=145n
Mmn25 n21 D VSS VSS g45n1svt M=1 L=45n W=145n
Mmn57 QN qint VSS VSS g45n1svt M=1 L=45n W=520n
Mmn55 Q qbint VSS VSS g45n1svt M=1 L=45n W=520n
Mmn36 n20 CKNb n30 VSS g45n1svt M=1 L=45n W=145n
Mmn35 n30 mout VSS VSS g45n1svt M=1 L=45n W=145n
Mmn22 RNb RN VSS VSS g45n1svt M=1 L=45n W=145n
Mmn20 CKNb CKN VSS VSS g45n1svt M=1 L=45n W=145n
Mmn45 qbint n35 VSS VSS g45n1svt M=1 L=45n W=205n
Mmn56 qint qbint VSS VSS g45n1svt M=1 L=45n W=145n
Mmn52 n40 qbint n42 VSS g45n1svt M=1 L=45n W=145n
Mmn51 n40 RNb n42 VSS g45n1svt M=1 L=45n W=145n
Mmn50 n42 SN VSS VSS g45n1svt M=1 L=45n W=145n
Mmn53 n40 CKNbb n35 VSS g45n1svt M=1 L=45n W=145n
Mmn21 CKNbb CKNb VSS VSS g45n1svt M=1 L=45n W=145n
Mmn32 mout n20 n25 VSS g45n1svt M=1 L=45n W=145n
Mmn31 n25 RNb mout VSS g45n1svt M=1 L=45n W=145n
Mmn30 n25 SN VSS VSS g45n1svt M=1 L=45n W=145n
Mmn40 n35 CKNb mout VSS g45n1svt M=1 L=45n W=145n
Mmp25 n22 D VDD VDD g45p1svt M=1 L=45n W=215n
Mmp26 n20 CKNb n22 VDD g45p1svt M=1 L=45n W=215n
Mmp51 n43 RNb VDD VDD g45p1svt M=1 L=45n W=215n
Mmp57 QN qint VDD VDD g45p1svt M=1 L=45n W=780n
Mmp55 Q qbint VDD VDD g45p1svt M=1 L=45n W=780n
Mmp36 n20 CKNbb n31 VDD g45p1svt M=1 L=45n W=215n
Mmp35 n31 mout VDD VDD g45p1svt M=1 L=45n W=215n
Mmp32 mout n20 n26 VDD g45p1svt M=1 L=45n W=215n
Mmp31 n26 RNb VDD VDD g45p1svt M=1 L=45n W=215n
Mmp22 RNb RN VDD VDD g45p1svt M=1 L=45n W=215n
Mmp20 CKNb CKN VDD VDD g45p1svt M=1 L=45n W=215n
Mmp53 n41 CKNb n35 VDD g45p1svt M=1 L=45n W=215n
Mmp50 n41 SN VDD VDD g45p1svt M=1 L=45n W=215n
Mmp45 qbint n35 VDD VDD g45p1svt M=1 L=45n W=310n
Mmp56 qint qbint VDD VDD g45p1svt M=1 L=45n W=215n
Mmp21 CKNbb CKNb VDD VDD g45p1svt M=1 L=45n W=215n
Mmp40 n35 CKNbb mout VDD g45p1svt M=1 L=45n W=215n
Mmp52 n41 qbint n43 VDD g45p1svt M=1 L=45n W=215n
Mmp30 mout SN VDD VDD g45p1svt M=1 L=45n W=215n
.ENDS

.SUBCKT DFFNSRX1 CKN D Q QN RN SN VDD VSS
Mmn26 n20 CKNbb n21 VSS g45n1svt M=1 L=45n W=145n
Mmn25 n21 D VSS VSS g45n1svt M=1 L=45n W=145n
Mmn57 QN qint VSS VSS g45n1svt M=1 L=45n W=260n
Mmn55 Q qbint VSS VSS g45n1svt M=1 L=45n W=260n
Mmn36 n20 CKNb n30 VSS g45n1svt M=1 L=45n W=145n
Mmn35 n30 mout VSS VSS g45n1svt M=1 L=45n W=145n
Mmn22 RNb RN VSS VSS g45n1svt M=1 L=45n W=145n
Mmn20 CKNb CKN VSS VSS g45n1svt M=1 L=45n W=145n
Mmn45 qbint n35 VSS VSS g45n1svt M=1 L=45n W=145n
Mmn56 qint qbint VSS VSS g45n1svt M=1 L=45n W=145n
Mmn52 n40 qbint n42 VSS g45n1svt M=1 L=45n W=145n
Mmn51 n40 RNb n42 VSS g45n1svt M=1 L=45n W=145n
Mmn50 n42 SN VSS VSS g45n1svt M=1 L=45n W=145n
Mmn53 n40 CKNbb n35 VSS g45n1svt M=1 L=45n W=145n
Mmn21 CKNbb CKNb VSS VSS g45n1svt M=1 L=45n W=145n
Mmn32 mout n20 n25 VSS g45n1svt M=1 L=45n W=145n
Mmn31 n25 RNb mout VSS g45n1svt M=1 L=45n W=145n
Mmn30 n25 SN VSS VSS g45n1svt M=1 L=45n W=145n
Mmn40 n35 CKNb mout VSS g45n1svt M=1 L=45n W=145n
Mmp25 n22 D VDD VDD g45p1svt M=1 L=45n W=215n
Mmp26 n20 CKNb n22 VDD g45p1svt M=1 L=45n W=215n
Mmp51 n43 RNb VDD VDD g45p1svt M=1 L=45n W=215n
Mmp57 QN qint VDD VDD g45p1svt M=1 L=45n W=390n
Mmp55 Q qbint VDD VDD g45p1svt M=1 L=45n W=390n
Mmp36 n20 CKNbb n31 VDD g45p1svt M=1 L=45n W=215n
Mmp35 n31 mout VDD VDD g45p1svt M=1 L=45n W=215n
Mmp32 mout n20 n26 VDD g45p1svt M=1 L=45n W=215n
Mmp31 n26 RNb VDD VDD g45p1svt M=1 L=45n W=215n
Mmp22 RNb RN VDD VDD g45p1svt M=1 L=45n W=215n
Mmp20 CKNb CKN VDD VDD g45p1svt M=1 L=45n W=215n
Mmp53 n41 CKNb n35 VDD g45p1svt M=1 L=45n W=215n
Mmp50 n41 SN VDD VDD g45p1svt M=1 L=45n W=215n
Mmp45 qbint n35 VDD VDD g45p1svt M=1 L=45n W=215n
Mmp56 qint qbint VDD VDD g45p1svt M=1 L=45n W=215n
Mmp21 CKNbb CKNb VDD VDD g45p1svt M=1 L=45n W=215n
Mmp40 n35 CKNbb mout VDD g45p1svt M=1 L=45n W=215n
Mmp52 n41 qbint n43 VDD g45p1svt M=1 L=45n W=215n
Mmp30 mout SN VDD VDD g45p1svt M=1 L=45n W=215n
.ENDS

.SUBCKT DFFHQX8 CK D Q VDD VSS
Mmn26 n20 CKb n21 VSS g45n1svt M=1 L=45n W=205n
Mmn25 n21 D VSS VSS g45n1svt M=1 L=45n W=205n
Mmn55 Q qbint VSS VSS g45n1svt M=1 L=45n W=2.065u
Mmn50 net172 qbint VSS VSS g45n1svt M=1 L=45n W=205n
Mmn51 n30 CKb net172 VSS g45n1svt M=1 L=45n W=205n
Mmn30 mout n20 VSS VSS g45n1svt M=1 L=45n W=205n
Mmn36 n20 CKbb net192 VSS g45n1svt M=1 L=45n W=205n
Mmn20 CKb CK VSS VSS g45n1svt M=1 L=45n W=145n
Mmn45 qbint n30 VSS VSS g45n1svt M=1 L=45n W=780n
Mmn40 mout CKbb n30 VSS g45n1svt M=1 L=45n W=205n
Mmn21 CKbb CKb VSS VSS g45n1svt M=1 L=45n W=145n
Mmn35 net192 mout VSS VSS g45n1svt M=1 L=45n W=205n
Mmp26 n20 CKbb n22 VDD g45p1svt M=1 L=45n W=310n
Mmp25 n22 D VDD VDD g45p1svt M=1 L=45n W=310n
Mmp51 n30 CKbb net123 VDD g45p1svt M=1 L=45n W=310n
Mmp50 net123 qbint VDD VDD g45p1svt M=1 L=45n W=310n
Mmp55 Q qbint VDD VDD g45p1svt M=1 L=45n W=3.115u
Mmp35 net147 mout VDD VDD g45p1svt M=1 L=45n W=310n
Mmp36 n20 CKb net147 VDD g45p1svt M=1 L=45n W=310n
Mmp45 qbint n30 VDD VDD g45p1svt M=1 L=45n W=1.17u
Mmp20 CKb CK VDD VDD g45p1svt M=1 L=45n W=215n
Mmp40 mout CKb n30 VDD g45p1svt M=1 L=45n W=310n
Mmp30 mout n20 VDD VDD g45p1svt M=1 L=45n W=310n
Mmp21 CKbb CKb VDD VDD g45p1svt M=1 L=45n W=215n
.ENDS

.SUBCKT DFFHQX4 CK D Q VDD VSS
Mmn26 n20 CKb n21 VSS g45n1svt M=1 L=45n W=205n
Mmn25 n21 D VSS VSS g45n1svt M=1 L=45n W=205n
Mmn55 Q qbint VSS VSS g45n1svt M=1 L=45n W=1.04u
Mmn50 net172 qbint VSS VSS g45n1svt M=1 L=45n W=205n
Mmn51 n30 CKb net172 VSS g45n1svt M=1 L=45n W=205n
Mmn30 mout n20 VSS VSS g45n1svt M=1 L=45n W=205n
Mmn36 n20 CKbb net192 VSS g45n1svt M=1 L=45n W=205n
Mmn20 CKb CK VSS VSS g45n1svt M=1 L=45n W=145n
Mmn45 qbint n30 VSS VSS g45n1svt M=1 L=45n W=410n
Mmn40 mout CKbb n30 VSS g45n1svt M=1 L=45n W=205n
Mmn21 CKbb CKb VSS VSS g45n1svt M=1 L=45n W=145n
Mmn35 net192 mout VSS VSS g45n1svt M=1 L=45n W=205n
Mmp26 n20 CKbb n22 VDD g45p1svt M=1 L=45n W=310n
Mmp25 n22 D VDD VDD g45p1svt M=1 L=45n W=310n
Mmp51 n30 CKbb net123 VDD g45p1svt M=1 L=45n W=310n
Mmp50 net123 qbint VDD VDD g45p1svt M=1 L=45n W=310n
Mmp55 Q qbint VDD VDD g45p1svt M=1 L=45n W=1.56u
Mmp35 net147 mout VDD VDD g45p1svt M=1 L=45n W=310n
Mmp36 n20 CKb net147 VDD g45p1svt M=1 L=45n W=310n
Mmp45 qbint n30 VDD VDD g45p1svt M=1 L=45n W=620n
Mmp20 CKb CK VDD VDD g45p1svt M=1 L=45n W=215n
Mmp40 mout CKb n30 VDD g45p1svt M=1 L=45n W=310n
Mmp30 mout n20 VDD VDD g45p1svt M=1 L=45n W=310n
Mmp21 CKbb CKb VDD VDD g45p1svt M=1 L=45n W=215n
.ENDS

.SUBCKT DFFHQX2 CK D Q VDD VSS
Mmn26 n20 CKb n21 VSS g45n1svt M=1 L=45n W=205n
Mmn25 n21 D VSS VSS g45n1svt M=1 L=45n W=205n
Mmn55 Q qbint VSS VSS g45n1svt M=1 L=45n W=520n
Mmn50 net172 qbint VSS VSS g45n1svt M=1 L=45n W=205n
Mmn51 n30 CKb net172 VSS g45n1svt M=1 L=45n W=205n
Mmn30 mout n20 VSS VSS g45n1svt M=1 L=45n W=205n
Mmn36 n20 CKbb net192 VSS g45n1svt M=1 L=45n W=205n
Mmn20 CKb CK VSS VSS g45n1svt M=1 L=45n W=145n
Mmn45 qbint n30 VSS VSS g45n1svt M=1 L=45n W=205n
Mmn40 mout CKbb n30 VSS g45n1svt M=1 L=45n W=205n
Mmn21 CKbb CKb VSS VSS g45n1svt M=1 L=45n W=145n
Mmn35 net192 mout VSS VSS g45n1svt M=1 L=45n W=205n
Mmp26 n20 CKbb n22 VDD g45p1svt M=1 L=45n W=310n
Mmp25 n22 D VDD VDD g45p1svt M=1 L=45n W=310n
Mmp51 n30 CKbb net123 VDD g45p1svt M=1 L=45n W=310n
Mmp50 net123 qbint VDD VDD g45p1svt M=1 L=45n W=310n
Mmp55 Q qbint VDD VDD g45p1svt M=1 L=45n W=780n
Mmp35 net147 mout VDD VDD g45p1svt M=1 L=45n W=310n
Mmp36 n20 CKb net147 VDD g45p1svt M=1 L=45n W=310n
Mmp45 qbint n30 VDD VDD g45p1svt M=1 L=45n W=310n
Mmp20 CKb CK VDD VDD g45p1svt M=1 L=45n W=215n
Mmp40 mout CKb n30 VDD g45p1svt M=1 L=45n W=310n
Mmp30 mout n20 VDD VDD g45p1svt M=1 L=45n W=310n
Mmp21 CKbb CKb VDD VDD g45p1svt M=1 L=45n W=215n
.ENDS

.SUBCKT DFFHQX1 CK D Q VDD VSS
Mmn26 n20 CKb n21 VSS g45n1svt M=1 L=45n W=205n
Mmn25 n21 D VSS VSS g45n1svt M=1 L=45n W=205n
Mmn55 Q qbint VSS VSS g45n1svt M=1 L=45n W=260n
Mmn50 net172 qbint VSS VSS g45n1svt M=1 L=45n W=205n
Mmn51 n30 CKb net172 VSS g45n1svt M=1 L=45n W=205n
Mmn30 mout n20 VSS VSS g45n1svt M=1 L=45n W=205n
Mmn36 n20 CKbb net192 VSS g45n1svt M=1 L=45n W=205n
Mmn20 CKb CK VSS VSS g45n1svt M=1 L=45n W=145n
Mmn45 qbint n30 VSS VSS g45n1svt M=1 L=45n W=205n
Mmn40 mout CKbb n30 VSS g45n1svt M=1 L=45n W=205n
Mmn21 CKbb CKb VSS VSS g45n1svt M=1 L=45n W=145n
Mmn35 net192 mout VSS VSS g45n1svt M=1 L=45n W=205n
Mmp26 n20 CKbb n22 VDD g45p1svt M=1 L=45n W=310n
Mmp25 n22 D VDD VDD g45p1svt M=1 L=45n W=310n
Mmp51 n30 CKbb net123 VDD g45p1svt M=1 L=45n W=310n
Mmp50 net123 qbint VDD VDD g45p1svt M=1 L=45n W=310n
Mmp55 Q qbint VDD VDD g45p1svt M=1 L=45n W=390n
Mmp35 net147 mout VDD VDD g45p1svt M=1 L=45n W=310n
Mmp36 n20 CKb net147 VDD g45p1svt M=1 L=45n W=310n
Mmp45 qbint n30 VDD VDD g45p1svt M=1 L=45n W=310n
Mmp20 CKb CK VDD VDD g45p1svt M=1 L=45n W=215n
Mmp40 mout CKb n30 VDD g45p1svt M=1 L=45n W=310n
Mmp30 mout n20 VDD VDD g45p1svt M=1 L=45n W=310n
Mmp21 CKbb CKb VDD VDD g45p1svt M=1 L=45n W=215n
.ENDS

.SUBCKT DFF4X2 CK D1 D2 D3 D4 Q1 Q1N Q2 Q2N Q3 Q3N Q4 Q4N VDD VSS
MNM54 Db_4 D4 VSS VSS g45n1svt M=1 L=45n W=145n
MNM50 Db_4 CKb n20_4 VSS g45n1svt M=1 L=45n W=145n
MNM49 mout_4 n20_4 VSS VSS g45n1svt M=1 L=45n W=145n
MNM48 n20_4 Ckbb n5_4 VSS g45n1svt M=1 L=45n W=145n
MNM46 n5_4 mout_4 VSS VSS g45n1svt M=1 L=45n W=145n
MNM45 mout_4 Ckbb n30_4 VSS g45n1svt M=1 L=45n W=145n
MNM44 qbint_4 n30_4 VSS VSS g45n1svt M=1 L=45n W=205n
MNM42 n11_4 qbint_4 VSS VSS g45n1svt M=1 L=45n W=145n
MNM41 n30_4 CKb n11_4 VSS g45n1svt M=1 L=45n W=145n
MNM40 Q4 qbint_4 VSS VSS g45n1svt M=1 L=45n W=520n
MNM39 qint_4 qbint_4 VSS VSS g45n1svt M=1 L=45n W=145n
MNM38 Q4N qint_4 VSS VSS g45n1svt M=1 L=45n W=520n
MNM37 Q3N qint_3 VSS VSS g45n1svt M=1 L=45n W=520n
MNM36 qint_3 qbint_3 VSS VSS g45n1svt M=1 L=45n W=145n
MNM35 Q3 qbint_3 VSS VSS g45n1svt M=1 L=45n W=520n
MNM34 n30_3 CKb n11_3 VSS g45n1svt M=1 L=45n W=145n
MNM33 n11_3 qbint_3 VSS VSS g45n1svt M=1 L=45n W=145n
MNM31 qbint_3 n30_3 VSS VSS g45n1svt M=1 L=45n W=205n
MNM30 mout_3 Ckbb n30_3 VSS g45n1svt M=1 L=45n W=145n
MNM29 n5_3 mout_3 VSS VSS g45n1svt M=1 L=45n W=145n
MNM27 n20_3 Ckbb n5_3 VSS g45n1svt M=1 L=45n W=145n
MNM26 mout_3 n20_3 VSS VSS g45n1svt M=1 L=45n W=145n
MNM25 Db_3 CKb n20_3 VSS g45n1svt M=1 L=45n W=145n
MNM19 Q2N qint_2 VSS VSS g45n1svt M=1 L=45n W=520n
MNM18 qint_2 qbint_2 VSS VSS g45n1svt M=1 L=45n W=145n
MNM17 Q2 qbint_2 VSS VSS g45n1svt M=1 L=45n W=520n
MNM16 n30_2 CKb n11_2 VSS g45n1svt M=1 L=45n W=145n
MNM15 n11_2 qbint_2 VSS VSS g45n1svt M=1 L=45n W=145n
MNM13 qbint_2 n30_2 VSS VSS g45n1svt M=1 L=45n W=205n
MNM12 mout_2 Ckbb n30_2 VSS g45n1svt M=1 L=45n W=145n
MNM11 n5_2 mout_2 VSS VSS g45n1svt M=1 L=45n W=145n
MNM9 n20_2 Ckbb n5_2 VSS g45n1svt M=1 L=45n W=145n
MNM8 mout_2 n20_2 VSS VSS g45n1svt M=1 L=45n W=145n
MNM7 Db_2 CKb n20_2 VSS g45n1svt M=1 L=45n W=145n
MNM1 Db_2 D2 VSS VSS g45n1svt M=1 L=45n W=145n
MNM21 Db_3 D3 VSS VSS g45n1svt M=1 L=45n W=145n
Mmn36 n5 mout VSS VSS g45n1svt M=1 L=45n W=145n
Mmn37 n20 Ckbb n5 VSS g45n1svt M=1 L=45n W=145n
Mmn11 Db D1 VSS VSS g45n1svt M=1 L=45n W=145n
Mmn57 Q1N qint VSS VSS g45n1svt M=1 L=45n W=520n
Mmn55 Q1 qbint VSS VSS g45n1svt M=1 L=45n W=520n
Mmn46 qbint n30 VSS VSS g45n1svt M=1 L=45n W=205n
Mmn51 n30 CKb n11 VSS g45n1svt M=1 L=45n W=145n
Mmn50 n11 qbint VSS VSS g45n1svt M=1 L=45n W=145n
Mmn20 CKb CK VSS VSS g45n1svt M=1 L=45n W=145n
Mmn56 qint qbint VSS VSS g45n1svt M=1 L=45n W=145n
Mmn40 mout Ckbb n30 VSS g45n1svt M=1 L=45n W=145n
Mmn30 mout n20 VSS VSS g45n1svt M=1 L=45n W=145n
Mmn21 Ckbb CKb VSS VSS g45n1svt M=1 L=45n W=145n
Mmn25 Db CKb n20 VSS g45n1svt M=1 L=45n W=145n
MPM54 Db_4 D4 VDD VDD g45p1svt M=1 L=45n W=215n
MPM50 n20_4 Ckbb Db_4 VDD g45p1svt M=1 L=45n W=215n
MPM49 mout_4 n20_4 VDD VDD g45p1svt M=1 L=45n W=215n
MPM47 n20_4 CKb n6_4 VDD g45p1svt M=1 L=45n W=215n
MPM46 n6_4 mout_4 VDD VDD g45p1svt M=1 L=45n W=215n
MPM45 n30_4 CKb mout_4 VDD g45p1svt M=1 L=45n W=215n
MPM43 qbint_4 n30_4 VDD VDD g45p1svt M=1 L=45n W=310n
MPM42 n8_4 qbint_4 VDD VDD g45p1svt M=1 L=45n W=215n
MPM41 n30_4 Ckbb n8_4 VDD g45p1svt M=1 L=45n W=215n
MPM40 Q4 qbint_4 VDD VDD g45p1svt M=1 L=45n W=780n
MPM39 qint_4 qbint_4 VDD VDD g45p1svt M=1 L=45n W=215n
MPM38 Q4N qint_4 VDD VDD g45p1svt M=1 L=45n W=780n
MPM37 Q3N qint_3 VDD VDD g45p1svt M=1 L=45n W=780n
MPM36 qint_3 qbint_3 VDD VDD g45p1svt M=1 L=45n W=215n
MPM35 Q3 qbint_3 VDD VDD g45p1svt M=1 L=45n W=780n
MPM34 n30_3 Ckbb n8_3 VDD g45p1svt M=1 L=45n W=215n
MPM33 n8_3 qbint_3 VDD VDD g45p1svt M=1 L=45n W=215n
MPM32 qbint_3 n30_3 VDD VDD g45p1svt M=1 L=45n W=310n
MPM30 n30_3 CKb mout_3 VDD g45p1svt M=1 L=45n W=215n
MPM29 n6_3 mout_3 VDD VDD g45p1svt M=1 L=45n W=215n
MPM28 n20_3 CKb n6_3 VDD g45p1svt M=1 L=45n W=215n
MPM26 mout_3 n20_3 VDD VDD g45p1svt M=1 L=45n W=215n
MPM25 n20_3 Ckbb Db_3 VDD g45p1svt M=1 L=45n W=215n
MPM19 Q2N qint_2 VDD VDD g45p1svt M=1 L=45n W=780n
MPM18 qint_2 qbint_2 VDD VDD g45p1svt M=1 L=45n W=215n
MPM17 Q2 qbint_2 VDD VDD g45p1svt M=1 L=45n W=780n
MPM16 n30_2 Ckbb n8_2 VDD g45p1svt M=1 L=45n W=215n
MPM15 n8_2 qbint_2 VDD VDD g45p1svt M=1 L=45n W=215n
MPM14 qbint_2 n30_2 VDD VDD g45p1svt M=1 L=45n W=310n
MPM12 n30_2 CKb mout_2 VDD g45p1svt M=1 L=45n W=215n
MPM11 n6_2 mout_2 VDD VDD g45p1svt M=1 L=45n W=215n
MPM10 n20_2 CKb n6_2 VDD g45p1svt M=1 L=45n W=215n
MPM8 mout_2 n20_2 VDD VDD g45p1svt M=1 L=45n W=215n
MPM7 n20_2 Ckbb Db_2 VDD g45p1svt M=1 L=45n W=215n
MPM21 Db_3 D3 VDD VDD g45p1svt M=1 L=45n W=215n
MPM1 Db_2 D2 VDD VDD g45p1svt M=1 L=45n W=215n
Mmp11 Db D1 VDD VDD g45p1svt M=1 L=45n W=215n
Mmp51 n30 Ckbb n8 VDD g45p1svt M=1 L=45n W=215n
Mmp50 n8 qbint VDD VDD g45p1svt M=1 L=45n W=215n
Mmp55 Q1 qbint VDD VDD g45p1svt M=1 L=45n W=780n
Mmp20 CKb CK VDD VDD g45p1svt M=1 L=45n W=215n
Mmp46 qbint n30 VDD VDD g45p1svt M=1 L=45n W=310n
Mmp56 qint qbint VDD VDD g45p1svt M=1 L=45n W=215n
Mmp36 n6 mout VDD VDD g45p1svt M=1 L=45n W=215n
Mmp37 n20 CKb n6 VDD g45p1svt M=1 L=45n W=215n
Mmp40 n30 CKb mout VDD g45p1svt M=1 L=45n W=215n
Mmp30 mout n20 VDD VDD g45p1svt M=1 L=45n W=215n
Mmp21 Ckbb CKb VDD VDD g45p1svt M=1 L=45n W=215n
Mmp25 n20 Ckbb Db VDD g45p1svt M=1 L=45n W=215n
Mmp57 Q1N qint VDD VDD g45p1svt M=1 L=45n W=780n
.ENDS

.SUBCKT DFF4X1 CK D1 D2 D3 D4 Q1 Q1N Q2 Q2N Q3 Q3N Q4 Q4N VDD VSS
MNM54 Db_4 D4 VSS VSS g45n1svt M=1 L=45n W=145n
MNM50 Db_4 CKb n20_4 VSS g45n1svt M=1 L=45n W=145n
MNM49 mout_4 n20_4 VSS VSS g45n1svt M=1 L=45n W=145n
MNM48 n20_4 Ckbb n5_4 VSS g45n1svt M=1 L=45n W=145n
MNM46 n5_4 mout_4 VSS VSS g45n1svt M=1 L=45n W=145n
MNM45 mout_4 Ckbb n30_4 VSS g45n1svt M=1 L=45n W=145n
MNM44 qbint_4 n30_4 VSS VSS g45n1svt M=1 L=45n W=145n
MNM42 n11_4 qbint_4 VSS VSS g45n1svt M=1 L=45n W=145n
MNM41 n30_4 CKb n11_4 VSS g45n1svt M=1 L=45n W=145n
MNM40 Q4 qbint_4 VSS VSS g45n1svt M=1 L=45n W=260n
MNM39 qint_4 qbint_4 VSS VSS g45n1svt M=1 L=45n W=145n
MNM38 Q4N qint_4 VSS VSS g45n1svt M=1 L=45n W=260n
MNM37 Q3N qint_3 VSS VSS g45n1svt M=1 L=45n W=260n
MNM36 qint_3 qbint_3 VSS VSS g45n1svt M=1 L=45n W=145n
MNM35 Q3 qbint_3 VSS VSS g45n1svt M=1 L=45n W=260n
MNM34 n30_3 CKb n11_3 VSS g45n1svt M=1 L=45n W=145n
MNM33 n11_3 qbint_3 VSS VSS g45n1svt M=1 L=45n W=145n
MNM31 qbint_3 n30_3 VSS VSS g45n1svt M=1 L=45n W=145n
MNM30 mout_3 Ckbb n30_3 VSS g45n1svt M=1 L=45n W=145n
MNM29 n5_3 mout_3 VSS VSS g45n1svt M=1 L=45n W=145n
MNM27 n20_3 Ckbb n5_3 VSS g45n1svt M=1 L=45n W=145n
MNM26 mout_3 n20_3 VSS VSS g45n1svt M=1 L=45n W=145n
MNM25 Db_3 CKb n20_3 VSS g45n1svt M=1 L=45n W=145n
MNM19 Q2N qint_2 VSS VSS g45n1svt M=1 L=45n W=260n
MNM18 qint_2 qbint_2 VSS VSS g45n1svt M=1 L=45n W=145n
MNM17 Q2 qbint_2 VSS VSS g45n1svt M=1 L=45n W=260n
MNM16 n30_2 CKb n11_2 VSS g45n1svt M=1 L=45n W=145n
MNM15 n11_2 qbint_2 VSS VSS g45n1svt M=1 L=45n W=145n
MNM13 qbint_2 n30_2 VSS VSS g45n1svt M=1 L=45n W=145n
MNM12 mout_2 Ckbb n30_2 VSS g45n1svt M=1 L=45n W=145n
MNM11 n5_2 mout_2 VSS VSS g45n1svt M=1 L=45n W=145n
MNM9 n20_2 Ckbb n5_2 VSS g45n1svt M=1 L=45n W=145n
MNM8 mout_2 n20_2 VSS VSS g45n1svt M=1 L=45n W=145n
MNM7 Db_2 CKb n20_2 VSS g45n1svt M=1 L=45n W=145n
MNM1 Db_2 D2 VSS VSS g45n1svt M=1 L=45n W=145n
MNM21 Db_3 D3 VSS VSS g45n1svt M=1 L=45n W=145n
Mmn36 n5 mout VSS VSS g45n1svt M=1 L=45n W=145n
Mmn37 n20 Ckbb n5 VSS g45n1svt M=1 L=45n W=145n
Mmn11 Db D1 VSS VSS g45n1svt M=1 L=45n W=145n
Mmn57 Q1N qint VSS VSS g45n1svt M=1 L=45n W=260n
Mmn55 Q1 qbint VSS VSS g45n1svt M=1 L=45n W=260n
Mmn46 qbint n30 VSS VSS g45n1svt M=1 L=45n W=145n
Mmn51 n30 CKb n11 VSS g45n1svt M=1 L=45n W=145n
Mmn50 n11 qbint VSS VSS g45n1svt M=1 L=45n W=145n
Mmn20 CKb CK VSS VSS g45n1svt M=1 L=45n W=145n
Mmn56 qint qbint VSS VSS g45n1svt M=1 L=45n W=145n
Mmn40 mout Ckbb n30 VSS g45n1svt M=1 L=45n W=145n
Mmn30 mout n20 VSS VSS g45n1svt M=1 L=45n W=145n
Mmn21 Ckbb CKb VSS VSS g45n1svt M=1 L=45n W=145n
Mmn25 Db CKb n20 VSS g45n1svt M=1 L=45n W=145n
MPM54 Db_4 D4 VDD VDD g45p1svt M=1 L=45n W=215n
MPM50 n20_4 Ckbb Db_4 VDD g45p1svt M=1 L=45n W=215n
MPM49 mout_4 n20_4 VDD VDD g45p1svt M=1 L=45n W=215n
MPM47 n20_4 CKb n6_4 VDD g45p1svt M=1 L=45n W=215n
MPM46 n6_4 mout_4 VDD VDD g45p1svt M=1 L=45n W=215n
MPM45 n30_4 CKb mout_4 VDD g45p1svt M=1 L=45n W=215n
MPM43 qbint_4 n30_4 VDD VDD g45p1svt M=1 L=45n W=215n
MPM42 n8_4 qbint_4 VDD VDD g45p1svt M=1 L=45n W=215n
MPM41 n30_4 Ckbb n8_4 VDD g45p1svt M=1 L=45n W=215n
MPM40 Q4 qbint_4 VDD VDD g45p1svt M=1 L=45n W=390n
MPM39 qint_4 qbint_4 VDD VDD g45p1svt M=1 L=45n W=215n
MPM38 Q4N qint_4 VDD VDD g45p1svt M=1 L=45n W=390n
MPM37 Q3N qint_3 VDD VDD g45p1svt M=1 L=45n W=390n
MPM36 qint_3 qbint_3 VDD VDD g45p1svt M=1 L=45n W=215n
MPM35 Q3 qbint_3 VDD VDD g45p1svt M=1 L=45n W=390n
MPM34 n30_3 Ckbb n8_3 VDD g45p1svt M=1 L=45n W=215n
MPM33 n8_3 qbint_3 VDD VDD g45p1svt M=1 L=45n W=215n
MPM32 qbint_3 n30_3 VDD VDD g45p1svt M=1 L=45n W=215n
MPM30 n30_3 CKb mout_3 VDD g45p1svt M=1 L=45n W=215n
MPM29 n6_3 mout_3 VDD VDD g45p1svt M=1 L=45n W=215n
MPM28 n20_3 CKb n6_3 VDD g45p1svt M=1 L=45n W=215n
MPM26 mout_3 n20_3 VDD VDD g45p1svt M=1 L=45n W=215n
MPM25 n20_3 Ckbb Db_3 VDD g45p1svt M=1 L=45n W=215n
MPM19 Q2N qint_2 VDD VDD g45p1svt M=1 L=45n W=390n
MPM18 qint_2 qbint_2 VDD VDD g45p1svt M=1 L=45n W=215n
MPM17 Q2 qbint_2 VDD VDD g45p1svt M=1 L=45n W=390n
MPM16 n30_2 Ckbb n8_2 VDD g45p1svt M=1 L=45n W=215n
MPM15 n8_2 qbint_2 VDD VDD g45p1svt M=1 L=45n W=215n
MPM14 qbint_2 n30_2 VDD VDD g45p1svt M=1 L=45n W=215n
MPM12 n30_2 CKb mout_2 VDD g45p1svt M=1 L=45n W=215n
MPM11 n6_2 mout_2 VDD VDD g45p1svt M=1 L=45n W=215n
MPM10 n20_2 CKb n6_2 VDD g45p1svt M=1 L=45n W=215n
MPM8 mout_2 n20_2 VDD VDD g45p1svt M=1 L=45n W=215n
MPM7 n20_2 Ckbb Db_2 VDD g45p1svt M=1 L=45n W=215n
MPM1 Db_2 D2 VDD VDD g45p1svt M=1 L=45n W=215n
MPM21 Db_3 D3 VDD VDD g45p1svt M=1 L=45n W=215n
Mmp11 Db D1 VDD VDD g45p1svt M=1 L=45n W=215n
Mmp51 n30 Ckbb n8 VDD g45p1svt M=1 L=45n W=215n
Mmp50 n8 qbint VDD VDD g45p1svt M=1 L=45n W=215n
Mmp55 Q1 qbint VDD VDD g45p1svt M=1 L=45n W=390n
Mmp20 CKb CK VDD VDD g45p1svt M=1 L=45n W=215n
Mmp46 qbint n30 VDD VDD g45p1svt M=1 L=45n W=215n
Mmp56 qint qbint VDD VDD g45p1svt M=1 L=45n W=215n
Mmp36 n6 mout VDD VDD g45p1svt M=1 L=45n W=215n
Mmp37 n20 CKb n6 VDD g45p1svt M=1 L=45n W=215n
Mmp40 n30 CKb mout VDD g45p1svt M=1 L=45n W=215n
Mmp30 mout n20 VDD VDD g45p1svt M=1 L=45n W=215n
Mmp21 Ckbb CKb VDD VDD g45p1svt M=1 L=45n W=215n
Mmp25 n20 Ckbb Db VDD g45p1svt M=1 L=45n W=215n
Mmp57 Q1N qint VDD VDD g45p1svt M=1 L=45n W=390n
.ENDS

.SUBCKT DFF4RX2 CK D1 D2 D3 D4 Q1 Q1N Q2 Q2N Q3 Q3N Q4 Q4N RN VDD VSS
MNM54 Db_4 D4 VSS VSS g45n1svt M=1 L=45n W=145n
MNM50 Db_4 CKb n20_4 VSS g45n1svt M=1 L=45n W=145n
MNM49 mout_4 n20_4 VSS VSS g45n1svt M=1 L=45n W=145n
MNM48 n20_4 Ckbb n5_4 VSS g45n1svt M=1 L=45n W=145n
MNM47 n7_4 RN VSS VSS g45n1svt M=1 L=45n W=145n
MNM46 n5_4 mout_4 n7_4 VSS g45n1svt M=1 L=45n W=145n
MNM45 mout_4 Ckbb n30_4 VSS g45n1svt M=1 L=45n W=145n
MNM44 qbint_4 n30_4 n9_4 VSS g45n1svt M=1 L=45n W=205n
MNM43 n9_4 RN VSS VSS g45n1svt M=1 L=45n W=205n
MNM42 n11_4 qbint_4 VSS VSS g45n1svt M=1 L=45n W=145n
MNM41 n30_4 CKb n11_4 VSS g45n1svt M=1 L=45n W=145n
MNM40 Q4 qbint_4 VSS VSS g45n1svt M=1 L=45n W=520n
MNM39 qint_4 qbint_4 VSS VSS g45n1svt M=1 L=45n W=145n
MNM38 Q4N qint_4 VSS VSS g45n1svt M=1 L=45n W=520n
MNM37 Q3N qint_3 VSS VSS g45n1svt M=1 L=45n W=520n
MNM36 qint_3 qbint_3 VSS VSS g45n1svt M=1 L=45n W=145n
MNM35 Q3 qbint_3 VSS VSS g45n1svt M=1 L=45n W=520n
MNM34 n30_3 CKb n11_3 VSS g45n1svt M=1 L=45n W=145n
MNM33 n11_3 qbint_3 VSS VSS g45n1svt M=1 L=45n W=145n
MNM32 n9_3 RN VSS VSS g45n1svt M=1 L=45n W=205n
MNM31 qbint_3 n30_3 n9_3 VSS g45n1svt M=1 L=45n W=205n
MNM30 mout_3 Ckbb n30_3 VSS g45n1svt M=1 L=45n W=145n
MNM29 n5_3 mout_3 n7_3 VSS g45n1svt M=1 L=45n W=145n
MNM28 n7_3 RN VSS VSS g45n1svt M=1 L=45n W=145n
MNM27 n20_3 Ckbb n5_3 VSS g45n1svt M=1 L=45n W=145n
MNM26 mout_3 n20_3 VSS VSS g45n1svt M=1 L=45n W=145n
MNM25 Db_3 CKb n20_3 VSS g45n1svt M=1 L=45n W=145n
MNM19 Q2N qint_2 VSS VSS g45n1svt M=1 L=45n W=520n
MNM18 qint_2 qbint_2 VSS VSS g45n1svt M=1 L=45n W=145n
MNM17 Q2 qbint_2 VSS VSS g45n1svt M=1 L=45n W=520n
MNM16 n30_2 CKb n11_2 VSS g45n1svt M=1 L=45n W=145n
MNM15 n11_2 qbint_2 VSS VSS g45n1svt M=1 L=45n W=145n
MNM14 n9_2 RN VSS VSS g45n1svt M=1 L=45n W=205n
MNM13 qbint_2 n30_2 n9_2 VSS g45n1svt M=1 L=45n W=205n
MNM12 mout_2 Ckbb n30_2 VSS g45n1svt M=1 L=45n W=145n
MNM11 n5_2 mout_2 n7_2 VSS g45n1svt M=1 L=45n W=145n
MNM10 n7_2 RN VSS VSS g45n1svt M=1 L=45n W=145n
MNM9 n20_2 Ckbb n5_2 VSS g45n1svt M=1 L=45n W=145n
MNM8 mout_2 n20_2 VSS VSS g45n1svt M=1 L=45n W=145n
MNM7 Db_2 CKb n20_2 VSS g45n1svt M=1 L=45n W=145n
MNM1 Db_2 D2 VSS VSS g45n1svt M=1 L=45n W=145n
MNM21 Db_3 D3 VSS VSS g45n1svt M=1 L=45n W=145n
Mmn36 n5 mout n7 VSS g45n1svt M=1 L=45n W=145n
Mmn35 n7 RN VSS VSS g45n1svt M=1 L=45n W=145n
Mmn37 n20 Ckbb n5 VSS g45n1svt M=1 L=45n W=145n
Mmn11 Db D1 VSS VSS g45n1svt M=1 L=45n W=145n
Mmn57 Q1N qint VSS VSS g45n1svt M=1 L=45n W=520n
Mmn55 Q1 qbint VSS VSS g45n1svt M=1 L=45n W=520n
Mmn45 n9 RN VSS VSS g45n1svt M=1 L=45n W=205n
Mmn46 qbint n30 n9 VSS g45n1svt M=1 L=45n W=205n
Mmn51 n30 CKb n11 VSS g45n1svt M=1 L=45n W=145n
Mmn50 n11 qbint VSS VSS g45n1svt M=1 L=45n W=145n
Mmn20 CKb CK VSS VSS g45n1svt M=1 L=45n W=145n
Mmn56 qint qbint VSS VSS g45n1svt M=1 L=45n W=145n
Mmn40 mout Ckbb n30 VSS g45n1svt M=1 L=45n W=145n
Mmn30 mout n20 VSS VSS g45n1svt M=1 L=45n W=145n
Mmn21 Ckbb CKb VSS VSS g45n1svt M=1 L=45n W=145n
Mmn25 Db CKb n20 VSS g45n1svt M=1 L=45n W=145n
MPM54 Db_4 D4 VDD VDD g45p1svt M=1 L=45n W=215n
MPM50 n20_4 Ckbb Db_4 VDD g45p1svt M=1 L=45n W=215n
MPM49 mout_4 n20_4 VDD VDD g45p1svt M=1 L=45n W=215n
MPM48 n6_4 RN VDD VDD g45p1svt M=1 L=45n W=215n
MPM47 n20_4 CKb n6_4 VDD g45p1svt M=1 L=45n W=215n
MPM46 n6_4 mout_4 VDD VDD g45p1svt M=1 L=45n W=215n
MPM45 n30_4 CKb mout_4 VDD g45p1svt M=1 L=45n W=215n
MPM44 qbint_4 RN VDD VDD g45p1svt M=1 L=45n W=310n
MPM43 qbint_4 n30_4 VDD VDD g45p1svt M=1 L=45n W=310n
MPM42 n8_4 qbint_4 VDD VDD g45p1svt M=1 L=45n W=215n
MPM41 n30_4 Ckbb n8_4 VDD g45p1svt M=1 L=45n W=215n
MPM40 Q4 qbint_4 VDD VDD g45p1svt M=1 L=45n W=780n
MPM39 qint_4 qbint_4 VDD VDD g45p1svt M=1 L=45n W=215n
MPM38 Q4N qint_4 VDD VDD g45p1svt M=1 L=45n W=780n
MPM37 Q3N qint_3 VDD VDD g45p1svt M=1 L=45n W=780n
MPM36 qint_3 qbint_3 VDD VDD g45p1svt M=1 L=45n W=215n
MPM35 Q3 qbint_3 VDD VDD g45p1svt M=1 L=45n W=780n
MPM34 n30_3 Ckbb n8_3 VDD g45p1svt M=1 L=45n W=215n
MPM33 n8_3 qbint_3 VDD VDD g45p1svt M=1 L=45n W=215n
MPM32 qbint_3 n30_3 VDD VDD g45p1svt M=1 L=45n W=310n
MPM31 qbint_3 RN VDD VDD g45p1svt M=1 L=45n W=310n
MPM30 n30_3 CKb mout_3 VDD g45p1svt M=1 L=45n W=215n
MPM29 n6_3 mout_3 VDD VDD g45p1svt M=1 L=45n W=215n
MPM28 n20_3 CKb n6_3 VDD g45p1svt M=1 L=45n W=215n
MPM27 n6_3 RN VDD VDD g45p1svt M=1 L=45n W=215n
MPM26 mout_3 n20_3 VDD VDD g45p1svt M=1 L=45n W=215n
MPM25 n20_3 Ckbb Db_3 VDD g45p1svt M=1 L=45n W=215n
MPM19 Q2N qint_2 VDD VDD g45p1svt M=1 L=45n W=780n
MPM18 qint_2 qbint_2 VDD VDD g45p1svt M=1 L=45n W=215n
MPM17 Q2 qbint_2 VDD VDD g45p1svt M=1 L=45n W=780n
MPM16 n30_2 Ckbb n8_2 VDD g45p1svt M=1 L=45n W=215n
MPM15 n8_2 qbint_2 VDD VDD g45p1svt M=1 L=45n W=215n
MPM14 qbint_2 n30_2 VDD VDD g45p1svt M=1 L=45n W=310n
MPM13 qbint_2 RN VDD VDD g45p1svt M=1 L=45n W=310n
MPM12 n30_2 CKb mout_2 VDD g45p1svt M=1 L=45n W=215n
MPM11 n6_2 mout_2 VDD VDD g45p1svt M=1 L=45n W=215n
MPM10 n20_2 CKb n6_2 VDD g45p1svt M=1 L=45n W=215n
MPM9 n6_2 RN VDD VDD g45p1svt M=1 L=45n W=215n
MPM8 mout_2 n20_2 VDD VDD g45p1svt M=1 L=45n W=215n
MPM7 n20_2 Ckbb Db_2 VDD g45p1svt M=1 L=45n W=215n
MPM21 Db_3 D3 VDD VDD g45p1svt M=1 L=45n W=215n
MPM1 Db_2 D2 VDD VDD g45p1svt M=1 L=45n W=215n
Mmp11 Db D1 VDD VDD g45p1svt M=1 L=45n W=215n
Mmp51 n30 Ckbb n8 VDD g45p1svt M=1 L=45n W=215n
Mmp50 n8 qbint VDD VDD g45p1svt M=1 L=45n W=215n
Mmp55 Q1 qbint VDD VDD g45p1svt M=1 L=45n W=780n
Mmp20 CKb CK VDD VDD g45p1svt M=1 L=45n W=215n
Mmp46 qbint n30 VDD VDD g45p1svt M=1 L=45n W=310n
Mmp56 qint qbint VDD VDD g45p1svt M=1 L=45n W=215n
Mmp45 qbint RN VDD VDD g45p1svt M=1 L=45n W=310n
Mmp35 n6 RN VDD VDD g45p1svt M=1 L=45n W=215n
Mmp36 n6 mout VDD VDD g45p1svt M=1 L=45n W=215n
Mmp37 n20 CKb n6 VDD g45p1svt M=1 L=45n W=215n
Mmp40 n30 CKb mout VDD g45p1svt M=1 L=45n W=215n
Mmp30 mout n20 VDD VDD g45p1svt M=1 L=45n W=215n
Mmp21 Ckbb CKb VDD VDD g45p1svt M=1 L=45n W=215n
Mmp25 n20 Ckbb Db VDD g45p1svt M=1 L=45n W=215n
Mmp57 Q1N qint VDD VDD g45p1svt M=1 L=45n W=780n
.ENDS

.SUBCKT DFF4RX1 CK D1 D2 D3 D4 Q1 Q1N Q2 Q2N Q3 Q3N Q4 Q4N RN VDD VSS
MNM54 Db_4 D4 VSS VSS g45n1svt M=1 L=45n W=145n
MNM50 Db_4 CKb n20_4 VSS g45n1svt M=1 L=45n W=145n
MNM49 mout_4 n20_4 VSS VSS g45n1svt M=1 L=45n W=145n
MNM48 n20_4 Ckbb n5_4 VSS g45n1svt M=1 L=45n W=145n
MNM47 n7_4 RN VSS VSS g45n1svt M=1 L=45n W=145n
MNM46 n5_4 mout_4 n7_4 VSS g45n1svt M=1 L=45n W=145n
MNM45 mout_4 Ckbb n30_4 VSS g45n1svt M=1 L=45n W=145n
MNM44 qbint_4 n30_4 n9_4 VSS g45n1svt M=1 L=45n W=145n
MNM43 n9_4 RN VSS VSS g45n1svt M=1 L=45n W=145n
MNM42 n11_4 qbint_4 VSS VSS g45n1svt M=1 L=45n W=145n
MNM41 n30_4 CKb n11_4 VSS g45n1svt M=1 L=45n W=145n
MNM40 Q4 qbint_4 VSS VSS g45n1svt M=1 L=45n W=260n
MNM39 qint_4 qbint_4 VSS VSS g45n1svt M=1 L=45n W=145n
MNM38 Q4N qint_4 VSS VSS g45n1svt M=1 L=45n W=260n
MNM37 Q3N qint_3 VSS VSS g45n1svt M=1 L=45n W=260n
MNM36 qint_3 qbint_3 VSS VSS g45n1svt M=1 L=45n W=145n
MNM35 Q3 qbint_3 VSS VSS g45n1svt M=1 L=45n W=260n
MNM34 n30_3 CKb n11_3 VSS g45n1svt M=1 L=45n W=145n
MNM33 n11_3 qbint_3 VSS VSS g45n1svt M=1 L=45n W=145n
MNM32 n9_3 RN VSS VSS g45n1svt M=1 L=45n W=145n
MNM31 qbint_3 n30_3 n9_3 VSS g45n1svt M=1 L=45n W=145n
MNM30 mout_3 Ckbb n30_3 VSS g45n1svt M=1 L=45n W=145n
MNM29 n5_3 mout_3 n7_3 VSS g45n1svt M=1 L=45n W=145n
MNM28 n7_3 RN VSS VSS g45n1svt M=1 L=45n W=145n
MNM27 n20_3 Ckbb n5_3 VSS g45n1svt M=1 L=45n W=145n
MNM26 mout_3 n20_3 VSS VSS g45n1svt M=1 L=45n W=145n
MNM25 Db_3 CKb n20_3 VSS g45n1svt M=1 L=45n W=145n
MNM19 Q2N qint_2 VSS VSS g45n1svt M=1 L=45n W=260n
MNM18 qint_2 qbint_2 VSS VSS g45n1svt M=1 L=45n W=145n
MNM17 Q2 qbint_2 VSS VSS g45n1svt M=1 L=45n W=260n
MNM16 n30_2 CKb n11_2 VSS g45n1svt M=1 L=45n W=145n
MNM15 n11_2 qbint_2 VSS VSS g45n1svt M=1 L=45n W=145n
MNM14 n9_2 RN VSS VSS g45n1svt M=1 L=45n W=145n
MNM13 qbint_2 n30_2 n9_2 VSS g45n1svt M=1 L=45n W=145n
MNM12 mout_2 Ckbb n30_2 VSS g45n1svt M=1 L=45n W=145n
MNM11 n5_2 mout_2 n7_2 VSS g45n1svt M=1 L=45n W=145n
MNM10 n7_2 RN VSS VSS g45n1svt M=1 L=45n W=145n
MNM9 n20_2 Ckbb n5_2 VSS g45n1svt M=1 L=45n W=145n
MNM8 mout_2 n20_2 VSS VSS g45n1svt M=1 L=45n W=145n
MNM7 Db_2 CKb n20_2 VSS g45n1svt M=1 L=45n W=145n
MNM1 Db_2 D2 VSS VSS g45n1svt M=1 L=45n W=145n
MNM21 Db_3 D3 VSS VSS g45n1svt M=1 L=45n W=145n
Mmn36 n5 mout n7 VSS g45n1svt M=1 L=45n W=145n
Mmn35 n7 RN VSS VSS g45n1svt M=1 L=45n W=145n
Mmn37 n20 Ckbb n5 VSS g45n1svt M=1 L=45n W=145n
Mmn11 Db D1 VSS VSS g45n1svt M=1 L=45n W=145n
Mmn57 Q1N qint VSS VSS g45n1svt M=1 L=45n W=260n
Mmn55 Q1 qbint VSS VSS g45n1svt M=1 L=45n W=260n
Mmn45 n9 RN VSS VSS g45n1svt M=1 L=45n W=145n
Mmn46 qbint n30 n9 VSS g45n1svt M=1 L=45n W=145n
Mmn51 n30 CKb n11 VSS g45n1svt M=1 L=45n W=145n
Mmn50 n11 qbint VSS VSS g45n1svt M=1 L=45n W=145n
Mmn20 CKb CK VSS VSS g45n1svt M=1 L=45n W=145n
Mmn56 qint qbint VSS VSS g45n1svt M=1 L=45n W=145n
Mmn40 mout Ckbb n30 VSS g45n1svt M=1 L=45n W=145n
Mmn30 mout n20 VSS VSS g45n1svt M=1 L=45n W=145n
Mmn21 Ckbb CKb VSS VSS g45n1svt M=1 L=45n W=145n
Mmn25 Db CKb n20 VSS g45n1svt M=1 L=45n W=145n
MPM54 Db_4 D4 VDD VDD g45p1svt M=1 L=45n W=215n
MPM50 n20_4 Ckbb Db_4 VDD g45p1svt M=1 L=45n W=215n
MPM49 mout_4 n20_4 VDD VDD g45p1svt M=1 L=45n W=215n
MPM48 n6_4 RN VDD VDD g45p1svt M=1 L=45n W=215n
MPM47 n20_4 CKb n6_4 VDD g45p1svt M=1 L=45n W=215n
MPM46 n6_4 mout_4 VDD VDD g45p1svt M=1 L=45n W=215n
MPM45 n30_4 CKb mout_4 VDD g45p1svt M=1 L=45n W=215n
MPM44 qbint_4 RN VDD VDD g45p1svt M=1 L=45n W=215n
MPM43 qbint_4 n30_4 VDD VDD g45p1svt M=1 L=45n W=215n
MPM42 n8_4 qbint_4 VDD VDD g45p1svt M=1 L=45n W=215n
MPM41 n30_4 Ckbb n8_4 VDD g45p1svt M=1 L=45n W=215n
MPM40 Q4 qbint_4 VDD VDD g45p1svt M=1 L=45n W=390n
MPM39 qint_4 qbint_4 VDD VDD g45p1svt M=1 L=45n W=215n
MPM38 Q4N qint_4 VDD VDD g45p1svt M=1 L=45n W=390n
MPM37 Q3N qint_3 VDD VDD g45p1svt M=1 L=45n W=390n
MPM36 qint_3 qbint_3 VDD VDD g45p1svt M=1 L=45n W=215n
MPM35 Q3 qbint_3 VDD VDD g45p1svt M=1 L=45n W=390n
MPM34 n30_3 Ckbb n8_3 VDD g45p1svt M=1 L=45n W=215n
MPM33 n8_3 qbint_3 VDD VDD g45p1svt M=1 L=45n W=215n
MPM32 qbint_3 n30_3 VDD VDD g45p1svt M=1 L=45n W=215n
MPM31 qbint_3 RN VDD VDD g45p1svt M=1 L=45n W=215n
MPM30 n30_3 CKb mout_3 VDD g45p1svt M=1 L=45n W=215n
MPM29 n6_3 mout_3 VDD VDD g45p1svt M=1 L=45n W=215n
MPM28 n20_3 CKb n6_3 VDD g45p1svt M=1 L=45n W=215n
MPM27 n6_3 RN VDD VDD g45p1svt M=1 L=45n W=215n
MPM26 mout_3 n20_3 VDD VDD g45p1svt M=1 L=45n W=215n
MPM25 n20_3 Ckbb Db_3 VDD g45p1svt M=1 L=45n W=215n
MPM19 Q2N qint_2 VDD VDD g45p1svt M=1 L=45n W=390n
MPM18 qint_2 qbint_2 VDD VDD g45p1svt M=1 L=45n W=215n
MPM17 Q2 qbint_2 VDD VDD g45p1svt M=1 L=45n W=390n
MPM16 n30_2 Ckbb n8_2 VDD g45p1svt M=1 L=45n W=215n
MPM15 n8_2 qbint_2 VDD VDD g45p1svt M=1 L=45n W=215n
MPM14 qbint_2 n30_2 VDD VDD g45p1svt M=1 L=45n W=215n
MPM13 qbint_2 RN VDD VDD g45p1svt M=1 L=45n W=215n
MPM12 n30_2 CKb mout_2 VDD g45p1svt M=1 L=45n W=215n
MPM11 n6_2 mout_2 VDD VDD g45p1svt M=1 L=45n W=215n
MPM10 n20_2 CKb n6_2 VDD g45p1svt M=1 L=45n W=215n
MPM9 n6_2 RN VDD VDD g45p1svt M=1 L=45n W=215n
MPM8 mout_2 n20_2 VDD VDD g45p1svt M=1 L=45n W=215n
MPM7 n20_2 Ckbb Db_2 VDD g45p1svt M=1 L=45n W=215n
MPM1 Db_2 D2 VDD VDD g45p1svt M=1 L=45n W=215n
MPM21 Db_3 D3 VDD VDD g45p1svt M=1 L=45n W=215n
Mmp11 Db D1 VDD VDD g45p1svt M=1 L=45n W=215n
Mmp51 n30 Ckbb n8 VDD g45p1svt M=1 L=45n W=215n
Mmp50 n8 qbint VDD VDD g45p1svt M=1 L=45n W=215n
Mmp55 Q1 qbint VDD VDD g45p1svt M=1 L=45n W=390n
Mmp20 CKb CK VDD VDD g45p1svt M=1 L=45n W=215n
Mmp46 qbint n30 VDD VDD g45p1svt M=1 L=45n W=215n
Mmp56 qint qbint VDD VDD g45p1svt M=1 L=45n W=215n
Mmp45 qbint RN VDD VDD g45p1svt M=1 L=45n W=215n
Mmp35 n6 RN VDD VDD g45p1svt M=1 L=45n W=215n
Mmp36 n6 mout VDD VDD g45p1svt M=1 L=45n W=215n
Mmp37 n20 CKb n6 VDD g45p1svt M=1 L=45n W=215n
Mmp40 n30 CKb mout VDD g45p1svt M=1 L=45n W=215n
Mmp30 mout n20 VDD VDD g45p1svt M=1 L=45n W=215n
Mmp21 Ckbb CKb VDD VDD g45p1svt M=1 L=45n W=215n
Mmp25 n20 Ckbb Db VDD g45p1svt M=1 L=45n W=215n
Mmp57 Q1N qint VDD VDD g45p1svt M=1 L=45n W=390n
.ENDS

.SUBCKT DFF2X2 CK D1 D2 Q1 Q1N Q2 Q2N VDD VSS
MNM19 Q2N qint_2 VSS VSS g45n1svt M=1 L=45n W=520n
MNM18 qint_2 qbint_2 VSS VSS g45n1svt M=1 L=45n W=145n
MNM17 Q2 qbint_2 VSS VSS g45n1svt M=1 L=45n W=520n
MNM16 n30_2 CKb n11_2 VSS g45n1svt M=1 L=45n W=145n
MNM15 n11_2 qbint_2 VSS VSS g45n1svt M=1 L=45n W=145n
MNM13 qbint_2 n30_2 VSS VSS g45n1svt M=1 L=45n W=205n
MNM12 mout_2 Ckbb n30_2 VSS g45n1svt M=1 L=45n W=145n
MNM11 n5_2 mout_2 VSS VSS g45n1svt M=1 L=45n W=145n
MNM9 n20_2 Ckbb n5_2 VSS g45n1svt M=1 L=45n W=145n
MNM8 mout_2 n20_2 VSS VSS g45n1svt M=1 L=45n W=145n
MNM7 Db_2 CKb n20_2 VSS g45n1svt M=1 L=45n W=145n
MNM1 Db_2 D2 VSS VSS g45n1svt M=1 L=45n W=145n
Mmn36 n5 mout VSS VSS g45n1svt M=1 L=45n W=145n
Mmn37 n20 Ckbb n5 VSS g45n1svt M=1 L=45n W=145n
Mmn11 Db D1 VSS VSS g45n1svt M=1 L=45n W=145n
Mmn57 Q1N qint VSS VSS g45n1svt M=1 L=45n W=520n
Mmn55 Q1 qbint VSS VSS g45n1svt M=1 L=45n W=520n
Mmn46 qbint n30 VSS VSS g45n1svt M=1 L=45n W=205n
Mmn51 n30 CKb n11 VSS g45n1svt M=1 L=45n W=145n
Mmn50 n11 qbint VSS VSS g45n1svt M=1 L=45n W=145n
Mmn20 CKb CK VSS VSS g45n1svt M=1 L=45n W=145n
Mmn56 qint qbint VSS VSS g45n1svt M=1 L=45n W=145n
Mmn40 mout Ckbb n30 VSS g45n1svt M=1 L=45n W=145n
Mmn30 mout n20 VSS VSS g45n1svt M=1 L=45n W=145n
Mmn21 Ckbb CKb VSS VSS g45n1svt M=1 L=45n W=145n
Mmn25 Db CKb n20 VSS g45n1svt M=1 L=45n W=145n
MPM19 Q2N qint_2 VDD VDD g45p1svt M=1 L=45n W=780n
MPM18 qint_2 qbint_2 VDD VDD g45p1svt M=1 L=45n W=215n
MPM17 Q2 qbint_2 VDD VDD g45p1svt M=1 L=45n W=780n
MPM16 n30_2 Ckbb n8_2 VDD g45p1svt M=1 L=45n W=215n
MPM15 n8_2 qbint_2 VDD VDD g45p1svt M=1 L=45n W=215n
MPM14 qbint_2 n30_2 VDD VDD g45p1svt M=1 L=45n W=310n
MPM12 n30_2 CKb mout_2 VDD g45p1svt M=1 L=45n W=215n
MPM11 n6_2 mout_2 VDD VDD g45p1svt M=1 L=45n W=215n
MPM10 n20_2 CKb n6_2 VDD g45p1svt M=1 L=45n W=215n
MPM8 mout_2 n20_2 VDD VDD g45p1svt M=1 L=45n W=215n
MPM7 n20_2 Ckbb Db_2 VDD g45p1svt M=1 L=45n W=215n
MPM1 Db_2 D2 VDD VDD g45p1svt M=1 L=45n W=215n
Mmp11 Db D1 VDD VDD g45p1svt M=1 L=45n W=215n
Mmp51 n30 Ckbb n8 VDD g45p1svt M=1 L=45n W=215n
Mmp50 n8 qbint VDD VDD g45p1svt M=1 L=45n W=215n
Mmp55 Q1 qbint VDD VDD g45p1svt M=1 L=45n W=780n
Mmp20 CKb CK VDD VDD g45p1svt M=1 L=45n W=215n
Mmp46 qbint n30 VDD VDD g45p1svt M=1 L=45n W=310n
Mmp56 qint qbint VDD VDD g45p1svt M=1 L=45n W=215n
Mmp36 n6 mout VDD VDD g45p1svt M=1 L=45n W=215n
Mmp37 n20 CKb n6 VDD g45p1svt M=1 L=45n W=215n
Mmp40 n30 CKb mout VDD g45p1svt M=1 L=45n W=215n
Mmp30 mout n20 VDD VDD g45p1svt M=1 L=45n W=215n
Mmp21 Ckbb CKb VDD VDD g45p1svt M=1 L=45n W=215n
Mmp25 n20 Ckbb Db VDD g45p1svt M=1 L=45n W=215n
Mmp57 Q1N qint VDD VDD g45p1svt M=1 L=45n W=780n
.ENDS

.SUBCKT DFF2X1 CK D1 D2 Q1 Q1N Q2 Q2N VDD VSS
MNM19 Q2N qint_2 VSS VSS g45n1svt M=1 L=45n W=260n
MNM18 qint_2 qbint_2 VSS VSS g45n1svt M=1 L=45n W=145n
MNM17 Q2 qbint_2 VSS VSS g45n1svt M=1 L=45n W=260n
MNM16 n30_2 CKb n11_2 VSS g45n1svt M=1 L=45n W=145n
MNM15 n11_2 qbint_2 VSS VSS g45n1svt M=1 L=45n W=145n
MNM13 qbint_2 n30_2 VSS VSS g45n1svt M=1 L=45n W=145n
MNM12 mout_2 Ckbb n30_2 VSS g45n1svt M=1 L=45n W=145n
MNM11 n5_2 mout_2 VSS VSS g45n1svt M=1 L=45n W=145n
MNM9 n20_2 Ckbb n5_2 VSS g45n1svt M=1 L=45n W=145n
MNM8 mout_2 n20_2 VSS VSS g45n1svt M=1 L=45n W=145n
MNM7 Db_2 CKb n20_2 VSS g45n1svt M=1 L=45n W=145n
MNM1 Db_2 D2 VSS VSS g45n1svt M=1 L=45n W=145n
Mmn36 n5 mout VSS VSS g45n1svt M=1 L=45n W=145n
Mmn37 n20 Ckbb n5 VSS g45n1svt M=1 L=45n W=145n
Mmn11 Db D1 VSS VSS g45n1svt M=1 L=45n W=145n
Mmn57 Q1N qint VSS VSS g45n1svt M=1 L=45n W=260n
Mmn55 Q1 qbint VSS VSS g45n1svt M=1 L=45n W=260n
Mmn46 qbint n30 VSS VSS g45n1svt M=1 L=45n W=145n
Mmn51 n30 CKb n11 VSS g45n1svt M=1 L=45n W=145n
Mmn50 n11 qbint VSS VSS g45n1svt M=1 L=45n W=145n
Mmn20 CKb CK VSS VSS g45n1svt M=1 L=45n W=145n
Mmn56 qint qbint VSS VSS g45n1svt M=1 L=45n W=145n
Mmn40 mout Ckbb n30 VSS g45n1svt M=1 L=45n W=145n
Mmn30 mout n20 VSS VSS g45n1svt M=1 L=45n W=145n
Mmn21 Ckbb CKb VSS VSS g45n1svt M=1 L=45n W=145n
Mmn25 Db CKb n20 VSS g45n1svt M=1 L=45n W=145n
MPM19 Q2N qint_2 VDD VDD g45p1svt M=1 L=45n W=390n
MPM18 qint_2 qbint_2 VDD VDD g45p1svt M=1 L=45n W=215n
MPM17 Q2 qbint_2 VDD VDD g45p1svt M=1 L=45n W=390n
MPM16 n30_2 Ckbb n8_2 VDD g45p1svt M=1 L=45n W=215n
MPM15 n8_2 qbint_2 VDD VDD g45p1svt M=1 L=45n W=215n
MPM14 qbint_2 n30_2 VDD VDD g45p1svt M=1 L=45n W=215n
MPM12 n30_2 CKb mout_2 VDD g45p1svt M=1 L=45n W=215n
MPM11 n6_2 mout_2 VDD VDD g45p1svt M=1 L=45n W=215n
MPM10 n20_2 CKb n6_2 VDD g45p1svt M=1 L=45n W=215n
MPM8 mout_2 n20_2 VDD VDD g45p1svt M=1 L=45n W=215n
MPM7 n20_2 Ckbb Db_2 VDD g45p1svt M=1 L=45n W=215n
MPM1 Db_2 D2 VDD VDD g45p1svt M=1 L=45n W=215n
Mmp11 Db D1 VDD VDD g45p1svt M=1 L=45n W=215n
Mmp51 n30 Ckbb n8 VDD g45p1svt M=1 L=45n W=215n
Mmp50 n8 qbint VDD VDD g45p1svt M=1 L=45n W=215n
Mmp55 Q1 qbint VDD VDD g45p1svt M=1 L=45n W=390n
Mmp20 CKb CK VDD VDD g45p1svt M=1 L=45n W=215n
Mmp46 qbint n30 VDD VDD g45p1svt M=1 L=45n W=215n
Mmp56 qint qbint VDD VDD g45p1svt M=1 L=45n W=215n
Mmp36 n6 mout VDD VDD g45p1svt M=1 L=45n W=215n
Mmp37 n20 CKb n6 VDD g45p1svt M=1 L=45n W=215n
Mmp40 n30 CKb mout VDD g45p1svt M=1 L=45n W=215n
Mmp30 mout n20 VDD VDD g45p1svt M=1 L=45n W=215n
Mmp21 Ckbb CKb VDD VDD g45p1svt M=1 L=45n W=215n
Mmp25 n20 Ckbb Db VDD g45p1svt M=1 L=45n W=215n
Mmp57 Q1N qint VDD VDD g45p1svt M=1 L=45n W=390n
.ENDS

.SUBCKT DFF2RX2 CK D1 D2 Q1 Q1N Q2 Q2N RN VDD VSS
MNM19 Q2N qint_2 VSS VSS g45n1svt M=1 L=45n W=520n
MNM18 qint_2 qbint_2 VSS VSS g45n1svt M=1 L=45n W=145n
MNM17 Q2 qbint_2 VSS VSS g45n1svt M=1 L=45n W=520n
MNM16 n30_2 CKb n11_2 VSS g45n1svt M=1 L=45n W=145n
MNM15 n11_2 qbint_2 VSS VSS g45n1svt M=1 L=45n W=145n
MNM14 n9_2 RN VSS VSS g45n1svt M=1 L=45n W=205n
MNM13 qbint_2 n30_2 n9_2 VSS g45n1svt M=1 L=45n W=205n
MNM12 mout_2 Ckbb n30_2 VSS g45n1svt M=1 L=45n W=145n
MNM11 n5_2 mout_2 n7_2 VSS g45n1svt M=1 L=45n W=145n
MNM10 n7_2 RN VSS VSS g45n1svt M=1 L=45n W=145n
MNM9 n20_2 Ckbb n5_2 VSS g45n1svt M=1 L=45n W=145n
MNM8 mout_2 n20_2 VSS VSS g45n1svt M=1 L=45n W=145n
MNM7 Db_2 CKb n20_2 VSS g45n1svt M=1 L=45n W=145n
MNM1 Db_2 D2 VSS VSS g45n1svt M=1 L=45n W=145n
Mmn36 n5 mout n7 VSS g45n1svt M=1 L=45n W=145n
Mmn35 n7 RN VSS VSS g45n1svt M=1 L=45n W=145n
Mmn37 n20 Ckbb n5 VSS g45n1svt M=1 L=45n W=145n
Mmn11 Db D1 VSS VSS g45n1svt M=1 L=45n W=145n
Mmn57 Q1N qint VSS VSS g45n1svt M=1 L=45n W=520n
Mmn55 Q1 qbint VSS VSS g45n1svt M=1 L=45n W=520n
Mmn45 n9 RN VSS VSS g45n1svt M=1 L=45n W=205n
Mmn46 qbint n30 n9 VSS g45n1svt M=1 L=45n W=205n
Mmn51 n30 CKb n11 VSS g45n1svt M=1 L=45n W=145n
Mmn50 n11 qbint VSS VSS g45n1svt M=1 L=45n W=145n
Mmn20 CKb CK VSS VSS g45n1svt M=1 L=45n W=145n
Mmn56 qint qbint VSS VSS g45n1svt M=1 L=45n W=145n
Mmn40 mout Ckbb n30 VSS g45n1svt M=1 L=45n W=145n
Mmn30 mout n20 VSS VSS g45n1svt M=1 L=45n W=145n
Mmn21 Ckbb CKb VSS VSS g45n1svt M=1 L=45n W=145n
Mmn25 Db CKb n20 VSS g45n1svt M=1 L=45n W=145n
MPM19 Q2N qint_2 VDD VDD g45p1svt M=1 L=45n W=780n
MPM18 qint_2 qbint_2 VDD VDD g45p1svt M=1 L=45n W=215n
MPM17 Q2 qbint_2 VDD VDD g45p1svt M=1 L=45n W=780n
MPM16 n30_2 Ckbb n8_2 VDD g45p1svt M=1 L=45n W=215n
MPM15 n8_2 qbint_2 VDD VDD g45p1svt M=1 L=45n W=215n
MPM14 qbint_2 n30_2 VDD VDD g45p1svt M=1 L=45n W=310n
MPM13 qbint_2 RN VDD VDD g45p1svt M=1 L=45n W=310n
MPM12 n30_2 CKb mout_2 VDD g45p1svt M=1 L=45n W=215n
MPM11 n6_2 mout_2 VDD VDD g45p1svt M=1 L=45n W=215n
MPM10 n20_2 CKb n6_2 VDD g45p1svt M=1 L=45n W=215n
MPM9 n6_2 RN VDD VDD g45p1svt M=1 L=45n W=215n
MPM8 mout_2 n20_2 VDD VDD g45p1svt M=1 L=45n W=215n
MPM7 n20_2 Ckbb Db_2 VDD g45p1svt M=1 L=45n W=215n
MPM1 Db_2 D2 VDD VDD g45p1svt M=1 L=45n W=215n
Mmp11 Db D1 VDD VDD g45p1svt M=1 L=45n W=215n
Mmp51 n30 Ckbb n8 VDD g45p1svt M=1 L=45n W=215n
Mmp50 n8 qbint VDD VDD g45p1svt M=1 L=45n W=215n
Mmp55 Q1 qbint VDD VDD g45p1svt M=1 L=45n W=780n
Mmp20 CKb CK VDD VDD g45p1svt M=1 L=45n W=215n
Mmp46 qbint n30 VDD VDD g45p1svt M=1 L=45n W=310n
Mmp56 qint qbint VDD VDD g45p1svt M=1 L=45n W=215n
Mmp45 qbint RN VDD VDD g45p1svt M=1 L=45n W=310n
Mmp35 n6 RN VDD VDD g45p1svt M=1 L=45n W=215n
Mmp36 n6 mout VDD VDD g45p1svt M=1 L=45n W=215n
Mmp37 n20 CKb n6 VDD g45p1svt M=1 L=45n W=215n
Mmp40 n30 CKb mout VDD g45p1svt M=1 L=45n W=215n
Mmp30 mout n20 VDD VDD g45p1svt M=1 L=45n W=215n
Mmp21 Ckbb CKb VDD VDD g45p1svt M=1 L=45n W=215n
Mmp25 n20 Ckbb Db VDD g45p1svt M=1 L=45n W=215n
Mmp57 Q1N qint VDD VDD g45p1svt M=1 L=45n W=780n
.ENDS

.SUBCKT DFF2RX1 CK D1 D2 Q1 Q1N Q2 Q2N RN VDD VSS
MNM19 Q2N qint_2 VSS VSS g45n1svt M=1 L=45n W=260n
MNM18 qint_2 qbint_2 VSS VSS g45n1svt M=1 L=45n W=145n
MNM17 Q2 qbint_2 VSS VSS g45n1svt M=1 L=45n W=260n
MNM16 n30_2 CKb n11_2 VSS g45n1svt M=1 L=45n W=145n
MNM15 n11_2 qbint_2 VSS VSS g45n1svt M=1 L=45n W=145n
MNM14 n9_2 RN VSS VSS g45n1svt M=1 L=45n W=145n
MNM13 qbint_2 n30_2 n9_2 VSS g45n1svt M=1 L=45n W=145n
MNM12 mout_2 Ckbb n30_2 VSS g45n1svt M=1 L=45n W=145n
MNM11 n5_2 mout_2 n7_2 VSS g45n1svt M=1 L=45n W=145n
MNM10 n7_2 RN VSS VSS g45n1svt M=1 L=45n W=145n
MNM9 n20_2 Ckbb n5_2 VSS g45n1svt M=1 L=45n W=145n
MNM8 mout_2 n20_2 VSS VSS g45n1svt M=1 L=45n W=145n
MNM7 Db_2 CKb n20_2 VSS g45n1svt M=1 L=45n W=145n
MNM1 Db_2 D2 VSS VSS g45n1svt M=1 L=45n W=145n
Mmn36 n5 mout n7 VSS g45n1svt M=1 L=45n W=145n
Mmn35 n7 RN VSS VSS g45n1svt M=1 L=45n W=145n
Mmn37 n20 Ckbb n5 VSS g45n1svt M=1 L=45n W=145n
Mmn11 Db D1 VSS VSS g45n1svt M=1 L=45n W=145n
Mmn57 Q1N qint VSS VSS g45n1svt M=1 L=45n W=260n
Mmn55 Q1 qbint VSS VSS g45n1svt M=1 L=45n W=260n
Mmn45 n9 RN VSS VSS g45n1svt M=1 L=45n W=145n
Mmn46 qbint n30 n9 VSS g45n1svt M=1 L=45n W=145n
Mmn51 n30 CKb n11 VSS g45n1svt M=1 L=45n W=145n
Mmn50 n11 qbint VSS VSS g45n1svt M=1 L=45n W=145n
Mmn20 CKb CK VSS VSS g45n1svt M=1 L=45n W=145n
Mmn56 qint qbint VSS VSS g45n1svt M=1 L=45n W=145n
Mmn40 mout Ckbb n30 VSS g45n1svt M=1 L=45n W=145n
Mmn30 mout n20 VSS VSS g45n1svt M=1 L=45n W=145n
Mmn21 Ckbb CKb VSS VSS g45n1svt M=1 L=45n W=145n
Mmn25 Db CKb n20 VSS g45n1svt M=1 L=45n W=145n
MPM19 Q2N qint_2 VDD VDD g45p1svt M=1 L=45n W=390n
MPM18 qint_2 qbint_2 VDD VDD g45p1svt M=1 L=45n W=215n
MPM17 Q2 qbint_2 VDD VDD g45p1svt M=1 L=45n W=390n
MPM16 n30_2 Ckbb n8_2 VDD g45p1svt M=1 L=45n W=215n
MPM15 n8_2 qbint_2 VDD VDD g45p1svt M=1 L=45n W=215n
MPM14 qbint_2 n30_2 VDD VDD g45p1svt M=1 L=45n W=215n
MPM13 qbint_2 RN VDD VDD g45p1svt M=1 L=45n W=215n
MPM12 n30_2 CKb mout_2 VDD g45p1svt M=1 L=45n W=215n
MPM11 n6_2 mout_2 VDD VDD g45p1svt M=1 L=45n W=215n
MPM10 n20_2 CKb n6_2 VDD g45p1svt M=1 L=45n W=215n
MPM9 n6_2 RN VDD VDD g45p1svt M=1 L=45n W=215n
MPM8 mout_2 n20_2 VDD VDD g45p1svt M=1 L=45n W=215n
MPM7 n20_2 Ckbb Db_2 VDD g45p1svt M=1 L=45n W=215n
MPM1 Db_2 D2 VDD VDD g45p1svt M=1 L=45n W=215n
Mmp11 Db D1 VDD VDD g45p1svt M=1 L=45n W=215n
Mmp51 n30 Ckbb n8 VDD g45p1svt M=1 L=45n W=215n
Mmp50 n8 qbint VDD VDD g45p1svt M=1 L=45n W=215n
Mmp55 Q1 qbint VDD VDD g45p1svt M=1 L=45n W=390n
Mmp20 CKb CK VDD VDD g45p1svt M=1 L=45n W=215n
Mmp46 qbint n30 VDD VDD g45p1svt M=1 L=45n W=215n
Mmp56 qint qbint VDD VDD g45p1svt M=1 L=45n W=215n
Mmp45 qbint RN VDD VDD g45p1svt M=1 L=45n W=215n
Mmp35 n6 RN VDD VDD g45p1svt M=1 L=45n W=215n
Mmp36 n6 mout VDD VDD g45p1svt M=1 L=45n W=215n
Mmp37 n20 CKb n6 VDD g45p1svt M=1 L=45n W=215n
Mmp40 n30 CKb mout VDD g45p1svt M=1 L=45n W=215n
Mmp30 mout n20 VDD VDD g45p1svt M=1 L=45n W=215n
Mmp21 Ckbb CKb VDD VDD g45p1svt M=1 L=45n W=215n
Mmp25 n20 Ckbb Db VDD g45p1svt M=1 L=45n W=215n
Mmp57 Q1N qint VDD VDD g45p1svt M=1 L=45n W=390n
.ENDS

.SUBCKT DECAP10 VDD VSS
Mmp0 VDD VSS VDD VDD g45p1svt M=1 L=1.64u W=550n
Mmn0 VSS VDD VSS VSS g45n1svt M=1 L=1.64u W=400n
.ENDS

.SUBCKT DECAP9 VDD VSS
Mmp0 VDD VSS VDD VDD g45p1svt M=1 L=1.44u W=550n
Mmn0 VSS VDD VSS VSS g45n1svt M=1 L=1.44u W=400n
.ENDS

.SUBCKT DECAP8 VDD VSS
Mmp0 VDD VSS VDD VDD g45p1svt M=1 L=1.24u W=550n
Mmn0 VSS VDD VSS VSS g45n1svt M=1 L=1.24u W=400n
.ENDS

.SUBCKT DECAP7 VDD VSS
Mmp0 VDD VSS VDD VDD g45p1svt M=1 L=1.04u W=550n
Mmn0 VSS VDD VSS VSS g45n1svt M=1 L=1.04u W=400n
.ENDS

.SUBCKT DECAP6 VDD VSS
Mmp0 VDD VSS VDD VDD g45p1svt M=1 L=840n W=550n
Mmn0 VSS VDD VSS VSS g45n1svt M=1 L=840n W=400n
.ENDS

.SUBCKT DECAP5 VDD VSS
Mmp0 VDD VSS VDD VDD g45p1svt M=1 L=640n W=550n
Mmn0 VSS VDD VSS VSS g45n1svt M=1 L=640n W=400n
.ENDS

.SUBCKT DECAP4 VDD VSS
Mmn0 VSS VDD VSS VSS g45n1svt M=1 L=440n W=400n
Mmp0 VDD VSS VDD VDD g45p1svt M=1 L=440n W=550n
.ENDS

.SUBCKT DECAP3 VDD VSS
Mmp0 VDD VSS VDD VDD g45p1svt M=1 L=240n W=550n
Mmn0 VSS VDD VSS VSS g45n1svt M=1 L=240n W=400n
.ENDS

.SUBCKT DECAP2 VDD VSS
Mmn0 VSS VDD VSS VSS g45n1svt M=1 L=45n W=255n
Mmp0 VDD VSS VDD VDD g45p1svt M=1 L=45n W=445n
.ENDS

.SUBCKT CLKXOR2X8 A B VDD VSS Y
Mmn1 n2 B VSS VSS g45n1svt M=1 L=45n W=145n
Mmn0 n1 A VSS VSS g45n1svt M=1 L=45n W=145n
Mmn5 Y n0 VSS VSS g45n1svt M=1 L=45n W=2.065u
Mmn3 n0 B net139 VSS g45n1svt M=1 L=45n W=205n
Mmn4 n0 n2 n1 VSS g45n1svt M=1 L=45n W=205n
Mmn2 net139 n1 VSS VSS g45n1svt M=1 L=45n W=205n
Mmp3 n0 n2 net130 VDD g45p1svt M=1 L=45n W=310n
Mmp1 n2 B VDD VDD g45p1svt M=1 L=45n W=215n
Mmp4 n0 B n1 VDD g45p1svt M=1 L=45n W=310n
Mmp0 n1 A VDD VDD g45p1svt M=1 L=45n W=215n
Mmp5 Y n0 VDD VDD g45p1svt M=1 L=45n W=3.115u
Mmp2 net130 n1 VDD VDD g45p1svt M=1 L=45n W=310n
.ENDS

.SUBCKT CLKXOR2X4 A B VDD VSS Y
Mmn1 n2 B VSS VSS g45n1svt M=1 L=45n W=145n
Mmn0 n1 A VSS VSS g45n1svt M=1 L=45n W=145n
Mmn5 Y n0 VSS VSS g45n1svt M=1 L=45n W=1.04u
Mmn3 n0 B net139 VSS g45n1svt M=1 L=45n W=205n
Mmn4 n0 n2 n1 VSS g45n1svt M=1 L=45n W=205n
Mmn2 net139 n1 VSS VSS g45n1svt M=1 L=45n W=205n
Mmp3 n0 n2 net130 VDD g45p1svt M=1 L=45n W=310n
Mmp1 n2 B VDD VDD g45p1svt M=1 L=45n W=215n
Mmp4 n0 B n1 VDD g45p1svt M=1 L=45n W=310n
Mmp0 n1 A VDD VDD g45p1svt M=1 L=45n W=215n
Mmp5 Y n0 VDD VDD g45p1svt M=1 L=45n W=1.56u
Mmp2 net130 n1 VDD VDD g45p1svt M=1 L=45n W=310n
.ENDS

.SUBCKT CLKXOR2X2 A B VDD VSS Y
Mmn1 n2 B VSS VSS g45n1svt M=1 L=45n W=145n
Mmn0 n1 A VSS VSS g45n1svt M=1 L=45n W=145n
Mmn5 Y n0 VSS VSS g45n1svt M=1 L=45n W=520n
Mmn3 n0 B net139 VSS g45n1svt M=1 L=45n W=145n
Mmn4 n0 n2 n1 VSS g45n1svt M=1 L=45n W=145n
Mmn2 net139 n1 VSS VSS g45n1svt M=1 L=45n W=145n
Mmp3 n0 n2 net130 VDD g45p1svt M=1 L=45n W=215n
Mmp1 n2 B VDD VDD g45p1svt M=1 L=45n W=215n
Mmp4 n0 B n1 VDD g45p1svt M=1 L=45n W=215n
Mmp0 n1 A VDD VDD g45p1svt M=1 L=45n W=215n
Mmp5 Y n0 VDD VDD g45p1svt M=1 L=45n W=780n
Mmp2 net130 n1 VDD VDD g45p1svt M=1 L=45n W=215n
.ENDS

.SUBCKT CLKXOR2X1 A B VDD VSS Y
Mmn1 n2 B VSS VSS g45n1svt M=1 L=45n W=145n
Mmn0 n1 A VSS VSS g45n1svt M=1 L=45n W=145n
Mmn5 Y n0 VSS VSS g45n1svt M=1 L=45n W=260n
Mmn3 n0 B net139 VSS g45n1svt M=1 L=45n W=145n
Mmn4 n0 n2 n1 VSS g45n1svt M=1 L=45n W=145n
Mmn2 net139 n1 VSS VSS g45n1svt M=1 L=45n W=145n
Mmp3 n0 n2 net130 VDD g45p1svt M=1 L=45n W=215n
Mmp1 n2 B VDD VDD g45p1svt M=1 L=45n W=215n
Mmp4 n0 B n1 VDD g45p1svt M=1 L=45n W=215n
Mmp0 n1 A VDD VDD g45p1svt M=1 L=45n W=215n
Mmp5 Y n0 VDD VDD g45p1svt M=1 L=45n W=390n
Mmp2 net130 n1 VDD VDD g45p1svt M=1 L=45n W=215n
.ENDS

.SUBCKT CLKMX2X8 A B S0 VDD VSS Y
Mmn3 net140 B VSS VSS g45n1svt M=1 L=45n W=205n
Mmn0 S0b S0 VSS VSS g45n1svt M=1 L=45n W=145n
Mmn2 n0 S0b net148 VSS g45n1svt M=1 L=45n W=205n
Mmn1 net148 A VSS VSS g45n1svt M=1 L=45n W=205n
Mmn5 Y n0 VSS VSS g45n1svt M=1 L=45n W=2.065u
Mmn4 n0 S0 net140 VSS g45n1svt M=1 L=45n W=205n
Mmp4 n0 S0b net115 VDD g45p1svt M=1 L=45n W=310n
Mmp3 net115 B VDD VDD g45p1svt M=1 L=45n W=310n
Mmp5 Y n0 VDD VDD g45p1svt M=1 L=45n W=3.115u
Mmp2 n0 S0 net123 VDD g45p1svt M=1 L=45n W=310n
Mmp0 S0b S0 VDD VDD g45p1svt M=1 L=45n W=215n
Mmp1 net123 A VDD VDD g45p1svt M=1 L=45n W=310n
.ENDS

.SUBCKT CLKMX2X6 A B S0 VDD VSS Y
Mmn3 net140 B VSS VSS g45n1svt M=1 L=45n W=205n
Mmn0 S0b S0 VSS VSS g45n1svt M=1 L=45n W=145n
Mmn2 n0 S0b net148 VSS g45n1svt M=1 L=45n W=205n
Mmn1 net148 A VSS VSS g45n1svt M=1 L=45n W=205n
Mmn5 Y n0 VSS VSS g45n1svt M=1 L=45n W=1.55u
Mmn4 n0 S0 net140 VSS g45n1svt M=1 L=45n W=205n
Mmp4 n0 S0b net115 VDD g45p1svt M=1 L=45n W=310n
Mmp3 net115 B VDD VDD g45p1svt M=1 L=45n W=310n
Mmp5 Y n0 VDD VDD g45p1svt M=1 L=45n W=2.35u
Mmp2 n0 S0 net123 VDD g45p1svt M=1 L=45n W=310n
Mmp0 S0b S0 VDD VDD g45p1svt M=1 L=45n W=215n
Mmp1 net123 A VDD VDD g45p1svt M=1 L=45n W=310n
.ENDS

.SUBCKT CLKMX2X4 A B S0 VDD VSS Y
Mmn3 net140 B VSS VSS g45n1svt M=1 L=45n W=205n
Mmn0 S0b S0 VSS VSS g45n1svt M=1 L=45n W=145n
Mmn2 n0 S0b net148 VSS g45n1svt M=1 L=45n W=205n
Mmn1 net148 A VSS VSS g45n1svt M=1 L=45n W=205n
Mmn5 Y n0 VSS VSS g45n1svt M=1 L=45n W=1.04u
Mmn4 n0 S0 net140 VSS g45n1svt M=1 L=45n W=205n
Mmp4 n0 S0b net115 VDD g45p1svt M=1 L=45n W=310n
Mmp3 net115 B VDD VDD g45p1svt M=1 L=45n W=310n
Mmp5 Y n0 VDD VDD g45p1svt M=1 L=45n W=1.56u
Mmp2 n0 S0 net123 VDD g45p1svt M=1 L=45n W=310n
Mmp0 S0b S0 VDD VDD g45p1svt M=1 L=45n W=215n
Mmp1 net123 A VDD VDD g45p1svt M=1 L=45n W=310n
.ENDS

.SUBCKT CLKMX2X3 A B S0 VDD VSS Y
Mmn3 net140 B VSS VSS g45n1svt M=1 L=45n W=260n
Mmn0 S0b S0 VSS VSS g45n1svt M=1 L=45n W=145n
Mmn2 n0 S0b net148 VSS g45n1svt M=1 L=45n W=260n
Mmn1 net148 A VSS VSS g45n1svt M=1 L=45n W=260n
Mmn5 Y n0 VSS VSS g45n1svt M=1 L=45n W=780n
Mmn4 n0 S0 net140 VSS g45n1svt M=1 L=45n W=260n
Mmp4 n0 S0b net115 VDD g45p1svt M=1 L=45n W=390n
Mmp3 net115 B VDD VDD g45p1svt M=1 L=45n W=390n
Mmp5 Y n0 VDD VDD g45p1svt M=1 L=45n W=1.17u
Mmp2 n0 S0 net123 VDD g45p1svt M=1 L=45n W=390n
Mmp0 S0b S0 VDD VDD g45p1svt M=1 L=45n W=215n
Mmp1 net123 A VDD VDD g45p1svt M=1 L=45n W=390n
.ENDS

.SUBCKT CLKMX2X2 A B S0 VDD VSS Y
Mmn3 net140 B VSS VSS g45n1svt M=1 L=45n W=145n
Mmn0 S0b S0 VSS VSS g45n1svt M=1 L=45n W=145n
Mmn2 n0 S0b net148 VSS g45n1svt M=1 L=45n W=145n
Mmn1 net148 A VSS VSS g45n1svt M=1 L=45n W=145n
Mmn5 Y n0 VSS VSS g45n1svt M=1 L=45n W=520n
Mmn4 n0 S0 net140 VSS g45n1svt M=1 L=45n W=145n
Mmp4 n0 S0b net115 VDD g45p1svt M=1 L=45n W=215n
Mmp3 net115 B VDD VDD g45p1svt M=1 L=45n W=215n
Mmp5 Y n0 VDD VDD g45p1svt M=1 L=45n W=780n
Mmp2 n0 S0 net123 VDD g45p1svt M=1 L=45n W=215n
Mmp0 S0b S0 VDD VDD g45p1svt M=1 L=45n W=215n
Mmp1 net123 A VDD VDD g45p1svt M=1 L=45n W=215n
.ENDS

.SUBCKT CLKMX2X12 A B S0 VDD VSS Y
Mmn3 net140 B VSS VSS g45n1svt M=1 L=45n W=205n
Mmn0 S0b S0 VSS VSS g45n1svt M=1 L=45n W=260n
Mmn2 n0 S0b net148 VSS g45n1svt M=1 L=45n W=205n
Mmn1 net148 A VSS VSS g45n1svt M=1 L=45n W=205n
Mmn5 Y n0 VSS VSS g45n1svt M=1 L=45n W=3.1u
Mmn4 n0 S0 net140 VSS g45n1svt M=1 L=45n W=205n
Mmp4 n0 S0b net115 VDD g45p1svt M=1 L=45n W=310n
Mmp3 net115 B VDD VDD g45p1svt M=1 L=45n W=310n
Mmp5 Y n0 VDD VDD g45p1svt M=1 L=45n W=4.7u
Mmp2 n0 S0 net123 VDD g45p1svt M=1 L=45n W=310n
Mmp0 S0b S0 VDD VDD g45p1svt M=1 L=45n W=390n
Mmp1 net123 A VDD VDD g45p1svt M=1 L=45n W=310n
.ENDS

.SUBCKT CLKINVX8 A VDD VSS Y
Mmp0 Y A VDD VDD g45p1svt M=1 L=45n W=3.115u
Mmn0 Y A VSS VSS g45n1svt M=1 L=45n W=2.065u
.ENDS

.SUBCKT CLKINVX6 A VDD VSS Y
Mmp0 Y A VDD VDD g45p1svt M=1 L=45n W=2.35u
Mmn0 Y A VSS VSS g45n1svt M=1 L=45n W=1.55u
.ENDS

.SUBCKT CLKINVX4 A VDD VSS Y
Mmp0 Y A VDD VDD g45p1svt M=1 L=45n W=1.56u
Mmn0 Y A VSS VSS g45n1svt M=1 L=45n W=1.04u
.ENDS

.SUBCKT CLKINVX3 A VDD VSS Y
Mmp0 Y A VDD VDD g45p1svt M=1 L=45n W=1.17u
Mmn0 Y A VSS VSS g45n1svt M=1 L=45n W=780n
.ENDS

.SUBCKT CLKINVX2 A VDD VSS Y
Mmp0 Y A VDD VDD g45p1svt M=1 L=45n W=780n
Mmn0 Y A VSS VSS g45n1svt M=1 L=45n W=520n
.ENDS

.SUBCKT CLKINVX20 A VDD VSS Y
Mmp0 Y A VDD VDD g45p1svt M=1 L=45n W=7.815u
Mmn0 Y A VSS VSS g45n1svt M=1 L=45n W=5.185u
.ENDS

.SUBCKT CLKINVX1 A VDD VSS Y
Mmp0 Y A VDD VDD g45p1svt M=1 L=45n W=390n
Mmn0 Y A VSS VSS g45n1svt M=1 L=45n W=260n
.ENDS

.SUBCKT CLKINVX16 A VDD VSS Y
Mmp0 Y A VDD VDD g45p1svt M=1 L=45n W=6.23u
Mmn0 Y A VSS VSS g45n1svt M=1 L=45n W=4.13u
.ENDS

.SUBCKT CLKINVX12 A VDD VSS Y
Mmp0 Y A VDD VDD g45p1svt M=1 L=45n W=4.7u
Mmn0 Y A VSS VSS g45n1svt M=1 L=45n W=3.1u
.ENDS

.SUBCKT CLKBUFX8 A VDD VSS Y
Mmn1 Y net44 VSS VSS g45n1svt M=1 L=45n W=2.065u
Mmn0 net44 A VSS VSS g45n1svt M=1 L=45n W=520n
Mmp1 Y net44 VDD VDD g45p1svt M=1 L=45n W=3.115u
Mmp0 net44 A VDD VDD g45p1svt M=1 L=45n W=780n
.ENDS

.SUBCKT CLKBUFX6 A VDD VSS Y
Mmn1 Y net44 VSS VSS g45n1svt M=1 L=45n W=1.55u
Mmn0 net44 A VSS VSS g45n1svt M=1 L=45n W=520n
Mmp1 Y net44 VDD VDD g45p1svt M=1 L=45n W=2.35u
Mmp0 net44 A VDD VDD g45p1svt M=1 L=45n W=780n
.ENDS

.SUBCKT CLKBUFX4 A VDD VSS Y
Mmn1 Y net44 VSS VSS g45n1svt M=1 L=45n W=1.04u
Mmn0 net44 A VSS VSS g45n1svt M=1 L=45n W=260n
Mmp1 Y net44 VDD VDD g45p1svt M=1 L=45n W=1.56u
Mmp0 net44 A VDD VDD g45p1svt M=1 L=45n W=390n
.ENDS

.SUBCKT CLKBUFX3 A VDD VSS Y
Mmn1 Y net44 VSS VSS g45n1svt M=1 L=45n W=780n
Mmn0 net44 A VSS VSS g45n1svt M=1 L=45n W=260n
Mmp1 Y net44 VDD VDD g45p1svt M=1 L=45n W=1.17u
Mmp0 net44 A VDD VDD g45p1svt M=1 L=45n W=390n
.ENDS

.SUBCKT CLKBUFX2 A VDD VSS Y
Mmn1 Y net44 VSS VSS g45n1svt M=1 L=45n W=520n
Mmn0 net44 A VSS VSS g45n1svt M=1 L=45n W=145n
Mmp1 Y net44 VDD VDD g45p1svt M=1 L=45n W=780n
Mmp0 net44 A VDD VDD g45p1svt M=1 L=45n W=215n
.ENDS

.SUBCKT CLKBUFX20 A VDD VSS Y
Mmn1 Y net44 VSS VSS g45n1svt M=1 L=45n W=5.185u
Mmn0 net44 A VSS VSS g45n1svt M=1 L=45n W=1.3u
Mmp1 Y net44 VDD VDD g45p1svt M=1 L=45n W=7.815u
Mmp0 net44 A VDD VDD g45p1svt M=1 L=45n W=1.95u
.ENDS

.SUBCKT CLKBUFX16 A VDD VSS Y
Mmn1 Y net44 VSS VSS g45n1svt M=1 L=45n W=4.13u
Mmn0 net44 A VSS VSS g45n1svt M=1 L=45n W=1.04u
Mmp1 Y net44 VDD VDD g45p1svt M=1 L=45n W=6.23u
Mmp0 net44 A VDD VDD g45p1svt M=1 L=45n W=1.56u
.ENDS

.SUBCKT CLKBUFX12 A VDD VSS Y
Mmn1 Y net44 VSS VSS g45n1svt M=1 L=45n W=3.1u
Mmn0 net44 A VSS VSS g45n1svt M=1 L=45n W=780n
Mmp1 Y net44 VDD VDD g45p1svt M=1 L=45n W=4.7u
Mmp0 net44 A VDD VDD g45p1svt M=1 L=45n W=1.17u
.ENDS

.SUBCKT CLKAND2X8 A B VDD VSS Y
Mmn2 Y net61 VSS VSS g45n1svt M=1 L=45n W=2.065u
Mmn0 net69 A VSS VSS g45n1svt M=1 L=45n W=1.04u
Mmn1 net61 B net69 VSS g45n1svt M=1 L=45n W=1.04u
Mmp1 net61 B VDD VDD g45p1svt M=1 L=45n W=780n
Mmp0 net61 A VDD VDD g45p1svt M=1 L=45n W=780n
Mmp2 Y net61 VDD VDD g45p1svt M=1 L=45n W=3.115u
.ENDS

.SUBCKT CLKAND2X6 A B VDD VSS Y
Mmn2 Y net61 VSS VSS g45n1svt M=1 L=45n W=1.55u
Mmn0 net69 A VSS VSS g45n1svt M=1 L=45n W=1.04u
Mmn1 net61 B net69 VSS g45n1svt M=1 L=45n W=1.04u
Mmp1 net61 B VDD VDD g45p1svt M=1 L=45n W=780n
Mmp0 net61 A VDD VDD g45p1svt M=1 L=45n W=780n
Mmp2 Y net61 VDD VDD g45p1svt M=1 L=45n W=2.35u
.ENDS

.SUBCKT CLKAND2X4 A B VDD VSS Y
Mmn2 Y net61 VSS VSS g45n1svt M=1 L=45n W=1.04u
Mmn0 net69 A VSS VSS g45n1svt M=1 L=45n W=520n
Mmn1 net61 B net69 VSS g45n1svt M=1 L=45n W=520n
Mmp1 net61 B VDD VDD g45p1svt M=1 L=45n W=390n
Mmp0 net61 A VDD VDD g45p1svt M=1 L=45n W=390n
Mmp2 Y net61 VDD VDD g45p1svt M=1 L=45n W=1.56u
.ENDS

.SUBCKT CLKAND2X3 A B VDD VSS Y
Mmn2 Y net61 VSS VSS g45n1svt M=1 L=45n W=780n
Mmn0 net69 A VSS VSS g45n1svt M=1 L=45n W=520n
Mmn1 net61 B net69 VSS g45n1svt M=1 L=45n W=520n
Mmp1 net61 B VDD VDD g45p1svt M=1 L=45n W=390n
Mmp0 net61 A VDD VDD g45p1svt M=1 L=45n W=390n
Mmp2 Y net61 VDD VDD g45p1svt M=1 L=45n W=1.17u
.ENDS

.SUBCKT CLKAND2X2 A B VDD VSS Y
Mmn2 Y net61 VSS VSS g45n1svt M=1 L=45n W=520n
Mmn0 net69 A VSS VSS g45n1svt M=1 L=45n W=290n
Mmn1 net61 B net69 VSS g45n1svt M=1 L=45n W=290n
Mmp1 net61 B VDD VDD g45p1svt M=1 L=45n W=215n
Mmp0 net61 A VDD VDD g45p1svt M=1 L=45n W=215n
Mmp2 Y net61 VDD VDD g45p1svt M=1 L=45n W=780n
.ENDS

.SUBCKT CLKAND2X12 A B VDD VSS Y
Mmn2 Y net61 VSS VSS g45n1svt M=1 L=45n W=3.1u
Mmn0 net69 A VSS VSS g45n1svt M=1 L=45n W=1.55u
Mmn1 net61 B net69 VSS g45n1svt M=1 L=45n W=1.55u
Mmp1 net61 B VDD VDD g45p1svt M=1 L=45n W=1.175u
Mmp0 net61 A VDD VDD g45p1svt M=1 L=45n W=1.175u
Mmp2 Y net61 VDD VDD g45p1svt M=1 L=45n W=4.7u
.ENDS

.SUBCKT BUFX8 A VDD VSS Y
Mmn1 VSS n0 Y VSS g45n1svt M=1 L=45n W=2.065u
Mmn0 VSS A n0 VSS g45n1svt M=1 L=45n W=520n
Mmp1 Y n0 VDD VDD g45p1svt M=1 L=45n W=3.115u
Mmp0 n0 A VDD VDD g45p1svt M=1 L=45n W=780n
.ENDS

.SUBCKT BUFX6 A VDD VSS Y
Mmn1 VSS n0 Y VSS g45n1svt M=1 L=45n W=1.55u
Mmn0 VSS A n0 VSS g45n1svt M=1 L=45n W=520n
Mmp1 Y n0 VDD VDD g45p1svt M=1 L=45n W=2.35u
Mmp0 n0 A VDD VDD g45p1svt M=1 L=45n W=780n
.ENDS

.SUBCKT BUFX4 A VDD VSS Y
Mmn1 VSS n0 Y VSS g45n1svt M=1 L=45n W=1.04u
Mmn0 VSS A n0 VSS g45n1svt M=1 L=45n W=260n
Mmp1 Y n0 VDD VDD g45p1svt M=1 L=45n W=1.56u
Mmp0 n0 A VDD VDD g45p1svt M=1 L=45n W=390n
.ENDS

.SUBCKT BUFX3 A VDD VSS Y
Mmn1 VSS n0 Y VSS g45n1svt M=1 L=45n W=780n
Mmn0 VSS A n0 VSS g45n1svt M=1 L=45n W=260n
Mmp1 Y n0 VDD VDD g45p1svt M=1 L=45n W=1.17u
Mmp0 n0 A VDD VDD g45p1svt M=1 L=45n W=390n
.ENDS

.SUBCKT BUFX2 A VDD VSS Y
Mmn1 VSS n0 Y VSS g45n1svt M=1 L=45n W=520n
Mmn0 VSS A n0 VSS g45n1svt M=1 L=45n W=145n
Mmp1 Y n0 VDD VDD g45p1svt M=1 L=45n W=780n
Mmp0 n0 A VDD VDD g45p1svt M=1 L=45n W=215n
.ENDS

.SUBCKT BUFX20 A VDD VSS Y
Mmn1 VSS n0 Y VSS g45n1svt M=1 L=45n W=5.185u
Mmn0 VSS A n0 VSS g45n1svt M=1 L=45n W=1.3u
Mmp1 Y n0 VDD VDD g45p1svt M=1 L=45n W=7.82u
Mmp0 n0 A VDD VDD g45p1svt M=1 L=45n W=1.95u
.ENDS

.SUBCKT BUFX16 A VDD VSS Y
Mmn1 VSS n0 Y VSS g45n1svt M=1 L=45n W=4.13u
Mmn0 VSS A n0 VSS g45n1svt M=1 L=45n W=1.04u
Mmp1 Y n0 VDD VDD g45p1svt M=1 L=45n W=6.23u
Mmp0 n0 A VDD VDD g45p1svt M=1 L=45n W=1.56u
.ENDS

.SUBCKT BUFX12 A VDD VSS Y
Mmn1 VSS n0 Y VSS g45n1svt M=1 L=45n W=3.1u
Mmn0 VSS A n0 VSS g45n1svt M=1 L=45n W=780n
Mmp1 Y n0 VDD VDD g45p1svt M=1 L=45n W=4.7u
Mmp0 n0 A VDD VDD g45p1svt M=1 L=45n W=1.17u
.ENDS

.SUBCKT BMXIX4 A M0 M1 PPN S VDD VSS X2
Mmn10 n1 M1 n9 VSS g45n1svt M=1 L=45n W=145n
Mmn9 n9 A VSS VSS g45n1svt M=1 L=45n W=145n
Mmn8 n1 M1b n7 VSS g45n1svt M=1 L=45n W=145n
Mmn7 n7 S VSS VSS g45n1svt M=1 L=45n W=145n
Mmn3 n3 S VSS VSS g45n1svt M=1 L=45n W=145n
Mmn4 n0 M0b n3 VSS g45n1svt M=1 L=45n W=145n
Mmn11 net293 X2 n0 VSS g45n1svt M=1 L=45n W=260n
Mmn6 n0 M0 n5 VSS g45n1svt M=1 L=45n W=145n
Mmn13 PPN net293 VSS VSS g45n1svt M=1 L=45n W=1.04u
Mmn5 n5 A VSS VSS g45n1svt M=1 L=45n W=145n
Mmn12 n1 X2b net293 VSS g45n1svt M=1 L=45n W=260n
Mmn0 M0b M0 VSS VSS g45n1svt M=1 L=45n W=145n
Mmn1 M1b M1 VSS VSS g45n1svt M=1 L=45n W=145n
Mmn2 X2b X2 VSS VSS g45n1svt M=1 L=45n W=145n
Mmp8 n1 M1 n8 VDD g45p1svt M=1 L=45n W=215n
Mmp7 n8 S VDD VDD g45p1svt M=1 L=45n W=215n
Mmp3 n4 S VDD VDD g45p1svt M=1 L=45n W=215n
Mmp4 n0 M0 n4 VDD g45p1svt M=1 L=45n W=215n
Mmp9 n10 A VDD VDD g45p1svt M=1 L=45n W=215n
Mmp10 n1 M1b n10 VDD g45p1svt M=1 L=45n W=215n
Mmp2 X2b X2 VDD VDD g45p1svt M=1 L=45n W=215n
Mmp6 n0 M0b n6 VDD g45p1svt M=1 L=45n W=215n
Mmp0 M0b M0 VDD VDD g45p1svt M=1 L=45n W=215n
Mmp1 M1b M1 VDD VDD g45p1svt M=1 L=45n W=215n
Mmp13 PPN net293 VDD VDD g45p1svt M=1 L=45n W=1.56u
Mmp12 n1 X2 net293 VDD g45p1svt M=1 L=45n W=390n
Mmp11 net293 X2b n0 VDD g45p1svt M=1 L=45n W=390n
Mmp5 n6 A VDD VDD g45p1svt M=1 L=45n W=215n
.ENDS

.SUBCKT BMXIX2 A M0 M1 PPN S VDD VSS X2
Mmn10 n1 M1 n9 VSS g45n1svt M=1 L=45n W=145n
Mmn9 n9 A VSS VSS g45n1svt M=1 L=45n W=145n
Mmn8 n1 M1b n7 VSS g45n1svt M=1 L=45n W=145n
Mmn7 n7 S VSS VSS g45n1svt M=1 L=45n W=145n
Mmn3 n3 S VSS VSS g45n1svt M=1 L=45n W=145n
Mmn4 n0 M0b n3 VSS g45n1svt M=1 L=45n W=145n
Mmn11 net293 X2 n0 VSS g45n1svt M=1 L=45n W=145n
Mmn6 n0 M0 n5 VSS g45n1svt M=1 L=45n W=145n
Mmn13 PPN net293 VSS VSS g45n1svt M=1 L=45n W=520n
Mmn5 n5 A VSS VSS g45n1svt M=1 L=45n W=145n
Mmn12 n1 X2b net293 VSS g45n1svt M=1 L=45n W=145n
Mmn0 M0b M0 VSS VSS g45n1svt M=1 L=45n W=145n
Mmn1 M1b M1 VSS VSS g45n1svt M=1 L=45n W=145n
Mmn2 X2b X2 VSS VSS g45n1svt M=1 L=45n W=145n
Mmp8 n1 M1 n8 VDD g45p1svt M=1 L=45n W=215n
Mmp7 n8 S VDD VDD g45p1svt M=1 L=45n W=215n
Mmp3 n4 S VDD VDD g45p1svt M=1 L=45n W=215n
Mmp4 n0 M0 n4 VDD g45p1svt M=1 L=45n W=215n
Mmp9 n10 A VDD VDD g45p1svt M=1 L=45n W=215n
Mmp10 n1 M1b n10 VDD g45p1svt M=1 L=45n W=215n
Mmp2 X2b X2 VDD VDD g45p1svt M=1 L=45n W=215n
Mmp6 n0 M0b n6 VDD g45p1svt M=1 L=45n W=215n
Mmp0 M0b M0 VDD VDD g45p1svt M=1 L=45n W=215n
Mmp1 M1b M1 VDD VDD g45p1svt M=1 L=45n W=215n
Mmp13 PPN net293 VDD VDD g45p1svt M=1 L=45n W=780n
Mmp12 n1 X2 net293 VDD g45p1svt M=1 L=45n W=215n
Mmp11 net293 X2b n0 VDD g45p1svt M=1 L=45n W=215n
Mmp5 n6 A VDD VDD g45p1svt M=1 L=45n W=215n
.ENDS

.SUBCKT AOI33XL A0 A1 A2 B0 B1 B2 VDD VSS Y
Mmn1 net153 A1 net149 VSS g45n1svt M=1 L=45n W=145n
Mmn4 net137 B1 VSS VSS g45n1svt M=1 L=45n W=145n
Mmn3 net141 B0 net137 VSS g45n1svt M=1 L=45n W=145n
Mmn5 Y B2 net141 VSS g45n1svt M=1 L=45n W=145n
Mmn0 net149 A0 VSS VSS g45n1svt M=1 L=45n W=145n
Mmn2 Y A2 net153 VSS g45n1svt M=1 L=45n W=145n
Mmp0 net124 A0 VDD VDD g45p1svt M=1 L=45n W=215n
Mmp1 net124 A1 VDD VDD g45p1svt M=1 L=45n W=215n
Mmp4 Y B1 net124 VDD g45p1svt M=1 L=45n W=215n
Mmp5 Y B2 net124 VDD g45p1svt M=1 L=45n W=215n
Mmp2 net124 A2 VDD VDD g45p1svt M=1 L=45n W=215n
Mmp3 Y B0 net124 VDD g45p1svt M=1 L=45n W=215n
.ENDS

.SUBCKT AOI33X4 A0 A1 A2 B0 B1 B2 VDD VSS Y
Mmn1 net153 A1 net149 VSS g45n1svt M=1 L=45n W=1.04u
Mmn4 net141 B1 net137 VSS g45n1svt M=1 L=45n W=1.04u
Mmn3 net137 B0 VSS VSS g45n1svt M=1 L=45n W=1.04u
Mmn5 Y B2 net141 VSS g45n1svt M=1 L=45n W=1.04u
Mmn0 net149 A0 VSS VSS g45n1svt M=1 L=45n W=1.04u
Mmn2 Y A2 net153 VSS g45n1svt M=1 L=45n W=1.04u
Mmp0 net124 A0 VDD VDD g45p1svt M=1 L=45n W=1.56u
Mmp1 net124 A1 VDD VDD g45p1svt M=1 L=45n W=1.56u
Mmp4 Y B1 net124 VDD g45p1svt M=1 L=45n W=1.56u
Mmp5 Y B2 net124 VDD g45p1svt M=1 L=45n W=1.56u
Mmp2 net124 A2 VDD VDD g45p1svt M=1 L=45n W=1.56u
Mmp3 Y B0 net124 VDD g45p1svt M=1 L=45n W=1.56u
.ENDS

.SUBCKT AOI33X2 A0 A1 A2 B0 B1 B2 VDD VSS Y
Mmn1 net153 A1 net149 VSS g45n1svt M=1 L=45n W=520n
Mmn4 net141 B1 net137 VSS g45n1svt M=1 L=45n W=520n
Mmn3 net137 B0 VSS VSS g45n1svt M=1 L=45n W=520n
Mmn5 Y B2 net141 VSS g45n1svt M=1 L=45n W=520n
Mmn0 net149 A0 VSS VSS g45n1svt M=1 L=45n W=520n
Mmn2 Y A2 net153 VSS g45n1svt M=1 L=45n W=520n
Mmp0 net124 A0 VDD VDD g45p1svt M=1 L=45n W=780n
Mmp1 net124 A1 VDD VDD g45p1svt M=1 L=45n W=780n
Mmp4 Y B1 net124 VDD g45p1svt M=1 L=45n W=780n
Mmp5 Y B2 net124 VDD g45p1svt M=1 L=45n W=780n
Mmp2 net124 A2 VDD VDD g45p1svt M=1 L=45n W=780n
Mmp3 Y B0 net124 VDD g45p1svt M=1 L=45n W=780n
.ENDS

.SUBCKT AOI33X1 A0 A1 A2 B0 B1 B2 VDD VSS Y
Mmn1 net157 A1 net149 VSS g45n1svt M=1 L=45n W=260n
Mmn4 net141 B1 net137 VSS g45n1svt M=1 L=45n W=260n
Mmn3 net137 B0 VSS VSS g45n1svt M=1 L=45n W=260n
Mmn5 Y B2 net141 VSS g45n1svt M=1 L=45n W=260n
Mmn0 net149 A0 VSS VSS g45n1svt M=1 L=45n W=260n
Mmn2 Y A2 net157 VSS g45n1svt M=1 L=45n W=260n
Mmp0 net059 A0 VDD VDD g45p1svt M=1 L=45n W=390n
Mmp1 net059 A1 VDD VDD g45p1svt M=1 L=45n W=390n
Mmp4 Y B1 net059 VDD g45p1svt M=1 L=45n W=390n
Mmp5 Y B2 net059 VDD g45p1svt M=1 L=45n W=390n
Mmp2 net059 A2 VDD VDD g45p1svt M=1 L=45n W=390n
Mmp3 Y B0 net059 VDD g45p1svt M=1 L=45n W=390n
.ENDS

.SUBCKT AOI32XL A0 A1 A2 B0 B1 VDD VSS Y
Mmn3 net118 B0 VSS VSS g45n1svt M=1 L=45n W=145n
Mmn2 Y A2 net130 VSS g45n1svt M=1 L=45n W=145n
Mmn0 net126 A0 VSS VSS g45n1svt M=1 L=45n W=145n
Mmn1 net130 A1 net126 VSS g45n1svt M=1 L=45n W=145n
Mmn4 Y B1 net118 VSS g45n1svt M=1 L=45n W=145n
Mmp3 Y B0 net114 VDD g45p1svt M=1 L=45n W=215n
Mmp4 Y B1 net114 VDD g45p1svt M=1 L=45n W=215n
Mmp2 net114 A2 VDD VDD g45p1svt M=1 L=45n W=215n
Mmp1 net114 A1 VDD VDD g45p1svt M=1 L=45n W=215n
Mmp0 net114 A0 VDD VDD g45p1svt M=1 L=45n W=215n
.ENDS

.SUBCKT AOI32X4 A0 A1 A2 B0 B1 VDD VSS Y
Mmn3 net118 B0 VSS VSS g45n1svt M=1 L=45n W=1.04u
Mmn2 Y A2 net126 VSS g45n1svt M=1 L=45n W=1.04u
Mmn0 net122 A0 VSS VSS g45n1svt M=1 L=45n W=1.04u
Mmn1 net126 A1 net122 VSS g45n1svt M=1 L=45n W=1.04u
Mmn4 Y B1 net118 VSS g45n1svt M=1 L=45n W=1.04u
Mmp3 Y B0 net106 VDD g45p1svt M=1 L=45n W=1.56u
Mmp4 Y B1 net106 VDD g45p1svt M=1 L=45n W=1.56u
Mmp2 net106 A2 VDD VDD g45p1svt M=1 L=45n W=1.56u
Mmp1 net106 A1 VDD VDD g45p1svt M=1 L=45n W=1.56u
Mmp0 net106 A0 VDD VDD g45p1svt M=1 L=45n W=1.56u
.ENDS

.SUBCKT AOI32X2 A0 A1 A2 B0 B1 VDD VSS Y
Mmn3 net83 B0 VSS VSS g45n1svt M=1 L=45n W=520n
Mmn2 Y A2 net71 VSS g45n1svt M=1 L=45n W=520n
Mmn0 net75 A0 VSS VSS g45n1svt M=1 L=45n W=520n
Mmn1 net71 A1 net75 VSS g45n1svt M=1 L=45n W=520n
Mmn4 Y B1 net83 VSS g45n1svt M=1 L=45n W=520n
Mmp3 Y B0 net47 VDD g45p1svt M=1 L=45n W=780n
Mmp4 Y B1 net47 VDD g45p1svt M=1 L=45n W=780n
Mmp2 net47 A2 VDD VDD g45p1svt M=1 L=45n W=780n
Mmp1 net47 A1 VDD VDD g45p1svt M=1 L=45n W=780n
Mmp0 net47 A0 VDD VDD g45p1svt M=1 L=45n W=780n
.ENDS

.SUBCKT AOI32X1 A0 A1 A2 B0 B1 VDD VSS Y
Mmn3 net118 B0 VSS VSS g45n1svt M=1 L=45n W=260n
Mmn2 Y A2 net126 VSS g45n1svt M=1 L=45n W=260n
Mmn0 net122 A0 VSS VSS g45n1svt M=1 L=45n W=260n
Mmn1 net126 A1 net122 VSS g45n1svt M=1 L=45n W=260n
Mmn4 Y B1 net118 VSS g45n1svt M=1 L=45n W=260n
Mmp3 Y B0 net114 VDD g45p1svt M=1 L=45n W=390n
Mmp4 Y B1 net114 VDD g45p1svt M=1 L=45n W=390n
Mmp2 net114 A2 VDD VDD g45p1svt M=1 L=45n W=390n
Mmp1 net114 A1 VDD VDD g45p1svt M=1 L=45n W=390n
Mmp0 net114 A0 VDD VDD g45p1svt M=1 L=45n W=390n
.ENDS

.SUBCKT AOI31XL A0 A1 A2 B0 VDD VSS Y
Mmn3 Y B0 VSS VSS g45n1svt M=1 L=45n W=145n
Mmn1 net101 A1 net97 VSS g45n1svt M=1 L=45n W=145n
Mmn2 Y A2 net101 VSS g45n1svt M=1 L=45n W=145n
Mmn0 net97 A0 VSS VSS g45n1svt M=1 L=45n W=145n
Mmp2 net89 A2 VDD VDD g45p1svt M=1 L=45n W=215n
Mmp3 Y B0 net89 VDD g45p1svt M=1 L=45n W=215n
Mmp1 net89 A1 VDD VDD g45p1svt M=1 L=45n W=215n
Mmp0 net89 A0 VDD VDD g45p1svt M=1 L=45n W=215n
.ENDS

.SUBCKT AOI31X4 A0 A1 A2 B0 VDD VSS Y
Mmn3 Y B0 VSS VSS g45n1svt M=1 L=45n W=1.04u
Mmn1 net101 A1 net97 VSS g45n1svt M=1 L=45n W=1.04u
Mmn2 Y A2 net101 VSS g45n1svt M=1 L=45n W=1.04u
Mmn0 net97 A0 VSS VSS g45n1svt M=1 L=45n W=1.04u
Mmp2 net89 A2 VDD VDD g45p1svt M=1 L=45n W=1.56u
Mmp3 Y B0 net89 VDD g45p1svt M=1 L=45n W=1.56u
Mmp1 net89 A1 VDD VDD g45p1svt M=1 L=45n W=1.56u
Mmp0 net89 A0 VDD VDD g45p1svt M=1 L=45n W=1.56u
.ENDS

.SUBCKT AOI31X2 A0 A1 A2 B0 VDD VSS Y
Mmn3 Y B0 VSS VSS g45n1svt M=1 L=45n W=520n
Mmn1 net100 A1 net104 VSS g45n1svt M=1 L=45n W=520n
Mmn2 Y A2 net100 VSS g45n1svt M=1 L=45n W=520n
Mmn0 net104 A0 VSS VSS g45n1svt M=1 L=45n W=520n
Mmp2 net81 A2 VDD VDD g45p1svt M=1 L=45n W=780n
Mmp3 Y B0 net81 VDD g45p1svt M=1 L=45n W=780n
Mmp1 net81 A1 VDD VDD g45p1svt M=1 L=45n W=780n
Mmp0 net81 A0 VDD VDD g45p1svt M=1 L=45n W=780n
.ENDS

.SUBCKT AOI31X1 A0 A1 A2 B0 VDD VSS Y
Mmn3 Y B0 VSS VSS g45n1svt M=1 L=45n W=260n
Mmn1 net97 A1 net93 VSS g45n1svt M=1 L=45n W=260n
Mmn2 Y A2 net97 VSS g45n1svt M=1 L=45n W=260n
Mmn0 net93 A0 VSS VSS g45n1svt M=1 L=45n W=260n
Mmp2 net81 A2 VDD VDD g45p1svt M=1 L=45n W=390n
Mmp3 Y B0 net81 VDD g45p1svt M=1 L=45n W=390n
Mmp1 net81 A1 VDD VDD g45p1svt M=1 L=45n W=390n
Mmp0 net81 A0 VDD VDD g45p1svt M=1 L=45n W=390n
.ENDS

.SUBCKT AOI2BB2XL A0N A1N B0 B1 VDD VSS Y
Mmn5 net156 B1 VSS VSS g45n1svt M=1 L=45n W=145n
Mmn4 Y B0 net156 VSS g45n1svt M=1 L=45n W=145n
Mmn3 Y net164 net144 VSS g45n1svt M=1 L=45n W=145n
Mmn2 net144 net146 VSS VSS g45n1svt M=1 L=45n W=145n
Mmn0 net146 A0N VSS VSS g45n1svt M=1 L=45n W=145n
Mmn1 net164 A1N VSS VSS g45n1svt M=1 L=45n W=145n
Mmp5 Y B1 net124 VDD g45p1svt M=1 L=45n W=215n
Mmp4 Y B0 net124 VDD g45p1svt M=1 L=45n W=215n
Mmp2 net124 net146 VDD VDD g45p1svt M=1 L=45n W=215n
Mmp0 net146 A0N VDD VDD g45p1svt M=1 L=45n W=215n
Mmp1 net164 A1N VDD VDD g45p1svt M=1 L=45n W=215n
Mmp3 net124 net164 VDD VDD g45p1svt M=1 L=45n W=215n
.ENDS

.SUBCKT AOI2BB2X4 A0N A1N B0 B1 VDD VSS Y
Mmn5 net152 B1 VSS VSS g45n1svt M=1 L=45n W=1.04u
Mmn4 Y B0 net152 VSS g45n1svt M=1 L=45n W=1.04u
Mmn3 Y net144 net160 VSS g45n1svt M=1 L=45n W=1.04u
Mmn2 net160 net148 VSS VSS g45n1svt M=1 L=45n W=1.04u
Mmn0 net148 A0N VSS VSS g45n1svt M=1 L=45n W=260n
Mmn1 net144 A1N VSS VSS g45n1svt M=1 L=45n W=260n
Mmp5 Y B1 net127 VDD g45p1svt M=1 L=45n W=1.56u
Mmp4 Y B0 net127 VDD g45p1svt M=1 L=45n W=1.56u
Mmp2 net127 net148 VDD VDD g45p1svt M=1 L=45n W=1.56u
Mmp0 net148 A0N VDD VDD g45p1svt M=1 L=45n W=390n
Mmp1 net144 A1N VDD VDD g45p1svt M=1 L=45n W=390n
Mmp3 net127 net144 VDD VDD g45p1svt M=1 L=45n W=1.56u
.ENDS

.SUBCKT AOI2BB2X2 A0N A1N B0 B1 VDD VSS Y
Mmn5 n3 B1 VSS VSS g45n1svt M=1 L=45n W=520n
Mmn4 Y B0 n3 VSS g45n1svt M=1 L=45n W=520n
Mmn3 Y n1 n2 VSS g45n1svt M=1 L=45n W=520n
Mmn2 n2 n0 VSS VSS g45n1svt M=1 L=45n W=520n
Mmn0 n0 A0N VSS VSS g45n1svt M=1 L=45n W=145n
Mmn1 n1 A1N VSS VSS g45n1svt M=1 L=45n W=145n
Mmp5 Y B1 n4 VDD g45p1svt M=1 L=45n W=780n
Mmp4 Y B0 n4 VDD g45p1svt M=1 L=45n W=780n
Mmp2 n4 n0 VDD VDD g45p1svt M=1 L=45n W=780n
Mmp0 n0 A0N VDD VDD g45p1svt M=1 L=45n W=215n
Mmp1 n1 A1N VDD VDD g45p1svt M=1 L=45n W=215n
Mmp3 n4 n1 VDD VDD g45p1svt M=1 L=45n W=780n
.ENDS

.SUBCKT AOI2BB2X1 A0N A1N B0 B1 VDD VSS Y
Mmn5 n3 B1 VSS VSS g45n1svt M=1 L=45n W=260n
Mmn4 Y B0 n3 VSS g45n1svt M=1 L=45n W=260n
Mmn3 Y n1 n2 VSS g45n1svt M=1 L=45n W=260n
Mmn2 n2 n0 VSS VSS g45n1svt M=1 L=45n W=260n
Mmn0 n0 A0N VSS VSS g45n1svt M=1 L=45n W=145n
Mmn1 n1 A1N VSS VSS g45n1svt M=1 L=45n W=145n
Mmp5 Y B1 n4 VDD g45p1svt M=1 L=45n W=390n
Mmp4 Y B0 n4 VDD g45p1svt M=1 L=45n W=390n
Mmp2 n4 n0 VDD VDD g45p1svt M=1 L=45n W=390n
Mmp0 n0 A0N VDD VDD g45p1svt M=1 L=45n W=215n
Mmp1 n1 A1N VDD VDD g45p1svt M=1 L=45n W=215n
Mmp3 n4 n1 VDD VDD g45p1svt M=1 L=45n W=390n
.ENDS

.SUBCKT AOI2BB1XL A0N A1N B0 VDD VSS Y
Mmn2 Y B0 VSS VSS g45n1svt M=1 L=45n W=145n
Mmn1 net100 A1N VSS VSS g45n1svt M=1 L=45n W=145n
Mmn3 Y net100 VSS VSS g45n1svt M=1 L=45n W=145n
Mmn0 net100 A0N VSS VSS g45n1svt M=1 L=45n W=145n
Mmp3 Y net100 net79 VDD g45p1svt M=1 L=45n W=215n
Mmp2 net79 B0 VDD VDD g45p1svt M=1 L=45n W=215n
Mmp1 net100 A1N net87 VDD g45p1svt M=1 L=45n W=215n
Mmp0 net87 A0N VDD VDD g45p1svt M=1 L=45n W=215n
.ENDS

.SUBCKT AOI2BB1X4 A0N A1N B0 VDD VSS Y
Mmn2 Y B0 VSS VSS g45n1svt M=1 L=45n W=1.04u
Mmn1 net104 A1N VSS VSS g45n1svt M=1 L=45n W=260n
Mmn3 Y net104 VSS VSS g45n1svt M=1 L=45n W=1.04u
Mmn0 net104 A0N VSS VSS g45n1svt M=1 L=45n W=260n
Mmp3 Y net104 net79 VDD g45p1svt M=1 L=45n W=1.56u
Mmp2 net79 B0 VDD VDD g45p1svt M=1 L=45n W=1.56u
Mmp1 net104 A1N net87 VDD g45p1svt M=1 L=45n W=390n
Mmp0 net87 A0N VDD VDD g45p1svt M=1 L=45n W=390n
.ENDS

.SUBCKT AOI2BB1X2 A0N A1N B0 VDD VSS Y
Mmn2 Y B0 VSS VSS g45n1svt M=1 L=45n W=520n
Mmn1 net104 A1N VSS VSS g45n1svt M=1 L=45n W=145n
Mmn3 Y net104 VSS VSS g45n1svt M=1 L=45n W=520n
Mmn0 net104 A0N VSS VSS g45n1svt M=1 L=45n W=145n
Mmp3 Y net104 net79 VDD g45p1svt M=1 L=45n W=780n
Mmp2 net79 B0 VDD VDD g45p1svt M=1 L=45n W=780n
Mmp1 net104 A1N net87 VDD g45p1svt M=1 L=45n W=215n
Mmp0 net87 A0N VDD VDD g45p1svt M=1 L=45n W=215n
.ENDS

.SUBCKT AOI2BB1X1 A0N A1N B0 VDD VSS Y
Mmn2 Y B0 VSS VSS g45n1svt M=1 L=45n W=260n
Mmn1 n0 A1N VSS VSS g45n1svt M=1 L=45n W=145n
Mmn3 Y n0 VSS VSS g45n1svt M=1 L=45n W=260n
Mmn0 n0 A0N VSS VSS g45n1svt M=1 L=45n W=145n
Mmp3 Y n0 n2 VDD g45p1svt M=1 L=45n W=390n
Mmp2 n2 B0 VDD VDD g45p1svt M=1 L=45n W=390n
Mmp1 n0 A1N n1 VDD g45p1svt M=1 L=45n W=215n
Mmp0 n1 A0N VDD VDD g45p1svt M=1 L=45n W=215n
.ENDS

.SUBCKT AOI22XL A0 A1 B0 B1 VDD VSS Y
Mmn3 Y B1 net98 VSS g45n1svt M=1 L=45n W=145n
Mmn0 net106 A0 VSS VSS g45n1svt M=1 L=45n W=145n
Mmn2 net98 B0 VSS VSS g45n1svt M=1 L=45n W=145n
Mmn1 Y A1 net106 VSS g45n1svt M=1 L=45n W=145n
Mmp3 Y B1 net89 VDD g45p1svt M=1 L=45n W=215n
Mmp0 net89 A0 VDD VDD g45p1svt M=1 L=45n W=215n
Mmp1 net89 A1 VDD VDD g45p1svt M=1 L=45n W=215n
Mmp2 Y B0 net89 VDD g45p1svt M=1 L=45n W=215n
.ENDS

.SUBCKT AOI22X4 A0 A1 B0 B1 VDD VSS Y
Mmn3 Y B1 net102 VSS g45n1svt M=1 L=45n W=1.04u
Mmn0 net98 A0 VSS VSS g45n1svt M=1 L=45n W=1.04u
Mmn2 net102 B0 VSS VSS g45n1svt M=1 L=45n W=1.04u
Mmn1 Y A1 net98 VSS g45n1svt M=1 L=45n W=1.04u
Mmp3 Y B1 net89 VDD g45p1svt M=1 L=45n W=1.56u
Mmp0 net89 A0 VDD VDD g45p1svt M=1 L=45n W=1.56u
Mmp1 net89 A1 VDD VDD g45p1svt M=1 L=45n W=1.56u
Mmp2 Y B0 net89 VDD g45p1svt M=1 L=45n W=1.56u
.ENDS

.SUBCKT AOI22X2 A0 A1 B0 B1 VDD VSS Y
Mmn3 Y B1 net106 VSS g45n1svt M=1 L=45n W=520n
Mmn0 net98 A0 VSS VSS g45n1svt M=1 L=45n W=520n
Mmn2 net106 B0 VSS VSS g45n1svt M=1 L=45n W=520n
Mmn1 Y A1 net98 VSS g45n1svt M=1 L=45n W=520n
Mmp3 Y B1 net89 VDD g45p1svt M=1 L=45n W=780n
Mmp0 net89 A0 VDD VDD g45p1svt M=1 L=45n W=780n
Mmp1 net89 A1 VDD VDD g45p1svt M=1 L=45n W=780n
Mmp2 Y B0 net89 VDD g45p1svt M=1 L=45n W=780n
.ENDS

.SUBCKT AOI22X1 A0 A1 B0 B1 VDD VSS Y
Mmn3 Y B1 net98 VSS g45n1svt M=1 L=45n W=260n
Mmn0 net102 A0 VSS VSS g45n1svt M=1 L=45n W=260n
Mmn2 net98 B0 VSS VSS g45n1svt M=1 L=45n W=260n
Mmn1 Y A1 net102 VSS g45n1svt M=1 L=45n W=260n
Mmp3 Y B1 net89 VDD g45p1svt M=1 L=45n W=390n
Mmp0 net89 A0 VDD VDD g45p1svt M=1 L=45n W=390n
Mmp1 net89 A1 VDD VDD g45p1svt M=1 L=45n W=390n
Mmp2 Y B0 net89 VDD g45p1svt M=1 L=45n W=390n
.ENDS

.SUBCKT AOI222XL A0 A1 B0 B1 C0 C1 VDD VSS Y
Mmn5 Y C1 net155 VSS g45n1svt M=1 L=45n W=145n
Mmn4 net155 C0 VSS VSS g45n1svt M=1 L=45n W=145n
Mmn2 net147 B0 VSS VSS g45n1svt M=1 L=45n W=145n
Mmn0 net139 A0 VSS VSS g45n1svt M=1 L=45n W=145n
Mmn1 Y A1 net139 VSS g45n1svt M=1 L=45n W=145n
Mmn3 Y B1 net147 VSS g45n1svt M=1 L=45n W=145n
Mmp5 Y C1 net122 VDD g45p1svt M=1 L=45n W=215n
Mmp4 Y C0 net122 VDD g45p1svt M=1 L=45n W=215n
Mmp3 net122 B1 net134 VDD g45p1svt M=1 L=45n W=215n
Mmp2 net122 B0 net134 VDD g45p1svt M=1 L=45n W=215n
Mmp0 net134 A0 VDD VDD g45p1svt M=1 L=45n W=215n
Mmp1 net134 A1 VDD VDD g45p1svt M=1 L=45n W=215n
.ENDS

.SUBCKT AOI222X4 A0 A1 B0 B1 C0 C1 VDD VSS Y
Mmn5 Y C1 net139 VSS g45n1svt M=1 L=45n W=1.04u
Mmn4 net139 C0 VSS VSS g45n1svt M=1 L=45n W=1.04u
Mmn2 net143 B0 VSS VSS g45n1svt M=1 L=45n W=1.04u
Mmn0 net147 A0 VSS VSS g45n1svt M=1 L=45n W=1.04u
Mmn1 Y A1 net147 VSS g45n1svt M=1 L=45n W=1.04u
Mmn3 Y B1 net143 VSS g45n1svt M=1 L=45n W=1.04u
Mmp5 Y C1 net122 VDD g45p1svt M=1 L=45n W=1.56u
Mmp4 Y C0 net122 VDD g45p1svt M=1 L=45n W=1.56u
Mmp3 net122 B1 net130 VDD g45p1svt M=1 L=45n W=1.56u
Mmp2 net122 B0 net130 VDD g45p1svt M=1 L=45n W=1.56u
Mmp0 net130 A0 VDD VDD g45p1svt M=1 L=45n W=1.56u
Mmp1 net130 A1 VDD VDD g45p1svt M=1 L=45n W=1.56u
.ENDS

.SUBCKT AOI222X2 A0 A1 B0 B1 C0 C1 VDD VSS Y
Mmn5 Y C1 net155 VSS g45n1svt M=1 L=45n W=520n
Mmn4 net155 C0 VSS VSS g45n1svt M=1 L=45n W=520n
Mmn2 net151 B0 VSS VSS g45n1svt M=1 L=45n W=520n
Mmn0 net147 A0 VSS VSS g45n1svt M=1 L=45n W=520n
Mmn1 Y A1 net147 VSS g45n1svt M=1 L=45n W=520n
Mmn3 Y B1 net151 VSS g45n1svt M=1 L=45n W=520n
Mmp5 Y C1 net134 VDD g45p1svt M=1 L=45n W=780n
Mmp4 Y C0 net134 VDD g45p1svt M=1 L=45n W=780n
Mmp3 net134 B1 net126 VDD g45p1svt M=1 L=45n W=780n
Mmp2 net134 B0 net126 VDD g45p1svt M=1 L=45n W=780n
Mmp0 net126 A0 VDD VDD g45p1svt M=1 L=45n W=780n
Mmp1 net126 A1 VDD VDD g45p1svt M=1 L=45n W=780n
.ENDS

.SUBCKT AOI222X1 A0 A1 B0 B1 C0 C1 VDD VSS Y
Mmn5 Y C1 net155 VSS g45n1svt M=1 L=45n W=260n
Mmn4 net155 C0 VSS VSS g45n1svt M=1 L=45n W=260n
Mmn2 net147 B0 VSS VSS g45n1svt M=1 L=45n W=260n
Mmn0 net139 A0 VSS VSS g45n1svt M=1 L=45n W=260n
Mmn1 Y A1 net139 VSS g45n1svt M=1 L=45n W=260n
Mmn3 Y B1 net147 VSS g45n1svt M=1 L=45n W=260n
Mmp5 Y C1 net118 VDD g45p1svt M=1 L=45n W=390n
Mmp4 Y C0 net118 VDD g45p1svt M=1 L=45n W=390n
Mmp3 net118 B1 net122 VDD g45p1svt M=1 L=45n W=390n
Mmp2 net118 B0 net122 VDD g45p1svt M=1 L=45n W=390n
Mmp0 net122 A0 VDD VDD g45p1svt M=1 L=45n W=390n
Mmp1 net122 A1 VDD VDD g45p1svt M=1 L=45n W=390n
.ENDS

.SUBCKT AOI221XL A0 A1 B0 B1 C0 VDD VSS Y
Mmn2 net116 B0 VSS VSS g45n1svt M=1 L=45n W=145n
Mmn3 Y B1 net116 VSS g45n1svt M=1 L=45n W=145n
Mmn4 Y C0 VSS VSS g45n1svt M=1 L=45n W=145n
Mmn1 Y A1 net124 VSS g45n1svt M=1 L=45n W=145n
Mmn0 net124 A0 VSS VSS g45n1svt M=1 L=45n W=145n
Mmp3 net104 B1 net107 VDD g45p1svt M=1 L=45n W=215n
Mmp2 net104 B0 net107 VDD g45p1svt M=1 L=45n W=215n
Mmp0 net107 A0 VDD VDD g45p1svt M=1 L=45n W=215n
Mmp1 net107 A1 VDD VDD g45p1svt M=1 L=45n W=215n
Mmp4 Y C0 net104 VDD g45p1svt M=1 L=45n W=215n
.ENDS

.SUBCKT AOI221X4 A0 A1 B0 B1 C0 VDD VSS Y
Mmn2 net116 B0 VSS VSS g45n1svt M=1 L=45n W=1.04u
Mmn3 Y B1 net116 VSS g45n1svt M=1 L=45n W=1.04u
Mmn4 Y C0 VSS VSS g45n1svt M=1 L=45n W=1.04u
Mmn1 Y A1 net120 VSS g45n1svt M=1 L=45n W=1.04u
Mmn0 net120 A0 VSS VSS g45n1svt M=1 L=45n W=1.04u
Mmp3 net104 B1 net107 VDD g45p1svt M=1 L=45n W=1.56u
Mmp2 net104 B0 net107 VDD g45p1svt M=1 L=45n W=1.56u
Mmp0 net107 A0 VDD VDD g45p1svt M=1 L=45n W=1.56u
Mmp1 net107 A1 VDD VDD g45p1svt M=1 L=45n W=1.56u
Mmp4 Y C0 net104 VDD g45p1svt M=1 L=45n W=1.56u
.ENDS

.SUBCKT AOI221X2 A0 A1 B0 B1 C0 VDD VSS Y
Mmn2 Y B0 net116 VSS g45n1svt M=1 L=45n W=520n
Mmn3 net116 B1 VSS VSS g45n1svt M=1 L=45n W=520n
Mmn4 Y C0 VSS VSS g45n1svt M=1 L=45n W=520n
Mmn1 Y A1 net124 VSS g45n1svt M=1 L=45n W=520n
Mmn0 net124 A0 VSS VSS g45n1svt M=1 L=45n W=520n
Mmp3 net104 B1 net103 VDD g45p1svt M=1 L=45n W=780n
Mmp2 net104 B0 net103 VDD g45p1svt M=1 L=45n W=780n
Mmp0 net103 A0 VDD VDD g45p1svt M=1 L=45n W=780n
Mmp1 net103 A1 VDD VDD g45p1svt M=1 L=45n W=780n
Mmp4 Y C0 net104 VDD g45p1svt M=1 L=45n W=780n
.ENDS

.SUBCKT AOI221X1 A0 A1 B0 B1 C0 VDD VSS Y
Mmn2 net120 B0 VSS VSS g45n1svt M=1 L=45n W=260n
Mmn3 Y B1 net120 VSS g45n1svt M=1 L=45n W=260n
Mmn4 Y C0 VSS VSS g45n1svt M=1 L=45n W=260n
Mmn1 Y A1 net128 VSS g45n1svt M=1 L=45n W=260n
Mmn0 net128 A0 VSS VSS g45n1svt M=1 L=45n W=260n
Mmp3 net108 B1 net111 VDD g45p1svt M=1 L=45n W=390n
Mmp2 net108 B0 net111 VDD g45p1svt M=1 L=45n W=390n
Mmp0 net111 A0 VDD VDD g45p1svt M=1 L=45n W=390n
Mmp1 net111 A1 VDD VDD g45p1svt M=1 L=45n W=390n
Mmp4 Y C0 net108 VDD g45p1svt M=1 L=45n W=390n
.ENDS

.SUBCKT AOI21XL A0 A1 B0 VDD VSS Y
Mmn2 Y B0 VSS VSS g45n1svt M=1 L=45n W=145n
Mmn0 net74 A0 VSS VSS g45n1svt M=1 L=45n W=145n
Mmn1 Y A1 net74 VSS g45n1svt M=1 L=45n W=145n
Mmp2 Y B0 net70 VDD g45p1svt M=1 L=45n W=215n
Mmp1 net70 A1 VDD VDD g45p1svt M=1 L=45n W=215n
Mmp0 net70 A0 VDD VDD g45p1svt M=1 L=45n W=215n
.ENDS

.SUBCKT AOI21X4 A0 A1 B0 VDD VSS Y
Mmn2 Y B0 VSS VSS g45n1svt M=1 L=45n W=1.04u
Mmn0 net82 A0 VSS VSS g45n1svt M=1 L=45n W=1.04u
Mmn1 Y A1 net82 VSS g45n1svt M=1 L=45n W=1.04u
Mmp2 Y B0 net70 VDD g45p1svt M=1 L=45n W=1.56u
Mmp1 net70 A1 VDD VDD g45p1svt M=1 L=45n W=1.56u
Mmp0 net70 A0 VDD VDD g45p1svt M=1 L=45n W=1.56u
.ENDS

.SUBCKT AOI21X2 A0 A1 B0 VDD VSS Y
Mmn2 Y B0 VSS VSS g45n1svt M=1 L=45n W=520n
Mmn0 net74 A0 VSS VSS g45n1svt M=1 L=45n W=520n
Mmn1 Y A1 net74 VSS g45n1svt M=1 L=45n W=520n
Mmp2 Y B0 net70 VDD g45p1svt M=1 L=45n W=780n
Mmp1 net70 A1 VDD VDD g45p1svt M=1 L=45n W=780n
Mmp0 net70 A0 VDD VDD g45p1svt M=1 L=45n W=780n
.ENDS

.SUBCKT AOI21X1 A0 A1 B0 VDD VSS Y
Mmn2 Y B0 VSS VSS g45n1svt M=1 L=45n W=260n
Mmn0 net78 A0 VSS VSS g45n1svt M=1 L=45n W=260n
Mmn1 Y A1 net78 VSS g45n1svt M=1 L=45n W=260n
Mmp2 Y B0 net62 VDD g45p1svt M=1 L=45n W=390n
Mmp1 net62 A1 VDD VDD g45p1svt M=1 L=45n W=390n
Mmp0 net62 A0 VDD VDD g45p1svt M=1 L=45n W=390n
.ENDS

.SUBCKT AOI211XL A0 A1 B0 C0 VDD VSS Y
Mmn2 Y B0 VSS VSS g45n1svt M=1 L=45n W=145n
Mmn3 Y C0 VSS VSS g45n1svt M=1 L=45n W=145n
Mmn1 Y A1 net95 VSS g45n1svt M=1 L=45n W=145n
Mmn0 net95 A0 VSS VSS g45n1svt M=1 L=45n W=145n
Mmp3 Y C0 net82 VDD g45p1svt M=1 L=45n W=215n
Mmp2 net82 B0 net91 VDD g45p1svt M=1 L=45n W=215n
Mmp1 net91 A1 VDD VDD g45p1svt M=1 L=45n W=215n
Mmp0 net91 A0 VDD VDD g45p1svt M=1 L=45n W=215n
.ENDS

.SUBCKT AOI211X4 A0 A1 B0 C0 VDD VSS Y
Mmn2 Y B0 VSS VSS g45n1svt M=1 L=45n W=1.04u
Mmn3 Y C0 VSS VSS g45n1svt M=1 L=45n W=1.04u
Mmn1 Y A1 net99 VSS g45n1svt M=1 L=45n W=1.04u
Mmn0 net99 A0 VSS VSS g45n1svt M=1 L=45n W=1.04u
Mmp3 Y C0 net82 VDD g45p1svt M=1 L=45n W=1.56u
Mmp2 net82 B0 net91 VDD g45p1svt M=1 L=45n W=1.56u
Mmp1 net91 A1 VDD VDD g45p1svt M=1 L=45n W=1.56u
Mmp0 net91 A0 VDD VDD g45p1svt M=1 L=45n W=1.56u
.ENDS

.SUBCKT AOI211X2 A0 A1 B0 C0 VDD VSS Y
Mmn2 Y B0 VSS VSS g45n1svt M=1 L=45n W=520n
Mmn3 Y C0 VSS VSS g45n1svt M=1 L=45n W=520n
Mmn1 Y A1 net95 VSS g45n1svt M=1 L=45n W=520n
Mmn0 net95 A0 VSS VSS g45n1svt M=1 L=45n W=520n
Mmp3 Y C0 net82 VDD g45p1svt M=1 L=45n W=780n
Mmp2 net82 B0 net91 VDD g45p1svt M=1 L=45n W=780n
Mmp1 net91 A1 VDD VDD g45p1svt M=1 L=45n W=780n
Mmp0 net91 A0 VDD VDD g45p1svt M=1 L=45n W=780n
.ENDS

.SUBCKT AOI211X1 A0 A1 B0 C0 VDD VSS Y
Mmn2 Y B0 VSS VSS g45n1svt M=1 L=45n W=260n
Mmn3 Y C0 VSS VSS g45n1svt M=1 L=45n W=260n
Mmn1 Y A1 net95 VSS g45n1svt M=1 L=45n W=260n
Mmn0 net95 A0 VSS VSS g45n1svt M=1 L=45n W=260n
Mmp3 Y C0 net82 VDD g45p1svt M=1 L=45n W=390n
Mmp2 net82 B0 net91 VDD g45p1svt M=1 L=45n W=390n
Mmp1 net91 A1 VDD VDD g45p1svt M=1 L=45n W=390n
Mmp0 net91 A0 VDD VDD g45p1svt M=1 L=45n W=390n
.ENDS

.SUBCKT AO22XL A0 A1 B0 B1 VDD VSS Y
Mmn3 n0 B1 n2 VSS g45n1svt M=1 L=45n W=145n
Mmn2 n2 B0 VSS VSS g45n1svt M=1 L=45n W=145n
Mmn1 n0 A1 n1 VSS g45n1svt M=1 L=45n W=145n
Mmn0 n1 A0 VSS VSS g45n1svt M=1 L=45n W=145n
Mmn4 Y n0 VSS VSS g45n1svt M=1 L=45n W=145n
Mmp3 n0 B1 n3 VDD g45p1svt M=1 L=45n W=215n
Mmp2 n0 B0 n3 VDD g45p1svt M=1 L=45n W=215n
Mmp1 n3 A1 VDD VDD g45p1svt M=1 L=45n W=215n
Mmp0 n3 A0 VDD VDD g45p1svt M=1 L=45n W=215n
Mmp4 Y n0 VDD VDD g45p1svt M=1 L=45n W=215n
.ENDS

.SUBCKT AO22X4 A0 A1 B0 B1 VDD VSS Y
Mmn3 n0 B1 n2 VSS g45n1svt M=1 L=45n W=260n
Mmn2 n2 B0 VSS VSS g45n1svt M=1 L=45n W=260n
Mmn1 n0 A1 n1 VSS g45n1svt M=1 L=45n W=260n
Mmn0 n1 A0 VSS VSS g45n1svt M=1 L=45n W=260n
Mmn4 Y n0 VSS VSS g45n1svt M=1 L=45n W=1.04u
Mmp3 n0 B1 n3 VDD g45p1svt M=1 L=45n W=390n
Mmp2 n0 B0 n3 VDD g45p1svt M=1 L=45n W=390n
Mmp1 n3 A1 VDD VDD g45p1svt M=1 L=45n W=390n
Mmp0 n3 A0 VDD VDD g45p1svt M=1 L=45n W=390n
Mmp4 Y n0 VDD VDD g45p1svt M=1 L=45n W=1.56u
.ENDS

.SUBCKT AO22X2 A0 A1 B0 B1 VDD VSS Y
Mmn3 net128 B1 net132 VSS g45n1svt M=1 L=45n W=145n
Mmn2 net132 B0 VSS VSS g45n1svt M=1 L=45n W=145n
Mmn1 net128 A1 net124 VSS g45n1svt M=1 L=45n W=145n
Mmn0 net124 A0 VSS VSS g45n1svt M=1 L=45n W=145n
Mmn4 Y net128 VSS VSS g45n1svt M=1 L=45n W=520n
Mmp3 net128 B1 net111 VDD g45p1svt M=1 L=45n W=215n
Mmp2 net128 B0 net111 VDD g45p1svt M=1 L=45n W=215n
Mmp1 net111 A1 VDD VDD g45p1svt M=1 L=45n W=215n
Mmp0 net111 A0 VDD VDD g45p1svt M=1 L=45n W=215n
Mmp4 Y net128 VDD VDD g45p1svt M=1 L=45n W=780n
.ENDS

.SUBCKT AO22X1 A0 A1 B0 B1 VDD VSS Y
Mmn3 n0 B1 n2 VSS g45n1svt M=1 L=45n W=145n
Mmn2 n2 B0 VSS VSS g45n1svt M=1 L=45n W=145n
Mmn1 n0 A1 n1 VSS g45n1svt M=1 L=45n W=145n
Mmn0 n1 A0 VSS VSS g45n1svt M=1 L=45n W=145n
Mmn4 Y n0 VSS VSS g45n1svt M=1 L=45n W=260n
Mmp3 n0 B1 n3 VDD g45p1svt M=1 L=45n W=215n
Mmp2 n0 B0 n3 VDD g45p1svt M=1 L=45n W=215n
Mmp1 n3 A1 VDD VDD g45p1svt M=1 L=45n W=215n
Mmp0 n3 A0 VDD VDD g45p1svt M=1 L=45n W=215n
Mmp4 Y n0 VDD VDD g45p1svt M=1 L=45n W=390n
.ENDS

.SUBCKT AO21XL A0 A1 B0 VDD VSS Y
Mmn1 n0 A1 n1 VSS g45n1svt M=1 L=45n W=145n
Mmn0 n1 A0 VSS VSS g45n1svt M=1 L=45n W=145n
Mmn3 Y n0 VSS VSS g45n1svt M=1 L=45n W=145n
Mmn2 n0 B0 VSS VSS g45n1svt M=1 L=45n W=145n
Mmp1 n2 A1 VDD VDD g45p1svt M=1 L=45n W=215n
Mmp0 n2 A0 VDD VDD g45p1svt M=1 L=45n W=215n
Mmp3 Y n0 VDD VDD g45p1svt M=1 L=45n W=215n
Mmp2 n0 B0 n2 VDD g45p1svt M=1 L=45n W=215n
.ENDS

.SUBCKT AO21X4 A0 A1 B0 VDD VSS Y
Mmn1 net100 A1 net104 VSS g45n1svt M=1 L=45n W=260n
Mmn0 net104 A0 VSS VSS g45n1svt M=1 L=45n W=260n
Mmn3 Y net100 VSS VSS g45n1svt M=1 L=45n W=1.04u
Mmn2 net100 B0 VSS VSS g45n1svt M=1 L=45n W=260n
Mmp1 net88 A1 VDD VDD g45p1svt M=1 L=45n W=390n
Mmp0 net88 A0 VDD VDD g45p1svt M=1 L=45n W=390n
Mmp3 Y net100 VDD VDD g45p1svt M=1 L=45n W=1.56u
Mmp2 net100 B0 net88 VDD g45p1svt M=1 L=45n W=390n
.ENDS

.SUBCKT AO21X2 A0 A1 B0 VDD VSS Y
Mmn1 net100 A1 net104 VSS g45n1svt M=1 L=45n W=145n
Mmn0 net104 A0 VSS VSS g45n1svt M=1 L=45n W=145n
Mmn3 Y net100 VSS VSS g45n1svt M=1 L=45n W=520n
Mmn2 net100 B0 VSS VSS g45n1svt M=1 L=45n W=145n
Mmp1 net84 A1 VDD VDD g45p1svt M=1 L=45n W=215n
Mmp0 net84 A0 VDD VDD g45p1svt M=1 L=45n W=215n
Mmp3 Y net100 VDD VDD g45p1svt M=1 L=45n W=780n
Mmp2 net100 B0 net84 VDD g45p1svt M=1 L=45n W=215n
.ENDS

.SUBCKT AO21X1 A0 A1 B0 VDD VSS Y
Mmn1 net049 A1 net104 VSS g45n1svt M=1 L=45n W=145n
Mmn0 net104 A0 VSS VSS g45n1svt M=1 L=45n W=145n
Mmn3 Y net049 VSS VSS g45n1svt M=1 L=45n W=260n
Mmn2 net049 B0 VSS VSS g45n1svt M=1 L=45n W=145n
Mmp1 net96 A1 VDD VDD g45p1svt M=1 L=45n W=215n
Mmp0 net96 A0 VDD VDD g45p1svt M=1 L=45n W=215n
Mmp3 Y net049 VDD VDD g45p1svt M=1 L=45n W=390n
Mmp2 net049 B0 net96 VDD g45p1svt M=1 L=45n W=215n
.ENDS

.SUBCKT ANTENNA A VDD VSS
DD1 A VDD g45pd1svt AREA=188.8f PJ=1.82u M=1
DD0 VSS A g45nd1svt AREA=155.1f PJ=1.6u M=1
.ENDS

.SUBCKT AND4XL A B C D VDD VSS Y
Mmn3 net100 D net136 VSS g45n1svt M=1 L=45n W=145n
Mmn2 net136 C net128 VSS g45n1svt M=1 L=45n W=145n
Mmn4 Y net100 VSS VSS g45n1svt M=1 L=45n W=145n
Mmn1 net128 B net124 VSS g45n1svt M=1 L=45n W=145n
Mmn0 net124 A VSS VSS g45n1svt M=1 L=45n W=145n
Mmp3 net100 D VDD VDD g45p1svt M=1 L=45n W=215n
Mmp2 net100 C VDD VDD g45p1svt M=1 L=45n W=215n
Mmp1 net100 B VDD VDD g45p1svt M=1 L=45n W=215n
Mmp4 Y net100 VDD VDD g45p1svt M=1 L=45n W=215n
Mmp0 net100 A VDD VDD g45p1svt M=1 L=45n W=215n
.ENDS

.SUBCKT AND4X8 A B C D VDD VSS Y
Mmn3 net116 D net132 VSS g45n1svt M=1 L=45n W=520n
Mmn2 net132 C net128 VSS g45n1svt M=1 L=45n W=520n
Mmn4 Y net116 VSS VSS g45n1svt M=1 L=45n W=2.065u
Mmn1 net128 B net124 VSS g45n1svt M=1 L=45n W=520n
Mmn0 net124 A VSS VSS g45n1svt M=1 L=45n W=520n
Mmp3 net116 D VDD VDD g45p1svt M=1 L=45n W=780n
Mmp2 net116 C VDD VDD g45p1svt M=1 L=45n W=780n
Mmp1 net116 B VDD VDD g45p1svt M=1 L=45n W=780n
Mmp4 Y net116 VDD VDD g45p1svt M=1 L=45n W=3.115u
Mmp0 net116 A VDD VDD g45p1svt M=1 L=45n W=780n
.ENDS

.SUBCKT AND4X6 A B C D VDD VSS Y
Mmn3 net116 D net132 VSS g45n1svt M=1 L=45n W=520n
Mmn2 net132 C net128 VSS g45n1svt M=1 L=45n W=520n
Mmn4 Y net116 VSS VSS g45n1svt M=1 L=45n W=1.55u
Mmn1 net128 B net124 VSS g45n1svt M=1 L=45n W=520n
Mmn0 net124 A VSS VSS g45n1svt M=1 L=45n W=520n
Mmp3 net116 D VDD VDD g45p1svt M=1 L=45n W=780n
Mmp2 net116 C VDD VDD g45p1svt M=1 L=45n W=780n
Mmp1 net116 B VDD VDD g45p1svt M=1 L=45n W=780n
Mmp4 Y net116 VDD VDD g45p1svt M=1 L=45n W=2.35u
Mmp0 net116 A VDD VDD g45p1svt M=1 L=45n W=780n
.ENDS

.SUBCKT AND4X4 A B C D VDD VSS Y
Mmn3 net100 D net132 VSS g45n1svt M=1 L=45n W=260n
Mmn2 net132 C net124 VSS g45n1svt M=1 L=45n W=260n
Mmn4 Y net100 VSS VSS g45n1svt M=1 L=45n W=1.04u
Mmn1 net124 B net120 VSS g45n1svt M=1 L=45n W=260n
Mmn0 net120 A VSS VSS g45n1svt M=1 L=45n W=260n
Mmp3 net100 D VDD VDD g45p1svt M=1 L=45n W=390n
Mmp2 net100 C VDD VDD g45p1svt M=1 L=45n W=390n
Mmp1 net100 B VDD VDD g45p1svt M=1 L=45n W=390n
Mmp4 Y net100 VDD VDD g45p1svt M=1 L=45n W=1.56u
Mmp0 net100 A VDD VDD g45p1svt M=1 L=45n W=390n
.ENDS

.SUBCKT AND4X2 A B C D VDD VSS Y
Mmn3 net100 D net132 VSS g45n1svt M=1 L=45n W=145n
Mmn2 net132 C net124 VSS g45n1svt M=1 L=45n W=145n
Mmn4 Y net100 VSS VSS g45n1svt M=1 L=45n W=520n
Mmn1 net124 B net120 VSS g45n1svt M=1 L=45n W=145n
Mmn0 net120 A VSS VSS g45n1svt M=1 L=45n W=145n
Mmp3 net100 D VDD VDD g45p1svt M=1 L=45n W=215n
Mmp2 net100 C VDD VDD g45p1svt M=1 L=45n W=215n
Mmp1 net100 B VDD VDD g45p1svt M=1 L=45n W=215n
Mmp4 Y net100 VDD VDD g45p1svt M=1 L=45n W=780n
Mmp0 net100 A VDD VDD g45p1svt M=1 L=45n W=215n
.ENDS

.SUBCKT AND4X1 A B C D VDD VSS Y
Mmn3 net116 D net132 VSS g45n1svt M=1 L=45n W=145n
Mmn2 net132 C net128 VSS g45n1svt M=1 L=45n W=145n
Mmn4 Y net116 VSS VSS g45n1svt M=1 L=45n W=260n
Mmn1 net128 B net124 VSS g45n1svt M=1 L=45n W=145n
Mmn0 net124 A VSS VSS g45n1svt M=1 L=45n W=145n
Mmp3 net116 D VDD VDD g45p1svt M=1 L=45n W=215n
Mmp2 net116 C VDD VDD g45p1svt M=1 L=45n W=215n
Mmp1 net116 B VDD VDD g45p1svt M=1 L=45n W=215n
Mmp4 Y net116 VDD VDD g45p1svt M=1 L=45n W=390n
Mmp0 net116 A VDD VDD g45p1svt M=1 L=45n W=215n
.ENDS

.SUBCKT AND3XL A B C VDD VSS Y
Mmn3 Y net87 VSS VSS g45n1svt M=1 L=45n W=145n
Mmn1 net107 B net103 VSS g45n1svt M=1 L=45n W=145n
Mmn0 net103 A VSS VSS g45n1svt M=1 L=45n W=145n
Mmn2 net87 C net107 VSS g45n1svt M=1 L=45n W=145n
Mmp1 net87 B VDD VDD g45p1svt M=1 L=45n W=215n
Mmp2 net87 C VDD VDD g45p1svt M=1 L=45n W=215n
Mmp0 net87 A VDD VDD g45p1svt M=1 L=45n W=215n
Mmp3 Y net87 VDD VDD g45p1svt M=1 L=45n W=215n
.ENDS

.SUBCKT AND3X8 A B C VDD VSS Y
Mmn3 Y net95 VSS VSS g45n1svt M=1 L=45n W=2.065u
Mmn1 net107 B net103 VSS g45n1svt M=1 L=45n W=520n
Mmn0 net103 A VSS VSS g45n1svt M=1 L=45n W=520n
Mmn2 net95 C net107 VSS g45n1svt M=1 L=45n W=520n
Mmp1 net95 B VDD VDD g45p1svt M=1 L=45n W=780n
Mmp2 net95 C VDD VDD g45p1svt M=1 L=45n W=780n
Mmp0 net95 A VDD VDD g45p1svt M=1 L=45n W=780n
Mmp3 Y net95 VDD VDD g45p1svt M=1 L=45n W=3.115u
.ENDS

.SUBCKT AND3X6 A B C VDD VSS Y
Mmn3 Y net95 VSS VSS g45n1svt M=1 L=45n W=1.55u
Mmn1 net107 B net103 VSS g45n1svt M=1 L=45n W=520n
Mmn0 net103 A VSS VSS g45n1svt M=1 L=45n W=520n
Mmn2 net95 C net107 VSS g45n1svt M=1 L=45n W=520n
Mmp1 net95 B VDD VDD g45p1svt M=1 L=45n W=780n
Mmp2 net95 C VDD VDD g45p1svt M=1 L=45n W=780n
Mmp0 net95 A VDD VDD g45p1svt M=1 L=45n W=780n
Mmp3 Y net95 VDD VDD g45p1svt M=1 L=45n W=2.35u
.ENDS

.SUBCKT AND3X4 A B C VDD VSS Y
Mmn3 Y net95 VSS VSS g45n1svt M=1 L=45n W=1.04u
Mmn1 net111 B net107 VSS g45n1svt M=1 L=45n W=260n
Mmn0 net107 A VSS VSS g45n1svt M=1 L=45n W=260n
Mmn2 net95 C net111 VSS g45n1svt M=1 L=45n W=260n
Mmp1 net95 B VDD VDD g45p1svt M=1 L=45n W=390n
Mmp2 net95 C VDD VDD g45p1svt M=1 L=45n W=390n
Mmp0 net95 A VDD VDD g45p1svt M=1 L=45n W=390n
Mmp3 Y net95 VDD VDD g45p1svt M=1 L=45n W=1.56u
.ENDS

.SUBCKT AND3X2 A B C VDD VSS Y
Mmn3 Y net95 VSS VSS g45n1svt M=1 L=45n W=520n
Mmn1 net111 B net103 VSS g45n1svt M=1 L=45n W=145n
Mmn0 net103 A VSS VSS g45n1svt M=1 L=45n W=145n
Mmn2 net95 C net111 VSS g45n1svt M=1 L=45n W=145n
Mmp1 net95 B VDD VDD g45p1svt M=1 L=45n W=215n
Mmp2 net95 C VDD VDD g45p1svt M=1 L=45n W=215n
Mmp0 net95 A VDD VDD g45p1svt M=1 L=45n W=215n
Mmp3 Y net95 VDD VDD g45p1svt M=1 L=45n W=780n
.ENDS

.SUBCKT AND3X1 A B C VDD VSS Y
Mmn3 Y net086 VSS VSS g45n1svt M=1 L=45n W=260n
Mmn1 net0106 B net0102 VSS g45n1svt M=1 L=45n W=145n
Mmn0 net0102 A VSS VSS g45n1svt M=1 L=45n W=145n
Mmn2 net086 C net0106 VSS g45n1svt M=1 L=45n W=145n
Mmp1 net086 B VDD VDD g45p1svt M=1 L=45n W=215n
Mmp2 net086 C VDD VDD g45p1svt M=1 L=45n W=215n
Mmp0 net086 A VDD VDD g45p1svt M=1 L=45n W=215n
Mmp3 Y net086 VDD VDD g45p1svt M=1 L=45n W=390n
.ENDS

.SUBCKT AND2XL A B VDD VSS Y
Mmn2 Y net57 VSS VSS g45n1svt M=1 L=45n W=145n
Mmn0 net73 A VSS VSS g45n1svt M=1 L=45n W=145n
Mmn1 net57 B net73 VSS g45n1svt M=1 L=45n W=145n
Mmp1 net57 B VDD VDD g45p1svt M=1 L=45n W=215n
Mmp0 net57 A VDD VDD g45p1svt M=1 L=45n W=215n
Mmp2 Y net57 VDD VDD g45p1svt M=1 L=45n W=215n
.ENDS

.SUBCKT AND2X8 A B VDD VSS Y
Mmn2 Y n0 VSS VSS g45n1svt M=1 L=45n W=2.065u
Mmn0 net69 A VSS VSS g45n1svt M=1 L=45n W=520n
Mmn1 n0 B net69 VSS g45n1svt M=1 L=45n W=520n
Mmp1 n0 B VDD VDD g45p1svt M=1 L=45n W=780n
Mmp0 n0 A VDD VDD g45p1svt M=1 L=45n W=780n
Mmp2 Y n0 VDD VDD g45p1svt M=1 L=45n W=3.115u
.ENDS

.SUBCKT AND2X6 A B VDD VSS Y
Mmn2 Y net61 VSS VSS g45n1svt M=1 L=45n W=1.55u
Mmn0 net61 B net69 VSS g45n1svt M=1 L=45n W=520n
Mmn1 net69 A VSS VSS g45n1svt M=1 L=45n W=520n
Mmp1 net61 B VDD VDD g45p1svt M=1 L=45n W=780n
Mmp0 net61 A VDD VDD g45p1svt M=1 L=45n W=780n
Mmp2 Y net61 VDD VDD g45p1svt M=1 L=45n W=2.35u
.ENDS

.SUBCKT AND2X4 A B VDD VSS Y
Mmn2 Y net61 VSS VSS g45n1svt M=1 L=45n W=1.04u
Mmn0 net69 A VSS VSS g45n1svt M=1 L=45n W=260n
Mmn1 net61 B net69 VSS g45n1svt M=1 L=45n W=260n
Mmp1 net61 B VDD VDD g45p1svt M=1 L=45n W=390n
Mmp0 net61 A VDD VDD g45p1svt M=1 L=45n W=390n
Mmp2 Y net61 VDD VDD g45p1svt M=1 L=45n W=1.56u
.ENDS

.SUBCKT AND2X2 A B VDD VSS Y
Mmn2 Y n0 VSS VSS g45n1svt M=1 L=45n W=520n
Mmn0 net73 A VSS VSS g45n1svt M=1 L=45n W=145n
Mmn1 n0 B net73 VSS g45n1svt M=1 L=45n W=145n
Mmp1 n0 B VDD VDD g45p1svt M=1 L=45n W=215n
Mmp0 n0 A VDD VDD g45p1svt M=1 L=45n W=215n
Mmp2 Y n0 VDD VDD g45p1svt M=1 L=45n W=780n
.ENDS

.SUBCKT ADDHXL A B CO S VDD VSS
Mmn8 CO COb VSS VSS g45n1svt M=1 L=45n W=145n
Mmn7 COb B n4 VSS g45n1svt M=1 L=45n W=145n
Mmn6 n4 A VSS VSS g45n1svt M=1 L=45n W=145n
Mmn5 S Sb VSS VSS g45n1svt M=1 L=45n W=145n
Mmn3 Sb B n2 VSS g45n1svt M=1 L=45n W=145n
Mmn2 n2 n0 VSS VSS g45n1svt M=1 L=45n W=145n
Mmn1 n1 B VSS VSS g45n1svt M=1 L=45n W=145n
Mmn4 Sb n1 n0 VSS g45n1svt M=1 L=45n W=145n
Mmn0 n0 A VSS VSS g45n1svt M=1 L=45n W=145n
Mmp8 CO COb VDD VDD g45p1svt M=1 L=45n W=215n
Mmp5 S Sb VDD VDD g45p1svt M=1 L=45n W=215n
Mmp2 n3 n0 VDD VDD g45p1svt M=1 L=45n W=215n
Mmp3 Sb n1 n3 VDD g45p1svt M=1 L=45n W=215n
Mmp4 Sb B n0 VDD g45p1svt M=1 L=45n W=215n
Mmp1 n1 B VDD VDD g45p1svt M=1 L=45n W=215n
Mmp7 COb B VDD VDD g45p1svt M=1 L=45n W=215n
Mmp0 n0 A VDD VDD g45p1svt M=1 L=45n W=215n
Mmp6 COb A VDD VDD g45p1svt M=1 L=45n W=215n
.ENDS

.SUBCKT ADDHX4 A B CO S VDD VSS
Mmn8 CO COb VSS VSS g45n1svt M=1 L=45n W=1.04u
Mmn7 COb B n4 VSS g45n1svt M=1 L=45n W=260n
Mmn6 n4 A VSS VSS g45n1svt M=1 L=45n W=260n
Mmn5 S Sb VSS VSS g45n1svt M=1 L=45n W=1.04u
Mmn3 Sb B n2 VSS g45n1svt M=1 L=45n W=260n
Mmn2 n2 n0 VSS VSS g45n1svt M=1 L=45n W=260n
Mmn1 n1 B VSS VSS g45n1svt M=1 L=45n W=145n
Mmn4 Sb n1 n0 VSS g45n1svt M=1 L=45n W=260n
Mmn0 n0 A VSS VSS g45n1svt M=1 L=45n W=145n
Mmp8 CO COb VDD VDD g45p1svt M=1 L=45n W=1.56u
Mmp5 S Sb VDD VDD g45p1svt M=1 L=45n W=1.56u
Mmp2 n3 n0 VDD VDD g45p1svt M=1 L=45n W=390n
Mmp3 Sb n1 n3 VDD g45p1svt M=1 L=45n W=390n
Mmp4 Sb B n0 VDD g45p1svt M=1 L=45n W=390n
Mmp1 n1 B VDD VDD g45p1svt M=1 L=45n W=215n
Mmp7 COb B VDD VDD g45p1svt M=1 L=45n W=390n
Mmp0 n0 A VDD VDD g45p1svt M=1 L=45n W=215n
Mmp6 COb A VDD VDD g45p1svt M=1 L=45n W=390n
.ENDS

.SUBCKT ADDHX2 A B CO S VDD VSS
Mmn8 CO COb VSS VSS g45n1svt M=1 L=45n W=520n
Mmn7 COb B n4 VSS g45n1svt M=1 L=45n W=145n
Mmn6 n4 A VSS VSS g45n1svt M=1 L=45n W=145n
Mmn5 S Sb VSS VSS g45n1svt M=1 L=45n W=520n
Mmn3 Sb B n2 VSS g45n1svt M=1 L=45n W=145n
Mmn2 n2 n0 VSS VSS g45n1svt M=1 L=45n W=145n
Mmn1 n1 B VSS VSS g45n1svt M=1 L=45n W=145n
Mmn4 Sb n1 n0 VSS g45n1svt M=1 L=45n W=145n
Mmn0 n0 A VSS VSS g45n1svt M=1 L=45n W=145n
Mmp8 CO COb VDD VDD g45p1svt M=1 L=45n W=780n
Mmp5 S Sb VDD VDD g45p1svt M=1 L=45n W=780n
Mmp2 n3 n0 VDD VDD g45p1svt M=1 L=45n W=215n
Mmp3 Sb n1 n3 VDD g45p1svt M=1 L=45n W=215n
Mmp4 Sb B n0 VDD g45p1svt M=1 L=45n W=215n
Mmp1 n1 B VDD VDD g45p1svt M=1 L=45n W=215n
Mmp7 COb B VDD VDD g45p1svt M=1 L=45n W=215n
Mmp0 n0 A VDD VDD g45p1svt M=1 L=45n W=215n
Mmp6 COb A VDD VDD g45p1svt M=1 L=45n W=215n
.ENDS

.SUBCKT ADDHX1 A B CO S VDD VSS
Mmn8 CO COb VSS VSS g45n1svt M=1 L=45n W=260n
Mmn7 COb B n4 VSS g45n1svt M=1 L=45n W=145n
Mmn6 n4 A VSS VSS g45n1svt M=1 L=45n W=145n
Mmn5 S Sb VSS VSS g45n1svt M=1 L=45n W=260n
Mmn3 Sb B n2 VSS g45n1svt M=1 L=45n W=145n
Mmn2 n2 n0 VSS VSS g45n1svt M=1 L=45n W=145n
Mmn1 n1 B VSS VSS g45n1svt M=1 L=45n W=145n
Mmn4 Sb n1 n0 VSS g45n1svt M=1 L=45n W=145n
Mmn0 n0 A VSS VSS g45n1svt M=1 L=45n W=145n
Mmp8 CO COb VDD VDD g45p1svt M=1 L=45n W=390n
Mmp5 S Sb VDD VDD g45p1svt M=1 L=45n W=390n
Mmp2 n3 n0 VDD VDD g45p1svt M=1 L=45n W=215n
Mmp3 Sb n1 n3 VDD g45p1svt M=1 L=45n W=215n
Mmp4 Sb B n0 VDD g45p1svt M=1 L=45n W=215n
Mmp1 n1 B VDD VDD g45p1svt M=1 L=45n W=215n
Mmp7 COb B VDD VDD g45p1svt M=1 L=45n W=215n
Mmp0 n0 A VDD VDD g45p1svt M=1 L=45n W=215n
Mmp6 COb A VDD VDD g45p1svt M=1 L=45n W=215n
.ENDS

.SUBCKT ADDFXL A B CI CO S VDD VSS
Mmn9 n6 A VSS VSS g45n1svt M=1 L=45n W=145n
Mmn10 n7 B n6 VSS g45n1svt M=1 L=45n W=145n
Mmn11 Sb CI n7 VSS g45n1svt M=1 L=45n W=145n
Mmn13 S Sb VSS VSS g45n1svt M=1 L=45n W=145n
Mmn12 CO COb VSS VSS g45n1svt M=1 L=45n W=145n
Mmn1 COb B n0 VSS g45n1svt M=1 L=45n W=145n
Mmn2 n2 A VSS VSS g45n1svt M=1 L=45n W=145n
Mmn0 n0 A VSS VSS g45n1svt M=1 L=45n W=145n
Mmn7 n4 CI VSS VSS g45n1svt M=1 L=45n W=145n
Mmn8 Sb COb n4 VSS g45n1svt M=1 L=45n W=145n
Mmn3 n2 B VSS VSS g45n1svt M=1 L=45n W=145n
Mmn6 n4 B VSS VSS g45n1svt M=1 L=45n W=145n
Mmn5 n4 A VSS VSS g45n1svt M=1 L=45n W=145n
Mmn4 COb CI n2 VSS g45n1svt M=1 L=45n W=145n
Mmp9 n8 A VDD VDD g45p1svt M=1 L=45n W=215n
Mmp10 n9 B n8 VDD g45p1svt M=1 L=45n W=215n
Mmp11 Sb CI n9 VDD g45p1svt M=1 L=45n W=215n
Mmp13 S Sb VDD VDD g45p1svt M=1 L=45n W=215n
Mmp12 CO COb VDD VDD g45p1svt M=1 L=45n W=215n
Mmp1 COb B n1 VDD g45p1svt M=1 L=45n W=215n
Mmp0 n1 A VDD VDD g45p1svt M=1 L=45n W=215n
Mmp2 n3 A VDD VDD g45p1svt M=1 L=45n W=215n
Mmp4 COb CI n3 VDD g45p1svt M=1 L=45n W=215n
Mmp5 n5 A VDD VDD g45p1svt M=1 L=45n W=215n
Mmp6 n5 B VDD VDD g45p1svt M=1 L=45n W=215n
Mmp7 n5 CI VDD VDD g45p1svt M=1 L=45n W=215n
Mmp3 n3 B VDD VDD g45p1svt M=1 L=45n W=215n
Mmp8 Sb COb n5 VDD g45p1svt M=1 L=45n W=215n
.ENDS

.SUBCKT ADDFX4 A B CI CO S VDD VSS
Mmn9 n6 A VSS VSS g45n1svt M=1 L=45n W=260n
Mmn10 n7 B n6 VSS g45n1svt M=1 L=45n W=260n
Mmn11 Sb CI n7 VSS g45n1svt M=1 L=45n W=260n
Mmn13 S Sb VSS VSS g45n1svt M=1 L=45n W=1.04u
Mmn12 CO COb VSS VSS g45n1svt M=1 L=45n W=1.04u
Mmn1 COb B n0 VSS g45n1svt M=1 L=45n W=260n
Mmn2 n2 A VSS VSS g45n1svt M=1 L=45n W=260n
Mmn0 n0 A VSS VSS g45n1svt M=1 L=45n W=260n
Mmn7 n4 CI VSS VSS g45n1svt M=1 L=45n W=260n
Mmn8 Sb COb n4 VSS g45n1svt M=1 L=45n W=260n
Mmn3 n2 B VSS VSS g45n1svt M=1 L=45n W=260n
Mmn6 n4 B VSS VSS g45n1svt M=1 L=45n W=260n
Mmn5 n4 A VSS VSS g45n1svt M=1 L=45n W=260n
Mmn4 COb CI n2 VSS g45n1svt M=1 L=45n W=260n
Mmp9 n8 A VDD VDD g45p1svt M=1 L=45n W=390n
Mmp10 n9 B n8 VDD g45p1svt M=1 L=45n W=390n
Mmp11 Sb CI n9 VDD g45p1svt M=1 L=45n W=390n
Mmp13 S Sb VDD VDD g45p1svt M=1 L=45n W=1.56u
Mmp12 CO COb VDD VDD g45p1svt M=1 L=45n W=1.56u
Mmp1 COb B n1 VDD g45p1svt M=1 L=45n W=390n
Mmp0 n1 A VDD VDD g45p1svt M=1 L=45n W=390n
Mmp2 n3 A VDD VDD g45p1svt M=1 L=45n W=390n
Mmp4 COb CI n3 VDD g45p1svt M=1 L=45n W=390n
Mmp5 n5 A VDD VDD g45p1svt M=1 L=45n W=390n
Mmp6 n5 B VDD VDD g45p1svt M=1 L=45n W=390n
Mmp7 n5 CI VDD VDD g45p1svt M=1 L=45n W=390n
Mmp3 n3 B VDD VDD g45p1svt M=1 L=45n W=390n
Mmp8 Sb COb n5 VDD g45p1svt M=1 L=45n W=390n
.ENDS

.SUBCKT ADDFX2 A B CI CO S VDD VSS
Mmn9 n6 A VSS VSS g45n1svt M=1 L=45n W=145n
Mmn10 n7 B n6 VSS g45n1svt M=1 L=45n W=145n
Mmn11 Sb CI n7 VSS g45n1svt M=1 L=45n W=145n
Mmn13 S Sb VSS VSS g45n1svt M=1 L=45n W=520n
Mmn12 CO COb VSS VSS g45n1svt M=1 L=45n W=520n
Mmn1 COb B n0 VSS g45n1svt M=1 L=45n W=145n
Mmn2 n2 A VSS VSS g45n1svt M=1 L=45n W=145n
Mmn0 n0 A VSS VSS g45n1svt M=1 L=45n W=145n
Mmn7 n4 CI VSS VSS g45n1svt M=1 L=45n W=145n
Mmn8 Sb COb n4 VSS g45n1svt M=1 L=45n W=145n
Mmn3 n2 B VSS VSS g45n1svt M=1 L=45n W=145n
Mmn6 n4 B VSS VSS g45n1svt M=1 L=45n W=145n
Mmn5 n4 A VSS VSS g45n1svt M=1 L=45n W=145n
Mmn4 COb CI n2 VSS g45n1svt M=1 L=45n W=145n
Mmp9 n8 A VDD VDD g45p1svt M=1 L=45n W=215n
Mmp10 n9 B n8 VDD g45p1svt M=1 L=45n W=215n
Mmp11 Sb CI n9 VDD g45p1svt M=1 L=45n W=215n
Mmp13 S Sb VDD VDD g45p1svt M=1 L=45n W=780n
Mmp12 CO COb VDD VDD g45p1svt M=1 L=45n W=780n
Mmp1 COb B n1 VDD g45p1svt M=1 L=45n W=215n
Mmp0 n1 A VDD VDD g45p1svt M=1 L=45n W=215n
Mmp2 n3 A VDD VDD g45p1svt M=1 L=45n W=215n
Mmp4 COb CI n3 VDD g45p1svt M=1 L=45n W=215n
Mmp5 n5 A VDD VDD g45p1svt M=1 L=45n W=215n
Mmp6 n5 B VDD VDD g45p1svt M=1 L=45n W=215n
Mmp7 n5 CI VDD VDD g45p1svt M=1 L=45n W=215n
Mmp3 n3 B VDD VDD g45p1svt M=1 L=45n W=215n
Mmp8 Sb COb n5 VDD g45p1svt M=1 L=45n W=215n
.ENDS

.SUBCKT ADDFX1 A B CI CO S VDD VSS
Mmn9 n6 A VSS VSS g45n1svt M=1 L=45n W=145n
Mmn10 n7 B n6 VSS g45n1svt M=1 L=45n W=145n
Mmn11 Sb CI n7 VSS g45n1svt M=1 L=45n W=145n
Mmn13 S Sb VSS VSS g45n1svt M=1 L=45n W=260n
Mmn12 CO COb VSS VSS g45n1svt M=1 L=45n W=260n
Mmn1 COb B n0 VSS g45n1svt M=1 L=45n W=145n
Mmn2 n2 A VSS VSS g45n1svt M=1 L=45n W=145n
Mmn0 n0 A VSS VSS g45n1svt M=1 L=45n W=145n
Mmn7 n4 CI VSS VSS g45n1svt M=1 L=45n W=145n
Mmn8 Sb COb n4 VSS g45n1svt M=1 L=45n W=145n
Mmn3 n2 B VSS VSS g45n1svt M=1 L=45n W=145n
Mmn6 n4 B VSS VSS g45n1svt M=1 L=45n W=145n
Mmn5 n4 A VSS VSS g45n1svt M=1 L=45n W=145n
Mmn4 COb CI n2 VSS g45n1svt M=1 L=45n W=145n
Mmp9 n8 A VDD VDD g45p1svt M=1 L=45n W=215n
Mmp10 n9 B n8 VDD g45p1svt M=1 L=45n W=215n
Mmp11 Sb CI n9 VDD g45p1svt M=1 L=45n W=215n
Mmp13 S Sb VDD VDD g45p1svt M=1 L=45n W=390n
Mmp12 CO COb VDD VDD g45p1svt M=1 L=45n W=390n
Mmp1 COb B n1 VDD g45p1svt M=1 L=45n W=215n
Mmp0 n1 A VDD VDD g45p1svt M=1 L=45n W=215n
Mmp2 n3 A VDD VDD g45p1svt M=1 L=45n W=215n
Mmp4 COb CI n3 VDD g45p1svt M=1 L=45n W=215n
Mmp5 n5 A VDD VDD g45p1svt M=1 L=45n W=215n
Mmp6 n5 B VDD VDD g45p1svt M=1 L=45n W=215n
Mmp7 n5 CI VDD VDD g45p1svt M=1 L=45n W=215n
Mmp3 n3 B VDD VDD g45p1svt M=1 L=45n W=215n
Mmp8 Sb COb n5 VDD g45p1svt M=1 L=45n W=215n
.ENDS

.SUBCKT ADDFHXL A B CI CO S VDD VSS
Mmn5 n4 A VSS VSS g45n1svt M=1 L=45n W=205n
Mmn6 n4 B VSS VSS g45n1svt M=1 L=45n W=205n
Mmn4 COb CI n2 VSS g45n1svt M=1 L=45n W=205n
Mmn3 n2 B VSS VSS g45n1svt M=1 L=45n W=205n
Mmn2 n2 A VSS VSS g45n1svt M=1 L=45n W=205n
Mmn7 n4 CI VSS VSS g45n1svt M=1 L=45n W=205n
Mmn8 Sb COb n4 VSS g45n1svt M=1 L=45n W=205n
Mmn0 n0 A VSS VSS g45n1svt M=1 L=45n W=205n
Mmn1 COb B n0 VSS g45n1svt M=1 L=45n W=205n
Mmn12 CO COb VSS VSS g45n1svt M=1 L=45n W=205n
Mmn13 S Sb VSS VSS g45n1svt M=1 L=45n W=205n
Mmn11 Sb CI n7 VSS g45n1svt M=1 L=45n W=205n
Mmn10 n7 B n6 VSS g45n1svt M=1 L=45n W=205n
Mmn9 n6 A VSS VSS g45n1svt M=1 L=45n W=205n
Mmp2 n3 A VDD VDD g45p1svt M=1 L=45n W=310n
Mmp3 n3 B VDD VDD g45p1svt M=1 L=45n W=310n
Mmp4 COb CI n3 VDD g45p1svt M=1 L=45n W=310n
Mmp5 n5 A VDD VDD g45p1svt M=1 L=45n W=310n
Mmp6 n5 B VDD VDD g45p1svt M=1 L=45n W=310n
Mmp7 n5 CI VDD VDD g45p1svt M=1 L=45n W=310n
Mmp8 Sb COb n5 VDD g45p1svt M=1 L=45n W=310n
Mmp0 n1 A VDD VDD g45p1svt M=1 L=45n W=310n
Mmp1 COb B n1 VDD g45p1svt M=1 L=45n W=310n
Mmp12 CO COb VDD VDD g45p1svt M=1 L=45n W=310n
Mmp13 S Sb VDD VDD g45p1svt M=1 L=45n W=310n
Mmp11 Sb CI n9 VDD g45p1svt M=1 L=45n W=310n
Mmp10 n9 B n8 VDD g45p1svt M=1 L=45n W=310n
Mmp9 n8 A VDD VDD g45p1svt M=1 L=45n W=310n
.ENDS

.SUBCKT ADDFHX4 A B CI CO S VDD VSS
Mmn5 n4 A VSS VSS g45n1svt M=1 L=45n W=260n
Mmn6 n4 B VSS VSS g45n1svt M=1 L=45n W=260n
Mmn4 COb CI n2 VSS g45n1svt M=1 L=45n W=260n
Mmn3 n2 B VSS VSS g45n1svt M=1 L=45n W=260n
Mmn2 n2 A VSS VSS g45n1svt M=1 L=45n W=260n
Mmn7 n4 CI VSS VSS g45n1svt M=1 L=45n W=260n
Mmn8 Sb COb n4 VSS g45n1svt M=1 L=45n W=260n
Mmn0 n0 A VSS VSS g45n1svt M=1 L=45n W=260n
Mmn1 COb B n0 VSS g45n1svt M=1 L=45n W=260n
Mmn12 CO COb VSS VSS g45n1svt M=1 L=45n W=1.04u
Mmn13 S Sb VSS VSS g45n1svt M=1 L=45n W=1.04u
Mmn11 Sb CI n7 VSS g45n1svt M=1 L=45n W=260n
Mmn10 n7 B n6 VSS g45n1svt M=1 L=45n W=260n
Mmn9 n6 A VSS VSS g45n1svt M=1 L=45n W=260n
Mmp2 n3 A VDD VDD g45p1svt M=1 L=45n W=390n
Mmp3 n3 B VDD VDD g45p1svt M=1 L=45n W=390n
Mmp4 COb CI n3 VDD g45p1svt M=1 L=45n W=390n
Mmp5 n5 A VDD VDD g45p1svt M=1 L=45n W=390n
Mmp6 n5 B VDD VDD g45p1svt M=1 L=45n W=390n
Mmp7 n5 CI VDD VDD g45p1svt M=1 L=45n W=390n
Mmp8 Sb COb n5 VDD g45p1svt M=1 L=45n W=390n
Mmp0 n1 A VDD VDD g45p1svt M=1 L=45n W=390n
Mmp1 COb B n1 VDD g45p1svt M=1 L=45n W=390n
Mmp12 CO COb VDD VDD g45p1svt M=1 L=45n W=1.56u
Mmp13 S Sb VDD VDD g45p1svt M=1 L=45n W=1.56u
Mmp11 Sb CI n9 VDD g45p1svt M=1 L=45n W=390n
Mmp10 n9 B n8 VDD g45p1svt M=1 L=45n W=390n
Mmp9 n8 A VDD VDD g45p1svt M=1 L=45n W=390n
.ENDS

.SUBCKT ADDFHX2 A B CI CO S VDD VSS
Mmn5 n4 A VSS VSS g45n1svt M=1 L=45n W=205n
Mmn6 n4 B VSS VSS g45n1svt M=1 L=45n W=205n
Mmn4 COb CI n2 VSS g45n1svt M=1 L=45n W=205n
Mmn3 n2 B VSS VSS g45n1svt M=1 L=45n W=205n
Mmn2 n2 A VSS VSS g45n1svt M=1 L=45n W=205n
Mmn7 n4 CI VSS VSS g45n1svt M=1 L=45n W=205n
Mmn8 Sb COb n4 VSS g45n1svt M=1 L=45n W=205n
Mmn0 n0 A VSS VSS g45n1svt M=1 L=45n W=205n
Mmn1 COb B n0 VSS g45n1svt M=1 L=45n W=205n
Mmn12 CO COb VSS VSS g45n1svt M=1 L=45n W=520n
Mmn13 S Sb VSS VSS g45n1svt M=1 L=45n W=520n
Mmn11 Sb CI n7 VSS g45n1svt M=1 L=45n W=205n
Mmn10 n7 B n6 VSS g45n1svt M=1 L=45n W=205n
Mmn9 n6 A VSS VSS g45n1svt M=1 L=45n W=205n
Mmp2 n3 A VDD VDD g45p1svt M=1 L=45n W=310n
Mmp3 n3 B VDD VDD g45p1svt M=1 L=45n W=310n
Mmp4 COb CI n3 VDD g45p1svt M=1 L=45n W=310n
Mmp5 n5 A VDD VDD g45p1svt M=1 L=45n W=310n
Mmp6 n5 B VDD VDD g45p1svt M=1 L=45n W=310n
Mmp7 n5 CI VDD VDD g45p1svt M=1 L=45n W=310n
Mmp8 Sb COb n5 VDD g45p1svt M=1 L=45n W=310n
Mmp0 n1 A VDD VDD g45p1svt M=1 L=45n W=310n
Mmp1 COb B n1 VDD g45p1svt M=1 L=45n W=310n
Mmp12 CO COb VDD VDD g45p1svt M=1 L=45n W=780n
Mmp13 S Sb VDD VDD g45p1svt M=1 L=45n W=780n
Mmp11 Sb CI n9 VDD g45p1svt M=1 L=45n W=310n
Mmp10 n9 B n8 VDD g45p1svt M=1 L=45n W=310n
Mmp9 n8 A VDD VDD g45p1svt M=1 L=45n W=310n
.ENDS

.SUBCKT ADDFHX1 A B CI CO S VDD VSS
Mmn5 n4 A VSS VSS g45n1svt M=1 L=45n W=205n
Mmn6 n4 B VSS VSS g45n1svt M=1 L=45n W=205n
Mmn4 COb CI n2 VSS g45n1svt M=1 L=45n W=205n
Mmn3 n2 B VSS VSS g45n1svt M=1 L=45n W=205n
Mmn2 n2 A VSS VSS g45n1svt M=1 L=45n W=205n
Mmn7 n4 CI VSS VSS g45n1svt M=1 L=45n W=205n
Mmn8 Sb COb n4 VSS g45n1svt M=1 L=45n W=205n
Mmn0 n0 A VSS VSS g45n1svt M=1 L=45n W=205n
Mmn1 COb B n0 VSS g45n1svt M=1 L=45n W=205n
Mmn12 CO COb VSS VSS g45n1svt M=1 L=45n W=260n
Mmn13 S Sb VSS VSS g45n1svt M=1 L=45n W=260n
Mmn11 Sb CI n7 VSS g45n1svt M=1 L=45n W=205n
Mmn10 n7 B n6 VSS g45n1svt M=1 L=45n W=205n
Mmn9 n6 A VSS VSS g45n1svt M=1 L=45n W=205n
Mmp2 n3 A VDD VDD g45p1svt M=1 L=45n W=310n
Mmp3 n3 B VDD VDD g45p1svt M=1 L=45n W=310n
Mmp4 COb CI n3 VDD g45p1svt M=1 L=45n W=310n
Mmp5 n5 A VDD VDD g45p1svt M=1 L=45n W=310n
Mmp6 n5 B VDD VDD g45p1svt M=1 L=45n W=310n
Mmp7 n5 CI VDD VDD g45p1svt M=1 L=45n W=310n
Mmp8 Sb COb n5 VDD g45p1svt M=1 L=45n W=310n
Mmp0 n1 A VDD VDD g45p1svt M=1 L=45n W=310n
Mmp1 COb B n1 VDD g45p1svt M=1 L=45n W=310n
Mmp12 CO COb VDD VDD g45p1svt M=1 L=45n W=390n
Mmp13 S Sb VDD VDD g45p1svt M=1 L=45n W=390n
Mmp11 Sb CI n9 VDD g45p1svt M=1 L=45n W=310n
Mmp10 n9 B n8 VDD g45p1svt M=1 L=45n W=310n
Mmp9 n8 A VDD VDD g45p1svt M=1 L=45n W=310n
.ENDS

.SUBCKT ACHCONX2 A B CI CON VDD VSS
Mmn6 n15 A VSS VSS g45n1svt M=1 L=45n W=390n
Mmn10 net0370 CI VSS VSS g45n1svt M=1 L=45n W=390n
Mmn11 n13 B VSS VSS g45n1svt M=1 L=45n W=390n
Mmn7 n12 B VSS VSS g45n1svt M=1 L=45n W=390n
Mmn8 net0370 n10 CON VSS g45n1svt M=1 L=45n W=390n
Mmn3 n9 n13 n15 VSS g45n1svt M=1 L=45n W=390n
Mmn1 n10 n13 n11 VSS g45n1svt M=1 L=45n W=310n
Mmn4 n11 B n9 VSS g45n1svt M=1 L=45n W=310n
Mmn5 n11 n15 VSS VSS g45n1svt M=1 L=45n W=310n
Mmn2 n15 B n10 VSS g45n1svt M=1 L=45n W=390n
Mmn9 n12 n9 CON VSS g45n1svt M=1 L=45n W=390n
Mmp6 n15 A VDD VDD g45p1svt M=1 L=45n W=770n
Mmp10 net0370 CI VDD VDD g45p1svt M=1 L=45n W=770n
Mmp8 net0370 n9 CON VDD g45p1svt M=1 L=45n W=770n
Mmp7 n12 B VDD VDD g45p1svt M=1 L=45n W=770n
Mmp5 n11 n15 VDD VDD g45p1svt M=1 L=45n W=520n
Mmp1 n10 B n11 VDD g45p1svt M=1 L=45n W=520n
Mmp2 n15 n13 n10 VDD g45p1svt M=1 L=45n W=770n
Mmp11 n13 B VDD VDD g45p1svt M=1 L=45n W=770n
Mmp4 n11 n13 n9 VDD g45p1svt M=1 L=45n W=520n
Mmp3 n9 B n15 VDD g45p1svt M=1 L=45n W=770n
Mmp9 n12 n10 CON VDD g45p1svt M=1 L=45n W=770n
.ENDS

.SUBCKT AND2X1 A B VDD VSS Y
Mmn2 Y n0 VSS VSS g45n1svt M=1 L=45n W=260n
Mmn0 net127 B VSS VSS g45n1svt M=1 L=45n W=145n
Mmn1 n0 A net127 VSS g45n1svt M=1 L=45n W=145n
Mmp1 n0 B VDD VDD g45p1svt M=1 L=45n W=215n
Mmp0 n0 A VDD VDD g45p1svt M=1 L=45n W=215n
Mmp2 Y n0 VDD VDD g45p1svt M=1 L=45n W=390n
.ENDS

.SUBCKT NAND2X1 A B VDD VSS Y
Mmn1 Y B n0 VSS g45n1svt M=1 L=45n W=260n
Mmn0 n0 A VSS VSS g45n1svt M=1 L=45n W=260n
Mmp1 Y B VDD VDD g45p1svt M=1 L=45n W=390n
Mmp0 Y A VDD VDD g45p1svt M=1 L=45n W=390n
.ENDS

.SUBCKT NOR2X1 A B VDD VSS Y
Mmn1 Y B VSS VSS g45n1svt M=1 L=45n W=260n
Mmn0 Y A VSS VSS g45n1svt M=1 L=45n W=260n
Mmp1 Y B net41 VDD g45p1svt M=1 L=45n W=390n
Mmp0 net41 A VDD VDD g45p1svt M=1 L=45n W=390n
.ENDS

.SUBCKT OR2X1 A B VDD VSS Y
Mmn2 Y n0 VSS VSS g45n1svt M=1 L=45n W=260n
Mmn0 n0 A VSS VSS g45n1svt M=1 L=45n W=145n
Mmn1 n0 B VSS VSS g45n1svt M=1 L=45n W=145n
Mmp1 n0 B n1 VDD g45p1svt M=1 L=45n W=215n
Mmp2 Y n0 VDD VDD g45p1svt M=1 L=45n W=390n
Mmp0 n1 A VDD VDD g45p1svt M=1 L=45n W=215n
.ENDS

.SUBCKT XOR2X1 A B VDD VSS Y
Mmn1 n2 B VSS VSS g45n1svt M=1 L=45n W=145n
Mmn0 n1 A VSS VSS g45n1svt M=1 L=45n W=145n
Mmn5 Y n0 VSS VSS g45n1svt M=1 L=45n W=260n
Mmn3 n0 B net131 VSS g45n1svt M=1 L=45n W=145n
Mmn4 n0 n2 n1 VSS g45n1svt M=1 L=45n W=145n
Mmn2 net131 n1 VSS VSS g45n1svt M=1 L=45n W=145n
Mmp3 n0 n2 net130 VDD g45p1svt M=1 L=45n W=215n
Mmp1 n2 B VDD VDD g45p1svt M=1 L=45n W=215n
Mmp4 n1 B n0 VDD g45p1svt M=1 L=45n W=215n
Mmp0 n1 A VDD VDD g45p1svt M=1 L=45n W=215n
Mmp5 Y n0 VDD VDD g45p1svt M=1 L=45n W=390n
Mmp2 net130 n1 VDD VDD g45p1svt M=1 L=45n W=215n
.ENDS

.SUBCKT INVX1 A VDD VSS Y
Mmp0 Y A VDD VDD g45p1svt M=1 L=45n W=390n
Mmn0 Y A VSS VSS g45n1svt M=1 L=45n W=260n
.ENDS

.SUBCKT s38417 CK g1249 g16297 g16355 g16399 g16437 g16496 g1943 g23919 g24890 g24909
+ g24925 g25489 g25490 g25520 g25566 g2637 g26974 g3212 g3213 g3214 g3215 g3216
+ g3217 g3218 g3219 g3220 g3221 g3222 g3223 g3224 g3225 g3226 g3227 g3228 g3229
+ g3230 g3231 g3232 g3233 g3234 g3993 g4088 g4090 g4200 g4321 g4323 g4450 g4590
+ g51 g5388 g5437 g5472 g5511 g5549 g5555 g5595 g5612 g5629 g563 g5637 g5648 g5657
+ g5686 g5695 g5738 g5747 g5796 g6225 g6231 g6313 g6368 g6442 g6447 g6485 g6518
+ g6573 g6642 g6677 g6712 g6750 g6782 g6837 g6895 g6911 g6944 g6979 g7014 g7052
+ g7084 g7161 g7194 g7229 g7264 g7302 g7334 g7357 g7390 g7425 g7487 g7519 g7909
+ g7956 g7961 g8007 g8012 g8021 g8023 g8030 g8082 g8087 g8096 g8106 g8167 g8175
+ g8249 g8251 g1 g2 g5 g8 g11 g14 g17 g20 g23 g26 g27 g30 g33 g36 g39 g42 g45 g48
+ VDD VSS
XDFF_0 CK g2814 g16475 VDD VSS dff
XDFF_1 CK g2817 g20571 VDD VSS dff
XDFF_2 CK g2933 g20588 VDD VSS dff
XDFF_3 CK g2950 g21951 VDD VSS dff
XDFF_4 CK g2883 g23315 VDD VSS dff
XDFF_5 CK g2888 g24423 VDD VSS dff
XDFF_6 CK g2896 g25175 VDD VSS dff
XDFF_7 CK g2892 g26019 VDD VSS dff
XDFF_8 CK g2903 g26747 VDD VSS dff
XDFF_9 CK g2900 g27237 VDD VSS dff
XDFF_10 CK g2908 g27715 VDD VSS dff
XDFF_11 CK g2912 g24424 VDD VSS dff
XDFF_12 CK g2917 g25174 VDD VSS dff
XDFF_13 CK g2924 g26020 VDD VSS dff
XDFF_14 CK g2920 g26746 VDD VSS dff
XDFF_15 CK g2984 g19061 VDD VSS dff
XDFF_16 CK g2985 g19060 VDD VSS dff
XDFF_17 CK g8021 g19062 VDD VSS dff
XDFF_18 CK g2929 g8021 VDD VSS dff
XDFF_19 CK g2879 g16494 VDD VSS dff
XDFF_20 CK g2934 g16476 VDD VSS dff
XDFF_21 CK g2935 g16477 VDD VSS dff
XDFF_22 CK g2938 g16478 VDD VSS dff
XDFF_23 CK g2941 g16479 VDD VSS dff
XDFF_24 CK g2944 g16480 VDD VSS dff
XDFF_25 CK g2947 g16481 VDD VSS dff
XDFF_26 CK g2953 g16482 VDD VSS dff
XDFF_27 CK g2956 g16483 VDD VSS dff
XDFF_28 CK g2959 g16484 VDD VSS dff
XDFF_29 CK g2962 g16485 VDD VSS dff
XDFF_30 CK g2963 g16486 VDD VSS dff
XDFF_31 CK g2966 g16487 VDD VSS dff
XDFF_32 CK g2969 g16488 VDD VSS dff
XDFF_33 CK g2972 g16489 VDD VSS dff
XDFF_34 CK g2975 g16490 VDD VSS dff
XDFF_35 CK g2978 g16491 VDD VSS dff
XDFF_36 CK g2981 g16492 VDD VSS dff
XDFF_37 CK g2874 g16493 VDD VSS dff
XDFF_38 CK g1506 g20572 VDD VSS dff
XDFF_39 CK g1501 g20573 VDD VSS dff
XDFF_40 CK g1496 g20574 VDD VSS dff
XDFF_41 CK g1491 g20575 VDD VSS dff
XDFF_42 CK g1486 g20576 VDD VSS dff
XDFF_43 CK g1481 g20577 VDD VSS dff
XDFF_44 CK g1476 g20578 VDD VSS dff
XDFF_45 CK g1471 g20579 VDD VSS dff
XDFF_46 CK g2877 g23313 VDD VSS dff
XDFF_47 CK g8251 g21960 VDD VSS dff
XDFF_48 CK g813 g8251 VDD VSS dff
XDFF_49 CK g4090 g21961 VDD VSS dff
XDFF_50 CK g809 g4090 VDD VSS dff
XDFF_51 CK g4323 g21962 VDD VSS dff
XDFF_52 CK g805 g4323 VDD VSS dff
XDFF_53 CK g4590 g21963 VDD VSS dff
XDFF_54 CK g801 g4590 VDD VSS dff
XDFF_55 CK g6225 g21947 VDD VSS dff
XDFF_56 CK g797 g6225 VDD VSS dff
XDFF_57 CK g6442 g21948 VDD VSS dff
XDFF_58 CK g793 g6442 VDD VSS dff
XDFF_59 CK g6895 g21949 VDD VSS dff
XDFF_60 CK g789 g6895 VDD VSS dff
XDFF_61 CK g7334 g21950 VDD VSS dff
XDFF_62 CK g785 g7334 VDD VSS dff
XDFF_63 CK g7519 g23312 VDD VSS dff
XDFF_64 CK g2873 g7519 VDD VSS dff
XDFF_65 CK g8249 g21952 VDD VSS dff
XDFF_66 CK g125 g8249 VDD VSS dff
XDFF_67 CK g4088 g21953 VDD VSS dff
XDFF_68 CK g121 g4088 VDD VSS dff
XDFF_69 CK g4321 g21954 VDD VSS dff
XDFF_70 CK g117 g4321 VDD VSS dff
XDFF_71 CK g8023 g21955 VDD VSS dff
XDFF_72 CK g113 g8023 VDD VSS dff
XDFF_73 CK g8175 g21956 VDD VSS dff
XDFF_74 CK g109 g8175 VDD VSS dff
XDFF_75 CK g3993 g21957 VDD VSS dff
XDFF_76 CK g105 g3993 VDD VSS dff
XDFF_77 CK g4200 g21958 VDD VSS dff
XDFF_78 CK g101 g4200 VDD VSS dff
XDFF_79 CK g4450 g21959 VDD VSS dff
XDFF_80 CK g97 g4450 VDD VSS dff
XDFF_81 CK g8096 g23316 VDD VSS dff
XDFF_82 CK g2857 g8096 VDD VSS dff
XDFF_83 CK g2200 g20587 VDD VSS dff
XDFF_84 CK g2195 g20585 VDD VSS dff
XDFF_85 CK g2190 g20586 VDD VSS dff
XDFF_86 CK g2185 g20584 VDD VSS dff
XDFF_87 CK g2180 g20583 VDD VSS dff
XDFF_88 CK g2175 g20582 VDD VSS dff
XDFF_89 CK g2170 g20581 VDD VSS dff
XDFF_90 CK g2165 g20580 VDD VSS dff
XDFF_91 CK g2878 g23314 VDD VSS dff
XDFF_92 CK g8106 g13475 VDD VSS dff
XDFF_93 CK g8030 g8106 VDD VSS dff
XDFF_94 CK g3109 g8030 VDD VSS dff
XDFF_95 CK g3210 g20630 VDD VSS dff
XDFF_96 CK g3211 g20631 VDD VSS dff
XDFF_97 CK g3084 g20632 VDD VSS dff
XDFF_98 CK g3085 g20609 VDD VSS dff
XDFF_99 CK g3086 g20610 VDD VSS dff
XDFF_100 CK g3087 g20611 VDD VSS dff
XDFF_101 CK g3091 g20612 VDD VSS dff
XDFF_102 CK g3092 g20613 VDD VSS dff
XDFF_103 CK g3093 g20614 VDD VSS dff
XDFF_104 CK g3094 g20615 VDD VSS dff
XDFF_105 CK g3095 g20616 VDD VSS dff
XDFF_106 CK g3096 g20617 VDD VSS dff
XDFF_107 CK g3097 g26751 VDD VSS dff
XDFF_108 CK g3098 g26752 VDD VSS dff
XDFF_109 CK g3099 g26753 VDD VSS dff
XDFF_110 CK g3100 g29163 VDD VSS dff
XDFF_111 CK g3101 g29164 VDD VSS dff
XDFF_112 CK g3102 g29165 VDD VSS dff
XDFF_113 CK g3103 g30120 VDD VSS dff
XDFF_114 CK g3104 g30121 VDD VSS dff
XDFF_115 CK g3105 g30122 VDD VSS dff
XDFF_116 CK g3106 g30941 VDD VSS dff
XDFF_117 CK g3107 g30942 VDD VSS dff
XDFF_118 CK g3108 g30943 VDD VSS dff
XDFF_119 CK g3155 g20618 VDD VSS dff
XDFF_120 CK g3158 g20619 VDD VSS dff
XDFF_121 CK g3161 g20620 VDD VSS dff
XDFF_122 CK g3164 g20621 VDD VSS dff
XDFF_123 CK g3167 g20622 VDD VSS dff
XDFF_124 CK g3170 g20623 VDD VSS dff
XDFF_125 CK g3173 g20624 VDD VSS dff
XDFF_126 CK g3176 g20625 VDD VSS dff
XDFF_127 CK g3179 g20626 VDD VSS dff
XDFF_128 CK g3182 g20627 VDD VSS dff
XDFF_129 CK g3185 g20628 VDD VSS dff
XDFF_130 CK g3088 g20629 VDD VSS dff
XDFF_131 CK g3191 g27717 VDD VSS dff
XDFF_132 CK g3194 g28316 VDD VSS dff
XDFF_133 CK g3197 g28317 VDD VSS dff
XDFF_134 CK g3198 g28318 VDD VSS dff
XDFF_135 CK g3201 g28704 VDD VSS dff
XDFF_136 CK g3204 g28705 VDD VSS dff
XDFF_137 CK g3207 g28706 VDD VSS dff
XDFF_138 CK g3188 g29463 VDD VSS dff
XDFF_139 CK g3133 g29656 VDD VSS dff
XDFF_140 CK g3132 g28698 VDD VSS dff
XDFF_141 CK g3128 g29166 VDD VSS dff
XDFF_142 CK g3127 g28697 VDD VSS dff
XDFF_143 CK g3126 g28315 VDD VSS dff
XDFF_144 CK g3125 g28696 VDD VSS dff
XDFF_145 CK g3124 g28314 VDD VSS dff
XDFF_146 CK g3123 g28313 VDD VSS dff
XDFF_147 CK g3120 g28695 VDD VSS dff
XDFF_148 CK g3114 g28694 VDD VSS dff
XDFF_149 CK g3113 g28693 VDD VSS dff
XDFF_150 CK g3112 g28312 VDD VSS dff
XDFF_151 CK g3110 g28311 VDD VSS dff
XDFF_152 CK g3111 g28310 VDD VSS dff
XDFF_153 CK g3139 g29461 VDD VSS dff
XDFF_154 CK g3136 g28701 VDD VSS dff
XDFF_155 CK g3134 g28700 VDD VSS dff
XDFF_156 CK g3135 g28699 VDD VSS dff
XDFF_157 CK g3151 g29462 VDD VSS dff
XDFF_158 CK g3142 g28703 VDD VSS dff
XDFF_159 CK g3147 g28702 VDD VSS dff
XDFF_160 CK g185 g29657 VDD VSS dff
XDFF_161 CK g6231 g13405 VDD VSS dff
XDFF_162 CK g6313 g6231 VDD VSS dff
XDFF_163 CK g165 g6313 VDD VSS dff
XDFF_164 CK g130 g24259 VDD VSS dff
XDFF_165 CK g131 g24260 VDD VSS dff
XDFF_166 CK g129 g24261 VDD VSS dff
XDFF_167 CK g133 g24262 VDD VSS dff
XDFF_168 CK g134 g24263 VDD VSS dff
XDFF_169 CK g132 g24264 VDD VSS dff
XDFF_170 CK g142 g24265 VDD VSS dff
XDFF_171 CK g143 g24266 VDD VSS dff
XDFF_172 CK g141 g24267 VDD VSS dff
XDFF_173 CK g145 g24268 VDD VSS dff
XDFF_174 CK g146 g24269 VDD VSS dff
XDFF_175 CK g144 g24270 VDD VSS dff
XDFF_176 CK g148 g24271 VDD VSS dff
XDFF_177 CK g149 g24272 VDD VSS dff
XDFF_178 CK g147 g24273 VDD VSS dff
XDFF_179 CK g151 g24274 VDD VSS dff
XDFF_180 CK g152 g24275 VDD VSS dff
XDFF_181 CK g150 g24276 VDD VSS dff
XDFF_182 CK g154 g24277 VDD VSS dff
XDFF_183 CK g155 g24278 VDD VSS dff
XDFF_184 CK g153 g24279 VDD VSS dff
XDFF_185 CK g157 g24280 VDD VSS dff
XDFF_186 CK g158 g24281 VDD VSS dff
XDFF_187 CK g156 g24282 VDD VSS dff
XDFF_188 CK g160 g24283 VDD VSS dff
XDFF_189 CK g161 g24284 VDD VSS dff
XDFF_190 CK g159 g24285 VDD VSS dff
XDFF_191 CK g163 g24286 VDD VSS dff
XDFF_192 CK g164 g24287 VDD VSS dff
XDFF_193 CK g162 g24288 VDD VSS dff
XDFF_194 CK g169 g26679 VDD VSS dff
XDFF_195 CK g170 g26680 VDD VSS dff
XDFF_196 CK g168 g26681 VDD VSS dff
XDFF_197 CK g172 g26682 VDD VSS dff
XDFF_198 CK g173 g26683 VDD VSS dff
XDFF_199 CK g171 g26684 VDD VSS dff
XDFF_200 CK g175 g26685 VDD VSS dff
XDFF_201 CK g176 g26686 VDD VSS dff
XDFF_202 CK g174 g26687 VDD VSS dff
XDFF_203 CK g178 g26688 VDD VSS dff
XDFF_204 CK g179 g26689 VDD VSS dff
XDFF_205 CK g177 g26690 VDD VSS dff
XDFF_206 CK g186 g30506 VDD VSS dff
XDFF_207 CK g189 g30507 VDD VSS dff
XDFF_208 CK g192 g30508 VDD VSS dff
XDFF_209 CK g231 g30842 VDD VSS dff
XDFF_210 CK g234 g30843 VDD VSS dff
XDFF_211 CK g237 g30844 VDD VSS dff
XDFF_212 CK g195 g30836 VDD VSS dff
XDFF_213 CK g198 g30837 VDD VSS dff
XDFF_214 CK g201 g30838 VDD VSS dff
XDFF_215 CK g240 g30845 VDD VSS dff
XDFF_216 CK g243 g30846 VDD VSS dff
XDFF_217 CK g246 g30847 VDD VSS dff
XDFF_218 CK g204 g30509 VDD VSS dff
XDFF_219 CK g207 g30510 VDD VSS dff
XDFF_220 CK g210 g30511 VDD VSS dff
XDFF_221 CK g249 g30515 VDD VSS dff
XDFF_222 CK g252 g30516 VDD VSS dff
XDFF_223 CK g255 g30517 VDD VSS dff
XDFF_224 CK g213 g30512 VDD VSS dff
XDFF_225 CK g216 g30513 VDD VSS dff
XDFF_226 CK g219 g30514 VDD VSS dff
XDFF_227 CK g258 g30518 VDD VSS dff
XDFF_228 CK g261 g30519 VDD VSS dff
XDFF_229 CK g264 g30520 VDD VSS dff
XDFF_230 CK g222 g30839 VDD VSS dff
XDFF_231 CK g225 g30840 VDD VSS dff
XDFF_232 CK g228 g30841 VDD VSS dff
XDFF_233 CK g267 g30848 VDD VSS dff
XDFF_234 CK g270 g30849 VDD VSS dff
XDFF_235 CK g273 g30850 VDD VSS dff
XDFF_236 CK g92 g25983 VDD VSS dff
XDFF_237 CK g88 g26678 VDD VSS dff
XDFF_238 CK g83 g27189 VDD VSS dff
XDFF_239 CK g79 g27683 VDD VSS dff
XDFF_240 CK g74 g28206 VDD VSS dff
XDFF_241 CK g70 g28673 VDD VSS dff
XDFF_242 CK g65 g29131 VDD VSS dff
XDFF_243 CK g61 g29413 VDD VSS dff
XDFF_244 CK g56 g29627 VDD VSS dff
XDFF_245 CK g52 g29794 VDD VSS dff
XDFF_246 CK g180 g20555 VDD VSS dff
XDFF_247 CK g5549 g180 VDD VSS dff
XDFF_248 CK g181 g5549 VDD VSS dff
XDFF_249 CK g5437 g13406 VDD VSS dff
XDFF_250 CK g6447 g5437 VDD VSS dff
XDFF_251 CK g401 g6447 VDD VSS dff
XDFF_252 CK g309 g11496 VDD VSS dff
XDFF_253 CK g354 g28207 VDD VSS dff
XDFF_254 CK g343 g28208 VDD VSS dff
XDFF_255 CK g346 g28209 VDD VSS dff
XDFF_256 CK g369 g28210 VDD VSS dff
XDFF_257 CK g358 g28211 VDD VSS dff
XDFF_258 CK g361 g28212 VDD VSS dff
XDFF_259 CK g384 g28213 VDD VSS dff
XDFF_260 CK g373 g28214 VDD VSS dff
XDFF_261 CK g376 g28215 VDD VSS dff
XDFF_262 CK g398 g28216 VDD VSS dff
XDFF_263 CK g388 g28217 VDD VSS dff
XDFF_264 CK g391 g28218 VDD VSS dff
XDFF_265 CK g408 g29414 VDD VSS dff
XDFF_266 CK g411 g29415 VDD VSS dff
XDFF_267 CK g414 g29416 VDD VSS dff
XDFF_268 CK g417 g29631 VDD VSS dff
XDFF_269 CK g420 g29632 VDD VSS dff
XDFF_270 CK g423 g29633 VDD VSS dff
XDFF_271 CK g427 g29417 VDD VSS dff
XDFF_272 CK g428 g29418 VDD VSS dff
XDFF_273 CK g426 g29419 VDD VSS dff
XDFF_274 CK g429 g27684 VDD VSS dff
XDFF_275 CK g432 g27685 VDD VSS dff
XDFF_276 CK g435 g27686 VDD VSS dff
XDFF_277 CK g438 g27687 VDD VSS dff
XDFF_278 CK g441 g27688 VDD VSS dff
XDFF_279 CK g444 g27689 VDD VSS dff
XDFF_280 CK g448 g28674 VDD VSS dff
XDFF_281 CK g449 g28675 VDD VSS dff
XDFF_282 CK g447 g28676 VDD VSS dff
XDFF_283 CK g312 g29795 VDD VSS dff
XDFF_284 CK g313 g29796 VDD VSS dff
XDFF_285 CK g314 g29797 VDD VSS dff
XDFF_286 CK g315 g30851 VDD VSS dff
XDFF_287 CK g316 g30852 VDD VSS dff
XDFF_288 CK g317 g30853 VDD VSS dff
XDFF_289 CK g318 g30710 VDD VSS dff
XDFF_290 CK g319 g30711 VDD VSS dff
XDFF_291 CK g320 g30712 VDD VSS dff
XDFF_292 CK g322 g29628 VDD VSS dff
XDFF_293 CK g323 g29629 VDD VSS dff
XDFF_294 CK g321 g29630 VDD VSS dff
XDFF_295 CK g403 g27191 VDD VSS dff
XDFF_296 CK g404 g27192 VDD VSS dff
XDFF_297 CK g402 g27193 VDD VSS dff
XDFF_298 CK g450 g11509 VDD VSS dff
XDFF_299 CK g451 g450 VDD VSS dff
XDFF_300 CK g452 g11510 VDD VSS dff
XDFF_301 CK g453 g452 VDD VSS dff
XDFF_302 CK g454 g11511 VDD VSS dff
XDFF_303 CK g279 g454 VDD VSS dff
XDFF_304 CK g280 g11491 VDD VSS dff
XDFF_305 CK g281 g280 VDD VSS dff
XDFF_306 CK g282 g11492 VDD VSS dff
XDFF_307 CK g283 g282 VDD VSS dff
XDFF_308 CK g284 g11493 VDD VSS dff
XDFF_309 CK g285 g284 VDD VSS dff
XDFF_310 CK g286 g11494 VDD VSS dff
XDFF_311 CK g287 g286 VDD VSS dff
XDFF_312 CK g288 g11495 VDD VSS dff
XDFF_313 CK g289 g288 VDD VSS dff
XDFF_314 CK g290 g13407 VDD VSS dff
XDFF_315 CK g291 g290 VDD VSS dff
XDFF_316 CK g299 g19012 VDD VSS dff
XDFF_317 CK g305 g23148 VDD VSS dff
XDFF_318 CK g308 g23149 VDD VSS dff
XDFF_319 CK g297 g23150 VDD VSS dff
XDFF_320 CK g296 g23151 VDD VSS dff
XDFF_321 CK g295 g23152 VDD VSS dff
XDFF_322 CK g294 g23153 VDD VSS dff
XDFF_323 CK g304 g19016 VDD VSS dff
XDFF_324 CK g303 g19015 VDD VSS dff
XDFF_325 CK g302 g19014 VDD VSS dff
XDFF_326 CK g301 g19013 VDD VSS dff
XDFF_327 CK g300 g25130 VDD VSS dff
XDFF_328 CK g298 g27190 VDD VSS dff
XDFF_329 CK g342 g11497 VDD VSS dff
XDFF_330 CK g349 g342 VDD VSS dff
XDFF_331 CK g350 g11498 VDD VSS dff
XDFF_332 CK g351 g350 VDD VSS dff
XDFF_333 CK g352 g11499 VDD VSS dff
XDFF_334 CK g353 g352 VDD VSS dff
XDFF_335 CK g357 g11500 VDD VSS dff
XDFF_336 CK g364 g357 VDD VSS dff
XDFF_337 CK g365 g11501 VDD VSS dff
XDFF_338 CK g366 g365 VDD VSS dff
XDFF_339 CK g367 g11502 VDD VSS dff
XDFF_340 CK g368 g367 VDD VSS dff
XDFF_341 CK g372 g11503 VDD VSS dff
XDFF_342 CK g379 g372 VDD VSS dff
XDFF_343 CK g380 g11504 VDD VSS dff
XDFF_344 CK g381 g380 VDD VSS dff
XDFF_345 CK g382 g11505 VDD VSS dff
XDFF_346 CK g383 g382 VDD VSS dff
XDFF_347 CK g387 g11506 VDD VSS dff
XDFF_348 CK g394 g387 VDD VSS dff
XDFF_349 CK g395 g11507 VDD VSS dff
XDFF_350 CK g396 g395 VDD VSS dff
XDFF_351 CK g397 g11508 VDD VSS dff
XDFF_352 CK g324 g397 VDD VSS dff
XDFF_353 CK g5629 g13408 VDD VSS dff
XDFF_354 CK g5648 g5629 VDD VSS dff
XDFF_355 CK g337 g5648 VDD VSS dff
XDFF_356 CK g6485 g13419 VDD VSS dff
XDFF_357 CK g6642 g6485 VDD VSS dff
XDFF_358 CK g550 g6642 VDD VSS dff
XDFF_359 CK g554 g23160 VDD VSS dff
XDFF_360 CK g557 g20556 VDD VSS dff
XDFF_361 CK g510 g20557 VDD VSS dff
XDFF_362 CK g513 g16467 VDD VSS dff
XDFF_363 CK g523 g513 VDD VSS dff
XDFF_364 CK g524 g523 VDD VSS dff
XDFF_365 CK g564 g11512 VDD VSS dff
XDFF_366 CK g569 g564 VDD VSS dff
XDFF_367 CK g570 g11515 VDD VSS dff
XDFF_368 CK g571 g570 VDD VSS dff
XDFF_369 CK g572 g11516 VDD VSS dff
XDFF_370 CK g573 g572 VDD VSS dff
XDFF_371 CK g574 g11517 VDD VSS dff
XDFF_372 CK g565 g574 VDD VSS dff
XDFF_373 CK g566 g11513 VDD VSS dff
XDFF_374 CK g567 g566 VDD VSS dff
XDFF_375 CK g568 g11514 VDD VSS dff
XDFF_376 CK g489 g568 VDD VSS dff
XDFF_377 CK g7909 g13409 VDD VSS dff
XDFF_378 CK g7956 g7909 VDD VSS dff
XDFF_379 CK g485 g7956 VDD VSS dff
XDFF_380 CK g486 g24292 VDD VSS dff
XDFF_381 CK g487 g24293 VDD VSS dff
XDFF_382 CK g488 g24294 VDD VSS dff
XDFF_383 CK g455 g25139 VDD VSS dff
XDFF_384 CK g458 g25131 VDD VSS dff
XDFF_385 CK g461 g25132 VDD VSS dff
XDFF_386 CK g477 g25136 VDD VSS dff
XDFF_387 CK g478 g25137 VDD VSS dff
XDFF_388 CK g479 g25138 VDD VSS dff
XDFF_389 CK g480 g24289 VDD VSS dff
XDFF_390 CK g484 g24290 VDD VSS dff
XDFF_391 CK g464 g24291 VDD VSS dff
XDFF_392 CK g465 g25133 VDD VSS dff
XDFF_393 CK g468 g25134 VDD VSS dff
XDFF_394 CK g471 g25135 VDD VSS dff
XDFF_395 CK g528 g16468 VDD VSS dff
XDFF_396 CK g535 g528 VDD VSS dff
XDFF_397 CK g542 g535 VDD VSS dff
XDFF_398 CK g543 g19021 VDD VSS dff
XDFF_399 CK g544 g543 VDD VSS dff
XDFF_400 CK g548 g23159 VDD VSS dff
XDFF_401 CK g549 g19022 VDD VSS dff
XDFF_402 CK g499 g549 VDD VSS dff
XDFF_403 CK g558 g19023 VDD VSS dff
XDFF_404 CK g559 g558 VDD VSS dff
XDFF_405 CK g576 g28219 VDD VSS dff
XDFF_406 CK g577 g28220 VDD VSS dff
XDFF_407 CK g575 g28221 VDD VSS dff
XDFF_408 CK g579 g28222 VDD VSS dff
XDFF_409 CK g580 g28223 VDD VSS dff
XDFF_410 CK g578 g28224 VDD VSS dff
XDFF_411 CK g582 g28225 VDD VSS dff
XDFF_412 CK g583 g28226 VDD VSS dff
XDFF_413 CK g581 g28227 VDD VSS dff
XDFF_414 CK g585 g28228 VDD VSS dff
XDFF_415 CK g586 g28229 VDD VSS dff
XDFF_416 CK g584 g28230 VDD VSS dff
XDFF_417 CK g587 g25985 VDD VSS dff
XDFF_418 CK g590 g25986 VDD VSS dff
XDFF_419 CK g593 g25987 VDD VSS dff
XDFF_420 CK g596 g25988 VDD VSS dff
XDFF_421 CK g599 g25989 VDD VSS dff
XDFF_422 CK g602 g25990 VDD VSS dff
XDFF_423 CK g614 g29135 VDD VSS dff
XDFF_424 CK g617 g29136 VDD VSS dff
XDFF_425 CK g620 g29137 VDD VSS dff
XDFF_426 CK g605 g29132 VDD VSS dff
XDFF_427 CK g608 g29133 VDD VSS dff
XDFF_428 CK g611 g29134 VDD VSS dff
XDFF_429 CK g490 g27194 VDD VSS dff
XDFF_430 CK g493 g27195 VDD VSS dff
XDFF_431 CK g496 g27196 VDD VSS dff
XDFF_432 CK g506 g8284 VDD VSS dff
XDFF_433 CK g507 g24295 VDD VSS dff
XDFF_434 CK g508 g19017 VDD VSS dff
XDFF_435 CK g509 g19018 VDD VSS dff
XDFF_436 CK g514 g19019 VDD VSS dff
XDFF_437 CK g515 g19020 VDD VSS dff
XDFF_438 CK g516 g23158 VDD VSS dff
XDFF_439 CK g517 g23157 VDD VSS dff
XDFF_440 CK g518 g23156 VDD VSS dff
XDFF_441 CK g519 g23155 VDD VSS dff
XDFF_442 CK g16297 g23154 VDD VSS dff
XDFF_443 CK g525 g16297 VDD VSS dff
XDFF_444 CK g529 g13410 VDD VSS dff
XDFF_445 CK g530 g13411 VDD VSS dff
XDFF_446 CK g531 g13412 VDD VSS dff
XDFF_447 CK g532 g13413 VDD VSS dff
XDFF_448 CK g533 g13414 VDD VSS dff
XDFF_449 CK g534 g13415 VDD VSS dff
XDFF_450 CK g536 g13416 VDD VSS dff
XDFF_451 CK g537 g13417 VDD VSS dff
XDFF_452 CK g538 g25984 VDD VSS dff
XDFF_453 CK g541 g13418 VDD VSS dff
XDFF_454 CK g6677 g13420 VDD VSS dff
XDFF_455 CK g6911 g6677 VDD VSS dff
XDFF_456 CK g629 g6911 VDD VSS dff
XDFF_457 CK g630 g20558 VDD VSS dff
XDFF_458 CK g659 g21943 VDD VSS dff
XDFF_459 CK g640 g23161 VDD VSS dff
XDFF_460 CK g633 g24296 VDD VSS dff
XDFF_461 CK g653 g25140 VDD VSS dff
XDFF_462 CK g646 g25991 VDD VSS dff
XDFF_463 CK g660 g26691 VDD VSS dff
XDFF_464 CK g672 g27197 VDD VSS dff
XDFF_465 CK g666 g27690 VDD VSS dff
XDFF_466 CK g679 g28231 VDD VSS dff
XDFF_467 CK g686 g28677 VDD VSS dff
XDFF_468 CK g692 g29138 VDD VSS dff
XDFF_469 CK g699 g23162 VDD VSS dff
XDFF_470 CK g700 g23163 VDD VSS dff
XDFF_471 CK g698 g23164 VDD VSS dff
XDFF_472 CK g702 g23165 VDD VSS dff
XDFF_473 CK g703 g23166 VDD VSS dff
XDFF_474 CK g701 g23167 VDD VSS dff
XDFF_475 CK g705 g23168 VDD VSS dff
XDFF_476 CK g706 g23169 VDD VSS dff
XDFF_477 CK g704 g23170 VDD VSS dff
XDFF_478 CK g708 g23171 VDD VSS dff
XDFF_479 CK g709 g23172 VDD VSS dff
XDFF_480 CK g707 g23173 VDD VSS dff
XDFF_481 CK g711 g23174 VDD VSS dff
XDFF_482 CK g712 g23175 VDD VSS dff
XDFF_483 CK g710 g23176 VDD VSS dff
XDFF_484 CK g714 g23177 VDD VSS dff
XDFF_485 CK g715 g23178 VDD VSS dff
XDFF_486 CK g713 g23179 VDD VSS dff
XDFF_487 CK g717 g23180 VDD VSS dff
XDFF_488 CK g718 g23181 VDD VSS dff
XDFF_489 CK g716 g23182 VDD VSS dff
XDFF_490 CK g720 g23183 VDD VSS dff
XDFF_491 CK g721 g23184 VDD VSS dff
XDFF_492 CK g719 g23185 VDD VSS dff
XDFF_493 CK g723 g23186 VDD VSS dff
XDFF_494 CK g724 g23187 VDD VSS dff
XDFF_495 CK g722 g23188 VDD VSS dff
XDFF_496 CK g726 g23189 VDD VSS dff
XDFF_497 CK g727 g23190 VDD VSS dff
XDFF_498 CK g725 g23191 VDD VSS dff
XDFF_499 CK g729 g23192 VDD VSS dff
XDFF_500 CK g730 g23193 VDD VSS dff
XDFF_501 CK g728 g23194 VDD VSS dff
XDFF_502 CK g732 g23195 VDD VSS dff
XDFF_503 CK g733 g23196 VDD VSS dff
XDFF_504 CK g731 g23197 VDD VSS dff
XDFF_505 CK g735 g26692 VDD VSS dff
XDFF_506 CK g736 g26693 VDD VSS dff
XDFF_507 CK g734 g26694 VDD VSS dff
XDFF_508 CK g738 g24297 VDD VSS dff
XDFF_509 CK g739 g24298 VDD VSS dff
XDFF_510 CK g737 g24299 VDD VSS dff
XDFF_511 CK g6368 g13421 VDD VSS dff
XDFF_512 CK g6518 g6368 VDD VSS dff
XDFF_513 CK g853 g6518 VDD VSS dff
XDFF_514 CK g818 g24300 VDD VSS dff
XDFF_515 CK g819 g24301 VDD VSS dff
XDFF_516 CK g817 g24302 VDD VSS dff
XDFF_517 CK g821 g24303 VDD VSS dff
XDFF_518 CK g822 g24304 VDD VSS dff
XDFF_519 CK g820 g24305 VDD VSS dff
XDFF_520 CK g830 g24306 VDD VSS dff
XDFF_521 CK g831 g24307 VDD VSS dff
XDFF_522 CK g829 g24308 VDD VSS dff
XDFF_523 CK g833 g24309 VDD VSS dff
XDFF_524 CK g834 g24310 VDD VSS dff
XDFF_525 CK g832 g24311 VDD VSS dff
XDFF_526 CK g836 g24312 VDD VSS dff
XDFF_527 CK g837 g24313 VDD VSS dff
XDFF_528 CK g835 g24314 VDD VSS dff
XDFF_529 CK g839 g24315 VDD VSS dff
XDFF_530 CK g840 g24316 VDD VSS dff
XDFF_531 CK g838 g24317 VDD VSS dff
XDFF_532 CK g842 g24318 VDD VSS dff
XDFF_533 CK g843 g24319 VDD VSS dff
XDFF_534 CK g841 g24320 VDD VSS dff
XDFF_535 CK g845 g24321 VDD VSS dff
XDFF_536 CK g846 g24322 VDD VSS dff
XDFF_537 CK g844 g24323 VDD VSS dff
XDFF_538 CK g848 g24324 VDD VSS dff
XDFF_539 CK g849 g24325 VDD VSS dff
XDFF_540 CK g847 g24326 VDD VSS dff
XDFF_541 CK g851 g24327 VDD VSS dff
XDFF_542 CK g852 g24328 VDD VSS dff
XDFF_543 CK g850 g24329 VDD VSS dff
XDFF_544 CK g857 g26696 VDD VSS dff
XDFF_545 CK g858 g26697 VDD VSS dff
XDFF_546 CK g856 g26698 VDD VSS dff
XDFF_547 CK g860 g26699 VDD VSS dff
XDFF_548 CK g861 g26700 VDD VSS dff
XDFF_549 CK g859 g26701 VDD VSS dff
XDFF_550 CK g863 g26702 VDD VSS dff
XDFF_551 CK g864 g26703 VDD VSS dff
XDFF_552 CK g862 g26704 VDD VSS dff
XDFF_553 CK g866 g26705 VDD VSS dff
XDFF_554 CK g867 g26706 VDD VSS dff
XDFF_555 CK g865 g26707 VDD VSS dff
XDFF_556 CK g873 g30521 VDD VSS dff
XDFF_557 CK g876 g30522 VDD VSS dff
XDFF_558 CK g879 g30523 VDD VSS dff
XDFF_559 CK g918 g30860 VDD VSS dff
XDFF_560 CK g921 g30861 VDD VSS dff
XDFF_561 CK g924 g30862 VDD VSS dff
XDFF_562 CK g882 g30854 VDD VSS dff
XDFF_563 CK g885 g30855 VDD VSS dff
XDFF_564 CK g888 g30856 VDD VSS dff
XDFF_565 CK g927 g30863 VDD VSS dff
XDFF_566 CK g930 g30864 VDD VSS dff
XDFF_567 CK g933 g30865 VDD VSS dff
XDFF_568 CK g891 g30524 VDD VSS dff
XDFF_569 CK g894 g30525 VDD VSS dff
XDFF_570 CK g897 g30526 VDD VSS dff
XDFF_571 CK g936 g30530 VDD VSS dff
XDFF_572 CK g939 g30531 VDD VSS dff
XDFF_573 CK g942 g30532 VDD VSS dff
XDFF_574 CK g900 g30527 VDD VSS dff
XDFF_575 CK g903 g30528 VDD VSS dff
XDFF_576 CK g906 g30529 VDD VSS dff
XDFF_577 CK g945 g30533 VDD VSS dff
XDFF_578 CK g948 g30534 VDD VSS dff
XDFF_579 CK g951 g30535 VDD VSS dff
XDFF_580 CK g909 g30857 VDD VSS dff
XDFF_581 CK g912 g30858 VDD VSS dff
XDFF_582 CK g915 g30859 VDD VSS dff
XDFF_583 CK g954 g30866 VDD VSS dff
XDFF_584 CK g957 g30867 VDD VSS dff
XDFF_585 CK g960 g30868 VDD VSS dff
XDFF_586 CK g780 g25992 VDD VSS dff
XDFF_587 CK g776 g26695 VDD VSS dff
XDFF_588 CK g771 g27198 VDD VSS dff
XDFF_589 CK g767 g27691 VDD VSS dff
XDFF_590 CK g762 g28232 VDD VSS dff
XDFF_591 CK g758 g28678 VDD VSS dff
XDFF_592 CK g753 g29139 VDD VSS dff
XDFF_593 CK g749 g29420 VDD VSS dff
XDFF_594 CK g744 g29634 VDD VSS dff
XDFF_595 CK g740 g29798 VDD VSS dff
XDFF_596 CK g868 g20559 VDD VSS dff
XDFF_597 CK g5595 g868 VDD VSS dff
XDFF_598 CK g869 g5595 VDD VSS dff
XDFF_599 CK g5472 g13422 VDD VSS dff
XDFF_600 CK g6712 g5472 VDD VSS dff
XDFF_601 CK g1088 g6712 VDD VSS dff
XDFF_602 CK g996 g11523 VDD VSS dff
XDFF_603 CK g1041 g28233 VDD VSS dff
XDFF_604 CK g1030 g28234 VDD VSS dff
XDFF_605 CK g1033 g28235 VDD VSS dff
XDFF_606 CK g1056 g28236 VDD VSS dff
XDFF_607 CK g1045 g28237 VDD VSS dff
XDFF_608 CK g1048 g28238 VDD VSS dff
XDFF_609 CK g1071 g28239 VDD VSS dff
XDFF_610 CK g1060 g28240 VDD VSS dff
XDFF_611 CK g1063 g28241 VDD VSS dff
XDFF_612 CK g1085 g28242 VDD VSS dff
XDFF_613 CK g1075 g28243 VDD VSS dff
XDFF_614 CK g1078 g28244 VDD VSS dff
XDFF_615 CK g1095 g29421 VDD VSS dff
XDFF_616 CK g1098 g29422 VDD VSS dff
XDFF_617 CK g1101 g29423 VDD VSS dff
XDFF_618 CK g1104 g29638 VDD VSS dff
XDFF_619 CK g1107 g29639 VDD VSS dff
XDFF_620 CK g1110 g29640 VDD VSS dff
XDFF_621 CK g1114 g29424 VDD VSS dff
XDFF_622 CK g1115 g29425 VDD VSS dff
XDFF_623 CK g1113 g29426 VDD VSS dff
XDFF_624 CK g1116 g27692 VDD VSS dff
XDFF_625 CK g1119 g27693 VDD VSS dff
XDFF_626 CK g1122 g27694 VDD VSS dff
XDFF_627 CK g1125 g27695 VDD VSS dff
XDFF_628 CK g1128 g27696 VDD VSS dff
XDFF_629 CK g1131 g27697 VDD VSS dff
XDFF_630 CK g1135 g28679 VDD VSS dff
XDFF_631 CK g1136 g28680 VDD VSS dff
XDFF_632 CK g1134 g28681 VDD VSS dff
XDFF_633 CK g999 g29799 VDD VSS dff
XDFF_634 CK g1000 g29800 VDD VSS dff
XDFF_635 CK g1001 g29801 VDD VSS dff
XDFF_636 CK g1002 g30869 VDD VSS dff
XDFF_637 CK g1003 g30870 VDD VSS dff
XDFF_638 CK g1004 g30871 VDD VSS dff
XDFF_639 CK g1005 g30713 VDD VSS dff
XDFF_640 CK g1006 g30714 VDD VSS dff
XDFF_641 CK g1007 g30715 VDD VSS dff
XDFF_642 CK g1009 g29635 VDD VSS dff
XDFF_643 CK g1010 g29636 VDD VSS dff
XDFF_644 CK g1008 g29637 VDD VSS dff
XDFF_645 CK g1090 g27206 VDD VSS dff
XDFF_646 CK g1091 g27207 VDD VSS dff
XDFF_647 CK g1089 g27208 VDD VSS dff
XDFF_648 CK g1137 g11536 VDD VSS dff
XDFF_649 CK g1138 g1137 VDD VSS dff
XDFF_650 CK g1139 g11537 VDD VSS dff
XDFF_651 CK g1140 g1139 VDD VSS dff
XDFF_652 CK g1141 g11538 VDD VSS dff
XDFF_653 CK g966 g1141 VDD VSS dff
XDFF_654 CK g967 g11518 VDD VSS dff
XDFF_655 CK g968 g967 VDD VSS dff
XDFF_656 CK g969 g11519 VDD VSS dff
XDFF_657 CK g970 g969 VDD VSS dff
XDFF_658 CK g971 g11520 VDD VSS dff
XDFF_659 CK g972 g971 VDD VSS dff
XDFF_660 CK g973 g11521 VDD VSS dff
XDFF_661 CK g974 g973 VDD VSS dff
XDFF_662 CK g975 g11522 VDD VSS dff
XDFF_663 CK g976 g975 VDD VSS dff
XDFF_664 CK g977 g13423 VDD VSS dff
XDFF_665 CK g978 g977 VDD VSS dff
XDFF_666 CK g986 g19024 VDD VSS dff
XDFF_667 CK g992 g27200 VDD VSS dff
XDFF_668 CK g995 g27201 VDD VSS dff
XDFF_669 CK g984 g27202 VDD VSS dff
XDFF_670 CK g983 g27203 VDD VSS dff
XDFF_671 CK g982 g27204 VDD VSS dff
XDFF_672 CK g981 g27205 VDD VSS dff
XDFF_673 CK g991 g19028 VDD VSS dff
XDFF_674 CK g990 g19027 VDD VSS dff
XDFF_675 CK g989 g19026 VDD VSS dff
XDFF_676 CK g988 g19025 VDD VSS dff
XDFF_677 CK g987 g25141 VDD VSS dff
XDFF_678 CK g985 g27199 VDD VSS dff
XDFF_679 CK g1029 g11524 VDD VSS dff
XDFF_680 CK g1036 g1029 VDD VSS dff
XDFF_681 CK g1037 g11525 VDD VSS dff
XDFF_682 CK g1038 g1037 VDD VSS dff
XDFF_683 CK g1039 g11526 VDD VSS dff
XDFF_684 CK g1040 g1039 VDD VSS dff
XDFF_685 CK g1044 g11527 VDD VSS dff
XDFF_686 CK g1051 g1044 VDD VSS dff
XDFF_687 CK g1052 g11528 VDD VSS dff
XDFF_688 CK g1053 g1052 VDD VSS dff
XDFF_689 CK g1054 g11529 VDD VSS dff
XDFF_690 CK g1055 g1054 VDD VSS dff
XDFF_691 CK g1059 g11530 VDD VSS dff
XDFF_692 CK g1066 g1059 VDD VSS dff
XDFF_693 CK g1067 g11531 VDD VSS dff
XDFF_694 CK g1068 g1067 VDD VSS dff
XDFF_695 CK g1069 g11532 VDD VSS dff
XDFF_696 CK g1070 g1069 VDD VSS dff
XDFF_697 CK g1074 g11533 VDD VSS dff
XDFF_698 CK g1081 g1074 VDD VSS dff
XDFF_699 CK g1082 g11534 VDD VSS dff
XDFF_700 CK g1083 g1082 VDD VSS dff
XDFF_701 CK g1084 g11535 VDD VSS dff
XDFF_702 CK g1011 g1084 VDD VSS dff
XDFF_703 CK g5657 g13424 VDD VSS dff
XDFF_704 CK g5686 g5657 VDD VSS dff
XDFF_705 CK g1024 g5686 VDD VSS dff
XDFF_706 CK g6750 g13435 VDD VSS dff
XDFF_707 CK g6944 g6750 VDD VSS dff
XDFF_708 CK g1236 g6944 VDD VSS dff
XDFF_709 CK g1240 g23198 VDD VSS dff
XDFF_710 CK g1243 g20560 VDD VSS dff
XDFF_711 CK g1196 g20561 VDD VSS dff
XDFF_712 CK g1199 g16469 VDD VSS dff
XDFF_713 CK g1209 g1199 VDD VSS dff
XDFF_714 CK g1210 g1209 VDD VSS dff
XDFF_715 CK g1250 g11539 VDD VSS dff
XDFF_716 CK g1255 g1250 VDD VSS dff
XDFF_717 CK g1256 g11542 VDD VSS dff
XDFF_718 CK g1257 g1256 VDD VSS dff
XDFF_719 CK g1258 g11543 VDD VSS dff
XDFF_720 CK g1259 g1258 VDD VSS dff
XDFF_721 CK g1260 g11544 VDD VSS dff
XDFF_722 CK g1251 g1260 VDD VSS dff
XDFF_723 CK g1252 g11540 VDD VSS dff
XDFF_724 CK g1253 g1252 VDD VSS dff
XDFF_725 CK g1254 g11541 VDD VSS dff
XDFF_726 CK g1176 g1254 VDD VSS dff
XDFF_727 CK g7961 g13425 VDD VSS dff
XDFF_728 CK g8007 g7961 VDD VSS dff
XDFF_729 CK g1172 g8007 VDD VSS dff
XDFF_730 CK g1173 g24333 VDD VSS dff
XDFF_731 CK g1174 g24334 VDD VSS dff
XDFF_732 CK g1175 g24335 VDD VSS dff
XDFF_733 CK g1142 g25150 VDD VSS dff
XDFF_734 CK g1145 g25142 VDD VSS dff
XDFF_735 CK g1148 g25143 VDD VSS dff
XDFF_736 CK g1164 g25147 VDD VSS dff
XDFF_737 CK g1165 g25148 VDD VSS dff
XDFF_738 CK g1166 g25149 VDD VSS dff
XDFF_739 CK g1167 g24330 VDD VSS dff
XDFF_740 CK g1171 g24331 VDD VSS dff
XDFF_741 CK g1151 g24332 VDD VSS dff
XDFF_742 CK g1152 g25144 VDD VSS dff
XDFF_743 CK g1155 g25145 VDD VSS dff
XDFF_744 CK g1158 g25146 VDD VSS dff
XDFF_745 CK g1214 g16470 VDD VSS dff
XDFF_746 CK g1221 g1214 VDD VSS dff
XDFF_747 CK g1228 g1221 VDD VSS dff
XDFF_748 CK g1229 g19033 VDD VSS dff
XDFF_749 CK g1230 g1229 VDD VSS dff
XDFF_750 CK g1234 g27217 VDD VSS dff
XDFF_751 CK g1235 g19034 VDD VSS dff
XDFF_752 CK g1186 g1235 VDD VSS dff
XDFF_753 CK g1244 g19035 VDD VSS dff
XDFF_754 CK g1245 g1244 VDD VSS dff
XDFF_755 CK g1262 g28245 VDD VSS dff
XDFF_756 CK g1263 g28246 VDD VSS dff
XDFF_757 CK g1261 g28247 VDD VSS dff
XDFF_758 CK g1265 g28248 VDD VSS dff
XDFF_759 CK g1266 g28249 VDD VSS dff
XDFF_760 CK g1264 g28250 VDD VSS dff
XDFF_761 CK g1268 g28251 VDD VSS dff
XDFF_762 CK g1269 g28252 VDD VSS dff
XDFF_763 CK g1267 g28253 VDD VSS dff
XDFF_764 CK g1271 g28254 VDD VSS dff
XDFF_765 CK g1272 g28255 VDD VSS dff
XDFF_766 CK g1270 g28256 VDD VSS dff
XDFF_767 CK g1273 g25994 VDD VSS dff
XDFF_768 CK g1276 g25995 VDD VSS dff
XDFF_769 CK g1279 g25996 VDD VSS dff
XDFF_770 CK g1282 g25997 VDD VSS dff
XDFF_771 CK g1285 g25998 VDD VSS dff
XDFF_772 CK g1288 g25999 VDD VSS dff
XDFF_773 CK g1300 g29143 VDD VSS dff
XDFF_774 CK g1303 g29144 VDD VSS dff
XDFF_775 CK g1306 g29145 VDD VSS dff
XDFF_776 CK g1291 g29140 VDD VSS dff
XDFF_777 CK g1294 g29141 VDD VSS dff
XDFF_778 CK g1297 g29142 VDD VSS dff
XDFF_779 CK g1177 g27209 VDD VSS dff
XDFF_780 CK g1180 g27210 VDD VSS dff
XDFF_781 CK g1183 g27211 VDD VSS dff
XDFF_782 CK g1192 g8293 VDD VSS dff
XDFF_783 CK g1193 g24336 VDD VSS dff
XDFF_784 CK g1194 g19029 VDD VSS dff
XDFF_785 CK g1195 g19030 VDD VSS dff
XDFF_786 CK g1200 g19031 VDD VSS dff
XDFF_787 CK g1201 g19032 VDD VSS dff
XDFF_788 CK g1202 g27216 VDD VSS dff
XDFF_789 CK g1203 g27215 VDD VSS dff
XDFF_790 CK g1204 g27214 VDD VSS dff
XDFF_791 CK g1205 g27213 VDD VSS dff
XDFF_792 CK g16355 g27212 VDD VSS dff
XDFF_793 CK g1211 g16355 VDD VSS dff
XDFF_794 CK g1215 g13426 VDD VSS dff
XDFF_795 CK g1216 g13427 VDD VSS dff
XDFF_796 CK g1217 g13428 VDD VSS dff
XDFF_797 CK g1218 g13429 VDD VSS dff
XDFF_798 CK g1219 g13430 VDD VSS dff
XDFF_799 CK g1220 g13431 VDD VSS dff
XDFF_800 CK g1222 g13432 VDD VSS dff
XDFF_801 CK g1223 g13433 VDD VSS dff
XDFF_802 CK g1224 g25993 VDD VSS dff
XDFF_803 CK g1227 g13434 VDD VSS dff
XDFF_804 CK g6979 g13436 VDD VSS dff
XDFF_805 CK g7161 g6979 VDD VSS dff
XDFF_806 CK g1315 g7161 VDD VSS dff
XDFF_807 CK g1316 g20562 VDD VSS dff
XDFF_808 CK g1345 g21944 VDD VSS dff
XDFF_809 CK g1326 g23199 VDD VSS dff
XDFF_810 CK g1319 g24337 VDD VSS dff
XDFF_811 CK g1339 g25151 VDD VSS dff
XDFF_812 CK g1332 g26000 VDD VSS dff
XDFF_813 CK g1346 g26708 VDD VSS dff
XDFF_814 CK g1358 g27218 VDD VSS dff
XDFF_815 CK g1352 g27698 VDD VSS dff
XDFF_816 CK g1365 g28257 VDD VSS dff
XDFF_817 CK g1372 g28682 VDD VSS dff
XDFF_818 CK g1378 g29146 VDD VSS dff
XDFF_819 CK g1385 g23200 VDD VSS dff
XDFF_820 CK g1386 g23201 VDD VSS dff
XDFF_821 CK g1384 g23202 VDD VSS dff
XDFF_822 CK g1388 g23203 VDD VSS dff
XDFF_823 CK g1389 g23204 VDD VSS dff
XDFF_824 CK g1387 g23205 VDD VSS dff
XDFF_825 CK g1391 g23206 VDD VSS dff
XDFF_826 CK g1392 g23207 VDD VSS dff
XDFF_827 CK g1390 g23208 VDD VSS dff
XDFF_828 CK g1394 g23209 VDD VSS dff
XDFF_829 CK g1395 g23210 VDD VSS dff
XDFF_830 CK g1393 g23211 VDD VSS dff
XDFF_831 CK g1397 g23212 VDD VSS dff
XDFF_832 CK g1398 g23213 VDD VSS dff
XDFF_833 CK g1396 g23214 VDD VSS dff
XDFF_834 CK g1400 g23215 VDD VSS dff
XDFF_835 CK g1401 g23216 VDD VSS dff
XDFF_836 CK g1399 g23217 VDD VSS dff
XDFF_837 CK g1403 g23218 VDD VSS dff
XDFF_838 CK g1404 g23219 VDD VSS dff
XDFF_839 CK g1402 g23220 VDD VSS dff
XDFF_840 CK g1406 g23221 VDD VSS dff
XDFF_841 CK g1407 g23222 VDD VSS dff
XDFF_842 CK g1405 g23223 VDD VSS dff
XDFF_843 CK g1409 g23224 VDD VSS dff
XDFF_844 CK g1410 g23225 VDD VSS dff
XDFF_845 CK g1408 g23226 VDD VSS dff
XDFF_846 CK g1412 g23227 VDD VSS dff
XDFF_847 CK g1413 g23228 VDD VSS dff
XDFF_848 CK g1411 g23229 VDD VSS dff
XDFF_849 CK g1415 g23230 VDD VSS dff
XDFF_850 CK g1416 g23231 VDD VSS dff
XDFF_851 CK g1414 g23232 VDD VSS dff
XDFF_852 CK g1418 g23233 VDD VSS dff
XDFF_853 CK g1419 g23234 VDD VSS dff
XDFF_854 CK g1417 g23235 VDD VSS dff
XDFF_855 CK g1421 g26709 VDD VSS dff
XDFF_856 CK g1422 g26710 VDD VSS dff
XDFF_857 CK g1420 g26711 VDD VSS dff
XDFF_858 CK g1424 g24338 VDD VSS dff
XDFF_859 CK g1425 g24339 VDD VSS dff
XDFF_860 CK g1423 g24340 VDD VSS dff
XDFF_861 CK g6573 g13437 VDD VSS dff
XDFF_862 CK g6782 g6573 VDD VSS dff
XDFF_863 CK g1547 g6782 VDD VSS dff
XDFF_864 CK g1512 g24341 VDD VSS dff
XDFF_865 CK g1513 g24342 VDD VSS dff
XDFF_866 CK g1511 g24343 VDD VSS dff
XDFF_867 CK g1515 g24344 VDD VSS dff
XDFF_868 CK g1516 g24345 VDD VSS dff
XDFF_869 CK g1514 g24346 VDD VSS dff
XDFF_870 CK g1524 g24347 VDD VSS dff
XDFF_871 CK g1525 g24348 VDD VSS dff
XDFF_872 CK g1523 g24349 VDD VSS dff
XDFF_873 CK g1527 g24350 VDD VSS dff
XDFF_874 CK g1528 g24351 VDD VSS dff
XDFF_875 CK g1526 g24352 VDD VSS dff
XDFF_876 CK g1530 g24353 VDD VSS dff
XDFF_877 CK g1531 g24354 VDD VSS dff
XDFF_878 CK g1529 g24355 VDD VSS dff
XDFF_879 CK g1533 g24356 VDD VSS dff
XDFF_880 CK g1534 g24357 VDD VSS dff
XDFF_881 CK g1532 g24358 VDD VSS dff
XDFF_882 CK g1536 g24359 VDD VSS dff
XDFF_883 CK g1537 g24360 VDD VSS dff
XDFF_884 CK g1535 g24361 VDD VSS dff
XDFF_885 CK g1539 g24362 VDD VSS dff
XDFF_886 CK g1540 g24363 VDD VSS dff
XDFF_887 CK g1538 g24364 VDD VSS dff
XDFF_888 CK g1542 g24365 VDD VSS dff
XDFF_889 CK g1543 g24366 VDD VSS dff
XDFF_890 CK g1541 g24367 VDD VSS dff
XDFF_891 CK g1545 g24368 VDD VSS dff
XDFF_892 CK g1546 g24369 VDD VSS dff
XDFF_893 CK g1544 g24370 VDD VSS dff
XDFF_894 CK g1551 g26713 VDD VSS dff
XDFF_895 CK g1552 g26714 VDD VSS dff
XDFF_896 CK g1550 g26715 VDD VSS dff
XDFF_897 CK g1554 g26716 VDD VSS dff
XDFF_898 CK g1555 g26717 VDD VSS dff
XDFF_899 CK g1553 g26718 VDD VSS dff
XDFF_900 CK g1557 g26719 VDD VSS dff
XDFF_901 CK g1558 g26720 VDD VSS dff
XDFF_902 CK g1556 g26721 VDD VSS dff
XDFF_903 CK g1560 g26722 VDD VSS dff
XDFF_904 CK g1561 g26723 VDD VSS dff
XDFF_905 CK g1559 g26724 VDD VSS dff
XDFF_906 CK g1567 g30536 VDD VSS dff
XDFF_907 CK g1570 g30537 VDD VSS dff
XDFF_908 CK g1573 g30538 VDD VSS dff
XDFF_909 CK g1612 g30878 VDD VSS dff
XDFF_910 CK g1615 g30879 VDD VSS dff
XDFF_911 CK g1618 g30880 VDD VSS dff
XDFF_912 CK g1576 g30872 VDD VSS dff
XDFF_913 CK g1579 g30873 VDD VSS dff
XDFF_914 CK g1582 g30874 VDD VSS dff
XDFF_915 CK g1621 g30881 VDD VSS dff
XDFF_916 CK g1624 g30882 VDD VSS dff
XDFF_917 CK g1627 g30883 VDD VSS dff
XDFF_918 CK g1585 g30539 VDD VSS dff
XDFF_919 CK g1588 g30540 VDD VSS dff
XDFF_920 CK g1591 g30541 VDD VSS dff
XDFF_921 CK g1630 g30545 VDD VSS dff
XDFF_922 CK g1633 g30546 VDD VSS dff
XDFF_923 CK g1636 g30547 VDD VSS dff
XDFF_924 CK g1594 g30542 VDD VSS dff
XDFF_925 CK g1597 g30543 VDD VSS dff
XDFF_926 CK g1600 g30544 VDD VSS dff
XDFF_927 CK g1639 g30548 VDD VSS dff
XDFF_928 CK g1642 g30549 VDD VSS dff
XDFF_929 CK g1645 g30550 VDD VSS dff
XDFF_930 CK g1603 g30875 VDD VSS dff
XDFF_931 CK g1606 g30876 VDD VSS dff
XDFF_932 CK g1609 g30877 VDD VSS dff
XDFF_933 CK g1648 g30884 VDD VSS dff
XDFF_934 CK g1651 g30885 VDD VSS dff
XDFF_935 CK g1654 g30886 VDD VSS dff
XDFF_936 CK g1466 g26001 VDD VSS dff
XDFF_937 CK g1462 g26712 VDD VSS dff
XDFF_938 CK g1457 g27219 VDD VSS dff
XDFF_939 CK g1453 g27699 VDD VSS dff
XDFF_940 CK g1448 g28258 VDD VSS dff
XDFF_941 CK g1444 g28683 VDD VSS dff
XDFF_942 CK g1439 g29147 VDD VSS dff
XDFF_943 CK g1435 g29427 VDD VSS dff
XDFF_944 CK g1430 g29641 VDD VSS dff
XDFF_945 CK g1426 g29802 VDD VSS dff
XDFF_946 CK g1562 g20563 VDD VSS dff
XDFF_947 CK g5612 g1562 VDD VSS dff
XDFF_948 CK g1563 g5612 VDD VSS dff
XDFF_949 CK g5511 g13438 VDD VSS dff
XDFF_950 CK g7014 g5511 VDD VSS dff
XDFF_951 CK g1782 g7014 VDD VSS dff
XDFF_952 CK g1690 g11550 VDD VSS dff
XDFF_953 CK g1735 g28259 VDD VSS dff
XDFF_954 CK g1724 g28260 VDD VSS dff
XDFF_955 CK g1727 g28261 VDD VSS dff
XDFF_956 CK g1750 g28262 VDD VSS dff
XDFF_957 CK g1739 g28263 VDD VSS dff
XDFF_958 CK g1742 g28264 VDD VSS dff
XDFF_959 CK g1765 g28265 VDD VSS dff
XDFF_960 CK g1754 g28266 VDD VSS dff
XDFF_961 CK g1757 g28267 VDD VSS dff
XDFF_962 CK g1779 g28268 VDD VSS dff
XDFF_963 CK g1769 g28269 VDD VSS dff
XDFF_964 CK g1772 g28270 VDD VSS dff
XDFF_965 CK g1789 g29434 VDD VSS dff
XDFF_966 CK g1792 g29435 VDD VSS dff
XDFF_967 CK g1795 g29436 VDD VSS dff
XDFF_968 CK g1798 g29645 VDD VSS dff
XDFF_969 CK g1801 g29646 VDD VSS dff
XDFF_970 CK g1804 g29647 VDD VSS dff
XDFF_971 CK g1808 g29437 VDD VSS dff
XDFF_972 CK g1809 g29438 VDD VSS dff
XDFF_973 CK g1807 g29439 VDD VSS dff
XDFF_974 CK g1810 g27700 VDD VSS dff
XDFF_975 CK g1813 g27701 VDD VSS dff
XDFF_976 CK g1816 g27702 VDD VSS dff
XDFF_977 CK g1819 g27703 VDD VSS dff
XDFF_978 CK g1822 g27704 VDD VSS dff
XDFF_979 CK g1825 g27705 VDD VSS dff
XDFF_980 CK g1829 g28684 VDD VSS dff
XDFF_981 CK g1830 g28685 VDD VSS dff
XDFF_982 CK g1828 g28686 VDD VSS dff
XDFF_983 CK g1693 g29803 VDD VSS dff
XDFF_984 CK g1694 g29804 VDD VSS dff
XDFF_985 CK g1695 g29805 VDD VSS dff
XDFF_986 CK g1696 g30887 VDD VSS dff
XDFF_987 CK g1697 g30888 VDD VSS dff
XDFF_988 CK g1698 g30889 VDD VSS dff
XDFF_989 CK g1699 g30716 VDD VSS dff
XDFF_990 CK g1700 g30717 VDD VSS dff
XDFF_991 CK g1701 g30718 VDD VSS dff
XDFF_992 CK g1703 g29642 VDD VSS dff
XDFF_993 CK g1704 g29643 VDD VSS dff
XDFF_994 CK g1702 g29644 VDD VSS dff
XDFF_995 CK g1784 g27221 VDD VSS dff
XDFF_996 CK g1785 g27222 VDD VSS dff
XDFF_997 CK g1783 g27223 VDD VSS dff
XDFF_998 CK g1831 g11563 VDD VSS dff
XDFF_999 CK g1832 g1831 VDD VSS dff
XDFF_1000 CK g1833 g11564 VDD VSS dff
XDFF_1001 CK g1834 g1833 VDD VSS dff
XDFF_1002 CK g1835 g11565 VDD VSS dff
XDFF_1003 CK g1660 g1835 VDD VSS dff
XDFF_1004 CK g1661 g11545 VDD VSS dff
XDFF_1005 CK g1662 g1661 VDD VSS dff
XDFF_1006 CK g1663 g11546 VDD VSS dff
XDFF_1007 CK g1664 g1663 VDD VSS dff
XDFF_1008 CK g1665 g11547 VDD VSS dff
XDFF_1009 CK g1666 g1665 VDD VSS dff
XDFF_1010 CK g1667 g11548 VDD VSS dff
XDFF_1011 CK g1668 g1667 VDD VSS dff
XDFF_1012 CK g1669 g11549 VDD VSS dff
XDFF_1013 CK g1670 g1669 VDD VSS dff
XDFF_1014 CK g1671 g13439 VDD VSS dff
XDFF_1015 CK g1672 g1671 VDD VSS dff
XDFF_1016 CK g1680 g19036 VDD VSS dff
XDFF_1017 CK g1686 g29428 VDD VSS dff
XDFF_1018 CK g1689 g29429 VDD VSS dff
XDFF_1019 CK g1678 g29430 VDD VSS dff
XDFF_1020 CK g1677 g29431 VDD VSS dff
XDFF_1021 CK g1676 g29432 VDD VSS dff
XDFF_1022 CK g1675 g29433 VDD VSS dff
XDFF_1023 CK g1685 g19040 VDD VSS dff
XDFF_1024 CK g1684 g19039 VDD VSS dff
XDFF_1025 CK g1683 g19038 VDD VSS dff
XDFF_1026 CK g1682 g19037 VDD VSS dff
XDFF_1027 CK g1681 g25152 VDD VSS dff
XDFF_1028 CK g1679 g27220 VDD VSS dff
XDFF_1029 CK g1723 g11551 VDD VSS dff
XDFF_1030 CK g1730 g1723 VDD VSS dff
XDFF_1031 CK g1731 g11552 VDD VSS dff
XDFF_1032 CK g1732 g1731 VDD VSS dff
XDFF_1033 CK g1733 g11553 VDD VSS dff
XDFF_1034 CK g1734 g1733 VDD VSS dff
XDFF_1035 CK g1738 g11554 VDD VSS dff
XDFF_1036 CK g1745 g1738 VDD VSS dff
XDFF_1037 CK g1746 g11555 VDD VSS dff
XDFF_1038 CK g1747 g1746 VDD VSS dff
XDFF_1039 CK g1748 g11556 VDD VSS dff
XDFF_1040 CK g1749 g1748 VDD VSS dff
XDFF_1041 CK g1753 g11557 VDD VSS dff
XDFF_1042 CK g1760 g1753 VDD VSS dff
XDFF_1043 CK g1761 g11558 VDD VSS dff
XDFF_1044 CK g1762 g1761 VDD VSS dff
XDFF_1045 CK g1763 g11559 VDD VSS dff
XDFF_1046 CK g1764 g1763 VDD VSS dff
XDFF_1047 CK g1768 g11560 VDD VSS dff
XDFF_1048 CK g1775 g1768 VDD VSS dff
XDFF_1049 CK g1776 g11561 VDD VSS dff
XDFF_1050 CK g1777 g1776 VDD VSS dff
XDFF_1051 CK g1778 g11562 VDD VSS dff
XDFF_1052 CK g1705 g1778 VDD VSS dff
XDFF_1053 CK g5695 g13440 VDD VSS dff
XDFF_1054 CK g5738 g5695 VDD VSS dff
XDFF_1055 CK g1718 g5738 VDD VSS dff
XDFF_1056 CK g7052 g13451 VDD VSS dff
XDFF_1057 CK g7194 g7052 VDD VSS dff
XDFF_1058 CK g1930 g7194 VDD VSS dff
XDFF_1059 CK g1934 g23236 VDD VSS dff
XDFF_1060 CK g1937 g20564 VDD VSS dff
XDFF_1061 CK g1890 g20565 VDD VSS dff
XDFF_1062 CK g1893 g16471 VDD VSS dff
XDFF_1063 CK g1903 g1893 VDD VSS dff
XDFF_1064 CK g1904 g1903 VDD VSS dff
XDFF_1065 CK g1944 g11566 VDD VSS dff
XDFF_1066 CK g1949 g1944 VDD VSS dff
XDFF_1067 CK g1950 g11569 VDD VSS dff
XDFF_1068 CK g1951 g1950 VDD VSS dff
XDFF_1069 CK g1952 g11570 VDD VSS dff
XDFF_1070 CK g1953 g1952 VDD VSS dff
XDFF_1071 CK g1954 g11571 VDD VSS dff
XDFF_1072 CK g1945 g1954 VDD VSS dff
XDFF_1073 CK g1946 g11567 VDD VSS dff
XDFF_1074 CK g1947 g1946 VDD VSS dff
XDFF_1075 CK g1948 g11568 VDD VSS dff
XDFF_1076 CK g1870 g1948 VDD VSS dff
XDFF_1077 CK g8012 g13441 VDD VSS dff
XDFF_1078 CK g8082 g8012 VDD VSS dff
XDFF_1079 CK g1866 g8082 VDD VSS dff
XDFF_1080 CK g1867 g24374 VDD VSS dff
XDFF_1081 CK g1868 g24375 VDD VSS dff
XDFF_1082 CK g1869 g24376 VDD VSS dff
XDFF_1083 CK g1836 g25161 VDD VSS dff
XDFF_1084 CK g1839 g25153 VDD VSS dff
XDFF_1085 CK g1842 g25154 VDD VSS dff
XDFF_1086 CK g1858 g25158 VDD VSS dff
XDFF_1087 CK g1859 g25159 VDD VSS dff
XDFF_1088 CK g1860 g25160 VDD VSS dff
XDFF_1089 CK g1861 g24371 VDD VSS dff
XDFF_1090 CK g1865 g24372 VDD VSS dff
XDFF_1091 CK g1845 g24373 VDD VSS dff
XDFF_1092 CK g1846 g25155 VDD VSS dff
XDFF_1093 CK g1849 g25156 VDD VSS dff
XDFF_1094 CK g1852 g25157 VDD VSS dff
XDFF_1095 CK g1908 g16472 VDD VSS dff
XDFF_1096 CK g1915 g1908 VDD VSS dff
XDFF_1097 CK g1922 g1915 VDD VSS dff
XDFF_1098 CK g1923 g19045 VDD VSS dff
XDFF_1099 CK g1924 g1923 VDD VSS dff
XDFF_1100 CK g1928 g29445 VDD VSS dff
XDFF_1101 CK g1929 g19046 VDD VSS dff
XDFF_1102 CK g1880 g1929 VDD VSS dff
XDFF_1103 CK g1938 g19047 VDD VSS dff
XDFF_1104 CK g1939 g1938 VDD VSS dff
XDFF_1105 CK g1956 g28271 VDD VSS dff
XDFF_1106 CK g1957 g28272 VDD VSS dff
XDFF_1107 CK g1955 g28273 VDD VSS dff
XDFF_1108 CK g1959 g28274 VDD VSS dff
XDFF_1109 CK g1960 g28275 VDD VSS dff
XDFF_1110 CK g1958 g28276 VDD VSS dff
XDFF_1111 CK g1962 g28277 VDD VSS dff
XDFF_1112 CK g1963 g28278 VDD VSS dff
XDFF_1113 CK g1961 g28279 VDD VSS dff
XDFF_1114 CK g1965 g28280 VDD VSS dff
XDFF_1115 CK g1966 g28281 VDD VSS dff
XDFF_1116 CK g1964 g28282 VDD VSS dff
XDFF_1117 CK g1967 g26003 VDD VSS dff
XDFF_1118 CK g1970 g26004 VDD VSS dff
XDFF_1119 CK g1973 g26005 VDD VSS dff
XDFF_1120 CK g1976 g26006 VDD VSS dff
XDFF_1121 CK g1979 g26007 VDD VSS dff
XDFF_1122 CK g1982 g26008 VDD VSS dff
XDFF_1123 CK g1994 g29151 VDD VSS dff
XDFF_1124 CK g1997 g29152 VDD VSS dff
XDFF_1125 CK g2000 g29153 VDD VSS dff
XDFF_1126 CK g1985 g29148 VDD VSS dff
XDFF_1127 CK g1988 g29149 VDD VSS dff
XDFF_1128 CK g1991 g29150 VDD VSS dff
XDFF_1129 CK g1871 g27224 VDD VSS dff
XDFF_1130 CK g1874 g27225 VDD VSS dff
XDFF_1131 CK g1877 g27226 VDD VSS dff
XDFF_1132 CK g1886 g8302 VDD VSS dff
XDFF_1133 CK g1887 g24377 VDD VSS dff
XDFF_1134 CK g1888 g19041 VDD VSS dff
XDFF_1135 CK g1889 g19042 VDD VSS dff
XDFF_1136 CK g1894 g19043 VDD VSS dff
XDFF_1137 CK g1895 g19044 VDD VSS dff
XDFF_1138 CK g1896 g29444 VDD VSS dff
XDFF_1139 CK g1897 g29443 VDD VSS dff
XDFF_1140 CK g1898 g29442 VDD VSS dff
XDFF_1141 CK g1899 g29441 VDD VSS dff
XDFF_1142 CK g16399 g29440 VDD VSS dff
XDFF_1143 CK g1905 g16399 VDD VSS dff
XDFF_1144 CK g1909 g13442 VDD VSS dff
XDFF_1145 CK g1910 g13443 VDD VSS dff
XDFF_1146 CK g1911 g13444 VDD VSS dff
XDFF_1147 CK g1912 g13445 VDD VSS dff
XDFF_1148 CK g1913 g13446 VDD VSS dff
XDFF_1149 CK g1914 g13447 VDD VSS dff
XDFF_1150 CK g1916 g13448 VDD VSS dff
XDFF_1151 CK g1917 g13449 VDD VSS dff
XDFF_1152 CK g1918 g26002 VDD VSS dff
XDFF_1153 CK g1921 g13450 VDD VSS dff
XDFF_1154 CK g7229 g13452 VDD VSS dff
XDFF_1155 CK g7357 g7229 VDD VSS dff
XDFF_1156 CK g2009 g7357 VDD VSS dff
XDFF_1157 CK g2010 g20566 VDD VSS dff
XDFF_1158 CK g2039 g21945 VDD VSS dff
XDFF_1159 CK g2020 g23237 VDD VSS dff
XDFF_1160 CK g2013 g24378 VDD VSS dff
XDFF_1161 CK g2033 g25162 VDD VSS dff
XDFF_1162 CK g2026 g26009 VDD VSS dff
XDFF_1163 CK g2040 g26725 VDD VSS dff
XDFF_1164 CK g2052 g27227 VDD VSS dff
XDFF_1165 CK g2046 g27706 VDD VSS dff
XDFF_1166 CK g2059 g28283 VDD VSS dff
XDFF_1167 CK g2066 g28687 VDD VSS dff
XDFF_1168 CK g2072 g29154 VDD VSS dff
XDFF_1169 CK g2079 g23238 VDD VSS dff
XDFF_1170 CK g2080 g23239 VDD VSS dff
XDFF_1171 CK g2078 g23240 VDD VSS dff
XDFF_1172 CK g2082 g23241 VDD VSS dff
XDFF_1173 CK g2083 g23242 VDD VSS dff
XDFF_1174 CK g2081 g23243 VDD VSS dff
XDFF_1175 CK g2085 g23244 VDD VSS dff
XDFF_1176 CK g2086 g23245 VDD VSS dff
XDFF_1177 CK g2084 g23246 VDD VSS dff
XDFF_1178 CK g2088 g23247 VDD VSS dff
XDFF_1179 CK g2089 g23248 VDD VSS dff
XDFF_1180 CK g2087 g23249 VDD VSS dff
XDFF_1181 CK g2091 g23250 VDD VSS dff
XDFF_1182 CK g2092 g23251 VDD VSS dff
XDFF_1183 CK g2090 g23252 VDD VSS dff
XDFF_1184 CK g2094 g23253 VDD VSS dff
XDFF_1185 CK g2095 g23254 VDD VSS dff
XDFF_1186 CK g2093 g23255 VDD VSS dff
XDFF_1187 CK g2097 g23256 VDD VSS dff
XDFF_1188 CK g2098 g23257 VDD VSS dff
XDFF_1189 CK g2096 g23258 VDD VSS dff
XDFF_1190 CK g2100 g23259 VDD VSS dff
XDFF_1191 CK g2101 g23260 VDD VSS dff
XDFF_1192 CK g2099 g23261 VDD VSS dff
XDFF_1193 CK g2103 g23262 VDD VSS dff
XDFF_1194 CK g2104 g23263 VDD VSS dff
XDFF_1195 CK g2102 g23264 VDD VSS dff
XDFF_1196 CK g2106 g23265 VDD VSS dff
XDFF_1197 CK g2107 g23266 VDD VSS dff
XDFF_1198 CK g2105 g23267 VDD VSS dff
XDFF_1199 CK g2109 g23268 VDD VSS dff
XDFF_1200 CK g2110 g23269 VDD VSS dff
XDFF_1201 CK g2108 g23270 VDD VSS dff
XDFF_1202 CK g2112 g23271 VDD VSS dff
XDFF_1203 CK g2113 g23272 VDD VSS dff
XDFF_1204 CK g2111 g23273 VDD VSS dff
XDFF_1205 CK g2115 g26726 VDD VSS dff
XDFF_1206 CK g2116 g26727 VDD VSS dff
XDFF_1207 CK g2114 g26728 VDD VSS dff
XDFF_1208 CK g2118 g24379 VDD VSS dff
XDFF_1209 CK g2119 g24380 VDD VSS dff
XDFF_1210 CK g2117 g24381 VDD VSS dff
XDFF_1211 CK g6837 g13453 VDD VSS dff
XDFF_1212 CK g7084 g6837 VDD VSS dff
XDFF_1213 CK g2241 g7084 VDD VSS dff
XDFF_1214 CK g2206 g24382 VDD VSS dff
XDFF_1215 CK g2207 g24383 VDD VSS dff
XDFF_1216 CK g2205 g24384 VDD VSS dff
XDFF_1217 CK g2209 g24385 VDD VSS dff
XDFF_1218 CK g2210 g24386 VDD VSS dff
XDFF_1219 CK g2208 g24387 VDD VSS dff
XDFF_1220 CK g2218 g24388 VDD VSS dff
XDFF_1221 CK g2219 g24389 VDD VSS dff
XDFF_1222 CK g2217 g24390 VDD VSS dff
XDFF_1223 CK g2221 g24391 VDD VSS dff
XDFF_1224 CK g2222 g24392 VDD VSS dff
XDFF_1225 CK g2220 g24393 VDD VSS dff
XDFF_1226 CK g2224 g24394 VDD VSS dff
XDFF_1227 CK g2225 g24395 VDD VSS dff
XDFF_1228 CK g2223 g24396 VDD VSS dff
XDFF_1229 CK g2227 g24397 VDD VSS dff
XDFF_1230 CK g2228 g24398 VDD VSS dff
XDFF_1231 CK g2226 g24399 VDD VSS dff
XDFF_1232 CK g2230 g24400 VDD VSS dff
XDFF_1233 CK g2231 g24401 VDD VSS dff
XDFF_1234 CK g2229 g24402 VDD VSS dff
XDFF_1235 CK g2233 g24403 VDD VSS dff
XDFF_1236 CK g2234 g24404 VDD VSS dff
XDFF_1237 CK g2232 g24405 VDD VSS dff
XDFF_1238 CK g2236 g24406 VDD VSS dff
XDFF_1239 CK g2237 g24407 VDD VSS dff
XDFF_1240 CK g2235 g24408 VDD VSS dff
XDFF_1241 CK g2239 g24409 VDD VSS dff
XDFF_1242 CK g2240 g24410 VDD VSS dff
XDFF_1243 CK g2238 g24411 VDD VSS dff
XDFF_1244 CK g2245 g26730 VDD VSS dff
XDFF_1245 CK g2246 g26731 VDD VSS dff
XDFF_1246 CK g2244 g26732 VDD VSS dff
XDFF_1247 CK g2248 g26733 VDD VSS dff
XDFF_1248 CK g2249 g26734 VDD VSS dff
XDFF_1249 CK g2247 g26735 VDD VSS dff
XDFF_1250 CK g2251 g26736 VDD VSS dff
XDFF_1251 CK g2252 g26737 VDD VSS dff
XDFF_1252 CK g2250 g26738 VDD VSS dff
XDFF_1253 CK g2254 g26739 VDD VSS dff
XDFF_1254 CK g2255 g26740 VDD VSS dff
XDFF_1255 CK g2253 g26741 VDD VSS dff
XDFF_1256 CK g2261 g30551 VDD VSS dff
XDFF_1257 CK g2264 g30552 VDD VSS dff
XDFF_1258 CK g2267 g30553 VDD VSS dff
XDFF_1259 CK g2306 g30896 VDD VSS dff
XDFF_1260 CK g2309 g30897 VDD VSS dff
XDFF_1261 CK g2312 g30898 VDD VSS dff
XDFF_1262 CK g2270 g30890 VDD VSS dff
XDFF_1263 CK g2273 g30891 VDD VSS dff
XDFF_1264 CK g2276 g30892 VDD VSS dff
XDFF_1265 CK g2315 g30899 VDD VSS dff
XDFF_1266 CK g2318 g30900 VDD VSS dff
XDFF_1267 CK g2321 g30901 VDD VSS dff
XDFF_1268 CK g2279 g30554 VDD VSS dff
XDFF_1269 CK g2282 g30555 VDD VSS dff
XDFF_1270 CK g2285 g30556 VDD VSS dff
XDFF_1271 CK g2324 g30560 VDD VSS dff
XDFF_1272 CK g2327 g30561 VDD VSS dff
XDFF_1273 CK g2330 g30562 VDD VSS dff
XDFF_1274 CK g2288 g30557 VDD VSS dff
XDFF_1275 CK g2291 g30558 VDD VSS dff
XDFF_1276 CK g2294 g30559 VDD VSS dff
XDFF_1277 CK g2333 g30563 VDD VSS dff
XDFF_1278 CK g2336 g30564 VDD VSS dff
XDFF_1279 CK g2339 g30565 VDD VSS dff
XDFF_1280 CK g2297 g30893 VDD VSS dff
XDFF_1281 CK g2300 g30894 VDD VSS dff
XDFF_1282 CK g2303 g30895 VDD VSS dff
XDFF_1283 CK g2342 g30902 VDD VSS dff
XDFF_1284 CK g2345 g30903 VDD VSS dff
XDFF_1285 CK g2348 g30904 VDD VSS dff
XDFF_1286 CK g2160 g26010 VDD VSS dff
XDFF_1287 CK g2156 g26729 VDD VSS dff
XDFF_1288 CK g2151 g27228 VDD VSS dff
XDFF_1289 CK g2147 g27707 VDD VSS dff
XDFF_1290 CK g2142 g28284 VDD VSS dff
XDFF_1291 CK g2138 g28688 VDD VSS dff
XDFF_1292 CK g2133 g29155 VDD VSS dff
XDFF_1293 CK g2129 g29446 VDD VSS dff
XDFF_1294 CK g2124 g29648 VDD VSS dff
XDFF_1295 CK g2120 g29806 VDD VSS dff
XDFF_1296 CK g2256 g20567 VDD VSS dff
XDFF_1297 CK g5637 g2256 VDD VSS dff
XDFF_1298 CK g2257 g5637 VDD VSS dff
XDFF_1299 CK g5555 g13454 VDD VSS dff
XDFF_1300 CK g7264 g5555 VDD VSS dff
XDFF_1301 CK g2476 g7264 VDD VSS dff
XDFF_1302 CK g2384 g11577 VDD VSS dff
XDFF_1303 CK g2429 g28285 VDD VSS dff
XDFF_1304 CK g2418 g28286 VDD VSS dff
XDFF_1305 CK g2421 g28287 VDD VSS dff
XDFF_1306 CK g2444 g28288 VDD VSS dff
XDFF_1307 CK g2433 g28289 VDD VSS dff
XDFF_1308 CK g2436 g28290 VDD VSS dff
XDFF_1309 CK g2459 g28291 VDD VSS dff
XDFF_1310 CK g2448 g28292 VDD VSS dff
XDFF_1311 CK g2451 g28293 VDD VSS dff
XDFF_1312 CK g2473 g28294 VDD VSS dff
XDFF_1313 CK g2463 g28295 VDD VSS dff
XDFF_1314 CK g2466 g28296 VDD VSS dff
XDFF_1315 CK g2483 g29447 VDD VSS dff
XDFF_1316 CK g2486 g29448 VDD VSS dff
XDFF_1317 CK g2489 g29449 VDD VSS dff
XDFF_1318 CK g2492 g29652 VDD VSS dff
XDFF_1319 CK g2495 g29653 VDD VSS dff
XDFF_1320 CK g2498 g29654 VDD VSS dff
XDFF_1321 CK g2502 g29450 VDD VSS dff
XDFF_1322 CK g2503 g29451 VDD VSS dff
XDFF_1323 CK g2501 g29452 VDD VSS dff
XDFF_1324 CK g2504 g27708 VDD VSS dff
XDFF_1325 CK g2507 g27709 VDD VSS dff
XDFF_1326 CK g2510 g27710 VDD VSS dff
XDFF_1327 CK g2513 g27711 VDD VSS dff
XDFF_1328 CK g2516 g27712 VDD VSS dff
XDFF_1329 CK g2519 g27713 VDD VSS dff
XDFF_1330 CK g2523 g28689 VDD VSS dff
XDFF_1331 CK g2524 g28690 VDD VSS dff
XDFF_1332 CK g2522 g28691 VDD VSS dff
XDFF_1333 CK g2387 g29807 VDD VSS dff
XDFF_1334 CK g2388 g29808 VDD VSS dff
XDFF_1335 CK g2389 g29809 VDD VSS dff
XDFF_1336 CK g2390 g30905 VDD VSS dff
XDFF_1337 CK g2391 g30906 VDD VSS dff
XDFF_1338 CK g2392 g30907 VDD VSS dff
XDFF_1339 CK g2393 g30719 VDD VSS dff
XDFF_1340 CK g2394 g30720 VDD VSS dff
XDFF_1341 CK g2395 g30721 VDD VSS dff
XDFF_1342 CK g2397 g29649 VDD VSS dff
XDFF_1343 CK g2398 g29650 VDD VSS dff
XDFF_1344 CK g2396 g29651 VDD VSS dff
XDFF_1345 CK g2478 g27230 VDD VSS dff
XDFF_1346 CK g2479 g27231 VDD VSS dff
XDFF_1347 CK g2477 g27232 VDD VSS dff
XDFF_1348 CK g2525 g11590 VDD VSS dff
XDFF_1349 CK g2526 g2525 VDD VSS dff
XDFF_1350 CK g2527 g11591 VDD VSS dff
XDFF_1351 CK g2528 g2527 VDD VSS dff
XDFF_1352 CK g2529 g11592 VDD VSS dff
XDFF_1353 CK g2354 g2529 VDD VSS dff
XDFF_1354 CK g2355 g11572 VDD VSS dff
XDFF_1355 CK g2356 g2355 VDD VSS dff
XDFF_1356 CK g2357 g11573 VDD VSS dff
XDFF_1357 CK g2358 g2357 VDD VSS dff
XDFF_1358 CK g2359 g11574 VDD VSS dff
XDFF_1359 CK g2360 g2359 VDD VSS dff
XDFF_1360 CK g2361 g11575 VDD VSS dff
XDFF_1361 CK g2362 g2361 VDD VSS dff
XDFF_1362 CK g2363 g11576 VDD VSS dff
XDFF_1363 CK g2364 g2363 VDD VSS dff
XDFF_1364 CK g2365 g13455 VDD VSS dff
XDFF_1365 CK g2366 g2365 VDD VSS dff
XDFF_1366 CK g2374 g19048 VDD VSS dff
XDFF_1367 CK g2380 g30314 VDD VSS dff
XDFF_1368 CK g2383 g30315 VDD VSS dff
XDFF_1369 CK g2372 g30316 VDD VSS dff
XDFF_1370 CK g2371 g30317 VDD VSS dff
XDFF_1371 CK g2370 g30318 VDD VSS dff
XDFF_1372 CK g2369 g30319 VDD VSS dff
XDFF_1373 CK g2379 g19052 VDD VSS dff
XDFF_1374 CK g2378 g19051 VDD VSS dff
XDFF_1375 CK g2377 g19050 VDD VSS dff
XDFF_1376 CK g2376 g19049 VDD VSS dff
XDFF_1377 CK g2375 g25163 VDD VSS dff
XDFF_1378 CK g2373 g27229 VDD VSS dff
XDFF_1379 CK g2417 g11578 VDD VSS dff
XDFF_1380 CK g2424 g2417 VDD VSS dff
XDFF_1381 CK g2425 g11579 VDD VSS dff
XDFF_1382 CK g2426 g2425 VDD VSS dff
XDFF_1383 CK g2427 g11580 VDD VSS dff
XDFF_1384 CK g2428 g2427 VDD VSS dff
XDFF_1385 CK g2432 g11581 VDD VSS dff
XDFF_1386 CK g2439 g2432 VDD VSS dff
XDFF_1387 CK g2440 g11582 VDD VSS dff
XDFF_1388 CK g2441 g2440 VDD VSS dff
XDFF_1389 CK g2442 g11583 VDD VSS dff
XDFF_1390 CK g2443 g2442 VDD VSS dff
XDFF_1391 CK g2447 g11584 VDD VSS dff
XDFF_1392 CK g2454 g2447 VDD VSS dff
XDFF_1393 CK g2455 g11585 VDD VSS dff
XDFF_1394 CK g2456 g2455 VDD VSS dff
XDFF_1395 CK g2457 g11586 VDD VSS dff
XDFF_1396 CK g2458 g2457 VDD VSS dff
XDFF_1397 CK g2462 g11587 VDD VSS dff
XDFF_1398 CK g2469 g2462 VDD VSS dff
XDFF_1399 CK g2470 g11588 VDD VSS dff
XDFF_1400 CK g2471 g2470 VDD VSS dff
XDFF_1401 CK g2472 g11589 VDD VSS dff
XDFF_1402 CK g2399 g2472 VDD VSS dff
XDFF_1403 CK g5747 g13456 VDD VSS dff
XDFF_1404 CK g5796 g5747 VDD VSS dff
XDFF_1405 CK g2412 g5796 VDD VSS dff
XDFF_1406 CK g7302 g13467 VDD VSS dff
XDFF_1407 CK g7390 g7302 VDD VSS dff
XDFF_1408 CK g2624 g7390 VDD VSS dff
XDFF_1409 CK g2628 g23274 VDD VSS dff
XDFF_1410 CK g2631 g20568 VDD VSS dff
XDFF_1411 CK g2584 g20569 VDD VSS dff
XDFF_1412 CK g2587 g16473 VDD VSS dff
XDFF_1413 CK g2597 g2587 VDD VSS dff
XDFF_1414 CK g2598 g2597 VDD VSS dff
XDFF_1415 CK g2638 g11593 VDD VSS dff
XDFF_1416 CK g2643 g2638 VDD VSS dff
XDFF_1417 CK g2644 g11596 VDD VSS dff
XDFF_1418 CK g2645 g2644 VDD VSS dff
XDFF_1419 CK g2646 g11597 VDD VSS dff
XDFF_1420 CK g2647 g2646 VDD VSS dff
XDFF_1421 CK g2648 g11598 VDD VSS dff
XDFF_1422 CK g2639 g2648 VDD VSS dff
XDFF_1423 CK g2640 g11594 VDD VSS dff
XDFF_1424 CK g2641 g2640 VDD VSS dff
XDFF_1425 CK g2642 g11595 VDD VSS dff
XDFF_1426 CK g2564 g2642 VDD VSS dff
XDFF_1427 CK g8087 g13457 VDD VSS dff
XDFF_1428 CK g8167 g8087 VDD VSS dff
XDFF_1429 CK g2560 g8167 VDD VSS dff
XDFF_1430 CK g2561 g24415 VDD VSS dff
XDFF_1431 CK g2562 g24416 VDD VSS dff
XDFF_1432 CK g2563 g24417 VDD VSS dff
XDFF_1433 CK g2530 g25172 VDD VSS dff
XDFF_1434 CK g2533 g25164 VDD VSS dff
XDFF_1435 CK g2536 g25165 VDD VSS dff
XDFF_1436 CK g2552 g25169 VDD VSS dff
XDFF_1437 CK g2553 g25170 VDD VSS dff
XDFF_1438 CK g2554 g25171 VDD VSS dff
XDFF_1439 CK g2555 g24412 VDD VSS dff
XDFF_1440 CK g2559 g24413 VDD VSS dff
XDFF_1441 CK g2539 g24414 VDD VSS dff
XDFF_1442 CK g2540 g25166 VDD VSS dff
XDFF_1443 CK g2543 g25167 VDD VSS dff
XDFF_1444 CK g2546 g25168 VDD VSS dff
XDFF_1445 CK g2602 g16474 VDD VSS dff
XDFF_1446 CK g2609 g2602 VDD VSS dff
XDFF_1447 CK g2616 g2609 VDD VSS dff
XDFF_1448 CK g2617 g19057 VDD VSS dff
XDFF_1449 CK g2618 g2617 VDD VSS dff
XDFF_1450 CK g2622 g30325 VDD VSS dff
XDFF_1451 CK g2623 g19058 VDD VSS dff
XDFF_1452 CK g2574 g2623 VDD VSS dff
XDFF_1453 CK g2632 g19059 VDD VSS dff
XDFF_1454 CK g2633 g2632 VDD VSS dff
XDFF_1455 CK g2650 g28297 VDD VSS dff
XDFF_1456 CK g2651 g28298 VDD VSS dff
XDFF_1457 CK g2649 g28299 VDD VSS dff
XDFF_1458 CK g2653 g28300 VDD VSS dff
XDFF_1459 CK g2654 g28301 VDD VSS dff
XDFF_1460 CK g2652 g28302 VDD VSS dff
XDFF_1461 CK g2656 g28303 VDD VSS dff
XDFF_1462 CK g2657 g28304 VDD VSS dff
XDFF_1463 CK g2655 g28305 VDD VSS dff
XDFF_1464 CK g2659 g28306 VDD VSS dff
XDFF_1465 CK g2660 g28307 VDD VSS dff
XDFF_1466 CK g2658 g28308 VDD VSS dff
XDFF_1467 CK g2661 g26012 VDD VSS dff
XDFF_1468 CK g2664 g26013 VDD VSS dff
XDFF_1469 CK g2667 g26014 VDD VSS dff
XDFF_1470 CK g2670 g26015 VDD VSS dff
XDFF_1471 CK g2673 g26016 VDD VSS dff
XDFF_1472 CK g2676 g26017 VDD VSS dff
XDFF_1473 CK g2688 g29159 VDD VSS dff
XDFF_1474 CK g2691 g29160 VDD VSS dff
XDFF_1475 CK g2694 g29161 VDD VSS dff
XDFF_1476 CK g2679 g29156 VDD VSS dff
XDFF_1477 CK g2682 g29157 VDD VSS dff
XDFF_1478 CK g2685 g29158 VDD VSS dff
XDFF_1479 CK g2565 g27233 VDD VSS dff
XDFF_1480 CK g2568 g27234 VDD VSS dff
XDFF_1481 CK g2571 g27235 VDD VSS dff
XDFF_1482 CK g2580 g8311 VDD VSS dff
XDFF_1483 CK g2581 g24418 VDD VSS dff
XDFF_1484 CK g2582 g19053 VDD VSS dff
XDFF_1485 CK g2583 g19054 VDD VSS dff
XDFF_1486 CK g2588 g19055 VDD VSS dff
XDFF_1487 CK g2589 g19056 VDD VSS dff
XDFF_1488 CK g2590 g30324 VDD VSS dff
XDFF_1489 CK g2591 g30323 VDD VSS dff
XDFF_1490 CK g2592 g30322 VDD VSS dff
XDFF_1491 CK g2593 g30321 VDD VSS dff
XDFF_1492 CK g16437 g30320 VDD VSS dff
XDFF_1493 CK g2599 g16437 VDD VSS dff
XDFF_1494 CK g2603 g13458 VDD VSS dff
XDFF_1495 CK g2604 g13459 VDD VSS dff
XDFF_1496 CK g2605 g13460 VDD VSS dff
XDFF_1497 CK g2606 g13461 VDD VSS dff
XDFF_1498 CK g2607 g13462 VDD VSS dff
XDFF_1499 CK g2608 g13463 VDD VSS dff
XDFF_1500 CK g2610 g13464 VDD VSS dff
XDFF_1501 CK g2611 g13465 VDD VSS dff
XDFF_1502 CK g2612 g26011 VDD VSS dff
XDFF_1503 CK g2615 g13466 VDD VSS dff
XDFF_1504 CK g7425 g13468 VDD VSS dff
XDFF_1505 CK g7487 g7425 VDD VSS dff
XDFF_1506 CK g2703 g7487 VDD VSS dff
XDFF_1507 CK g2704 g20570 VDD VSS dff
XDFF_1508 CK g2733 g21946 VDD VSS dff
XDFF_1509 CK g2714 g23275 VDD VSS dff
XDFF_1510 CK g2707 g24419 VDD VSS dff
XDFF_1511 CK g2727 g25173 VDD VSS dff
XDFF_1512 CK g2720 g26018 VDD VSS dff
XDFF_1513 CK g2734 g26742 VDD VSS dff
XDFF_1514 CK g2746 g27236 VDD VSS dff
XDFF_1515 CK g2740 g27714 VDD VSS dff
XDFF_1516 CK g2753 g28309 VDD VSS dff
XDFF_1517 CK g2760 g28692 VDD VSS dff
XDFF_1518 CK g2766 g29162 VDD VSS dff
XDFF_1519 CK g2773 g23276 VDD VSS dff
XDFF_1520 CK g2774 g23277 VDD VSS dff
XDFF_1521 CK g2772 g23278 VDD VSS dff
XDFF_1522 CK g2776 g23279 VDD VSS dff
XDFF_1523 CK g2777 g23280 VDD VSS dff
XDFF_1524 CK g2775 g23281 VDD VSS dff
XDFF_1525 CK g2779 g23282 VDD VSS dff
XDFF_1526 CK g2780 g23283 VDD VSS dff
XDFF_1527 CK g2778 g23284 VDD VSS dff
XDFF_1528 CK g2782 g23285 VDD VSS dff
XDFF_1529 CK g2783 g23286 VDD VSS dff
XDFF_1530 CK g2781 g23287 VDD VSS dff
XDFF_1531 CK g2785 g23288 VDD VSS dff
XDFF_1532 CK g2786 g23289 VDD VSS dff
XDFF_1533 CK g2784 g23290 VDD VSS dff
XDFF_1534 CK g2788 g23291 VDD VSS dff
XDFF_1535 CK g2789 g23292 VDD VSS dff
XDFF_1536 CK g2787 g23293 VDD VSS dff
XDFF_1537 CK g2791 g23294 VDD VSS dff
XDFF_1538 CK g2792 g23295 VDD VSS dff
XDFF_1539 CK g2790 g23296 VDD VSS dff
XDFF_1540 CK g2794 g23297 VDD VSS dff
XDFF_1541 CK g2795 g23298 VDD VSS dff
XDFF_1542 CK g2793 g23299 VDD VSS dff
XDFF_1543 CK g2797 g23300 VDD VSS dff
XDFF_1544 CK g2798 g23301 VDD VSS dff
XDFF_1545 CK g2796 g23302 VDD VSS dff
XDFF_1546 CK g2800 g23303 VDD VSS dff
XDFF_1547 CK g2801 g23304 VDD VSS dff
XDFF_1548 CK g2799 g23305 VDD VSS dff
XDFF_1549 CK g2803 g23306 VDD VSS dff
XDFF_1550 CK g2804 g23307 VDD VSS dff
XDFF_1551 CK g2802 g23308 VDD VSS dff
XDFF_1552 CK g2806 g23309 VDD VSS dff
XDFF_1553 CK g2807 g23310 VDD VSS dff
XDFF_1554 CK g2805 g23311 VDD VSS dff
XDFF_1555 CK g2809 g26743 VDD VSS dff
XDFF_1556 CK g2810 g26744 VDD VSS dff
XDFF_1557 CK g2808 g26745 VDD VSS dff
XDFF_1558 CK g2812 g24420 VDD VSS dff
XDFF_1559 CK g2813 g24421 VDD VSS dff
XDFF_1560 CK g2811 g24422 VDD VSS dff
XDFF_1561 CK g3054 g23317 VDD VSS dff
XDFF_1562 CK g3079 g23318 VDD VSS dff
XDFF_1563 CK g3080 g21965 VDD VSS dff
XDFF_1564 CK g3043 g29453 VDD VSS dff
XDFF_1565 CK g3044 g29454 VDD VSS dff
XDFF_1566 CK g3045 g29455 VDD VSS dff
XDFF_1567 CK g3046 g29456 VDD VSS dff
XDFF_1568 CK g3047 g29457 VDD VSS dff
XDFF_1569 CK g3048 g29458 VDD VSS dff
XDFF_1570 CK g3049 g29459 VDD VSS dff
XDFF_1571 CK g3050 g29460 VDD VSS dff
XDFF_1572 CK g3051 g29655 VDD VSS dff
XDFF_1573 CK g3052 g29972 VDD VSS dff
XDFF_1574 CK g3053 g29973 VDD VSS dff
XDFF_1575 CK g3055 g29974 VDD VSS dff
XDFF_1576 CK g3056 g29975 VDD VSS dff
XDFF_1577 CK g3057 g29976 VDD VSS dff
XDFF_1578 CK g3058 g29977 VDD VSS dff
XDFF_1579 CK g3059 g29978 VDD VSS dff
XDFF_1580 CK g3060 g29979 VDD VSS dff
XDFF_1581 CK g3061 g30119 VDD VSS dff
XDFF_1582 CK g3062 g30908 VDD VSS dff
XDFF_1583 CK g3063 g30909 VDD VSS dff
XDFF_1584 CK g3064 g30910 VDD VSS dff
XDFF_1585 CK g3065 g30911 VDD VSS dff
XDFF_1586 CK g3066 g30912 VDD VSS dff
XDFF_1587 CK g3067 g30913 VDD VSS dff
XDFF_1588 CK g3068 g30914 VDD VSS dff
XDFF_1589 CK g3069 g30915 VDD VSS dff
XDFF_1590 CK g3070 g30940 VDD VSS dff
XDFF_1591 CK g3071 g30980 VDD VSS dff
XDFF_1592 CK g3072 g30981 VDD VSS dff
XDFF_1593 CK g3073 g30982 VDD VSS dff
XDFF_1594 CK g3074 g30983 VDD VSS dff
XDFF_1595 CK g3075 g30984 VDD VSS dff
XDFF_1596 CK g3076 g30985 VDD VSS dff
XDFF_1597 CK g3077 g30986 VDD VSS dff
XDFF_1598 CK g3078 g30987 VDD VSS dff
XDFF_1599 CK g2997 g30989 VDD VSS dff
XDFF_1600 CK g2993 g26748 VDD VSS dff
XDFF_1601 CK g2998 g27238 VDD VSS dff
XDFF_1602 CK g3006 g25177 VDD VSS dff
XDFF_1603 CK g3002 g26021 VDD VSS dff
XDFF_1604 CK g3013 g26750 VDD VSS dff
XDFF_1605 CK g3010 g27239 VDD VSS dff
XDFF_1606 CK g3024 g27716 VDD VSS dff
XDFF_1607 CK g3018 g24425 VDD VSS dff
XDFF_1608 CK g3028 g25176 VDD VSS dff
XDFF_1609 CK g3036 g26022 VDD VSS dff
XDFF_1610 CK g3032 g26749 VDD VSS dff
XDFF_1611 CK g5388 g16497 VDD VSS dff
XDFF_1612 CK g2986 g5388 VDD VSS dff
XDFF_1613 CK g2987 g16495 VDD VSS dff
XDFF_1614 CK g48 g20595 VDD VSS dff
XDFF_1615 CK g45 g20596 VDD VSS dff
XDFF_1616 CK g42 g20597 VDD VSS dff
XDFF_1617 CK g39 g20598 VDD VSS dff
XDFF_1618 CK g27 g20599 VDD VSS dff
XDFF_1619 CK g30 g20600 VDD VSS dff
XDFF_1620 CK g33 g20601 VDD VSS dff
XDFF_1621 CK g36 g20602 VDD VSS dff
XDFF_1622 CK g3083 g20603 VDD VSS dff
XDFF_1623 CK g26 g20604 VDD VSS dff
XDFF_1624 CK g2992 g21966 VDD VSS dff
XDFF_1625 CK g23 g20605 VDD VSS dff
XDFF_1626 CK g20 g20606 VDD VSS dff
XDFF_1627 CK g17 g20607 VDD VSS dff
XDFF_1628 CK g11 g20608 VDD VSS dff
XDFF_1629 CK g14 g20589 VDD VSS dff
XDFF_1630 CK g5 g20590 VDD VSS dff
XDFF_1631 CK g8 g20591 VDD VSS dff
XDFF_1632 CK g2 g20592 VDD VSS dff
XDFF_1633 CK g2990 g20593 VDD VSS dff
XDFF_1634 CK g2991 g21964 VDD VSS dff
XDFF_1635 CK g1 g20594 VDD VSS dff
XI_5365 g30970 VDD VSS g30989 INVX1
XI_5364 g30958 VDD VSS g30987 INVX1
XI_5363 g30957 VDD VSS g30986 INVX1
XI_5362 g30961 VDD VSS g30985 INVX1
XI_5361 g30959 VDD VSS g30984 INVX1
XI_5360 g30956 VDD VSS g30983 INVX1
XI_5359 g30954 VDD VSS g30982 INVX1
XI_5358 g30960 VDD VSS g30981 INVX1
XI_5357 g30955 VDD VSS g30980 INVX1
XI_5356 n8084 VDD VSS g30943 INVX1
XI_5354 n8073 VDD VSS g30942 INVX1
XI_5352 n8061 VDD VSS g30941 INVX1
XI_5350 g30685 VDD VSS g30940 INVX1
XI_5349 g30403 VDD VSS g30915 INVX1
XI_5348 g30402 VDD VSS g30914 INVX1
XI_5347 g30406 VDD VSS g30913 INVX1
XI_5346 g30404 VDD VSS g30912 INVX1
XI_5345 g30401 VDD VSS g30911 INVX1
XI_5344 g30399 VDD VSS g30910 INVX1
XI_5343 g30405 VDD VSS g30909 INVX1
XI_5342 g30400 VDD VSS g30908 INVX1
XI_5341 n7975 VDD VSS g30907 INVX1
XI_5339 n7976 VDD VSS g30906 INVX1
XI_5337 n7977 VDD VSS g30905 INVX1
XI_5335 n7996 VDD VSS g30904 INVX1
XI_5333 n7997 VDD VSS g30903 INVX1
XI_5331 n7998 VDD VSS g30902 INVX1
XI_5329 n7990 VDD VSS g30901 INVX1
XI_5327 n7991 VDD VSS g30900 INVX1
XI_5325 n7992 VDD VSS g30899 INVX1
XI_5323 n7984 VDD VSS g30898 INVX1
XI_5321 n7985 VDD VSS g30897 INVX1
XI_5319 n7986 VDD VSS g30896 INVX1
XI_5317 n7993 VDD VSS g30895 INVX1
XI_5315 n7994 VDD VSS g30894 INVX1
XI_5313 n7995 VDD VSS g30893 INVX1
XI_5311 n7987 VDD VSS g30892 INVX1
XI_5309 n7988 VDD VSS g30891 INVX1
XI_5307 n7989 VDD VSS g30890 INVX1
XI_5305 n7714 VDD VSS g30889 INVX1
XI_5303 n7715 VDD VSS g30888 INVX1
XI_5301 n7716 VDD VSS g30887 INVX1
XI_5299 n7736 VDD VSS g30886 INVX1
XI_5297 n7737 VDD VSS g30885 INVX1
XI_5295 n7735 VDD VSS g30884 INVX1
XI_5293 n7729 VDD VSS g30883 INVX1
XI_5291 n7730 VDD VSS g30882 INVX1
XI_5289 n7731 VDD VSS g30881 INVX1
XI_5287 n7723 VDD VSS g30880 INVX1
XI_5285 n7724 VDD VSS g30879 INVX1
XI_5283 n7725 VDD VSS g30878 INVX1
XI_5281 n7732 VDD VSS g30877 INVX1
XI_5279 n7733 VDD VSS g30876 INVX1
XI_5277 n7734 VDD VSS g30875 INVX1
XI_5275 n7726 VDD VSS g30874 INVX1
XI_5273 n7727 VDD VSS g30873 INVX1
XI_5271 n7728 VDD VSS g30872 INVX1
XI_5269 n7801 VDD VSS g30871 INVX1
XI_5267 n7802 VDD VSS g30870 INVX1
XI_5265 n7803 VDD VSS g30869 INVX1
XI_5263 n7824 VDD VSS g30868 INVX1
XI_5261 n7822 VDD VSS g30867 INVX1
XI_5259 n7823 VDD VSS g30866 INVX1
XI_5257 n7816 VDD VSS g30865 INVX1
XI_5255 n7817 VDD VSS g30864 INVX1
XI_5253 n7818 VDD VSS g30863 INVX1
XI_5251 n7810 VDD VSS g30862 INVX1
XI_5249 n7811 VDD VSS g30861 INVX1
XI_5247 n7812 VDD VSS g30860 INVX1
XI_5245 n7819 VDD VSS g30859 INVX1
XI_5243 n7820 VDD VSS g30858 INVX1
XI_5241 n7821 VDD VSS g30857 INVX1
XI_5239 n7814 VDD VSS g30856 INVX1
XI_5237 n7815 VDD VSS g30855 INVX1
XI_5235 n7813 VDD VSS g30854 INVX1
XI_5233 n7888 VDD VSS g30853 INVX1
XI_5231 n7889 VDD VSS g30852 INVX1
XI_5229 n7890 VDD VSS g30851 INVX1
XI_5227 n7909 VDD VSS g30850 INVX1
XI_5225 n7910 VDD VSS g30849 INVX1
XI_5223 n7911 VDD VSS g30848 INVX1
XI_5221 n7903 VDD VSS g30847 INVX1
XI_5219 n7904 VDD VSS g30846 INVX1
XI_5217 n7905 VDD VSS g30845 INVX1
XI_5215 n7897 VDD VSS g30844 INVX1
XI_5213 n7898 VDD VSS g30843 INVX1
XI_5211 n7899 VDD VSS g30842 INVX1
XI_5209 n7906 VDD VSS g30841 INVX1
XI_5207 n7907 VDD VSS g30840 INVX1
XI_5205 n7908 VDD VSS g30839 INVX1
XI_5203 n7902 VDD VSS g30838 INVX1
XI_5201 n7900 VDD VSS g30837 INVX1
XI_5199 n7901 VDD VSS g30836 INVX1
XI_5197 n7978 VDD VSS g30721 INVX1
XI_5195 n7979 VDD VSS g30720 INVX1
XI_5193 n7980 VDD VSS g30719 INVX1
XI_5191 n7717 VDD VSS g30718 INVX1
XI_5189 n7718 VDD VSS g30717 INVX1
XI_5187 n7719 VDD VSS g30716 INVX1
XI_5185 n7804 VDD VSS g30715 INVX1
XI_5183 n7805 VDD VSS g30714 INVX1
XI_5181 n7806 VDD VSS g30713 INVX1
XI_5179 n7891 VDD VSS g30712 INVX1
XI_5177 n7892 VDD VSS g30711 INVX1
XI_5175 n7893 VDD VSS g30710 INVX1
XI_5172 n7973 VDD VSS g30565 INVX1
XI_5170 n7974 VDD VSS g30564 INVX1
XI_5168 n7972 VDD VSS g30563 INVX1
XI_5166 n8007 VDD VSS g30562 INVX1
XI_5164 n8005 VDD VSS g30561 INVX1
XI_5162 n8006 VDD VSS g30560 INVX1
XI_5160 n8008 VDD VSS g30559 INVX1
XI_5158 n8009 VDD VSS g30558 INVX1
XI_5156 n8010 VDD VSS g30557 INVX1
XI_5154 n8002 VDD VSS g30556 INVX1
XI_5152 n8003 VDD VSS g30555 INVX1
XI_5150 n8004 VDD VSS g30554 INVX1
XI_5148 n7999 VDD VSS g30553 INVX1
XI_5146 n8000 VDD VSS g30552 INVX1
XI_5144 n8001 VDD VSS g30551 INVX1
XI_5142 n7713 VDD VSS g30550 INVX1
XI_5140 n7711 VDD VSS g30549 INVX1
XI_5138 n7712 VDD VSS g30548 INVX1
XI_5136 n7744 VDD VSS g30547 INVX1
XI_5134 n7745 VDD VSS g30546 INVX1
XI_5132 n7746 VDD VSS g30545 INVX1
XI_5130 n7747 VDD VSS g30544 INVX1
XI_5128 n7748 VDD VSS g30543 INVX1
XI_5126 n7749 VDD VSS g30542 INVX1
XI_5124 n7741 VDD VSS g30541 INVX1
XI_5122 n7742 VDD VSS g30540 INVX1
XI_5120 n7743 VDD VSS g30539 INVX1
XI_5118 n7739 VDD VSS g30538 INVX1
XI_5116 n7740 VDD VSS g30537 INVX1
XI_5114 n7738 VDD VSS g30536 INVX1
XI_5112 n7798 VDD VSS g30535 INVX1
XI_5110 n7799 VDD VSS g30534 INVX1
XI_5108 n7800 VDD VSS g30533 INVX1
XI_5106 n7831 VDD VSS g30532 INVX1
XI_5104 n7832 VDD VSS g30531 INVX1
XI_5102 n7833 VDD VSS g30530 INVX1
XI_5100 n7834 VDD VSS g30529 INVX1
XI_5098 n7835 VDD VSS g30528 INVX1
XI_5096 n7836 VDD VSS g30527 INVX1
XI_5094 n7828 VDD VSS g30526 INVX1
XI_5092 n7829 VDD VSS g30525 INVX1
XI_5090 n7830 VDD VSS g30524 INVX1
XI_5088 n7827 VDD VSS g30523 INVX1
XI_5086 n7825 VDD VSS g30522 INVX1
XI_5084 n7826 VDD VSS g30521 INVX1
XI_5082 n7885 VDD VSS g30520 INVX1
XI_5080 n7886 VDD VSS g30519 INVX1
XI_5078 n7887 VDD VSS g30518 INVX1
XI_5076 n7918 VDD VSS g30517 INVX1
XI_5074 n7919 VDD VSS g30516 INVX1
XI_5072 n7920 VDD VSS g30515 INVX1
XI_5070 n7921 VDD VSS g30514 INVX1
XI_5068 n7922 VDD VSS g30513 INVX1
XI_5066 n7923 VDD VSS g30512 INVX1
XI_5064 n7916 VDD VSS g30511 INVX1
XI_5062 n7917 VDD VSS g30510 INVX1
XI_5060 n7915 VDD VSS g30509 INVX1
XI_5058 n7912 VDD VSS g30508 INVX1
XI_5056 n7913 VDD VSS g30507 INVX1
XI_5054 n7914 VDD VSS g30506 INVX1
XI_5052 n8174 VDD VSS g30325 INVX1
XI_5050 n8223 VDD VSS g30324 INVX1
XI_5048 n8219 VDD VSS g30323 INVX1
XI_5046 n8215 VDD VSS g30322 INVX1
XI_5044 n8211 VDD VSS g30321 INVX1
XI_5042 n8207 VDD VSS g30320 INVX1
XI_5040 n8166 VDD VSS g30319 INVX1
XI_5038 n8165 VDD VSS g30318 INVX1
XI_5036 n8164 VDD VSS g30317 INVX1
XI_5034 n8172 VDD VSS g30316 INVX1
XI_5032 n8171 VDD VSS g30315 INVX1
XI_5030 n8170 VDD VSS g30314 INVX1
XI_5004 n8086 VDD VSS g30122 INVX1
XI_5002 n8075 VDD VSS g30121 INVX1
XI_5000 n8063 VDD VSS g30120 INVX1
XI_4998 g29761 VDD VSS g30119 INVX1
XI_4993 g29574 VDD VSS g29979 INVX1
XI_4992 g29571 VDD VSS g29978 INVX1
XI_4991 g29578 VDD VSS g29977 INVX1
XI_4990 g29576 VDD VSS g29976 INVX1
XI_4989 g29570 VDD VSS g29975 INVX1
XI_4988 g29552 VDD VSS g29974 INVX1
XI_4987 g29577 VDD VSS g29973 INVX1
XI_4986 g29569 VDD VSS g29972 INVX1
XI_4965 n8011 VDD VSS g29809 INVX1
XI_4963 n8012 VDD VSS g29808 INVX1
XI_4961 n8013 VDD VSS g29807 INVX1
XI_4959 n7592 VDD VSS g29806 INVX1
XI_4957 n7750 VDD VSS g29805 INVX1
XI_4955 n7751 VDD VSS g29804 INVX1
XI_4953 n7752 VDD VSS g29803 INVX1
XI_4951 n7602 VDD VSS g29802 INVX1
XI_4949 n7837 VDD VSS g29801 INVX1
XI_4947 n7838 VDD VSS g29800 INVX1
XI_4945 n7839 VDD VSS g29799 INVX1
XI_4943 n7612 VDD VSS g29798 INVX1
XI_4941 n7924 VDD VSS g29797 INVX1
XI_4939 n7925 VDD VSS g29796 INVX1
XI_4937 n7926 VDD VSS g29795 INVX1
XI_4935 n7622 VDD VSS g29794 INVX1
XI_4928 g26974 VDD VSS g29657 INVX1
XI_4927 g26974 VDD VSS g29656 INVX1
XI_4926 g28954 VDD VSS g29655 INVX1
XI_4925 n8026 VDD VSS g29654 INVX1
XI_4923 n8027 VDD VSS g29653 INVX1
XI_4921 n8028 VDD VSS g29652 INVX1
XI_4919 n7981 VDD VSS g29651 INVX1
XI_4917 n7983 VDD VSS g29650 INVX1
XI_4915 n7982 VDD VSS g29649 INVX1
XI_4913 n7591 VDD VSS g29648 INVX1
XI_4911 n7765 VDD VSS g29647 INVX1
XI_4909 n7766 VDD VSS g29646 INVX1
XI_4907 n7767 VDD VSS g29645 INVX1
XI_4905 n7720 VDD VSS g29644 INVX1
XI_4903 n7722 VDD VSS g29643 INVX1
XI_4901 n7721 VDD VSS g29642 INVX1
XI_4899 n7601 VDD VSS g29641 INVX1
XI_4897 n7852 VDD VSS g29640 INVX1
XI_4895 n7853 VDD VSS g29639 INVX1
XI_4893 n7854 VDD VSS g29638 INVX1
XI_4891 n7807 VDD VSS g29637 INVX1
XI_4889 n7809 VDD VSS g29636 INVX1
XI_4887 n7808 VDD VSS g29635 INVX1
XI_4885 n7611 VDD VSS g29634 INVX1
XI_4883 n7939 VDD VSS g29633 INVX1
XI_4881 n7940 VDD VSS g29632 INVX1
XI_4879 n7941 VDD VSS g29631 INVX1
XI_4877 n7894 VDD VSS g29630 INVX1
XI_4875 n7896 VDD VSS g29629 INVX1
XI_4873 n7895 VDD VSS g29628 INVX1
XI_4871 n7621 VDD VSS g29627 INVX1
XI_4869 n28 VDD VSS g29463 INVX1
XI_4868 n28 VDD VSS g29462 INVX1
XI_4867 n28 VDD VSS g29461 INVX1
XI_4865 g28495 VDD VSS g29460 INVX1
XI_4864 g28490 VDD VSS g29459 INVX1
XI_4863 g28528 VDD VSS g29458 INVX1
XI_4862 g28499 VDD VSS g29457 INVX1
XI_4861 g28489 VDD VSS g29456 INVX1
XI_4860 g28470 VDD VSS g29455 INVX1
XI_4859 g28525 VDD VSS g29454 INVX1
XI_4858 g28488 VDD VSS g29453 INVX1
XI_4857 n8023 VDD VSS g29452 INVX1
XI_4855 n8024 VDD VSS g29451 INVX1
XI_4853 n8025 VDD VSS g29450 INVX1
XI_4851 n8020 VDD VSS g29449 INVX1
XI_4849 n8021 VDD VSS g29448 INVX1
XI_4847 n8022 VDD VSS g29447 INVX1
XI_4845 n7590 VDD VSS g29446 INVX1
XI_4843 n8175 VDD VSS g29445 INVX1
XI_4841 n8222 VDD VSS g29444 INVX1
XI_4839 n8218 VDD VSS g29443 INVX1
XI_4837 n8214 VDD VSS g29442 INVX1
XI_4835 n8210 VDD VSS g29441 INVX1
XI_4833 n8206 VDD VSS g29440 INVX1
XI_4831 n7762 VDD VSS g29439 INVX1
XI_4829 n7763 VDD VSS g29438 INVX1
XI_4827 n7764 VDD VSS g29437 INVX1
XI_4825 n7759 VDD VSS g29436 INVX1
XI_4823 n7760 VDD VSS g29435 INVX1
XI_4821 n7761 VDD VSS g29434 INVX1
XI_4819 n132 VDD VSS g29433 INVX1
XI_4817 n135 VDD VSS g29432 INVX1
XI_4815 n140 VDD VSS g29431 INVX1
XI_4813 n126 VDD VSS g29430 INVX1
XI_4811 n128 VDD VSS g29429 INVX1
XI_4809 n8169 VDD VSS g29428 INVX1
XI_4807 n7600 VDD VSS g29427 INVX1
XI_4805 n7849 VDD VSS g29426 INVX1
XI_4803 n7850 VDD VSS g29425 INVX1
XI_4801 n7851 VDD VSS g29424 INVX1
XI_4799 n7846 VDD VSS g29423 INVX1
XI_4797 n7847 VDD VSS g29422 INVX1
XI_4795 n7848 VDD VSS g29421 INVX1
XI_4793 n7610 VDD VSS g29420 INVX1
XI_4791 n7936 VDD VSS g29419 INVX1
XI_4789 n7937 VDD VSS g29418 INVX1
XI_4787 n7938 VDD VSS g29417 INVX1
XI_4785 n7933 VDD VSS g29416 INVX1
XI_4783 n7934 VDD VSS g29415 INVX1
XI_4781 n7935 VDD VSS g29414 INVX1
XI_4779 n7620 VDD VSS g29413 INVX1
XI_4769 g25520 VDD VSS g29166 INVX1
XI_4768 n8088 VDD VSS g29165 INVX1
XI_4766 n8077 VDD VSS g29164 INVX1
XI_4764 n8065 VDD VSS g29163 INVX1
XI_4762 n8564 VDD VSS g29162 INVX1
XI_4760 n8095 VDD VSS g29161 INVX1
XI_4758 n8096 VDD VSS g29160 INVX1
XI_4756 n8097 VDD VSS g29159 INVX1
XI_4754 n8098 VDD VSS g29158 INVX1
XI_4752 n8099 VDD VSS g29157 INVX1
XI_4750 n8100 VDD VSS g29156 INVX1
XI_4748 n7589 VDD VSS g29155 INVX1
XI_4746 n8464 VDD VSS g29154 INVX1
XI_4744 n8104 VDD VSS g29153 INVX1
XI_4742 n8105 VDD VSS g29152 INVX1
XI_4740 n8106 VDD VSS g29151 INVX1
XI_4738 n8107 VDD VSS g29150 INVX1
XI_4736 n8108 VDD VSS g29149 INVX1
XI_4734 n8109 VDD VSS g29148 INVX1
XI_4732 n7599 VDD VSS g29147 INVX1
XI_4730 n8364 VDD VSS g29146 INVX1
XI_4728 n8113 VDD VSS g29145 INVX1
XI_4726 n8114 VDD VSS g29144 INVX1
XI_4724 n8115 VDD VSS g29143 INVX1
XI_4722 n8116 VDD VSS g29142 INVX1
XI_4720 n8117 VDD VSS g29141 INVX1
XI_4718 n8118 VDD VSS g29140 INVX1
XI_4716 n7609 VDD VSS g29139 INVX1
XI_4714 n8264 VDD VSS g29138 INVX1
XI_4712 n8125 VDD VSS g29137 INVX1
XI_4710 n8126 VDD VSS g29136 INVX1
XI_4708 n8127 VDD VSS g29135 INVX1
XI_4706 n8128 VDD VSS g29134 INVX1
XI_4704 n8129 VDD VSS g29133 INVX1
XI_4702 n8130 VDD VSS g29132 INVX1
XI_4700 n7619 VDD VSS g29131 INVX1
XI_4694 n27 VDD VSS g28706 INVX1
XI_4693 n74 VDD VSS g28705 INVX1
XI_4692 n75 VDD VSS g28704 INVX1
XI_4691 n27 VDD VSS g28703 INVX1
XI_4690 n74 VDD VSS g28702 INVX1
XI_4689 n27 VDD VSS g28701 INVX1
XI_4687 n74 VDD VSS g28700 INVX1
XI_4685 n75 VDD VSS g28699 INVX1
XI_4683 n27 VDD VSS g28698 INVX1
XI_4682 n75 VDD VSS g28697 INVX1
XI_4681 g24909 VDD VSS g28696 INVX1
XI_4680 n27 VDD VSS g28695 INVX1
XI_4679 n74 VDD VSS g28694 INVX1
XI_4678 n75 VDD VSS g28693 INVX1
XI_4677 n8565 VDD VSS g28692 INVX1
XI_4675 n8031 VDD VSS g28691 INVX1
XI_4673 n8030 VDD VSS g28690 INVX1
XI_4671 n8029 VDD VSS g28689 INVX1
XI_4669 n7588 VDD VSS g28688 INVX1
XI_4667 n8465 VDD VSS g28687 INVX1
XI_4665 n7770 VDD VSS g28686 INVX1
XI_4663 n7769 VDD VSS g28685 INVX1
XI_4661 n7768 VDD VSS g28684 INVX1
XI_4659 n7598 VDD VSS g28683 INVX1
XI_4657 n8365 VDD VSS g28682 INVX1
XI_4655 n7857 VDD VSS g28681 INVX1
XI_4653 n7856 VDD VSS g28680 INVX1
XI_4651 n7855 VDD VSS g28679 INVX1
XI_4649 n7608 VDD VSS g28678 INVX1
XI_4647 n8265 VDD VSS g28677 INVX1
XI_4645 n7944 VDD VSS g28676 INVX1
XI_4643 n7943 VDD VSS g28675 INVX1
XI_4641 n7942 VDD VSS g28674 INVX1
XI_4639 n7618 VDD VSS g28673 INVX1
XI_4601 n77 VDD VSS g28318 INVX1
XI_4600 n80 VDD VSS g28317 INVX1
XI_4599 n78 VDD VSS g28316 INVX1
XI_4598 n77 VDD VSS g28315 INVX1
XI_4597 n78 VDD VSS g28314 INVX1
XI_4596 g23919 VDD VSS g28313 INVX1
XI_4595 n77 VDD VSS g28312 INVX1
XI_4593 n80 VDD VSS g28311 INVX1
XI_4591 n78 VDD VSS g28310 INVX1
XI_4589 n8566 VDD VSS g28309 INVX1
XI_4587 n8512 VDD VSS g28308 INVX1
XI_4585 n8508 VDD VSS g28307 INVX1
XI_4583 n8498 VDD VSS g28306 INVX1
XI_4581 n8513 VDD VSS g28305 INVX1
XI_4579 n8509 VDD VSS g28304 INVX1
XI_4577 n8499 VDD VSS g28303 INVX1
XI_4575 n8514 VDD VSS g28302 INVX1
XI_4573 n8510 VDD VSS g28301 INVX1
XI_4571 n8500 VDD VSS g28300 INVX1
XI_4569 n8515 VDD VSS g28299 INVX1
XI_4567 n8511 VDD VSS g28298 INVX1
XI_4565 n8501 VDD VSS g28297 INVX1
XI_4563 n7632 VDD VSS g28296 INVX1
XI_4561 n7625 VDD VSS g28295 INVX1
XI_4559 n7624 VDD VSS g28294 INVX1
XI_4557 n7633 VDD VSS g28293 INVX1
XI_4555 n7627 VDD VSS g28292 INVX1
XI_4553 n7626 VDD VSS g28291 INVX1
XI_4551 n7634 VDD VSS g28290 INVX1
XI_4549 n7629 VDD VSS g28289 INVX1
XI_4547 n7628 VDD VSS g28288 INVX1
XI_4545 n7635 VDD VSS g28287 INVX1
XI_4543 n7631 VDD VSS g28286 INVX1
XI_4541 n7630 VDD VSS g28285 INVX1
XI_4539 n7587 VDD VSS g28284 INVX1
XI_4537 n8466 VDD VSS g28283 INVX1
XI_4535 n8412 VDD VSS g28282 INVX1
XI_4533 n8408 VDD VSS g28281 INVX1
XI_4531 n8398 VDD VSS g28280 INVX1
XI_4529 n8413 VDD VSS g28279 INVX1
XI_4527 n8409 VDD VSS g28278 INVX1
XI_4525 n8399 VDD VSS g28277 INVX1
XI_4523 n8414 VDD VSS g28276 INVX1
XI_4521 n8410 VDD VSS g28275 INVX1
XI_4519 n8400 VDD VSS g28274 INVX1
XI_4517 n8415 VDD VSS g28273 INVX1
XI_4515 n8411 VDD VSS g28272 INVX1
XI_4513 n8401 VDD VSS g28271 INVX1
XI_4511 n7645 VDD VSS g28270 INVX1
XI_4509 n7638 VDD VSS g28269 INVX1
XI_4507 n7637 VDD VSS g28268 INVX1
XI_4505 n7646 VDD VSS g28267 INVX1
XI_4503 n7640 VDD VSS g28266 INVX1
XI_4501 n7639 VDD VSS g28265 INVX1
XI_4499 n7647 VDD VSS g28264 INVX1
XI_4497 n7642 VDD VSS g28263 INVX1
XI_4495 n7641 VDD VSS g28262 INVX1
XI_4493 n7648 VDD VSS g28261 INVX1
XI_4491 n7644 VDD VSS g28260 INVX1
XI_4489 n7643 VDD VSS g28259 INVX1
XI_4487 n7597 VDD VSS g28258 INVX1
XI_4485 n8366 VDD VSS g28257 INVX1
XI_4483 n8312 VDD VSS g28256 INVX1
XI_4481 n8308 VDD VSS g28255 INVX1
XI_4479 n8298 VDD VSS g28254 INVX1
XI_4477 n8313 VDD VSS g28253 INVX1
XI_4475 n8309 VDD VSS g28252 INVX1
XI_4473 n8299 VDD VSS g28251 INVX1
XI_4471 n8314 VDD VSS g28250 INVX1
XI_4469 n8310 VDD VSS g28249 INVX1
XI_4467 n8300 VDD VSS g28248 INVX1
XI_4465 n8315 VDD VSS g28247 INVX1
XI_4463 n8311 VDD VSS g28246 INVX1
XI_4461 n8301 VDD VSS g28245 INVX1
XI_4459 n7658 VDD VSS g28244 INVX1
XI_4457 n7651 VDD VSS g28243 INVX1
XI_4455 n7650 VDD VSS g28242 INVX1
XI_4453 n7659 VDD VSS g28241 INVX1
XI_4451 n7653 VDD VSS g28240 INVX1
XI_4449 n7652 VDD VSS g28239 INVX1
XI_4447 n7660 VDD VSS g28238 INVX1
XI_4445 n7655 VDD VSS g28237 INVX1
XI_4443 n7654 VDD VSS g28236 INVX1
XI_4441 n7661 VDD VSS g28235 INVX1
XI_4439 n7657 VDD VSS g28234 INVX1
XI_4437 n7656 VDD VSS g28233 INVX1
XI_4435 n7607 VDD VSS g28232 INVX1
XI_4433 n8266 VDD VSS g28231 INVX1
XI_4431 n8192 VDD VSS g28230 INVX1
XI_4429 n8188 VDD VSS g28229 INVX1
XI_4427 n8178 VDD VSS g28228 INVX1
XI_4425 n8193 VDD VSS g28227 INVX1
XI_4423 n8189 VDD VSS g28226 INVX1
XI_4421 n8179 VDD VSS g28225 INVX1
XI_4419 n8194 VDD VSS g28224 INVX1
XI_4417 n8190 VDD VSS g28223 INVX1
XI_4415 n8180 VDD VSS g28222 INVX1
XI_4413 n8195 VDD VSS g28221 INVX1
XI_4411 n8191 VDD VSS g28220 INVX1
XI_4409 n8181 VDD VSS g28219 INVX1
XI_4407 n7671 VDD VSS g28218 INVX1
XI_4405 n7664 VDD VSS g28217 INVX1
XI_4403 n7663 VDD VSS g28216 INVX1
XI_4401 n7672 VDD VSS g28215 INVX1
XI_4399 n7666 VDD VSS g28214 INVX1
XI_4397 n7665 VDD VSS g28213 INVX1
XI_4395 n7673 VDD VSS g28212 INVX1
XI_4393 n7668 VDD VSS g28211 INVX1
XI_4391 n7667 VDD VSS g28210 INVX1
XI_4389 n7674 VDD VSS g28209 INVX1
XI_4387 n7670 VDD VSS g28208 INVX1
XI_4385 n7669 VDD VSS g28207 INVX1
XI_4383 n7617 VDD VSS g28206 INVX1
XI_4348 n76 VDD VSS g27717 INVX1
XI_4346 n8582 VDD VSS g27716 INVX1
XI_4344 n7526 VDD VSS g27715 INVX1
XI_4342 n8567 VDD VSS g27714 INVX1
XI_4340 n8032 VDD VSS g27713 INVX1
XI_4338 n8033 VDD VSS g27712 INVX1
XI_4336 n8034 VDD VSS g27711 INVX1
XI_4334 n8035 VDD VSS g27710 INVX1
XI_4332 n8036 VDD VSS g27709 INVX1
XI_4330 n8037 VDD VSS g27708 INVX1
XI_4328 n7586 VDD VSS g27707 INVX1
XI_4326 n8467 VDD VSS g27706 INVX1
XI_4324 n7771 VDD VSS g27705 INVX1
XI_4322 n7772 VDD VSS g27704 INVX1
XI_4320 n7773 VDD VSS g27703 INVX1
XI_4318 n7774 VDD VSS g27702 INVX1
XI_4316 n7775 VDD VSS g27701 INVX1
XI_4314 n7776 VDD VSS g27700 INVX1
XI_4312 n7596 VDD VSS g27699 INVX1
XI_4310 n8367 VDD VSS g27698 INVX1
XI_4308 n7858 VDD VSS g27697 INVX1
XI_4306 n7859 VDD VSS g27696 INVX1
XI_4304 n7860 VDD VSS g27695 INVX1
XI_4302 n7861 VDD VSS g27694 INVX1
XI_4300 n7862 VDD VSS g27693 INVX1
XI_4298 n7863 VDD VSS g27692 INVX1
XI_4296 n7606 VDD VSS g27691 INVX1
XI_4294 n8267 VDD VSS g27690 INVX1
XI_4292 n7945 VDD VSS g27689 INVX1
XI_4290 n7946 VDD VSS g27688 INVX1
XI_4288 n7947 VDD VSS g27687 INVX1
XI_4286 n7948 VDD VSS g27686 INVX1
XI_4284 n7949 VDD VSS g27685 INVX1
XI_4282 n7950 VDD VSS g27684 INVX1
XI_4280 n7616 VDD VSS g27683 INVX1
XI_4262 n8581 VDD VSS g27239 INVX1
XI_4260 n8577 VDD VSS g27238 INVX1
XI_4258 n7527 VDD VSS g27237 INVX1
XI_4256 n8568 VDD VSS g27236 INVX1
XI_4254 n8505 VDD VSS g27235 INVX1
XI_4252 n8506 VDD VSS g27234 INVX1
XI_4250 n8497 VDD VSS g27233 INVX1
XI_4248 n8014 VDD VSS g27232 INVX1
XI_4246 n8015 VDD VSS g27231 INVX1
XI_4244 n8016 VDD VSS g27230 INVX1
XI_4242 N1768 VDD VSS g27229 INVX1
XI_4240 n7585 VDD VSS g27228 INVX1
XI_4238 n8468 VDD VSS g27227 INVX1
XI_4236 n8405 VDD VSS g27226 INVX1
XI_4234 n8406 VDD VSS g27225 INVX1
XI_4232 n8397 VDD VSS g27224 INVX1
XI_4230 n7753 VDD VSS g27223 INVX1
XI_4228 n7754 VDD VSS g27222 INVX1
XI_4226 n7755 VDD VSS g27221 INVX1
XI_4224 N1766 VDD VSS g27220 INVX1
XI_4222 n7595 VDD VSS g27219 INVX1
XI_4220 n8368 VDD VSS g27218 INVX1
XI_4218 n8176 VDD VSS g27217 INVX1
XI_4216 n8221 VDD VSS g27216 INVX1
XI_4214 n8217 VDD VSS g27215 INVX1
XI_4212 n8213 VDD VSS g27214 INVX1
XI_4210 n8209 VDD VSS g27213 INVX1
XI_4208 n8205 VDD VSS g27212 INVX1
XI_4206 n8305 VDD VSS g27211 INVX1
XI_4204 n8306 VDD VSS g27210 INVX1
XI_4202 n8297 VDD VSS g27209 INVX1
XI_4200 n7840 VDD VSS g27208 INVX1
XI_4198 n7841 VDD VSS g27207 INVX1
XI_4196 n7842 VDD VSS g27206 INVX1
XI_4194 n133 VDD VSS g27205 INVX1
XI_4192 n136 VDD VSS g27204 INVX1
XI_4190 n139 VDD VSS g27203 INVX1
XI_4188 n125 VDD VSS g27202 INVX1
XI_4186 n129 VDD VSS g27201 INVX1
XI_4184 n8168 VDD VSS g27200 INVX1
XI_4182 N1764 VDD VSS g27199 INVX1
XI_4180 n7605 VDD VSS g27198 INVX1
XI_4178 n8268 VDD VSS g27197 INVX1
XI_4176 n8185 VDD VSS g27196 INVX1
XI_4174 n8186 VDD VSS g27195 INVX1
XI_4172 n8177 VDD VSS g27194 INVX1
XI_4170 n7927 VDD VSS g27193 INVX1
XI_4168 n7928 VDD VSS g27192 INVX1
XI_4166 n7929 VDD VSS g27191 INVX1
XI_4164 N1762 VDD VSS g27190 INVX1
XI_4162 n7615 VDD VSS g27189 INVX1
XI_4132 n8090 VDD VSS g26753 INVX1
XI_4130 n8079 VDD VSS g26752 INVX1
XI_4128 n8067 VDD VSS g26751 INVX1
XI_4126 n8580 VDD VSS g26750 INVX1
XI_4124 n8585 VDD VSS g26749 INVX1
XI_4122 n8576 VDD VSS g26748 INVX1
XI_4120 n7528 VDD VSS g26747 INVX1
XI_4118 n7523 VDD VSS g26746 INVX1
XI_4116 n8552 VDD VSS g26745 INVX1
XI_4114 n8534 VDD VSS g26744 INVX1
XI_4112 n8531 VDD VSS g26743 INVX1
XI_4110 n8569 VDD VSS g26742 INVX1
XI_4108 n7542 VDD VSS g26741 INVX1
XI_4106 n7535 VDD VSS g26740 INVX1
XI_4104 n7534 VDD VSS g26739 INVX1
XI_4102 n7543 VDD VSS g26738 INVX1
XI_4100 n7537 VDD VSS g26737 INVX1
XI_4098 n7536 VDD VSS g26736 INVX1
XI_4096 n7544 VDD VSS g26735 INVX1
XI_4094 n7539 VDD VSS g26734 INVX1
XI_4092 n7538 VDD VSS g26733 INVX1
XI_4090 n7545 VDD VSS g26732 INVX1
XI_4088 n7541 VDD VSS g26731 INVX1
XI_4086 n7540 VDD VSS g26730 INVX1
XI_4084 n7584 VDD VSS g26729 INVX1
XI_4082 n8452 VDD VSS g26728 INVX1
XI_4080 n8434 VDD VSS g26727 INVX1
XI_4078 n8431 VDD VSS g26726 INVX1
XI_4076 n8469 VDD VSS g26725 INVX1
XI_4074 n7554 VDD VSS g26724 INVX1
XI_4072 n7547 VDD VSS g26723 INVX1
XI_4070 n7546 VDD VSS g26722 INVX1
XI_4068 n7555 VDD VSS g26721 INVX1
XI_4066 n7549 VDD VSS g26720 INVX1
XI_4064 n7548 VDD VSS g26719 INVX1
XI_4062 n7556 VDD VSS g26718 INVX1
XI_4060 n7551 VDD VSS g26717 INVX1
XI_4058 n7550 VDD VSS g26716 INVX1
XI_4056 n7557 VDD VSS g26715 INVX1
XI_4054 n7553 VDD VSS g26714 INVX1
XI_4052 n7552 VDD VSS g26713 INVX1
XI_4050 n7594 VDD VSS g26712 INVX1
XI_4048 n8352 VDD VSS g26711 INVX1
XI_4046 n8334 VDD VSS g26710 INVX1
XI_4044 n8331 VDD VSS g26709 INVX1
XI_4042 n8369 VDD VSS g26708 INVX1
XI_4040 n7566 VDD VSS g26707 INVX1
XI_4038 n7559 VDD VSS g26706 INVX1
XI_4036 n7558 VDD VSS g26705 INVX1
XI_4034 n7567 VDD VSS g26704 INVX1
XI_4032 n7561 VDD VSS g26703 INVX1
XI_4030 n7560 VDD VSS g26702 INVX1
XI_4028 n7568 VDD VSS g26701 INVX1
XI_4026 n7563 VDD VSS g26700 INVX1
XI_4024 n7562 VDD VSS g26699 INVX1
XI_4022 n7569 VDD VSS g26698 INVX1
XI_4020 n7565 VDD VSS g26697 INVX1
XI_4018 n7564 VDD VSS g26696 INVX1
XI_4016 n7604 VDD VSS g26695 INVX1
XI_4014 n8252 VDD VSS g26694 INVX1
XI_4012 n8234 VDD VSS g26693 INVX1
XI_4010 n8231 VDD VSS g26692 INVX1
XI_4008 n8269 VDD VSS g26691 INVX1
XI_4006 n7578 VDD VSS g26690 INVX1
XI_4004 n7571 VDD VSS g26689 INVX1
XI_4002 n7570 VDD VSS g26688 INVX1
XI_4000 n7579 VDD VSS g26687 INVX1
XI_3998 n7573 VDD VSS g26686 INVX1
XI_3996 n7572 VDD VSS g26685 INVX1
XI_3994 n7580 VDD VSS g26684 INVX1
XI_3992 n7575 VDD VSS g26683 INVX1
XI_3990 n7574 VDD VSS g26682 INVX1
XI_3988 n7581 VDD VSS g26681 INVX1
XI_3986 n7577 VDD VSS g26680 INVX1
XI_3984 n7576 VDD VSS g26679 INVX1
XI_3982 n7614 VDD VSS g26678 INVX1
XI_3868 n8584 VDD VSS g26022 INVX1
XI_3866 n8579 VDD VSS g26021 INVX1
XI_3864 n7524 VDD VSS g26020 INVX1
XI_3862 n7529 VDD VSS g26019 INVX1
XI_3860 n8570 VDD VSS g26018 INVX1
XI_3858 n8122 VDD VSS g26017 INVX1
XI_3856 n8123 VDD VSS g26016 INVX1
XI_3854 n8124 VDD VSS g26015 INVX1
XI_3852 n8101 VDD VSS g26014 INVX1
XI_3850 n8102 VDD VSS g26013 INVX1
XI_3848 n8103 VDD VSS g26012 INVX1
XI_3846 n8496 VDD VSS g26011 INVX1
XI_3844 n7583 VDD VSS g26010 INVX1
XI_3842 n8470 VDD VSS g26009 INVX1
XI_3840 n8134 VDD VSS g26008 INVX1
XI_3838 n8135 VDD VSS g26007 INVX1
XI_3836 n8136 VDD VSS g26006 INVX1
XI_3834 n8110 VDD VSS g26005 INVX1
XI_3832 n8111 VDD VSS g26004 INVX1
XI_3830 n8112 VDD VSS g26003 INVX1
XI_3828 n8396 VDD VSS g26002 INVX1
XI_3826 n7593 VDD VSS g26001 INVX1
XI_3824 n8370 VDD VSS g26000 INVX1
XI_3822 n8137 VDD VSS g25999 INVX1
XI_3820 n8138 VDD VSS g25998 INVX1
XI_3818 n8139 VDD VSS g25997 INVX1
XI_3816 n8119 VDD VSS g25996 INVX1
XI_3814 n8120 VDD VSS g25995 INVX1
XI_3812 n8121 VDD VSS g25994 INVX1
XI_3810 n8296 VDD VSS g25993 INVX1
XI_3808 n7603 VDD VSS g25992 INVX1
XI_3806 n8270 VDD VSS g25991 INVX1
XI_3804 n8140 VDD VSS g25990 INVX1
XI_3802 n8141 VDD VSS g25989 INVX1
XI_3800 n8142 VDD VSS g25988 INVX1
XI_3798 n8131 VDD VSS g25987 INVX1
XI_3796 n8132 VDD VSS g25986 INVX1
XI_3794 n8133 VDD VSS g25985 INVX1
XI_3792 n8173 VDD VSS g25984 INVX1
XI_3790 n7613 VDD VSS g25983 INVX1
XI_3727 n8578 VDD VSS g25177 INVX1
XI_3725 n8583 VDD VSS g25176 INVX1
XI_3723 n7530 VDD VSS g25175 INVX1
XI_3721 n7525 VDD VSS g25174 INVX1
XI_3719 n8571 VDD VSS g25173 INVX1
XI_3717 n8491 VDD VSS g25172 INVX1
XI_3715 n8487 VDD VSS g25171 INVX1
XI_3713 n8488 VDD VSS g25170 INVX1
XI_3711 n8489 VDD VSS g25169 INVX1
XI_3709 n8493 VDD VSS g25168 INVX1
XI_3707 n8494 VDD VSS g25167 INVX1
XI_3705 n8495 VDD VSS g25166 INVX1
XI_3703 n8492 VDD VSS g25165 INVX1
XI_3701 n8490 VDD VSS g25164 INVX1
XI_3699 n7623 VDD VSS g25163 INVX1
XI_3697 n8471 VDD VSS g25162 INVX1
XI_3695 n8391 VDD VSS g25161 INVX1
XI_3693 n8387 VDD VSS g25160 INVX1
XI_3691 n8388 VDD VSS g25159 INVX1
XI_3689 n8389 VDD VSS g25158 INVX1
XI_3687 n8393 VDD VSS g25157 INVX1
XI_3685 n8394 VDD VSS g25156 INVX1
XI_3683 n8395 VDD VSS g25155 INVX1
XI_3681 n8392 VDD VSS g25154 INVX1
XI_3679 n8390 VDD VSS g25153 INVX1
XI_3677 n7636 VDD VSS g25152 INVX1
XI_3675 n8371 VDD VSS g25151 INVX1
XI_3673 n8291 VDD VSS g25150 INVX1
XI_3671 n8287 VDD VSS g25149 INVX1
XI_3669 n8288 VDD VSS g25148 INVX1
XI_3667 n8289 VDD VSS g25147 INVX1
XI_3665 n8293 VDD VSS g25146 INVX1
XI_3663 n8294 VDD VSS g25145 INVX1
XI_3661 n8295 VDD VSS g25144 INVX1
XI_3659 n8292 VDD VSS g25143 INVX1
XI_3657 n8290 VDD VSS g25142 INVX1
XI_3655 n7649 VDD VSS g25141 INVX1
XI_3653 n8271 VDD VSS g25140 INVX1
XI_3651 n8159 VDD VSS g25139 INVX1
XI_3649 n8155 VDD VSS g25138 INVX1
XI_3647 n8156 VDD VSS g25137 INVX1
XI_3645 n8157 VDD VSS g25136 INVX1
XI_3643 n8161 VDD VSS g25135 INVX1
XI_3641 n8162 VDD VSS g25134 INVX1
XI_3639 n8163 VDD VSS g25133 INVX1
XI_3637 n8160 VDD VSS g25132 INVX1
XI_3635 n8158 VDD VSS g25131 INVX1
XI_3633 n7662 VDD VSS g25130 INVX1
XI_3608 N1285 VDD VSS g24425 INVX1
XI_3606 N1282 VDD VSS g24424 INVX1
XI_3604 n7531 VDD VSS g24423 INVX1
XI_3602 n8563 VDD VSS g24422 INVX1
XI_3600 n8562 VDD VSS g24421 INVX1
XI_3598 n8561 VDD VSS g24420 INVX1
XI_3596 n8572 VDD VSS g24419 INVX1
XI_3594 n8507 VDD VSS g24418 INVX1
XI_3592 n8481 VDD VSS g24417 INVX1
XI_3590 n8482 VDD VSS g24416 INVX1
XI_3588 n8483 VDD VSS g24415 INVX1
XI_3586 n8485 VDD VSS g24414 INVX1
XI_3584 n8486 VDD VSS g24413 INVX1
XI_3582 n8484 VDD VSS g24412 INVX1
XI_3580 n8479 VDD VSS g24411 INVX1
XI_3578 n8480 VDD VSS g24410 INVX1
XI_3576 n8475 VDD VSS g24409 INVX1
XI_3574 n8477 VDD VSS g24408 INVX1
XI_3572 n8478 VDD VSS g24407 INVX1
XI_3570 n8476 VDD VSS g24406 INVX1
XI_3568 n8017 VDD VSS g24405 INVX1
XI_3566 n8018 VDD VSS g24404 INVX1
XI_3564 n8019 VDD VSS g24403 INVX1
XI_3562 n8038 VDD VSS g24402 INVX1
XI_3560 n8039 VDD VSS g24401 INVX1
XI_3558 n8040 VDD VSS g24400 INVX1
XI_3556 n8041 VDD VSS g24399 INVX1
XI_3554 n8042 VDD VSS g24398 INVX1
XI_3552 n8043 VDD VSS g24397 INVX1
XI_3550 n8044 VDD VSS g24396 INVX1
XI_3548 n8045 VDD VSS g24395 INVX1
XI_3546 n8046 VDD VSS g24394 INVX1
XI_3544 n8047 VDD VSS g24393 INVX1
XI_3542 n8048 VDD VSS g24392 INVX1
XI_3540 n8049 VDD VSS g24391 INVX1
XI_3538 n8050 VDD VSS g24390 INVX1
XI_3536 n8051 VDD VSS g24389 INVX1
XI_3534 n8052 VDD VSS g24388 INVX1
XI_3532 n8053 VDD VSS g24387 INVX1
XI_3530 n8054 VDD VSS g24386 INVX1
XI_3528 n8055 VDD VSS g24385 INVX1
XI_3526 n8056 VDD VSS g24384 INVX1
XI_3524 n8057 VDD VSS g24383 INVX1
XI_3522 n8058 VDD VSS g24382 INVX1
XI_3520 n8463 VDD VSS g24381 INVX1
XI_3518 n8462 VDD VSS g24380 INVX1
XI_3516 n8461 VDD VSS g24379 INVX1
XI_3514 n8472 VDD VSS g24378 INVX1
XI_3512 n8407 VDD VSS g24377 INVX1
XI_3510 n8381 VDD VSS g24376 INVX1
XI_3508 n8382 VDD VSS g24375 INVX1
XI_3506 n8383 VDD VSS g24374 INVX1
XI_3504 n8385 VDD VSS g24373 INVX1
XI_3502 n8386 VDD VSS g24372 INVX1
XI_3500 n8384 VDD VSS g24371 INVX1
XI_3498 n8379 VDD VSS g24370 INVX1
XI_3496 n8380 VDD VSS g24369 INVX1
XI_3494 n8375 VDD VSS g24368 INVX1
XI_3492 n8377 VDD VSS g24367 INVX1
XI_3490 n8378 VDD VSS g24366 INVX1
XI_3488 n8376 VDD VSS g24365 INVX1
XI_3486 n7756 VDD VSS g24364 INVX1
XI_3484 n7757 VDD VSS g24363 INVX1
XI_3482 n7758 VDD VSS g24362 INVX1
XI_3480 n7777 VDD VSS g24361 INVX1
XI_3478 n7778 VDD VSS g24360 INVX1
XI_3476 n7779 VDD VSS g24359 INVX1
XI_3474 n7780 VDD VSS g24358 INVX1
XI_3472 n7781 VDD VSS g24357 INVX1
XI_3470 n7782 VDD VSS g24356 INVX1
XI_3468 n7783 VDD VSS g24355 INVX1
XI_3466 n7784 VDD VSS g24354 INVX1
XI_3464 n7785 VDD VSS g24353 INVX1
XI_3462 n7786 VDD VSS g24352 INVX1
XI_3460 n7787 VDD VSS g24351 INVX1
XI_3458 n7788 VDD VSS g24350 INVX1
XI_3456 n7789 VDD VSS g24349 INVX1
XI_3454 n7790 VDD VSS g24348 INVX1
XI_3452 n7791 VDD VSS g24347 INVX1
XI_3450 n7792 VDD VSS g24346 INVX1
XI_3448 n7793 VDD VSS g24345 INVX1
XI_3446 n7794 VDD VSS g24344 INVX1
XI_3444 n7795 VDD VSS g24343 INVX1
XI_3442 n7796 VDD VSS g24342 INVX1
XI_3440 n7797 VDD VSS g24341 INVX1
XI_3438 n8363 VDD VSS g24340 INVX1
XI_3436 n8362 VDD VSS g24339 INVX1
XI_3434 n8361 VDD VSS g24338 INVX1
XI_3432 n8372 VDD VSS g24337 INVX1
XI_3430 n8307 VDD VSS g24336 INVX1
XI_3428 n8281 VDD VSS g24335 INVX1
XI_3426 n8282 VDD VSS g24334 INVX1
XI_3424 n8283 VDD VSS g24333 INVX1
XI_3422 n8285 VDD VSS g24332 INVX1
XI_3420 n8286 VDD VSS g24331 INVX1
XI_3418 n8284 VDD VSS g24330 INVX1
XI_3416 n8279 VDD VSS g24329 INVX1
XI_3414 n8280 VDD VSS g24328 INVX1
XI_3412 n8275 VDD VSS g24327 INVX1
XI_3410 n8277 VDD VSS g24326 INVX1
XI_3408 n8278 VDD VSS g24325 INVX1
XI_3406 n8276 VDD VSS g24324 INVX1
XI_3404 n7843 VDD VSS g24323 INVX1
XI_3402 n7844 VDD VSS g24322 INVX1
XI_3400 n7845 VDD VSS g24321 INVX1
XI_3398 n7864 VDD VSS g24320 INVX1
XI_3396 n7865 VDD VSS g24319 INVX1
XI_3394 n7866 VDD VSS g24318 INVX1
XI_3392 n7867 VDD VSS g24317 INVX1
XI_3390 n7868 VDD VSS g24316 INVX1
XI_3388 n7869 VDD VSS g24315 INVX1
XI_3386 n7870 VDD VSS g24314 INVX1
XI_3384 n7871 VDD VSS g24313 INVX1
XI_3382 n7872 VDD VSS g24312 INVX1
XI_3380 n7873 VDD VSS g24311 INVX1
XI_3378 n7874 VDD VSS g24310 INVX1
XI_3376 n7875 VDD VSS g24309 INVX1
XI_3374 n7876 VDD VSS g24308 INVX1
XI_3372 n7877 VDD VSS g24307 INVX1
XI_3370 n7878 VDD VSS g24306 INVX1
XI_3368 n7879 VDD VSS g24305 INVX1
XI_3366 n7880 VDD VSS g24304 INVX1
XI_3364 n7881 VDD VSS g24303 INVX1
XI_3362 n7882 VDD VSS g24302 INVX1
XI_3360 n7883 VDD VSS g24301 INVX1
XI_3358 n7884 VDD VSS g24300 INVX1
XI_3356 n8263 VDD VSS g24299 INVX1
XI_3354 n8262 VDD VSS g24298 INVX1
XI_3352 n8261 VDD VSS g24297 INVX1
XI_3350 n8272 VDD VSS g24296 INVX1
XI_3348 n8187 VDD VSS g24295 INVX1
XI_3346 n8149 VDD VSS g24294 INVX1
XI_3344 n8150 VDD VSS g24293 INVX1
XI_3342 n8151 VDD VSS g24292 INVX1
XI_3340 n8153 VDD VSS g24291 INVX1
XI_3338 n8154 VDD VSS g24290 INVX1
XI_3336 n8152 VDD VSS g24289 INVX1
XI_3334 n8147 VDD VSS g24288 INVX1
XI_3332 n8148 VDD VSS g24287 INVX1
XI_3330 n8143 VDD VSS g24286 INVX1
XI_3328 n8145 VDD VSS g24285 INVX1
XI_3326 n8146 VDD VSS g24284 INVX1
XI_3324 n8144 VDD VSS g24283 INVX1
XI_3322 n7930 VDD VSS g24282 INVX1
XI_3320 n7931 VDD VSS g24281 INVX1
XI_3318 n7932 VDD VSS g24280 INVX1
XI_3316 n7951 VDD VSS g24279 INVX1
XI_3314 n7952 VDD VSS g24278 INVX1
XI_3312 n7953 VDD VSS g24277 INVX1
XI_3310 n7954 VDD VSS g24276 INVX1
XI_3308 n7955 VDD VSS g24275 INVX1
XI_3306 n7956 VDD VSS g24274 INVX1
XI_3304 n7957 VDD VSS g24273 INVX1
XI_3302 n7958 VDD VSS g24272 INVX1
XI_3300 n7959 VDD VSS g24271 INVX1
XI_3298 n7960 VDD VSS g24270 INVX1
XI_3296 n7961 VDD VSS g24269 INVX1
XI_3294 n7962 VDD VSS g24268 INVX1
XI_3292 n7963 VDD VSS g24267 INVX1
XI_3290 n7964 VDD VSS g24266 INVX1
XI_3288 n7965 VDD VSS g24265 INVX1
XI_3286 n7966 VDD VSS g24264 INVX1
XI_3284 n7967 VDD VSS g24263 INVX1
XI_3282 n7968 VDD VSS g24262 INVX1
XI_3280 n7969 VDD VSS g24261 INVX1
XI_3278 n7970 VDD VSS g24260 INVX1
XI_3276 n7971 VDD VSS g24259 INVX1
XI_3188 n8575 VDD VSS g23318 INVX1
XI_3186 n8586 VDD VSS g23317 INVX1
XI_3184 n7686 VDD VSS g23316 INVX1
XI_3182 N1202 VDD VSS g23315 INVX1
XI_3180 n7697 VDD VSS g23314 INVX1
XI_3178 n7699 VDD VSS g23313 INVX1
XI_3176 n7688 VDD VSS g23312 INVX1
XI_3174 n8516 VDD VSS g23311 INVX1
XI_3172 n8517 VDD VSS g23310 INVX1
XI_3170 n8518 VDD VSS g23309 INVX1
XI_3168 n8502 VDD VSS g23308 INVX1
XI_3166 n8503 VDD VSS g23307 INVX1
XI_3164 n8504 VDD VSS g23306 INVX1
XI_3162 n8559 VDD VSS g23305 INVX1
XI_3160 n8548 VDD VSS g23304 INVX1
XI_3158 n8545 VDD VSS g23303 INVX1
XI_3156 n8550 VDD VSS g23302 INVX1
XI_3154 n8529 VDD VSS g23301 INVX1
XI_3152 n8528 VDD VSS g23300 INVX1
XI_3150 n8551 VDD VSS g23299 INVX1
XI_3148 n8532 VDD VSS g23298 INVX1
XI_3146 n8530 VDD VSS g23297 INVX1
XI_3144 n8553 VDD VSS g23296 INVX1
XI_3142 n8535 VDD VSS g23295 INVX1
XI_3140 n8533 VDD VSS g23294 INVX1
XI_3138 n8554 VDD VSS g23293 INVX1
XI_3136 n8537 VDD VSS g23292 INVX1
XI_3134 n8536 VDD VSS g23291 INVX1
XI_3132 n8555 VDD VSS g23290 INVX1
XI_3130 n8539 VDD VSS g23289 INVX1
XI_3128 n8538 VDD VSS g23288 INVX1
XI_3126 n8556 VDD VSS g23287 INVX1
XI_3124 n8541 VDD VSS g23286 INVX1
XI_3122 n8540 VDD VSS g23285 INVX1
XI_3120 n8557 VDD VSS g23284 INVX1
XI_3118 n8543 VDD VSS g23283 INVX1
XI_3116 n8542 VDD VSS g23282 INVX1
XI_3114 n8558 VDD VSS g23281 INVX1
XI_3112 n8546 VDD VSS g23280 INVX1
XI_3110 n8544 VDD VSS g23279 INVX1
XI_3108 n8560 VDD VSS g23278 INVX1
XI_3106 n8549 VDD VSS g23277 INVX1
XI_3104 n8547 VDD VSS g23276 INVX1
XI_3102 n8573 VDD VSS g23275 INVX1
XI_3100 n8526 VDD VSS g23274 INVX1
XI_3098 n8416 VDD VSS g23273 INVX1
XI_3096 n8417 VDD VSS g23272 INVX1
XI_3094 n8418 VDD VSS g23271 INVX1
XI_3092 n8402 VDD VSS g23270 INVX1
XI_3090 n8403 VDD VSS g23269 INVX1
XI_3088 n8404 VDD VSS g23268 INVX1
XI_3086 n8459 VDD VSS g23267 INVX1
XI_3084 n8448 VDD VSS g23266 INVX1
XI_3082 n8445 VDD VSS g23265 INVX1
XI_3080 n8450 VDD VSS g23264 INVX1
XI_3078 n8429 VDD VSS g23263 INVX1
XI_3076 n8428 VDD VSS g23262 INVX1
XI_3074 n8451 VDD VSS g23261 INVX1
XI_3072 n8432 VDD VSS g23260 INVX1
XI_3070 n8430 VDD VSS g23259 INVX1
XI_3068 n8453 VDD VSS g23258 INVX1
XI_3066 n8435 VDD VSS g23257 INVX1
XI_3064 n8433 VDD VSS g23256 INVX1
XI_3062 n8454 VDD VSS g23255 INVX1
XI_3060 n8437 VDD VSS g23254 INVX1
XI_3058 n8436 VDD VSS g23253 INVX1
XI_3056 n8455 VDD VSS g23252 INVX1
XI_3054 n8439 VDD VSS g23251 INVX1
XI_3052 n8438 VDD VSS g23250 INVX1
XI_3050 n8456 VDD VSS g23249 INVX1
XI_3048 n8441 VDD VSS g23248 INVX1
XI_3046 n8440 VDD VSS g23247 INVX1
XI_3044 n8457 VDD VSS g23246 INVX1
XI_3042 n8443 VDD VSS g23245 INVX1
XI_3040 n8442 VDD VSS g23244 INVX1
XI_3038 n8458 VDD VSS g23243 INVX1
XI_3036 n8446 VDD VSS g23242 INVX1
XI_3034 n8444 VDD VSS g23241 INVX1
XI_3032 n8460 VDD VSS g23240 INVX1
XI_3030 n8449 VDD VSS g23239 INVX1
XI_3028 n8447 VDD VSS g23238 INVX1
XI_3026 n8473 VDD VSS g23237 INVX1
XI_3024 n8426 VDD VSS g23236 INVX1
XI_3022 n8316 VDD VSS g23235 INVX1
XI_3020 n8317 VDD VSS g23234 INVX1
XI_3018 n8318 VDD VSS g23233 INVX1
XI_3016 n8302 VDD VSS g23232 INVX1
XI_3014 n8303 VDD VSS g23231 INVX1
XI_3012 n8304 VDD VSS g23230 INVX1
XI_3010 n8359 VDD VSS g23229 INVX1
XI_3008 n8348 VDD VSS g23228 INVX1
XI_3006 n8345 VDD VSS g23227 INVX1
XI_3004 n8350 VDD VSS g23226 INVX1
XI_3002 n8329 VDD VSS g23225 INVX1
XI_3000 n8328 VDD VSS g23224 INVX1
XI_2998 n8351 VDD VSS g23223 INVX1
XI_2996 n8332 VDD VSS g23222 INVX1
XI_2994 n8330 VDD VSS g23221 INVX1
XI_2992 n8353 VDD VSS g23220 INVX1
XI_2990 n8335 VDD VSS g23219 INVX1
XI_2988 n8333 VDD VSS g23218 INVX1
XI_2986 n8354 VDD VSS g23217 INVX1
XI_2984 n8337 VDD VSS g23216 INVX1
XI_2982 n8336 VDD VSS g23215 INVX1
XI_2980 n8355 VDD VSS g23214 INVX1
XI_2978 n8339 VDD VSS g23213 INVX1
XI_2976 n8338 VDD VSS g23212 INVX1
XI_2974 n8356 VDD VSS g23211 INVX1
XI_2972 n8341 VDD VSS g23210 INVX1
XI_2970 n8340 VDD VSS g23209 INVX1
XI_2968 n8357 VDD VSS g23208 INVX1
XI_2966 n8343 VDD VSS g23207 INVX1
XI_2964 n8342 VDD VSS g23206 INVX1
XI_2962 n8358 VDD VSS g23205 INVX1
XI_2960 n8346 VDD VSS g23204 INVX1
XI_2958 n8344 VDD VSS g23203 INVX1
XI_2956 n8360 VDD VSS g23202 INVX1
XI_2954 n8349 VDD VSS g23201 INVX1
XI_2952 n8347 VDD VSS g23200 INVX1
XI_2950 n8373 VDD VSS g23199 INVX1
XI_2948 n8326 VDD VSS g23198 INVX1
XI_2946 n8196 VDD VSS g23197 INVX1
XI_2944 n8197 VDD VSS g23196 INVX1
XI_2942 n8198 VDD VSS g23195 INVX1
XI_2940 n8182 VDD VSS g23194 INVX1
XI_2938 n8183 VDD VSS g23193 INVX1
XI_2936 n8184 VDD VSS g23192 INVX1
XI_2934 n8259 VDD VSS g23191 INVX1
XI_2932 n8248 VDD VSS g23190 INVX1
XI_2930 n8245 VDD VSS g23189 INVX1
XI_2928 n8250 VDD VSS g23188 INVX1
XI_2926 n8229 VDD VSS g23187 INVX1
XI_2924 n8228 VDD VSS g23186 INVX1
XI_2922 n8251 VDD VSS g23185 INVX1
XI_2920 n8232 VDD VSS g23184 INVX1
XI_2918 n8230 VDD VSS g23183 INVX1
XI_2916 n8253 VDD VSS g23182 INVX1
XI_2914 n8235 VDD VSS g23181 INVX1
XI_2912 n8233 VDD VSS g23180 INVX1
XI_2910 n8254 VDD VSS g23179 INVX1
XI_2908 n8237 VDD VSS g23178 INVX1
XI_2906 n8236 VDD VSS g23177 INVX1
XI_2904 n8255 VDD VSS g23176 INVX1
XI_2902 n8239 VDD VSS g23175 INVX1
XI_2900 n8238 VDD VSS g23174 INVX1
XI_2898 n8256 VDD VSS g23173 INVX1
XI_2896 n8241 VDD VSS g23172 INVX1
XI_2894 n8240 VDD VSS g23171 INVX1
XI_2892 n8257 VDD VSS g23170 INVX1
XI_2890 n8243 VDD VSS g23169 INVX1
XI_2888 n8242 VDD VSS g23168 INVX1
XI_2886 n8258 VDD VSS g23167 INVX1
XI_2884 n8246 VDD VSS g23166 INVX1
XI_2882 n8244 VDD VSS g23165 INVX1
XI_2880 n8260 VDD VSS g23164 INVX1
XI_2878 n8249 VDD VSS g23163 INVX1
XI_2876 n8247 VDD VSS g23162 INVX1
XI_2874 n8273 VDD VSS g23161 INVX1
XI_2872 n8226 VDD VSS g23160 INVX1
XI_2870 n162 VDD VSS g23159 INVX1
XI_2868 n8220 VDD VSS g23158 INVX1
XI_2866 n8216 VDD VSS g23157 INVX1
XI_2864 n8212 VDD VSS g23156 INVX1
XI_2862 n8208 VDD VSS g23155 INVX1
XI_2860 n8204 VDD VSS g23154 INVX1
XI_2858 n134 VDD VSS g23153 INVX1
XI_2856 n137 VDD VSS g23152 INVX1
XI_2854 n138 VDD VSS g23151 INVX1
XI_2852 n127 VDD VSS g23150 INVX1
XI_2850 n130 VDD VSS g23149 INVX1
XI_2848 n8167 VDD VSS g23148 INVX1
XI_2792 n8606 VDD VSS g21966 INVX1
XI_2791 N1181 VDD VSS g21965 INVX1
XI_2789 n8607 VDD VSS g21964 INVX1
XI_2788 n7675 VDD VSS g21963 INVX1
XI_2786 n7677 VDD VSS g21962 INVX1
XI_2784 n7680 VDD VSS g21961 INVX1
XI_2782 n7683 VDD VSS g21960 INVX1
XI_2780 n7676 VDD VSS g21959 INVX1
XI_2778 n7679 VDD VSS g21958 INVX1
XI_2776 n7682 VDD VSS g21957 INVX1
XI_2774 n7685 VDD VSS g21956 INVX1
XI_2772 n7687 VDD VSS g21955 INVX1
XI_2770 n7678 VDD VSS g21954 INVX1
XI_2768 n7681 VDD VSS g21953 INVX1
XI_2766 n7684 VDD VSS g21952 INVX1
XI_2764 N1004 VDD VSS g21951 INVX1
XI_2762 n7689 VDD VSS g21950 INVX1
XI_2760 n7690 VDD VSS g21949 INVX1
XI_2758 n7691 VDD VSS g21948 INVX1
XI_2756 n7692 VDD VSS g21947 INVX1
XI_2754 n8574 VDD VSS g21946 INVX1
XI_2752 n8474 VDD VSS g21945 INVX1
XI_2750 n8374 VDD VSS g21944 INVX1
XI_2748 n8274 VDD VSS g21943 INVX1
XI_2712 n8094 VDD VSS g20632 INVX1
XI_2710 n8071 VDD VSS g20631 INVX1
XI_2708 n8059 VDD VSS g20630 INVX1
XI_2706 n8083 VDD VSS g20629 INVX1
XI_2704 n8072 VDD VSS g20628 INVX1
XI_2702 n8060 VDD VSS g20627 INVX1
XI_2700 n8085 VDD VSS g20626 INVX1
XI_2698 n8074 VDD VSS g20625 INVX1
XI_2696 n8062 VDD VSS g20624 INVX1
XI_2694 n8087 VDD VSS g20623 INVX1
XI_2692 n8076 VDD VSS g20622 INVX1
XI_2690 n8064 VDD VSS g20621 INVX1
XI_2688 n8089 VDD VSS g20620 INVX1
XI_2686 n8078 VDD VSS g20619 INVX1
XI_2684 n8066 VDD VSS g20618 INVX1
XI_2682 n8091 VDD VSS g20617 INVX1
XI_2680 n8080 VDD VSS g20616 INVX1
XI_2678 n8068 VDD VSS g20615 INVX1
XI_2676 n8092 VDD VSS g20614 INVX1
XI_2674 n8081 VDD VSS g20613 INVX1
XI_2672 n8069 VDD VSS g20612 INVX1
XI_2670 n8093 VDD VSS g20611 INVX1
XI_2668 n8082 VDD VSS g20610 INVX1
XI_2666 n8070 VDD VSS g20609 INVX1
XI_2664 n8599 VDD VSS g20608 INVX1
XI_2662 n8598 VDD VSS g20607 INVX1
XI_2660 n8597 VDD VSS g20606 INVX1
XI_2658 n8596 VDD VSS g20605 INVX1
XI_2656 N478 VDD VSS g20604 INVX1
XI_2654 n8595 VDD VSS g20603 INVX1
XI_2652 n8594 VDD VSS g20602 INVX1
XI_2650 n8593 VDD VSS g20601 INVX1
XI_2648 n8592 VDD VSS g20600 INVX1
XI_2646 n8591 VDD VSS g20599 INVX1
XI_2644 n8590 VDD VSS g20598 INVX1
XI_2642 n8589 VDD VSS g20597 INVX1
XI_2640 n8588 VDD VSS g20596 INVX1
XI_2638 n8587 VDD VSS g20595 INVX1
XI_2636 N930 VDD VSS g20594 INVX1
XI_2634 n8604 VDD VSS g20593 INVX1
XI_2632 n8603 VDD VSS g20592 INVX1
XI_2630 n8602 VDD VSS g20591 INVX1
XI_2628 n8601 VDD VSS g20590 INVX1
XI_2626 n8600 VDD VSS g20589 INVX1
XI_2624 n7532 VDD VSS g20588 INVX1
XI_2622 n7700 VDD VSS g20587 INVX1
XI_2620 n7694 VDD VSS g20586 INVX1
XI_2618 n7693 VDD VSS g20585 INVX1
XI_2616 n7696 VDD VSS g20584 INVX1
XI_2614 n7698 VDD VSS g20583 INVX1
XI_2612 n7702 VDD VSS g20582 INVX1
XI_2610 n7705 VDD VSS g20581 INVX1
XI_2608 n7695 VDD VSS g20580 INVX1
XI_2606 n7701 VDD VSS g20579 INVX1
XI_2604 n7703 VDD VSS g20578 INVX1
XI_2602 n7704 VDD VSS g20577 INVX1
XI_2600 n7706 VDD VSS g20576 INVX1
XI_2598 n7707 VDD VSS g20575 INVX1
XI_2596 n7708 VDD VSS g20574 INVX1
XI_2594 n7709 VDD VSS g20573 INVX1
XI_2592 n7710 VDD VSS g20572 INVX1
XI_2590 n7533 VDD VSS g20571 INVX1
XI_2588 n8527 VDD VSS g20570 INVX1
XI_2586 n8524 VDD VSS g20569 INVX1
XI_2584 n8525 VDD VSS g20568 INVX1
XI_2582 n7582 VDD VSS g20567 INVX1
XI_2581 n8427 VDD VSS g20566 INVX1
XI_2579 n8424 VDD VSS g20565 INVX1
XI_2577 n8425 VDD VSS g20564 INVX1
XI_2575 n7582 VDD VSS g20563 INVX1
XI_2574 n8327 VDD VSS g20562 INVX1
XI_2572 n8324 VDD VSS g20561 INVX1
XI_2570 n8325 VDD VSS g20560 INVX1
XI_2568 n7582 VDD VSS g20559 INVX1
XI_2567 n8227 VDD VSS g20558 INVX1
XI_2565 n8224 VDD VSS g20557 INVX1
XI_2563 n8225 VDD VSS g20556 INVX1
XI_2561 n7582 VDD VSS g20555 INVX1
XI_2372 n386 VDD VSS g19062 INVX1
XI_2370 N466 VDD VSS g19061 INVX1
XI_2368 N461 VDD VSS g19060 INVX1
XI_2366 n8521 VDD VSS g19059 INVX1
XI_2364 n8523 VDD VSS g19058 INVX1
XI_2362 n8522 VDD VSS g19057 INVX1
XI_2360 n331 VDD VSS g19056 INVX1
XI_2359 n333 VDD VSS g19055 INVX1
XI_2358 n334 VDD VSS g19054 INVX1
XI_2357 n335 VDD VSS g19053 INVX1
XI_2356 n322 VDD VSS g19052 INVX1
XI_2355 n323 VDD VSS g19051 INVX1
XI_2354 n324 VDD VSS g19050 INVX1
XI_2353 n325 VDD VSS g19049 INVX1
XI_2352 n321 VDD VSS g19048 INVX1
XI_2351 n8421 VDD VSS g19047 INVX1
XI_2349 n8423 VDD VSS g19046 INVX1
XI_2347 n8422 VDD VSS g19045 INVX1
XI_2345 n273 VDD VSS g19044 INVX1
XI_2344 n275 VDD VSS g19043 INVX1
XI_2343 n276 VDD VSS g19042 INVX1
XI_2342 n277 VDD VSS g19041 INVX1
XI_2341 n264 VDD VSS g19040 INVX1
XI_2340 n265 VDD VSS g19039 INVX1
XI_2339 n266 VDD VSS g19038 INVX1
XI_2338 n267 VDD VSS g19037 INVX1
XI_2337 n263 VDD VSS g19036 INVX1
XI_2336 n8321 VDD VSS g19035 INVX1
XI_2334 n8323 VDD VSS g19034 INVX1
XI_2332 n8322 VDD VSS g19033 INVX1
XI_2330 n215 VDD VSS g19032 INVX1
XI_2329 n217 VDD VSS g19031 INVX1
XI_2328 n218 VDD VSS g19030 INVX1
XI_2327 n219 VDD VSS g19029 INVX1
XI_2326 n206 VDD VSS g19028 INVX1
XI_2325 n207 VDD VSS g19027 INVX1
XI_2324 n208 VDD VSS g19026 INVX1
XI_2323 n209 VDD VSS g19025 INVX1
XI_2322 n205 VDD VSS g19024 INVX1
XI_2321 n8201 VDD VSS g19023 INVX1
XI_2319 n8203 VDD VSS g19022 INVX1
XI_2317 n8202 VDD VSS g19021 INVX1
XI_2315 n144 VDD VSS g19020 INVX1
XI_2314 n146 VDD VSS g19019 INVX1
XI_2313 n147 VDD VSS g19018 INVX1
XI_2312 n148 VDD VSS g19017 INVX1
XI_2311 n119 VDD VSS g19016 INVX1
XI_2310 n120 VDD VSS g19015 INVX1
XI_2309 n121 VDD VSS g19014 INVX1
XI_2308 n122 VDD VSS g19013 INVX1
XI_2307 n118 VDD VSS g19012 INVX1
XI_2104 n385 VDD VSS g16497 INVX1
XI_2101 n359 VDD VSS g16495 INVX1
XI_2100 N159 VDD VSS g16494 INVX1
XI_2098 n364 VDD VSS g16493 INVX1
XI_2096 n365 VDD VSS g16492 INVX1
XI_2094 n366 VDD VSS g16491 INVX1
XI_2092 n367 VDD VSS g16490 INVX1
XI_2090 n368 VDD VSS g16489 INVX1
XI_2088 n369 VDD VSS g16488 INVX1
XI_2086 n370 VDD VSS g16487 INVX1
XI_2084 n371 VDD VSS g16486 INVX1
XI_2082 n384 VDD VSS g16485 INVX1
XI_2080 n372 VDD VSS g16484 INVX1
XI_2078 n373 VDD VSS g16483 INVX1
XI_2076 n374 VDD VSS g16482 INVX1
XI_2074 n375 VDD VSS g16481 INVX1
XI_2072 n376 VDD VSS g16480 INVX1
XI_2070 n377 VDD VSS g16479 INVX1
XI_2068 n378 VDD VSS g16478 INVX1
XI_2066 n379 VDD VSS g16477 INVX1
XI_2064 n363 VDD VSS g16476 INVX1
XI_2062 n386 VDD VSS g16475 INVX1
XI_2060 n8520 VDD VSS g16474 INVX1
XI_2058 n8519 VDD VSS g16473 INVX1
XI_2056 n8420 VDD VSS g16472 INVX1
XI_2054 n8419 VDD VSS g16471 INVX1
XI_2052 n8320 VDD VSS g16470 INVX1
XI_2050 n8319 VDD VSS g16469 INVX1
XI_2048 n8200 VDD VSS g16468 INVX1
XI_2046 n8199 VDD VSS g16467 INVX1
XI_1737 II20523 VDD VSS g13475 INVX1
XI_1736 II20523 VDD VSS g13468 INVX1
XI_1735 II20523 VDD VSS g13467 INVX1
XI_1734 g2366 VDD VSS g13466 INVX1
XI_1733 g2364 VDD VSS g13465 INVX1
XI_1732 g2362 VDD VSS g13464 INVX1
XI_1731 g2360 VDD VSS g13463 INVX1
XI_1730 g2358 VDD VSS g13462 INVX1
XI_1729 g2356 VDD VSS g13461 INVX1
XI_1728 g2354 VDD VSS g13460 INVX1
XI_1727 g2528 VDD VSS g13459 INVX1
XI_1726 g2526 VDD VSS g13458 INVX1
XI_1725 II20514 VDD VSS g13457 INVX1
XI_1724 II20523 VDD VSS g13456 INVX1
XI_1723 II20664 VDD VSS g13455 INVX1
XI_1721 II20514 VDD VSS g13454 INVX1
XI_1720 II20514 VDD VSS g13453 INVX1
XI_1719 II20523 VDD VSS g13452 INVX1
XI_1718 II20523 VDD VSS g13451 INVX1
XI_1717 g1672 VDD VSS g13450 INVX1
XI_1716 g1670 VDD VSS g13449 INVX1
XI_1715 g1668 VDD VSS g13448 INVX1
XI_1714 g1666 VDD VSS g13447 INVX1
XI_1713 g1664 VDD VSS g13446 INVX1
XI_1712 g1662 VDD VSS g13445 INVX1
XI_1711 g1660 VDD VSS g13444 INVX1
XI_1710 g1834 VDD VSS g13443 INVX1
XI_1709 g1832 VDD VSS g13442 INVX1
XI_1708 II20514 VDD VSS g13441 INVX1
XI_1707 II20523 VDD VSS g13440 INVX1
XI_1706 II20616 VDD VSS g13439 INVX1
XI_1704 II20514 VDD VSS g13438 INVX1
XI_1703 II20514 VDD VSS g13437 INVX1
XI_1702 II20523 VDD VSS g13436 INVX1
XI_1701 II20523 VDD VSS g13435 INVX1
XI_1700 g978 VDD VSS g13434 INVX1
XI_1699 g976 VDD VSS g13433 INVX1
XI_1698 g974 VDD VSS g13432 INVX1
XI_1697 g972 VDD VSS g13431 INVX1
XI_1696 g970 VDD VSS g13430 INVX1
XI_1695 g968 VDD VSS g13429 INVX1
XI_1694 g966 VDD VSS g13428 INVX1
XI_1693 g1140 VDD VSS g13427 INVX1
XI_1692 g1138 VDD VSS g13426 INVX1
XI_1691 II20514 VDD VSS g13425 INVX1
XI_1690 II20523 VDD VSS g13424 INVX1
XI_1689 II20568 VDD VSS g13423 INVX1
XI_1687 II20514 VDD VSS g13422 INVX1
XI_1686 II20514 VDD VSS g13421 INVX1
XI_1685 II20523 VDD VSS g13420 INVX1
XI_1684 II20523 VDD VSS g13419 INVX1
XI_1683 g291 VDD VSS g13418 INVX1
XI_1682 g289 VDD VSS g13417 INVX1
XI_1681 g287 VDD VSS g13416 INVX1
XI_1680 g285 VDD VSS g13415 INVX1
XI_1679 g283 VDD VSS g13414 INVX1
XI_1678 g281 VDD VSS g13413 INVX1
XI_1677 g279 VDD VSS g13412 INVX1
XI_1676 g453 VDD VSS g13411 INVX1
XI_1675 g451 VDD VSS g13410 INVX1
XI_1674 II20514 VDD VSS g13409 INVX1
XI_1673 II20523 VDD VSS g13408 INVX1
XI_1671 II20520 VDD VSS g13407 INVX1
XI_1669 II20514 VDD VSS g13406 INVX1
XI_1668 II20514 VDD VSS g13405 INVX1
XI_1619 II18770 VDD VSS g11598 INVX1
XI_1617 II18767 VDD VSS g11597 INVX1
XI_1615 II18764 VDD VSS g11596 INVX1
XI_1613 II18761 VDD VSS g11595 INVX1
XI_1611 II18758 VDD VSS g11594 INVX1
XI_1609 II18755 VDD VSS g11593 INVX1
XI_1607 g2190 VDD VSS g11592 INVX1
XI_1606 g2195 VDD VSS g11591 INVX1
XI_1605 g2200 VDD VSS g11590 INVX1
XI_1604 II18743 VDD VSS g11589 INVX1
XI_1602 II18740 VDD VSS g11588 INVX1
XI_1600 II18737 VDD VSS g11587 INVX1
XI_1598 II18734 VDD VSS g11586 INVX1
XI_1596 II18731 VDD VSS g11585 INVX1
XI_1594 II18728 VDD VSS g11584 INVX1
XI_1592 II18725 VDD VSS g11583 INVX1
XI_1590 II18722 VDD VSS g11582 INVX1
XI_1588 II18719 VDD VSS g11581 INVX1
XI_1586 II18716 VDD VSS g11580 INVX1
XI_1584 II18713 VDD VSS g11579 INVX1
XI_1582 II18710 VDD VSS g11578 INVX1
XI_1580 II14094 VDD VSS g11577 INVX1
XI_1579 g2165 VDD VSS g11576 INVX1
XI_1578 g2170 VDD VSS g11575 INVX1
XI_1577 g2175 VDD VSS g11574 INVX1
XI_1576 g2180 VDD VSS g11573 INVX1
XI_1575 g2185 VDD VSS g11572 INVX1
XI_1574 II18689 VDD VSS g11571 INVX1
XI_1572 II18686 VDD VSS g11570 INVX1
XI_1570 II18683 VDD VSS g11569 INVX1
XI_1568 II18680 VDD VSS g11568 INVX1
XI_1566 II18677 VDD VSS g11567 INVX1
XI_1564 II18674 VDD VSS g11566 INVX1
XI_1562 g1496 VDD VSS g11565 INVX1
XI_1561 g1501 VDD VSS g11564 INVX1
XI_1560 g1506 VDD VSS g11563 INVX1
XI_1559 II18662 VDD VSS g11562 INVX1
XI_1557 II18659 VDD VSS g11561 INVX1
XI_1555 II18656 VDD VSS g11560 INVX1
XI_1553 II18653 VDD VSS g11559 INVX1
XI_1551 II18650 VDD VSS g11558 INVX1
XI_1549 II18647 VDD VSS g11557 INVX1
XI_1547 II18644 VDD VSS g11556 INVX1
XI_1545 II18641 VDD VSS g11555 INVX1
XI_1543 II18638 VDD VSS g11554 INVX1
XI_1541 II18635 VDD VSS g11553 INVX1
XI_1539 II18632 VDD VSS g11552 INVX1
XI_1537 II18629 VDD VSS g11551 INVX1
XI_1535 II14069 VDD VSS g11550 INVX1
XI_1534 g1471 VDD VSS g11549 INVX1
XI_1533 g1476 VDD VSS g11548 INVX1
XI_1532 g1481 VDD VSS g11547 INVX1
XI_1531 g1486 VDD VSS g11546 INVX1
XI_1530 g1491 VDD VSS g11545 INVX1
XI_1529 II18608 VDD VSS g11544 INVX1
XI_1527 II18605 VDD VSS g11543 INVX1
XI_1525 II18602 VDD VSS g11542 INVX1
XI_1523 II18599 VDD VSS g11541 INVX1
XI_1521 II18596 VDD VSS g11540 INVX1
XI_1519 II18593 VDD VSS g11539 INVX1
XI_1517 g805 VDD VSS g11538 INVX1
XI_1516 g809 VDD VSS g11537 INVX1
XI_1515 g813 VDD VSS g11536 INVX1
XI_1514 II18581 VDD VSS g11535 INVX1
XI_1512 II18578 VDD VSS g11534 INVX1
XI_1510 II18575 VDD VSS g11533 INVX1
XI_1508 II18572 VDD VSS g11532 INVX1
XI_1506 II18569 VDD VSS g11531 INVX1
XI_1504 II18566 VDD VSS g11530 INVX1
XI_1502 II18563 VDD VSS g11529 INVX1
XI_1500 II18560 VDD VSS g11528 INVX1
XI_1498 II18557 VDD VSS g11527 INVX1
XI_1496 II18554 VDD VSS g11526 INVX1
XI_1494 II18551 VDD VSS g11525 INVX1
XI_1492 II18548 VDD VSS g11524 INVX1
XI_1490 II14052 VDD VSS g11523 INVX1
XI_1489 g785 VDD VSS g11522 INVX1
XI_1488 g789 VDD VSS g11521 INVX1
XI_1487 g793 VDD VSS g11520 INVX1
XI_1486 g797 VDD VSS g11519 INVX1
XI_1485 g801 VDD VSS g11518 INVX1
XI_1484 II18527 VDD VSS g11517 INVX1
XI_1482 II18524 VDD VSS g11516 INVX1
XI_1480 II18521 VDD VSS g11515 INVX1
XI_1478 II18518 VDD VSS g11514 INVX1
XI_1476 II18515 VDD VSS g11513 INVX1
XI_1474 II18512 VDD VSS g11512 INVX1
XI_1472 g117 VDD VSS g11511 INVX1
XI_1471 g121 VDD VSS g11510 INVX1
XI_1470 g125 VDD VSS g11509 INVX1
XI_1469 II18500 VDD VSS g11508 INVX1
XI_1467 II18497 VDD VSS g11507 INVX1
XI_1465 II18494 VDD VSS g11506 INVX1
XI_1463 II18491 VDD VSS g11505 INVX1
XI_1461 II18488 VDD VSS g11504 INVX1
XI_1459 II18485 VDD VSS g11503 INVX1
XI_1457 II18482 VDD VSS g11502 INVX1
XI_1455 II18479 VDD VSS g11501 INVX1
XI_1453 II18476 VDD VSS g11500 INVX1
XI_1451 II18473 VDD VSS g11499 INVX1
XI_1449 II18470 VDD VSS g11498 INVX1
XI_1447 II18467 VDD VSS g11497 INVX1
XI_1445 II14030 VDD VSS g11496 INVX1
XI_1444 g97 VDD VSS g11495 INVX1
XI_1443 g101 VDD VSS g11494 INVX1
XI_1442 g105 VDD VSS g11493 INVX1
XI_1441 g109 VDD VSS g11492 INVX1
XI_1440 g113 VDD VSS g11491 INVX1
XI_1406 II15517 VDD VSS g8311 INVX1
XI_1404 II15511 VDD VSS g8302 INVX1
XI_1402 II15505 VDD VSS g8293 INVX1
XI_1400 II15499 VDD VSS g8284 INVX1
XU8753 n13892 VDD VSS n8608 INVX1
XU8754 n8608 VDD VSS n8609 INVX1
XU8755 n8610 g2990 VDD VSS n8607 XOR2X1
XU8756 n8611 VDD VSS n8610 INVX1
XU8757 n8612 g3083 VDD VSS n8606 XOR2X1
XU8758 n8613 VDD VSS n8612 INVX1
XU8759 n8614 n8615 VDD VSS n8604 OR2X1
XU8760 g3061 g2987 VDD VSS n8615 NOR2X1
XU8761 g2997 n8616 VDD VSS n8614 NOR2X1
XU8762 n8617 n8618 VDD VSS n8603 OR2X1
XU8763 g3060 g2987 VDD VSS n8618 NOR2X1
XU8764 g3078 n8616 VDD VSS n8617 NOR2X1
XU8765 n8619 n8620 VDD VSS n8602 OR2X1
XU8766 g3059 g2987 VDD VSS n8620 NOR2X1
XU8767 g3077 n8616 VDD VSS n8619 NOR2X1
XU8768 n8621 n8622 VDD VSS n8601 OR2X1
XU8769 g3058 g2987 VDD VSS n8622 NOR2X1
XU8770 g3076 n8616 VDD VSS n8621 NOR2X1
XU8771 n8623 n8624 VDD VSS n8600 OR2X1
XU8772 g3057 g2987 VDD VSS n8624 NOR2X1
XU8773 g3075 n8616 VDD VSS n8623 NOR2X1
XU8774 n8625 n8626 VDD VSS n8599 OR2X1
XU8775 g3056 g2987 VDD VSS n8626 NOR2X1
XU8776 g3074 n8616 VDD VSS n8625 NOR2X1
XU8777 n8627 n8628 VDD VSS n8598 OR2X1
XU8778 g3055 g2987 VDD VSS n8628 NOR2X1
XU8779 g3073 n8616 VDD VSS n8627 NOR2X1
XU8780 n8629 n8630 VDD VSS n8597 OR2X1
XU8781 g3053 g2987 VDD VSS n8630 NOR2X1
XU8782 g3072 n8616 VDD VSS n8629 NOR2X1
XU8783 n8631 n8632 VDD VSS n8596 OR2X1
XU8784 g3052 g2987 VDD VSS n8632 NOR2X1
XU8785 g3071 n8616 VDD VSS n8631 NOR2X1
XU8786 n8633 n8634 VDD VSS n8595 OR2X1
XU8787 g3051 g2987 VDD VSS n8634 NOR2X1
XU8788 g3070 n8616 VDD VSS n8633 NOR2X1
XU8789 n8635 n8636 VDD VSS n8594 OR2X1
XU8790 g3050 g2987 VDD VSS n8636 NOR2X1
XU8791 g3069 n8616 VDD VSS n8635 NOR2X1
XU8792 n8637 n8638 VDD VSS n8593 OR2X1
XU8793 g3049 g2987 VDD VSS n8638 NOR2X1
XU8794 g3068 n8616 VDD VSS n8637 NOR2X1
XU8795 n8639 n8640 VDD VSS n8592 OR2X1
XU8796 g3048 g2987 VDD VSS n8640 NOR2X1
XU8797 g3067 n8616 VDD VSS n8639 NOR2X1
XU8798 n8641 n8642 VDD VSS n8591 OR2X1
XU8799 g3047 g2987 VDD VSS n8642 NOR2X1
XU8800 g3066 n8616 VDD VSS n8641 NOR2X1
XU8801 n8643 n8644 VDD VSS n8590 OR2X1
XU8802 g3046 g2987 VDD VSS n8644 NOR2X1
XU8803 g3065 n8616 VDD VSS n8643 NOR2X1
XU8804 n8645 n8646 VDD VSS n8589 OR2X1
XU8805 g3045 g2987 VDD VSS n8646 NOR2X1
XU8806 g3064 n8616 VDD VSS n8645 NOR2X1
XU8807 n8647 n8648 VDD VSS n8588 OR2X1
XU8808 g3044 g2987 VDD VSS n8648 NOR2X1
XU8809 g3063 n8616 VDD VSS n8647 NOR2X1
XU8810 n8649 n8650 VDD VSS n8587 OR2X1
XU8811 g3043 g2987 VDD VSS n8650 NOR2X1
XU8812 g3062 n8616 VDD VSS n8649 NOR2X1
XU8813 g2987 VDD VSS n8616 INVX1
XU8814 g3080 n385 VDD VSS n8586 NAND2X1
XU8815 n8651 n8652 VDD VSS n8585 NAND2X1
XU8816 g3032 n8653 VDD VSS n8651 XOR2X1
XU8817 n8654 n8655 VDD VSS n8584 NAND2X1
XU8818 n8656 n8657 VDD VSS n8655 NAND2X1
XU8819 g3028 n8658 VDD VSS n8656 NAND2X1
XU8820 n8653 n8659 VDD VSS n8654 NOR2X1
XU8821 n8660 g3036 VDD VSS n8653 AND2X1
XU8822 n8661 n8662 VDD VSS n8660 NOR2X1
XU8823 n8663 n8652 VDD VSS n8583 NAND2X1
XU8824 n8662 n8661 VDD VSS n8663 XOR2X1
XU8825 n8664 n8665 VDD VSS n8582 NAND2X1
XU8826 n8666 n8667 VDD VSS n8665 XOR2X1
XU8827 g3010 n8668 VDD VSS n8667 NAND2X1
XU8828 n8664 n8669 VDD VSS n8581 NAND2X1
XU8829 g3010 n8668 VDD VSS n8669 XOR2X1
XU8830 n8670 n8664 VDD VSS n8580 NAND2X1
XU8831 n8668 n8671 VDD VSS n8670 NOR2X1
XU8832 g3013 n8672 VDD VSS n8671 NOR2X1
XU8833 n8673 n8674 VDD VSS n8672 NOR2X1
XU8834 n8675 n8676 VDD VSS n8668 AND2X1
XU8835 n8673 n8677 VDD VSS n8675 NOR2X1
XU8836 n8664 n8678 VDD VSS n8579 NAND2X1
XU8837 n8673 n8674 VDD VSS n8678 XOR2X1
XU8838 g3002 VDD VSS n8673 INVX1
XU8839 n8679 n8664 VDD VSS n8578 NAND2X1
XU8840 n8676 n8680 VDD VSS n8679 NOR2X1
XU8841 g3006 n8681 VDD VSS n8680 NOR2X1
XU8842 n8674 VDD VSS n8676 INVX1
XU8843 n8681 g3006 VDD VSS n8674 NAND2X1
XU8844 n8682 n8683 VDD VSS n8681 NOR2X1
XU8845 n8684 n8685 VDD VSS n8577 NAND2X1
XU8846 n8686 n385 VDD VSS n8685 NAND2X1
XU8847 n8687 n8664 VDD VSS n8684 NAND2X1
XU8848 n8682 n8688 VDD VSS n8687 XOR2X1
XU8849 g2998 VDD VSS n8682 INVX1
XU8850 n8689 n8690 VDD VSS n8576 NAND2X1
XU8851 n8691 II20523 VDD VSS n8690 NAND2X1
XU8852 g3234 n8688 VDD VSS n8689 NOR2X1
XU8853 n8683 VDD VSS n8688 INVX1
XU8854 g2993 g3080 VDD VSS n8683 NAND2X1
XU8855 g3054 n385 VDD VSS n8575 NAND2X1
XU8856 n8692 n8693 VDD VSS n8574 NAND2X1
XU8857 g2703 g2733 VDD VSS n8693 OR2X1
XU8858 g2703 n8694 VDD VSS n8692 NAND2X1
XU8859 n8695 n8696 VDD VSS n8573 NAND2X1
XU8860 g2714 n8697 VDD VSS n8695 XOR2X1
XU8861 n8698 n8699 VDD VSS n8572 NAND2X1
XU8862 n8700 n8701 VDD VSS n8699 NAND2X1
XU8863 g2707 VDD VSS n8701 INVX1
XU8864 n8697 g2714 VDD VSS n8700 NAND2X1
XU8865 n8702 n8703 VDD VSS n8698 NOR2X1
XU8866 n8704 n8696 VDD VSS n8571 NAND2X1
XU8867 g2727 n8702 VDD VSS n8704 XOR2X1
XU8868 n8705 n8706 VDD VSS n8570 NAND2X1
XU8869 n8707 n8708 VDD VSS n8706 NAND2X1
XU8870 n8702 g2727 VDD VSS n8707 NAND2X1
XU8871 n8709 n8703 VDD VSS n8705 NOR2X1
XU8872 n8710 n8696 VDD VSS n8569 NAND2X1
XU8873 g2734 n8709 VDD VSS n8710 XOR2X1
XU8874 n8711 n8712 VDD VSS n8568 NAND2X1
XU8875 n8713 n8714 VDD VSS n8712 NAND2X1
XU8876 n8709 g2734 VDD VSS n8713 NAND2X1
XU8877 n8715 n8703 VDD VSS n8711 NOR2X1
XU8878 n8716 n8696 VDD VSS n8567 NAND2X1
XU8879 g2740 n8715 VDD VSS n8716 XOR2X1
XU8880 n8717 n8718 VDD VSS n8566 NAND2X1
XU8881 n8719 n8720 VDD VSS n8718 NAND2X1
XU8882 g2753 VDD VSS n8720 INVX1
XU8883 n8715 g2740 VDD VSS n8719 NAND2X1
XU8884 n8721 n8696 VDD VSS n8717 AND2X1
XU8885 n8722 n8696 VDD VSS n8565 NAND2X1
XU8886 n8723 n8721 VDD VSS n8722 XOR2X1
XU8887 n8724 n8696 VDD VSS n8564 NAND2X1
XU8888 g2766 n8725 VDD VSS n8724 XOR2X1
XU8889 n8723 n8721 VDD VSS n8725 NOR2X1
XU8890 n8726 g2753 VDD VSS n8721 NAND2X1
XU8891 g2740 n8715 VDD VSS n8726 AND2X1
XU8892 n8727 g2746 VDD VSS n8715 AND2X1
XU8893 g2734 n8709 VDD VSS n8727 AND2X1
XU8894 n8728 g2720 VDD VSS n8709 AND2X1
XU8895 g2727 n8702 VDD VSS n8728 AND2X1
XU8896 n8729 g2707 VDD VSS n8702 AND2X1
XU8897 g2714 n8697 VDD VSS n8729 AND2X1
XU8898 n8730 g2733 VDD VSS n8697 NOR2X1
XU8899 g2760 VDD VSS n8723 INVX1
XU8900 n8731 n8732 VDD VSS n8563 NAND2X1
XU8901 n8733 g2811 VDD VSS n8732 OR2X1
XU8902 n8696 n8734 VDD VSS n8562 NAND2X1
XU8903 n8735 n8736 VDD VSS n8734 NAND2X1
XU8904 n8737 n8738 VDD VSS n8561 NAND2X1
XU8905 n8739 n8740 VDD VSS n8738 NAND2X1
XU8906 n8741 n8742 VDD VSS n8560 NAND2X1
XU8907 n8733 g2714 VDD VSS n8742 NAND2X1
XU8908 n8733 g2772 VDD VSS n8741 OR2X1
XU8909 n8743 n8744 VDD VSS n8559 NAND2X1
XU8910 g2766 n8733 VDD VSS n8744 NAND2X1
XU8911 n8733 g2799 VDD VSS n8743 OR2X1
XU8912 n8745 n8746 VDD VSS n8558 NAND2X1
XU8913 n8733 g2707 VDD VSS n8746 NAND2X1
XU8914 n8733 g2775 VDD VSS n8745 OR2X1
XU8915 n8747 n8748 VDD VSS n8557 NAND2X1
XU8916 n8733 g2727 VDD VSS n8748 NAND2X1
XU8917 n8733 g2778 VDD VSS n8747 OR2X1
XU8918 n8749 n8750 VDD VSS n8556 NAND2X1
XU8919 n8733 g2720 VDD VSS n8750 NAND2X1
XU8920 n8733 g2781 VDD VSS n8749 OR2X1
XU8921 n8751 n8752 VDD VSS n8555 NAND2X1
XU8922 n8733 g2734 VDD VSS n8752 NAND2X1
XU8923 n8733 g2784 VDD VSS n8751 OR2X1
XU8924 n8753 n8754 VDD VSS n8554 NAND2X1
XU8925 n8733 g2746 VDD VSS n8754 NAND2X1
XU8926 n8733 g2787 VDD VSS n8753 OR2X1
XU8927 n8755 n8756 VDD VSS n8553 NAND2X1
XU8928 n8733 g2740 VDD VSS n8756 NAND2X1
XU8929 n8733 g2790 VDD VSS n8755 OR2X1
XU8930 n8757 n8758 VDD VSS n8552 NAND2X1
XU8931 n8733 g2808 VDD VSS n8758 OR2X1
XU8932 n8733 n8759 VDD VSS n8757 NAND2X1
XU8933 n8760 n8761 VDD VSS n8551 NAND2X1
XU8934 n8733 g2753 VDD VSS n8761 NAND2X1
XU8935 n8733 g2793 VDD VSS n8760 OR2X1
XU8936 n8762 n8763 VDD VSS n8550 NAND2X1
XU8937 n8733 g2760 VDD VSS n8763 NAND2X1
XU8938 n8733 g2796 VDD VSS n8762 OR2X1
XU8939 n8764 g2703 VDD VSS n8733 AND2X1
XU8940 n8765 n8766 VDD VSS n8549 NAND2X1
XU8941 n8767 g2714 VDD VSS n8766 NAND2X1
XU8942 n8735 n8768 VDD VSS n8765 NAND2X1
XU8943 n8769 n8770 VDD VSS n8548 NAND2X1
XU8944 n8767 g2766 VDD VSS n8770 NAND2X1
XU8945 n8735 n8771 VDD VSS n8769 NAND2X1
XU8946 n8772 n8773 VDD VSS n8547 NAND2X1
XU8947 n8774 g2714 VDD VSS n8773 NAND2X1
XU8948 n8774 g2773 VDD VSS n8772 OR2X1
XU8949 n8775 n8776 VDD VSS n8546 NAND2X1
XU8950 n8767 g2707 VDD VSS n8776 NAND2X1
XU8951 n8735 n8777 VDD VSS n8775 NAND2X1
XU8952 n8778 n8779 VDD VSS n8545 NAND2X1
XU8953 n8774 g2766 VDD VSS n8779 NAND2X1
XU8954 n8774 g2800 VDD VSS n8778 OR2X1
XU8955 n8780 n8781 VDD VSS n8544 NAND2X1
XU8956 n8774 g2707 VDD VSS n8781 NAND2X1
XU8957 n8774 g2776 VDD VSS n8780 OR2X1
XU8958 n8782 n8783 VDD VSS n8543 NAND2X1
XU8959 n8767 g2727 VDD VSS n8783 NAND2X1
XU8960 n8735 n8784 VDD VSS n8782 NAND2X1
XU8961 n8785 n8786 VDD VSS n8542 NAND2X1
XU8962 n8774 g2727 VDD VSS n8786 NAND2X1
XU8963 n8774 g2779 VDD VSS n8785 OR2X1
XU8964 n8787 n8788 VDD VSS n8541 NAND2X1
XU8965 n8767 g2720 VDD VSS n8788 NAND2X1
XU8966 n8735 n8789 VDD VSS n8787 NAND2X1
XU8967 n8790 n8791 VDD VSS n8540 NAND2X1
XU8968 n8774 g2720 VDD VSS n8791 NAND2X1
XU8969 n8774 g2782 VDD VSS n8790 OR2X1
XU8970 n8792 n8793 VDD VSS n8539 NAND2X1
XU8971 n8767 g2734 VDD VSS n8793 NAND2X1
XU8972 n8735 n8794 VDD VSS n8792 NAND2X1
XU8973 n8795 n8796 VDD VSS n8538 NAND2X1
XU8974 n8774 g2734 VDD VSS n8796 NAND2X1
XU8975 n8774 g2785 VDD VSS n8795 OR2X1
XU8976 n8797 n8798 VDD VSS n8537 NAND2X1
XU8977 n8767 g2746 VDD VSS n8798 NAND2X1
XU8978 n8735 n8799 VDD VSS n8797 NAND2X1
XU8979 n8800 n8801 VDD VSS n8536 NAND2X1
XU8980 n8774 g2746 VDD VSS n8801 NAND2X1
XU8981 n8774 g2788 VDD VSS n8800 OR2X1
XU8982 n8802 n8803 VDD VSS n8535 NAND2X1
XU8983 n8767 g2740 VDD VSS n8803 NAND2X1
XU8984 n8735 n8804 VDD VSS n8802 NAND2X1
XU8985 n8805 n8806 VDD VSS n8534 NAND2X1
XU8986 n8767 g2810 VDD VSS n8806 OR2X1
XU8987 n8767 n8759 VDD VSS n8805 NAND2X1
XU8988 n8807 n8808 VDD VSS n8533 NAND2X1
XU8989 n8774 g2740 VDD VSS n8808 NAND2X1
XU8990 n8774 g2791 VDD VSS n8807 OR2X1
XU8991 n8809 n8810 VDD VSS n8532 NAND2X1
XU8992 n8767 g2753 VDD VSS n8810 NAND2X1
XU8993 n8735 n8811 VDD VSS n8809 NAND2X1
XU8994 n8812 n8813 VDD VSS n8531 NAND2X1
XU8995 n8774 g2809 VDD VSS n8813 OR2X1
XU8996 n8774 n8759 VDD VSS n8812 NAND2X1
XU8997 n8814 n8815 VDD VSS n8759 NAND2X1
XU8998 n8816 n8817 VDD VSS n8815 NOR2X1
XU8999 n8818 n8819 VDD VSS n8817 NAND2X1
XU9000 n8820 n8821 VDD VSS n8819 NAND2X1
XU9001 n8822 n8823 VDD VSS n8821 NOR2X1
XU9002 n8824 n8825 VDD VSS n8823 NAND2X1
XU9003 g2727 n8826 VDD VSS n8825 XOR2X1
XU9004 g2707 n8827 VDD VSS n8824 XOR2X1
XU9005 n8828 n8829 VDD VSS n8822 NAND2X1
XU9006 g2734 n8830 VDD VSS n8829 XOR2X1
XU9007 n8831 n8832 VDD VSS n8828 NOR2X1
XU9008 n8708 n8833 VDD VSS n8832 XOR2X1
XU9009 g2720 VDD VSS n8708 INVX1
XU9010 g2714 n8834 VDD VSS n8831 XOR2X1
XU9011 n8835 n8836 VDD VSS n8820 NOR2X1
XU9012 n8837 n8838 VDD VSS n8836 NAND2X1
XU9013 g2753 n8839 VDD VSS n8838 XOR2X1
XU9014 g2740 n8840 VDD VSS n8837 XOR2X1
XU9015 n8841 n8842 VDD VSS n8835 NAND2X1
XU9016 g2760 n8843 VDD VSS n8842 XOR2X1
XU9017 n8844 n8845 VDD VSS n8841 NOR2X1
XU9018 g2766 n8846 VDD VSS n8845 XOR2X1
XU9019 n8714 n8847 VDD VSS n8844 XOR2X1
XU9020 g2746 VDD VSS n8714 INVX1
XU9021 g2703 n8848 VDD VSS n8818 NAND2X1
XU9022 g2803 n8849 VDD VSS n8816 NOR2X1
XU9023 n8850 n8851 VDD VSS n8814 NOR2X1
XU9024 g2804 n8852 VDD VSS n8850 NOR2X1
XU9025 n8853 n8854 VDD VSS n8530 NAND2X1
XU9026 n8774 g2753 VDD VSS n8854 NAND2X1
XU9027 n8774 g2794 VDD VSS n8853 OR2X1
XU9028 n8855 n8856 VDD VSS n8529 NAND2X1
XU9029 n8767 g2760 VDD VSS n8856 NAND2X1
XU9030 n8735 VDD VSS n8767 INVX1
XU9031 n8735 n8857 VDD VSS n8855 NAND2X1
XU9032 n8764 g7487 VDD VSS n8735 NAND2X1
XU9033 n8858 n8859 VDD VSS n8528 NAND2X1
XU9034 n8774 g2760 VDD VSS n8859 NAND2X1
XU9035 n8774 g2797 VDD VSS n8858 OR2X1
XU9036 n8739 VDD VSS n8774 INVX1
XU9037 g7425 n8764 VDD VSS n8739 NAND2X1
XU9038 n8860 g2612 VDD VSS n8764 AND2X1
XU9039 g2733 n8861 VDD VSS n8860 NOR2X1
XU9040 n8862 n8863 VDD VSS n8527 NAND2X1
XU9041 g2703 g2704 VDD VSS n8863 OR2X1
XU9042 g2703 n8864 VDD VSS n8862 NAND2X1
XU9043 n8865 n8866 VDD VSS n8526 NAND2X1
XU9044 g2624 g2628 VDD VSS n8866 OR2X1
XU9045 g2624 n8867 VDD VSS n8865 NAND2X1
XU9046 n8868 n8869 VDD VSS n8525 NAND2X1
XU9047 g2628 g2624 VDD VSS n8869 NAND2X1
XU9048 n8870 n8871 VDD VSS n8868 NAND2X1
XU9049 n8872 n8873 VDD VSS n8524 NAND2X1
XU9050 g2624 n8871 VDD VSS n8873 NAND2X1
XU9051 n8864 n8870 VDD VSS n8872 NAND2X1
XU9052 n8874 n8875 VDD VSS n8523 NAND2X1
XU9053 g2624 n8876 VDD VSS n8875 NAND2X1
XU9054 n8877 n8878 VDD VSS n8874 NOR2X1
XU9055 g2555 n8879 VDD VSS n8878 NOR2X1
XU9056 g2539 n8880 VDD VSS n8877 NOR2X1
XU9057 n8881 n8882 VDD VSS n8522 NAND2X1
XU9058 g7302 n8883 VDD VSS n8882 NAND2X1
XU9059 n8884 n8885 VDD VSS n8881 NOR2X1
XU9060 g2553 n8870 VDD VSS n8885 NOR2X1
XU9061 g2552 n8879 VDD VSS n8884 NOR2X1
XU9062 n8886 n8887 VDD VSS n8521 NAND2X1
XU9063 g7302 n8888 VDD VSS n8887 NAND2X1
XU9064 n8889 n8890 VDD VSS n8886 NOR2X1
XU9065 g2562 n8870 VDD VSS n8890 NOR2X1
XU9066 g2561 n8879 VDD VSS n8889 NOR2X1
XU9067 n8891 n8892 VDD VSS n8518 NAND2X1
XU9068 n8893 g2806 VDD VSS n8892 OR2X1
XU9069 n8893 n8894 VDD VSS n8891 NAND2X1
XU9070 n8895 n8896 VDD VSS n8517 NAND2X1
XU9071 n8696 n8897 VDD VSS n8896 NAND2X1
XU9072 n8703 n8894 VDD VSS n8895 NAND2X1
XU9073 n8898 n8899 VDD VSS n8516 NAND2X1
XU9074 n8900 g2805 VDD VSS n8899 OR2X1
XU9075 n8900 n8894 VDD VSS n8898 NAND2X1
XU9076 n8901 n8902 VDD VSS n8515 NAND2X1
XU9077 n8903 g2649 VDD VSS n8902 OR2X1
XU9078 n8903 n8904 VDD VSS n8901 NAND2X1
XU9079 n8905 n8906 VDD VSS n8514 NAND2X1
XU9080 n8903 g2652 VDD VSS n8906 OR2X1
XU9081 n8903 n8907 VDD VSS n8905 NAND2X1
XU9082 n8908 n8909 VDD VSS n8513 NAND2X1
XU9083 n8903 g2655 VDD VSS n8909 OR2X1
XU9084 n8910 n8903 VDD VSS n8908 NAND2X1
XU9085 n8911 n8912 VDD VSS n8512 NAND2X1
XU9086 n8913 n8903 VDD VSS n8912 NAND2X1
XU9087 n8903 g2658 VDD VSS n8911 OR2X1
XU9088 n8870 n8507 VDD VSS n8903 NOR2X1
XU9089 n8914 n8915 VDD VSS n8511 NAND2X1
XU9090 n8916 n8917 VDD VSS n8915 NAND2X1
XU9091 n8918 n8904 VDD VSS n8914 NAND2X1
XU9092 n8919 n8920 VDD VSS n8510 NAND2X1
XU9093 n8916 n8921 VDD VSS n8920 NAND2X1
XU9094 n8918 n8907 VDD VSS n8919 NAND2X1
XU9095 n8922 n8923 VDD VSS n8509 NAND2X1
XU9096 n8916 n8924 VDD VSS n8923 NAND2X1
XU9097 n8918 n8910 VDD VSS n8922 NAND2X1
XU9098 n8925 n8926 VDD VSS n8508 NAND2X1
XU9099 n8918 n8913 VDD VSS n8926 NAND2X1
XU9100 n8916 n8927 VDD VSS n8925 NAND2X1
XU9101 n8918 VDD VSS n8916 INVX1
XU9102 n8879 n8507 VDD VSS n8918 NOR2X1
XU9103 n8928 n8929 VDD VSS n8506 NAND2X1
XU9104 n8930 n8879 VDD VSS n8929 NAND2X1
XU9105 g7390 n8931 VDD VSS n8928 NAND2X1
XU9106 n8932 n8933 VDD VSS n8505 NAND2X1
XU9107 g2571 g2624 VDD VSS n8933 OR2X1
XU9108 g2624 n8931 VDD VSS n8932 NAND2X1
XU9109 n8934 n8935 VDD VSS n8504 NAND2X1
XU9110 n8893 g2803 VDD VSS n8935 OR2X1
XU9111 n8893 n8936 VDD VSS n8934 NAND2X1
XU9112 n8737 VDD VSS n8893 INVX1
XU9113 g7425 g2704 VDD VSS n8737 NAND2X1
XU9114 n8937 n8938 VDD VSS n8503 NAND2X1
XU9115 n8703 g2804 VDD VSS n8938 OR2X1
XU9116 n8703 n8936 VDD VSS n8937 NAND2X1
XU9117 n8696 VDD VSS n8703 INVX1
XU9118 g7487 g2704 VDD VSS n8696 NAND2X1
XU9119 n8939 n8940 VDD VSS n8502 NAND2X1
XU9120 n8731 n8848 VDD VSS n8940 NAND2X1
XU9121 g2802 VDD VSS n8848 INVX1
XU9122 n8900 n8936 VDD VSS n8939 NAND2X1
XU9123 n8731 VDD VSS n8900 INVX1
XU9124 g2704 g2703 VDD VSS n8731 NAND2X1
XU9125 n8941 n8942 VDD VSS n8501 NAND2X1
XU9126 n8943 g2650 VDD VSS n8942 OR2X1
XU9127 n8943 n8904 VDD VSS n8941 NAND2X1
XU9128 n8944 n8945 VDD VSS n8904 NAND2X1
XU9129 g3229 n8946 VDD VSS n8945 NAND2X1
XU9130 n8947 n8948 VDD VSS n8944 NOR2X1
XU9131 g3229 n8949 VDD VSS n8948 NOR2X1
XU9132 n8950 n8951 VDD VSS n8947 NOR2X1
XU9133 n335 n8952 VDD VSS n8951 NAND2X1
XU9134 n8949 VDD VSS n8950 INVX1
XU9135 n8953 n8954 VDD VSS n8500 NAND2X1
XU9136 n8943 g2653 VDD VSS n8954 OR2X1
XU9137 n8943 n8907 VDD VSS n8953 NAND2X1
XU9138 n8949 n8955 VDD VSS n8907 NAND2X1
XU9139 n8956 n8957 VDD VSS n8955 NAND2X1
XU9140 n334 n8958 VDD VSS n8949 NAND2X1
XU9141 n8959 n8960 VDD VSS n8499 NAND2X1
XU9142 n8943 g2656 VDD VSS n8960 OR2X1
XU9143 n8943 n8910 VDD VSS n8959 NAND2X1
XU9144 n8961 n8962 VDD VSS n8910 NAND2X1
XU9145 n8963 n8956 VDD VSS n8962 NAND2X1
XU9146 n8956 n333 VDD VSS n8961 OR2X1
XU9147 n8964 n8965 VDD VSS n8498 NAND2X1
XU9148 n8943 g2659 VDD VSS n8965 OR2X1
XU9149 n8943 n8913 VDD VSS n8964 NAND2X1
XU9150 n8966 n8956 VDD VSS n8913 NOR2X1
XU9151 g3229 n331 VDD VSS n8956 XOR2X1
XU9152 n8880 n8507 VDD VSS n8943 NOR2X1
XU9153 n8967 n8968 VDD VSS n8507 AND2X1
XU9154 n8969 g2584 VDD VSS n8968 NAND2X1
XU9155 n8970 n8971 VDD VSS n8969 NOR2X1
XU9156 n8694 n8972 VDD VSS n8967 NAND2X1
XU9157 n8971 n8894 VDD VSS n8972 NAND2X1
XU9158 n8973 n8974 VDD VSS n8497 NAND2X1
XU9159 n8975 n8880 VDD VSS n8974 NAND2X1
XU9160 g7302 n8931 VDD VSS n8973 NAND2X1
XU9161 n8976 n8970 VDD VSS n8931 NAND2X1
XU9162 n8971 n8864 VDD VSS n8976 NOR2X1
XU9163 n8977 n8978 VDD VSS n8971 NAND2X1
XU9164 g2571 g2624 VDD VSS n8978 NAND2X1
XU9165 n8979 n8980 VDD VSS n8977 NOR2X1
XU9166 n8879 n8930 VDD VSS n8980 NOR2X1
XU9167 g2568 VDD VSS n8930 INVX1
XU9168 n8880 n8975 VDD VSS n8979 NOR2X1
XU9169 g2565 VDD VSS n8975 INVX1
XU9170 n8981 n8982 VDD VSS n8496 NAND2X1
XU9171 g2380 g3229 VDD VSS n8982 OR2X1
XU9172 g2366 g3229 VDD VSS n8981 NAND2X1
XU9173 n8983 n8984 VDD VSS n8495 NAND2X1
XU9174 II18770 n8985 VDD VSS n8984 NAND2X1
XU9175 g8087 n8986 VDD VSS n8983 NAND2X1
XU9176 n8987 n8988 VDD VSS n8494 NAND2X1
XU9177 II18758 n8989 VDD VSS n8988 NAND2X1
XU9178 g8167 n8986 VDD VSS n8987 NAND2X1
XU9179 n8990 n8991 VDD VSS n8493 NAND2X1
XU9180 II18761 n8992 VDD VSS n8991 NAND2X1
XU9181 g2560 n8986 VDD VSS n8990 NAND2X1
XU9182 n8993 n8994 VDD VSS n8492 NAND2X1
XU9183 II18767 n8992 VDD VSS n8994 NAND2X1
XU9184 g2560 n8995 VDD VSS n8993 NAND2X1
XU9185 n8996 n8997 VDD VSS n8491 NAND2X1
XU9186 II18755 n8985 VDD VSS n8997 NAND2X1
XU9187 g8087 VDD VSS n8985 INVX1
XU9188 g8087 n8995 VDD VSS n8996 NAND2X1
XU9189 n8998 n8999 VDD VSS n8490 NAND2X1
XU9190 II18764 n8989 VDD VSS n8999 NAND2X1
XU9191 g8167 n8995 VDD VSS n8998 NAND2X1
XU9192 n9000 n9001 VDD VSS n8489 NAND2X1
XU9193 g2552 g8087 VDD VSS n9001 OR2X1
XU9194 g8087 n9002 VDD VSS n9000 NAND2X1
XU9195 n9003 n9004 VDD VSS n8488 NAND2X1
XU9196 g2553 g8167 VDD VSS n9004 OR2X1
XU9197 g8167 n9002 VDD VSS n9003 NAND2X1
XU9198 n9005 n9006 VDD VSS n8487 NAND2X1
XU9199 n8883 n8992 VDD VSS n9006 NAND2X1
XU9200 g2554 VDD VSS n8883 INVX1
XU9201 g2560 n9002 VDD VSS n9005 NAND2X1
XU9202 n9007 n9008 VDD VSS n8486 NAND2X1
XU9203 n8876 n8989 VDD VSS n9008 NAND2X1
XU9204 g8167 VDD VSS n8989 INVX1
XU9205 g2559 VDD VSS n8876 INVX1
XU9206 g8167 n9009 VDD VSS n9007 NAND2X1
XU9207 n9010 n9011 VDD VSS n8485 NAND2X1
XU9208 g2539 g2560 VDD VSS n9011 OR2X1
XU9209 g2560 n9009 VDD VSS n9010 NAND2X1
XU9210 n9012 n9013 VDD VSS n8484 NAND2X1
XU9211 g2555 g8087 VDD VSS n9013 OR2X1
XU9212 g8087 n9009 VDD VSS n9012 NAND2X1
XU9213 n9014 n9015 VDD VSS n8483 NAND2X1
XU9214 g2561 g8087 VDD VSS n9015 OR2X1
XU9215 g8087 n9016 VDD VSS n9014 NAND2X1
XU9216 n9017 n9018 VDD VSS n8482 NAND2X1
XU9217 g2562 g8167 VDD VSS n9018 OR2X1
XU9218 g8167 n9016 VDD VSS n9017 NAND2X1
XU9219 n9019 n9020 VDD VSS n8481 NAND2X1
XU9220 n8992 n8888 VDD VSS n9020 NAND2X1
XU9221 g2563 VDD VSS n8888 INVX1
XU9222 g2560 VDD VSS n8992 INVX1
XU9223 g2560 n9016 VDD VSS n9019 NAND2X1
XU9224 n9021 n9022 VDD VSS n8480 NAND2X1
XU9225 n9023 n9024 VDD VSS n9022 NAND2X1
XU9226 n9023 g2240 VDD VSS n9021 OR2X1
XU9227 n9025 n9026 VDD VSS n8479 NAND2X1
XU9228 n9027 n9024 VDD VSS n9026 NAND2X1
XU9229 n9028 n9029 VDD VSS n9025 NAND2X1
XU9230 n9030 n9031 VDD VSS n8478 NAND2X1
XU9231 n9023 g2237 VDD VSS n9031 OR2X1
XU9232 n9023 n9032 VDD VSS n9030 NAND2X1
XU9233 n9033 n9034 VDD VSS n8477 NAND2X1
XU9234 n9028 n9035 VDD VSS n9034 NAND2X1
XU9235 n9027 n9032 VDD VSS n9033 NAND2X1
XU9236 n9036 n9037 VDD VSS n8476 NAND2X1
XU9237 n9038 n9032 VDD VSS n9037 NAND2X1
XU9238 n9039 n9040 VDD VSS n9036 NAND2X1
XU9239 n9041 n9042 VDD VSS n8475 NAND2X1
XU9240 n9038 n9024 VDD VSS n9042 NAND2X1
XU9241 n9039 n9043 VDD VSS n9041 NAND2X1
XU9242 n9044 n9045 VDD VSS n8474 NAND2X1
XU9243 g2009 g2039 VDD VSS n9045 OR2X1
XU9244 g2009 n8694 VDD VSS n9044 NAND2X1
XU9245 n9046 n9047 VDD VSS n8473 NAND2X1
XU9246 g2020 n9048 VDD VSS n9046 XOR2X1
XU9247 n9049 n9050 VDD VSS n8472 NAND2X1
XU9248 n9051 n9052 VDD VSS n9050 NAND2X1
XU9249 g2013 VDD VSS n9052 INVX1
XU9250 n9048 g2020 VDD VSS n9051 NAND2X1
XU9251 n9053 n9054 VDD VSS n9049 NOR2X1
XU9252 n9055 n9047 VDD VSS n8471 NAND2X1
XU9253 g2033 n9053 VDD VSS n9055 XOR2X1
XU9254 n9056 n9057 VDD VSS n8470 NAND2X1
XU9255 n9058 n9059 VDD VSS n9057 NAND2X1
XU9256 n9053 g2033 VDD VSS n9058 NAND2X1
XU9257 n9060 n9054 VDD VSS n9056 NOR2X1
XU9258 n9061 n9047 VDD VSS n8469 NAND2X1
XU9259 g2040 n9060 VDD VSS n9061 XOR2X1
XU9260 n9062 n9063 VDD VSS n8468 NAND2X1
XU9261 n9064 n9065 VDD VSS n9063 NAND2X1
XU9262 n9060 g2040 VDD VSS n9064 NAND2X1
XU9263 n9066 n9054 VDD VSS n9062 NOR2X1
XU9264 n9067 n9047 VDD VSS n8467 NAND2X1
XU9265 g2046 n9066 VDD VSS n9067 XOR2X1
XU9266 n9068 n9069 VDD VSS n8466 NAND2X1
XU9267 n9070 n9071 VDD VSS n9069 NAND2X1
XU9268 g2059 VDD VSS n9071 INVX1
XU9269 n9066 g2046 VDD VSS n9070 NAND2X1
XU9270 n9072 n9047 VDD VSS n9068 AND2X1
XU9271 n9073 n9047 VDD VSS n8465 NAND2X1
XU9272 n9074 n9072 VDD VSS n9073 XOR2X1
XU9273 n9075 n9047 VDD VSS n8464 NAND2X1
XU9274 g2072 n9076 VDD VSS n9075 XOR2X1
XU9275 n9074 n9072 VDD VSS n9076 NOR2X1
XU9276 n9077 g2059 VDD VSS n9072 NAND2X1
XU9277 g2046 n9066 VDD VSS n9077 AND2X1
XU9278 n9078 g2052 VDD VSS n9066 AND2X1
XU9279 g2040 n9060 VDD VSS n9078 AND2X1
XU9280 n9079 g2026 VDD VSS n9060 AND2X1
XU9281 g2033 n9053 VDD VSS n9079 AND2X1
XU9282 n9080 g2013 VDD VSS n9053 AND2X1
XU9283 g2020 n9048 VDD VSS n9080 AND2X1
XU9284 n9081 g2039 VDD VSS n9048 NOR2X1
XU9285 g2066 VDD VSS n9074 INVX1
XU9286 n9082 n9083 VDD VSS n8463 NAND2X1
XU9287 n9084 g2117 VDD VSS n9083 OR2X1
XU9288 n9047 n9085 VDD VSS n8462 NAND2X1
XU9289 n9086 n9087 VDD VSS n9085 NAND2X1
XU9290 n9088 n9089 VDD VSS n8461 NAND2X1
XU9291 n9090 n9091 VDD VSS n9089 NAND2X1
XU9292 n9092 n9093 VDD VSS n8460 NAND2X1
XU9293 n9084 g2020 VDD VSS n9093 NAND2X1
XU9294 n9084 g2078 VDD VSS n9092 OR2X1
XU9295 n9094 n9095 VDD VSS n8459 NAND2X1
XU9296 g2072 n9084 VDD VSS n9095 NAND2X1
XU9297 n9084 g2105 VDD VSS n9094 OR2X1
XU9298 n9096 n9097 VDD VSS n8458 NAND2X1
XU9299 n9084 g2013 VDD VSS n9097 NAND2X1
XU9300 n9084 g2081 VDD VSS n9096 OR2X1
XU9301 n9098 n9099 VDD VSS n8457 NAND2X1
XU9302 n9084 g2033 VDD VSS n9099 NAND2X1
XU9303 n9084 g2084 VDD VSS n9098 OR2X1
XU9304 n9100 n9101 VDD VSS n8456 NAND2X1
XU9305 n9084 g2026 VDD VSS n9101 NAND2X1
XU9306 n9084 g2087 VDD VSS n9100 OR2X1
XU9307 n9102 n9103 VDD VSS n8455 NAND2X1
XU9308 n9084 g2040 VDD VSS n9103 NAND2X1
XU9309 n9084 g2090 VDD VSS n9102 OR2X1
XU9310 n9104 n9105 VDD VSS n8454 NAND2X1
XU9311 n9084 g2052 VDD VSS n9105 NAND2X1
XU9312 n9084 g2093 VDD VSS n9104 OR2X1
XU9313 n9106 n9107 VDD VSS n8453 NAND2X1
XU9314 n9084 g2046 VDD VSS n9107 NAND2X1
XU9315 n9084 g2096 VDD VSS n9106 OR2X1
XU9316 n9108 n9109 VDD VSS n8452 NAND2X1
XU9317 n9084 g2114 VDD VSS n9109 OR2X1
XU9318 n9084 n9110 VDD VSS n9108 NAND2X1
XU9319 n9111 n9112 VDD VSS n8451 NAND2X1
XU9320 n9084 g2059 VDD VSS n9112 NAND2X1
XU9321 n9084 g2099 VDD VSS n9111 OR2X1
XU9322 n9113 n9114 VDD VSS n8450 NAND2X1
XU9323 n9084 g2066 VDD VSS n9114 NAND2X1
XU9324 n9084 g2102 VDD VSS n9113 OR2X1
XU9325 n9115 g2009 VDD VSS n9084 AND2X1
XU9326 n9116 n9117 VDD VSS n8449 NAND2X1
XU9327 n9118 g2020 VDD VSS n9117 NAND2X1
XU9328 n9086 n9119 VDD VSS n9116 NAND2X1
XU9329 n9120 n9121 VDD VSS n8448 NAND2X1
XU9330 n9118 g2072 VDD VSS n9121 NAND2X1
XU9331 n9086 n9122 VDD VSS n9120 NAND2X1
XU9332 n9123 n9124 VDD VSS n8447 NAND2X1
XU9333 n9125 g2020 VDD VSS n9124 NAND2X1
XU9334 n9125 g2079 VDD VSS n9123 OR2X1
XU9335 n9126 n9127 VDD VSS n8446 NAND2X1
XU9336 n9118 g2013 VDD VSS n9127 NAND2X1
XU9337 n9086 n9128 VDD VSS n9126 NAND2X1
XU9338 n9129 n9130 VDD VSS n8445 NAND2X1
XU9339 n9125 g2072 VDD VSS n9130 NAND2X1
XU9340 n9125 g2106 VDD VSS n9129 OR2X1
XU9341 n9131 n9132 VDD VSS n8444 NAND2X1
XU9342 n9125 g2013 VDD VSS n9132 NAND2X1
XU9343 n9125 g2082 VDD VSS n9131 OR2X1
XU9344 n9133 n9134 VDD VSS n8443 NAND2X1
XU9345 n9118 g2033 VDD VSS n9134 NAND2X1
XU9346 n9086 n9135 VDD VSS n9133 NAND2X1
XU9347 n9136 n9137 VDD VSS n8442 NAND2X1
XU9348 n9125 g2033 VDD VSS n9137 NAND2X1
XU9349 n9125 g2085 VDD VSS n9136 OR2X1
XU9350 n9138 n9139 VDD VSS n8441 NAND2X1
XU9351 n9118 g2026 VDD VSS n9139 NAND2X1
XU9352 n9086 n9140 VDD VSS n9138 NAND2X1
XU9353 n9141 n9142 VDD VSS n8440 NAND2X1
XU9354 n9125 g2026 VDD VSS n9142 NAND2X1
XU9355 n9125 g2088 VDD VSS n9141 OR2X1
XU9356 n9143 n9144 VDD VSS n8439 NAND2X1
XU9357 n9118 g2040 VDD VSS n9144 NAND2X1
XU9358 n9086 n9145 VDD VSS n9143 NAND2X1
XU9359 n9146 n9147 VDD VSS n8438 NAND2X1
XU9360 n9125 g2040 VDD VSS n9147 NAND2X1
XU9361 n9125 g2091 VDD VSS n9146 OR2X1
XU9362 n9148 n9149 VDD VSS n8437 NAND2X1
XU9363 n9118 g2052 VDD VSS n9149 NAND2X1
XU9364 n9086 n9150 VDD VSS n9148 NAND2X1
XU9365 n9151 n9152 VDD VSS n8436 NAND2X1
XU9366 n9125 g2052 VDD VSS n9152 NAND2X1
XU9367 n9125 g2094 VDD VSS n9151 OR2X1
XU9368 n9153 n9154 VDD VSS n8435 NAND2X1
XU9369 n9118 g2046 VDD VSS n9154 NAND2X1
XU9370 n9086 n9155 VDD VSS n9153 NAND2X1
XU9371 n9156 n9157 VDD VSS n8434 NAND2X1
XU9372 n9118 g2116 VDD VSS n9157 OR2X1
XU9373 n9118 n9110 VDD VSS n9156 NAND2X1
XU9374 n9158 n9159 VDD VSS n8433 NAND2X1
XU9375 n9125 g2046 VDD VSS n9159 NAND2X1
XU9376 n9125 g2097 VDD VSS n9158 OR2X1
XU9377 n9160 n9161 VDD VSS n8432 NAND2X1
XU9378 n9118 g2059 VDD VSS n9161 NAND2X1
XU9379 n9086 n9162 VDD VSS n9160 NAND2X1
XU9380 n9163 n9164 VDD VSS n8431 NAND2X1
XU9381 n9125 g2115 VDD VSS n9164 OR2X1
XU9382 n9125 n9110 VDD VSS n9163 NAND2X1
XU9383 n9165 n9166 VDD VSS n9110 NAND2X1
XU9384 n9167 n9168 VDD VSS n9166 NOR2X1
XU9385 n9169 n9170 VDD VSS n9168 NAND2X1
XU9386 n9171 n9172 VDD VSS n9170 NAND2X1
XU9387 n9173 n9174 VDD VSS n9172 NOR2X1
XU9388 n9175 n9176 VDD VSS n9174 NAND2X1
XU9389 g2033 n9177 VDD VSS n9176 XOR2X1
XU9390 g2013 n9178 VDD VSS n9175 XOR2X1
XU9391 n9179 n9180 VDD VSS n9173 NAND2X1
XU9392 g2040 n9181 VDD VSS n9180 XOR2X1
XU9393 n9182 n9183 VDD VSS n9179 NOR2X1
XU9394 n9059 n9184 VDD VSS n9183 XOR2X1
XU9395 g2026 VDD VSS n9059 INVX1
XU9396 g2020 n9185 VDD VSS n9182 XOR2X1
XU9397 n9186 n9187 VDD VSS n9171 NOR2X1
XU9398 n9188 n9189 VDD VSS n9187 NAND2X1
XU9399 g2059 n9190 VDD VSS n9189 XOR2X1
XU9400 g2046 n9191 VDD VSS n9188 XOR2X1
XU9401 n9192 n9193 VDD VSS n9186 NAND2X1
XU9402 g2066 n9194 VDD VSS n9193 XOR2X1
XU9403 n9195 n9196 VDD VSS n9192 NOR2X1
XU9404 g2072 n9197 VDD VSS n9196 XOR2X1
XU9405 n9065 n9198 VDD VSS n9195 XOR2X1
XU9406 g2052 VDD VSS n9065 INVX1
XU9407 g2009 n9199 VDD VSS n9169 NAND2X1
XU9408 g2109 n9200 VDD VSS n9167 NOR2X1
XU9409 n9201 n9202 VDD VSS n9165 NOR2X1
XU9410 g2110 n9203 VDD VSS n9201 NOR2X1
XU9411 n9204 n9205 VDD VSS n8430 NAND2X1
XU9412 n9125 g2059 VDD VSS n9205 NAND2X1
XU9413 n9125 g2100 VDD VSS n9204 OR2X1
XU9414 n9206 n9207 VDD VSS n8429 NAND2X1
XU9415 n9118 g2066 VDD VSS n9207 NAND2X1
XU9416 n9086 VDD VSS n9118 INVX1
XU9417 n9086 n9208 VDD VSS n9206 NAND2X1
XU9418 n9115 g7357 VDD VSS n9086 NAND2X1
XU9419 n9209 n9210 VDD VSS n8428 NAND2X1
XU9420 n9125 g2066 VDD VSS n9210 NAND2X1
XU9421 n9125 g2103 VDD VSS n9209 OR2X1
XU9422 n9090 VDD VSS n9125 INVX1
XU9423 g7229 n9115 VDD VSS n9090 NAND2X1
XU9424 n9211 g1918 VDD VSS n9115 AND2X1
XU9425 g2039 n9212 VDD VSS n9211 NOR2X1
XU9426 n9213 n9214 VDD VSS n8427 NAND2X1
XU9427 g2009 g2010 VDD VSS n9214 OR2X1
XU9428 g2009 n9215 VDD VSS n9213 NAND2X1
XU9429 n9216 n9217 VDD VSS n8426 NAND2X1
XU9430 g1930 g1934 VDD VSS n9217 OR2X1
XU9431 g1930 n8867 VDD VSS n9216 NAND2X1
XU9432 n9218 n9219 VDD VSS n8425 NAND2X1
XU9433 g1934 g1930 VDD VSS n9219 NAND2X1
XU9434 n9220 n9221 VDD VSS n9218 NAND2X1
XU9435 n9222 n9223 VDD VSS n8424 NAND2X1
XU9436 g1930 n9221 VDD VSS n9223 NAND2X1
XU9437 n9215 n9220 VDD VSS n9222 NAND2X1
XU9438 n9224 n9225 VDD VSS n8423 NAND2X1
XU9439 g1930 n9226 VDD VSS n9225 NAND2X1
XU9440 n9227 n9228 VDD VSS n9224 NOR2X1
XU9441 g1861 n9229 VDD VSS n9228 NOR2X1
XU9442 g1845 n9230 VDD VSS n9227 NOR2X1
XU9443 n9231 n9232 VDD VSS n8422 NAND2X1
XU9444 g7052 n9233 VDD VSS n9232 NAND2X1
XU9445 n9234 n9235 VDD VSS n9231 NOR2X1
XU9446 g1859 n9220 VDD VSS n9235 NOR2X1
XU9447 g1858 n9229 VDD VSS n9234 NOR2X1
XU9448 n9236 n9237 VDD VSS n8421 NAND2X1
XU9449 g7052 n9238 VDD VSS n9237 NAND2X1
XU9450 n9239 n9240 VDD VSS n9236 NOR2X1
XU9451 g1868 n9220 VDD VSS n9240 NOR2X1
XU9452 g1867 n9229 VDD VSS n9239 NOR2X1
XU9453 n9241 n9242 VDD VSS n8418 NAND2X1
XU9454 n9243 g2112 VDD VSS n9242 OR2X1
XU9455 n9243 n9244 VDD VSS n9241 NAND2X1
XU9456 n9245 n9246 VDD VSS n8417 NAND2X1
XU9457 n9047 n9247 VDD VSS n9246 NAND2X1
XU9458 n9054 n9244 VDD VSS n9245 NAND2X1
XU9459 n9248 n9249 VDD VSS n8416 NAND2X1
XU9460 n9250 g2111 VDD VSS n9249 OR2X1
XU9461 n9250 n9244 VDD VSS n9248 NAND2X1
XU9462 n9251 n9252 VDD VSS n8415 NAND2X1
XU9463 n9253 g1955 VDD VSS n9252 OR2X1
XU9464 n9253 n9254 VDD VSS n9251 NAND2X1
XU9465 n9255 n9256 VDD VSS n8414 NAND2X1
XU9466 n9253 g1958 VDD VSS n9256 OR2X1
XU9467 n9253 n9257 VDD VSS n9255 NAND2X1
XU9468 n9258 n9259 VDD VSS n8413 NAND2X1
XU9469 n9253 g1961 VDD VSS n9259 OR2X1
XU9470 n9260 n9253 VDD VSS n9258 NAND2X1
XU9471 n9261 n9262 VDD VSS n8412 NAND2X1
XU9472 n9263 n9253 VDD VSS n9262 NAND2X1
XU9473 n9253 g1964 VDD VSS n9261 OR2X1
XU9474 n9220 n8407 VDD VSS n9253 NOR2X1
XU9475 n9264 n9265 VDD VSS n8411 NAND2X1
XU9476 n9266 n9267 VDD VSS n9265 NAND2X1
XU9477 n9268 n9254 VDD VSS n9264 NAND2X1
XU9478 n9269 n9270 VDD VSS n8410 NAND2X1
XU9479 n9266 n9271 VDD VSS n9270 NAND2X1
XU9480 n9268 n9257 VDD VSS n9269 NAND2X1
XU9481 n9272 n9273 VDD VSS n8409 NAND2X1
XU9482 n9266 n9274 VDD VSS n9273 NAND2X1
XU9483 n9268 n9260 VDD VSS n9272 NAND2X1
XU9484 n9275 n9276 VDD VSS n8408 NAND2X1
XU9485 n9268 n9263 VDD VSS n9276 NAND2X1
XU9486 n9266 n9277 VDD VSS n9275 NAND2X1
XU9487 n9268 VDD VSS n9266 INVX1
XU9488 n9229 n8407 VDD VSS n9268 NOR2X1
XU9489 n9278 n9279 VDD VSS n8406 NAND2X1
XU9490 n9280 n9229 VDD VSS n9279 NAND2X1
XU9491 g7194 n9281 VDD VSS n9278 NAND2X1
XU9492 n9282 n9283 VDD VSS n8405 NAND2X1
XU9493 g1877 g1930 VDD VSS n9283 OR2X1
XU9494 g1930 n9281 VDD VSS n9282 NAND2X1
XU9495 n9284 n9285 VDD VSS n8404 NAND2X1
XU9496 n9243 g2109 VDD VSS n9285 OR2X1
XU9497 n9243 n9286 VDD VSS n9284 NAND2X1
XU9498 n9088 VDD VSS n9243 INVX1
XU9499 g7229 g2010 VDD VSS n9088 NAND2X1
XU9500 n9287 n9288 VDD VSS n8403 NAND2X1
XU9501 n9054 g2110 VDD VSS n9288 OR2X1
XU9502 n9054 n9286 VDD VSS n9287 NAND2X1
XU9503 n9047 VDD VSS n9054 INVX1
XU9504 g7357 g2010 VDD VSS n9047 NAND2X1
XU9505 n9289 n9290 VDD VSS n8402 NAND2X1
XU9506 n9082 n9199 VDD VSS n9290 NAND2X1
XU9507 g2108 VDD VSS n9199 INVX1
XU9508 n9250 n9286 VDD VSS n9289 NAND2X1
XU9509 n9082 VDD VSS n9250 INVX1
XU9510 g2010 g2009 VDD VSS n9082 NAND2X1
XU9511 n9291 n9292 VDD VSS n8401 NAND2X1
XU9512 n9293 g1956 VDD VSS n9292 OR2X1
XU9513 n9293 n9254 VDD VSS n9291 NAND2X1
XU9514 n9294 n9295 VDD VSS n9254 NAND2X1
XU9515 g3229 n9296 VDD VSS n9295 NAND2X1
XU9516 n9297 n9298 VDD VSS n9294 NOR2X1
XU9517 g3229 n9299 VDD VSS n9298 NOR2X1
XU9518 n9300 n9301 VDD VSS n9297 NOR2X1
XU9519 n277 n9302 VDD VSS n9301 NAND2X1
XU9520 n9299 VDD VSS n9300 INVX1
XU9521 n9303 n9304 VDD VSS n8400 NAND2X1
XU9522 n9293 g1959 VDD VSS n9304 OR2X1
XU9523 n9293 n9257 VDD VSS n9303 NAND2X1
XU9524 n9299 n9305 VDD VSS n9257 NAND2X1
XU9525 n9306 n9307 VDD VSS n9305 NAND2X1
XU9526 n276 n9308 VDD VSS n9299 NAND2X1
XU9527 n9309 n9310 VDD VSS n8399 NAND2X1
XU9528 n9293 g1962 VDD VSS n9310 OR2X1
XU9529 n9293 n9260 VDD VSS n9309 NAND2X1
XU9530 n9311 n9312 VDD VSS n9260 NAND2X1
XU9531 n9313 n9306 VDD VSS n9312 NAND2X1
XU9532 n9306 n275 VDD VSS n9311 OR2X1
XU9533 n9314 n9315 VDD VSS n8398 NAND2X1
XU9534 n9293 g1965 VDD VSS n9315 OR2X1
XU9535 n9293 n9263 VDD VSS n9314 NAND2X1
XU9536 n9316 n9306 VDD VSS n9263 NOR2X1
XU9537 g3229 n273 VDD VSS n9306 XOR2X1
XU9538 n9230 n8407 VDD VSS n9293 NOR2X1
XU9539 n9317 n9318 VDD VSS n8407 AND2X1
XU9540 n9319 g1890 VDD VSS n9318 NAND2X1
XU9541 n9320 n9321 VDD VSS n9319 NOR2X1
XU9542 n8694 n9322 VDD VSS n9317 NAND2X1
XU9543 n9321 n9244 VDD VSS n9322 NAND2X1
XU9544 n9323 n9324 VDD VSS n8397 NAND2X1
XU9545 n9325 n9230 VDD VSS n9324 NAND2X1
XU9546 g7052 n9281 VDD VSS n9323 NAND2X1
XU9547 n9326 n9320 VDD VSS n9281 NAND2X1
XU9548 n9321 n9215 VDD VSS n9326 NOR2X1
XU9549 n9327 n9328 VDD VSS n9321 NAND2X1
XU9550 g1877 g1930 VDD VSS n9328 NAND2X1
XU9551 n9329 n9330 VDD VSS n9327 NOR2X1
XU9552 n9229 n9280 VDD VSS n9330 NOR2X1
XU9553 g1874 VDD VSS n9280 INVX1
XU9554 n9230 n9325 VDD VSS n9329 NOR2X1
XU9555 g1871 VDD VSS n9325 INVX1
XU9556 n9331 n9332 VDD VSS n8396 NAND2X1
XU9557 n9333 n9334 VDD VSS n9332 NAND2X1
XU9558 g1672 g3229 VDD VSS n9331 NAND2X1
XU9559 n9335 n9336 VDD VSS n8395 NAND2X1
XU9560 II18689 n9337 VDD VSS n9336 NAND2X1
XU9561 g8012 n9338 VDD VSS n9335 NAND2X1
XU9562 n9339 n9340 VDD VSS n8394 NAND2X1
XU9563 II18677 n9341 VDD VSS n9340 NAND2X1
XU9564 g8082 n9338 VDD VSS n9339 NAND2X1
XU9565 n9342 n9343 VDD VSS n8393 NAND2X1
XU9566 II18680 n9344 VDD VSS n9343 NAND2X1
XU9567 g1866 n9338 VDD VSS n9342 NAND2X1
XU9568 n9345 n9346 VDD VSS n8392 NAND2X1
XU9569 II18686 n9344 VDD VSS n9346 NAND2X1
XU9570 g1866 n9347 VDD VSS n9345 NAND2X1
XU9571 n9348 n9349 VDD VSS n8391 NAND2X1
XU9572 II18674 n9337 VDD VSS n9349 NAND2X1
XU9573 g8012 VDD VSS n9337 INVX1
XU9574 g8012 n9347 VDD VSS n9348 NAND2X1
XU9575 n9350 n9351 VDD VSS n8390 NAND2X1
XU9576 II18683 n9341 VDD VSS n9351 NAND2X1
XU9577 g8082 n9347 VDD VSS n9350 NAND2X1
XU9578 n9352 n9353 VDD VSS n8389 NAND2X1
XU9579 g1858 g8012 VDD VSS n9353 OR2X1
XU9580 g8012 n9354 VDD VSS n9352 NAND2X1
XU9581 n9355 n9356 VDD VSS n8388 NAND2X1
XU9582 g1859 g8082 VDD VSS n9356 OR2X1
XU9583 g8082 n9354 VDD VSS n9355 NAND2X1
XU9584 n9357 n9358 VDD VSS n8387 NAND2X1
XU9585 n9233 n9344 VDD VSS n9358 NAND2X1
XU9586 g1860 VDD VSS n9233 INVX1
XU9587 g1866 n9354 VDD VSS n9357 NAND2X1
XU9588 n9359 n9360 VDD VSS n8386 NAND2X1
XU9589 n9226 n9341 VDD VSS n9360 NAND2X1
XU9590 g8082 VDD VSS n9341 INVX1
XU9591 g1865 VDD VSS n9226 INVX1
XU9592 g8082 n9361 VDD VSS n9359 NAND2X1
XU9593 n9362 n9363 VDD VSS n8385 NAND2X1
XU9594 g1845 g1866 VDD VSS n9363 OR2X1
XU9595 g1866 n9361 VDD VSS n9362 NAND2X1
XU9596 n9364 n9365 VDD VSS n8384 NAND2X1
XU9597 g1861 g8012 VDD VSS n9365 OR2X1
XU9598 g8012 n9361 VDD VSS n9364 NAND2X1
XU9599 n9366 n9367 VDD VSS n8383 NAND2X1
XU9600 g1867 g8012 VDD VSS n9367 OR2X1
XU9601 g8012 n9368 VDD VSS n9366 NAND2X1
XU9602 n9369 n9370 VDD VSS n8382 NAND2X1
XU9603 g1868 g8082 VDD VSS n9370 OR2X1
XU9604 g8082 n9368 VDD VSS n9369 NAND2X1
XU9605 n9371 n9372 VDD VSS n8381 NAND2X1
XU9606 n9344 n9238 VDD VSS n9372 NAND2X1
XU9607 g1869 VDD VSS n9238 INVX1
XU9608 g1866 VDD VSS n9344 INVX1
XU9609 g1866 n9368 VDD VSS n9371 NAND2X1
XU9610 n9373 n9374 VDD VSS n8380 NAND2X1
XU9611 n9375 n9376 VDD VSS n9374 NAND2X1
XU9612 n9375 g1546 VDD VSS n9373 OR2X1
XU9613 n9377 n9378 VDD VSS n8379 NAND2X1
XU9614 n9379 n9376 VDD VSS n9378 NAND2X1
XU9615 n9380 n9381 VDD VSS n9377 NAND2X1
XU9616 n9382 n9383 VDD VSS n8378 NAND2X1
XU9617 n9375 g1543 VDD VSS n9383 OR2X1
XU9618 n9375 n9384 VDD VSS n9382 NAND2X1
XU9619 n9385 n9386 VDD VSS n8377 NAND2X1
XU9620 n9380 n9387 VDD VSS n9386 NAND2X1
XU9621 n9379 n9384 VDD VSS n9385 NAND2X1
XU9622 n9388 n9389 VDD VSS n8376 NAND2X1
XU9623 n9390 n9384 VDD VSS n9389 NAND2X1
XU9624 n9391 n9392 VDD VSS n9388 NAND2X1
XU9625 n9393 n9394 VDD VSS n8375 NAND2X1
XU9626 n9390 n9376 VDD VSS n9394 NAND2X1
XU9627 n9391 n9395 VDD VSS n9393 NAND2X1
XU9628 n9396 n9397 VDD VSS n8374 NAND2X1
XU9629 g1315 g1345 VDD VSS n9397 OR2X1
XU9630 g1315 n8694 VDD VSS n9396 NAND2X1
XU9631 n9398 n9399 VDD VSS n8373 NAND2X1
XU9632 g1326 n9400 VDD VSS n9398 XOR2X1
XU9633 n9401 n9402 VDD VSS n8372 NAND2X1
XU9634 n9403 n9404 VDD VSS n9402 NAND2X1
XU9635 g1319 VDD VSS n9404 INVX1
XU9636 n9400 g1326 VDD VSS n9403 NAND2X1
XU9637 n9405 n9406 VDD VSS n9401 NOR2X1
XU9638 n9407 n9399 VDD VSS n8371 NAND2X1
XU9639 g1339 n9405 VDD VSS n9407 XOR2X1
XU9640 n9408 n9409 VDD VSS n8370 NAND2X1
XU9641 n9410 n9411 VDD VSS n9409 NAND2X1
XU9642 n9405 g1339 VDD VSS n9410 NAND2X1
XU9643 n9412 n9406 VDD VSS n9408 NOR2X1
XU9644 n9413 n9399 VDD VSS n8369 NAND2X1
XU9645 g1346 n9412 VDD VSS n9413 XOR2X1
XU9646 n9414 n9415 VDD VSS n8368 NAND2X1
XU9647 n9416 n9417 VDD VSS n9415 NAND2X1
XU9648 n9412 g1346 VDD VSS n9416 NAND2X1
XU9649 n9418 n9406 VDD VSS n9414 NOR2X1
XU9650 n9419 n9399 VDD VSS n8367 NAND2X1
XU9651 g1352 n9418 VDD VSS n9419 XOR2X1
XU9652 n9420 n9421 VDD VSS n8366 NAND2X1
XU9653 n9422 n9423 VDD VSS n9421 NAND2X1
XU9654 g1365 VDD VSS n9423 INVX1
XU9655 n9418 g1352 VDD VSS n9422 NAND2X1
XU9656 n9424 n9399 VDD VSS n9420 AND2X1
XU9657 n9425 n9399 VDD VSS n8365 NAND2X1
XU9658 n9426 n9424 VDD VSS n9425 XOR2X1
XU9659 n9427 n9399 VDD VSS n8364 NAND2X1
XU9660 g1378 n9428 VDD VSS n9427 XOR2X1
XU9661 n9426 n9424 VDD VSS n9428 NOR2X1
XU9662 n9429 g1365 VDD VSS n9424 NAND2X1
XU9663 g1352 n9418 VDD VSS n9429 AND2X1
XU9664 n9430 g1358 VDD VSS n9418 AND2X1
XU9665 g1346 n9412 VDD VSS n9430 AND2X1
XU9666 n9431 g1332 VDD VSS n9412 AND2X1
XU9667 g1339 n9405 VDD VSS n9431 AND2X1
XU9668 n9432 g1319 VDD VSS n9405 AND2X1
XU9669 g1326 n9400 VDD VSS n9432 AND2X1
XU9670 n9433 g1345 VDD VSS n9400 NOR2X1
XU9671 g1372 VDD VSS n9426 INVX1
XU9672 n9434 n9435 VDD VSS n8363 NAND2X1
XU9673 n9436 g1423 VDD VSS n9435 OR2X1
XU9674 n9399 n9437 VDD VSS n8362 NAND2X1
XU9675 n9438 n9439 VDD VSS n9437 NAND2X1
XU9676 n9440 n9441 VDD VSS n8361 NAND2X1
XU9677 n9442 n9443 VDD VSS n9441 NAND2X1
XU9678 n9444 n9445 VDD VSS n8360 NAND2X1
XU9679 n9436 g1326 VDD VSS n9445 NAND2X1
XU9680 n9436 g1384 VDD VSS n9444 OR2X1
XU9681 n9446 n9447 VDD VSS n8359 NAND2X1
XU9682 g1378 n9436 VDD VSS n9447 NAND2X1
XU9683 n9436 g1411 VDD VSS n9446 OR2X1
XU9684 n9448 n9449 VDD VSS n8358 NAND2X1
XU9685 n9436 g1319 VDD VSS n9449 NAND2X1
XU9686 n9436 g1387 VDD VSS n9448 OR2X1
XU9687 n9450 n9451 VDD VSS n8357 NAND2X1
XU9688 n9436 g1339 VDD VSS n9451 NAND2X1
XU9689 n9436 g1390 VDD VSS n9450 OR2X1
XU9690 n9452 n9453 VDD VSS n8356 NAND2X1
XU9691 n9436 g1332 VDD VSS n9453 NAND2X1
XU9692 n9436 g1393 VDD VSS n9452 OR2X1
XU9693 n9454 n9455 VDD VSS n8355 NAND2X1
XU9694 n9436 g1346 VDD VSS n9455 NAND2X1
XU9695 n9436 g1396 VDD VSS n9454 OR2X1
XU9696 n9456 n9457 VDD VSS n8354 NAND2X1
XU9697 n9436 g1358 VDD VSS n9457 NAND2X1
XU9698 n9436 g1399 VDD VSS n9456 OR2X1
XU9699 n9458 n9459 VDD VSS n8353 NAND2X1
XU9700 n9436 g1352 VDD VSS n9459 NAND2X1
XU9701 n9436 g1402 VDD VSS n9458 OR2X1
XU9702 n9460 n9461 VDD VSS n8352 NAND2X1
XU9703 n9436 g1420 VDD VSS n9461 OR2X1
XU9704 n9436 n9462 VDD VSS n9460 NAND2X1
XU9705 n9463 n9464 VDD VSS n8351 NAND2X1
XU9706 n9436 g1365 VDD VSS n9464 NAND2X1
XU9707 n9436 g1405 VDD VSS n9463 OR2X1
XU9708 n9465 n9466 VDD VSS n8350 NAND2X1
XU9709 n9436 g1372 VDD VSS n9466 NAND2X1
XU9710 n9436 g1408 VDD VSS n9465 OR2X1
XU9711 n9467 g1315 VDD VSS n9436 AND2X1
XU9712 n9468 n9469 VDD VSS n8349 NAND2X1
XU9713 n9470 g1326 VDD VSS n9469 NAND2X1
XU9714 n9438 n9471 VDD VSS n9468 NAND2X1
XU9715 n9472 n9473 VDD VSS n8348 NAND2X1
XU9716 n9470 g1378 VDD VSS n9473 NAND2X1
XU9717 n9438 n9474 VDD VSS n9472 NAND2X1
XU9718 n9475 n9476 VDD VSS n8347 NAND2X1
XU9719 n9477 g1326 VDD VSS n9476 NAND2X1
XU9720 n9477 g1385 VDD VSS n9475 OR2X1
XU9721 n9478 n9479 VDD VSS n8346 NAND2X1
XU9722 n9470 g1319 VDD VSS n9479 NAND2X1
XU9723 n9438 n9480 VDD VSS n9478 NAND2X1
XU9724 n9481 n9482 VDD VSS n8345 NAND2X1
XU9725 n9477 g1378 VDD VSS n9482 NAND2X1
XU9726 n9477 g1412 VDD VSS n9481 OR2X1
XU9727 n9483 n9484 VDD VSS n8344 NAND2X1
XU9728 n9477 g1319 VDD VSS n9484 NAND2X1
XU9729 n9477 g1388 VDD VSS n9483 OR2X1
XU9730 n9485 n9486 VDD VSS n8343 NAND2X1
XU9731 n9470 g1339 VDD VSS n9486 NAND2X1
XU9732 n9438 n9487 VDD VSS n9485 NAND2X1
XU9733 n9488 n9489 VDD VSS n8342 NAND2X1
XU9734 n9477 g1339 VDD VSS n9489 NAND2X1
XU9735 n9477 g1391 VDD VSS n9488 OR2X1
XU9736 n9490 n9491 VDD VSS n8341 NAND2X1
XU9737 n9470 g1332 VDD VSS n9491 NAND2X1
XU9738 n9438 n9492 VDD VSS n9490 NAND2X1
XU9739 n9493 n9494 VDD VSS n8340 NAND2X1
XU9740 n9477 g1332 VDD VSS n9494 NAND2X1
XU9741 n9477 g1394 VDD VSS n9493 OR2X1
XU9742 n9495 n9496 VDD VSS n8339 NAND2X1
XU9743 n9470 g1346 VDD VSS n9496 NAND2X1
XU9744 n9438 n9497 VDD VSS n9495 NAND2X1
XU9745 n9498 n9499 VDD VSS n8338 NAND2X1
XU9746 n9477 g1346 VDD VSS n9499 NAND2X1
XU9747 n9477 g1397 VDD VSS n9498 OR2X1
XU9748 n9500 n9501 VDD VSS n8337 NAND2X1
XU9749 n9470 g1358 VDD VSS n9501 NAND2X1
XU9750 n9438 n9502 VDD VSS n9500 NAND2X1
XU9751 n9503 n9504 VDD VSS n8336 NAND2X1
XU9752 n9477 g1358 VDD VSS n9504 NAND2X1
XU9753 n9477 g1400 VDD VSS n9503 OR2X1
XU9754 n9505 n9506 VDD VSS n8335 NAND2X1
XU9755 n9470 g1352 VDD VSS n9506 NAND2X1
XU9756 n9438 n9507 VDD VSS n9505 NAND2X1
XU9757 n9508 n9509 VDD VSS n8334 NAND2X1
XU9758 n9470 g1422 VDD VSS n9509 OR2X1
XU9759 n9470 n9462 VDD VSS n9508 NAND2X1
XU9760 n9510 n9511 VDD VSS n8333 NAND2X1
XU9761 n9477 g1352 VDD VSS n9511 NAND2X1
XU9762 n9477 g1403 VDD VSS n9510 OR2X1
XU9763 n9512 n9513 VDD VSS n8332 NAND2X1
XU9764 n9470 g1365 VDD VSS n9513 NAND2X1
XU9765 n9438 n9514 VDD VSS n9512 NAND2X1
XU9766 n9515 n9516 VDD VSS n8331 NAND2X1
XU9767 n9477 g1421 VDD VSS n9516 OR2X1
XU9768 n9477 n9462 VDD VSS n9515 NAND2X1
XU9769 n9517 n9518 VDD VSS n9462 NAND2X1
XU9770 n9519 n9520 VDD VSS n9518 NOR2X1
XU9771 n9521 n9522 VDD VSS n9520 NAND2X1
XU9772 n9523 n9524 VDD VSS n9522 NAND2X1
XU9773 n9525 n9526 VDD VSS n9524 NOR2X1
XU9774 n9527 n9528 VDD VSS n9526 NAND2X1
XU9775 g1339 n9529 VDD VSS n9528 XOR2X1
XU9776 g1319 n9530 VDD VSS n9527 XOR2X1
XU9777 n9531 n9532 VDD VSS n9525 NAND2X1
XU9778 g1346 n9533 VDD VSS n9532 XOR2X1
XU9779 n9534 n9535 VDD VSS n9531 NOR2X1
XU9780 n9411 n9536 VDD VSS n9535 XOR2X1
XU9781 g1332 VDD VSS n9411 INVX1
XU9782 g1326 n9537 VDD VSS n9534 XOR2X1
XU9783 n9538 n9539 VDD VSS n9523 NOR2X1
XU9784 n9540 n9541 VDD VSS n9539 NAND2X1
XU9785 g1365 n9542 VDD VSS n9541 XOR2X1
XU9786 g1352 n9543 VDD VSS n9540 XOR2X1
XU9787 n9544 n9545 VDD VSS n9538 NAND2X1
XU9788 g1372 n9546 VDD VSS n9545 XOR2X1
XU9789 n9547 n9548 VDD VSS n9544 NOR2X1
XU9790 g1378 n9549 VDD VSS n9548 XOR2X1
XU9791 n9417 n9550 VDD VSS n9547 XOR2X1
XU9792 g1358 VDD VSS n9417 INVX1
XU9793 g1315 n9551 VDD VSS n9521 NAND2X1
XU9794 g1415 n9552 VDD VSS n9519 NOR2X1
XU9795 n9553 n9554 VDD VSS n9517 NOR2X1
XU9796 g1416 n9555 VDD VSS n9553 NOR2X1
XU9797 n9556 n9557 VDD VSS n8330 NAND2X1
XU9798 n9477 g1365 VDD VSS n9557 NAND2X1
XU9799 n9477 g1406 VDD VSS n9556 OR2X1
XU9800 n9558 n9559 VDD VSS n8329 NAND2X1
XU9801 n9470 g1372 VDD VSS n9559 NAND2X1
XU9802 n9438 VDD VSS n9470 INVX1
XU9803 n9438 n9560 VDD VSS n9558 NAND2X1
XU9804 n9467 g7161 VDD VSS n9438 NAND2X1
XU9805 n9561 n9562 VDD VSS n8328 NAND2X1
XU9806 n9477 g1372 VDD VSS n9562 NAND2X1
XU9807 n9477 g1409 VDD VSS n9561 OR2X1
XU9808 n9442 VDD VSS n9477 INVX1
XU9809 g6979 n9467 VDD VSS n9442 NAND2X1
XU9810 n9563 g1224 VDD VSS n9467 AND2X1
XU9811 g1345 n9564 VDD VSS n9563 NOR2X1
XU9812 n9565 n9566 VDD VSS n8327 NAND2X1
XU9813 g1315 g1316 VDD VSS n9566 OR2X1
XU9814 g1315 n9567 VDD VSS n9565 NAND2X1
XU9815 n9568 n9569 VDD VSS n8326 NAND2X1
XU9816 g1236 g1240 VDD VSS n9569 OR2X1
XU9817 g1236 n8867 VDD VSS n9568 NAND2X1
XU9818 n9570 n9571 VDD VSS n8325 NAND2X1
XU9819 g1240 g1236 VDD VSS n9571 NAND2X1
XU9820 n9572 n9573 VDD VSS n9570 NAND2X1
XU9821 n9574 n9575 VDD VSS n8324 NAND2X1
XU9822 g1236 n9573 VDD VSS n9575 NAND2X1
XU9823 n9567 n9572 VDD VSS n9574 NAND2X1
XU9824 n9576 n9577 VDD VSS n8323 NAND2X1
XU9825 g1236 n9578 VDD VSS n9577 NAND2X1
XU9826 n9579 n9580 VDD VSS n9576 NOR2X1
XU9827 g1167 n9581 VDD VSS n9580 NOR2X1
XU9828 g1151 n9582 VDD VSS n9579 NOR2X1
XU9829 n9583 n9584 VDD VSS n8322 NAND2X1
XU9830 g6750 n9585 VDD VSS n9584 NAND2X1
XU9831 n9586 n9587 VDD VSS n9583 NOR2X1
XU9832 g1165 n9572 VDD VSS n9587 NOR2X1
XU9833 g1164 n9581 VDD VSS n9586 NOR2X1
XU9834 n9588 n9589 VDD VSS n8321 NAND2X1
XU9835 g6750 n9590 VDD VSS n9589 NAND2X1
XU9836 n9591 n9592 VDD VSS n9588 NOR2X1
XU9837 g1174 n9572 VDD VSS n9592 NOR2X1
XU9838 g1173 n9581 VDD VSS n9591 NOR2X1
XU9839 n9593 n9594 VDD VSS n8318 NAND2X1
XU9840 n9595 g1418 VDD VSS n9594 OR2X1
XU9841 n9595 n9596 VDD VSS n9593 NAND2X1
XU9842 n9597 n9598 VDD VSS n8317 NAND2X1
XU9843 n9399 n9599 VDD VSS n9598 NAND2X1
XU9844 n9406 n9596 VDD VSS n9597 NAND2X1
XU9845 n9600 n9601 VDD VSS n8316 NAND2X1
XU9846 n9602 g1417 VDD VSS n9601 OR2X1
XU9847 n9602 n9596 VDD VSS n9600 NAND2X1
XU9848 n9603 n9604 VDD VSS n8315 NAND2X1
XU9849 n9605 g1261 VDD VSS n9604 OR2X1
XU9850 n9605 n9606 VDD VSS n9603 NAND2X1
XU9851 n9607 n9608 VDD VSS n8314 NAND2X1
XU9852 n9605 g1264 VDD VSS n9608 OR2X1
XU9853 n9605 n9609 VDD VSS n9607 NAND2X1
XU9854 n9610 n9611 VDD VSS n8313 NAND2X1
XU9855 n9605 g1267 VDD VSS n9611 OR2X1
XU9856 n9612 n9605 VDD VSS n9610 NAND2X1
XU9857 n9613 n9614 VDD VSS n8312 NAND2X1
XU9858 n9615 n9605 VDD VSS n9614 NAND2X1
XU9859 n9605 g1270 VDD VSS n9613 OR2X1
XU9860 n9572 n8307 VDD VSS n9605 NOR2X1
XU9861 n9616 n9617 VDD VSS n8311 NAND2X1
XU9862 n9618 n9619 VDD VSS n9617 NAND2X1
XU9863 n9620 n9606 VDD VSS n9616 NAND2X1
XU9864 n9621 n9622 VDD VSS n8310 NAND2X1
XU9865 n9618 n9623 VDD VSS n9622 NAND2X1
XU9866 n9620 n9609 VDD VSS n9621 NAND2X1
XU9867 n9624 n9625 VDD VSS n8309 NAND2X1
XU9868 n9618 n9626 VDD VSS n9625 NAND2X1
XU9869 n9620 n9612 VDD VSS n9624 NAND2X1
XU9870 n9627 n9628 VDD VSS n8308 NAND2X1
XU9871 n9620 n9615 VDD VSS n9628 NAND2X1
XU9872 n9618 n9629 VDD VSS n9627 NAND2X1
XU9873 n9620 VDD VSS n9618 INVX1
XU9874 n9581 n8307 VDD VSS n9620 NOR2X1
XU9875 n9630 n9631 VDD VSS n8306 NAND2X1
XU9876 n9632 n9581 VDD VSS n9631 NAND2X1
XU9877 g6944 n9633 VDD VSS n9630 NAND2X1
XU9878 n9634 n9635 VDD VSS n8305 NAND2X1
XU9879 g1183 g1236 VDD VSS n9635 OR2X1
XU9880 g1236 n9633 VDD VSS n9634 NAND2X1
XU9881 n9636 n9637 VDD VSS n8304 NAND2X1
XU9882 n9595 g1415 VDD VSS n9637 OR2X1
XU9883 n9595 n9638 VDD VSS n9636 NAND2X1
XU9884 n9440 VDD VSS n9595 INVX1
XU9885 g6979 g1316 VDD VSS n9440 NAND2X1
XU9886 n9639 n9640 VDD VSS n8303 NAND2X1
XU9887 n9406 g1416 VDD VSS n9640 OR2X1
XU9888 n9406 n9638 VDD VSS n9639 NAND2X1
XU9889 n9399 VDD VSS n9406 INVX1
XU9890 g7161 g1316 VDD VSS n9399 NAND2X1
XU9891 n9641 n9642 VDD VSS n8302 NAND2X1
XU9892 n9434 n9551 VDD VSS n9642 NAND2X1
XU9893 g1414 VDD VSS n9551 INVX1
XU9894 n9602 n9638 VDD VSS n9641 NAND2X1
XU9895 n9434 VDD VSS n9602 INVX1
XU9896 g1316 g1315 VDD VSS n9434 NAND2X1
XU9897 n9643 n9644 VDD VSS n8301 NAND2X1
XU9898 n9645 g1262 VDD VSS n9644 OR2X1
XU9899 n9645 n9606 VDD VSS n9643 NAND2X1
XU9900 n9646 n9647 VDD VSS n9606 NAND2X1
XU9901 g3229 n9648 VDD VSS n9647 NAND2X1
XU9902 n9649 n9650 VDD VSS n9646 NOR2X1
XU9903 g3229 n9651 VDD VSS n9650 NOR2X1
XU9904 n9652 n9653 VDD VSS n9649 NOR2X1
XU9905 n219 n9654 VDD VSS n9653 NAND2X1
XU9906 n9651 VDD VSS n9652 INVX1
XU9907 n9655 n9656 VDD VSS n8300 NAND2X1
XU9908 n9645 g1265 VDD VSS n9656 OR2X1
XU9909 n9645 n9609 VDD VSS n9655 NAND2X1
XU9910 n9651 n9657 VDD VSS n9609 NAND2X1
XU9911 n9658 n9659 VDD VSS n9657 NAND2X1
XU9912 n218 n9660 VDD VSS n9651 NAND2X1
XU9913 n9661 n9662 VDD VSS n8299 NAND2X1
XU9914 n9645 g1268 VDD VSS n9662 OR2X1
XU9915 n9645 n9612 VDD VSS n9661 NAND2X1
XU9916 n9663 n9664 VDD VSS n9612 NAND2X1
XU9917 n9665 n9658 VDD VSS n9664 NAND2X1
XU9918 n9658 n217 VDD VSS n9663 OR2X1
XU9919 n9666 n9667 VDD VSS n8298 NAND2X1
XU9920 n9645 g1271 VDD VSS n9667 OR2X1
XU9921 n9645 n9615 VDD VSS n9666 NAND2X1
XU9922 n9668 n9658 VDD VSS n9615 NOR2X1
XU9923 g3229 n215 VDD VSS n9658 XOR2X1
XU9924 n9582 n8307 VDD VSS n9645 NOR2X1
XU9925 n9669 n9670 VDD VSS n8307 AND2X1
XU9926 n9671 g1196 VDD VSS n9670 NAND2X1
XU9927 n9672 n9673 VDD VSS n9671 NOR2X1
XU9928 n8694 n9674 VDD VSS n9669 NAND2X1
XU9929 n9673 n9596 VDD VSS n9674 NAND2X1
XU9930 n9675 n9676 VDD VSS n8297 NAND2X1
XU9931 n9677 n9582 VDD VSS n9676 NAND2X1
XU9932 g6750 n9633 VDD VSS n9675 NAND2X1
XU9933 n9678 n9672 VDD VSS n9633 NAND2X1
XU9934 n9673 n9567 VDD VSS n9678 NOR2X1
XU9935 n9679 n9680 VDD VSS n9673 NAND2X1
XU9936 g1183 g1236 VDD VSS n9680 NAND2X1
XU9937 n9681 n9682 VDD VSS n9679 NOR2X1
XU9938 n9581 n9632 VDD VSS n9682 NOR2X1
XU9939 g1180 VDD VSS n9632 INVX1
XU9940 n9582 n9677 VDD VSS n9681 NOR2X1
XU9941 g1177 VDD VSS n9677 INVX1
XU9942 n9683 n9684 VDD VSS n8296 NAND2X1
XU9943 g978 g3229 VDD VSS n9684 NAND2X1
XU9944 n9334 n9685 VDD VSS n9683 NAND2X1
XU9945 n9686 n9687 VDD VSS n8295 NAND2X1
XU9946 II18608 n9688 VDD VSS n9687 NAND2X1
XU9947 g7961 n9689 VDD VSS n9686 NAND2X1
XU9948 n9690 n9691 VDD VSS n8294 NAND2X1
XU9949 II18596 n9692 VDD VSS n9691 NAND2X1
XU9950 g8007 n9689 VDD VSS n9690 NAND2X1
XU9951 n9693 n9694 VDD VSS n8293 NAND2X1
XU9952 II18599 n9695 VDD VSS n9694 NAND2X1
XU9953 g1172 n9689 VDD VSS n9693 NAND2X1
XU9954 n9696 n9697 VDD VSS n8292 NAND2X1
XU9955 II18605 n9695 VDD VSS n9697 NAND2X1
XU9956 g1172 n9698 VDD VSS n9696 NAND2X1
XU9957 n9699 n9700 VDD VSS n8291 NAND2X1
XU9958 II18593 n9688 VDD VSS n9700 NAND2X1
XU9959 g7961 VDD VSS n9688 INVX1
XU9960 g7961 n9698 VDD VSS n9699 NAND2X1
XU9961 n9701 n9702 VDD VSS n8290 NAND2X1
XU9962 II18602 n9692 VDD VSS n9702 NAND2X1
XU9963 g8007 n9698 VDD VSS n9701 NAND2X1
XU9964 n9703 n9704 VDD VSS n8289 NAND2X1
XU9965 g1164 g7961 VDD VSS n9704 OR2X1
XU9966 g7961 n9705 VDD VSS n9703 NAND2X1
XU9967 n9706 n9707 VDD VSS n8288 NAND2X1
XU9968 g1165 g8007 VDD VSS n9707 OR2X1
XU9969 g8007 n9705 VDD VSS n9706 NAND2X1
XU9970 n9708 n9709 VDD VSS n8287 NAND2X1
XU9971 n9585 n9695 VDD VSS n9709 NAND2X1
XU9972 g1166 VDD VSS n9585 INVX1
XU9973 g1172 n9705 VDD VSS n9708 NAND2X1
XU9974 n9710 n9711 VDD VSS n8286 NAND2X1
XU9975 n9578 n9692 VDD VSS n9711 NAND2X1
XU9976 g8007 VDD VSS n9692 INVX1
XU9977 g1171 VDD VSS n9578 INVX1
XU9978 g8007 n9712 VDD VSS n9710 NAND2X1
XU9979 n9713 n9714 VDD VSS n8285 NAND2X1
XU9980 g1151 g1172 VDD VSS n9714 OR2X1
XU9981 g1172 n9712 VDD VSS n9713 NAND2X1
XU9982 n9715 n9716 VDD VSS n8284 NAND2X1
XU9983 g1167 g7961 VDD VSS n9716 OR2X1
XU9984 g7961 n9712 VDD VSS n9715 NAND2X1
XU9985 n9717 n9718 VDD VSS n8283 NAND2X1
XU9986 g1173 g7961 VDD VSS n9718 OR2X1
XU9987 g7961 n9719 VDD VSS n9717 NAND2X1
XU9988 n9720 n9721 VDD VSS n8282 NAND2X1
XU9989 g1174 g8007 VDD VSS n9721 OR2X1
XU9990 g8007 n9719 VDD VSS n9720 NAND2X1
XU9991 n9722 n9723 VDD VSS n8281 NAND2X1
XU9992 n9695 n9590 VDD VSS n9723 NAND2X1
XU9993 g1175 VDD VSS n9590 INVX1
XU9994 g1172 VDD VSS n9695 INVX1
XU9995 g1172 n9719 VDD VSS n9722 NAND2X1
XU9996 n9724 n9725 VDD VSS n8280 NAND2X1
XU9997 n9726 n9727 VDD VSS n9725 NAND2X1
XU9998 n9728 n9729 VDD VSS n9724 NAND2X1
XU9999 n9730 n9731 VDD VSS n8279 NAND2X1
XU10000 n9732 n9727 VDD VSS n9731 NAND2X1
XU10001 n9732 g850 VDD VSS n9730 OR2X1
XU10002 n9733 n9734 VDD VSS n8278 NAND2X1
XU10003 n9728 n9735 VDD VSS n9734 NAND2X1
XU10004 n9726 n9736 VDD VSS n9733 NAND2X1
XU10005 n9737 n9738 VDD VSS n8277 NAND2X1
XU10006 n9732 g847 VDD VSS n9738 OR2X1
XU10007 n9732 n9736 VDD VSS n9737 NAND2X1
XU10008 n9739 n9740 VDD VSS n8276 NAND2X1
XU10009 n9741 n9736 VDD VSS n9740 NAND2X1
XU10010 n9742 n9743 VDD VSS n9739 NAND2X1
XU10011 n9744 n9745 VDD VSS n8275 NAND2X1
XU10012 n9741 n9727 VDD VSS n9745 NAND2X1
XU10013 n9742 n9746 VDD VSS n9744 NAND2X1
XU10014 n9747 n9748 VDD VSS n8274 NAND2X1
XU10015 g629 g659 VDD VSS n9748 OR2X1
XU10016 g629 n8694 VDD VSS n9747 NAND2X1
XU10017 n9749 n9750 VDD VSS n8273 NAND2X1
XU10018 g640 n9751 VDD VSS n9749 XOR2X1
XU10019 n9752 n9753 VDD VSS n8272 NAND2X1
XU10020 n9754 n9755 VDD VSS n9753 NAND2X1
XU10021 g633 VDD VSS n9755 INVX1
XU10022 n9751 g640 VDD VSS n9754 NAND2X1
XU10023 n9756 n9757 VDD VSS n9752 NOR2X1
XU10024 n9758 n9750 VDD VSS n8271 NAND2X1
XU10025 g653 n9756 VDD VSS n9758 XOR2X1
XU10026 n9759 n9760 VDD VSS n8270 NAND2X1
XU10027 n9761 n9762 VDD VSS n9760 NAND2X1
XU10028 n9756 g653 VDD VSS n9761 NAND2X1
XU10029 n9763 n9757 VDD VSS n9759 NOR2X1
XU10030 n9764 n9750 VDD VSS n8269 NAND2X1
XU10031 g660 n9763 VDD VSS n9764 XOR2X1
XU10032 n9765 n9766 VDD VSS n8268 NAND2X1
XU10033 n9767 n9768 VDD VSS n9766 NAND2X1
XU10034 n9763 g660 VDD VSS n9767 NAND2X1
XU10035 n9769 n9757 VDD VSS n9765 NOR2X1
XU10036 n9770 n9750 VDD VSS n8267 NAND2X1
XU10037 g666 n9769 VDD VSS n9770 XOR2X1
XU10038 n9771 n9772 VDD VSS n8266 NAND2X1
XU10039 n9773 n9774 VDD VSS n9772 NAND2X1
XU10040 g679 VDD VSS n9774 INVX1
XU10041 n9769 g666 VDD VSS n9773 NAND2X1
XU10042 n9775 n9750 VDD VSS n9771 AND2X1
XU10043 n9776 n9750 VDD VSS n8265 NAND2X1
XU10044 n9777 n9775 VDD VSS n9776 XOR2X1
XU10045 n9778 n9750 VDD VSS n8264 NAND2X1
XU10046 g692 n9779 VDD VSS n9778 XOR2X1
XU10047 n9777 n9775 VDD VSS n9779 NOR2X1
XU10048 n9780 g679 VDD VSS n9775 NAND2X1
XU10049 g666 n9769 VDD VSS n9780 AND2X1
XU10050 n9781 g672 VDD VSS n9769 AND2X1
XU10051 g660 n9763 VDD VSS n9781 AND2X1
XU10052 n9782 g646 VDD VSS n9763 AND2X1
XU10053 g653 n9756 VDD VSS n9782 AND2X1
XU10054 n9783 g633 VDD VSS n9756 AND2X1
XU10055 g640 n9751 VDD VSS n9783 AND2X1
XU10056 n9784 g659 VDD VSS n9751 NOR2X1
XU10057 g686 VDD VSS n9777 INVX1
XU10058 n9785 n9786 VDD VSS n8263 NAND2X1
XU10059 n9787 g737 VDD VSS n9786 OR2X1
XU10060 n9750 n9788 VDD VSS n8262 NAND2X1
XU10061 n9789 n9790 VDD VSS n9788 NAND2X1
XU10062 n9791 n9792 VDD VSS n8261 NAND2X1
XU10063 n9793 n9794 VDD VSS n9792 NAND2X1
XU10064 n9795 n9796 VDD VSS n8260 NAND2X1
XU10065 n9787 g640 VDD VSS n9796 NAND2X1
XU10066 n9787 g698 VDD VSS n9795 OR2X1
XU10067 n9797 n9798 VDD VSS n8259 NAND2X1
XU10068 g692 n9787 VDD VSS n9798 NAND2X1
XU10069 n9787 g725 VDD VSS n9797 OR2X1
XU10070 n9799 n9800 VDD VSS n8258 NAND2X1
XU10071 n9787 g633 VDD VSS n9800 NAND2X1
XU10072 n9787 g701 VDD VSS n9799 OR2X1
XU10073 n9801 n9802 VDD VSS n8257 NAND2X1
XU10074 n9787 g653 VDD VSS n9802 NAND2X1
XU10075 n9787 g704 VDD VSS n9801 OR2X1
XU10076 n9803 n9804 VDD VSS n8256 NAND2X1
XU10077 n9787 g646 VDD VSS n9804 NAND2X1
XU10078 n9787 g707 VDD VSS n9803 OR2X1
XU10079 n9805 n9806 VDD VSS n8255 NAND2X1
XU10080 n9787 g660 VDD VSS n9806 NAND2X1
XU10081 n9787 g710 VDD VSS n9805 OR2X1
XU10082 n9807 n9808 VDD VSS n8254 NAND2X1
XU10083 n9787 g672 VDD VSS n9808 NAND2X1
XU10084 n9787 g713 VDD VSS n9807 OR2X1
XU10085 n9809 n9810 VDD VSS n8253 NAND2X1
XU10086 n9787 g666 VDD VSS n9810 NAND2X1
XU10087 n9787 g716 VDD VSS n9809 OR2X1
XU10088 n9811 n9812 VDD VSS n8252 NAND2X1
XU10089 n9787 g734 VDD VSS n9812 OR2X1
XU10090 n9787 n9813 VDD VSS n9811 NAND2X1
XU10091 n9814 n9815 VDD VSS n8251 NAND2X1
XU10092 n9787 g679 VDD VSS n9815 NAND2X1
XU10093 n9787 g719 VDD VSS n9814 OR2X1
XU10094 n9816 n9817 VDD VSS n8250 NAND2X1
XU10095 n9787 g686 VDD VSS n9817 NAND2X1
XU10096 n9787 g722 VDD VSS n9816 OR2X1
XU10097 n9818 g629 VDD VSS n9787 AND2X1
XU10098 n9819 n9820 VDD VSS n8249 NAND2X1
XU10099 n9821 g640 VDD VSS n9820 NAND2X1
XU10100 n9789 n9822 VDD VSS n9819 NAND2X1
XU10101 n9823 n9824 VDD VSS n8248 NAND2X1
XU10102 n9821 g692 VDD VSS n9824 NAND2X1
XU10103 n9789 n9825 VDD VSS n9823 NAND2X1
XU10104 n9826 n9827 VDD VSS n8247 NAND2X1
XU10105 n9828 g640 VDD VSS n9827 NAND2X1
XU10106 n9828 g699 VDD VSS n9826 OR2X1
XU10107 n9829 n9830 VDD VSS n8246 NAND2X1
XU10108 n9821 g633 VDD VSS n9830 NAND2X1
XU10109 n9789 n9831 VDD VSS n9829 NAND2X1
XU10110 n9832 n9833 VDD VSS n8245 NAND2X1
XU10111 n9828 g692 VDD VSS n9833 NAND2X1
XU10112 n9828 g726 VDD VSS n9832 OR2X1
XU10113 n9834 n9835 VDD VSS n8244 NAND2X1
XU10114 n9828 g633 VDD VSS n9835 NAND2X1
XU10115 n9828 g702 VDD VSS n9834 OR2X1
XU10116 n9836 n9837 VDD VSS n8243 NAND2X1
XU10117 n9821 g653 VDD VSS n9837 NAND2X1
XU10118 n9789 n9838 VDD VSS n9836 NAND2X1
XU10119 n9839 n9840 VDD VSS n8242 NAND2X1
XU10120 n9828 g653 VDD VSS n9840 NAND2X1
XU10121 n9828 g705 VDD VSS n9839 OR2X1
XU10122 n9841 n9842 VDD VSS n8241 NAND2X1
XU10123 n9821 g646 VDD VSS n9842 NAND2X1
XU10124 n9789 n9843 VDD VSS n9841 NAND2X1
XU10125 n9844 n9845 VDD VSS n8240 NAND2X1
XU10126 n9828 g646 VDD VSS n9845 NAND2X1
XU10127 n9828 g708 VDD VSS n9844 OR2X1
XU10128 n9846 n9847 VDD VSS n8239 NAND2X1
XU10129 n9821 g660 VDD VSS n9847 NAND2X1
XU10130 n9789 n9848 VDD VSS n9846 NAND2X1
XU10131 n9849 n9850 VDD VSS n8238 NAND2X1
XU10132 n9828 g660 VDD VSS n9850 NAND2X1
XU10133 n9828 g711 VDD VSS n9849 OR2X1
XU10134 n9851 n9852 VDD VSS n8237 NAND2X1
XU10135 n9821 g672 VDD VSS n9852 NAND2X1
XU10136 n9789 n9853 VDD VSS n9851 NAND2X1
XU10137 n9854 n9855 VDD VSS n8236 NAND2X1
XU10138 n9828 g672 VDD VSS n9855 NAND2X1
XU10139 n9828 g714 VDD VSS n9854 OR2X1
XU10140 n9856 n9857 VDD VSS n8235 NAND2X1
XU10141 n9821 g666 VDD VSS n9857 NAND2X1
XU10142 n9789 n9858 VDD VSS n9856 NAND2X1
XU10143 n9859 n9860 VDD VSS n8234 NAND2X1
XU10144 n9821 g736 VDD VSS n9860 OR2X1
XU10145 n9821 n9813 VDD VSS n9859 NAND2X1
XU10146 n9861 n9862 VDD VSS n8233 NAND2X1
XU10147 n9828 g666 VDD VSS n9862 NAND2X1
XU10148 n9828 g717 VDD VSS n9861 OR2X1
XU10149 n9863 n9864 VDD VSS n8232 NAND2X1
XU10150 n9821 g679 VDD VSS n9864 NAND2X1
XU10151 n9789 n9865 VDD VSS n9863 NAND2X1
XU10152 n9866 n9867 VDD VSS n8231 NAND2X1
XU10153 n9828 g735 VDD VSS n9867 OR2X1
XU10154 n9828 n9813 VDD VSS n9866 NAND2X1
XU10155 n9868 n9869 VDD VSS n9813 NAND2X1
XU10156 n9870 n9871 VDD VSS n9869 NOR2X1
XU10157 n9872 n9873 VDD VSS n9871 NAND2X1
XU10158 n9874 n9875 VDD VSS n9873 NAND2X1
XU10159 n9876 n9877 VDD VSS n9875 NOR2X1
XU10160 n9878 n9879 VDD VSS n9877 NAND2X1
XU10161 g653 n9880 VDD VSS n9879 XOR2X1
XU10162 g633 n9881 VDD VSS n9878 XOR2X1
XU10163 n9882 n9883 VDD VSS n9876 NAND2X1
XU10164 g660 n9884 VDD VSS n9883 XOR2X1
XU10165 n9885 n9886 VDD VSS n9882 NOR2X1
XU10166 n9762 n9887 VDD VSS n9886 XOR2X1
XU10167 g646 VDD VSS n9762 INVX1
XU10168 g640 n9888 VDD VSS n9885 XOR2X1
XU10169 n9889 n9890 VDD VSS n9874 NOR2X1
XU10170 n9891 n9892 VDD VSS n9890 NAND2X1
XU10171 g679 n9893 VDD VSS n9892 XOR2X1
XU10172 g666 n9894 VDD VSS n9891 XOR2X1
XU10173 n9895 n9896 VDD VSS n9889 NAND2X1
XU10174 g686 n9897 VDD VSS n9896 XOR2X1
XU10175 n9898 n9899 VDD VSS n9895 NOR2X1
XU10176 g692 n9900 VDD VSS n9899 XOR2X1
XU10177 n9768 n9901 VDD VSS n9898 XOR2X1
XU10178 g672 VDD VSS n9768 INVX1
XU10179 g629 n9902 VDD VSS n9872 NAND2X1
XU10180 g729 n9903 VDD VSS n9870 NOR2X1
XU10181 n9904 n9905 VDD VSS n9868 NOR2X1
XU10182 g730 n9906 VDD VSS n9904 NOR2X1
XU10183 n9907 n9908 VDD VSS n8230 NAND2X1
XU10184 n9828 g679 VDD VSS n9908 NAND2X1
XU10185 n9828 g720 VDD VSS n9907 OR2X1
XU10186 n9909 n9910 VDD VSS n8229 NAND2X1
XU10187 n9821 g686 VDD VSS n9910 NAND2X1
XU10188 n9789 VDD VSS n9821 INVX1
XU10189 n9789 n9911 VDD VSS n9909 NAND2X1
XU10190 n9818 g6911 VDD VSS n9789 NAND2X1
XU10191 n9912 n9913 VDD VSS n8228 NAND2X1
XU10192 n9828 g686 VDD VSS n9913 NAND2X1
XU10193 n9828 g723 VDD VSS n9912 OR2X1
XU10194 n9793 VDD VSS n9828 INVX1
XU10195 g6677 n9818 VDD VSS n9793 NAND2X1
XU10196 n9914 g538 VDD VSS n9818 AND2X1
XU10197 g659 n9915 VDD VSS n9914 NOR2X1
XU10198 n9916 n9917 VDD VSS n8227 NAND2X1
XU10199 g629 g630 VDD VSS n9917 OR2X1
XU10200 g629 n9918 VDD VSS n9916 NAND2X1
XU10201 n9919 n9920 VDD VSS n8226 NAND2X1
XU10202 g550 g554 VDD VSS n9920 OR2X1
XU10203 g550 n8867 VDD VSS n9919 NAND2X1
XU10204 n9921 n9922 VDD VSS n8225 NAND2X1
XU10205 g554 g550 VDD VSS n9922 NAND2X1
XU10206 n9923 n9924 VDD VSS n9921 NAND2X1
XU10207 n9925 n9926 VDD VSS n8224 NAND2X1
XU10208 g550 n9924 VDD VSS n9926 NAND2X1
XU10209 n9918 n9923 VDD VSS n9925 NAND2X1
XU10210 n9927 n9928 VDD VSS n8223 NAND2X1
XU10211 g2589 n9929 VDD VSS n9928 OR2X1
XU10212 n9930 n9931 VDD VSS n9927 NOR2X1
XU10213 n9932 n9933 VDD VSS n9931 NOR2X1
XU10214 n8222 VDD VSS n9932 INVX1
XU10215 g2590 n9934 VDD VSS n9930 NOR2X1
XU10216 n9935 n9936 VDD VSS n8222 NAND2X1
XU10217 g1895 n9937 VDD VSS n9936 OR2X1
XU10218 n9938 n9939 VDD VSS n9935 NOR2X1
XU10219 n9940 n9941 VDD VSS n9939 NOR2X1
XU10220 g1896 n9942 VDD VSS n9938 NOR2X1
XU10221 n9940 VDD VSS n8221 INVX1
XU10222 n9943 n9944 VDD VSS n9940 NOR2X1
XU10223 g1192 n9945 VDD VSS n9944 NOR2X1
XU10224 n9946 n9947 VDD VSS n9945 NOR2X1
XU10225 n9581 n9948 VDD VSS n9947 NOR2X1
XU10226 g6944 g1202 VDD VSS n9946 NOR2X1
XU10227 g1201 n9949 VDD VSS n9943 NOR2X1
XU10228 n9948 VDD VSS n8220 INVX1
XU10229 n9950 n9951 VDD VSS n9948 NAND2X1
XU10230 g515 g506 VDD VSS n9951 NAND2X1
XU10231 g516 n9952 VDD VSS n9950 NAND2X1
XU10232 n9953 n9954 VDD VSS n8219 NAND2X1
XU10233 g2588 n9929 VDD VSS n9954 OR2X1
XU10234 n9955 n9956 VDD VSS n9953 NOR2X1
XU10235 n9957 n9933 VDD VSS n9956 NOR2X1
XU10236 n8218 VDD VSS n9957 INVX1
XU10237 g2591 n9934 VDD VSS n9955 NOR2X1
XU10238 n9958 n9959 VDD VSS n8218 NAND2X1
XU10239 g1894 n9937 VDD VSS n9959 OR2X1
XU10240 n9960 n9961 VDD VSS n9958 NOR2X1
XU10241 n9962 n9941 VDD VSS n9961 NOR2X1
XU10242 g1897 n9942 VDD VSS n9960 NOR2X1
XU10243 n9962 VDD VSS n8217 INVX1
XU10244 n9963 n9964 VDD VSS n9962 NOR2X1
XU10245 g1192 n9965 VDD VSS n9964 NOR2X1
XU10246 n9966 n9967 VDD VSS n9965 NOR2X1
XU10247 n9581 n9968 VDD VSS n9967 NOR2X1
XU10248 g6944 g1203 VDD VSS n9966 NOR2X1
XU10249 g1200 n9949 VDD VSS n9963 NOR2X1
XU10250 n9968 VDD VSS n8216 INVX1
XU10251 n9969 n9970 VDD VSS n9968 NAND2X1
XU10252 g514 g506 VDD VSS n9970 NAND2X1
XU10253 g517 n9952 VDD VSS n9969 NAND2X1
XU10254 n9971 n9972 VDD VSS n8215 NAND2X1
XU10255 g2583 n9929 VDD VSS n9972 OR2X1
XU10256 n9973 n9974 VDD VSS n9971 NOR2X1
XU10257 n9975 n9933 VDD VSS n9974 NOR2X1
XU10258 n8214 VDD VSS n9975 INVX1
XU10259 g2592 n9934 VDD VSS n9973 NOR2X1
XU10260 n9976 n9977 VDD VSS n8214 NAND2X1
XU10261 g1889 n9937 VDD VSS n9977 OR2X1
XU10262 n9978 n9979 VDD VSS n9976 NOR2X1
XU10263 n9980 n9941 VDD VSS n9979 NOR2X1
XU10264 g1898 n9942 VDD VSS n9978 NOR2X1
XU10265 n9980 VDD VSS n8213 INVX1
XU10266 n9981 n9982 VDD VSS n9980 NOR2X1
XU10267 g1192 n9983 VDD VSS n9982 NOR2X1
XU10268 n9984 n9985 VDD VSS n9983 NOR2X1
XU10269 n9581 n9986 VDD VSS n9985 NOR2X1
XU10270 g6944 g1204 VDD VSS n9984 NOR2X1
XU10271 g1195 n9949 VDD VSS n9981 NOR2X1
XU10272 n9986 VDD VSS n8212 INVX1
XU10273 n9987 n9988 VDD VSS n9986 NAND2X1
XU10274 g509 g506 VDD VSS n9988 NAND2X1
XU10275 g518 n9952 VDD VSS n9987 NAND2X1
XU10276 n9989 n9990 VDD VSS n8211 NAND2X1
XU10277 g2582 n9929 VDD VSS n9990 OR2X1
XU10278 n9991 n9992 VDD VSS n9989 NOR2X1
XU10279 n9993 n9933 VDD VSS n9992 NOR2X1
XU10280 n8210 VDD VSS n9993 INVX1
XU10281 g2593 n9934 VDD VSS n9991 NOR2X1
XU10282 n9994 n9995 VDD VSS n8210 NAND2X1
XU10283 g1888 n9937 VDD VSS n9995 OR2X1
XU10284 n9996 n9997 VDD VSS n9994 NOR2X1
XU10285 n9998 n9941 VDD VSS n9997 NOR2X1
XU10286 g1899 n9942 VDD VSS n9996 NOR2X1
XU10287 n9998 VDD VSS n8209 INVX1
XU10288 n9999 n10000 VDD VSS n9998 NOR2X1
XU10289 g1192 n10001 VDD VSS n10000 NOR2X1
XU10290 n10002 n10003 VDD VSS n10001 NOR2X1
XU10291 n9581 n10004 VDD VSS n10003 NOR2X1
XU10292 g6944 g1205 VDD VSS n10002 NOR2X1
XU10293 g1194 n9949 VDD VSS n9999 NOR2X1
XU10294 n10004 VDD VSS n8208 INVX1
XU10295 n10005 n10006 VDD VSS n10004 NAND2X1
XU10296 g508 g506 VDD VSS n10006 NAND2X1
XU10297 g519 n9952 VDD VSS n10005 NAND2X1
XU10298 n10007 VDD VSS n9952 INVX1
XU10299 n10008 n10009 VDD VSS n8207 NAND2X1
XU10300 g2581 n9929 VDD VSS n10009 OR2X1
XU10301 n10010 n10011 VDD VSS n10008 NOR2X1
XU10302 n10012 n9933 VDD VSS n10011 NOR2X1
XU10303 g7390 n9929 VDD VSS n9933 NAND2X1
XU10304 n8206 VDD VSS n10012 INVX1
XU10305 g16437 n9934 VDD VSS n10010 NOR2X1
XU10306 n8879 n9929 VDD VSS n9934 NAND2X1
XU10307 g2580 VDD VSS n9929 INVX1
XU10308 n10013 n10014 VDD VSS n8206 NAND2X1
XU10309 g1887 n9937 VDD VSS n10014 OR2X1
XU10310 n10015 n10016 VDD VSS n10013 NOR2X1
XU10311 n10017 n9941 VDD VSS n10016 NOR2X1
XU10312 g7194 n9937 VDD VSS n9941 NAND2X1
XU10313 g16399 n9942 VDD VSS n10015 NOR2X1
XU10314 n9937 n9229 VDD VSS n9942 NAND2X1
XU10315 g1886 VDD VSS n9937 INVX1
XU10316 n10017 VDD VSS n8205 INVX1
XU10317 n10018 n10019 VDD VSS n10017 NOR2X1
XU10318 g1192 n10020 VDD VSS n10019 NOR2X1
XU10319 n10021 n10022 VDD VSS n10020 NOR2X1
XU10320 n10023 n9581 VDD VSS n10022 NOR2X1
XU10321 g6944 g16355 VDD VSS n10021 NOR2X1
XU10322 g1193 n9949 VDD VSS n10018 NOR2X1
XU10323 g1192 VDD VSS n9949 INVX1
XU10324 n10023 VDD VSS n8204 INVX1
XU10325 n10024 n10025 VDD VSS n10023 NOR2X1
XU10326 g507 n10026 VDD VSS n10025 NOR2X1
XU10327 g16297 n10007 VDD VSS n10024 NOR2X1
XU10328 n10026 n10027 VDD VSS n10007 NAND2X1
XU10329 g506 VDD VSS n10026 INVX1
XU10330 n10028 n10029 VDD VSS n8203 NAND2X1
XU10331 g550 n10030 VDD VSS n10029 NAND2X1
XU10332 n10031 n10032 VDD VSS n10028 NOR2X1
XU10333 g480 n10027 VDD VSS n10032 NOR2X1
XU10334 g464 n10033 VDD VSS n10031 NOR2X1
XU10335 n10034 n10035 VDD VSS n8202 NAND2X1
XU10336 g6485 n10036 VDD VSS n10035 NAND2X1
XU10337 n10037 n10038 VDD VSS n10034 NOR2X1
XU10338 g478 n9923 VDD VSS n10038 NOR2X1
XU10339 g477 n10027 VDD VSS n10037 NOR2X1
XU10340 n10039 n10040 VDD VSS n8201 NAND2X1
XU10341 g6485 n10041 VDD VSS n10040 NAND2X1
XU10342 n10042 n10043 VDD VSS n10039 NOR2X1
XU10343 g487 n9923 VDD VSS n10043 NOR2X1
XU10344 g486 n10027 VDD VSS n10042 NOR2X1
XU10345 n10044 n10045 VDD VSS n8198 NAND2X1
XU10346 n10046 g732 VDD VSS n10045 OR2X1
XU10347 n10046 n10047 VDD VSS n10044 NAND2X1
XU10348 n10048 n10049 VDD VSS n8197 NAND2X1
XU10349 n9750 n10050 VDD VSS n10049 NAND2X1
XU10350 n9757 n10047 VDD VSS n10048 NAND2X1
XU10351 n10051 n10052 VDD VSS n8196 NAND2X1
XU10352 n10053 g731 VDD VSS n10052 OR2X1
XU10353 n10053 n10047 VDD VSS n10051 NAND2X1
XU10354 n10054 n10055 VDD VSS n8195 NAND2X1
XU10355 n10056 g575 VDD VSS n10055 OR2X1
XU10356 n10056 n10057 VDD VSS n10054 NAND2X1
XU10357 n10058 n10059 VDD VSS n8194 NAND2X1
XU10358 n10056 g578 VDD VSS n10059 OR2X1
XU10359 n10056 n10060 VDD VSS n10058 NAND2X1
XU10360 n10061 n10062 VDD VSS n8193 NAND2X1
XU10361 n10056 g581 VDD VSS n10062 OR2X1
XU10362 n10063 n10056 VDD VSS n10061 NAND2X1
XU10363 n10064 n10065 VDD VSS n8192 NAND2X1
XU10364 n10066 n10056 VDD VSS n10065 NAND2X1
XU10365 n10056 g584 VDD VSS n10064 OR2X1
XU10366 n9923 n8187 VDD VSS n10056 NOR2X1
XU10367 n10067 n10068 VDD VSS n8191 NAND2X1
XU10368 n10069 n10070 VDD VSS n10068 NAND2X1
XU10369 n10071 n10057 VDD VSS n10067 NAND2X1
XU10370 n10072 n10073 VDD VSS n8190 NAND2X1
XU10371 n10069 n10074 VDD VSS n10073 NAND2X1
XU10372 n10071 n10060 VDD VSS n10072 NAND2X1
XU10373 n10075 n10076 VDD VSS n8189 NAND2X1
XU10374 n10069 n10077 VDD VSS n10076 NAND2X1
XU10375 n10071 n10063 VDD VSS n10075 NAND2X1
XU10376 n10078 n10079 VDD VSS n8188 NAND2X1
XU10377 n10071 n10066 VDD VSS n10079 NAND2X1
XU10378 n10069 n10080 VDD VSS n10078 NAND2X1
XU10379 n10071 VDD VSS n10069 INVX1
XU10380 n10027 n8187 VDD VSS n10071 NOR2X1
XU10381 n10081 n10082 VDD VSS n8186 NAND2X1
XU10382 n10083 n10027 VDD VSS n10082 NAND2X1
XU10383 g6642 n10084 VDD VSS n10081 NAND2X1
XU10384 n10085 n10086 VDD VSS n8185 NAND2X1
XU10385 g496 g550 VDD VSS n10086 OR2X1
XU10386 g550 n10084 VDD VSS n10085 NAND2X1
XU10387 n10087 n10088 VDD VSS n8184 NAND2X1
XU10388 n10046 g729 VDD VSS n10088 OR2X1
XU10389 n10046 n10089 VDD VSS n10087 NAND2X1
XU10390 n9791 VDD VSS n10046 INVX1
XU10391 g6677 g630 VDD VSS n9791 NAND2X1
XU10392 n10090 n10091 VDD VSS n8183 NAND2X1
XU10393 n9757 g730 VDD VSS n10091 OR2X1
XU10394 n9757 n10089 VDD VSS n10090 NAND2X1
XU10395 n9750 VDD VSS n9757 INVX1
XU10396 g6911 g630 VDD VSS n9750 NAND2X1
XU10397 n10092 n10093 VDD VSS n8182 NAND2X1
XU10398 n9785 n9902 VDD VSS n10093 NAND2X1
XU10399 g728 VDD VSS n9902 INVX1
XU10400 n10053 n10089 VDD VSS n10092 NAND2X1
XU10401 n9785 VDD VSS n10053 INVX1
XU10402 g630 g629 VDD VSS n9785 NAND2X1
XU10403 n10094 n10095 VDD VSS n8181 NAND2X1
XU10404 n10096 g576 VDD VSS n10095 OR2X1
XU10405 n10096 n10057 VDD VSS n10094 NAND2X1
XU10406 n10097 n10098 VDD VSS n10057 NAND2X1
XU10407 g3229 n10099 VDD VSS n10098 NAND2X1
XU10408 n10100 n10101 VDD VSS n10097 NOR2X1
XU10409 g3229 n10102 VDD VSS n10101 NOR2X1
XU10410 n10103 n10104 VDD VSS n10100 NOR2X1
XU10411 n148 n10105 VDD VSS n10104 NAND2X1
XU10412 n10102 VDD VSS n10103 INVX1
XU10413 n10106 n10107 VDD VSS n8180 NAND2X1
XU10414 n10096 g579 VDD VSS n10107 OR2X1
XU10415 n10096 n10060 VDD VSS n10106 NAND2X1
XU10416 n10102 n10108 VDD VSS n10060 NAND2X1
XU10417 n10109 n10110 VDD VSS n10108 NAND2X1
XU10418 n147 n10111 VDD VSS n10102 NAND2X1
XU10419 n10112 n10113 VDD VSS n8179 NAND2X1
XU10420 n10096 g582 VDD VSS n10113 OR2X1
XU10421 n10096 n10063 VDD VSS n10112 NAND2X1
XU10422 n10114 n10115 VDD VSS n10063 NAND2X1
XU10423 n10116 n10109 VDD VSS n10115 NAND2X1
XU10424 n10109 n146 VDD VSS n10114 OR2X1
XU10425 n10117 n10118 VDD VSS n8178 NAND2X1
XU10426 n10096 g585 VDD VSS n10118 OR2X1
XU10427 n10096 n10066 VDD VSS n10117 NAND2X1
XU10428 n10119 n10109 VDD VSS n10066 NOR2X1
XU10429 g3229 n144 VDD VSS n10109 XOR2X1
XU10430 n10033 n8187 VDD VSS n10096 NOR2X1
XU10431 n10120 n10121 VDD VSS n8187 AND2X1
XU10432 n10122 g510 VDD VSS n10121 NAND2X1
XU10433 n10123 n10124 VDD VSS n10122 NOR2X1
XU10434 n8694 n10125 VDD VSS n10120 NAND2X1
XU10435 n10124 n10047 VDD VSS n10125 NAND2X1
XU10436 n10126 n10127 VDD VSS n8694 NAND2X1
XU10437 g3010 n10128 VDD VSS n10127 NOR2X1
XU10438 n8677 n8666 VDD VSS n10128 NAND2X1
XU10439 g3013 VDD VSS n8677 INVX1
XU10440 g3006 g3002 VDD VSS n10126 NOR2X1
XU10441 n10129 n10130 VDD VSS n8177 NAND2X1
XU10442 n10131 n10033 VDD VSS n10130 NAND2X1
XU10443 g6485 n10084 VDD VSS n10129 NAND2X1
XU10444 n10132 n10123 VDD VSS n10084 NAND2X1
XU10445 n10124 n9918 VDD VSS n10132 NOR2X1
XU10446 n10133 n10134 VDD VSS n10124 NAND2X1
XU10447 g496 g550 VDD VSS n10134 NAND2X1
XU10448 n10135 n10136 VDD VSS n10133 NOR2X1
XU10449 n10027 n10083 VDD VSS n10136 NOR2X1
XU10450 g493 VDD VSS n10083 INVX1
XU10451 n10033 n10131 VDD VSS n10135 NOR2X1
XU10452 g490 VDD VSS n10131 INVX1
XU10453 n10137 n10138 VDD VSS n8173 NAND2X1
XU10454 g305 g3229 VDD VSS n10138 OR2X1
XU10455 g291 g3229 VDD VSS n10137 NAND2X1
XU10456 n10139 n10140 VDD VSS n8172 NAND2X1
XU10457 g2376 g2374 VDD VSS n10140 OR2X1
XU10458 n10141 n10142 VDD VSS n10139 NOR2X1
XU10459 g2372 n10143 VDD VSS n10142 NOR2X1
XU10460 n10144 n10145 VDD VSS n10141 NOR2X1
XU10461 n10146 n10147 VDD VSS n8171 NAND2X1
XU10462 g2375 g2374 VDD VSS n10147 OR2X1
XU10463 n10148 n10149 VDD VSS n10146 NOR2X1
XU10464 g2383 n10143 VDD VSS n10149 NOR2X1
XU10465 n10150 n10145 VDD VSS n10148 NOR2X1
XU10466 n10151 n10152 VDD VSS n8170 NAND2X1
XU10467 g2373 n10153 VDD VSS n10152 NAND2X1
XU10468 g2374 VDD VSS n10153 INVX1
XU10469 n10154 n10155 VDD VSS n10151 NOR2X1
XU10470 g2380 n10143 VDD VSS n10155 NOR2X1
XU10471 n10156 n10145 VDD VSS n10154 NOR2X1
XU10472 n8169 VDD VSS n10156 INVX1
XU10473 n10157 n10158 VDD VSS n8169 NAND2X1
XU10474 g1679 n10159 VDD VSS n10158 NAND2X1
XU10475 n10160 g1680 VDD VSS n10157 NAND2X1
XU10476 n10161 n10162 VDD VSS n10160 NAND2X1
XU10477 n9333 n10163 VDD VSS n10162 NAND2X1
XU10478 g1686 VDD VSS n9333 INVX1
XU10479 n8168 g7014 VDD VSS n10161 NAND2X1
XU10480 n10164 n10165 VDD VSS n8168 NAND2X1
XU10481 g985 n10166 VDD VSS n10165 NAND2X1
XU10482 g986 VDD VSS n10166 INVX1
XU10483 n10167 g986 VDD VSS n10164 NAND2X1
XU10484 n10168 n10169 VDD VSS n10167 NAND2X1
XU10485 n10170 n9685 VDD VSS n10169 NAND2X1
XU10486 g992 VDD VSS n9685 INVX1
XU10487 n8167 g6712 VDD VSS n10168 NAND2X1
XU10488 n10171 n10172 VDD VSS n8167 AND2X1
XU10489 g298 g299 VDD VSS n10172 OR2X1
XU10490 g305 n10173 VDD VSS n10171 NAND2X1
XU10491 n10174 n10175 VDD VSS n8166 NAND2X1
XU10492 g2379 g2374 VDD VSS n10175 OR2X1
XU10493 n10176 n10177 VDD VSS n10174 NOR2X1
XU10494 g2369 n10143 VDD VSS n10177 NOR2X1
XU10495 n10178 n10145 VDD VSS n10176 NOR2X1
XU10496 n10179 n10180 VDD VSS n8165 NAND2X1
XU10497 g2378 g2374 VDD VSS n10180 OR2X1
XU10498 n10181 n10182 VDD VSS n10179 NOR2X1
XU10499 g2370 n10143 VDD VSS n10182 NOR2X1
XU10500 n10183 n10145 VDD VSS n10181 NOR2X1
XU10501 n10184 n10185 VDD VSS n8164 NAND2X1
XU10502 g2377 g2374 VDD VSS n10185 OR2X1
XU10503 n10186 n10187 VDD VSS n10184 NOR2X1
XU10504 g2371 n10143 VDD VSS n10187 NOR2X1
XU10505 g2374 n10188 VDD VSS n10143 NAND2X1
XU10506 n10189 n10145 VDD VSS n10186 NOR2X1
XU10507 g2374 g7264 VDD VSS n10145 NAND2X1
XU10508 n10190 n10191 VDD VSS n8163 NAND2X1
XU10509 II18527 n10192 VDD VSS n10191 NAND2X1
XU10510 g7909 n10193 VDD VSS n10190 NAND2X1
XU10511 n10194 n10195 VDD VSS n8162 NAND2X1
XU10512 II18515 n10196 VDD VSS n10195 NAND2X1
XU10513 g7956 n10193 VDD VSS n10194 NAND2X1
XU10514 n10197 n10198 VDD VSS n8161 NAND2X1
XU10515 II18518 n10199 VDD VSS n10198 NAND2X1
XU10516 g485 n10193 VDD VSS n10197 NAND2X1
XU10517 n10200 n10201 VDD VSS n8160 NAND2X1
XU10518 II18524 n10199 VDD VSS n10201 NAND2X1
XU10519 g485 n10202 VDD VSS n10200 NAND2X1
XU10520 n10203 n10204 VDD VSS n8159 NAND2X1
XU10521 II18512 n10192 VDD VSS n10204 NAND2X1
XU10522 g7909 VDD VSS n10192 INVX1
XU10523 g7909 n10202 VDD VSS n10203 NAND2X1
XU10524 n10205 n10206 VDD VSS n8158 NAND2X1
XU10525 II18521 n10196 VDD VSS n10206 NAND2X1
XU10526 g7956 n10202 VDD VSS n10205 NAND2X1
XU10527 n10207 n10208 VDD VSS n8157 NAND2X1
XU10528 g477 g7909 VDD VSS n10208 OR2X1
XU10529 g7909 n10209 VDD VSS n10207 NAND2X1
XU10530 n10210 n10211 VDD VSS n8156 NAND2X1
XU10531 g478 g7956 VDD VSS n10211 OR2X1
XU10532 g7956 n10209 VDD VSS n10210 NAND2X1
XU10533 n10212 n10213 VDD VSS n8155 NAND2X1
XU10534 n10036 n10199 VDD VSS n10213 NAND2X1
XU10535 g479 VDD VSS n10036 INVX1
XU10536 g485 n10209 VDD VSS n10212 NAND2X1
XU10537 n10214 n10215 VDD VSS n8154 NAND2X1
XU10538 n10030 n10196 VDD VSS n10215 NAND2X1
XU10539 g7956 VDD VSS n10196 INVX1
XU10540 g484 VDD VSS n10030 INVX1
XU10541 g7956 n10216 VDD VSS n10214 NAND2X1
XU10542 n10217 n10218 VDD VSS n8153 NAND2X1
XU10543 g464 g485 VDD VSS n10218 OR2X1
XU10544 g485 n10216 VDD VSS n10217 NAND2X1
XU10545 n10219 n10220 VDD VSS n8152 NAND2X1
XU10546 g480 g7909 VDD VSS n10220 OR2X1
XU10547 g7909 n10216 VDD VSS n10219 NAND2X1
XU10548 n10221 n10222 VDD VSS n8151 NAND2X1
XU10549 g486 g7909 VDD VSS n10222 OR2X1
XU10550 g7909 n10223 VDD VSS n10221 NAND2X1
XU10551 n10224 n10225 VDD VSS n8150 NAND2X1
XU10552 g487 g7956 VDD VSS n10225 OR2X1
XU10553 g7956 n10223 VDD VSS n10224 NAND2X1
XU10554 n10226 n10227 VDD VSS n8149 NAND2X1
XU10555 n10199 n10041 VDD VSS n10227 NAND2X1
XU10556 g488 VDD VSS n10041 INVX1
XU10557 g485 VDD VSS n10199 INVX1
XU10558 g485 n10223 VDD VSS n10226 NAND2X1
XU10559 n10228 n10229 VDD VSS n8148 NAND2X1
XU10560 n10230 n10231 VDD VSS n10229 NAND2X1
XU10561 n10230 g164 VDD VSS n10228 OR2X1
XU10562 n10232 n10233 VDD VSS n8147 NAND2X1
XU10563 n10234 n10231 VDD VSS n10233 NAND2X1
XU10564 n10235 n10236 VDD VSS n10232 NAND2X1
XU10565 n10237 n10238 VDD VSS n8146 NAND2X1
XU10566 n10230 g161 VDD VSS n10238 OR2X1
XU10567 n10230 n10239 VDD VSS n10237 NAND2X1
XU10568 n10240 n10241 VDD VSS n8145 NAND2X1
XU10569 n10235 n10242 VDD VSS n10241 NAND2X1
XU10570 n10234 n10239 VDD VSS n10240 NAND2X1
XU10571 n10243 n10244 VDD VSS n8144 NAND2X1
XU10572 n10245 n10239 VDD VSS n10244 NAND2X1
XU10573 n10246 n10247 VDD VSS n10243 NAND2X1
XU10574 n10248 n10249 VDD VSS n8143 NAND2X1
XU10575 n10245 n10231 VDD VSS n10249 NAND2X1
XU10576 n10246 n10250 VDD VSS n10248 NAND2X1
XU10577 n10251 n10252 VDD VSS n8142 NAND2X1
XU10578 n10253 n10033 VDD VSS n10252 NAND2X1
XU10579 g6485 n10254 VDD VSS n10251 NAND2X1
XU10580 n10255 n10256 VDD VSS n8141 NAND2X1
XU10581 n10257 n10027 VDD VSS n10256 NAND2X1
XU10582 g6642 n10254 VDD VSS n10255 NAND2X1
XU10583 n10258 n10259 VDD VSS n8140 NAND2X1
XU10584 n9923 n10260 VDD VSS n10259 NAND2X1
XU10585 g550 n10254 VDD VSS n10258 NAND2X1
XU10586 n10261 n10262 VDD VSS n10254 NAND2X1
XU10587 n10263 n10264 VDD VSS n8139 NAND2X1
XU10588 n10265 n9582 VDD VSS n10264 NAND2X1
XU10589 g6750 n10266 VDD VSS n10263 NAND2X1
XU10590 n10267 n10268 VDD VSS n8138 NAND2X1
XU10591 n10269 n9581 VDD VSS n10268 NAND2X1
XU10592 g6944 n10266 VDD VSS n10267 NAND2X1
XU10593 n10270 n10271 VDD VSS n8137 NAND2X1
XU10594 n9572 n10272 VDD VSS n10271 NAND2X1
XU10595 g1236 n10266 VDD VSS n10270 NAND2X1
XU10596 n10261 n10273 VDD VSS n10266 NAND2X1
XU10597 n10274 n10275 VDD VSS n8136 NAND2X1
XU10598 n10276 n9230 VDD VSS n10275 NAND2X1
XU10599 g7052 n10277 VDD VSS n10274 NAND2X1
XU10600 n10278 n10279 VDD VSS n8135 NAND2X1
XU10601 n10280 n9229 VDD VSS n10279 NAND2X1
XU10602 g7194 n10277 VDD VSS n10278 NAND2X1
XU10603 n10281 n10282 VDD VSS n8134 NAND2X1
XU10604 n9220 n10283 VDD VSS n10282 NAND2X1
XU10605 g1930 n10277 VDD VSS n10281 NAND2X1
XU10606 n10261 n10284 VDD VSS n10277 NAND2X1
XU10607 n10285 n10286 VDD VSS n8133 NAND2X1
XU10608 n10287 n10033 VDD VSS n10286 NAND2X1
XU10609 g6485 n10288 VDD VSS n10285 NAND2X1
XU10610 n10289 n10290 VDD VSS n8132 NAND2X1
XU10611 n10291 n10027 VDD VSS n10290 NAND2X1
XU10612 g6642 n10288 VDD VSS n10289 NAND2X1
XU10613 n10292 n10293 VDD VSS n8131 NAND2X1
XU10614 n9923 n10294 VDD VSS n10293 NAND2X1
XU10615 g550 n10288 VDD VSS n10292 NAND2X1
XU10616 n10261 n10295 VDD VSS n10288 NAND2X1
XU10617 n10296 n10297 VDD VSS n8130 NAND2X1
XU10618 n10298 n10033 VDD VSS n10297 NAND2X1
XU10619 n10299 g6485 VDD VSS n10296 NAND2X1
XU10620 n10300 n10301 VDD VSS n8129 NAND2X1
XU10621 g608 g6642 VDD VSS n10301 OR2X1
XU10622 n10299 g6642 VDD VSS n10300 NAND2X1
XU10623 n10302 n10303 VDD VSS n8128 NAND2X1
XU10624 n9923 n10304 VDD VSS n10303 NAND2X1
XU10625 n10299 g550 VDD VSS n10302 NAND2X1
XU10626 n10305 n10306 VDD VSS n10299 AND2X1
XU10627 n10047 n10261 VDD VSS n10306 NAND2X1
XU10628 n10307 n8867 VDD VSS n10305 NAND2X1
XU10629 n10308 n10309 VDD VSS n10307 NOR2X1
XU10630 n10310 n10311 VDD VSS n10308 NAND2X1
XU10631 n10295 n10312 VDD VSS n10310 OR2X1
XU10632 n10313 n10314 VDD VSS n8127 NAND2X1
XU10633 n10315 n10033 VDD VSS n10314 NAND2X1
XU10634 n10316 g6485 VDD VSS n10313 NAND2X1
XU10635 n10317 n10318 VDD VSS n8126 NAND2X1
XU10636 g617 g6642 VDD VSS n10318 OR2X1
XU10637 n10316 g6642 VDD VSS n10317 NAND2X1
XU10638 n10319 n10320 VDD VSS n8125 NAND2X1
XU10639 n9923 n10321 VDD VSS n10320 NAND2X1
XU10640 n10316 g550 VDD VSS n10319 NAND2X1
XU10641 n10322 n10323 VDD VSS n10316 AND2X1
XU10642 n10089 n10261 VDD VSS n10323 NAND2X1
XU10643 n10324 n8867 VDD VSS n10322 NAND2X1
XU10644 n10325 n10312 VDD VSS n10324 NOR2X1
XU10645 n10326 n10327 VDD VSS n10312 NAND2X1
XU10646 n10328 n10105 VDD VSS n10327 NAND2X1
XU10647 n10329 n10330 VDD VSS n10328 NAND2X1
XU10648 n10331 n10119 VDD VSS n10330 OR2X1
XU10649 n10332 n10333 VDD VSS n10329 NAND2X1
XU10650 n10334 n10335 VDD VSS n10333 NAND2X1
XU10651 n10336 n10111 VDD VSS n10335 NAND2X1
XU10652 n10337 n10338 VDD VSS n10334 NOR2X1
XU10653 n10116 n10339 VDD VSS n10338 AND2X1
XU10654 n10340 n10341 VDD VSS n10337 NOR2X1
XU10655 n10342 n10110 VDD VSS n10341 NAND2X1
XU10656 n10343 n10344 VDD VSS n10326 NOR2X1
XU10657 n10332 n10345 VDD VSS n10344 NOR2X1
XU10658 n10346 n10347 VDD VSS n10345 NOR2X1
XU10659 n10348 n10105 VDD VSS n10347 NOR2X1
XU10660 n10349 n10350 VDD VSS n10348 NOR2X1
XU10661 n10351 n10352 VDD VSS n10350 NAND2X1
XU10662 n10336 n10116 VDD VSS n10352 NAND2X1
XU10663 n10111 n10099 VDD VSS n10116 NOR2X1
XU10664 n10353 n146 VDD VSS n10351 NAND2X1
XU10665 n10099 n10339 VDD VSS n10346 AND2X1
XU10666 n10342 n10354 VDD VSS n10343 NOR2X1
XU10667 n10355 n10111 VDD VSS n10354 NAND2X1
XU10668 n10356 n10357 VDD VSS n10355 NAND2X1
XU10669 n144 n10358 VDD VSS n10357 NAND2X1
XU10670 n10332 n147 VDD VSS n10356 NAND2X1
XU10671 n10311 n10359 VDD VSS n10325 NAND2X1
XU10672 n10262 n10309 VDD VSS n10359 OR2X1
XU10673 n10360 n10361 VDD VSS n10309 NAND2X1
XU10674 n10362 n10363 VDD VSS n10361 NAND2X1
XU10675 n147 n10364 VDD VSS n10363 NAND2X1
XU10676 n148 n10365 VDD VSS n10364 NAND2X1
XU10677 n10366 n10367 VDD VSS n10362 NOR2X1
XU10678 n144 n10368 VDD VSS n10367 NOR2X1
XU10679 n10336 n10342 VDD VSS n10368 NOR2X1
XU10680 n10340 n10105 VDD VSS n10366 NOR2X1
XU10681 n10369 n10370 VDD VSS n10360 NOR2X1
XU10682 n10371 n10365 VDD VSS n10370 NOR2X1
XU10683 n10372 n10373 VDD VSS n10371 NOR2X1
XU10684 n10374 n10375 VDD VSS n10373 NAND2X1
XU10685 n10376 n10336 VDD VSS n10375 NAND2X1
XU10686 n10377 n10119 VDD VSS n10376 NOR2X1
XU10687 n146 n147 VDD VSS n10119 NAND2X1
XU10688 n10378 n10099 VDD VSS n10374 NAND2X1
XU10689 n10358 n10379 VDD VSS n10378 NAND2X1
XU10690 n10331 n10105 VDD VSS n10379 NAND2X1
XU10691 n10380 n10111 VDD VSS n10372 NOR2X1
XU10692 n10332 n10381 VDD VSS n10369 NOR2X1
XU10693 n10382 n10383 VDD VSS n10381 NOR2X1
XU10694 n147 n10380 VDD VSS n10383 NOR2X1
XU10695 n10384 n10385 VDD VSS n10380 AND2X1
XU10696 n10377 n10105 VDD VSS n10385 NAND2X1
XU10697 n10339 n144 VDD VSS n10384 NAND2X1
XU10698 n10336 n10377 VDD VSS n10339 NOR2X1
XU10699 n10358 VDD VSS n10336 INVX1
XU10700 n146 n10386 VDD VSS n10382 NOR2X1
XU10701 n10387 n10353 VDD VSS n10386 NOR2X1
XU10702 n10388 n147 VDD VSS n10353 AND2X1
XU10703 n10377 n10340 VDD VSS n10388 NOR2X1
XU10704 n10331 VDD VSS n10340 INVX1
XU10705 n10389 n10390 VDD VSS n10331 NAND2X1
XU10706 g396 g5648 VDD VSS n10390 NAND2X1
XU10707 n10391 n10392 VDD VSS n10389 AND2X1
XU10708 g324 g337 VDD VSS n10392 NAND2X1
XU10709 g394 g5629 VDD VSS n10391 NAND2X1
XU10710 n10342 VDD VSS n10377 INVX1
XU10711 n10349 n10358 VDD VSS n10387 NOR2X1
XU10712 n10393 n10394 VDD VSS n10358 NAND2X1
XU10713 g381 g5648 VDD VSS n10394 NAND2X1
XU10714 n10395 n10396 VDD VSS n10393 AND2X1
XU10715 g383 g337 VDD VSS n10396 NAND2X1
XU10716 g379 g5629 VDD VSS n10395 NAND2X1
XU10717 n147 n10342 VDD VSS n10349 NOR2X1
XU10718 n10397 n10398 VDD VSS n10342 NAND2X1
XU10719 g366 g5648 VDD VSS n10398 NAND2X1
XU10720 n10399 n10400 VDD VSS n10397 AND2X1
XU10721 g368 g337 VDD VSS n10400 NAND2X1
XU10722 g364 g5629 VDD VSS n10399 NAND2X1
XU10723 n10365 VDD VSS n10332 INVX1
XU10724 n10401 n10402 VDD VSS n10365 NAND2X1
XU10725 g353 g337 VDD VSS n10402 NAND2X1
XU10726 n10403 n10404 VDD VSS n10401 AND2X1
XU10727 g5629 g349 VDD VSS n10404 NAND2X1
XU10728 g5648 g351 VDD VSS n10403 NAND2X1
XU10729 n10295 n10262 VDD VSS n10311 NAND2X1
XU10730 n10405 n10406 VDD VSS n10262 NAND2X1
XU10731 n10407 n10408 VDD VSS n10406 NOR2X1
XU10732 n9923 n10260 VDD VSS n10408 NOR2X1
XU10733 g602 VDD VSS n10260 INVX1
XU10734 n10409 g542 VDD VSS n10407 AND2X1
XU10735 n8200 g185 VDD VSS n10409 AND2X1
XU10736 n10410 n10411 VDD VSS n8200 NAND2X1
XU10737 g567 g6642 VDD VSS n10411 NAND2X1
XU10738 n10412 n10413 VDD VSS n10410 AND2X1
XU10739 g489 g550 VDD VSS n10413 NAND2X1
XU10740 g565 g6485 VDD VSS n10412 NAND2X1
XU10741 n10414 n10415 VDD VSS n10405 NOR2X1
XU10742 n10027 n10257 VDD VSS n10415 NOR2X1
XU10743 g599 VDD VSS n10257 INVX1
XU10744 n10033 n10253 VDD VSS n10414 NOR2X1
XU10745 g596 VDD VSS n10253 INVX1
XU10746 n10416 n10417 VDD VSS n10295 NAND2X1
XU10747 n10418 n10419 VDD VSS n10417 NOR2X1
XU10748 n9923 n10294 VDD VSS n10419 NOR2X1
XU10749 g593 VDD VSS n10294 INVX1
XU10750 n10420 g524 VDD VSS n10418 AND2X1
XU10751 n8199 g185 VDD VSS n10420 AND2X1
XU10752 n10421 n10422 VDD VSS n8199 NAND2X1
XU10753 g571 g6642 VDD VSS n10422 NAND2X1
XU10754 n10423 n10424 VDD VSS n10421 AND2X1
XU10755 g573 g550 VDD VSS n10424 NAND2X1
XU10756 g569 g6485 VDD VSS n10423 NAND2X1
XU10757 n10425 n10426 VDD VSS n10416 NOR2X1
XU10758 n10027 n10291 VDD VSS n10426 NOR2X1
XU10759 g590 VDD VSS n10291 INVX1
XU10760 g6642 VDD VSS n10027 INVX1
XU10761 n10033 n10287 VDD VSS n10425 NOR2X1
XU10762 g587 VDD VSS n10287 INVX1
XU10763 n10427 n10428 VDD VSS n8124 NAND2X1
XU10764 n10429 n8880 VDD VSS n10428 NAND2X1
XU10765 g7302 n10430 VDD VSS n10427 NAND2X1
XU10766 n10431 n10432 VDD VSS n8123 NAND2X1
XU10767 n10433 n8879 VDD VSS n10432 NAND2X1
XU10768 g7390 n10430 VDD VSS n10431 NAND2X1
XU10769 n10434 n10435 VDD VSS n8122 NAND2X1
XU10770 n8870 n10436 VDD VSS n10435 NAND2X1
XU10771 g2624 n10430 VDD VSS n10434 NAND2X1
XU10772 n10261 n10437 VDD VSS n10430 NAND2X1
XU10773 n10438 n10439 VDD VSS n8121 NAND2X1
XU10774 n10440 n9582 VDD VSS n10439 NAND2X1
XU10775 g6750 n10441 VDD VSS n10438 NAND2X1
XU10776 n10442 n10443 VDD VSS n8120 NAND2X1
XU10777 n10444 n9581 VDD VSS n10443 NAND2X1
XU10778 g6944 n10441 VDD VSS n10442 NAND2X1
XU10779 n10445 n10446 VDD VSS n8119 NAND2X1
XU10780 n9572 n10447 VDD VSS n10446 NAND2X1
XU10781 g1236 n10441 VDD VSS n10445 NAND2X1
XU10782 n10261 n10448 VDD VSS n10441 NAND2X1
XU10783 n10449 n10450 VDD VSS n8118 NAND2X1
XU10784 n10451 n9582 VDD VSS n10450 NAND2X1
XU10785 n10452 g6750 VDD VSS n10449 NAND2X1
XU10786 n10453 n10454 VDD VSS n8117 NAND2X1
XU10787 g1294 g6944 VDD VSS n10454 OR2X1
XU10788 n10452 g6944 VDD VSS n10453 NAND2X1
XU10789 n10455 n10456 VDD VSS n8116 NAND2X1
XU10790 n9572 n10457 VDD VSS n10456 NAND2X1
XU10791 n10452 g1236 VDD VSS n10455 NAND2X1
XU10792 n10458 n10459 VDD VSS n10452 AND2X1
XU10793 n9596 n10261 VDD VSS n10459 NAND2X1
XU10794 n10460 n8867 VDD VSS n10458 NAND2X1
XU10795 n10461 n10462 VDD VSS n10460 NOR2X1
XU10796 n10463 n10464 VDD VSS n10461 NAND2X1
XU10797 n10448 n10465 VDD VSS n10463 OR2X1
XU10798 n10466 n10467 VDD VSS n8115 NAND2X1
XU10799 n10468 n9582 VDD VSS n10467 NAND2X1
XU10800 n10469 g6750 VDD VSS n10466 NAND2X1
XU10801 n10470 n10471 VDD VSS n8114 NAND2X1
XU10802 g1303 g6944 VDD VSS n10471 OR2X1
XU10803 n10469 g6944 VDD VSS n10470 NAND2X1
XU10804 n10472 n10473 VDD VSS n8113 NAND2X1
XU10805 n9572 n10474 VDD VSS n10473 NAND2X1
XU10806 n10469 g1236 VDD VSS n10472 NAND2X1
XU10807 n10475 n10476 VDD VSS n10469 AND2X1
XU10808 n9638 n10261 VDD VSS n10476 NAND2X1
XU10809 n10477 n8867 VDD VSS n10475 NAND2X1
XU10810 n10478 n10465 VDD VSS n10477 NOR2X1
XU10811 n10479 n10480 VDD VSS n10465 NAND2X1
XU10812 n10481 n9654 VDD VSS n10480 NAND2X1
XU10813 n10482 n10483 VDD VSS n10481 NAND2X1
XU10814 n10484 n9668 VDD VSS n10483 OR2X1
XU10815 n10485 n10486 VDD VSS n10482 NAND2X1
XU10816 n10487 n10488 VDD VSS n10486 NAND2X1
XU10817 n10489 n9660 VDD VSS n10488 NAND2X1
XU10818 n10490 n10491 VDD VSS n10487 NOR2X1
XU10819 n9665 n10492 VDD VSS n10491 AND2X1
XU10820 n10493 n10494 VDD VSS n10490 NOR2X1
XU10821 n10495 n9659 VDD VSS n10494 NAND2X1
XU10822 n10496 n10497 VDD VSS n10479 NOR2X1
XU10823 n10485 n10498 VDD VSS n10497 NOR2X1
XU10824 n10499 n10500 VDD VSS n10498 NOR2X1
XU10825 n10501 n9654 VDD VSS n10500 NOR2X1
XU10826 n10502 n10503 VDD VSS n10501 NOR2X1
XU10827 n10504 n10505 VDD VSS n10503 NAND2X1
XU10828 n10489 n9665 VDD VSS n10505 NAND2X1
XU10829 n9660 n9648 VDD VSS n9665 NOR2X1
XU10830 n10506 n217 VDD VSS n10504 NAND2X1
XU10831 n9648 n10492 VDD VSS n10499 AND2X1
XU10832 n10495 n10507 VDD VSS n10496 NOR2X1
XU10833 n10508 n9660 VDD VSS n10507 NAND2X1
XU10834 n10509 n10510 VDD VSS n10508 NAND2X1
XU10835 n215 n10511 VDD VSS n10510 NAND2X1
XU10836 n10485 n218 VDD VSS n10509 NAND2X1
XU10837 n10464 n10512 VDD VSS n10478 NAND2X1
XU10838 n10273 n10462 VDD VSS n10512 OR2X1
XU10839 n10513 n10514 VDD VSS n10462 NAND2X1
XU10840 n10515 n10516 VDD VSS n10514 NAND2X1
XU10841 n218 n10517 VDD VSS n10516 NAND2X1
XU10842 n219 n10518 VDD VSS n10517 NAND2X1
XU10843 n10519 n10520 VDD VSS n10515 NOR2X1
XU10844 n215 n10521 VDD VSS n10520 NOR2X1
XU10845 n10489 n10495 VDD VSS n10521 NOR2X1
XU10846 n10493 n9654 VDD VSS n10519 NOR2X1
XU10847 n10522 n10523 VDD VSS n10513 NOR2X1
XU10848 n10524 n10518 VDD VSS n10523 NOR2X1
XU10849 n10525 n10526 VDD VSS n10524 NOR2X1
XU10850 n10527 n10528 VDD VSS n10526 NAND2X1
XU10851 n10529 n10489 VDD VSS n10528 NAND2X1
XU10852 n10530 n9668 VDD VSS n10529 NOR2X1
XU10853 n217 n218 VDD VSS n9668 NAND2X1
XU10854 n10531 n9648 VDD VSS n10527 NAND2X1
XU10855 n10511 n10532 VDD VSS n10531 NAND2X1
XU10856 n10484 n9654 VDD VSS n10532 NAND2X1
XU10857 n10533 n9660 VDD VSS n10525 NOR2X1
XU10858 n10485 n10534 VDD VSS n10522 NOR2X1
XU10859 n10535 n10536 VDD VSS n10534 NOR2X1
XU10860 n218 n10533 VDD VSS n10536 NOR2X1
XU10861 n10537 n10538 VDD VSS n10533 AND2X1
XU10862 n10530 n9654 VDD VSS n10538 NAND2X1
XU10863 n10492 n215 VDD VSS n10537 NAND2X1
XU10864 n10489 n10530 VDD VSS n10492 NOR2X1
XU10865 n10511 VDD VSS n10489 INVX1
XU10866 n217 n10539 VDD VSS n10535 NOR2X1
XU10867 n10540 n10506 VDD VSS n10539 NOR2X1
XU10868 n10541 n218 VDD VSS n10506 AND2X1
XU10869 n10530 n10493 VDD VSS n10541 NOR2X1
XU10870 n10484 VDD VSS n10493 INVX1
XU10871 n10542 n10543 VDD VSS n10484 NAND2X1
XU10872 g1083 g5686 VDD VSS n10543 NAND2X1
XU10873 n10544 n10545 VDD VSS n10542 AND2X1
XU10874 g1011 g1024 VDD VSS n10545 NAND2X1
XU10875 g1081 g5657 VDD VSS n10544 NAND2X1
XU10876 n10495 VDD VSS n10530 INVX1
XU10877 n10502 n10511 VDD VSS n10540 NOR2X1
XU10878 n10546 n10547 VDD VSS n10511 NAND2X1
XU10879 g1068 g5686 VDD VSS n10547 NAND2X1
XU10880 n10548 n10549 VDD VSS n10546 AND2X1
XU10881 g1070 g1024 VDD VSS n10549 NAND2X1
XU10882 g1066 g5657 VDD VSS n10548 NAND2X1
XU10883 n218 n10495 VDD VSS n10502 NOR2X1
XU10884 n10550 n10551 VDD VSS n10495 NAND2X1
XU10885 g1053 g5686 VDD VSS n10551 NAND2X1
XU10886 n10552 n10553 VDD VSS n10550 AND2X1
XU10887 g1055 g1024 VDD VSS n10553 NAND2X1
XU10888 g1051 g5657 VDD VSS n10552 NAND2X1
XU10889 n10518 VDD VSS n10485 INVX1
XU10890 n10554 n10555 VDD VSS n10518 NAND2X1
XU10891 g1040 g1024 VDD VSS n10555 NAND2X1
XU10892 n10556 n10557 VDD VSS n10554 AND2X1
XU10893 g5657 g1036 VDD VSS n10557 NAND2X1
XU10894 g5686 g1038 VDD VSS n10556 NAND2X1
XU10895 n10448 n10273 VDD VSS n10464 NAND2X1
XU10896 n10558 n10559 VDD VSS n10273 NAND2X1
XU10897 n10560 n10561 VDD VSS n10559 NOR2X1
XU10898 n9572 n10272 VDD VSS n10561 NOR2X1
XU10899 g1288 VDD VSS n10272 INVX1
XU10900 n10562 g1228 VDD VSS n10560 AND2X1
XU10901 n8320 g185 VDD VSS n10562 AND2X1
XU10902 n10563 n10564 VDD VSS n8320 NAND2X1
XU10903 g1253 g6944 VDD VSS n10564 NAND2X1
XU10904 n10565 n10566 VDD VSS n10563 AND2X1
XU10905 g1176 g1236 VDD VSS n10566 NAND2X1
XU10906 g1251 g6750 VDD VSS n10565 NAND2X1
XU10907 n10567 n10568 VDD VSS n10558 NOR2X1
XU10908 n9581 n10269 VDD VSS n10568 NOR2X1
XU10909 g1285 VDD VSS n10269 INVX1
XU10910 n9582 n10265 VDD VSS n10567 NOR2X1
XU10911 g1282 VDD VSS n10265 INVX1
XU10912 n10569 n10570 VDD VSS n10448 NAND2X1
XU10913 n10571 n10572 VDD VSS n10570 NOR2X1
XU10914 n9572 n10447 VDD VSS n10572 NOR2X1
XU10915 g1279 VDD VSS n10447 INVX1
XU10916 n10573 g1210 VDD VSS n10571 AND2X1
XU10917 n8319 g185 VDD VSS n10573 AND2X1
XU10918 n10574 n10575 VDD VSS n8319 NAND2X1
XU10919 g1257 g6944 VDD VSS n10575 NAND2X1
XU10920 n10576 n10577 VDD VSS n10574 AND2X1
XU10921 g1259 g1236 VDD VSS n10577 NAND2X1
XU10922 g1255 g6750 VDD VSS n10576 NAND2X1
XU10923 n10578 n10579 VDD VSS n10569 NOR2X1
XU10924 n9581 n10444 VDD VSS n10579 NOR2X1
XU10925 g1276 VDD VSS n10444 INVX1
XU10926 g6944 VDD VSS n9581 INVX1
XU10927 n9582 n10440 VDD VSS n10578 NOR2X1
XU10928 g1273 VDD VSS n10440 INVX1
XU10929 n10580 n10581 VDD VSS n8112 NAND2X1
XU10930 n10582 n9230 VDD VSS n10581 NAND2X1
XU10931 g7052 n10583 VDD VSS n10580 NAND2X1
XU10932 n10584 n10585 VDD VSS n8111 NAND2X1
XU10933 n10586 n9229 VDD VSS n10585 NAND2X1
XU10934 g7194 n10583 VDD VSS n10584 NAND2X1
XU10935 n10587 n10588 VDD VSS n8110 NAND2X1
XU10936 n9220 n10589 VDD VSS n10588 NAND2X1
XU10937 g1930 n10583 VDD VSS n10587 NAND2X1
XU10938 n10261 n10590 VDD VSS n10583 NAND2X1
XU10939 n10591 n10592 VDD VSS n8109 NAND2X1
XU10940 n10593 n9230 VDD VSS n10592 NAND2X1
XU10941 n10594 g7052 VDD VSS n10591 NAND2X1
XU10942 n10595 n10596 VDD VSS n8108 NAND2X1
XU10943 g1988 g7194 VDD VSS n10596 OR2X1
XU10944 n10594 g7194 VDD VSS n10595 NAND2X1
XU10945 n10597 n10598 VDD VSS n8107 NAND2X1
XU10946 n9220 n10599 VDD VSS n10598 NAND2X1
XU10947 n10594 g1930 VDD VSS n10597 NAND2X1
XU10948 n10600 n10601 VDD VSS n10594 AND2X1
XU10949 n9244 n10261 VDD VSS n10601 NAND2X1
XU10950 n10602 n8867 VDD VSS n10600 NAND2X1
XU10951 n10603 n10604 VDD VSS n10602 NOR2X1
XU10952 n10605 n10606 VDD VSS n10603 NAND2X1
XU10953 n10590 n10607 VDD VSS n10605 OR2X1
XU10954 n10608 n10609 VDD VSS n8106 NAND2X1
XU10955 n10610 n9230 VDD VSS n10609 NAND2X1
XU10956 n10611 g7052 VDD VSS n10608 NAND2X1
XU10957 n10612 n10613 VDD VSS n8105 NAND2X1
XU10958 g1997 g7194 VDD VSS n10613 OR2X1
XU10959 n10611 g7194 VDD VSS n10612 NAND2X1
XU10960 n10614 n10615 VDD VSS n8104 NAND2X1
XU10961 n9220 n10616 VDD VSS n10615 NAND2X1
XU10962 n10611 g1930 VDD VSS n10614 NAND2X1
XU10963 n10617 n10618 VDD VSS n10611 AND2X1
XU10964 n9286 n10261 VDD VSS n10618 NAND2X1
XU10965 n10619 n8867 VDD VSS n10617 NAND2X1
XU10966 n10620 n10607 VDD VSS n10619 NOR2X1
XU10967 n10621 n10622 VDD VSS n10607 NAND2X1
XU10968 n10623 n9302 VDD VSS n10622 NAND2X1
XU10969 n10624 n10625 VDD VSS n10623 NAND2X1
XU10970 n10626 n9316 VDD VSS n10625 OR2X1
XU10971 n10627 n10628 VDD VSS n10624 NAND2X1
XU10972 n10629 n10630 VDD VSS n10628 NAND2X1
XU10973 n10631 n9308 VDD VSS n10630 NAND2X1
XU10974 n10632 n10633 VDD VSS n10629 NOR2X1
XU10975 n9313 n10634 VDD VSS n10633 AND2X1
XU10976 n10635 n10636 VDD VSS n10632 NOR2X1
XU10977 n10637 n9307 VDD VSS n10636 NAND2X1
XU10978 n10638 n10639 VDD VSS n10621 NOR2X1
XU10979 n10627 n10640 VDD VSS n10639 NOR2X1
XU10980 n10641 n10642 VDD VSS n10640 NOR2X1
XU10981 n10643 n9302 VDD VSS n10642 NOR2X1
XU10982 n10644 n10645 VDD VSS n10643 NOR2X1
XU10983 n10646 n10647 VDD VSS n10645 NAND2X1
XU10984 n10631 n9313 VDD VSS n10647 NAND2X1
XU10985 n9308 n9296 VDD VSS n9313 NOR2X1
XU10986 n10648 n275 VDD VSS n10646 NAND2X1
XU10987 n9296 n10634 VDD VSS n10641 AND2X1
XU10988 n10637 n10649 VDD VSS n10638 NOR2X1
XU10989 n10650 n9308 VDD VSS n10649 NAND2X1
XU10990 n10651 n10652 VDD VSS n10650 NAND2X1
XU10991 n273 n10653 VDD VSS n10652 NAND2X1
XU10992 n10627 n276 VDD VSS n10651 NAND2X1
XU10993 n10606 n10654 VDD VSS n10620 NAND2X1
XU10994 n10284 n10604 VDD VSS n10654 OR2X1
XU10995 n10655 n10656 VDD VSS n10604 NAND2X1
XU10996 n10657 n10658 VDD VSS n10656 NAND2X1
XU10997 n276 n10659 VDD VSS n10658 NAND2X1
XU10998 n277 n10660 VDD VSS n10659 NAND2X1
XU10999 n10661 n10662 VDD VSS n10657 NOR2X1
XU11000 n273 n10663 VDD VSS n10662 NOR2X1
XU11001 n10631 n10637 VDD VSS n10663 NOR2X1
XU11002 n10635 n9302 VDD VSS n10661 NOR2X1
XU11003 n10664 n10665 VDD VSS n10655 NOR2X1
XU11004 n10666 n10660 VDD VSS n10665 NOR2X1
XU11005 n10667 n10668 VDD VSS n10666 NOR2X1
XU11006 n10669 n10670 VDD VSS n10668 NAND2X1
XU11007 n10671 n10631 VDD VSS n10670 NAND2X1
XU11008 n10672 n9316 VDD VSS n10671 NOR2X1
XU11009 n275 n276 VDD VSS n9316 NAND2X1
XU11010 n10673 n9296 VDD VSS n10669 NAND2X1
XU11011 n10653 n10674 VDD VSS n10673 NAND2X1
XU11012 n10626 n9302 VDD VSS n10674 NAND2X1
XU11013 n10675 n9308 VDD VSS n10667 NOR2X1
XU11014 n10627 n10676 VDD VSS n10664 NOR2X1
XU11015 n10677 n10678 VDD VSS n10676 NOR2X1
XU11016 n276 n10675 VDD VSS n10678 NOR2X1
XU11017 n10679 n10680 VDD VSS n10675 AND2X1
XU11018 n10672 n9302 VDD VSS n10680 NAND2X1
XU11019 n10634 n273 VDD VSS n10679 NAND2X1
XU11020 n10631 n10672 VDD VSS n10634 NOR2X1
XU11021 n10653 VDD VSS n10631 INVX1
XU11022 n275 n10681 VDD VSS n10677 NOR2X1
XU11023 n10682 n10648 VDD VSS n10681 NOR2X1
XU11024 n10683 n276 VDD VSS n10648 AND2X1
XU11025 n10672 n10635 VDD VSS n10683 NOR2X1
XU11026 n10626 VDD VSS n10635 INVX1
XU11027 n10684 n10685 VDD VSS n10626 NAND2X1
XU11028 g1777 g5738 VDD VSS n10685 NAND2X1
XU11029 n10686 n10687 VDD VSS n10684 AND2X1
XU11030 g1705 g1718 VDD VSS n10687 NAND2X1
XU11031 g1775 g5695 VDD VSS n10686 NAND2X1
XU11032 n10637 VDD VSS n10672 INVX1
XU11033 n10644 n10653 VDD VSS n10682 NOR2X1
XU11034 n10688 n10689 VDD VSS n10653 NAND2X1
XU11035 g1762 g5738 VDD VSS n10689 NAND2X1
XU11036 n10690 n10691 VDD VSS n10688 AND2X1
XU11037 g1764 g1718 VDD VSS n10691 NAND2X1
XU11038 g1760 g5695 VDD VSS n10690 NAND2X1
XU11039 n276 n10637 VDD VSS n10644 NOR2X1
XU11040 n10692 n10693 VDD VSS n10637 NAND2X1
XU11041 g1747 g5738 VDD VSS n10693 NAND2X1
XU11042 n10694 n10695 VDD VSS n10692 AND2X1
XU11043 g1749 g1718 VDD VSS n10695 NAND2X1
XU11044 g1745 g5695 VDD VSS n10694 NAND2X1
XU11045 n10660 VDD VSS n10627 INVX1
XU11046 n10696 n10697 VDD VSS n10660 NAND2X1
XU11047 g1734 g1718 VDD VSS n10697 NAND2X1
XU11048 n10698 n10699 VDD VSS n10696 AND2X1
XU11049 g5695 g1730 VDD VSS n10699 NAND2X1
XU11050 g5738 g1732 VDD VSS n10698 NAND2X1
XU11051 n10590 n10284 VDD VSS n10606 NAND2X1
XU11052 n10700 n10701 VDD VSS n10284 NAND2X1
XU11053 n10702 n10703 VDD VSS n10701 NOR2X1
XU11054 n9220 n10283 VDD VSS n10703 NOR2X1
XU11055 g1982 VDD VSS n10283 INVX1
XU11056 n10704 g1922 VDD VSS n10702 AND2X1
XU11057 n8420 g185 VDD VSS n10704 AND2X1
XU11058 n10705 n10706 VDD VSS n8420 NAND2X1
XU11059 g1947 g7194 VDD VSS n10706 NAND2X1
XU11060 n10707 n10708 VDD VSS n10705 AND2X1
XU11061 g1870 g1930 VDD VSS n10708 NAND2X1
XU11062 g1945 g7052 VDD VSS n10707 NAND2X1
XU11063 n10709 n10710 VDD VSS n10700 NOR2X1
XU11064 n9229 n10280 VDD VSS n10710 NOR2X1
XU11065 g1979 VDD VSS n10280 INVX1
XU11066 n9230 n10276 VDD VSS n10709 NOR2X1
XU11067 g1976 VDD VSS n10276 INVX1
XU11068 n10711 n10712 VDD VSS n10590 NAND2X1
XU11069 n10713 n10714 VDD VSS n10712 NOR2X1
XU11070 n9220 n10589 VDD VSS n10714 NOR2X1
XU11071 g1973 VDD VSS n10589 INVX1
XU11072 n10715 g1904 VDD VSS n10713 AND2X1
XU11073 n8419 g185 VDD VSS n10715 AND2X1
XU11074 n10716 n10717 VDD VSS n8419 NAND2X1
XU11075 g1951 g7194 VDD VSS n10717 NAND2X1
XU11076 n10718 n10719 VDD VSS n10716 AND2X1
XU11077 g1953 g1930 VDD VSS n10719 NAND2X1
XU11078 g1949 g7052 VDD VSS n10718 NAND2X1
XU11079 n10720 n10721 VDD VSS n10711 NOR2X1
XU11080 n9229 n10586 VDD VSS n10721 NOR2X1
XU11081 g1970 VDD VSS n10586 INVX1
XU11082 g7194 VDD VSS n9229 INVX1
XU11083 n9230 n10582 VDD VSS n10720 NOR2X1
XU11084 g1967 VDD VSS n10582 INVX1
XU11085 n10722 n10723 VDD VSS n8103 NAND2X1
XU11086 n10724 n8880 VDD VSS n10723 NAND2X1
XU11087 g7302 n10725 VDD VSS n10722 NAND2X1
XU11088 n10726 n10727 VDD VSS n8102 NAND2X1
XU11089 n10728 n8879 VDD VSS n10727 NAND2X1
XU11090 g7390 n10725 VDD VSS n10726 NAND2X1
XU11091 n10729 n10730 VDD VSS n8101 NAND2X1
XU11092 n8870 n10731 VDD VSS n10730 NAND2X1
XU11093 g2624 n10725 VDD VSS n10729 NAND2X1
XU11094 n10261 n10732 VDD VSS n10725 NAND2X1
XU11095 n10733 n10734 VDD VSS n8100 NAND2X1
XU11096 n10735 n8880 VDD VSS n10734 NAND2X1
XU11097 n10736 g7302 VDD VSS n10733 NAND2X1
XU11098 n10737 n10738 VDD VSS n8099 NAND2X1
XU11099 g2682 g7390 VDD VSS n10738 OR2X1
XU11100 n10736 g7390 VDD VSS n10737 NAND2X1
XU11101 n10739 n10740 VDD VSS n8098 NAND2X1
XU11102 n8870 n10741 VDD VSS n10740 NAND2X1
XU11103 n10736 g2624 VDD VSS n10739 NAND2X1
XU11104 n10742 n10743 VDD VSS n10736 AND2X1
XU11105 n10744 n10745 VDD VSS n10743 NAND2X1
XU11106 n10746 VDD VSS n10745 INVX1
XU11107 n10747 n10748 VDD VSS n10744 NOR2X1
XU11108 n10749 n10732 VDD VSS n10747 NOR2X1
XU11109 n8894 n10261 VDD VSS n10742 NAND2X1
XU11110 n10750 n10751 VDD VSS n8097 NAND2X1
XU11111 n10752 n8880 VDD VSS n10751 NAND2X1
XU11112 n10753 g7302 VDD VSS n10750 NAND2X1
XU11113 n10754 n10755 VDD VSS n8096 NAND2X1
XU11114 g2691 g7390 VDD VSS n10755 OR2X1
XU11115 n10753 g7390 VDD VSS n10754 NAND2X1
XU11116 n10756 n10757 VDD VSS n8095 NAND2X1
XU11117 n8870 n10758 VDD VSS n10757 NAND2X1
XU11118 n10753 g2624 VDD VSS n10756 NAND2X1
XU11119 n10759 n10760 VDD VSS n10753 AND2X1
XU11120 n10761 n10762 VDD VSS n10760 NAND2X1
XU11121 n10748 VDD VSS n10762 INVX1
XU11122 n8867 n10763 VDD VSS n10748 NAND2X1
XU11123 n10732 n10437 VDD VSS n10763 NAND2X1
XU11124 n10764 n10765 VDD VSS n10732 NAND2X1
XU11125 n10766 n10767 VDD VSS n10765 NOR2X1
XU11126 n8870 n10731 VDD VSS n10767 NOR2X1
XU11127 g2667 VDD VSS n10731 INVX1
XU11128 n10768 g2598 VDD VSS n10766 AND2X1
XU11129 n8519 g185 VDD VSS n10768 AND2X1
XU11130 n10769 n10770 VDD VSS n8519 NAND2X1
XU11131 g2645 g7390 VDD VSS n10770 NAND2X1
XU11132 n10771 n10772 VDD VSS n10769 AND2X1
XU11133 g2647 g2624 VDD VSS n10772 NAND2X1
XU11134 g2643 g7302 VDD VSS n10771 NAND2X1
XU11135 n10773 n10774 VDD VSS n10764 NOR2X1
XU11136 n8879 n10728 VDD VSS n10774 NOR2X1
XU11137 g2664 VDD VSS n10728 INVX1
XU11138 n8880 n10724 VDD VSS n10773 NOR2X1
XU11139 g2661 VDD VSS n10724 INVX1
XU11140 n10261 VDD VSS n8867 INVX1
XU11141 n10775 n10749 VDD VSS n10761 NOR2X1
XU11142 n10776 n10777 VDD VSS n10749 NAND2X1
XU11143 n10778 n8952 VDD VSS n10777 NAND2X1
XU11144 n10779 n10780 VDD VSS n10778 NAND2X1
XU11145 n10781 n8966 VDD VSS n10780 OR2X1
XU11146 n10782 n10783 VDD VSS n10779 NAND2X1
XU11147 n10784 n10785 VDD VSS n10783 NAND2X1
XU11148 n10786 n8958 VDD VSS n10785 NAND2X1
XU11149 n10787 n10788 VDD VSS n10784 NOR2X1
XU11150 n8963 n10789 VDD VSS n10788 AND2X1
XU11151 n10790 n10791 VDD VSS n10787 NOR2X1
XU11152 n10792 n8957 VDD VSS n10791 NAND2X1
XU11153 n10793 n10794 VDD VSS n10776 NOR2X1
XU11154 n10782 n10795 VDD VSS n10794 NOR2X1
XU11155 n10796 n10797 VDD VSS n10795 NOR2X1
XU11156 n10798 n8952 VDD VSS n10797 NOR2X1
XU11157 n10799 n10800 VDD VSS n10798 NOR2X1
XU11158 n10801 n10802 VDD VSS n10800 NAND2X1
XU11159 n10786 n8963 VDD VSS n10802 NAND2X1
XU11160 n8958 n8946 VDD VSS n8963 NOR2X1
XU11161 n10803 n333 VDD VSS n10801 NAND2X1
XU11162 n8946 n10789 VDD VSS n10796 AND2X1
XU11163 n10792 n10804 VDD VSS n10793 NOR2X1
XU11164 n10805 n8958 VDD VSS n10804 NAND2X1
XU11165 n10806 n10807 VDD VSS n10805 NAND2X1
XU11166 n331 n10808 VDD VSS n10807 NAND2X1
XU11167 n10782 n334 VDD VSS n10806 NAND2X1
XU11168 n10746 n10437 VDD VSS n10775 NOR2X1
XU11169 n10809 n10810 VDD VSS n10437 NAND2X1
XU11170 n10811 n10812 VDD VSS n10810 NOR2X1
XU11171 n8870 n10436 VDD VSS n10812 NOR2X1
XU11172 g2676 VDD VSS n10436 INVX1
XU11173 n10813 g2616 VDD VSS n10811 AND2X1
XU11174 n8520 g185 VDD VSS n10813 AND2X1
XU11175 n10814 n10815 VDD VSS n8520 NAND2X1
XU11176 g2641 g7390 VDD VSS n10815 NAND2X1
XU11177 n10816 n10817 VDD VSS n10814 AND2X1
XU11178 g2564 g2624 VDD VSS n10817 NAND2X1
XU11179 g2639 g7302 VDD VSS n10816 NAND2X1
XU11180 n10818 n10819 VDD VSS n10809 NOR2X1
XU11181 n8879 n10433 VDD VSS n10819 NOR2X1
XU11182 g2673 VDD VSS n10433 INVX1
XU11183 g7390 VDD VSS n8879 INVX1
XU11184 n8880 n10429 VDD VSS n10818 NOR2X1
XU11185 g2670 VDD VSS n10429 INVX1
XU11186 n10820 n10821 VDD VSS n10746 NAND2X1
XU11187 n10822 n10823 VDD VSS n10821 NAND2X1
XU11188 n334 n10824 VDD VSS n10823 NAND2X1
XU11189 n335 n10825 VDD VSS n10824 NAND2X1
XU11190 n10826 n10827 VDD VSS n10822 NOR2X1
XU11191 n331 n10828 VDD VSS n10827 NOR2X1
XU11192 n10786 n10792 VDD VSS n10828 NOR2X1
XU11193 n10790 n8952 VDD VSS n10826 NOR2X1
XU11194 n10829 n10830 VDD VSS n10820 NOR2X1
XU11195 n10831 n10825 VDD VSS n10830 NOR2X1
XU11196 n10832 n10833 VDD VSS n10831 NOR2X1
XU11197 n10834 n10835 VDD VSS n10833 NAND2X1
XU11198 n10836 n10786 VDD VSS n10835 NAND2X1
XU11199 n10837 n8966 VDD VSS n10836 NOR2X1
XU11200 n333 n334 VDD VSS n8966 NAND2X1
XU11201 n10838 n8946 VDD VSS n10834 NAND2X1
XU11202 n10808 n10839 VDD VSS n10838 NAND2X1
XU11203 n10781 n8952 VDD VSS n10839 NAND2X1
XU11204 n10840 n8958 VDD VSS n10832 NOR2X1
XU11205 n10782 n10841 VDD VSS n10829 NOR2X1
XU11206 n10842 n10843 VDD VSS n10841 NOR2X1
XU11207 n334 n10840 VDD VSS n10843 NOR2X1
XU11208 n10844 n10845 VDD VSS n10840 AND2X1
XU11209 n10837 n8952 VDD VSS n10845 NAND2X1
XU11210 n10789 n331 VDD VSS n10844 NAND2X1
XU11211 n10786 n10837 VDD VSS n10789 NOR2X1
XU11212 n10808 VDD VSS n10786 INVX1
XU11213 n333 n10846 VDD VSS n10842 NOR2X1
XU11214 n10847 n10803 VDD VSS n10846 NOR2X1
XU11215 n10848 n334 VDD VSS n10803 AND2X1
XU11216 n10837 n10790 VDD VSS n10848 NOR2X1
XU11217 n10781 VDD VSS n10790 INVX1
XU11218 n10849 n10850 VDD VSS n10781 NAND2X1
XU11219 g2471 g5796 VDD VSS n10850 NAND2X1
XU11220 n10851 n10852 VDD VSS n10849 AND2X1
XU11221 g2399 g2412 VDD VSS n10852 NAND2X1
XU11222 g2469 g5747 VDD VSS n10851 NAND2X1
XU11223 n10792 VDD VSS n10837 INVX1
XU11224 n10799 n10808 VDD VSS n10847 NOR2X1
XU11225 n10853 n10854 VDD VSS n10808 NAND2X1
XU11226 g2456 g5796 VDD VSS n10854 NAND2X1
XU11227 n10855 n10856 VDD VSS n10853 AND2X1
XU11228 g2458 g2412 VDD VSS n10856 NAND2X1
XU11229 g2454 g5747 VDD VSS n10855 NAND2X1
XU11230 n334 n10792 VDD VSS n10799 NOR2X1
XU11231 n10857 n10858 VDD VSS n10792 NAND2X1
XU11232 g2441 g5796 VDD VSS n10858 NAND2X1
XU11233 n10859 n10860 VDD VSS n10857 AND2X1
XU11234 g2443 g2412 VDD VSS n10860 NAND2X1
XU11235 g2439 g5747 VDD VSS n10859 NAND2X1
XU11236 n10825 VDD VSS n10782 INVX1
XU11237 n10861 n10862 VDD VSS n10825 NAND2X1
XU11238 g2428 g2412 VDD VSS n10862 NAND2X1
XU11239 n10863 n10864 VDD VSS n10861 AND2X1
XU11240 g5747 g2424 VDD VSS n10864 NAND2X1
XU11241 g5796 g2426 VDD VSS n10863 NAND2X1
XU11242 n8936 n10261 VDD VSS n10759 NAND2X1
XU11243 n10865 n10866 VDD VSS n10261 NAND2X1
XU11244 n10867 n10868 VDD VSS n10866 NOR2X1
XU11245 n10869 n8657 VDD VSS n10868 NAND2X1
XU11246 g3036 VDD VSS n8657 INVX1
XU11247 n10870 n8662 VDD VSS n10865 NOR2X1
XU11248 g3028 VDD VSS n8662 INVX1
XU11249 n10871 n10872 VDD VSS n8094 NAND2X1
XU11250 g3109 n10873 VDD VSS n10872 NAND2X1
XU11251 g3084 g3109 VDD VSS n10871 OR2X1
XU11252 n10874 n10875 VDD VSS n8093 NAND2X1
XU11253 n10876 n10877 VDD VSS n10875 NAND2X1
XU11254 g3109 n10878 VDD VSS n10874 NAND2X1
XU11255 n10879 n10880 VDD VSS n8092 NAND2X1
XU11256 n10881 n10877 VDD VSS n10880 NAND2X1
XU11257 g3109 n10882 VDD VSS n10879 NAND2X1
XU11258 n10883 n10884 VDD VSS n8091 NAND2X1
XU11259 n10885 n10877 VDD VSS n10884 NAND2X1
XU11260 g3109 n10886 VDD VSS n10883 NAND2X1
XU11261 n10887 n10888 VDD VSS n8090 NAND2X1
XU11262 n10889 n10877 VDD VSS n10888 NAND2X1
XU11263 g3109 n162 VDD VSS n10887 NAND2X1
XU11264 n10890 n10891 VDD VSS n8089 NAND2X1
XU11265 g3109 II15499 VDD VSS n10891 NAND2X1
XU11266 g3109 g3161 VDD VSS n10890 OR2X1
XU11267 n10892 n10893 VDD VSS n8088 NAND2X1
XU11268 n10894 n10877 VDD VSS n10893 NAND2X1
XU11269 g3109 n8176 VDD VSS n10892 NAND2X1
XU11270 n10895 n10896 VDD VSS n8087 NAND2X1
XU11271 n10877 n10897 VDD VSS n10896 NAND2X1
XU11272 g3109 II15505 VDD VSS n10895 NAND2X1
XU11273 n10898 n10899 VDD VSS n8086 NAND2X1
XU11274 n10900 n10877 VDD VSS n10899 NAND2X1
XU11275 g3109 n8175 VDD VSS n10898 NAND2X1
XU11276 n10901 n10902 VDD VSS n8085 NAND2X1
XU11277 n10877 n10903 VDD VSS n10902 NAND2X1
XU11278 g3109 II15511 VDD VSS n10901 NAND2X1
XU11279 n10904 n10905 VDD VSS n8084 NAND2X1
XU11280 n10906 n10877 VDD VSS n10905 NAND2X1
XU11281 g3109 n8174 VDD VSS n10904 NAND2X1
XU11282 n10907 n10908 VDD VSS n8083 NAND2X1
XU11283 n10909 n10877 VDD VSS n10908 NAND2X1
XU11284 g3109 VDD VSS n10877 INVX1
XU11285 g3109 II15517 VDD VSS n10907 NAND2X1
XU11286 n10910 n10911 VDD VSS n8082 NAND2X1
XU11287 g3086 g8030 VDD VSS n10911 OR2X1
XU11288 g8030 n10878 VDD VSS n10910 NAND2X1
XU11289 n10912 n10913 VDD VSS n8081 NAND2X1
XU11290 n10914 n10915 VDD VSS n10913 NAND2X1
XU11291 g8030 n10882 VDD VSS n10912 NAND2X1
XU11292 n10916 n10917 VDD VSS n8080 NAND2X1
XU11293 n10918 n10915 VDD VSS n10917 NAND2X1
XU11294 g8030 n10886 VDD VSS n10916 NAND2X1
XU11295 n10919 n10920 VDD VSS n8079 NAND2X1
XU11296 g3098 g8030 VDD VSS n10920 OR2X1
XU11297 g8030 n162 VDD VSS n10919 NAND2X1
XU11298 n10921 n10922 VDD VSS n8078 NAND2X1
XU11299 g8030 II15499 VDD VSS n10922 NAND2X1
XU11300 g3158 g8030 VDD VSS n10921 OR2X1
XU11301 n10923 n10924 VDD VSS n8077 NAND2X1
XU11302 n10925 n10915 VDD VSS n10924 NAND2X1
XU11303 g8030 n8176 VDD VSS n10923 NAND2X1
XU11304 n10926 n10927 VDD VSS n8076 NAND2X1
XU11305 n10928 n10915 VDD VSS n10927 NAND2X1
XU11306 g8030 II15505 VDD VSS n10926 NAND2X1
XU11307 n10929 n10930 VDD VSS n8075 NAND2X1
XU11308 n10931 n10915 VDD VSS n10930 NAND2X1
XU11309 g8030 n8175 VDD VSS n10929 NAND2X1
XU11310 n10932 n10933 VDD VSS n8074 NAND2X1
XU11311 n10934 n10915 VDD VSS n10933 NAND2X1
XU11312 g8030 II15511 VDD VSS n10932 NAND2X1
XU11313 n10935 n10936 VDD VSS n8073 NAND2X1
XU11314 n10937 n10915 VDD VSS n10936 NAND2X1
XU11315 g8030 n8174 VDD VSS n10935 NAND2X1
XU11316 n10938 n10939 VDD VSS n8072 NAND2X1
XU11317 n10940 n10915 VDD VSS n10939 NAND2X1
XU11318 g8030 VDD VSS n10915 INVX1
XU11319 g8030 II15517 VDD VSS n10938 NAND2X1
XU11320 n10941 n10942 VDD VSS n8071 NAND2X1
XU11321 g8030 n10873 VDD VSS n10942 NAND2X1
XU11322 g3211 g8030 VDD VSS n10941 OR2X1
XU11323 n10943 n10944 VDD VSS n8070 NAND2X1
XU11324 g3085 g8106 VDD VSS n10944 OR2X1
XU11325 g8106 n10878 VDD VSS n10943 NAND2X1
XU11326 g1245 VDD VSS n10878 INVX1
XU11327 n10945 n10946 VDD VSS n8069 NAND2X1
XU11328 n10947 n10948 VDD VSS n10946 NAND2X1
XU11329 g8106 n10882 VDD VSS n10945 NAND2X1
XU11330 g1939 VDD VSS n10882 INVX1
XU11331 n10949 n10950 VDD VSS n8068 NAND2X1
XU11332 n10951 n10948 VDD VSS n10950 NAND2X1
XU11333 g8106 n10886 VDD VSS n10949 NAND2X1
XU11334 g2633 VDD VSS n10886 INVX1
XU11335 n10952 n10953 VDD VSS n8067 NAND2X1
XU11336 g3097 g8106 VDD VSS n10953 OR2X1
XU11337 g8106 n162 VDD VSS n10952 NAND2X1
XU11338 n10954 n10955 VDD VSS n8066 NAND2X1
XU11339 g8106 II15499 VDD VSS n10955 NAND2X1
XU11340 n10956 n10948 VDD VSS n10954 NAND2X1
XU11341 n10957 n10958 VDD VSS n8065 NAND2X1
XU11342 g3100 g8106 VDD VSS n10958 OR2X1
XU11343 g8106 n8176 VDD VSS n10957 NAND2X1
XU11344 n10959 n10960 VDD VSS n8064 NAND2X1
XU11345 g3164 g8106 VDD VSS n10960 OR2X1
XU11346 g8106 II15505 VDD VSS n10959 NAND2X1
XU11347 n10961 n10962 VDD VSS n8063 NAND2X1
XU11348 n10963 n10948 VDD VSS n10962 NAND2X1
XU11349 g8106 n8175 VDD VSS n10961 NAND2X1
XU11350 n10964 n10965 VDD VSS n8062 NAND2X1
XU11351 n10966 n10948 VDD VSS n10965 NAND2X1
XU11352 g8106 II15511 VDD VSS n10964 NAND2X1
XU11353 n10967 n10968 VDD VSS n8061 NAND2X1
XU11354 n10969 n10948 VDD VSS n10968 NAND2X1
XU11355 g8106 n8174 VDD VSS n10967 NAND2X1
XU11356 n10970 n10971 VDD VSS n8060 NAND2X1
XU11357 n10972 n10948 VDD VSS n10971 NAND2X1
XU11358 g8106 II15517 VDD VSS n10970 NAND2X1
XU11359 n10973 n10974 VDD VSS n8059 NAND2X1
XU11360 g8106 n10873 VDD VSS n10974 NAND2X1
XU11361 g559 VDD VSS n10873 INVX1
XU11362 n10975 n10948 VDD VSS n10973 NAND2X1
XU11363 g8106 VDD VSS n10948 INVX1
XU11364 n10976 n10977 VDD VSS n8058 NAND2X1
XU11365 n9038 g2165 VDD VSS n10977 NAND2X1
XU11366 n9039 n10978 VDD VSS n10976 NAND2X1
XU11367 n10979 n10980 VDD VSS n8057 NAND2X1
XU11368 n9023 g2165 VDD VSS n10980 NAND2X1
XU11369 n9023 g2207 VDD VSS n10979 OR2X1
XU11370 n10981 n10982 VDD VSS n8056 NAND2X1
XU11371 g2165 n9027 VDD VSS n10982 NAND2X1
XU11372 n9028 n10983 VDD VSS n10981 NAND2X1
XU11373 n10984 n10985 VDD VSS n8055 NAND2X1
XU11374 n9038 g2170 VDD VSS n10985 NAND2X1
XU11375 n9039 n10986 VDD VSS n10984 NAND2X1
XU11376 n10987 n10988 VDD VSS n8054 NAND2X1
XU11377 n9023 g2170 VDD VSS n10988 NAND2X1
XU11378 n9023 g2210 VDD VSS n10987 OR2X1
XU11379 n10989 n10990 VDD VSS n8053 NAND2X1
XU11380 g2170 n9027 VDD VSS n10990 NAND2X1
XU11381 n9028 n10991 VDD VSS n10989 NAND2X1
XU11382 n10992 n10993 VDD VSS n8052 NAND2X1
XU11383 n9038 g2175 VDD VSS n10993 NAND2X1
XU11384 n9039 n10994 VDD VSS n10992 NAND2X1
XU11385 n10995 n10996 VDD VSS n8051 NAND2X1
XU11386 n9023 g2175 VDD VSS n10996 NAND2X1
XU11387 n10997 n10998 VDD VSS n10995 NAND2X1
XU11388 n10999 n11000 VDD VSS n8050 NAND2X1
XU11389 g2175 n9027 VDD VSS n11000 NAND2X1
XU11390 n9028 n11001 VDD VSS n10999 NAND2X1
XU11391 n11002 n11003 VDD VSS n8049 NAND2X1
XU11392 n9038 g2180 VDD VSS n11003 NAND2X1
XU11393 n9039 n11004 VDD VSS n11002 NAND2X1
XU11394 n11005 n11006 VDD VSS n8048 NAND2X1
XU11395 n9023 g2180 VDD VSS n11006 NAND2X1
XU11396 n10997 n11007 VDD VSS n11005 NAND2X1
XU11397 n11008 n11009 VDD VSS n8047 NAND2X1
XU11398 g2180 n9027 VDD VSS n11009 NAND2X1
XU11399 n9028 n11010 VDD VSS n11008 NAND2X1
XU11400 n11011 n11012 VDD VSS n8046 NAND2X1
XU11401 n9038 g2185 VDD VSS n11012 NAND2X1
XU11402 n9039 n11013 VDD VSS n11011 NAND2X1
XU11403 n11014 n11015 VDD VSS n8045 NAND2X1
XU11404 n9023 g2185 VDD VSS n11015 NAND2X1
XU11405 n10997 n11016 VDD VSS n11014 NAND2X1
XU11406 n11017 n11018 VDD VSS n8044 NAND2X1
XU11407 g2185 n9027 VDD VSS n11018 NAND2X1
XU11408 n9028 n11019 VDD VSS n11017 NAND2X1
XU11409 n11020 n11021 VDD VSS n8043 NAND2X1
XU11410 n9038 g2190 VDD VSS n11021 NAND2X1
XU11411 n9039 n11022 VDD VSS n11020 NAND2X1
XU11412 n11023 n11024 VDD VSS n8042 NAND2X1
XU11413 n9023 g2190 VDD VSS n11024 NAND2X1
XU11414 n10997 n11025 VDD VSS n11023 NAND2X1
XU11415 n11026 n11027 VDD VSS n8041 NAND2X1
XU11416 g2190 n9027 VDD VSS n11027 NAND2X1
XU11417 n9028 n11028 VDD VSS n11026 NAND2X1
XU11418 n11029 n11030 VDD VSS n8040 NAND2X1
XU11419 n9038 g2195 VDD VSS n11030 NAND2X1
XU11420 n9039 n11031 VDD VSS n11029 NAND2X1
XU11421 n11032 n11033 VDD VSS n8039 NAND2X1
XU11422 n9023 g2195 VDD VSS n11033 NAND2X1
XU11423 n10997 n11034 VDD VSS n11032 NAND2X1
XU11424 n11035 n11036 VDD VSS n8038 NAND2X1
XU11425 g2195 n9027 VDD VSS n11036 NAND2X1
XU11426 n9028 n11037 VDD VSS n11035 NAND2X1
XU11427 n9027 VDD VSS n9028 INVX1
XU11428 n11038 n11039 VDD VSS n8037 NAND2X1
XU11429 n11040 n11041 VDD VSS n11039 NAND2X1
XU11430 n11042 g5555 VDD VSS n11038 NAND2X1
XU11431 n11043 n11044 VDD VSS n8036 NAND2X1
XU11432 g2507 g7264 VDD VSS n11044 OR2X1
XU11433 n11042 g7264 VDD VSS n11043 NAND2X1
XU11434 n11045 n11046 VDD VSS n8035 NAND2X1
XU11435 n11047 n11048 VDD VSS n11046 NAND2X1
XU11436 n11042 g2476 VDD VSS n11045 NAND2X1
XU11437 n11049 n11050 VDD VSS n11042 NAND2X1
XU11438 n11051 n11052 VDD VSS n11050 NAND2X1
XU11439 g2384 n11053 VDD VSS n11049 NAND2X1
XU11440 n11054 n11055 VDD VSS n8034 NAND2X1
XU11441 n11056 n11041 VDD VSS n11055 NAND2X1
XU11442 n11057 g5555 VDD VSS n11054 NAND2X1
XU11443 n11058 n11059 VDD VSS n8033 NAND2X1
XU11444 n11060 n10188 VDD VSS n11059 NAND2X1
XU11445 n11057 g7264 VDD VSS n11058 NAND2X1
XU11446 n11061 n11062 VDD VSS n8032 NAND2X1
XU11447 g2476 g2519 VDD VSS n11062 OR2X1
XU11448 n11057 g2476 VDD VSS n11061 NAND2X1
XU11449 n11063 n11064 VDD VSS n11057 XOR2X1
XU11450 n11065 g2384 VDD VSS n11063 NAND2X1
XU11451 n11066 n11067 VDD VSS n11065 NOR2X1
XU11452 n11068 n11069 VDD VSS n8031 NAND2X1
XU11453 n11070 n11071 VDD VSS n11069 NAND2X1
XU11454 g2522 VDD VSS n11071 INVX1
XU11455 n11072 g2476 VDD VSS n11070 NAND2X1
XU11456 n11073 g2476 VDD VSS n11068 NAND2X1
XU11457 n11074 n11075 VDD VSS n8030 NAND2X1
XU11458 n11076 n11077 VDD VSS n11075 NAND2X1
XU11459 n11072 g7264 VDD VSS n11076 NAND2X1
XU11460 n11073 g7264 VDD VSS n11074 NAND2X1
XU11461 n11078 n11079 VDD VSS n8029 NAND2X1
XU11462 n11080 n11081 VDD VSS n11079 NAND2X1
XU11463 g2523 VDD VSS n11081 INVX1
XU11464 n11072 g5555 VDD VSS n11080 NAND2X1
XU11465 n11082 g2384 VDD VSS n11072 AND2X1
XU11466 n11083 n11084 VDD VSS n11082 NOR2X1
XU11467 n11085 n11086 VDD VSS n11084 NOR2X1
XU11468 n11064 n11053 VDD VSS n11085 NOR2X1
XU11469 n11051 n11087 VDD VSS n11083 NOR2X1
XU11470 n9016 n11088 VDD VSS n11087 NOR2X1
XU11471 n11073 g5555 VDD VSS n11078 NAND2X1
XU11472 n11089 n11066 VDD VSS n11073 AND2X1
XU11473 n11090 n11091 VDD VSS n11066 AND2X1
XU11474 g7264 n11077 VDD VSS n11091 NAND2X1
XU11475 g2524 VDD VSS n11077 INVX1
XU11476 n11092 n11093 VDD VSS n11090 NOR2X1
XU11477 g2523 n11041 VDD VSS n11093 NOR2X1
XU11478 g2522 n11047 VDD VSS n11092 NOR2X1
XU11479 n11067 n11052 VDD VSS n11089 NOR2X1
XU11480 n11094 n11095 VDD VSS n11067 AND2X1
XU11481 n11096 n11064 VDD VSS n11095 NAND2X1
XU11482 n11088 n11086 VDD VSS n11096 NOR2X1
XU11483 n11053 VDD VSS n11088 INVX1
XU11484 n11097 n9016 VDD VSS n11094 NAND2X1
XU11485 n11064 VDD VSS n9016 INVX1
XU11486 n11098 n11099 VDD VSS n11064 NAND2X1
XU11487 g2519 g2476 VDD VSS n11099 NAND2X1
XU11488 n11100 n11101 VDD VSS n11098 NOR2X1
XU11489 n10188 n11060 VDD VSS n11101 NOR2X1
XU11490 g2516 VDD VSS n11060 INVX1
XU11491 n11041 n11056 VDD VSS n11100 NOR2X1
XU11492 g2513 VDD VSS n11056 INVX1
XU11493 n11051 n11053 VDD VSS n11097 NOR2X1
XU11494 n11102 n11103 VDD VSS n11053 NAND2X1
XU11495 n11104 n11105 VDD VSS n11103 NAND2X1
XU11496 g7084 n11106 VDD VSS n11105 NAND2X1
XU11497 n11107 n11108 VDD VSS n11104 NOR2X1
XU11498 g2254 n11109 VDD VSS n11108 NOR2X1
XU11499 g2253 n11110 VDD VSS n11107 NOR2X1
XU11500 n11086 VDD VSS n11051 INVX1
XU11501 n11111 n11112 VDD VSS n11086 NAND2X1
XU11502 g2507 g7264 VDD VSS n11112 NAND2X1
XU11503 n11113 n11114 VDD VSS n11111 NOR2X1
XU11504 n11041 n11040 VDD VSS n11114 NOR2X1
XU11505 g2504 VDD VSS n11040 INVX1
XU11506 n11047 n11048 VDD VSS n11113 NOR2X1
XU11507 g2510 VDD VSS n11048 INVX1
XU11508 n11115 n11116 VDD VSS n8028 NAND2X1
XU11509 n11117 n11041 VDD VSS n11116 NAND2X1
XU11510 n11118 g5555 VDD VSS n11115 NAND2X1
XU11511 n11119 n11120 VDD VSS n8027 NAND2X1
XU11512 g2495 g7264 VDD VSS n11120 OR2X1
XU11513 n11118 g7264 VDD VSS n11119 NAND2X1
XU11514 n11121 n11122 VDD VSS n8026 NAND2X1
XU11515 n11047 n11123 VDD VSS n11122 NAND2X1
XU11516 n11118 g2476 VDD VSS n11121 NAND2X1
XU11517 n9009 n11124 VDD VSS n11118 XOR2X1
XU11518 n11125 n11126 VDD VSS n11124 NOR2X1
XU11519 n11127 n11128 VDD VSS n11126 NOR2X1
XU11520 g2384 n11129 VDD VSS n11128 NAND2X1
XU11521 n11130 n11131 VDD VSS n11127 NAND2X1
XU11522 n321 n11132 VDD VSS n11131 NAND2X1
XU11523 n11133 n11134 VDD VSS n11132 NAND2X1
XU11524 n11135 n9009 VDD VSS n11130 NAND2X1
XU11525 n11134 n11136 VDD VSS n11135 NAND2X1
XU11526 n11137 n11138 VDD VSS n11125 NOR2X1
XU11527 n321 n11133 VDD VSS n11138 NAND2X1
XU11528 n11136 VDD VSS n11133 INVX1
XU11529 n11139 g2384 VDD VSS n11137 NAND2X1
XU11530 n11140 n11141 VDD VSS n8025 NAND2X1
XU11531 n11142 n11143 VDD VSS n11141 NAND2X1
XU11532 g2502 VDD VSS n11143 INVX1
XU11533 n11144 g5555 VDD VSS n11142 NAND2X1
XU11534 n11145 g5555 VDD VSS n11140 NAND2X1
XU11535 n11146 n11147 VDD VSS n8024 NAND2X1
XU11536 n11148 n11149 VDD VSS n11147 NAND2X1
XU11537 n11144 g7264 VDD VSS n11148 NAND2X1
XU11538 n11145 g7264 VDD VSS n11146 NAND2X1
XU11539 n11150 n11151 VDD VSS n8023 NAND2X1
XU11540 n11152 n11153 VDD VSS n11151 NAND2X1
XU11541 g2501 VDD VSS n11153 INVX1
XU11542 n11144 g2476 VDD VSS n11152 NAND2X1
XU11543 n11145 g2476 VDD VSS n11150 NAND2X1
XU11544 n11154 n11155 VDD VSS n11145 AND2X1
XU11545 n11156 n11157 VDD VSS n11155 NOR2X1
XU11546 n11052 n11134 VDD VSS n11154 NOR2X1
XU11547 n11158 n11159 VDD VSS n8022 NAND2X1
XU11548 n11160 n11041 VDD VSS n11159 NAND2X1
XU11549 n11161 g5555 VDD VSS n11158 NAND2X1
XU11550 n11162 n11163 VDD VSS n8021 NAND2X1
XU11551 g2486 g7264 VDD VSS n11163 OR2X1
XU11552 n11161 g7264 VDD VSS n11162 NAND2X1
XU11553 n11164 n11165 VDD VSS n8020 NAND2X1
XU11554 n11047 n11166 VDD VSS n11165 NAND2X1
XU11555 n11161 g2476 VDD VSS n11164 NAND2X1
XU11556 n11129 n11167 VDD VSS n11161 XOR2X1
XU11557 n11144 n11168 VDD VSS n11167 NOR2X1
XU11558 n11052 n11169 VDD VSS n11168 NOR2X1
XU11559 n11170 n11129 VDD VSS n11169 NAND2X1
XU11560 n11134 n11157 VDD VSS n11170 OR2X1
XU11561 n11171 n11172 VDD VSS n11134 NAND2X1
XU11562 g7264 n11149 VDD VSS n11172 NAND2X1
XU11563 g2503 VDD VSS n11149 INVX1
XU11564 n11173 n11174 VDD VSS n11171 NOR2X1
XU11565 g2502 n11041 VDD VSS n11174 NOR2X1
XU11566 g2501 n11047 VDD VSS n11173 NOR2X1
XU11567 n11175 n11156 VDD VSS n11144 AND2X1
XU11568 n11129 VDD VSS n11156 INVX1
XU11569 n11157 n11052 VDD VSS n11175 NOR2X1
XU11570 n11176 n11177 VDD VSS n11157 AND2X1
XU11571 n11136 n9009 VDD VSS n11177 NAND2X1
XU11572 n11178 n321 VDD VSS n11176 NAND2X1
XU11573 n11139 n11136 VDD VSS n11178 NOR2X1
XU11574 n11179 n11102 VDD VSS n11136 NAND2X1
XU11575 n11180 n11181 VDD VSS n11179 NOR2X1
XU11576 n11182 n11183 VDD VSS n11129 NAND2X1
XU11577 g2486 g7264 VDD VSS n11183 NAND2X1
XU11578 n11184 n11185 VDD VSS n11182 NOR2X1
XU11579 n11041 n11160 VDD VSS n11185 NOR2X1
XU11580 g2483 VDD VSS n11160 INVX1
XU11581 n11047 n11166 VDD VSS n11184 NOR2X1
XU11582 g2489 VDD VSS n11166 INVX1
XU11583 n11186 n11187 VDD VSS n8019 NAND2X1
XU11584 n9038 g2200 VDD VSS n11187 NAND2X1
XU11585 n9039 n11188 VDD VSS n11186 NAND2X1
XU11586 n9038 VDD VSS n9039 INVX1
XU11587 n11109 n11189 VDD VSS n9038 NOR2X1
XU11588 n11190 n11191 VDD VSS n8018 NAND2X1
XU11589 n9023 g2200 VDD VSS n11191 NAND2X1
XU11590 n10997 n11192 VDD VSS n11190 NAND2X1
XU11591 n9023 VDD VSS n10997 INVX1
XU11592 n11193 n11189 VDD VSS n9023 NOR2X1
XU11593 n11194 n11195 VDD VSS n8017 NAND2X1
XU11594 g2200 n9027 VDD VSS n11195 NAND2X1
XU11595 n9027 g2232 VDD VSS n11194 OR2X1
XU11596 n11196 n11197 VDD VSS n8016 NAND2X1
XU11597 n11198 n11199 VDD VSS n11197 NAND2X1
XU11598 g2478 VDD VSS n11199 INVX1
XU11599 g2384 g5555 VDD VSS n11198 NAND2X1
XU11600 n11200 g5555 VDD VSS n11196 NAND2X1
XU11601 n11201 n11202 VDD VSS n8015 NAND2X1
XU11602 n11203 n11204 VDD VSS n11202 NAND2X1
XU11603 g2479 VDD VSS n11204 INVX1
XU11604 g2384 g7264 VDD VSS n11203 NAND2X1
XU11605 n11200 g7264 VDD VSS n11201 NAND2X1
XU11606 n11205 n11206 VDD VSS n8014 NAND2X1
XU11607 n11207 n11208 VDD VSS n11206 NAND2X1
XU11608 g2384 g2476 VDD VSS n11207 NAND2X1
XU11609 n11200 g2476 VDD VSS n11205 NAND2X1
XU11610 n11209 n11210 VDD VSS n11200 NOR2X1
XU11611 g2384 n11211 VDD VSS n11209 NAND2X1
XU11612 n11212 n11213 VDD VSS n8013 NAND2X1
XU11613 g2387 g5555 VDD VSS n11213 OR2X1
XU11614 g5555 n11214 VDD VSS n11212 NAND2X1
XU11615 n11215 n11216 VDD VSS n8012 NAND2X1
XU11616 g2388 g7264 VDD VSS n11216 OR2X1
XU11617 g7264 n11214 VDD VSS n11215 NAND2X1
XU11618 n11217 n11218 VDD VSS n8011 NAND2X1
XU11619 n11219 n11047 VDD VSS n11218 NAND2X1
XU11620 g2476 n11214 VDD VSS n11217 NAND2X1
XU11621 n11220 n11221 VDD VSS n11214 NAND2X1
XU11622 n11222 n11223 VDD VSS n11221 NAND2X1
XU11623 n11224 n11225 VDD VSS n11222 NAND2X1
XU11624 n11226 n11227 VDD VSS n11224 NOR2X1
XU11625 n11228 n11229 VDD VSS n8010 NAND2X1
XU11626 n11230 n11109 VDD VSS n11229 NAND2X1
XU11627 n11231 g6837 VDD VSS n11228 NAND2X1
XU11628 n11232 n11233 VDD VSS n8009 NAND2X1
XU11629 g2291 g7084 VDD VSS n11233 OR2X1
XU11630 n11231 g7084 VDD VSS n11232 NAND2X1
XU11631 n11234 n11235 VDD VSS n8008 NAND2X1
XU11632 n11110 n11236 VDD VSS n11235 NAND2X1
XU11633 n11231 g2241 VDD VSS n11234 NAND2X1
XU11634 n11237 n11238 VDD VSS n11231 AND2X1
XU11635 n11239 n11240 VDD VSS n11238 NAND2X1
XU11636 n11241 n11242 VDD VSS n11239 XOR2X1
XU11637 n11243 g2195 VDD VSS n11237 NAND2X1
XU11638 n11244 n11245 VDD VSS n8007 NAND2X1
XU11639 n11110 n11246 VDD VSS n11245 NAND2X1
XU11640 g2241 n11247 VDD VSS n11244 NAND2X1
XU11641 n11248 n11249 VDD VSS n8006 NAND2X1
XU11642 n11250 n11109 VDD VSS n11249 NAND2X1
XU11643 g6837 n11247 VDD VSS n11248 NAND2X1
XU11644 n11251 n11252 VDD VSS n8005 NAND2X1
XU11645 g2327 g7084 VDD VSS n11252 OR2X1
XU11646 g7084 n11247 VDD VSS n11251 NAND2X1
XU11647 n11253 n11254 VDD VSS n11247 NAND2X1
XU11648 n11255 n11256 VDD VSS n11253 NOR2X1
XU11649 n11257 n11258 VDD VSS n11256 NOR2X1
XU11650 n11259 n11260 VDD VSS n11258 XOR2X1
XU11651 g2190 n11240 VDD VSS n11255 NOR2X1
XU11652 n11261 n11262 VDD VSS n8004 NAND2X1
XU11653 n11263 n11109 VDD VSS n11262 NAND2X1
XU11654 n11264 g6837 VDD VSS n11261 NAND2X1
XU11655 n11265 n11266 VDD VSS n8003 NAND2X1
XU11656 g2282 g7084 VDD VSS n11266 OR2X1
XU11657 n11264 g7084 VDD VSS n11265 NAND2X1
XU11658 n11267 n11268 VDD VSS n8002 NAND2X1
XU11659 n11110 n11269 VDD VSS n11268 NAND2X1
XU11660 n11264 g2241 VDD VSS n11267 NAND2X1
XU11661 n11270 n11271 VDD VSS n11264 AND2X1
XU11662 n11272 n11240 VDD VSS n11271 NAND2X1
XU11663 n11273 n11274 VDD VSS n11272 XOR2X1
XU11664 n11243 g2185 VDD VSS n11270 NAND2X1
XU11665 n11275 n11276 VDD VSS n8001 NAND2X1
XU11666 n11277 n11109 VDD VSS n11276 NAND2X1
XU11667 n11278 g6837 VDD VSS n11275 NAND2X1
XU11668 n11279 n11280 VDD VSS n8000 NAND2X1
XU11669 g2264 g7084 VDD VSS n11280 OR2X1
XU11670 n11278 g7084 VDD VSS n11279 NAND2X1
XU11671 g24909 VDD VSS n80 INVX1
XU11672 n11281 n11282 VDD VSS n7999 NAND2X1
XU11673 n11110 n11283 VDD VSS n11282 NAND2X1
XU11674 n11278 g2241 VDD VSS n11281 NAND2X1
XU11675 n11284 n11285 VDD VSS n11278 AND2X1
XU11676 n11240 n11286 VDD VSS n11285 NAND2X1
XU11677 n11287 n11288 VDD VSS n11286 XOR2X1
XU11678 n11243 g2165 VDD VSS n11284 NAND2X1
XU11679 n11289 n11290 VDD VSS n7998 NAND2X1
XU11680 n11291 n11109 VDD VSS n11290 NAND2X1
XU11681 g6837 n11292 VDD VSS n11289 NAND2X1
XU11682 n11293 n11294 VDD VSS n7997 NAND2X1
XU11683 g2345 g7084 VDD VSS n11294 OR2X1
XU11684 g7084 n11292 VDD VSS n11293 NAND2X1
XU11685 n11295 n11296 VDD VSS n7996 NAND2X1
XU11686 n11110 n11297 VDD VSS n11296 NAND2X1
XU11687 g2241 n11292 VDD VSS n11295 NAND2X1
XU11688 n11298 n11299 VDD VSS n11292 NAND2X1
XU11689 n11243 n11180 VDD VSS n11299 NAND2X1
XU11690 n11300 n11301 VDD VSS n11298 NOR2X1
XU11691 n11302 n11257 VDD VSS n11301 NOR2X1
XU11692 n11303 n11304 VDD VSS n11302 XOR2X1
XU11693 n11305 n11306 VDD VSS n11304 NOR2X1
XU11694 n11307 n11308 VDD VSS n11305 XOR2X1
XU11695 n11309 n11310 VDD VSS n7995 NAND2X1
XU11696 n11311 n11109 VDD VSS n11310 NAND2X1
XU11697 n11312 g6837 VDD VSS n11309 NAND2X1
XU11698 n11313 n11314 VDD VSS n7994 NAND2X1
XU11699 g2300 g7084 VDD VSS n11314 OR2X1
XU11700 n11312 g7084 VDD VSS n11313 NAND2X1
XU11701 n11315 n11316 VDD VSS n7993 NAND2X1
XU11702 n11110 n11317 VDD VSS n11316 NAND2X1
XU11703 n11312 g2241 VDD VSS n11315 NAND2X1
XU11704 n11318 n11319 VDD VSS n11312 AND2X1
XU11705 n11320 n11321 VDD VSS n11318 NOR2X1
XU11706 n11181 n11322 VDD VSS n11321 NOR2X1
XU11707 n11257 n11323 VDD VSS n11320 NOR2X1
XU11708 n11307 n11306 VDD VSS n11323 XOR2X1
XU11709 n11324 n11325 VDD VSS n11306 AND2X1
XU11710 n11326 n11327 VDD VSS n11325 OR2X1
XU11711 n11328 n11329 VDD VSS n11324 OR2X1
XU11712 n11330 n11331 VDD VSS n7992 NAND2X1
XU11713 n11332 n11109 VDD VSS n11331 NAND2X1
XU11714 g6837 n11333 VDD VSS n11330 NAND2X1
XU11715 n11334 n11335 VDD VSS n7991 NAND2X1
XU11716 g2318 g7084 VDD VSS n11335 OR2X1
XU11717 g7084 n11333 VDD VSS n11334 NAND2X1
XU11718 n11336 n11337 VDD VSS n7990 NAND2X1
XU11719 n11110 n11338 VDD VSS n11337 NAND2X1
XU11720 g2241 n11333 VDD VSS n11336 NAND2X1
XU11721 n11339 n11340 VDD VSS n11333 NAND2X1
XU11722 n11243 n11341 VDD VSS n11340 NAND2X1
XU11723 n11300 n11342 VDD VSS n11339 NOR2X1
XU11724 n11257 n11343 VDD VSS n11342 NOR2X1
XU11725 n11344 n11345 VDD VSS n11343 XOR2X1
XU11726 n11346 n11347 VDD VSS n11345 NOR2X1
XU11727 n11348 n11349 VDD VSS n7989 NAND2X1
XU11728 n11350 n11109 VDD VSS n11349 NAND2X1
XU11729 n11351 g6837 VDD VSS n11348 NAND2X1
XU11730 n11352 n11353 VDD VSS n7988 NAND2X1
XU11731 g2273 g7084 VDD VSS n11353 OR2X1
XU11732 n11351 g7084 VDD VSS n11352 NAND2X1
XU11733 n11354 n11355 VDD VSS n7987 NAND2X1
XU11734 n11110 n11356 VDD VSS n11355 NAND2X1
XU11735 n11351 g2241 VDD VSS n11354 NAND2X1
XU11736 n11357 n11319 VDD VSS n11351 AND2X1
XU11737 n11358 n11223 VDD VSS n11319 NAND2X1
XU11738 n11359 n11360 VDD VSS n11357 NOR2X1
XU11739 n11361 n11322 VDD VSS n11360 NOR2X1
XU11740 n11257 n11362 VDD VSS n11359 NOR2X1
XU11741 n11363 n11364 VDD VSS n11362 XOR2X1
XU11742 n11365 n11366 VDD VSS n7986 NAND2X1
XU11743 n11367 n11109 VDD VSS n11366 NAND2X1
XU11744 g6837 n11368 VDD VSS n11365 NAND2X1
XU11745 n11369 n11370 VDD VSS n7985 NAND2X1
XU11746 g2309 g7084 VDD VSS n11370 OR2X1
XU11747 g7084 n11368 VDD VSS n11369 NAND2X1
XU11748 n11371 n11372 VDD VSS n7984 NAND2X1
XU11749 n11110 n11373 VDD VSS n11372 NAND2X1
XU11750 g2241 n11368 VDD VSS n11371 NAND2X1
XU11751 n11374 n11375 VDD VSS n11368 NAND2X1
XU11752 n11243 n11376 VDD VSS n11375 NAND2X1
XU11753 n11322 VDD VSS n11243 INVX1
XU11754 n11254 n11257 VDD VSS n11322 NAND2X1
XU11755 n11300 n11377 VDD VSS n11374 NOR2X1
XU11756 n11378 n11257 VDD VSS n11377 NOR2X1
XU11757 n11379 n11380 VDD VSS n11378 XOR2X1
XU11758 n11288 n11381 VDD VSS n11380 NOR2X1
XU11759 n11382 n11308 VDD VSS n11381 XOR2X1
XU11760 n11254 n11223 VDD VSS n11300 NOR2X1
XU11761 n11383 n11384 VDD VSS n7983 NAND2X1
XU11762 n11385 n11386 VDD VSS n11384 NAND2X1
XU11763 g7264 n11387 VDD VSS n11385 NAND2X1
XU11764 n11388 g7264 VDD VSS n11383 NAND2X1
XU11765 n11389 n11390 VDD VSS n7982 NAND2X1
XU11766 n11391 n11392 VDD VSS n11390 NAND2X1
XU11767 g2397 VDD VSS n11392 INVX1
XU11768 g5555 n11387 VDD VSS n11391 NAND2X1
XU11769 n11388 g5555 VDD VSS n11389 NAND2X1
XU11770 n11393 n11394 VDD VSS n7981 NAND2X1
XU11771 n11395 n11396 VDD VSS n11394 NAND2X1
XU11772 g2396 VDD VSS n11396 INVX1
XU11773 g2476 n11387 VDD VSS n11395 NAND2X1
XU11774 n11388 g2476 VDD VSS n11393 NAND2X1
XU11775 n11387 n11397 VDD VSS n11388 AND2X1
XU11776 n11398 n11399 VDD VSS n11397 NAND2X1
XU11777 n11400 n11401 VDD VSS n11399 NAND2X1
XU11778 n11226 n11402 VDD VSS n11400 NOR2X1
XU11779 n11227 n11211 VDD VSS n11398 NAND2X1
XU11780 n11403 n11404 VDD VSS n11387 NAND2X1
XU11781 n11405 n9002 VDD VSS n11404 NAND2X1
XU11782 n11406 n11407 VDD VSS n11405 NOR2X1
XU11783 n11227 g2384 VDD VSS n11403 NAND2X1
XU11784 n9002 VDD VSS n11227 INVX1
XU11785 n11408 n11409 VDD VSS n7980 NAND2X1
XU11786 g2393 g5555 VDD VSS n11409 OR2X1
XU11787 g5555 n11410 VDD VSS n11408 NAND2X1
XU11788 n11411 n11412 VDD VSS n7979 NAND2X1
XU11789 g2394 g7264 VDD VSS n11412 OR2X1
XU11790 g7264 n11410 VDD VSS n11411 NAND2X1
XU11791 n11413 n11414 VDD VSS n7978 NAND2X1
XU11792 n11415 n11047 VDD VSS n11414 NAND2X1
XU11793 g2476 n11410 VDD VSS n11413 NAND2X1
XU11794 n11416 n11220 VDD VSS n11410 NAND2X1
XU11795 n11417 n11418 VDD VSS n11416 XOR2X1
XU11796 n11419 n11420 VDD VSS n11417 NAND2X1
XU11797 n11418 n11421 VDD VSS n11420 NAND2X1
XU11798 n11422 n11423 VDD VSS n11421 NAND2X1
XU11799 n11424 n11425 VDD VSS n11423 NAND2X1
XU11800 n11426 n11427 VDD VSS n11424 NAND2X1
XU11801 n11428 n11402 VDD VSS n11419 NAND2X1
XU11802 n11429 n11430 VDD VSS n11428 NOR2X1
XU11803 n11431 n11432 VDD VSS n11430 NAND2X1
XU11804 n11422 n11425 VDD VSS n11429 NAND2X1
XU11805 n11433 n11434 VDD VSS n11425 NAND2X1
XU11806 n11435 n11436 VDD VSS n11434 NAND2X1
XU11807 n11437 VDD VSS n11436 INVX1
XU11808 n11438 n11052 VDD VSS n11435 NOR2X1
XU11809 g2384 VDD VSS n11052 INVX1
XU11810 n11439 n11407 VDD VSS n11438 NOR2X1
XU11811 n11440 n11441 VDD VSS n7977 NAND2X1
XU11812 g2390 g5555 VDD VSS n11441 OR2X1
XU11813 g5555 n11442 VDD VSS n11440 NAND2X1
XU11814 n11443 n11444 VDD VSS n7976 NAND2X1
XU11815 g2391 g7264 VDD VSS n11444 OR2X1
XU11816 g7264 n11442 VDD VSS n11443 NAND2X1
XU11817 n11445 n11446 VDD VSS n7975 NAND2X1
XU11818 n11447 n11047 VDD VSS n11446 NAND2X1
XU11819 g2476 n11442 VDD VSS n11445 NAND2X1
XU11820 n11448 n11220 VDD VSS n11442 NAND2X1
XU11821 n11427 n11449 VDD VSS n11448 XOR2X1
XU11822 n11450 n11451 VDD VSS n11449 NAND2X1
XU11823 n11226 n11452 VDD VSS n11451 NAND2X1
XU11824 n11433 n11418 VDD VSS n11452 NAND2X1
XU11825 n11453 n11422 VDD VSS n11450 NAND2X1
XU11826 n11454 n11455 VDD VSS n11453 NAND2X1
XU11827 n11456 n11427 VDD VSS n11455 NAND2X1
XU11828 n11431 n11457 VDD VSS n11456 NAND2X1
XU11829 n11439 n11458 VDD VSS n11457 NAND2X1
XU11830 n11459 n11460 VDD VSS n11458 NAND2X1
XU11831 n11406 n11402 VDD VSS n11459 NOR2X1
XU11832 n11432 VDD VSS n11406 INVX1
XU11833 n11433 n11461 VDD VSS n11454 NAND2X1
XU11834 n11462 n11463 VDD VSS n11461 NAND2X1
XU11835 n11464 n11426 VDD VSS n11463 NAND2X1
XU11836 n11139 n11465 VDD VSS n11426 NOR2X1
XU11837 n11432 n11407 VDD VSS n11465 NOR2X1
XU11838 n11466 n11467 VDD VSS n11432 NAND2X1
XU11839 n11468 n11469 VDD VSS n11467 NOR2X1
XU11840 n11470 n11471 VDD VSS n11469 NAND2X1
XU11841 n11472 n11473 VDD VSS n11468 NAND2X1
XU11842 n11474 n11475 VDD VSS n11466 NOR2X1
XU11843 n11476 n11477 VDD VSS n11475 NAND2X1
XU11844 n11478 n11479 VDD VSS n11474 NAND2X1
XU11845 n11480 n11481 VDD VSS n11478 AND2X1
XU11846 n11482 n11437 VDD VSS n11464 NOR2X1
XU11847 n11418 n11483 VDD VSS n11437 NAND2X1
XU11848 n11431 n11484 VDD VSS n11483 NAND2X1
XU11849 n11485 n11401 VDD VSS n11482 AND2X1
XU11850 n11486 n11487 VDD VSS n11462 NAND2X1
XU11851 n11418 n11139 VDD VSS n11486 NOR2X1
XU11852 n11488 n11489 VDD VSS n7974 NAND2X1
XU11853 g2336 g7084 VDD VSS n11489 OR2X1
XU11854 g7084 n11490 VDD VSS n11488 NAND2X1
XU11855 n11491 n11492 VDD VSS n7973 NAND2X1
XU11856 n11110 n11493 VDD VSS n11492 NAND2X1
XU11857 g2241 n11490 VDD VSS n11491 NAND2X1
XU11858 n11494 n11495 VDD VSS n7972 NAND2X1
XU11859 n11496 n11109 VDD VSS n11495 NAND2X1
XU11860 g6837 n11490 VDD VSS n11494 NAND2X1
XU11861 n11497 n11254 VDD VSS n11490 NAND2X1
XU11862 n11358 VDD VSS n11254 INVX1
XU11863 n11498 n11499 VDD VSS n11358 NOR2X1
XU11864 n11500 n11501 VDD VSS n11497 NOR2X1
XU11865 n11257 n11502 VDD VSS n11501 NOR2X1
XU11866 n11329 n11503 VDD VSS n11502 XOR2X1
XU11867 n11326 n11328 VDD VSS n11503 NAND2X1
XU11868 n11504 n11242 VDD VSS n11328 NAND2X1
XU11869 n11308 n11241 VDD VSS n11504 NOR2X1
XU11870 n11505 n11242 VDD VSS n11326 NAND2X1
XU11871 n11260 n11506 VDD VSS n11242 AND2X1
XU11872 n11223 n11259 VDD VSS n11506 XOR2X1
XU11873 n11274 n11507 VDD VSS n11260 AND2X1
XU11874 n11308 n11508 VDD VSS n11507 XOR2X1
XU11875 n11509 n11510 VDD VSS n11274 NAND2X1
XU11876 n11347 n11511 VDD VSS n11510 NAND2X1
XU11877 n11512 n11364 VDD VSS n11347 AND2X1
XU11878 n11363 n11223 VDD VSS n11512 NOR2X1
XU11879 n11346 n11344 VDD VSS n11509 NAND2X1
XU11880 n11513 n11364 VDD VSS n11346 AND2X1
XU11881 n11514 n11515 VDD VSS n11364 AND2X1
XU11882 n11516 n11517 VDD VSS n11515 NOR2X1
XU11883 n11518 n11382 VDD VSS n11517 NOR2X1
XU11884 n11379 n11223 VDD VSS n11516 NOR2X1
XU11885 n11288 n11519 VDD VSS n11514 NOR2X1
XU11886 n11308 n11287 VDD VSS n11519 NOR2X1
XU11887 n11308 n11520 VDD VSS n11513 NOR2X1
XU11888 n11521 n11223 VDD VSS n11505 NOR2X1
XU11889 g2200 n11240 VDD VSS n11500 NOR2X1
XU11890 n11257 VDD VSS n11240 INVX1
XU11891 n11522 n11523 VDD VSS n11257 NAND2X1
XU11892 n11524 n11499 VDD VSS n11523 NOR2X1
XU11893 n11220 VDD VSS n11499 INVX1
XU11894 n11211 n11210 VDD VSS n11220 NAND2X1
XU11895 n11525 n11526 VDD VSS n11210 NAND2X1
XU11896 g2476 n11208 VDD VSS n11526 NAND2X1
XU11897 g2477 VDD VSS n11208 INVX1
XU11898 n11527 n11528 VDD VSS n11525 NOR2X1
XU11899 g2479 n10188 VDD VSS n11528 NOR2X1
XU11900 g2478 n11041 VDD VSS n11527 NOR2X1
XU11901 n9002 n11487 VDD VSS n11524 NOR2X1
XU11902 n11211 n11485 VDD VSS n11487 NAND2X1
XU11903 n11529 VDD VSS n11211 INVX1
XU11904 n11530 n11433 VDD VSS n9002 NAND2X1
XU11905 n11418 n11226 VDD VSS n11530 NOR2X1
XU11906 n11531 n11532 VDD VSS n11522 NOR2X1
XU11907 n11533 n11498 VDD VSS n11532 NOR2X1
XU11908 n11288 n11534 VDD VSS n11498 OR2X1
XU11909 n11535 n11536 VDD VSS n11534 AND2X1
XU11910 n8986 n11223 VDD VSS n11288 AND2X1
XU11911 n11535 n11308 VDD VSS n11533 AND2X1
XU11912 n11223 VDD VSS n11308 INVX1
XU11913 n11537 n11538 VDD VSS n11535 NAND2X1
XU11914 n11539 n11540 VDD VSS n11538 NOR2X1
XU11915 n11511 n11303 VDD VSS n11540 NAND2X1
XU11916 n11520 n11307 VDD VSS n11539 NAND2X1
XU11917 n11223 n11541 VDD VSS n11537 NOR2X1
XU11918 n11542 n11518 VDD VSS n11541 OR2X1
XU11919 n11543 n11418 VDD VSS n11223 NAND2X1
XU11920 n11433 n11422 VDD VSS n11543 NOR2X1
XU11921 n11544 n11226 VDD VSS n11531 NOR2X1
XU11922 n11139 n11545 VDD VSS n11544 NOR2X1
XU11923 n11546 n11547 VDD VSS n11545 NOR2X1
XU11924 n11433 n11485 VDD VSS n11547 NAND2X1
XU11925 n11548 n11549 VDD VSS n11485 NAND2X1
XU11926 g7264 n11386 VDD VSS n11549 NAND2X1
XU11927 g2398 VDD VSS n11386 INVX1
XU11928 n11550 n11551 VDD VSS n11548 NOR2X1
XU11929 g2397 n11041 VDD VSS n11551 NOR2X1
XU11930 g2396 n11047 VDD VSS n11550 NOR2X1
XU11931 n11401 VDD VSS n11546 INVX1
XU11932 n11529 n11225 VDD VSS n11401 NOR2X1
XU11933 n11431 n11552 VDD VSS n11225 AND2X1
XU11934 n11439 n11460 VDD VSS n11552 NAND2X1
XU11935 n11484 VDD VSS n11460 INVX1
XU11936 n11553 n11554 VDD VSS n11484 NAND2X1
XU11937 n11555 n11556 VDD VSS n11554 NAND2X1
XU11938 n11557 n11558 VDD VSS n11555 NOR2X1
XU11939 n11481 n11477 VDD VSS n11558 AND2X1
XU11940 n11470 n11480 VDD VSS n11557 AND2X1
XU11941 n11559 n11560 VDD VSS n11553 NOR2X1
XU11942 n11477 n11561 VDD VSS n11560 NOR2X1
XU11943 n11562 n11563 VDD VSS n11561 NAND2X1
XU11944 n11481 n11470 VDD VSS n11563 NAND2X1
XU11945 n11479 n11480 VDD VSS n11562 NAND2X1
XU11946 n11470 n11564 VDD VSS n11559 NOR2X1
XU11947 n11565 n11566 VDD VSS n11564 NAND2X1
XU11948 n11477 n11480 VDD VSS n11566 NAND2X1
XU11949 g2200 n11327 VDD VSS n11480 XOR2X1
XU11950 n11303 n11180 VDD VSS n11477 XOR2X1
XU11951 n11479 n11481 VDD VSS n11565 NAND2X1
XU11952 n11341 n11511 VDD VSS n11481 XOR2X1
XU11953 n11556 VDD VSS n11479 INVX1
XU11954 g2190 n11259 VDD VSS n11556 XOR2X1
XU11955 g2170 n11518 VDD VSS n11470 XOR2X1
XU11956 n11567 n11568 VDD VSS n11439 AND2X1
XU11957 n11569 n11570 VDD VSS n11568 NAND2X1
XU11958 n11472 n11571 VDD VSS n11569 NOR2X1
XU11959 n11473 n11476 VDD VSS n11571 AND2X1
XU11960 n11572 n11573 VDD VSS n11472 NOR2X1
XU11961 n11574 n11575 VDD VSS n11567 NOR2X1
XU11962 n11476 n11576 VDD VSS n11575 NOR2X1
XU11963 n11577 n11578 VDD VSS n11576 NAND2X1
XU11964 n11473 n11579 VDD VSS n11578 NAND2X1
XU11965 n11471 n11580 VDD VSS n11577 NAND2X1
XU11966 n11579 n11581 VDD VSS n11574 NOR2X1
XU11967 n11582 n11583 VDD VSS n11581 NAND2X1
XU11968 n11476 n11580 VDD VSS n11583 NAND2X1
XU11969 n11573 VDD VSS n11580 INVX1
XU11970 n11584 n11521 VDD VSS n11573 XOR2X1
XU11971 n11181 n11307 VDD VSS n11476 XOR2X1
XU11972 n11471 n11473 VDD VSS n11582 NAND2X1
XU11973 g2175 n11363 VDD VSS n11473 XOR2X1
XU11974 n11570 VDD VSS n11471 INVX1
XU11975 n11585 n11508 VDD VSS n11570 XOR2X1
XU11976 n11572 VDD VSS n11579 INVX1
XU11977 n11586 n11287 VDD VSS n11572 XOR2X1
XU11978 n11587 n11588 VDD VSS n11529 NAND2X1
XU11979 n11589 n11590 VDD VSS n11588 NOR2X1
XU11980 n11591 n11592 VDD VSS n11590 NAND2X1
XU11981 n11593 n11594 VDD VSS n11592 NOR2X1
XU11982 n11341 n11595 VDD VSS n11594 NOR2X1
XU11983 g2220 n11596 VDD VSS n11595 NAND2X1
XU11984 g2180 n11596 VDD VSS n11593 NOR2X1
XU11985 n11597 n11598 VDD VSS n11591 NOR2X1
XU11986 n11181 n11599 VDD VSS n11598 XOR2X1
XU11987 n11600 n11601 VDD VSS n11599 NOR2X1
XU11988 n11602 n11603 VDD VSS n11601 NAND2X1
XU11989 g2241 n9035 VDD VSS n11603 NAND2X1
XU11990 g2235 VDD VSS n9035 INVX1
XU11991 g6837 n9040 VDD VSS n11602 NAND2X1
XU11992 g2236 VDD VSS n9040 INVX1
XU11993 g2237 n11193 VDD VSS n11600 NOR2X1
XU11994 n9032 VDD VSS n11181 INVX1
XU11995 n11604 n11605 VDD VSS n9032 NAND2X1
XU11996 g7084 n11606 VDD VSS n11605 NAND2X1
XU11997 n11607 n11608 VDD VSS n11604 NOR2X1
XU11998 g2251 n11109 VDD VSS n11608 NOR2X1
XU11999 g2250 n11110 VDD VSS n11607 NOR2X1
XU12000 n11180 n11609 VDD VSS n11597 XOR2X1
XU12001 n11610 n11611 VDD VSS n11609 NOR2X1
XU12002 n11612 n11613 VDD VSS n11611 NAND2X1
XU12003 g2241 n9029 VDD VSS n11613 NAND2X1
XU12004 g2238 VDD VSS n9029 INVX1
XU12005 g6837 n9043 VDD VSS n11612 NAND2X1
XU12006 g2239 VDD VSS n9043 INVX1
XU12007 g2240 n11193 VDD VSS n11610 NOR2X1
XU12008 n9024 VDD VSS n11180 INVX1
XU12009 n11614 n11615 VDD VSS n9024 NAND2X1
XU12010 g7084 n11616 VDD VSS n11615 NAND2X1
XU12011 n11617 n11618 VDD VSS n11614 NOR2X1
XU12012 g2248 n11109 VDD VSS n11618 NOR2X1
XU12013 g2247 n11110 VDD VSS n11617 NOR2X1
XU12014 n11619 n11431 VDD VSS n11589 NAND2X1
XU12015 n11407 VDD VSS n11431 INVX1
XU12016 g2257 n11620 VDD VSS n11407 NAND2X1
XU12017 n11621 n11622 VDD VSS n11619 NOR2X1
XU12018 n11586 n11623 VDD VSS n11622 XOR2X1
XU12019 n11624 n11625 VDD VSS n11623 NOR2X1
XU12020 n11626 n11627 VDD VSS n11625 NAND2X1
XU12021 g2241 n10983 VDD VSS n11627 NAND2X1
XU12022 g2205 VDD VSS n10983 INVX1
XU12023 g6837 n10978 VDD VSS n11626 NAND2X1
XU12024 g2206 VDD VSS n10978 INVX1
XU12025 g2207 n11193 VDD VSS n11624 NOR2X1
XU12026 n11376 n11628 VDD VSS n11621 XOR2X1
XU12027 n11629 n11630 VDD VSS n11628 NOR2X1
XU12028 n11631 n11632 VDD VSS n11630 NAND2X1
XU12029 g2241 n10991 VDD VSS n11632 NAND2X1
XU12030 g2208 VDD VSS n10991 INVX1
XU12031 g6837 n10986 VDD VSS n11631 NAND2X1
XU12032 g2209 VDD VSS n10986 INVX1
XU12033 g2210 n11193 VDD VSS n11629 NOR2X1
XU12034 n11633 n11634 VDD VSS n11587 NOR2X1
XU12035 n11635 n11636 VDD VSS n11634 NAND2X1
XU12036 n11637 n11638 VDD VSS n11636 NOR2X1
XU12037 n11584 n11639 VDD VSS n11638 NOR2X1
XU12038 g2229 n11640 VDD VSS n11639 NAND2X1
XU12039 g2195 n11640 VDD VSS n11637 NOR2X1
XU12040 n11641 VDD VSS n11640 INVX1
XU12041 n11642 n11643 VDD VSS n11635 NOR2X1
XU12042 n11644 n11645 VDD VSS n11643 NAND2X1
XU12043 n11646 n11647 VDD VSS n11645 NAND2X1
XU12044 n11648 g2190 VDD VSS n11644 NAND2X1
XU12045 n11646 n11028 VDD VSS n11648 NOR2X1
XU12046 n11649 n11650 VDD VSS n11642 NAND2X1
XU12047 n11651 n11110 VDD VSS n11650 NAND2X1
XU12048 n11652 n11653 VDD VSS n11651 NAND2X1
XU12049 n11654 n11655 VDD VSS n11653 NOR2X1
XU12050 n11656 n11657 VDD VSS n11655 NAND2X1
XU12051 n11596 g2180 VDD VSS n11657 NAND2X1
XU12052 n11658 n11659 VDD VSS n11596 AND2X1
XU12053 g6837 n11004 VDD VSS n11659 NAND2X1
XU12054 g2221 VDD VSS n11004 INVX1
XU12055 g7084 n11007 VDD VSS n11658 NAND2X1
XU12056 g2222 VDD VSS n11007 INVX1
XU12057 n11660 n11585 VDD VSS n11656 OR2X1
XU12058 n11661 n11662 VDD VSS n11654 NOR2X1
XU12059 n11663 n11664 VDD VSS n11652 NOR2X1
XU12060 n11665 n11666 VDD VSS n11664 NAND2X1
XU12061 n11667 n11361 VDD VSS n11666 OR2X1
XU12062 n11646 n11647 VDD VSS n11665 OR2X1
XU12063 n11668 n11669 VDD VSS n11646 NAND2X1
XU12064 g6837 n11022 VDD VSS n11669 NAND2X1
XU12065 g2227 VDD VSS n11022 INVX1
XU12066 g7084 n11025 VDD VSS n11668 NAND2X1
XU12067 g2228 VDD VSS n11025 INVX1
XU12068 n11584 n11641 VDD VSS n11663 NOR2X1
XU12069 n11670 n11671 VDD VSS n11641 NAND2X1
XU12070 g6837 n11031 VDD VSS n11671 NAND2X1
XU12071 g2230 VDD VSS n11031 INVX1
XU12072 g7084 n11034 VDD VSS n11670 NAND2X1
XU12073 g2231 VDD VSS n11034 INVX1
XU12074 g2241 n11672 VDD VSS n11649 NAND2X1
XU12075 n11673 n11674 VDD VSS n11672 NAND2X1
XU12076 n11675 n11676 VDD VSS n11674 NOR2X1
XU12077 n11677 n11678 VDD VSS n11676 NAND2X1
XU12078 n11361 n11001 VDD VSS n11678 NAND2X1
XU12079 n11341 n11010 VDD VSS n11677 NAND2X1
XU12080 g2220 VDD VSS n11010 INVX1
XU12081 g2223 g2185 VDD VSS n11675 NOR2X1
XU12082 n11679 n11680 VDD VSS n11673 NOR2X1
XU12083 n11681 n11682 VDD VSS n11680 NAND2X1
XU12084 n11647 n11028 VDD VSS n11682 NAND2X1
XU12085 g2226 VDD VSS n11028 INVX1
XU12086 n11584 n11037 VDD VSS n11681 NAND2X1
XU12087 g2229 VDD VSS n11037 INVX1
XU12088 g2232 g2200 VDD VSS n11679 NOR2X1
XU12089 n11683 n11684 VDD VSS n11633 NAND2X1
XU12090 n11685 n11686 VDD VSS n11684 NOR2X1
XU12091 n11661 n11687 VDD VSS n11686 NOR2X1
XU12092 g2232 n11688 VDD VSS n11687 NAND2X1
XU12093 g2200 n11688 VDD VSS n11685 NOR2X1
XU12094 n11662 VDD VSS n11688 INVX1
XU12095 n11689 n11690 VDD VSS n11662 NAND2X1
XU12096 g6837 n11188 VDD VSS n11690 NAND2X1
XU12097 g2233 VDD VSS n11188 INVX1
XU12098 g7084 n11192 VDD VSS n11689 NAND2X1
XU12099 g2234 VDD VSS n11192 INVX1
XU12100 n11691 n11692 VDD VSS n11683 NOR2X1
XU12101 n11693 n11694 VDD VSS n11692 NAND2X1
XU12102 n11660 n11585 VDD VSS n11694 NAND2X1
XU12103 n11695 g2185 VDD VSS n11693 NAND2X1
XU12104 n11660 n11019 VDD VSS n11695 NOR2X1
XU12105 g2223 VDD VSS n11019 INVX1
XU12106 n11696 n11697 VDD VSS n11660 NAND2X1
XU12107 g6837 n11013 VDD VSS n11697 NAND2X1
XU12108 g2224 VDD VSS n11013 INVX1
XU12109 g7084 n11016 VDD VSS n11696 NAND2X1
XU12110 g2225 VDD VSS n11016 INVX1
XU12111 n11698 n11699 VDD VSS n11691 NAND2X1
XU12112 n11667 n11361 VDD VSS n11699 NAND2X1
XU12113 n11700 g2175 VDD VSS n11698 NAND2X1
XU12114 n11667 n11001 VDD VSS n11700 NOR2X1
XU12115 g2217 VDD VSS n11001 INVX1
XU12116 n11701 n11702 VDD VSS n11667 NAND2X1
XU12117 g6837 n10994 VDD VSS n11702 NAND2X1
XU12118 g2218 VDD VSS n10994 INVX1
XU12119 g7084 n10998 VDD VSS n11701 NAND2X1
XU12120 g2219 VDD VSS n10998 INVX1
XU12121 n11620 n11189 VDD VSS n11139 NOR2X1
XU12122 n11703 n11704 VDD VSS n11620 NAND2X1
XU12123 g7084 n11705 VDD VSS n11704 NAND2X1
XU12124 n11706 n11707 VDD VSS n11703 NOR2X1
XU12125 g2245 n11109 VDD VSS n11707 NOR2X1
XU12126 g2244 n11110 VDD VSS n11706 NOR2X1
XU12127 n11708 n11709 VDD VSS n7971 NAND2X1
XU12128 n10245 g97 VDD VSS n11709 NAND2X1
XU12129 n10246 n11710 VDD VSS n11708 NAND2X1
XU12130 n11711 n11712 VDD VSS n7970 NAND2X1
XU12131 n10230 g97 VDD VSS n11712 NAND2X1
XU12132 n10230 g131 VDD VSS n11711 OR2X1
XU12133 n11713 n11714 VDD VSS n7969 NAND2X1
XU12134 g97 n10234 VDD VSS n11714 NAND2X1
XU12135 n10235 n11715 VDD VSS n11713 NAND2X1
XU12136 n11716 n11717 VDD VSS n7968 NAND2X1
XU12137 n10245 g101 VDD VSS n11717 NAND2X1
XU12138 n10246 n11718 VDD VSS n11716 NAND2X1
XU12139 n11719 n11720 VDD VSS n7967 NAND2X1
XU12140 n10230 g101 VDD VSS n11720 NAND2X1
XU12141 n10230 g134 VDD VSS n11719 OR2X1
XU12142 n11721 n11722 VDD VSS n7966 NAND2X1
XU12143 g101 n10234 VDD VSS n11722 NAND2X1
XU12144 n10235 n11723 VDD VSS n11721 NAND2X1
XU12145 n11724 n11725 VDD VSS n7965 NAND2X1
XU12146 n10245 g105 VDD VSS n11725 NAND2X1
XU12147 n10246 n11726 VDD VSS n11724 NAND2X1
XU12148 n11727 n11728 VDD VSS n7964 NAND2X1
XU12149 n10230 g105 VDD VSS n11728 NAND2X1
XU12150 n11729 n11730 VDD VSS n11727 NAND2X1
XU12151 n11731 n11732 VDD VSS n7963 NAND2X1
XU12152 g105 n10234 VDD VSS n11732 NAND2X1
XU12153 n10235 n11733 VDD VSS n11731 NAND2X1
XU12154 n11734 n11735 VDD VSS n7962 NAND2X1
XU12155 n10245 g109 VDD VSS n11735 NAND2X1
XU12156 n10246 n11736 VDD VSS n11734 NAND2X1
XU12157 n11737 n11738 VDD VSS n7961 NAND2X1
XU12158 n10230 g109 VDD VSS n11738 NAND2X1
XU12159 n11729 n11739 VDD VSS n11737 NAND2X1
XU12160 n11740 n11741 VDD VSS n7960 NAND2X1
XU12161 g109 n10234 VDD VSS n11741 NAND2X1
XU12162 n10235 n11742 VDD VSS n11740 NAND2X1
XU12163 n11743 n11744 VDD VSS n7959 NAND2X1
XU12164 n10245 g113 VDD VSS n11744 NAND2X1
XU12165 n10246 n11745 VDD VSS n11743 NAND2X1
XU12166 n11746 n11747 VDD VSS n7958 NAND2X1
XU12167 n10230 g113 VDD VSS n11747 NAND2X1
XU12168 n11729 n11748 VDD VSS n11746 NAND2X1
XU12169 n11749 n11750 VDD VSS n7957 NAND2X1
XU12170 g113 n10234 VDD VSS n11750 NAND2X1
XU12171 n10235 n11751 VDD VSS n11749 NAND2X1
XU12172 n11752 n11753 VDD VSS n7956 NAND2X1
XU12173 n10245 g117 VDD VSS n11753 NAND2X1
XU12174 n10246 n11754 VDD VSS n11752 NAND2X1
XU12175 n11755 n11756 VDD VSS n7955 NAND2X1
XU12176 n10230 g117 VDD VSS n11756 NAND2X1
XU12177 n11729 n11757 VDD VSS n11755 NAND2X1
XU12178 n11758 n11759 VDD VSS n7954 NAND2X1
XU12179 g117 n10234 VDD VSS n11759 NAND2X1
XU12180 n10235 n11760 VDD VSS n11758 NAND2X1
XU12181 n11761 n11762 VDD VSS n7953 NAND2X1
XU12182 n10245 g121 VDD VSS n11762 NAND2X1
XU12183 n10246 n11763 VDD VSS n11761 NAND2X1
XU12184 n11764 n11765 VDD VSS n7952 NAND2X1
XU12185 n10230 g121 VDD VSS n11765 NAND2X1
XU12186 n11729 n11766 VDD VSS n11764 NAND2X1
XU12187 n11767 n11768 VDD VSS n7951 NAND2X1
XU12188 g121 n10234 VDD VSS n11768 NAND2X1
XU12189 n10235 n11769 VDD VSS n11767 NAND2X1
XU12190 n10234 VDD VSS n10235 INVX1
XU12191 n11770 n11771 VDD VSS n7950 NAND2X1
XU12192 n11772 n11773 VDD VSS n11771 NAND2X1
XU12193 n11774 g5437 VDD VSS n11770 NAND2X1
XU12194 n11775 n11776 VDD VSS n7949 NAND2X1
XU12195 g432 g6447 VDD VSS n11776 OR2X1
XU12196 n11774 g6447 VDD VSS n11775 NAND2X1
XU12197 n11777 n11778 VDD VSS n7948 NAND2X1
XU12198 n11779 n11780 VDD VSS n11778 NAND2X1
XU12199 n11774 g401 VDD VSS n11777 NAND2X1
XU12200 n11781 n11782 VDD VSS n11774 NAND2X1
XU12201 n11783 n11784 VDD VSS n11782 NAND2X1
XU12202 g309 n11785 VDD VSS n11781 NAND2X1
XU12203 n11786 n11787 VDD VSS n7947 NAND2X1
XU12204 n11788 n11773 VDD VSS n11787 NAND2X1
XU12205 n11789 g5437 VDD VSS n11786 NAND2X1
XU12206 n11790 n11791 VDD VSS n7946 NAND2X1
XU12207 n11792 n11793 VDD VSS n11791 NAND2X1
XU12208 n11789 g6447 VDD VSS n11790 NAND2X1
XU12209 n11794 n11795 VDD VSS n7945 NAND2X1
XU12210 g401 g444 VDD VSS n11795 OR2X1
XU12211 n11789 g401 VDD VSS n11794 NAND2X1
XU12212 n11796 n11797 VDD VSS n11789 XOR2X1
XU12213 n11798 g309 VDD VSS n11796 NAND2X1
XU12214 n11799 n11800 VDD VSS n11798 NOR2X1
XU12215 n11801 n11802 VDD VSS n7944 NAND2X1
XU12216 n11803 n11804 VDD VSS n11802 NAND2X1
XU12217 g447 VDD VSS n11804 INVX1
XU12218 n11805 g401 VDD VSS n11803 NAND2X1
XU12219 n11806 g401 VDD VSS n11801 NAND2X1
XU12220 n11807 n11808 VDD VSS n7943 NAND2X1
XU12221 n11809 n11810 VDD VSS n11808 NAND2X1
XU12222 n11805 g6447 VDD VSS n11809 NAND2X1
XU12223 n11806 g6447 VDD VSS n11807 NAND2X1
XU12224 n11811 n11812 VDD VSS n7942 NAND2X1
XU12225 n11813 n11814 VDD VSS n11812 NAND2X1
XU12226 g448 VDD VSS n11814 INVX1
XU12227 n11805 g5437 VDD VSS n11813 NAND2X1
XU12228 n11815 g309 VDD VSS n11805 AND2X1
XU12229 n11816 n11817 VDD VSS n11815 NOR2X1
XU12230 n11818 n11819 VDD VSS n11817 NOR2X1
XU12231 n11797 n11785 VDD VSS n11818 NOR2X1
XU12232 n11783 n11820 VDD VSS n11816 NOR2X1
XU12233 n10223 n11821 VDD VSS n11820 NOR2X1
XU12234 n11806 g5437 VDD VSS n11811 NAND2X1
XU12235 n11822 n11799 VDD VSS n11806 AND2X1
XU12236 n11823 n11824 VDD VSS n11799 AND2X1
XU12237 g6447 n11810 VDD VSS n11824 NAND2X1
XU12238 g449 VDD VSS n11810 INVX1
XU12239 n11825 n11826 VDD VSS n11823 NOR2X1
XU12240 g448 n11773 VDD VSS n11826 NOR2X1
XU12241 g447 n11779 VDD VSS n11825 NOR2X1
XU12242 n11800 n11784 VDD VSS n11822 NOR2X1
XU12243 n11827 n11828 VDD VSS n11800 AND2X1
XU12244 n11829 n11797 VDD VSS n11828 NAND2X1
XU12245 n11821 n11819 VDD VSS n11829 NOR2X1
XU12246 n11785 VDD VSS n11821 INVX1
XU12247 n11830 n10223 VDD VSS n11827 NAND2X1
XU12248 n11797 VDD VSS n10223 INVX1
XU12249 n11831 n11832 VDD VSS n11797 NAND2X1
XU12250 g444 g401 VDD VSS n11832 NAND2X1
XU12251 n11833 n11834 VDD VSS n11831 NOR2X1
XU12252 n11793 n11792 VDD VSS n11834 NOR2X1
XU12253 g441 VDD VSS n11792 INVX1
XU12254 n11773 n11788 VDD VSS n11833 NOR2X1
XU12255 g438 VDD VSS n11788 INVX1
XU12256 n11783 n11785 VDD VSS n11830 NOR2X1
XU12257 n11835 n11836 VDD VSS n11785 NAND2X1
XU12258 n11837 n11838 VDD VSS n11836 NAND2X1
XU12259 g6313 n11839 VDD VSS n11838 NAND2X1
XU12260 n11840 n11841 VDD VSS n11837 NOR2X1
XU12261 g178 n11842 VDD VSS n11841 NOR2X1
XU12262 g177 n11843 VDD VSS n11840 NOR2X1
XU12263 n11819 VDD VSS n11783 INVX1
XU12264 n11844 n11845 VDD VSS n11819 NAND2X1
XU12265 g432 g6447 VDD VSS n11845 NAND2X1
XU12266 n11846 n11847 VDD VSS n11844 NOR2X1
XU12267 n11773 n11772 VDD VSS n11847 NOR2X1
XU12268 g429 VDD VSS n11772 INVX1
XU12269 n11779 n11780 VDD VSS n11846 NOR2X1
XU12270 g435 VDD VSS n11780 INVX1
XU12271 n11848 n11849 VDD VSS n7941 NAND2X1
XU12272 n11850 n11773 VDD VSS n11849 NAND2X1
XU12273 n11851 g5437 VDD VSS n11848 NAND2X1
XU12274 n11852 n11853 VDD VSS n7940 NAND2X1
XU12275 g420 g6447 VDD VSS n11853 OR2X1
XU12276 n11851 g6447 VDD VSS n11852 NAND2X1
XU12277 n11854 n11855 VDD VSS n7939 NAND2X1
XU12278 n11779 n11856 VDD VSS n11855 NAND2X1
XU12279 n11851 g401 VDD VSS n11854 NAND2X1
XU12280 n10216 n11857 VDD VSS n11851 XOR2X1
XU12281 n11858 n11859 VDD VSS n11857 NOR2X1
XU12282 n11860 n11861 VDD VSS n11859 NOR2X1
XU12283 g309 n11862 VDD VSS n11861 NAND2X1
XU12284 n11863 n11864 VDD VSS n11860 NAND2X1
XU12285 n118 n11865 VDD VSS n11864 NAND2X1
XU12286 n11866 n11867 VDD VSS n11865 NAND2X1
XU12287 n11868 n10216 VDD VSS n11863 NAND2X1
XU12288 n11867 n11869 VDD VSS n11868 NAND2X1
XU12289 n11870 n11871 VDD VSS n11858 NOR2X1
XU12290 n118 n11866 VDD VSS n11871 NAND2X1
XU12291 n11869 VDD VSS n11866 INVX1
XU12292 n11872 g309 VDD VSS n11870 NAND2X1
XU12293 n11873 n11874 VDD VSS n7938 NAND2X1
XU12294 n11875 n11876 VDD VSS n11874 NAND2X1
XU12295 g427 VDD VSS n11876 INVX1
XU12296 n11877 g5437 VDD VSS n11875 NAND2X1
XU12297 n11878 g5437 VDD VSS n11873 NAND2X1
XU12298 n11879 n11880 VDD VSS n7937 NAND2X1
XU12299 n11881 n11882 VDD VSS n11880 NAND2X1
XU12300 n11877 g6447 VDD VSS n11881 NAND2X1
XU12301 n11878 g6447 VDD VSS n11879 NAND2X1
XU12302 n11883 n11884 VDD VSS n7936 NAND2X1
XU12303 n11885 n11886 VDD VSS n11884 NAND2X1
XU12304 g426 VDD VSS n11886 INVX1
XU12305 n11877 g401 VDD VSS n11885 NAND2X1
XU12306 n11878 g401 VDD VSS n11883 NAND2X1
XU12307 n11887 n11888 VDD VSS n11878 AND2X1
XU12308 n11889 n11890 VDD VSS n11888 NOR2X1
XU12309 n11784 n11867 VDD VSS n11887 NOR2X1
XU12310 n11891 n11892 VDD VSS n7935 NAND2X1
XU12311 n11893 n11773 VDD VSS n11892 NAND2X1
XU12312 n11894 g5437 VDD VSS n11891 NAND2X1
XU12313 n11895 n11896 VDD VSS n7934 NAND2X1
XU12314 g411 g6447 VDD VSS n11896 OR2X1
XU12315 n11894 g6447 VDD VSS n11895 NAND2X1
XU12316 n11897 n11898 VDD VSS n7933 NAND2X1
XU12317 n11779 n11899 VDD VSS n11898 NAND2X1
XU12318 n11894 g401 VDD VSS n11897 NAND2X1
XU12319 n11862 n11900 VDD VSS n11894 XOR2X1
XU12320 n11877 n11901 VDD VSS n11900 NOR2X1
XU12321 n11784 n11902 VDD VSS n11901 NOR2X1
XU12322 n11903 n11862 VDD VSS n11902 NAND2X1
XU12323 n11867 n11890 VDD VSS n11903 OR2X1
XU12324 n11904 n11905 VDD VSS n11867 NAND2X1
XU12325 g6447 n11882 VDD VSS n11905 NAND2X1
XU12326 g428 VDD VSS n11882 INVX1
XU12327 n11906 n11907 VDD VSS n11904 NOR2X1
XU12328 g427 n11773 VDD VSS n11907 NOR2X1
XU12329 g426 n11779 VDD VSS n11906 NOR2X1
XU12330 n11908 n11889 VDD VSS n11877 AND2X1
XU12331 n11862 VDD VSS n11889 INVX1
XU12332 n11890 n11784 VDD VSS n11908 NOR2X1
XU12333 n11909 n11910 VDD VSS n11890 AND2X1
XU12334 n11869 n10216 VDD VSS n11910 NAND2X1
XU12335 n11911 n118 VDD VSS n11909 NAND2X1
XU12336 n11872 n11869 VDD VSS n11911 NOR2X1
XU12337 n11912 n11835 VDD VSS n11869 NAND2X1
XU12338 n11913 n11914 VDD VSS n11912 NOR2X1
XU12339 n11915 n11916 VDD VSS n11862 NAND2X1
XU12340 g411 g6447 VDD VSS n11916 NAND2X1
XU12341 n11917 n11918 VDD VSS n11915 NOR2X1
XU12342 n11773 n11893 VDD VSS n11918 NOR2X1
XU12343 g408 VDD VSS n11893 INVX1
XU12344 n11779 n11899 VDD VSS n11917 NOR2X1
XU12345 g414 VDD VSS n11899 INVX1
XU12346 n11919 n11920 VDD VSS n7932 NAND2X1
XU12347 n10245 g125 VDD VSS n11920 NAND2X1
XU12348 n10246 n11921 VDD VSS n11919 NAND2X1
XU12349 n10245 VDD VSS n10246 INVX1
XU12350 n11842 n11922 VDD VSS n10245 NOR2X1
XU12351 n11923 n11924 VDD VSS n7931 NAND2X1
XU12352 n10230 g125 VDD VSS n11924 NAND2X1
XU12353 n11729 n11925 VDD VSS n11923 NAND2X1
XU12354 n10230 VDD VSS n11729 INVX1
XU12355 n11926 n11922 VDD VSS n10230 NOR2X1
XU12356 n11927 n11928 VDD VSS n7930 NAND2X1
XU12357 g125 n10234 VDD VSS n11928 NAND2X1
XU12358 n10234 g156 VDD VSS n11927 OR2X1
XU12359 n11929 n11930 VDD VSS n7929 NAND2X1
XU12360 n11931 n11932 VDD VSS n11930 NAND2X1
XU12361 g403 VDD VSS n11932 INVX1
XU12362 g309 g5437 VDD VSS n11931 NAND2X1
XU12363 n11933 g5437 VDD VSS n11929 NAND2X1
XU12364 n11934 n11935 VDD VSS n7928 NAND2X1
XU12365 n11936 n11937 VDD VSS n11935 NAND2X1
XU12366 g404 VDD VSS n11937 INVX1
XU12367 g309 g6447 VDD VSS n11936 NAND2X1
XU12368 n11933 g6447 VDD VSS n11934 NAND2X1
XU12369 n11938 n11939 VDD VSS n7927 NAND2X1
XU12370 n11940 n11941 VDD VSS n11939 NAND2X1
XU12371 g309 g401 VDD VSS n11940 NAND2X1
XU12372 n11933 g401 VDD VSS n11938 NAND2X1
XU12373 n11942 n11943 VDD VSS n11933 NOR2X1
XU12374 g309 n11944 VDD VSS n11942 NAND2X1
XU12375 n11945 n11946 VDD VSS n7926 NAND2X1
XU12376 g312 g5437 VDD VSS n11946 OR2X1
XU12377 g5437 n11947 VDD VSS n11945 NAND2X1
XU12378 n11948 n11949 VDD VSS n7925 NAND2X1
XU12379 g313 g6447 VDD VSS n11949 OR2X1
XU12380 g6447 n11947 VDD VSS n11948 NAND2X1
XU12381 n11950 n11951 VDD VSS n7924 NAND2X1
XU12382 n11952 n11779 VDD VSS n11951 NAND2X1
XU12383 g401 n11947 VDD VSS n11950 NAND2X1
XU12384 n11953 n11954 VDD VSS n11947 NAND2X1
XU12385 n11955 n11956 VDD VSS n11954 NAND2X1
XU12386 n11957 n11958 VDD VSS n11955 NAND2X1
XU12387 n11959 n11960 VDD VSS n11957 NOR2X1
XU12388 n11961 n11962 VDD VSS n7923 NAND2X1
XU12389 n11963 n11842 VDD VSS n11962 NAND2X1
XU12390 n11964 g6231 VDD VSS n11961 NAND2X1
XU12391 n11965 n11966 VDD VSS n7922 NAND2X1
XU12392 g216 g6313 VDD VSS n11966 OR2X1
XU12393 n11964 g6313 VDD VSS n11965 NAND2X1
XU12394 n11967 n11968 VDD VSS n7921 NAND2X1
XU12395 n11843 n11969 VDD VSS n11968 NAND2X1
XU12396 n11964 g165 VDD VSS n11967 NAND2X1
XU12397 n11970 n11971 VDD VSS n11964 AND2X1
XU12398 n11972 n11973 VDD VSS n11971 NAND2X1
XU12399 n11974 n11975 VDD VSS n11972 XOR2X1
XU12400 n11976 g121 VDD VSS n11970 NAND2X1
XU12401 n11977 n11978 VDD VSS n7920 NAND2X1
XU12402 n11979 n11842 VDD VSS n11978 NAND2X1
XU12403 g6231 n11980 VDD VSS n11977 NAND2X1
XU12404 n11981 n11982 VDD VSS n7919 NAND2X1
XU12405 g252 g6313 VDD VSS n11982 OR2X1
XU12406 g6313 n11980 VDD VSS n11981 NAND2X1
XU12407 n11983 n11984 VDD VSS n7918 NAND2X1
XU12408 n11843 n11985 VDD VSS n11984 NAND2X1
XU12409 g165 n11980 VDD VSS n11983 NAND2X1
XU12410 n11986 n11987 VDD VSS n11980 NAND2X1
XU12411 n11988 n11989 VDD VSS n11986 NOR2X1
XU12412 n11990 n11991 VDD VSS n11989 NOR2X1
XU12413 n11992 n11993 VDD VSS n11991 XOR2X1
XU12414 g117 n11973 VDD VSS n11988 NOR2X1
XU12415 n11994 n11995 VDD VSS n7917 NAND2X1
XU12416 g207 g6313 VDD VSS n11995 OR2X1
XU12417 n11996 g6313 VDD VSS n11994 NAND2X1
XU12418 n11997 n11998 VDD VSS n7916 NAND2X1
XU12419 n11843 n11999 VDD VSS n11998 NAND2X1
XU12420 n11996 g165 VDD VSS n11997 NAND2X1
XU12421 n12000 n12001 VDD VSS n7915 NAND2X1
XU12422 n12002 n11842 VDD VSS n12001 NAND2X1
XU12423 n11996 g6231 VDD VSS n12000 NAND2X1
XU12424 n12003 n12004 VDD VSS n11996 AND2X1
XU12425 n12005 n11973 VDD VSS n12004 NAND2X1
XU12426 n12006 n12007 VDD VSS n12005 XOR2X1
XU12427 n11976 g113 VDD VSS n12003 NAND2X1
XU12428 n12008 n12009 VDD VSS n7914 NAND2X1
XU12429 n12010 n11842 VDD VSS n12009 NAND2X1
XU12430 n12011 g6231 VDD VSS n12008 NAND2X1
XU12431 n12012 n12013 VDD VSS n7913 NAND2X1
XU12432 g189 g6313 VDD VSS n12013 OR2X1
XU12433 n12011 g6313 VDD VSS n12012 NAND2X1
XU12434 n12014 n12015 VDD VSS n7912 NAND2X1
XU12435 n11843 n12016 VDD VSS n12015 NAND2X1
XU12436 n12011 g165 VDD VSS n12014 NAND2X1
XU12437 n12017 n12018 VDD VSS n12011 AND2X1
XU12438 n11973 n12019 VDD VSS n12018 NAND2X1
XU12439 n12020 n12021 VDD VSS n12019 XOR2X1
XU12440 n11976 g97 VDD VSS n12017 NAND2X1
XU12441 n12022 n12023 VDD VSS n7911 NAND2X1
XU12442 n12024 n11842 VDD VSS n12023 NAND2X1
XU12443 g6231 n12025 VDD VSS n12022 NAND2X1
XU12444 n12026 n12027 VDD VSS n7910 NAND2X1
XU12445 g270 g6313 VDD VSS n12027 OR2X1
XU12446 g6313 n12025 VDD VSS n12026 NAND2X1
XU12447 n12028 n12029 VDD VSS n7909 NAND2X1
XU12448 n11843 n12030 VDD VSS n12029 NAND2X1
XU12449 g165 n12025 VDD VSS n12028 NAND2X1
XU12450 n12031 n12032 VDD VSS n12025 NAND2X1
XU12451 n11976 n11913 VDD VSS n12032 NAND2X1
XU12452 n12033 n12034 VDD VSS n12031 NOR2X1
XU12453 n12035 n11990 VDD VSS n12034 NOR2X1
XU12454 n12036 n12037 VDD VSS n12035 XOR2X1
XU12455 n12038 n12039 VDD VSS n12037 NOR2X1
XU12456 n12040 n12041 VDD VSS n12038 XOR2X1
XU12457 n12042 n12043 VDD VSS n7908 NAND2X1
XU12458 n12044 n11842 VDD VSS n12043 NAND2X1
XU12459 n12045 g6231 VDD VSS n12042 NAND2X1
XU12460 n12046 n12047 VDD VSS n7907 NAND2X1
XU12461 g225 g6313 VDD VSS n12047 OR2X1
XU12462 n12045 g6313 VDD VSS n12046 NAND2X1
XU12463 n12048 n12049 VDD VSS n7906 NAND2X1
XU12464 n11843 n12050 VDD VSS n12049 NAND2X1
XU12465 n12045 g165 VDD VSS n12048 NAND2X1
XU12466 n12051 n12052 VDD VSS n12045 AND2X1
XU12467 n12053 n12054 VDD VSS n12051 NOR2X1
XU12468 n11914 n12055 VDD VSS n12054 NOR2X1
XU12469 n11990 n12056 VDD VSS n12053 NOR2X1
XU12470 n12040 n12039 VDD VSS n12056 XOR2X1
XU12471 n12057 n12058 VDD VSS n12039 AND2X1
XU12472 n12059 n12060 VDD VSS n12058 OR2X1
XU12473 n12061 n12062 VDD VSS n12057 OR2X1
XU12474 n12063 n12064 VDD VSS n7905 NAND2X1
XU12475 n12065 n11842 VDD VSS n12064 NAND2X1
XU12476 g6231 n12066 VDD VSS n12063 NAND2X1
XU12477 n12067 n12068 VDD VSS n7904 NAND2X1
XU12478 g243 g6313 VDD VSS n12068 OR2X1
XU12479 g6313 n12066 VDD VSS n12067 NAND2X1
XU12480 n12069 n12070 VDD VSS n7903 NAND2X1
XU12481 n11843 n12071 VDD VSS n12070 NAND2X1
XU12482 g165 n12066 VDD VSS n12069 NAND2X1
XU12483 n12072 n12073 VDD VSS n12066 NAND2X1
XU12484 n11976 n12074 VDD VSS n12073 NAND2X1
XU12485 n12033 n12075 VDD VSS n12072 NOR2X1
XU12486 n11990 n12076 VDD VSS n12075 NOR2X1
XU12487 n12077 n12078 VDD VSS n12076 XOR2X1
XU12488 n12079 n12080 VDD VSS n12078 NOR2X1
XU12489 n12081 n12082 VDD VSS n7902 NAND2X1
XU12490 n11843 n12083 VDD VSS n12082 NAND2X1
XU12491 n12084 g165 VDD VSS n12081 NAND2X1
XU12492 n12085 n12086 VDD VSS n7901 NAND2X1
XU12493 n12087 n11842 VDD VSS n12086 NAND2X1
XU12494 n12084 g6231 VDD VSS n12085 NAND2X1
XU12495 n12088 n12089 VDD VSS n7900 NAND2X1
XU12496 g198 g6313 VDD VSS n12089 OR2X1
XU12497 n12084 g6313 VDD VSS n12088 NAND2X1
XU12498 n12090 n12052 VDD VSS n12084 AND2X1
XU12499 n12091 n11956 VDD VSS n12052 NAND2X1
XU12500 n12092 n12093 VDD VSS n12090 NOR2X1
XU12501 n12094 n12055 VDD VSS n12093 NOR2X1
XU12502 n11990 n12095 VDD VSS n12092 NOR2X1
XU12503 n12096 n12097 VDD VSS n12095 XOR2X1
XU12504 n12098 n12099 VDD VSS n7899 NAND2X1
XU12505 n12100 n11842 VDD VSS n12099 NAND2X1
XU12506 g6231 n12101 VDD VSS n12098 NAND2X1
XU12507 n12102 n12103 VDD VSS n7898 NAND2X1
XU12508 g234 g6313 VDD VSS n12103 OR2X1
XU12509 g6313 n12101 VDD VSS n12102 NAND2X1
XU12510 n12104 n12105 VDD VSS n7897 NAND2X1
XU12511 n11843 n12106 VDD VSS n12105 NAND2X1
XU12512 g165 n12101 VDD VSS n12104 NAND2X1
XU12513 n12107 n12108 VDD VSS n12101 NAND2X1
XU12514 n11976 n12109 VDD VSS n12108 NAND2X1
XU12515 n12055 VDD VSS n11976 INVX1
XU12516 n11987 n11990 VDD VSS n12055 NAND2X1
XU12517 n12033 n12110 VDD VSS n12107 NOR2X1
XU12518 n12111 n11990 VDD VSS n12110 NOR2X1
XU12519 n12112 n12113 VDD VSS n12111 XOR2X1
XU12520 n12021 n12114 VDD VSS n12113 NOR2X1
XU12521 n12115 n12041 VDD VSS n12114 XOR2X1
XU12522 n11987 n11956 VDD VSS n12033 NOR2X1
XU12523 n12116 n12117 VDD VSS n7896 NAND2X1
XU12524 n12118 n12119 VDD VSS n12117 NAND2X1
XU12525 g6447 n12120 VDD VSS n12118 NAND2X1
XU12526 n12121 g6447 VDD VSS n12116 NAND2X1
XU12527 n12122 n12123 VDD VSS n7895 NAND2X1
XU12528 n12124 n12125 VDD VSS n12123 NAND2X1
XU12529 g322 VDD VSS n12125 INVX1
XU12530 g5437 n12120 VDD VSS n12124 NAND2X1
XU12531 n12121 g5437 VDD VSS n12122 NAND2X1
XU12532 n12126 n12127 VDD VSS n7894 NAND2X1
XU12533 n12128 n12129 VDD VSS n12127 NAND2X1
XU12534 g321 VDD VSS n12129 INVX1
XU12535 g401 n12120 VDD VSS n12128 NAND2X1
XU12536 n12121 g401 VDD VSS n12126 NAND2X1
XU12537 n12120 n12130 VDD VSS n12121 AND2X1
XU12538 n12131 n12132 VDD VSS n12130 NAND2X1
XU12539 n12133 n12134 VDD VSS n12132 NAND2X1
XU12540 n11959 n12135 VDD VSS n12133 NOR2X1
XU12541 n11960 n11944 VDD VSS n12131 NAND2X1
XU12542 n12136 n12137 VDD VSS n12120 NAND2X1
XU12543 n12138 n10209 VDD VSS n12137 NAND2X1
XU12544 n12139 n12140 VDD VSS n12138 NOR2X1
XU12545 n11960 g309 VDD VSS n12136 NAND2X1
XU12546 n10209 VDD VSS n11960 INVX1
XU12547 n12141 n12142 VDD VSS n7893 NAND2X1
XU12548 g318 g5437 VDD VSS n12142 OR2X1
XU12549 g5437 n12143 VDD VSS n12141 NAND2X1
XU12550 n12144 n12145 VDD VSS n7892 NAND2X1
XU12551 g319 g6447 VDD VSS n12145 OR2X1
XU12552 g6447 n12143 VDD VSS n12144 NAND2X1
XU12553 n12146 n12147 VDD VSS n7891 NAND2X1
XU12554 n12148 n11779 VDD VSS n12147 NAND2X1
XU12555 g401 n12143 VDD VSS n12146 NAND2X1
XU12556 n12149 n11953 VDD VSS n12143 NAND2X1
XU12557 n12150 n12151 VDD VSS n12149 XOR2X1
XU12558 n12152 n12153 VDD VSS n12150 NAND2X1
XU12559 n12151 n12154 VDD VSS n12153 NAND2X1
XU12560 n12155 n12156 VDD VSS n12154 NAND2X1
XU12561 n12157 n12158 VDD VSS n12156 NAND2X1
XU12562 n12159 n12160 VDD VSS n12157 NAND2X1
XU12563 n12161 n12135 VDD VSS n12152 NAND2X1
XU12564 n12162 n12163 VDD VSS n12161 NOR2X1
XU12565 n12164 n12165 VDD VSS n12163 NAND2X1
XU12566 n12155 n12158 VDD VSS n12162 NAND2X1
XU12567 n12166 n12167 VDD VSS n12158 NAND2X1
XU12568 n12168 n12169 VDD VSS n12167 NAND2X1
XU12569 n12170 VDD VSS n12169 INVX1
XU12570 n12171 n11784 VDD VSS n12168 NOR2X1
XU12571 g309 VDD VSS n11784 INVX1
XU12572 n12172 n12140 VDD VSS n12171 NOR2X1
XU12573 n12173 n12174 VDD VSS n7890 NAND2X1
XU12574 g315 g5437 VDD VSS n12174 OR2X1
XU12575 g5437 n12175 VDD VSS n12173 NAND2X1
XU12576 n12176 n12177 VDD VSS n7889 NAND2X1
XU12577 g316 g6447 VDD VSS n12177 OR2X1
XU12578 g6447 n12175 VDD VSS n12176 NAND2X1
XU12579 n12178 n12179 VDD VSS n7888 NAND2X1
XU12580 n12180 n11779 VDD VSS n12179 NAND2X1
XU12581 g401 n12175 VDD VSS n12178 NAND2X1
XU12582 n12181 n11953 VDD VSS n12175 NAND2X1
XU12583 n12160 n12182 VDD VSS n12181 XOR2X1
XU12584 n12183 n12184 VDD VSS n12182 NAND2X1
XU12585 n11959 n12185 VDD VSS n12184 NAND2X1
XU12586 n12166 n12151 VDD VSS n12185 NAND2X1
XU12587 n12186 n12155 VDD VSS n12183 NAND2X1
XU12588 n12187 n12188 VDD VSS n12186 NAND2X1
XU12589 n12189 n12160 VDD VSS n12188 NAND2X1
XU12590 n12164 n12190 VDD VSS n12189 NAND2X1
XU12591 n12172 n12191 VDD VSS n12190 NAND2X1
XU12592 n12192 n12193 VDD VSS n12191 NAND2X1
XU12593 n12139 n12135 VDD VSS n12192 NOR2X1
XU12594 n12165 VDD VSS n12139 INVX1
XU12595 n12166 n12194 VDD VSS n12187 NAND2X1
XU12596 n12195 n12196 VDD VSS n12194 NAND2X1
XU12597 n12197 n12159 VDD VSS n12196 NAND2X1
XU12598 n11872 n12198 VDD VSS n12159 NOR2X1
XU12599 n12165 n12140 VDD VSS n12198 NOR2X1
XU12600 n12199 n12200 VDD VSS n12165 NAND2X1
XU12601 n12201 n12202 VDD VSS n12200 NOR2X1
XU12602 n12203 n12204 VDD VSS n12202 NAND2X1
XU12603 n12205 n12206 VDD VSS n12201 NAND2X1
XU12604 n12207 n12208 VDD VSS n12199 NOR2X1
XU12605 n12209 n12210 VDD VSS n12208 NAND2X1
XU12606 n12211 n12212 VDD VSS n12207 NAND2X1
XU12607 n12213 n12214 VDD VSS n12211 AND2X1
XU12608 n12215 n12170 VDD VSS n12197 NOR2X1
XU12609 n12151 n12216 VDD VSS n12170 NAND2X1
XU12610 n12164 n12217 VDD VSS n12216 NAND2X1
XU12611 n12218 n12134 VDD VSS n12215 AND2X1
XU12612 n12219 n12220 VDD VSS n12195 NAND2X1
XU12613 n12151 n11872 VDD VSS n12219 NOR2X1
XU12614 n12221 n12222 VDD VSS n7887 NAND2X1
XU12615 n12223 n11842 VDD VSS n12222 NAND2X1
XU12616 g6231 n12224 VDD VSS n12221 NAND2X1
XU12617 n12225 n12226 VDD VSS n7886 NAND2X1
XU12618 g261 g6313 VDD VSS n12226 OR2X1
XU12619 g6313 n12224 VDD VSS n12225 NAND2X1
XU12620 n12227 n12228 VDD VSS n7885 NAND2X1
XU12621 n11843 n12229 VDD VSS n12228 NAND2X1
XU12622 g165 n12224 VDD VSS n12227 NAND2X1
XU12623 n12230 n11987 VDD VSS n12224 NAND2X1
XU12624 n12091 VDD VSS n11987 INVX1
XU12625 n12231 n12232 VDD VSS n12091 NOR2X1
XU12626 n12233 n12234 VDD VSS n12230 NOR2X1
XU12627 n11990 n12235 VDD VSS n12234 NOR2X1
XU12628 n12062 n12236 VDD VSS n12235 XOR2X1
XU12629 n12059 n12061 VDD VSS n12236 NAND2X1
XU12630 n12237 n11975 VDD VSS n12061 NAND2X1
XU12631 n12041 n11974 VDD VSS n12237 NOR2X1
XU12632 n12238 n11975 VDD VSS n12059 NAND2X1
XU12633 n11993 n12239 VDD VSS n11975 AND2X1
XU12634 n11956 n11992 VDD VSS n12239 XOR2X1
XU12635 n12007 n12240 VDD VSS n11993 AND2X1
XU12636 n12041 n12241 VDD VSS n12240 XOR2X1
XU12637 n12242 n12243 VDD VSS n12007 NAND2X1
XU12638 n12080 n12244 VDD VSS n12243 NAND2X1
XU12639 n12245 n12097 VDD VSS n12080 AND2X1
XU12640 n12096 n11956 VDD VSS n12245 NOR2X1
XU12641 n12079 n12077 VDD VSS n12242 NAND2X1
XU12642 n12246 n12097 VDD VSS n12079 AND2X1
XU12643 n12247 n12248 VDD VSS n12097 AND2X1
XU12644 n12249 n12250 VDD VSS n12248 NOR2X1
XU12645 n12251 n12115 VDD VSS n12250 NOR2X1
XU12646 n12112 n11956 VDD VSS n12249 NOR2X1
XU12647 n12021 n12252 VDD VSS n12247 NOR2X1
XU12648 n12041 n12020 VDD VSS n12252 NOR2X1
XU12649 n12041 n12253 VDD VSS n12246 NOR2X1
XU12650 n12254 n11956 VDD VSS n12238 NOR2X1
XU12651 g125 n11973 VDD VSS n12233 NOR2X1
XU12652 n11990 VDD VSS n11973 INVX1
XU12653 n12255 n12256 VDD VSS n11990 NAND2X1
XU12654 n12257 n12232 VDD VSS n12256 NOR2X1
XU12655 n11953 VDD VSS n12232 INVX1
XU12656 n11944 n11943 VDD VSS n11953 NAND2X1
XU12657 n12258 n12259 VDD VSS n11943 NAND2X1
XU12658 g401 n11941 VDD VSS n12259 NAND2X1
XU12659 g402 VDD VSS n11941 INVX1
XU12660 n12260 n12261 VDD VSS n12258 NOR2X1
XU12661 g404 n11793 VDD VSS n12261 NOR2X1
XU12662 g403 n11773 VDD VSS n12260 NOR2X1
XU12663 n10209 n12220 VDD VSS n12257 NOR2X1
XU12664 n11944 n12218 VDD VSS n12220 NAND2X1
XU12665 n12262 VDD VSS n11944 INVX1
XU12666 n12263 n12166 VDD VSS n10209 NAND2X1
XU12667 n12151 n11959 VDD VSS n12263 NOR2X1
XU12668 n12264 n12265 VDD VSS n12255 NOR2X1
XU12669 n12266 n12231 VDD VSS n12265 NOR2X1
XU12670 n12021 n12267 VDD VSS n12231 OR2X1
XU12671 n12268 n12269 VDD VSS n12267 AND2X1
XU12672 n10193 n11956 VDD VSS n12021 AND2X1
XU12673 n12268 n12041 VDD VSS n12266 AND2X1
XU12674 n11956 VDD VSS n12041 INVX1
XU12675 n12270 n12271 VDD VSS n12268 NAND2X1
XU12676 n12272 n12273 VDD VSS n12271 NOR2X1
XU12677 n12244 n12036 VDD VSS n12273 NAND2X1
XU12678 n12253 n12040 VDD VSS n12272 NAND2X1
XU12679 n11956 n12274 VDD VSS n12270 NOR2X1
XU12680 n12275 n12251 VDD VSS n12274 OR2X1
XU12681 n12276 n12151 VDD VSS n11956 NAND2X1
XU12682 n12166 n12155 VDD VSS n12276 NOR2X1
XU12683 n12277 n11959 VDD VSS n12264 NOR2X1
XU12684 n11872 n12278 VDD VSS n12277 NOR2X1
XU12685 n12279 n12280 VDD VSS n12278 NOR2X1
XU12686 n12166 n12218 VDD VSS n12280 NAND2X1
XU12687 n12281 n12282 VDD VSS n12218 NAND2X1
XU12688 g6447 n12119 VDD VSS n12282 NAND2X1
XU12689 g323 VDD VSS n12119 INVX1
XU12690 n12283 n12284 VDD VSS n12281 NOR2X1
XU12691 g322 n11773 VDD VSS n12284 NOR2X1
XU12692 g321 n11779 VDD VSS n12283 NOR2X1
XU12693 n12134 VDD VSS n12279 INVX1
XU12694 n12262 n11958 VDD VSS n12134 NOR2X1
XU12695 n12164 n12285 VDD VSS n11958 AND2X1
XU12696 n12172 n12193 VDD VSS n12285 NAND2X1
XU12697 n12217 VDD VSS n12193 INVX1
XU12698 n12286 n12287 VDD VSS n12217 NAND2X1
XU12699 n12288 n12289 VDD VSS n12287 NAND2X1
XU12700 n12290 n12291 VDD VSS n12288 NOR2X1
XU12701 n12214 n12210 VDD VSS n12291 AND2X1
XU12702 n12203 n12213 VDD VSS n12290 AND2X1
XU12703 n12292 n12293 VDD VSS n12286 NOR2X1
XU12704 n12210 n12294 VDD VSS n12293 NOR2X1
XU12705 n12295 n12296 VDD VSS n12294 NAND2X1
XU12706 n12214 n12203 VDD VSS n12296 NAND2X1
XU12707 n12212 n12213 VDD VSS n12295 NAND2X1
XU12708 n12203 n12297 VDD VSS n12292 NOR2X1
XU12709 n12298 n12299 VDD VSS n12297 NAND2X1
XU12710 n12210 n12213 VDD VSS n12299 NAND2X1
XU12711 g125 n12060 VDD VSS n12213 XOR2X1
XU12712 n12036 n11913 VDD VSS n12210 XOR2X1
XU12713 n12212 n12214 VDD VSS n12298 NAND2X1
XU12714 n12074 n12244 VDD VSS n12214 XOR2X1
XU12715 n12289 VDD VSS n12212 INVX1
XU12716 g117 n11992 VDD VSS n12289 XOR2X1
XU12717 g101 n12251 VDD VSS n12203 XOR2X1
XU12718 n12300 n12301 VDD VSS n12172 AND2X1
XU12719 n12302 n12303 VDD VSS n12301 NAND2X1
XU12720 n12205 n12304 VDD VSS n12302 NOR2X1
XU12721 n12206 n12209 VDD VSS n12304 AND2X1
XU12722 n12305 n12306 VDD VSS n12205 NOR2X1
XU12723 n12307 n12308 VDD VSS n12300 NOR2X1
XU12724 n12209 n12309 VDD VSS n12308 NOR2X1
XU12725 n12310 n12311 VDD VSS n12309 NAND2X1
XU12726 n12206 n12312 VDD VSS n12311 NAND2X1
XU12727 n12204 n12313 VDD VSS n12310 NAND2X1
XU12728 n12312 n12314 VDD VSS n12307 NOR2X1
XU12729 n12315 n12316 VDD VSS n12314 NAND2X1
XU12730 n12209 n12313 VDD VSS n12316 NAND2X1
XU12731 n12306 VDD VSS n12313 INVX1
XU12732 n12317 n12254 VDD VSS n12306 XOR2X1
XU12733 n11914 n12040 VDD VSS n12209 XOR2X1
XU12734 n12204 n12206 VDD VSS n12315 NAND2X1
XU12735 g105 n12096 VDD VSS n12206 XOR2X1
XU12736 n12303 VDD VSS n12204 INVX1
XU12737 n12318 n12241 VDD VSS n12303 XOR2X1
XU12738 n12305 VDD VSS n12312 INVX1
XU12739 n12319 n12020 VDD VSS n12305 XOR2X1
XU12740 n12320 n12321 VDD VSS n12262 NAND2X1
XU12741 n12322 n12323 VDD VSS n12321 NOR2X1
XU12742 n12324 n12325 VDD VSS n12323 NAND2X1
XU12743 n12326 n12327 VDD VSS n12325 NOR2X1
XU12744 n12074 n12328 VDD VSS n12327 NOR2X1
XU12745 g144 n12329 VDD VSS n12328 NAND2X1
XU12746 g109 n12329 VDD VSS n12326 NOR2X1
XU12747 n12330 n12331 VDD VSS n12324 NOR2X1
XU12748 n11914 n12332 VDD VSS n12331 XOR2X1
XU12749 n12333 n12334 VDD VSS n12332 NOR2X1
XU12750 n12335 n12336 VDD VSS n12334 NAND2X1
XU12751 g165 n10242 VDD VSS n12336 NAND2X1
XU12752 g159 VDD VSS n10242 INVX1
XU12753 g6231 n10247 VDD VSS n12335 NAND2X1
XU12754 g160 VDD VSS n10247 INVX1
XU12755 g161 n11926 VDD VSS n12333 NOR2X1
XU12756 n10239 VDD VSS n11914 INVX1
XU12757 n12337 n12338 VDD VSS n10239 NAND2X1
XU12758 g6313 n12339 VDD VSS n12338 NAND2X1
XU12759 n12340 n12341 VDD VSS n12337 NOR2X1
XU12760 g175 n11842 VDD VSS n12341 NOR2X1
XU12761 g174 n11843 VDD VSS n12340 NOR2X1
XU12762 n11913 n12342 VDD VSS n12330 XOR2X1
XU12763 n12343 n12344 VDD VSS n12342 NOR2X1
XU12764 n12345 n12346 VDD VSS n12344 NAND2X1
XU12765 g165 n10236 VDD VSS n12346 NAND2X1
XU12766 g162 VDD VSS n10236 INVX1
XU12767 g6231 n10250 VDD VSS n12345 NAND2X1
XU12768 g163 VDD VSS n10250 INVX1
XU12769 g164 n11926 VDD VSS n12343 NOR2X1
XU12770 n10231 VDD VSS n11913 INVX1
XU12771 n12347 n12348 VDD VSS n10231 NAND2X1
XU12772 g6313 n12349 VDD VSS n12348 NAND2X1
XU12773 n12350 n12351 VDD VSS n12347 NOR2X1
XU12774 g172 n11842 VDD VSS n12351 NOR2X1
XU12775 g171 n11843 VDD VSS n12350 NOR2X1
XU12776 n12352 n12164 VDD VSS n12322 NAND2X1
XU12777 n12140 VDD VSS n12164 INVX1
XU12778 g181 n12353 VDD VSS n12140 NAND2X1
XU12779 n12354 n12355 VDD VSS n12352 NOR2X1
XU12780 n12109 n12356 VDD VSS n12355 XOR2X1
XU12781 n12357 n12358 VDD VSS n12356 NOR2X1
XU12782 n12359 n12360 VDD VSS n12358 NAND2X1
XU12783 g165 n11723 VDD VSS n12360 NAND2X1
XU12784 g132 VDD VSS n11723 INVX1
XU12785 g6231 n11718 VDD VSS n12359 NAND2X1
XU12786 g133 VDD VSS n11718 INVX1
XU12787 g134 n11926 VDD VSS n12357 NOR2X1
XU12788 g101 VDD VSS n12109 INVX1
XU12789 n12319 n12361 VDD VSS n12354 XOR2X1
XU12790 n12362 n12363 VDD VSS n12361 NOR2X1
XU12791 n12364 n12365 VDD VSS n12363 NAND2X1
XU12792 g165 n11715 VDD VSS n12365 NAND2X1
XU12793 g129 VDD VSS n11715 INVX1
XU12794 g6231 n11710 VDD VSS n12364 NAND2X1
XU12795 g130 VDD VSS n11710 INVX1
XU12796 g131 n11926 VDD VSS n12362 NOR2X1
XU12797 g97 VDD VSS n12319 INVX1
XU12798 n12366 n12367 VDD VSS n12320 NOR2X1
XU12799 n12368 n12369 VDD VSS n12367 NAND2X1
XU12800 n12370 n12371 VDD VSS n12369 NOR2X1
XU12801 n12317 n12372 VDD VSS n12371 NOR2X1
XU12802 g153 n12373 VDD VSS n12372 NAND2X1
XU12803 g121 n12373 VDD VSS n12370 NOR2X1
XU12804 n12374 VDD VSS n12373 INVX1
XU12805 n12375 n12376 VDD VSS n12368 NOR2X1
XU12806 n12377 n12378 VDD VSS n12376 NAND2X1
XU12807 n12379 n12380 VDD VSS n12378 NAND2X1
XU12808 n12381 g117 VDD VSS n12377 NAND2X1
XU12809 n12379 n11760 VDD VSS n12381 NOR2X1
XU12810 n12382 n12383 VDD VSS n12375 NAND2X1
XU12811 n12384 n11843 VDD VSS n12383 NAND2X1
XU12812 n12385 n12386 VDD VSS n12384 NAND2X1
XU12813 n12387 n12388 VDD VSS n12386 NOR2X1
XU12814 n12389 n12390 VDD VSS n12388 NAND2X1
XU12815 n12329 g109 VDD VSS n12390 NAND2X1
XU12816 n12391 n12392 VDD VSS n12329 AND2X1
XU12817 g6231 n11736 VDD VSS n12392 NAND2X1
XU12818 g145 VDD VSS n11736 INVX1
XU12819 g6313 n11739 VDD VSS n12391 NAND2X1
XU12820 g146 VDD VSS n11739 INVX1
XU12821 n12393 n12318 VDD VSS n12389 OR2X1
XU12822 n12394 n12395 VDD VSS n12387 NOR2X1
XU12823 n12396 n12397 VDD VSS n12385 NOR2X1
XU12824 n12398 n12399 VDD VSS n12397 NAND2X1
XU12825 n12400 n12094 VDD VSS n12399 OR2X1
XU12826 n12379 n12380 VDD VSS n12398 OR2X1
XU12827 n12401 n12402 VDD VSS n12379 NAND2X1
XU12828 g6231 n11754 VDD VSS n12402 NAND2X1
XU12829 g151 VDD VSS n11754 INVX1
XU12830 g6313 n11757 VDD VSS n12401 NAND2X1
XU12831 g152 VDD VSS n11757 INVX1
XU12832 n12317 n12374 VDD VSS n12396 NOR2X1
XU12833 n12403 n12404 VDD VSS n12374 NAND2X1
XU12834 g6231 n11763 VDD VSS n12404 NAND2X1
XU12835 g154 VDD VSS n11763 INVX1
XU12836 g6313 n11766 VDD VSS n12403 NAND2X1
XU12837 g155 VDD VSS n11766 INVX1
XU12838 g165 n12405 VDD VSS n12382 NAND2X1
XU12839 n12406 n12407 VDD VSS n12405 NAND2X1
XU12840 n12408 n12409 VDD VSS n12407 NOR2X1
XU12841 n12410 n12411 VDD VSS n12409 NAND2X1
XU12842 n12094 n11733 VDD VSS n12411 NAND2X1
XU12843 n12074 n11742 VDD VSS n12410 NAND2X1
XU12844 g144 VDD VSS n11742 INVX1
XU12845 g109 VDD VSS n12074 INVX1
XU12846 g147 g113 VDD VSS n12408 NOR2X1
XU12847 n12412 n12413 VDD VSS n12406 NOR2X1
XU12848 n12414 n12415 VDD VSS n12413 NAND2X1
XU12849 n12380 n11760 VDD VSS n12415 NAND2X1
XU12850 g150 VDD VSS n11760 INVX1
XU12851 g117 VDD VSS n12380 INVX1
XU12852 n12317 n11769 VDD VSS n12414 NAND2X1
XU12853 g153 VDD VSS n11769 INVX1
XU12854 g121 VDD VSS n12317 INVX1
XU12855 g156 g125 VDD VSS n12412 NOR2X1
XU12856 n12416 n12417 VDD VSS n12366 NAND2X1
XU12857 n12418 n12419 VDD VSS n12417 NOR2X1
XU12858 n12394 n12420 VDD VSS n12419 NOR2X1
XU12859 g156 n12421 VDD VSS n12420 NAND2X1
XU12860 g125 n12421 VDD VSS n12418 NOR2X1
XU12861 n12395 VDD VSS n12421 INVX1
XU12862 n12422 n12423 VDD VSS n12395 NAND2X1
XU12863 g6231 n11921 VDD VSS n12423 NAND2X1
XU12864 g157 VDD VSS n11921 INVX1
XU12865 g6313 n11925 VDD VSS n12422 NAND2X1
XU12866 g158 VDD VSS n11925 INVX1
XU12867 n12424 n12425 VDD VSS n12416 NOR2X1
XU12868 n12426 n12427 VDD VSS n12425 NAND2X1
XU12869 n12393 n12318 VDD VSS n12427 NAND2X1
XU12870 n12428 g113 VDD VSS n12426 NAND2X1
XU12871 n12393 n11751 VDD VSS n12428 NOR2X1
XU12872 g147 VDD VSS n11751 INVX1
XU12873 n12429 n12430 VDD VSS n12393 NAND2X1
XU12874 g6231 n11745 VDD VSS n12430 NAND2X1
XU12875 g148 VDD VSS n11745 INVX1
XU12876 g6313 n11748 VDD VSS n12429 NAND2X1
XU12877 g149 VDD VSS n11748 INVX1
XU12878 n12431 n12432 VDD VSS n12424 NAND2X1
XU12879 n12400 n12094 VDD VSS n12432 NAND2X1
XU12880 g105 VDD VSS n12094 INVX1
XU12881 n12433 g105 VDD VSS n12431 NAND2X1
XU12882 n12400 n11733 VDD VSS n12433 NOR2X1
XU12883 g141 VDD VSS n11733 INVX1
XU12884 n12434 n12435 VDD VSS n12400 NAND2X1
XU12885 g6231 n11726 VDD VSS n12435 NAND2X1
XU12886 g142 VDD VSS n11726 INVX1
XU12887 g6313 n11730 VDD VSS n12434 NAND2X1
XU12888 g143 VDD VSS n11730 INVX1
XU12889 n12353 n11922 VDD VSS n11872 NOR2X1
XU12890 n12436 n12437 VDD VSS n12353 NAND2X1
XU12891 g6313 n12438 VDD VSS n12437 NAND2X1
XU12892 n12439 n12440 VDD VSS n12436 NOR2X1
XU12893 g169 n11842 VDD VSS n12440 NOR2X1
XU12894 g168 n11843 VDD VSS n12439 NOR2X1
XU12895 n12441 n12442 VDD VSS n7884 NAND2X1
XU12896 n9741 g785 VDD VSS n12442 NAND2X1
XU12897 n9742 n12443 VDD VSS n12441 NAND2X1
XU12898 n12444 n12445 VDD VSS n7883 NAND2X1
XU12899 n9726 g785 VDD VSS n12445 NAND2X1
XU12900 n9728 n12446 VDD VSS n12444 NAND2X1
XU12901 n12447 n12448 VDD VSS n7882 NAND2X1
XU12902 g785 n9732 VDD VSS n12448 NAND2X1
XU12903 n9732 g817 VDD VSS n12447 OR2X1
XU12904 n12449 n12450 VDD VSS n7881 NAND2X1
XU12905 n9741 g789 VDD VSS n12450 NAND2X1
XU12906 n9742 n12451 VDD VSS n12449 NAND2X1
XU12907 n12452 n12453 VDD VSS n7880 NAND2X1
XU12908 n9726 g789 VDD VSS n12453 NAND2X1
XU12909 n9728 n12454 VDD VSS n12452 NAND2X1
XU12910 n12455 n12456 VDD VSS n7879 NAND2X1
XU12911 g789 n9732 VDD VSS n12456 NAND2X1
XU12912 n9732 g820 VDD VSS n12455 OR2X1
XU12913 n12457 n12458 VDD VSS n7878 NAND2X1
XU12914 n9741 g793 VDD VSS n12458 NAND2X1
XU12915 n9742 n12459 VDD VSS n12457 NAND2X1
XU12916 n12460 n12461 VDD VSS n7877 NAND2X1
XU12917 n9726 g793 VDD VSS n12461 NAND2X1
XU12918 n9728 n12462 VDD VSS n12460 NAND2X1
XU12919 n12463 n12464 VDD VSS n7876 NAND2X1
XU12920 g793 n9732 VDD VSS n12464 NAND2X1
XU12921 n12465 n12466 VDD VSS n12463 NAND2X1
XU12922 n12467 n12468 VDD VSS n7875 NAND2X1
XU12923 n9741 g797 VDD VSS n12468 NAND2X1
XU12924 n9742 n12469 VDD VSS n12467 NAND2X1
XU12925 n12470 n12471 VDD VSS n7874 NAND2X1
XU12926 n9726 g797 VDD VSS n12471 NAND2X1
XU12927 n9728 n12472 VDD VSS n12470 NAND2X1
XU12928 n12473 n12474 VDD VSS n7873 NAND2X1
XU12929 g797 n9732 VDD VSS n12474 NAND2X1
XU12930 n12465 n12475 VDD VSS n12473 NAND2X1
XU12931 n12476 n12477 VDD VSS n7872 NAND2X1
XU12932 n9741 g801 VDD VSS n12477 NAND2X1
XU12933 n9742 n12478 VDD VSS n12476 NAND2X1
XU12934 n12479 n12480 VDD VSS n7871 NAND2X1
XU12935 n9726 g801 VDD VSS n12480 NAND2X1
XU12936 n9728 n12481 VDD VSS n12479 NAND2X1
XU12937 n12482 n12483 VDD VSS n7870 NAND2X1
XU12938 g801 n9732 VDD VSS n12483 NAND2X1
XU12939 n12465 n12484 VDD VSS n12482 NAND2X1
XU12940 n12485 n12486 VDD VSS n7869 NAND2X1
XU12941 n9741 g805 VDD VSS n12486 NAND2X1
XU12942 n9742 n12487 VDD VSS n12485 NAND2X1
XU12943 n12488 n12489 VDD VSS n7868 NAND2X1
XU12944 n9726 g805 VDD VSS n12489 NAND2X1
XU12945 n9728 n12490 VDD VSS n12488 NAND2X1
XU12946 n12491 n12492 VDD VSS n7867 NAND2X1
XU12947 g805 n9732 VDD VSS n12492 NAND2X1
XU12948 n12465 n12493 VDD VSS n12491 NAND2X1
XU12949 n12494 n12495 VDD VSS n7866 NAND2X1
XU12950 n9741 g809 VDD VSS n12495 NAND2X1
XU12951 n9742 n12496 VDD VSS n12494 NAND2X1
XU12952 n12497 n12498 VDD VSS n7865 NAND2X1
XU12953 n9726 g809 VDD VSS n12498 NAND2X1
XU12954 n9728 n12499 VDD VSS n12497 NAND2X1
XU12955 n12500 n12501 VDD VSS n7864 NAND2X1
XU12956 g809 n9732 VDD VSS n12501 NAND2X1
XU12957 n12465 n12502 VDD VSS n12500 NAND2X1
XU12958 n9732 VDD VSS n12465 INVX1
XU12959 n12503 n12504 VDD VSS n7863 NAND2X1
XU12960 n12505 n12506 VDD VSS n12504 NAND2X1
XU12961 n12507 g5472 VDD VSS n12503 NAND2X1
XU12962 n12508 n12509 VDD VSS n7862 NAND2X1
XU12963 g1119 g6712 VDD VSS n12509 OR2X1
XU12964 n12507 g6712 VDD VSS n12508 NAND2X1
XU12965 n12510 n12511 VDD VSS n7861 NAND2X1
XU12966 n12512 n12513 VDD VSS n12511 NAND2X1
XU12967 n12507 g1088 VDD VSS n12510 NAND2X1
XU12968 n12514 n12515 VDD VSS n12507 NAND2X1
XU12969 n12516 n12517 VDD VSS n12515 NAND2X1
XU12970 g996 n12518 VDD VSS n12514 NAND2X1
XU12971 n12519 n12520 VDD VSS n7860 NAND2X1
XU12972 n12521 n12506 VDD VSS n12520 NAND2X1
XU12973 n12522 g5472 VDD VSS n12519 NAND2X1
XU12974 n12523 n12524 VDD VSS n7859 NAND2X1
XU12975 n12525 n10170 VDD VSS n12524 NAND2X1
XU12976 n12522 g6712 VDD VSS n12523 NAND2X1
XU12977 n12526 n12527 VDD VSS n7858 NAND2X1
XU12978 g1088 g1131 VDD VSS n12527 OR2X1
XU12979 n12522 g1088 VDD VSS n12526 NAND2X1
XU12980 n12528 n12529 VDD VSS n12522 XOR2X1
XU12981 n12530 g996 VDD VSS n12528 NAND2X1
XU12982 n12531 n12532 VDD VSS n12530 NOR2X1
XU12983 n12533 n12534 VDD VSS n7857 NAND2X1
XU12984 n12535 n12536 VDD VSS n12534 NAND2X1
XU12985 g1134 VDD VSS n12536 INVX1
XU12986 n12537 g1088 VDD VSS n12535 NAND2X1
XU12987 n12538 g1088 VDD VSS n12533 NAND2X1
XU12988 n12539 n12540 VDD VSS n7856 NAND2X1
XU12989 n12541 n12542 VDD VSS n12540 NAND2X1
XU12990 n12537 g6712 VDD VSS n12541 NAND2X1
XU12991 n12538 g6712 VDD VSS n12539 NAND2X1
XU12992 n12543 n12544 VDD VSS n7855 NAND2X1
XU12993 n12545 n12546 VDD VSS n12544 NAND2X1
XU12994 g1135 VDD VSS n12546 INVX1
XU12995 n12537 g5472 VDD VSS n12545 NAND2X1
XU12996 n12547 g996 VDD VSS n12537 AND2X1
XU12997 n12548 n12549 VDD VSS n12547 NOR2X1
XU12998 n12550 n12551 VDD VSS n12549 NOR2X1
XU12999 n12529 n12518 VDD VSS n12550 NOR2X1
XU13000 n12516 n12552 VDD VSS n12548 NOR2X1
XU13001 n9719 n12553 VDD VSS n12552 NOR2X1
XU13002 n12538 g5472 VDD VSS n12543 NAND2X1
XU13003 n12554 n12531 VDD VSS n12538 AND2X1
XU13004 n12555 n12556 VDD VSS n12531 AND2X1
XU13005 g6712 n12542 VDD VSS n12556 NAND2X1
XU13006 g1136 VDD VSS n12542 INVX1
XU13007 n12557 n12558 VDD VSS n12555 NOR2X1
XU13008 g1135 n12506 VDD VSS n12558 NOR2X1
XU13009 g1134 n12512 VDD VSS n12557 NOR2X1
XU13010 n12532 n12517 VDD VSS n12554 NOR2X1
XU13011 n12559 n12560 VDD VSS n12532 AND2X1
XU13012 n12561 n12529 VDD VSS n12560 NAND2X1
XU13013 n12553 n12551 VDD VSS n12561 NOR2X1
XU13014 n12518 VDD VSS n12553 INVX1
XU13015 n12562 n9719 VDD VSS n12559 NAND2X1
XU13016 n12529 VDD VSS n9719 INVX1
XU13017 n12563 n12564 VDD VSS n12529 NAND2X1
XU13018 g1131 g1088 VDD VSS n12564 NAND2X1
XU13019 n12565 n12566 VDD VSS n12563 NOR2X1
XU13020 n12506 n12521 VDD VSS n12566 NOR2X1
XU13021 g1125 VDD VSS n12521 INVX1
XU13022 n10170 n12525 VDD VSS n12565 NOR2X1
XU13023 g1128 VDD VSS n12525 INVX1
XU13024 n12516 n12518 VDD VSS n12562 NOR2X1
XU13025 n12567 n12568 VDD VSS n12518 NAND2X1
XU13026 n12569 n12570 VDD VSS n12568 NAND2X1
XU13027 g853 n12571 VDD VSS n12570 NAND2X1
XU13028 n12572 n12573 VDD VSS n12569 NOR2X1
XU13029 g867 n12574 VDD VSS n12573 NOR2X1
XU13030 g866 n12575 VDD VSS n12572 NOR2X1
XU13031 n12551 VDD VSS n12516 INVX1
XU13032 n12576 n12577 VDD VSS n12551 NAND2X1
XU13033 g1119 g6712 VDD VSS n12577 NAND2X1
XU13034 n12578 n12579 VDD VSS n12576 NOR2X1
XU13035 n12506 n12505 VDD VSS n12579 NOR2X1
XU13036 g1116 VDD VSS n12505 INVX1
XU13037 n12512 n12513 VDD VSS n12578 NOR2X1
XU13038 g1122 VDD VSS n12513 INVX1
XU13039 n12580 n12581 VDD VSS n7854 NAND2X1
XU13040 n12582 n12506 VDD VSS n12581 NAND2X1
XU13041 n12583 g5472 VDD VSS n12580 NAND2X1
XU13042 n12584 n12585 VDD VSS n7853 NAND2X1
XU13043 g1107 g6712 VDD VSS n12585 OR2X1
XU13044 n12583 g6712 VDD VSS n12584 NAND2X1
XU13045 n12586 n12587 VDD VSS n7852 NAND2X1
XU13046 n12512 n12588 VDD VSS n12587 NAND2X1
XU13047 n12583 g1088 VDD VSS n12586 NAND2X1
XU13048 n9712 n12589 VDD VSS n12583 XOR2X1
XU13049 n12590 n12591 VDD VSS n12589 NOR2X1
XU13050 n12592 n12593 VDD VSS n12591 NOR2X1
XU13051 g996 n12594 VDD VSS n12593 NAND2X1
XU13052 n12595 n12596 VDD VSS n12592 NAND2X1
XU13053 n205 n12597 VDD VSS n12596 NAND2X1
XU13054 n12598 n12599 VDD VSS n12597 NAND2X1
XU13055 n12600 n9712 VDD VSS n12595 NAND2X1
XU13056 n12599 n12601 VDD VSS n12600 NAND2X1
XU13057 n12602 n12603 VDD VSS n12590 NOR2X1
XU13058 n205 n12598 VDD VSS n12603 NAND2X1
XU13059 n12601 VDD VSS n12598 INVX1
XU13060 n12604 g996 VDD VSS n12602 NAND2X1
XU13061 n12605 n12606 VDD VSS n7851 NAND2X1
XU13062 n12607 n12608 VDD VSS n12606 NAND2X1
XU13063 g1114 VDD VSS n12608 INVX1
XU13064 n12609 g5472 VDD VSS n12607 NAND2X1
XU13065 n12610 g5472 VDD VSS n12605 NAND2X1
XU13066 n12611 n12612 VDD VSS n7850 NAND2X1
XU13067 n12613 n12614 VDD VSS n12612 NAND2X1
XU13068 n12609 g6712 VDD VSS n12613 NAND2X1
XU13069 n12610 g6712 VDD VSS n12611 NAND2X1
XU13070 n12615 n12616 VDD VSS n7849 NAND2X1
XU13071 n12617 n12618 VDD VSS n12616 NAND2X1
XU13072 g1113 VDD VSS n12618 INVX1
XU13073 n12609 g1088 VDD VSS n12617 NAND2X1
XU13074 n12610 g1088 VDD VSS n12615 NAND2X1
XU13075 n12619 n12620 VDD VSS n12610 AND2X1
XU13076 n12621 n12622 VDD VSS n12620 NOR2X1
XU13077 n12517 n12599 VDD VSS n12619 NOR2X1
XU13078 n12623 n12624 VDD VSS n7848 NAND2X1
XU13079 n12625 n12506 VDD VSS n12624 NAND2X1
XU13080 n12626 g5472 VDD VSS n12623 NAND2X1
XU13081 n12627 n12628 VDD VSS n7847 NAND2X1
XU13082 g1098 g6712 VDD VSS n12628 OR2X1
XU13083 n12626 g6712 VDD VSS n12627 NAND2X1
XU13084 n12629 n12630 VDD VSS n7846 NAND2X1
XU13085 n12512 n12631 VDD VSS n12630 NAND2X1
XU13086 n12626 g1088 VDD VSS n12629 NAND2X1
XU13087 n12594 n12632 VDD VSS n12626 XOR2X1
XU13088 n12609 n12633 VDD VSS n12632 NOR2X1
XU13089 n12517 n12634 VDD VSS n12633 NOR2X1
XU13090 n12635 n12594 VDD VSS n12634 NAND2X1
XU13091 n12599 n12622 VDD VSS n12635 OR2X1
XU13092 n12636 n12637 VDD VSS n12599 NAND2X1
XU13093 g6712 n12614 VDD VSS n12637 NAND2X1
XU13094 g1115 VDD VSS n12614 INVX1
XU13095 n12638 n12639 VDD VSS n12636 NOR2X1
XU13096 g1114 n12506 VDD VSS n12639 NOR2X1
XU13097 g1113 n12512 VDD VSS n12638 NOR2X1
XU13098 n12640 n12621 VDD VSS n12609 AND2X1
XU13099 n12594 VDD VSS n12621 INVX1
XU13100 n12622 n12517 VDD VSS n12640 NOR2X1
XU13101 n12641 n12642 VDD VSS n12622 AND2X1
XU13102 n12601 n9712 VDD VSS n12642 NAND2X1
XU13103 n12643 n205 VDD VSS n12641 NAND2X1
XU13104 n12604 n12601 VDD VSS n12643 NOR2X1
XU13105 n12644 n12567 VDD VSS n12601 NAND2X1
XU13106 n12645 n12646 VDD VSS n12644 NOR2X1
XU13107 n12647 n12648 VDD VSS n12594 NAND2X1
XU13108 g1098 g6712 VDD VSS n12648 NAND2X1
XU13109 n12649 n12650 VDD VSS n12647 NOR2X1
XU13110 n12506 n12625 VDD VSS n12650 NOR2X1
XU13111 g1095 VDD VSS n12625 INVX1
XU13112 n12512 n12631 VDD VSS n12649 NOR2X1
XU13113 g1101 VDD VSS n12631 INVX1
XU13114 n12651 n12652 VDD VSS n7845 NAND2X1
XU13115 n9741 g813 VDD VSS n12652 NAND2X1
XU13116 n9742 n12653 VDD VSS n12651 NAND2X1
XU13117 n9741 VDD VSS n9742 INVX1
XU13118 n12575 n12654 VDD VSS n9741 NOR2X1
XU13119 n12655 n12656 VDD VSS n7844 NAND2X1
XU13120 n9726 g813 VDD VSS n12656 NAND2X1
XU13121 n9728 n12657 VDD VSS n12655 NAND2X1
XU13122 n9726 VDD VSS n9728 INVX1
XU13123 n12654 n12574 VDD VSS n9726 NOR2X1
XU13124 n12658 n12659 VDD VSS n7843 NAND2X1
XU13125 g813 n9732 VDD VSS n12659 NAND2X1
XU13126 n9732 g844 VDD VSS n12658 OR2X1
XU13127 n12660 n12661 VDD VSS n7842 NAND2X1
XU13128 n12662 n12663 VDD VSS n12661 NAND2X1
XU13129 g1090 VDD VSS n12663 INVX1
XU13130 g996 g5472 VDD VSS n12662 NAND2X1
XU13131 n12664 g5472 VDD VSS n12660 NAND2X1
XU13132 n12665 n12666 VDD VSS n7841 NAND2X1
XU13133 n12667 n12668 VDD VSS n12666 NAND2X1
XU13134 g1091 VDD VSS n12668 INVX1
XU13135 g996 g6712 VDD VSS n12667 NAND2X1
XU13136 n12664 g6712 VDD VSS n12665 NAND2X1
XU13137 n12669 n12670 VDD VSS n7840 NAND2X1
XU13138 n12671 n12672 VDD VSS n12670 NAND2X1
XU13139 g996 g1088 VDD VSS n12671 NAND2X1
XU13140 n12664 g1088 VDD VSS n12669 NAND2X1
XU13141 n12673 n12674 VDD VSS n12664 NOR2X1
XU13142 g996 n12675 VDD VSS n12673 NAND2X1
XU13143 n12676 n12677 VDD VSS n7839 NAND2X1
XU13144 n12506 n12678 VDD VSS n12677 NAND2X1
XU13145 g5472 n12679 VDD VSS n12676 NAND2X1
XU13146 n12680 n12681 VDD VSS n7838 NAND2X1
XU13147 g1000 g6712 VDD VSS n12681 OR2X1
XU13148 g6712 n12679 VDD VSS n12680 NAND2X1
XU13149 n12682 n12683 VDD VSS n7837 NAND2X1
XU13150 g1001 g1088 VDD VSS n12683 OR2X1
XU13151 g1088 n12679 VDD VSS n12682 NAND2X1
XU13152 n12684 n12685 VDD VSS n12679 NAND2X1
XU13153 n12686 n12687 VDD VSS n12685 NAND2X1
XU13154 n12688 n12689 VDD VSS n12686 NAND2X1
XU13155 n12690 n12691 VDD VSS n12688 NOR2X1
XU13156 n12692 n12693 VDD VSS n7836 NAND2X1
XU13157 n12575 n12694 VDD VSS n12693 NAND2X1
XU13158 n12695 g6368 VDD VSS n12692 NAND2X1
XU13159 n12696 n12697 VDD VSS n7835 NAND2X1
XU13160 n12574 n12698 VDD VSS n12697 NAND2X1
XU13161 n12695 g6518 VDD VSS n12696 NAND2X1
XU13162 n12699 n12700 VDD VSS n7834 NAND2X1
XU13163 g853 g906 VDD VSS n12700 OR2X1
XU13164 n12695 g853 VDD VSS n12699 NAND2X1
XU13165 n12701 n12702 VDD VSS n12695 AND2X1
XU13166 n12703 n12704 VDD VSS n12702 NAND2X1
XU13167 n12705 n12706 VDD VSS n12703 XOR2X1
XU13168 n12707 g809 VDD VSS n12701 NAND2X1
XU13169 n12708 n12709 VDD VSS n7833 NAND2X1
XU13170 n12575 n12710 VDD VSS n12709 NAND2X1
XU13171 g6368 n12711 VDD VSS n12708 NAND2X1
XU13172 n12712 n12713 VDD VSS n7832 NAND2X1
XU13173 n12574 n12714 VDD VSS n12713 NAND2X1
XU13174 g6518 n12711 VDD VSS n12712 NAND2X1
XU13175 n12715 n12716 VDD VSS n7831 NAND2X1
XU13176 g853 g942 VDD VSS n12716 OR2X1
XU13177 g853 n12711 VDD VSS n12715 NAND2X1
XU13178 n12717 n12718 VDD VSS n12711 NAND2X1
XU13179 n12719 n12720 VDD VSS n12717 NOR2X1
XU13180 n12721 n12722 VDD VSS n12720 NOR2X1
XU13181 n12723 n12724 VDD VSS n12722 XOR2X1
XU13182 g805 n12704 VDD VSS n12719 NOR2X1
XU13183 n12725 n12726 VDD VSS n7830 NAND2X1
XU13184 n12575 n12727 VDD VSS n12726 NAND2X1
XU13185 n12728 g6368 VDD VSS n12725 NAND2X1
XU13186 n12729 n12730 VDD VSS n7829 NAND2X1
XU13187 n12574 n12731 VDD VSS n12730 NAND2X1
XU13188 n12728 g6518 VDD VSS n12729 NAND2X1
XU13189 n12732 n12733 VDD VSS n7828 NAND2X1
XU13190 g853 g897 VDD VSS n12733 OR2X1
XU13191 n12728 g853 VDD VSS n12732 NAND2X1
XU13192 n12734 n12735 VDD VSS n12728 AND2X1
XU13193 n12736 n12704 VDD VSS n12735 NAND2X1
XU13194 n12737 n12738 VDD VSS n12736 XOR2X1
XU13195 n12707 g801 VDD VSS n12734 NAND2X1
XU13196 n12739 n12740 VDD VSS n7827 NAND2X1
XU13197 g853 g879 VDD VSS n12740 OR2X1
XU13198 n12741 g853 VDD VSS n12739 NAND2X1
XU13199 n12742 n12743 VDD VSS n7826 NAND2X1
XU13200 n12575 n12744 VDD VSS n12743 NAND2X1
XU13201 n12741 g6368 VDD VSS n12742 NAND2X1
XU13202 n12745 n12746 VDD VSS n7825 NAND2X1
XU13203 n12574 n12747 VDD VSS n12746 NAND2X1
XU13204 n12741 g6518 VDD VSS n12745 NAND2X1
XU13205 n12748 n12749 VDD VSS n12741 AND2X1
XU13206 n12704 n12750 VDD VSS n12749 NAND2X1
XU13207 n12751 n12752 VDD VSS n12750 XOR2X1
XU13208 n12707 g785 VDD VSS n12748 NAND2X1
XU13209 n12753 n12754 VDD VSS n7824 NAND2X1
XU13210 g853 g960 VDD VSS n12754 OR2X1
XU13211 g853 n12755 VDD VSS n12753 NAND2X1
XU13212 n12756 n12757 VDD VSS n7823 NAND2X1
XU13213 n12575 n12758 VDD VSS n12757 NAND2X1
XU13214 g6368 n12755 VDD VSS n12756 NAND2X1
XU13215 n12759 n12760 VDD VSS n7822 NAND2X1
XU13216 n12574 n12761 VDD VSS n12760 NAND2X1
XU13217 g6518 n12755 VDD VSS n12759 NAND2X1
XU13218 n12762 n12763 VDD VSS n12755 NAND2X1
XU13219 n12707 n12645 VDD VSS n12763 NAND2X1
XU13220 n12764 n12765 VDD VSS n12762 NOR2X1
XU13221 n12766 n12721 VDD VSS n12765 NOR2X1
XU13222 n12767 n12768 VDD VSS n12766 XOR2X1
XU13223 n12769 n12770 VDD VSS n12768 NOR2X1
XU13224 n12771 n12687 VDD VSS n12769 XOR2X1
XU13225 n12772 n12773 VDD VSS n7821 NAND2X1
XU13226 n12575 n12774 VDD VSS n12773 NAND2X1
XU13227 n12775 g6368 VDD VSS n12772 NAND2X1
XU13228 n12776 n12777 VDD VSS n7820 NAND2X1
XU13229 n12574 n12778 VDD VSS n12777 NAND2X1
XU13230 n12775 g6518 VDD VSS n12776 NAND2X1
XU13231 n12779 n12780 VDD VSS n7819 NAND2X1
XU13232 g853 g915 VDD VSS n12780 OR2X1
XU13233 n12775 g853 VDD VSS n12779 NAND2X1
XU13234 n12781 n12782 VDD VSS n12775 AND2X1
XU13235 n12783 n12784 VDD VSS n12781 NOR2X1
XU13236 n12646 n12785 VDD VSS n12784 NOR2X1
XU13237 n12721 n12786 VDD VSS n12783 NOR2X1
XU13238 n12770 n12787 VDD VSS n12786 XOR2X1
XU13239 n12788 n12789 VDD VSS n12770 NAND2X1
XU13240 n12687 n12790 VDD VSS n12789 XOR2X1
XU13241 n12791 n12792 VDD VSS n7818 NAND2X1
XU13242 n12575 n12793 VDD VSS n12792 NAND2X1
XU13243 g6368 n12794 VDD VSS n12791 NAND2X1
XU13244 n12795 n12796 VDD VSS n7817 NAND2X1
XU13245 n12574 n12797 VDD VSS n12796 NAND2X1
XU13246 g6518 n12794 VDD VSS n12795 NAND2X1
XU13247 n12798 n12799 VDD VSS n7816 NAND2X1
XU13248 g853 g933 VDD VSS n12799 OR2X1
XU13249 g853 n12794 VDD VSS n12798 NAND2X1
XU13250 n12800 n12801 VDD VSS n12794 NAND2X1
XU13251 n12707 n12802 VDD VSS n12801 NAND2X1
XU13252 n12764 n12803 VDD VSS n12800 NOR2X1
XU13253 n12804 n12721 VDD VSS n12803 NOR2X1
XU13254 n12805 n12806 VDD VSS n12804 XOR2X1
XU13255 n12807 n12808 VDD VSS n7815 NAND2X1
XU13256 n12574 n12809 VDD VSS n12808 NAND2X1
XU13257 n12810 g6518 VDD VSS n12807 NAND2X1
XU13258 n12811 n12812 VDD VSS n7814 NAND2X1
XU13259 g853 g888 VDD VSS n12812 OR2X1
XU13260 n12810 g853 VDD VSS n12811 NAND2X1
XU13261 n12813 n12814 VDD VSS n7813 NAND2X1
XU13262 n12575 n12815 VDD VSS n12814 NAND2X1
XU13263 n12810 g6368 VDD VSS n12813 NAND2X1
XU13264 n12816 n12782 VDD VSS n12810 AND2X1
XU13265 n12817 n12687 VDD VSS n12782 NAND2X1
XU13266 n12818 n12819 VDD VSS n12816 NOR2X1
XU13267 n12820 n12785 VDD VSS n12819 NOR2X1
XU13268 n12721 n12821 VDD VSS n12818 NOR2X1
XU13269 n12822 n12823 VDD VSS n12821 XOR2X1
XU13270 n12824 n12825 VDD VSS n7812 NAND2X1
XU13271 n12575 n12826 VDD VSS n12825 NAND2X1
XU13272 g6368 n12827 VDD VSS n12824 NAND2X1
XU13273 n12828 n12829 VDD VSS n7811 NAND2X1
XU13274 n12574 n12830 VDD VSS n12829 NAND2X1
XU13275 g6518 n12827 VDD VSS n12828 NAND2X1
XU13276 n12831 n12832 VDD VSS n7810 NAND2X1
XU13277 g853 g924 VDD VSS n12832 OR2X1
XU13278 g853 n12827 VDD VSS n12831 NAND2X1
XU13279 n12833 n12834 VDD VSS n12827 NAND2X1
XU13280 n12707 n12835 VDD VSS n12834 NAND2X1
XU13281 n12785 VDD VSS n12707 INVX1
XU13282 n12718 n12721 VDD VSS n12785 NAND2X1
XU13283 n12764 n12836 VDD VSS n12833 NOR2X1
XU13284 n12837 n12721 VDD VSS n12836 NOR2X1
XU13285 n12838 n12839 VDD VSS n12837 XOR2X1
XU13286 n12718 n12687 VDD VSS n12764 NOR2X1
XU13287 n12840 n12841 VDD VSS n7809 NAND2X1
XU13288 n12842 n12843 VDD VSS n12841 NAND2X1
XU13289 g6712 n12844 VDD VSS n12842 NAND2X1
XU13290 n12845 g6712 VDD VSS n12840 NAND2X1
XU13291 n12846 n12847 VDD VSS n7808 NAND2X1
XU13292 n12848 n12849 VDD VSS n12847 NAND2X1
XU13293 g1009 VDD VSS n12849 INVX1
XU13294 g5472 n12844 VDD VSS n12848 NAND2X1
XU13295 n12845 g5472 VDD VSS n12846 NAND2X1
XU13296 n12850 n12851 VDD VSS n7807 NAND2X1
XU13297 n12852 n12853 VDD VSS n12851 NAND2X1
XU13298 g1008 VDD VSS n12853 INVX1
XU13299 g1088 n12844 VDD VSS n12852 NAND2X1
XU13300 n12845 g1088 VDD VSS n12850 NAND2X1
XU13301 n12844 n12854 VDD VSS n12845 AND2X1
XU13302 n12855 n12856 VDD VSS n12854 NAND2X1
XU13303 n12857 n12858 VDD VSS n12856 NAND2X1
XU13304 n12690 n12859 VDD VSS n12857 NOR2X1
XU13305 n12691 n12675 VDD VSS n12855 NAND2X1
XU13306 n12860 n12861 VDD VSS n12844 NAND2X1
XU13307 n12862 n9705 VDD VSS n12861 NAND2X1
XU13308 n12863 n12864 VDD VSS n12862 NOR2X1
XU13309 n12691 g996 VDD VSS n12860 NAND2X1
XU13310 n9705 VDD VSS n12691 INVX1
XU13311 n12865 n12866 VDD VSS n7806 NAND2X1
XU13312 g1005 g5472 VDD VSS n12866 OR2X1
XU13313 g5472 n12867 VDD VSS n12865 NAND2X1
XU13314 n12868 n12869 VDD VSS n7805 NAND2X1
XU13315 g1006 g6712 VDD VSS n12869 OR2X1
XU13316 g6712 n12867 VDD VSS n12868 NAND2X1
XU13317 n12870 n12871 VDD VSS n7804 NAND2X1
XU13318 n12872 n12512 VDD VSS n12871 NAND2X1
XU13319 g1088 n12867 VDD VSS n12870 NAND2X1
XU13320 n12873 n12684 VDD VSS n12867 NAND2X1
XU13321 n12874 n12875 VDD VSS n12873 XOR2X1
XU13322 n12876 n12877 VDD VSS n12874 NAND2X1
XU13323 n12875 n12878 VDD VSS n12877 NAND2X1
XU13324 n12879 n12880 VDD VSS n12878 NAND2X1
XU13325 n12881 n12882 VDD VSS n12880 NAND2X1
XU13326 n12883 n12884 VDD VSS n12881 NAND2X1
XU13327 n12885 n12859 VDD VSS n12876 NAND2X1
XU13328 n12886 n12887 VDD VSS n12885 NOR2X1
XU13329 n12888 n12889 VDD VSS n12887 NAND2X1
XU13330 n12879 n12882 VDD VSS n12886 NAND2X1
XU13331 n12890 n12891 VDD VSS n12882 NAND2X1
XU13332 n12892 n12893 VDD VSS n12891 NAND2X1
XU13333 n12894 VDD VSS n12893 INVX1
XU13334 n12895 n12517 VDD VSS n12892 NOR2X1
XU13335 g996 VDD VSS n12517 INVX1
XU13336 n12896 n12864 VDD VSS n12895 NOR2X1
XU13337 n12897 n12898 VDD VSS n7803 NAND2X1
XU13338 g1002 g5472 VDD VSS n12898 OR2X1
XU13339 g5472 n12899 VDD VSS n12897 NAND2X1
XU13340 n12900 n12901 VDD VSS n7802 NAND2X1
XU13341 g1003 g6712 VDD VSS n12901 OR2X1
XU13342 g6712 n12899 VDD VSS n12900 NAND2X1
XU13343 n12902 n12903 VDD VSS n7801 NAND2X1
XU13344 n12904 n12512 VDD VSS n12903 NAND2X1
XU13345 g1088 n12899 VDD VSS n12902 NAND2X1
XU13346 n12905 n12684 VDD VSS n12899 NAND2X1
XU13347 n12884 n12906 VDD VSS n12905 XOR2X1
XU13348 n12907 n12908 VDD VSS n12906 NAND2X1
XU13349 n12690 n12909 VDD VSS n12908 NAND2X1
XU13350 n12890 n12875 VDD VSS n12909 NAND2X1
XU13351 n12910 n12879 VDD VSS n12907 NAND2X1
XU13352 n12911 n12912 VDD VSS n12910 NAND2X1
XU13353 n12913 n12884 VDD VSS n12912 NAND2X1
XU13354 n12888 n12914 VDD VSS n12913 NAND2X1
XU13355 n12896 n12915 VDD VSS n12914 NAND2X1
XU13356 n12916 n12917 VDD VSS n12915 NAND2X1
XU13357 n12863 n12859 VDD VSS n12916 NOR2X1
XU13358 n12889 VDD VSS n12863 INVX1
XU13359 n12890 n12918 VDD VSS n12911 NAND2X1
XU13360 n12919 n12920 VDD VSS n12918 NAND2X1
XU13361 n12921 n12883 VDD VSS n12920 NAND2X1
XU13362 n12604 n12922 VDD VSS n12883 NOR2X1
XU13363 n12889 n12864 VDD VSS n12922 NOR2X1
XU13364 n12923 n12924 VDD VSS n12889 NAND2X1
XU13365 n12925 n12926 VDD VSS n12924 NOR2X1
XU13366 n12927 n12928 VDD VSS n12926 NAND2X1
XU13367 n12929 n12930 VDD VSS n12925 NAND2X1
XU13368 n12931 n12932 VDD VSS n12923 NOR2X1
XU13369 n12933 n12934 VDD VSS n12932 NAND2X1
XU13370 n12935 n12936 VDD VSS n12931 NAND2X1
XU13371 n12937 n12938 VDD VSS n12935 AND2X1
XU13372 n12939 n12894 VDD VSS n12921 NOR2X1
XU13373 n12875 n12940 VDD VSS n12894 NAND2X1
XU13374 n12888 n12941 VDD VSS n12940 NAND2X1
XU13375 n12942 n12858 VDD VSS n12939 AND2X1
XU13376 n12943 n12944 VDD VSS n12919 NAND2X1
XU13377 n12875 n12604 VDD VSS n12943 NOR2X1
XU13378 n12945 n12946 VDD VSS n7800 NAND2X1
XU13379 n12575 n12947 VDD VSS n12946 NAND2X1
XU13380 g6368 n12948 VDD VSS n12945 NAND2X1
XU13381 g24925 VDD VSS n78 INVX1
XU13382 n12949 n12950 VDD VSS n7799 NAND2X1
XU13383 n12574 n12951 VDD VSS n12950 NAND2X1
XU13384 g6518 n12948 VDD VSS n12949 NAND2X1
XU13385 n12952 n12953 VDD VSS n7798 NAND2X1
XU13386 g853 g951 VDD VSS n12953 OR2X1
XU13387 g853 n12948 VDD VSS n12952 NAND2X1
XU13388 n12954 n12718 VDD VSS n12948 NAND2X1
XU13389 n12817 VDD VSS n12718 INVX1
XU13390 n12955 n12956 VDD VSS n12817 NOR2X1
XU13391 n12957 n12958 VDD VSS n12954 NOR2X1
XU13392 n12721 n12959 VDD VSS n12958 NOR2X1
XU13393 n12790 n12788 VDD VSS n12959 XOR2X1
XU13394 n12706 n12960 VDD VSS n12788 AND2X1
XU13395 n12687 n12705 VDD VSS n12960 XOR2X1
XU13396 n12724 n12961 VDD VSS n12706 AND2X1
XU13397 n12687 n12723 VDD VSS n12961 XOR2X1
XU13398 n12738 n12962 VDD VSS n12724 AND2X1
XU13399 n12687 n12737 VDD VSS n12962 XOR2X1
XU13400 n12806 n12963 VDD VSS n12738 AND2X1
XU13401 n12687 n12805 VDD VSS n12963 XOR2X1
XU13402 n12822 n12964 VDD VSS n12806 NOR2X1
XU13403 n12687 n12965 VDD VSS n12964 XOR2X1
XU13404 n12839 n12966 VDD VSS n12822 NAND2X1
XU13405 n12687 n12838 VDD VSS n12966 XOR2X1
XU13406 n12967 n12752 VDD VSS n12839 AND2X1
XU13407 n12687 n12751 VDD VSS n12967 XOR2X1
XU13408 g813 n12704 VDD VSS n12957 NOR2X1
XU13409 n12721 VDD VSS n12704 INVX1
XU13410 n12968 n12969 VDD VSS n12721 NAND2X1
XU13411 n12970 n12956 VDD VSS n12969 NOR2X1
XU13412 n12684 VDD VSS n12956 INVX1
XU13413 n12675 n12674 VDD VSS n12684 NAND2X1
XU13414 n12971 n12972 VDD VSS n12674 NAND2X1
XU13415 g1088 n12672 VDD VSS n12972 NAND2X1
XU13416 g1089 VDD VSS n12672 INVX1
XU13417 n12973 n12974 VDD VSS n12971 NOR2X1
XU13418 g1090 n12506 VDD VSS n12974 NOR2X1
XU13419 g1091 n10170 VDD VSS n12973 NOR2X1
XU13420 n9705 n12944 VDD VSS n12970 NOR2X1
XU13421 n12675 n12942 VDD VSS n12944 NAND2X1
XU13422 n12975 VDD VSS n12675 INVX1
XU13423 n12976 n12890 VDD VSS n9705 NAND2X1
XU13424 n12875 n12690 VDD VSS n12976 NOR2X1
XU13425 n12977 n12978 VDD VSS n12968 NOR2X1
XU13426 n12979 n12955 VDD VSS n12978 NOR2X1
XU13427 n12752 n12980 VDD VSS n12955 NAND2X1
XU13428 n12981 n12982 VDD VSS n12980 NAND2X1
XU13429 n9689 n12687 VDD VSS n12752 NAND2X1
XU13430 n12983 n12687 VDD VSS n12979 NOR2X1
XU13431 n12981 VDD VSS n12983 INVX1
XU13432 n12984 n12985 VDD VSS n12981 NAND2X1
XU13433 n12986 n12987 VDD VSS n12985 NOR2X1
XU13434 n12805 n12767 VDD VSS n12987 NAND2X1
XU13435 n12823 n12787 VDD VSS n12986 NAND2X1
XU13436 n12687 n12988 VDD VSS n12984 NOR2X1
XU13437 n12989 n12990 VDD VSS n12988 OR2X1
XU13438 n12991 n12875 VDD VSS n12687 NAND2X1
XU13439 n12890 n12879 VDD VSS n12991 NOR2X1
XU13440 n12992 n12690 VDD VSS n12977 NOR2X1
XU13441 n12604 n12993 VDD VSS n12992 NOR2X1
XU13442 n12994 n12995 VDD VSS n12993 NOR2X1
XU13443 n12890 n12942 VDD VSS n12995 NAND2X1
XU13444 n12996 n12997 VDD VSS n12942 NAND2X1
XU13445 g6712 n12843 VDD VSS n12997 NAND2X1
XU13446 g1010 VDD VSS n12843 INVX1
XU13447 n12998 n12999 VDD VSS n12996 NOR2X1
XU13448 g1009 n12506 VDD VSS n12999 NOR2X1
XU13449 g1008 n12512 VDD VSS n12998 NOR2X1
XU13450 n12858 VDD VSS n12994 INVX1
XU13451 n12975 n12689 VDD VSS n12858 NOR2X1
XU13452 n12888 n13000 VDD VSS n12689 AND2X1
XU13453 n12896 n12917 VDD VSS n13000 NAND2X1
XU13454 n12941 VDD VSS n12917 INVX1
XU13455 n13001 n13002 VDD VSS n12941 NAND2X1
XU13456 n13003 n13004 VDD VSS n13002 NAND2X1
XU13457 n13005 n13006 VDD VSS n13003 NOR2X1
XU13458 n12938 n12934 VDD VSS n13006 AND2X1
XU13459 n12927 n12937 VDD VSS n13005 AND2X1
XU13460 n13007 n13008 VDD VSS n13001 NOR2X1
XU13461 n12934 n13009 VDD VSS n13008 NOR2X1
XU13462 n13010 n13011 VDD VSS n13009 NAND2X1
XU13463 n12938 n12927 VDD VSS n13011 NAND2X1
XU13464 n12936 n12937 VDD VSS n13010 NAND2X1
XU13465 n12927 n13012 VDD VSS n13007 NOR2X1
XU13466 n13013 n13014 VDD VSS n13012 NAND2X1
XU13467 n12934 n12937 VDD VSS n13014 NAND2X1
XU13468 n13015 n12790 VDD VSS n12937 XOR2X1
XU13469 n12767 n12645 VDD VSS n12934 XOR2X1
XU13470 n12936 n12938 VDD VSS n13013 NAND2X1
XU13471 n12802 n12805 VDD VSS n12938 XOR2X1
XU13472 n13004 VDD VSS n12936 INVX1
XU13473 g805 n12723 VDD VSS n13004 XOR2X1
XU13474 g789 n12990 VDD VSS n12927 XOR2X1
XU13475 n13016 n13017 VDD VSS n12896 AND2X1
XU13476 n13018 n13019 VDD VSS n13017 NAND2X1
XU13477 n12929 n13020 VDD VSS n13018 NOR2X1
XU13478 n12930 n12933 VDD VSS n13020 AND2X1
XU13479 n13021 n13022 VDD VSS n12929 NOR2X1
XU13480 n13023 n13024 VDD VSS n13016 NOR2X1
XU13481 n12933 n13025 VDD VSS n13024 NOR2X1
XU13482 n13026 n13027 VDD VSS n13025 NAND2X1
XU13483 n12930 n13028 VDD VSS n13027 NAND2X1
XU13484 n12928 n13029 VDD VSS n13026 NAND2X1
XU13485 n13028 n13030 VDD VSS n13023 NOR2X1
XU13486 n13031 n13032 VDD VSS n13030 NAND2X1
XU13487 n12933 n13029 VDD VSS n13032 NAND2X1
XU13488 n13022 VDD VSS n13029 INVX1
XU13489 g809 n12705 VDD VSS n13022 XOR2X1
XU13490 n12646 n12787 VDD VSS n12933 XOR2X1
XU13491 n12928 n12930 VDD VSS n13031 NAND2X1
XU13492 g793 n12965 VDD VSS n12930 XOR2X1
XU13493 n13019 VDD VSS n12928 INVX1
XU13494 g801 n12737 VDD VSS n13019 XOR2X1
XU13495 n13021 VDD VSS n13028 INVX1
XU13496 g785 n12751 VDD VSS n13021 XOR2X1
XU13497 n13033 n13034 VDD VSS n12975 NAND2X1
XU13498 n13035 n13036 VDD VSS n13034 NOR2X1
XU13499 n13037 n13038 VDD VSS n13036 NAND2X1
XU13500 n13039 n13040 VDD VSS n13038 NOR2X1
XU13501 n12802 n13041 VDD VSS n13040 NOR2X1
XU13502 g832 n13042 VDD VSS n13041 NAND2X1
XU13503 g797 n13042 VDD VSS n13039 NOR2X1
XU13504 n13043 n13044 VDD VSS n13037 NOR2X1
XU13505 n12646 n13045 VDD VSS n13044 XOR2X1
XU13506 n13046 n13047 VDD VSS n13045 NOR2X1
XU13507 n13048 n13049 VDD VSS n13047 NAND2X1
XU13508 g6368 n9743 VDD VSS n13049 NAND2X1
XU13509 g848 VDD VSS n9743 INVX1
XU13510 g6518 n9735 VDD VSS n13048 NAND2X1
XU13511 g849 VDD VSS n9735 INVX1
XU13512 g847 n13050 VDD VSS n13046 NOR2X1
XU13513 n9736 VDD VSS n12646 INVX1
XU13514 n13051 n13052 VDD VSS n9736 NAND2X1
XU13515 g853 n13053 VDD VSS n13052 NAND2X1
XU13516 n13054 n13055 VDD VSS n13051 NOR2X1
XU13517 g864 n12574 VDD VSS n13055 NOR2X1
XU13518 g863 n12575 VDD VSS n13054 NOR2X1
XU13519 n12645 n13056 VDD VSS n13043 XOR2X1
XU13520 n13057 n13058 VDD VSS n13056 NOR2X1
XU13521 n13059 n13060 VDD VSS n13058 NAND2X1
XU13522 g6368 n9746 VDD VSS n13060 NAND2X1
XU13523 g851 VDD VSS n9746 INVX1
XU13524 g6518 n9729 VDD VSS n13059 NAND2X1
XU13525 g852 VDD VSS n9729 INVX1
XU13526 g850 n13050 VDD VSS n13057 NOR2X1
XU13527 n9727 VDD VSS n12645 INVX1
XU13528 n13061 n13062 VDD VSS n9727 NAND2X1
XU13529 g853 n13063 VDD VSS n13062 NAND2X1
XU13530 n13064 n13065 VDD VSS n13061 NOR2X1
XU13531 g861 n12574 VDD VSS n13065 NOR2X1
XU13532 g860 n12575 VDD VSS n13064 NOR2X1
XU13533 n13066 n12888 VDD VSS n13035 NAND2X1
XU13534 n12864 VDD VSS n12888 INVX1
XU13535 g869 n13067 VDD VSS n12864 NAND2X1
XU13536 n13068 n13069 VDD VSS n13066 NOR2X1
XU13537 n13070 VDD VSS n13069 INVX1
XU13538 g785 n13071 VDD VSS n13070 XOR2X1
XU13539 n13072 n13073 VDD VSS n13071 NOR2X1
XU13540 n13074 n13075 VDD VSS n13073 NAND2X1
XU13541 g6368 n12443 VDD VSS n13075 NAND2X1
XU13542 g818 VDD VSS n12443 INVX1
XU13543 g6518 n12446 VDD VSS n13074 NAND2X1
XU13544 g819 VDD VSS n12446 INVX1
XU13545 g817 n13050 VDD VSS n13072 NOR2X1
XU13546 n12835 n13076 VDD VSS n13068 XOR2X1
XU13547 n13077 n13078 VDD VSS n13076 NOR2X1
XU13548 n13079 n13080 VDD VSS n13078 NAND2X1
XU13549 g6368 n12451 VDD VSS n13080 NAND2X1
XU13550 g821 VDD VSS n12451 INVX1
XU13551 g6518 n12454 VDD VSS n13079 NAND2X1
XU13552 g822 VDD VSS n12454 INVX1
XU13553 g820 n13050 VDD VSS n13077 NOR2X1
XU13554 g789 VDD VSS n12835 INVX1
XU13555 n13081 n13082 VDD VSS n13033 NOR2X1
XU13556 n13083 n13084 VDD VSS n13082 NAND2X1
XU13557 n13085 n13086 VDD VSS n13084 NOR2X1
XU13558 n13087 n13088 VDD VSS n13086 NOR2X1
XU13559 g841 n13089 VDD VSS n13088 NAND2X1
XU13560 g809 n13089 VDD VSS n13085 NOR2X1
XU13561 n13090 VDD VSS n13089 INVX1
XU13562 n13091 n13092 VDD VSS n13083 NOR2X1
XU13563 n13093 n13094 VDD VSS n13092 NAND2X1
XU13564 n13095 n13096 VDD VSS n13094 NAND2X1
XU13565 n13097 g805 VDD VSS n13093 NAND2X1
XU13566 n13095 n12493 VDD VSS n13097 NOR2X1
XU13567 n13098 n13099 VDD VSS n13091 NAND2X1
XU13568 n13100 n13050 VDD VSS n13099 NAND2X1
XU13569 n13101 n13102 VDD VSS n13100 NAND2X1
XU13570 n13103 n13104 VDD VSS n13102 NOR2X1
XU13571 n13105 n13106 VDD VSS n13104 NAND2X1
XU13572 n13042 g797 VDD VSS n13106 NAND2X1
XU13573 n13107 n13108 VDD VSS n13042 AND2X1
XU13574 g6368 n12469 VDD VSS n13108 NAND2X1
XU13575 g833 VDD VSS n12469 INVX1
XU13576 g6518 n12472 VDD VSS n13107 NAND2X1
XU13577 g834 VDD VSS n12472 INVX1
XU13578 n13109 n13110 VDD VSS n13105 OR2X1
XU13579 n13015 n13111 VDD VSS n13103 NOR2X1
XU13580 n13112 n13113 VDD VSS n13101 NOR2X1
XU13581 n13114 n13115 VDD VSS n13113 NAND2X1
XU13582 n13116 n12820 VDD VSS n13115 OR2X1
XU13583 n13095 n13096 VDD VSS n13114 OR2X1
XU13584 n13117 n13118 VDD VSS n13095 NAND2X1
XU13585 g6368 n12487 VDD VSS n13118 NAND2X1
XU13586 g839 VDD VSS n12487 INVX1
XU13587 g6518 n12490 VDD VSS n13117 NAND2X1
XU13588 g840 VDD VSS n12490 INVX1
XU13589 n13087 n13090 VDD VSS n13112 NOR2X1
XU13590 n13119 n13120 VDD VSS n13090 NAND2X1
XU13591 g6368 n12496 VDD VSS n13120 NAND2X1
XU13592 g842 VDD VSS n12496 INVX1
XU13593 g6518 n12499 VDD VSS n13119 NAND2X1
XU13594 g843 VDD VSS n12499 INVX1
XU13595 g853 n13121 VDD VSS n13098 NAND2X1
XU13596 n13122 n13123 VDD VSS n13121 NAND2X1
XU13597 n13124 n13125 VDD VSS n13123 NOR2X1
XU13598 n13126 n13127 VDD VSS n13125 NAND2X1
XU13599 n12820 n12466 VDD VSS n13127 NAND2X1
XU13600 n12802 n12475 VDD VSS n13126 NAND2X1
XU13601 g832 VDD VSS n12475 INVX1
XU13602 g797 VDD VSS n12802 INVX1
XU13603 g835 g801 VDD VSS n13124 NOR2X1
XU13604 n13128 n13129 VDD VSS n13122 NOR2X1
XU13605 n13130 n13131 VDD VSS n13129 NAND2X1
XU13606 n13096 n12493 VDD VSS n13131 NAND2X1
XU13607 g838 VDD VSS n12493 INVX1
XU13608 g805 VDD VSS n13096 INVX1
XU13609 n13087 n12502 VDD VSS n13130 NAND2X1
XU13610 g841 VDD VSS n12502 INVX1
XU13611 g809 VDD VSS n13087 INVX1
XU13612 g844 g813 VDD VSS n13128 NOR2X1
XU13613 n13132 n13133 VDD VSS n13081 NAND2X1
XU13614 n13134 n13135 VDD VSS n13133 NOR2X1
XU13615 n13015 n13136 VDD VSS n13135 NOR2X1
XU13616 g844 n13137 VDD VSS n13136 NAND2X1
XU13617 g813 n13137 VDD VSS n13134 NOR2X1
XU13618 n13111 VDD VSS n13137 INVX1
XU13619 n13138 n13139 VDD VSS n13111 NAND2X1
XU13620 g6368 n12653 VDD VSS n13139 NAND2X1
XU13621 g845 VDD VSS n12653 INVX1
XU13622 g6518 n12657 VDD VSS n13138 NAND2X1
XU13623 g846 VDD VSS n12657 INVX1
XU13624 n13140 n13141 VDD VSS n13132 NOR2X1
XU13625 n13142 n13143 VDD VSS n13141 NAND2X1
XU13626 n13109 n13110 VDD VSS n13143 NAND2X1
XU13627 n13144 g801 VDD VSS n13142 NAND2X1
XU13628 n13109 n12484 VDD VSS n13144 NOR2X1
XU13629 g835 VDD VSS n12484 INVX1
XU13630 n13145 n13146 VDD VSS n13109 NAND2X1
XU13631 g6368 n12478 VDD VSS n13146 NAND2X1
XU13632 g836 VDD VSS n12478 INVX1
XU13633 g6518 n12481 VDD VSS n13145 NAND2X1
XU13634 g837 VDD VSS n12481 INVX1
XU13635 n13147 n13148 VDD VSS n13140 NAND2X1
XU13636 n13116 n12820 VDD VSS n13148 NAND2X1
XU13637 g793 VDD VSS n12820 INVX1
XU13638 n13149 g793 VDD VSS n13147 NAND2X1
XU13639 n13116 n12466 VDD VSS n13149 NOR2X1
XU13640 g829 VDD VSS n12466 INVX1
XU13641 n13150 n13151 VDD VSS n13116 NAND2X1
XU13642 g6368 n12459 VDD VSS n13151 NAND2X1
XU13643 g830 VDD VSS n12459 INVX1
XU13644 g6518 n12462 VDD VSS n13150 NAND2X1
XU13645 g831 VDD VSS n12462 INVX1
XU13646 n13067 n12654 VDD VSS n12604 NOR2X1
XU13647 n13152 n13153 VDD VSS n13067 NAND2X1
XU13648 g853 n13154 VDD VSS n13153 NAND2X1
XU13649 n13155 n13156 VDD VSS n13152 NOR2X1
XU13650 g858 n12574 VDD VSS n13156 NOR2X1
XU13651 g857 n12575 VDD VSS n13155 NOR2X1
XU13652 n13157 n13158 VDD VSS n7797 NAND2X1
XU13653 n9390 g1471 VDD VSS n13158 NAND2X1
XU13654 n9391 n13159 VDD VSS n13157 NAND2X1
XU13655 n13160 n13161 VDD VSS n7796 NAND2X1
XU13656 n9375 g1471 VDD VSS n13161 NAND2X1
XU13657 n9375 g1513 VDD VSS n13160 OR2X1
XU13658 n13162 n13163 VDD VSS n7795 NAND2X1
XU13659 g1471 n9379 VDD VSS n13163 NAND2X1
XU13660 n9380 n13164 VDD VSS n13162 NAND2X1
XU13661 n13165 n13166 VDD VSS n7794 NAND2X1
XU13662 n9390 g1476 VDD VSS n13166 NAND2X1
XU13663 n9391 n13167 VDD VSS n13165 NAND2X1
XU13664 n13168 n13169 VDD VSS n7793 NAND2X1
XU13665 n9375 g1476 VDD VSS n13169 NAND2X1
XU13666 n9375 g1516 VDD VSS n13168 OR2X1
XU13667 n13170 n13171 VDD VSS n7792 NAND2X1
XU13668 g1476 n9379 VDD VSS n13171 NAND2X1
XU13669 n9380 n13172 VDD VSS n13170 NAND2X1
XU13670 n13173 n13174 VDD VSS n7791 NAND2X1
XU13671 n9390 g1481 VDD VSS n13174 NAND2X1
XU13672 n9391 n13175 VDD VSS n13173 NAND2X1
XU13673 n13176 n13177 VDD VSS n7790 NAND2X1
XU13674 n9375 g1481 VDD VSS n13177 NAND2X1
XU13675 n13178 n13179 VDD VSS n13176 NAND2X1
XU13676 n13180 n13181 VDD VSS n7789 NAND2X1
XU13677 g1481 n9379 VDD VSS n13181 NAND2X1
XU13678 n9380 n13182 VDD VSS n13180 NAND2X1
XU13679 n13183 n13184 VDD VSS n7788 NAND2X1
XU13680 n9390 g1486 VDD VSS n13184 NAND2X1
XU13681 n9391 n13185 VDD VSS n13183 NAND2X1
XU13682 n13186 n13187 VDD VSS n7787 NAND2X1
XU13683 n9375 g1486 VDD VSS n13187 NAND2X1
XU13684 n13178 n13188 VDD VSS n13186 NAND2X1
XU13685 n13189 n13190 VDD VSS n7786 NAND2X1
XU13686 g1486 n9379 VDD VSS n13190 NAND2X1
XU13687 n9380 n13191 VDD VSS n13189 NAND2X1
XU13688 n13192 n13193 VDD VSS n7785 NAND2X1
XU13689 n9390 g1491 VDD VSS n13193 NAND2X1
XU13690 n9391 n13194 VDD VSS n13192 NAND2X1
XU13691 n13195 n13196 VDD VSS n7784 NAND2X1
XU13692 n9375 g1491 VDD VSS n13196 NAND2X1
XU13693 n13178 n13197 VDD VSS n13195 NAND2X1
XU13694 n13198 n13199 VDD VSS n7783 NAND2X1
XU13695 g1491 n9379 VDD VSS n13199 NAND2X1
XU13696 n9380 n13200 VDD VSS n13198 NAND2X1
XU13697 n13201 n13202 VDD VSS n7782 NAND2X1
XU13698 n9390 g1496 VDD VSS n13202 NAND2X1
XU13699 n9391 n13203 VDD VSS n13201 NAND2X1
XU13700 n13204 n13205 VDD VSS n7781 NAND2X1
XU13701 n9375 g1496 VDD VSS n13205 NAND2X1
XU13702 n13178 n13206 VDD VSS n13204 NAND2X1
XU13703 n13207 n13208 VDD VSS n7780 NAND2X1
XU13704 g1496 n9379 VDD VSS n13208 NAND2X1
XU13705 n9380 n13209 VDD VSS n13207 NAND2X1
XU13706 n13210 n13211 VDD VSS n7779 NAND2X1
XU13707 n9390 g1501 VDD VSS n13211 NAND2X1
XU13708 n9391 n13212 VDD VSS n13210 NAND2X1
XU13709 n13213 n13214 VDD VSS n7778 NAND2X1
XU13710 n9375 g1501 VDD VSS n13214 NAND2X1
XU13711 n13178 n13215 VDD VSS n13213 NAND2X1
XU13712 n13216 n13217 VDD VSS n7777 NAND2X1
XU13713 g1501 n9379 VDD VSS n13217 NAND2X1
XU13714 n9380 n13218 VDD VSS n13216 NAND2X1
XU13715 n9379 VDD VSS n9380 INVX1
XU13716 n13219 n13220 VDD VSS n7776 NAND2X1
XU13717 n13221 n13222 VDD VSS n13220 NAND2X1
XU13718 n13223 g5511 VDD VSS n13219 NAND2X1
XU13719 n13224 n13225 VDD VSS n7775 NAND2X1
XU13720 g1813 g7014 VDD VSS n13225 OR2X1
XU13721 n13223 g7014 VDD VSS n13224 NAND2X1
XU13722 n13226 n13227 VDD VSS n7774 NAND2X1
XU13723 n13228 n13229 VDD VSS n13227 NAND2X1
XU13724 n13223 g1782 VDD VSS n13226 NAND2X1
XU13725 n13230 n13231 VDD VSS n13223 NAND2X1
XU13726 n13232 n13233 VDD VSS n13231 NAND2X1
XU13727 g1690 n13234 VDD VSS n13230 NAND2X1
XU13728 n13235 n13236 VDD VSS n7773 NAND2X1
XU13729 n13237 n13222 VDD VSS n13236 NAND2X1
XU13730 n13238 g5511 VDD VSS n13235 NAND2X1
XU13731 n13239 n13240 VDD VSS n7772 NAND2X1
XU13732 n13241 n10163 VDD VSS n13240 NAND2X1
XU13733 n13238 g7014 VDD VSS n13239 NAND2X1
XU13734 n13242 n13243 VDD VSS n7771 NAND2X1
XU13735 g1782 g1825 VDD VSS n13243 OR2X1
XU13736 n13238 g1782 VDD VSS n13242 NAND2X1
XU13737 n13244 n13245 VDD VSS n13238 XOR2X1
XU13738 n13246 g1690 VDD VSS n13244 NAND2X1
XU13739 n13247 n13248 VDD VSS n13246 NOR2X1
XU13740 n13249 n13250 VDD VSS n7770 NAND2X1
XU13741 n13251 n13252 VDD VSS n13250 NAND2X1
XU13742 g1828 VDD VSS n13252 INVX1
XU13743 n13253 g1782 VDD VSS n13251 NAND2X1
XU13744 n13254 g1782 VDD VSS n13249 NAND2X1
XU13745 n13255 n13256 VDD VSS n7769 NAND2X1
XU13746 n13257 n13258 VDD VSS n13256 NAND2X1
XU13747 n13253 g7014 VDD VSS n13257 NAND2X1
XU13748 n13254 g7014 VDD VSS n13255 NAND2X1
XU13749 n13259 n13260 VDD VSS n7768 NAND2X1
XU13750 n13261 n13262 VDD VSS n13260 NAND2X1
XU13751 g1829 VDD VSS n13262 INVX1
XU13752 n13253 g5511 VDD VSS n13261 NAND2X1
XU13753 n13263 g1690 VDD VSS n13253 AND2X1
XU13754 n13264 n13265 VDD VSS n13263 NOR2X1
XU13755 n13266 n13267 VDD VSS n13265 NOR2X1
XU13756 n13245 n13234 VDD VSS n13266 NOR2X1
XU13757 n13232 n13268 VDD VSS n13264 NOR2X1
XU13758 n9368 n13269 VDD VSS n13268 NOR2X1
XU13759 n13254 g5511 VDD VSS n13259 NAND2X1
XU13760 n13270 n13247 VDD VSS n13254 AND2X1
XU13761 n13271 n13272 VDD VSS n13247 AND2X1
XU13762 g7014 n13258 VDD VSS n13272 NAND2X1
XU13763 g1830 VDD VSS n13258 INVX1
XU13764 n13273 n13274 VDD VSS n13271 NOR2X1
XU13765 g1829 n13222 VDD VSS n13274 NOR2X1
XU13766 g1828 n13228 VDD VSS n13273 NOR2X1
XU13767 n13248 n13233 VDD VSS n13270 NOR2X1
XU13768 n13275 n13276 VDD VSS n13248 AND2X1
XU13769 n13277 n13245 VDD VSS n13276 NAND2X1
XU13770 n13269 n13267 VDD VSS n13277 NOR2X1
XU13771 n13234 VDD VSS n13269 INVX1
XU13772 n13278 n9368 VDD VSS n13275 NAND2X1
XU13773 n13245 VDD VSS n9368 INVX1
XU13774 n13279 n13280 VDD VSS n13245 NAND2X1
XU13775 g1825 g1782 VDD VSS n13280 NAND2X1
XU13776 n13281 n13282 VDD VSS n13279 NOR2X1
XU13777 n10163 n13241 VDD VSS n13282 NOR2X1
XU13778 g1822 VDD VSS n13241 INVX1
XU13779 n13222 n13237 VDD VSS n13281 NOR2X1
XU13780 g1819 VDD VSS n13237 INVX1
XU13781 n13232 n13234 VDD VSS n13278 NOR2X1
XU13782 n13283 n13284 VDD VSS n13234 NAND2X1
XU13783 n13285 n13286 VDD VSS n13284 NAND2X1
XU13784 g6782 n13287 VDD VSS n13286 NAND2X1
XU13785 n13288 n13289 VDD VSS n13285 NOR2X1
XU13786 g1560 n13290 VDD VSS n13289 NOR2X1
XU13787 g1559 n13291 VDD VSS n13288 NOR2X1
XU13788 n13267 VDD VSS n13232 INVX1
XU13789 n13292 n13293 VDD VSS n13267 NAND2X1
XU13790 g1813 g7014 VDD VSS n13293 NAND2X1
XU13791 n13294 n13295 VDD VSS n13292 NOR2X1
XU13792 n13222 n13221 VDD VSS n13295 NOR2X1
XU13793 g1810 VDD VSS n13221 INVX1
XU13794 n13228 n13229 VDD VSS n13294 NOR2X1
XU13795 g1816 VDD VSS n13229 INVX1
XU13796 n13296 n13297 VDD VSS n7767 NAND2X1
XU13797 n13298 n13222 VDD VSS n13297 NAND2X1
XU13798 n13299 g5511 VDD VSS n13296 NAND2X1
XU13799 n13300 n13301 VDD VSS n7766 NAND2X1
XU13800 g1801 g7014 VDD VSS n13301 OR2X1
XU13801 n13299 g7014 VDD VSS n13300 NAND2X1
XU13802 n13302 n13303 VDD VSS n7765 NAND2X1
XU13803 n13228 n13304 VDD VSS n13303 NAND2X1
XU13804 n13299 g1782 VDD VSS n13302 NAND2X1
XU13805 n9361 n13305 VDD VSS n13299 XOR2X1
XU13806 n13306 n13307 VDD VSS n13305 NOR2X1
XU13807 n13308 n13309 VDD VSS n13307 NOR2X1
XU13808 g1690 n13310 VDD VSS n13309 NAND2X1
XU13809 n13311 n13312 VDD VSS n13308 NAND2X1
XU13810 n263 n13313 VDD VSS n13312 NAND2X1
XU13811 n13314 n13315 VDD VSS n13313 NAND2X1
XU13812 n13316 n9361 VDD VSS n13311 NAND2X1
XU13813 n13315 n13317 VDD VSS n13316 NAND2X1
XU13814 n13318 n13319 VDD VSS n13306 NOR2X1
XU13815 n263 n13314 VDD VSS n13319 NAND2X1
XU13816 n13317 VDD VSS n13314 INVX1
XU13817 n13320 g1690 VDD VSS n13318 NAND2X1
XU13818 n13321 n13322 VDD VSS n7764 NAND2X1
XU13819 n13323 n13324 VDD VSS n13322 NAND2X1
XU13820 g1808 VDD VSS n13324 INVX1
XU13821 n13325 g5511 VDD VSS n13323 NAND2X1
XU13822 n13326 g5511 VDD VSS n13321 NAND2X1
XU13823 n13327 n13328 VDD VSS n7763 NAND2X1
XU13824 n13329 n13330 VDD VSS n13328 NAND2X1
XU13825 n13325 g7014 VDD VSS n13329 NAND2X1
XU13826 n13326 g7014 VDD VSS n13327 NAND2X1
XU13827 n13331 n13332 VDD VSS n7762 NAND2X1
XU13828 n13333 n13334 VDD VSS n13332 NAND2X1
XU13829 g1807 VDD VSS n13334 INVX1
XU13830 n13325 g1782 VDD VSS n13333 NAND2X1
XU13831 n13326 g1782 VDD VSS n13331 NAND2X1
XU13832 n13335 n13336 VDD VSS n13326 AND2X1
XU13833 n13337 n13338 VDD VSS n13336 NOR2X1
XU13834 n13233 n13315 VDD VSS n13335 NOR2X1
XU13835 n13339 n13340 VDD VSS n7761 NAND2X1
XU13836 n13341 n13222 VDD VSS n13340 NAND2X1
XU13837 n13342 g5511 VDD VSS n13339 NAND2X1
XU13838 n13343 n13344 VDD VSS n7760 NAND2X1
XU13839 g1792 g7014 VDD VSS n13344 OR2X1
XU13840 n13342 g7014 VDD VSS n13343 NAND2X1
XU13841 n13345 n13346 VDD VSS n7759 NAND2X1
XU13842 n13228 n13347 VDD VSS n13346 NAND2X1
XU13843 n13342 g1782 VDD VSS n13345 NAND2X1
XU13844 n13310 n13348 VDD VSS n13342 XOR2X1
XU13845 n13325 n13349 VDD VSS n13348 NOR2X1
XU13846 n13233 n13350 VDD VSS n13349 NOR2X1
XU13847 n13351 n13310 VDD VSS n13350 NAND2X1
XU13848 n13315 n13338 VDD VSS n13351 OR2X1
XU13849 n13352 n13353 VDD VSS n13315 NAND2X1
XU13850 g7014 n13330 VDD VSS n13353 NAND2X1
XU13851 g1809 VDD VSS n13330 INVX1
XU13852 n13354 n13355 VDD VSS n13352 NOR2X1
XU13853 g1808 n13222 VDD VSS n13355 NOR2X1
XU13854 g1807 n13228 VDD VSS n13354 NOR2X1
XU13855 n13356 n13337 VDD VSS n13325 AND2X1
XU13856 n13310 VDD VSS n13337 INVX1
XU13857 n13338 n13233 VDD VSS n13356 NOR2X1
XU13858 n13357 n13358 VDD VSS n13338 AND2X1
XU13859 n13317 n9361 VDD VSS n13358 NAND2X1
XU13860 n13359 n263 VDD VSS n13357 NAND2X1
XU13861 n13320 n13317 VDD VSS n13359 NOR2X1
XU13862 n13360 n13283 VDD VSS n13317 NAND2X1
XU13863 n13361 n13362 VDD VSS n13360 NOR2X1
XU13864 n13363 n13364 VDD VSS n13310 NAND2X1
XU13865 g1792 g7014 VDD VSS n13364 NAND2X1
XU13866 n13365 n13366 VDD VSS n13363 NOR2X1
XU13867 n13222 n13341 VDD VSS n13366 NOR2X1
XU13868 g1789 VDD VSS n13341 INVX1
XU13869 n13228 n13347 VDD VSS n13365 NOR2X1
XU13870 g1795 VDD VSS n13347 INVX1
XU13871 n13367 n13368 VDD VSS n7758 NAND2X1
XU13872 n9390 g1506 VDD VSS n13368 NAND2X1
XU13873 n9391 n13369 VDD VSS n13367 NAND2X1
XU13874 n9390 VDD VSS n9391 INVX1
XU13875 n13290 n13370 VDD VSS n9390 NOR2X1
XU13876 n13371 n13372 VDD VSS n7757 NAND2X1
XU13877 n9375 g1506 VDD VSS n13372 NAND2X1
XU13878 n13178 n13373 VDD VSS n13371 NAND2X1
XU13879 n9375 VDD VSS n13178 INVX1
XU13880 n13374 n13370 VDD VSS n9375 NOR2X1
XU13881 n13375 n13376 VDD VSS n7756 NAND2X1
XU13882 g1506 n9379 VDD VSS n13376 NAND2X1
XU13883 n9379 g1538 VDD VSS n13375 OR2X1
XU13884 n13377 n13378 VDD VSS n7755 NAND2X1
XU13885 n13379 n13380 VDD VSS n13378 NAND2X1
XU13886 g1784 VDD VSS n13380 INVX1
XU13887 g1690 g5511 VDD VSS n13379 NAND2X1
XU13888 n13381 g5511 VDD VSS n13377 NAND2X1
XU13889 n13382 n13383 VDD VSS n7754 NAND2X1
XU13890 n13384 n13385 VDD VSS n13383 NAND2X1
XU13891 g1785 VDD VSS n13385 INVX1
XU13892 g1690 g7014 VDD VSS n13384 NAND2X1
XU13893 n13381 g7014 VDD VSS n13382 NAND2X1
XU13894 n13386 n13387 VDD VSS n7753 NAND2X1
XU13895 n13388 n13389 VDD VSS n13387 NAND2X1
XU13896 g1690 g1782 VDD VSS n13388 NAND2X1
XU13897 n13381 g1782 VDD VSS n13386 NAND2X1
XU13898 n13390 n13391 VDD VSS n13381 NOR2X1
XU13899 g1690 n13392 VDD VSS n13390 NAND2X1
XU13900 n13393 n13394 VDD VSS n7752 NAND2X1
XU13901 g1693 g5511 VDD VSS n13394 OR2X1
XU13902 g5511 n13395 VDD VSS n13393 NAND2X1
XU13903 n13396 n13397 VDD VSS n7751 NAND2X1
XU13904 g1694 g7014 VDD VSS n13397 OR2X1
XU13905 g7014 n13395 VDD VSS n13396 NAND2X1
XU13906 n13398 n13399 VDD VSS n7750 NAND2X1
XU13907 n13400 n13228 VDD VSS n13399 NAND2X1
XU13908 g1782 n13395 VDD VSS n13398 NAND2X1
XU13909 n13401 n13402 VDD VSS n13395 NAND2X1
XU13910 n13403 n13404 VDD VSS n13402 NAND2X1
XU13911 n13405 n13406 VDD VSS n13403 NAND2X1
XU13912 n13407 n13408 VDD VSS n13405 NOR2X1
XU13913 n13409 n13410 VDD VSS n7749 NAND2X1
XU13914 n13411 n13290 VDD VSS n13410 NAND2X1
XU13915 n13412 g6573 VDD VSS n13409 NAND2X1
XU13916 n13413 n13414 VDD VSS n7748 NAND2X1
XU13917 g1597 g6782 VDD VSS n13414 OR2X1
XU13918 n13412 g6782 VDD VSS n13413 NAND2X1
XU13919 n13415 n13416 VDD VSS n7747 NAND2X1
XU13920 n13291 n13417 VDD VSS n13416 NAND2X1
XU13921 n13412 g1547 VDD VSS n13415 NAND2X1
XU13922 n13418 n13419 VDD VSS n13412 AND2X1
XU13923 n13420 n13421 VDD VSS n13419 NAND2X1
XU13924 n13422 n13423 VDD VSS n13420 XOR2X1
XU13925 n13424 g1501 VDD VSS n13418 NAND2X1
XU13926 n13425 n13426 VDD VSS n7746 NAND2X1
XU13927 n13427 n13290 VDD VSS n13426 NAND2X1
XU13928 g6573 n13428 VDD VSS n13425 NAND2X1
XU13929 n13429 n13430 VDD VSS n7745 NAND2X1
XU13930 g1633 g6782 VDD VSS n13430 OR2X1
XU13931 g6782 n13428 VDD VSS n13429 NAND2X1
XU13932 n13431 n13432 VDD VSS n7744 NAND2X1
XU13933 n13291 n13433 VDD VSS n13432 NAND2X1
XU13934 g1547 n13428 VDD VSS n13431 NAND2X1
XU13935 n13434 n13435 VDD VSS n13428 NAND2X1
XU13936 n13436 n13437 VDD VSS n13434 NOR2X1
XU13937 n13438 n13439 VDD VSS n13437 NOR2X1
XU13938 n13440 n13441 VDD VSS n13439 XOR2X1
XU13939 g1496 n13421 VDD VSS n13436 NOR2X1
XU13940 n13442 n13443 VDD VSS n7743 NAND2X1
XU13941 n13444 n13290 VDD VSS n13443 NAND2X1
XU13942 n13445 g6573 VDD VSS n13442 NAND2X1
XU13943 n13446 n13447 VDD VSS n7742 NAND2X1
XU13944 g1588 g6782 VDD VSS n13447 OR2X1
XU13945 n13445 g6782 VDD VSS n13446 NAND2X1
XU13946 n13448 n13449 VDD VSS n7741 NAND2X1
XU13947 n13291 n13450 VDD VSS n13449 NAND2X1
XU13948 n13445 g1547 VDD VSS n13448 NAND2X1
XU13949 n13451 n13452 VDD VSS n13445 AND2X1
XU13950 n13453 n13421 VDD VSS n13452 NAND2X1
XU13951 n13454 n13455 VDD VSS n13453 XOR2X1
XU13952 n13424 g1491 VDD VSS n13451 NAND2X1
XU13953 n13456 n13457 VDD VSS n7740 NAND2X1
XU13954 g1570 g6782 VDD VSS n13457 OR2X1
XU13955 n13458 g6782 VDD VSS n13456 NAND2X1
XU13956 n13459 n13460 VDD VSS n7739 NAND2X1
XU13957 n13291 n13461 VDD VSS n13460 NAND2X1
XU13958 n13458 g1547 VDD VSS n13459 NAND2X1
XU13959 n13462 n13463 VDD VSS n7738 NAND2X1
XU13960 n13464 n13290 VDD VSS n13463 NAND2X1
XU13961 n13458 g6573 VDD VSS n13462 NAND2X1
XU13962 n13465 n13466 VDD VSS n13458 AND2X1
XU13963 n13421 n13467 VDD VSS n13466 NAND2X1
XU13964 n13468 n13469 VDD VSS n13467 XOR2X1
XU13965 n13424 g1471 VDD VSS n13465 NAND2X1
XU13966 n13470 n13471 VDD VSS n7737 NAND2X1
XU13967 g1651 g6782 VDD VSS n13471 OR2X1
XU13968 g6782 n13472 VDD VSS n13470 NAND2X1
XU13969 n13473 n13474 VDD VSS n7736 NAND2X1
XU13970 n13291 n13475 VDD VSS n13474 NAND2X1
XU13971 g1547 n13472 VDD VSS n13473 NAND2X1
XU13972 n13476 n13477 VDD VSS n7735 NAND2X1
XU13973 n13478 n13290 VDD VSS n13477 NAND2X1
XU13974 g6573 n13472 VDD VSS n13476 NAND2X1
XU13975 n13479 n13480 VDD VSS n13472 NAND2X1
XU13976 n13424 n13361 VDD VSS n13480 NAND2X1
XU13977 n13481 n13482 VDD VSS n13479 NOR2X1
XU13978 n13483 n13438 VDD VSS n13482 NOR2X1
XU13979 n13484 n13485 VDD VSS n13483 XOR2X1
XU13980 n13486 n13487 VDD VSS n13485 NOR2X1
XU13981 n13488 n13489 VDD VSS n13486 XOR2X1
XU13982 n13490 n13491 VDD VSS n7734 NAND2X1
XU13983 n13492 n13290 VDD VSS n13491 NAND2X1
XU13984 n13493 g6573 VDD VSS n13490 NAND2X1
XU13985 n13494 n13495 VDD VSS n7733 NAND2X1
XU13986 g1606 g6782 VDD VSS n13495 OR2X1
XU13987 n13493 g6782 VDD VSS n13494 NAND2X1
XU13988 n13496 n13497 VDD VSS n7732 NAND2X1
XU13989 n13291 n13498 VDD VSS n13497 NAND2X1
XU13990 n13493 g1547 VDD VSS n13496 NAND2X1
XU13991 n13499 n13500 VDD VSS n13493 AND2X1
XU13992 n13501 n13502 VDD VSS n13499 NOR2X1
XU13993 n13362 n13503 VDD VSS n13502 NOR2X1
XU13994 n13438 n13504 VDD VSS n13501 NOR2X1
XU13995 n13488 n13487 VDD VSS n13504 XOR2X1
XU13996 n13505 n13506 VDD VSS n13487 AND2X1
XU13997 n13507 n13508 VDD VSS n13506 OR2X1
XU13998 n13509 n13510 VDD VSS n13505 OR2X1
XU13999 n13511 n13512 VDD VSS n7731 NAND2X1
XU14000 n13513 n13290 VDD VSS n13512 NAND2X1
XU14001 g6573 n13514 VDD VSS n13511 NAND2X1
XU14002 n13515 n13516 VDD VSS n7730 NAND2X1
XU14003 g1624 g6782 VDD VSS n13516 OR2X1
XU14004 g6782 n13514 VDD VSS n13515 NAND2X1
XU14005 n13517 n13518 VDD VSS n7729 NAND2X1
XU14006 n13291 n13519 VDD VSS n13518 NAND2X1
XU14007 g1547 n13514 VDD VSS n13517 NAND2X1
XU14008 n13520 n13521 VDD VSS n13514 NAND2X1
XU14009 n13424 n13522 VDD VSS n13521 NAND2X1
XU14010 n13481 n13523 VDD VSS n13520 NOR2X1
XU14011 n13438 n13524 VDD VSS n13523 NOR2X1
XU14012 n13525 n13526 VDD VSS n13524 XOR2X1
XU14013 n13527 n13528 VDD VSS n13526 NOR2X1
XU14014 n13529 n13530 VDD VSS n7728 NAND2X1
XU14015 n13531 n13290 VDD VSS n13530 NAND2X1
XU14016 n13532 g6573 VDD VSS n13529 NAND2X1
XU14017 n13533 n13534 VDD VSS n7727 NAND2X1
XU14018 g1579 g6782 VDD VSS n13534 OR2X1
XU14019 n13532 g6782 VDD VSS n13533 NAND2X1
XU14020 n13535 n13536 VDD VSS n7726 NAND2X1
XU14021 n13291 n13537 VDD VSS n13536 NAND2X1
XU14022 n13532 g1547 VDD VSS n13535 NAND2X1
XU14023 n13538 n13500 VDD VSS n13532 AND2X1
XU14024 n13539 n13404 VDD VSS n13500 NAND2X1
XU14025 n13540 n13541 VDD VSS n13538 NOR2X1
XU14026 n13542 n13503 VDD VSS n13541 NOR2X1
XU14027 n13438 n13543 VDD VSS n13540 NOR2X1
XU14028 n13544 n13545 VDD VSS n13543 XOR2X1
XU14029 n13546 n13547 VDD VSS n7725 NAND2X1
XU14030 n13548 n13290 VDD VSS n13547 NAND2X1
XU14031 g6573 n13549 VDD VSS n13546 NAND2X1
XU14032 n13550 n13551 VDD VSS n7724 NAND2X1
XU14033 g1615 g6782 VDD VSS n13551 OR2X1
XU14034 g6782 n13549 VDD VSS n13550 NAND2X1
XU14035 n13552 n13553 VDD VSS n7723 NAND2X1
XU14036 n13291 n13554 VDD VSS n13553 NAND2X1
XU14037 g1547 n13549 VDD VSS n13552 NAND2X1
XU14038 n13555 n13556 VDD VSS n13549 NAND2X1
XU14039 n13424 n13557 VDD VSS n13556 NAND2X1
XU14040 n13503 VDD VSS n13424 INVX1
XU14041 n13435 n13438 VDD VSS n13503 NAND2X1
XU14042 n13481 n13558 VDD VSS n13555 NOR2X1
XU14043 n13559 n13438 VDD VSS n13558 NOR2X1
XU14044 n13560 n13561 VDD VSS n13559 XOR2X1
XU14045 n13469 n13562 VDD VSS n13561 NOR2X1
XU14046 n13563 n13489 VDD VSS n13562 XOR2X1
XU14047 n13435 n13404 VDD VSS n13481 NOR2X1
XU14048 n13564 n13565 VDD VSS n7722 NAND2X1
XU14049 n13566 n13567 VDD VSS n13565 NAND2X1
XU14050 g7014 n13568 VDD VSS n13566 NAND2X1
XU14051 n13569 g7014 VDD VSS n13564 NAND2X1
XU14052 n13570 n13571 VDD VSS n7721 NAND2X1
XU14053 n13572 n13573 VDD VSS n13571 NAND2X1
XU14054 g1703 VDD VSS n13573 INVX1
XU14055 g5511 n13568 VDD VSS n13572 NAND2X1
XU14056 n13569 g5511 VDD VSS n13570 NAND2X1
XU14057 n13574 n13575 VDD VSS n7720 NAND2X1
XU14058 n13576 n13577 VDD VSS n13575 NAND2X1
XU14059 g1702 VDD VSS n13577 INVX1
XU14060 g1782 n13568 VDD VSS n13576 NAND2X1
XU14061 n13569 g1782 VDD VSS n13574 NAND2X1
XU14062 n13568 n13578 VDD VSS n13569 AND2X1
XU14063 n13579 n13580 VDD VSS n13578 NAND2X1
XU14064 n13581 n13582 VDD VSS n13580 NAND2X1
XU14065 n13407 n13583 VDD VSS n13581 NOR2X1
XU14066 n13408 n13392 VDD VSS n13579 NAND2X1
XU14067 n13584 n13585 VDD VSS n13568 NAND2X1
XU14068 n13586 n9354 VDD VSS n13585 NAND2X1
XU14069 n13587 n13588 VDD VSS n13586 NOR2X1
XU14070 n13408 g1690 VDD VSS n13584 NAND2X1
XU14071 n9354 VDD VSS n13408 INVX1
XU14072 n13589 n13590 VDD VSS n7719 NAND2X1
XU14073 g1699 g5511 VDD VSS n13590 OR2X1
XU14074 g5511 n13591 VDD VSS n13589 NAND2X1
XU14075 n13592 n13593 VDD VSS n7718 NAND2X1
XU14076 g1700 g7014 VDD VSS n13593 OR2X1
XU14077 g7014 n13591 VDD VSS n13592 NAND2X1
XU14078 n13594 n13595 VDD VSS n7717 NAND2X1
XU14079 n13596 n13228 VDD VSS n13595 NAND2X1
XU14080 g1782 n13591 VDD VSS n13594 NAND2X1
XU14081 n13597 n13401 VDD VSS n13591 NAND2X1
XU14082 n13598 n13599 VDD VSS n13597 XOR2X1
XU14083 n13600 n13601 VDD VSS n13598 NAND2X1
XU14084 n13599 n13602 VDD VSS n13601 NAND2X1
XU14085 n13603 n13604 VDD VSS n13602 NAND2X1
XU14086 n13605 n13606 VDD VSS n13604 NAND2X1
XU14087 n13607 n13608 VDD VSS n13605 NAND2X1
XU14088 n13609 n13583 VDD VSS n13600 NAND2X1
XU14089 n13610 n13611 VDD VSS n13609 NOR2X1
XU14090 n13612 n13613 VDD VSS n13611 NAND2X1
XU14091 n13603 n13606 VDD VSS n13610 NAND2X1
XU14092 n13614 n13615 VDD VSS n13606 NAND2X1
XU14093 n13616 n13617 VDD VSS n13615 NAND2X1
XU14094 n13618 VDD VSS n13617 INVX1
XU14095 n13619 n13233 VDD VSS n13616 NOR2X1
XU14096 g1690 VDD VSS n13233 INVX1
XU14097 n13620 n13588 VDD VSS n13619 NOR2X1
XU14098 n13621 n13622 VDD VSS n7716 NAND2X1
XU14099 g1696 g5511 VDD VSS n13622 OR2X1
XU14100 g5511 n13623 VDD VSS n13621 NAND2X1
XU14101 n13624 n13625 VDD VSS n7715 NAND2X1
XU14102 g1697 g7014 VDD VSS n13625 OR2X1
XU14103 g7014 n13623 VDD VSS n13624 NAND2X1
XU14104 n13626 n13627 VDD VSS n7714 NAND2X1
XU14105 n13628 n13228 VDD VSS n13627 NAND2X1
XU14106 g1782 n13623 VDD VSS n13626 NAND2X1
XU14107 n13629 n13401 VDD VSS n13623 NAND2X1
XU14108 n13608 n13630 VDD VSS n13629 XOR2X1
XU14109 n13631 n13632 VDD VSS n13630 NAND2X1
XU14110 n13407 n13633 VDD VSS n13632 NAND2X1
XU14111 n13614 n13599 VDD VSS n13633 NAND2X1
XU14112 n13634 n13603 VDD VSS n13631 NAND2X1
XU14113 n13635 n13636 VDD VSS n13634 NAND2X1
XU14114 n13637 n13608 VDD VSS n13636 NAND2X1
XU14115 n13612 n13638 VDD VSS n13637 NAND2X1
XU14116 n13620 n13639 VDD VSS n13638 NAND2X1
XU14117 n13640 n13641 VDD VSS n13639 NAND2X1
XU14118 n13587 n13583 VDD VSS n13640 NOR2X1
XU14119 n13613 VDD VSS n13587 INVX1
XU14120 n13614 n13642 VDD VSS n13635 NAND2X1
XU14121 n13643 n13644 VDD VSS n13642 NAND2X1
XU14122 n13645 n13607 VDD VSS n13644 NAND2X1
XU14123 n13320 n13646 VDD VSS n13607 NOR2X1
XU14124 n13613 n13588 VDD VSS n13646 NOR2X1
XU14125 n13647 n13648 VDD VSS n13613 NAND2X1
XU14126 n13649 n13650 VDD VSS n13648 NOR2X1
XU14127 n13651 n13652 VDD VSS n13650 NAND2X1
XU14128 n13653 n13654 VDD VSS n13649 NAND2X1
XU14129 n13655 n13656 VDD VSS n13647 NOR2X1
XU14130 n13657 n13658 VDD VSS n13656 NAND2X1
XU14131 n13659 n13660 VDD VSS n13655 NAND2X1
XU14132 n13661 n13662 VDD VSS n13659 AND2X1
XU14133 n13663 n13618 VDD VSS n13645 NOR2X1
XU14134 n13599 n13664 VDD VSS n13618 NAND2X1
XU14135 n13612 n13665 VDD VSS n13664 NAND2X1
XU14136 n13666 n13582 VDD VSS n13663 AND2X1
XU14137 n13667 n13668 VDD VSS n13643 NAND2X1
XU14138 n13599 n13320 VDD VSS n13667 NOR2X1
XU14139 n13669 n13670 VDD VSS n7713 NAND2X1
XU14140 n13291 n13671 VDD VSS n13670 NAND2X1
XU14141 g1547 n13672 VDD VSS n13669 NAND2X1
XU14142 n13673 n13674 VDD VSS n7712 NAND2X1
XU14143 n13675 n13290 VDD VSS n13674 NAND2X1
XU14144 g6573 n13672 VDD VSS n13673 NAND2X1
XU14145 n13676 n13677 VDD VSS n7711 NAND2X1
XU14146 g1642 g6782 VDD VSS n13677 OR2X1
XU14147 g6782 n13672 VDD VSS n13676 NAND2X1
XU14148 n13678 n13435 VDD VSS n13672 NAND2X1
XU14149 n13539 VDD VSS n13435 INVX1
XU14150 n13679 n13680 VDD VSS n13539 NOR2X1
XU14151 n13681 n13682 VDD VSS n13678 NOR2X1
XU14152 n13438 n13683 VDD VSS n13682 NOR2X1
XU14153 n13510 n13684 VDD VSS n13683 XOR2X1
XU14154 n13507 n13509 VDD VSS n13684 NAND2X1
XU14155 n13685 n13423 VDD VSS n13509 NAND2X1
XU14156 n13489 n13422 VDD VSS n13685 NOR2X1
XU14157 n13686 n13423 VDD VSS n13507 NAND2X1
XU14158 n13441 n13687 VDD VSS n13423 AND2X1
XU14159 n13404 n13440 VDD VSS n13687 XOR2X1
XU14160 n13455 n13688 VDD VSS n13441 AND2X1
XU14161 n13489 n13689 VDD VSS n13688 XOR2X1
XU14162 n13690 n13691 VDD VSS n13455 NAND2X1
XU14163 n13528 n13692 VDD VSS n13691 NAND2X1
XU14164 n13693 n13545 VDD VSS n13528 AND2X1
XU14165 n13544 n13404 VDD VSS n13693 NOR2X1
XU14166 n13527 n13525 VDD VSS n13690 NAND2X1
XU14167 n13694 n13545 VDD VSS n13527 AND2X1
XU14168 n13695 n13696 VDD VSS n13545 AND2X1
XU14169 n13697 n13698 VDD VSS n13696 NOR2X1
XU14170 n13699 n13563 VDD VSS n13698 NOR2X1
XU14171 n13560 n13404 VDD VSS n13697 NOR2X1
XU14172 n13469 n13700 VDD VSS n13695 NOR2X1
XU14173 n13489 n13468 VDD VSS n13700 NOR2X1
XU14174 n13489 n13701 VDD VSS n13694 NOR2X1
XU14175 n13702 n13404 VDD VSS n13686 NOR2X1
XU14176 g1506 n13421 VDD VSS n13681 NOR2X1
XU14177 n13438 VDD VSS n13421 INVX1
XU14178 n13703 n13704 VDD VSS n13438 NAND2X1
XU14179 n13705 n13680 VDD VSS n13704 NOR2X1
XU14180 n13401 VDD VSS n13680 INVX1
XU14181 n13392 n13391 VDD VSS n13401 NAND2X1
XU14182 n13706 n13707 VDD VSS n13391 NAND2X1
XU14183 g1782 n13389 VDD VSS n13707 NAND2X1
XU14184 g1783 VDD VSS n13389 INVX1
XU14185 n13708 n13709 VDD VSS n13706 NOR2X1
XU14186 g1785 n10163 VDD VSS n13709 NOR2X1
XU14187 g1784 n13222 VDD VSS n13708 NOR2X1
XU14188 n9354 n13668 VDD VSS n13705 NOR2X1
XU14189 n13392 n13666 VDD VSS n13668 NAND2X1
XU14190 n13710 VDD VSS n13392 INVX1
XU14191 n13711 n13614 VDD VSS n9354 NAND2X1
XU14192 n13599 n13407 VDD VSS n13711 NOR2X1
XU14193 n13712 n13713 VDD VSS n13703 NOR2X1
XU14194 n13714 n13679 VDD VSS n13713 NOR2X1
XU14195 n13469 n13715 VDD VSS n13679 OR2X1
XU14196 n13716 n13717 VDD VSS n13715 AND2X1
XU14197 n9338 n13404 VDD VSS n13469 AND2X1
XU14198 n13716 n13489 VDD VSS n13714 AND2X1
XU14199 n13404 VDD VSS n13489 INVX1
XU14200 n13718 n13719 VDD VSS n13716 NAND2X1
XU14201 n13720 n13721 VDD VSS n13719 NOR2X1
XU14202 n13692 n13484 VDD VSS n13721 NAND2X1
XU14203 n13701 n13488 VDD VSS n13720 NAND2X1
XU14204 n13404 n13722 VDD VSS n13718 NOR2X1
XU14205 n13723 n13699 VDD VSS n13722 OR2X1
XU14206 n13724 n13599 VDD VSS n13404 NAND2X1
XU14207 n13614 n13603 VDD VSS n13724 NOR2X1
XU14208 n13725 n13407 VDD VSS n13712 NOR2X1
XU14209 n13320 n13726 VDD VSS n13725 NOR2X1
XU14210 n13727 n13728 VDD VSS n13726 NOR2X1
XU14211 n13614 n13666 VDD VSS n13728 NAND2X1
XU14212 n13729 n13730 VDD VSS n13666 NAND2X1
XU14213 g7014 n13567 VDD VSS n13730 NAND2X1
XU14214 g1704 VDD VSS n13567 INVX1
XU14215 n13731 n13732 VDD VSS n13729 NOR2X1
XU14216 g1703 n13222 VDD VSS n13732 NOR2X1
XU14217 g1702 n13228 VDD VSS n13731 NOR2X1
XU14218 n13582 VDD VSS n13727 INVX1
XU14219 n13710 n13406 VDD VSS n13582 NOR2X1
XU14220 n13612 n13733 VDD VSS n13406 AND2X1
XU14221 n13620 n13641 VDD VSS n13733 NAND2X1
XU14222 n13665 VDD VSS n13641 INVX1
XU14223 n13734 n13735 VDD VSS n13665 NAND2X1
XU14224 n13736 n13737 VDD VSS n13735 NAND2X1
XU14225 n13738 n13739 VDD VSS n13736 NOR2X1
XU14226 n13662 n13658 VDD VSS n13739 AND2X1
XU14227 n13651 n13661 VDD VSS n13738 AND2X1
XU14228 n13740 n13741 VDD VSS n13734 NOR2X1
XU14229 n13658 n13742 VDD VSS n13741 NOR2X1
XU14230 n13743 n13744 VDD VSS n13742 NAND2X1
XU14231 n13662 n13651 VDD VSS n13744 NAND2X1
XU14232 n13660 n13661 VDD VSS n13743 NAND2X1
XU14233 n13651 n13745 VDD VSS n13740 NOR2X1
XU14234 n13746 n13747 VDD VSS n13745 NAND2X1
XU14235 n13658 n13661 VDD VSS n13747 NAND2X1
XU14236 g1506 n13508 VDD VSS n13661 XOR2X1
XU14237 n13484 n13361 VDD VSS n13658 XOR2X1
XU14238 n13660 n13662 VDD VSS n13746 NAND2X1
XU14239 n13522 n13692 VDD VSS n13662 XOR2X1
XU14240 n13737 VDD VSS n13660 INVX1
XU14241 g1496 n13440 VDD VSS n13737 XOR2X1
XU14242 g1476 n13699 VDD VSS n13651 XOR2X1
XU14243 n13748 n13749 VDD VSS n13620 AND2X1
XU14244 n13750 n13751 VDD VSS n13749 NAND2X1
XU14245 n13653 n13752 VDD VSS n13750 NOR2X1
XU14246 n13654 n13657 VDD VSS n13752 AND2X1
XU14247 n13753 n13754 VDD VSS n13653 NOR2X1
XU14248 n13755 n13756 VDD VSS n13748 NOR2X1
XU14249 n13657 n13757 VDD VSS n13756 NOR2X1
XU14250 n13758 n13759 VDD VSS n13757 NAND2X1
XU14251 n13654 n13760 VDD VSS n13759 NAND2X1
XU14252 n13652 n13761 VDD VSS n13758 NAND2X1
XU14253 n13760 n13762 VDD VSS n13755 NOR2X1
XU14254 n13763 n13764 VDD VSS n13762 NAND2X1
XU14255 n13657 n13761 VDD VSS n13764 NAND2X1
XU14256 n13754 VDD VSS n13761 INVX1
XU14257 n13765 n13702 VDD VSS n13754 XOR2X1
XU14258 n13362 n13488 VDD VSS n13657 XOR2X1
XU14259 n13652 n13654 VDD VSS n13763 NAND2X1
XU14260 g1481 n13544 VDD VSS n13654 XOR2X1
XU14261 n13751 VDD VSS n13652 INVX1
XU14262 n13766 n13689 VDD VSS n13751 XOR2X1
XU14263 n13753 VDD VSS n13760 INVX1
XU14264 n13767 n13468 VDD VSS n13753 XOR2X1
XU14265 n13768 n13769 VDD VSS n13710 NAND2X1
XU14266 n13770 n13771 VDD VSS n13769 NOR2X1
XU14267 n13772 n13773 VDD VSS n13771 NAND2X1
XU14268 n13774 n13775 VDD VSS n13773 NOR2X1
XU14269 n13522 n13776 VDD VSS n13775 NOR2X1
XU14270 g1526 n13777 VDD VSS n13776 NAND2X1
XU14271 g1486 n13777 VDD VSS n13774 NOR2X1
XU14272 n13778 n13779 VDD VSS n13772 NOR2X1
XU14273 n13362 n13780 VDD VSS n13779 XOR2X1
XU14274 n13781 n13782 VDD VSS n13780 NOR2X1
XU14275 n13783 n13784 VDD VSS n13782 NAND2X1
XU14276 g1547 n9387 VDD VSS n13784 NAND2X1
XU14277 g1541 VDD VSS n9387 INVX1
XU14278 g6573 n9392 VDD VSS n13783 NAND2X1
XU14279 g1542 VDD VSS n9392 INVX1
XU14280 g1543 n13374 VDD VSS n13781 NOR2X1
XU14281 n9384 VDD VSS n13362 INVX1
XU14282 n13785 n13786 VDD VSS n9384 NAND2X1
XU14283 g6782 n13787 VDD VSS n13786 NAND2X1
XU14284 n13788 n13789 VDD VSS n13785 NOR2X1
XU14285 g1557 n13290 VDD VSS n13789 NOR2X1
XU14286 g1556 n13291 VDD VSS n13788 NOR2X1
XU14287 n13361 n13790 VDD VSS n13778 XOR2X1
XU14288 n13791 n13792 VDD VSS n13790 NOR2X1
XU14289 n13793 n13794 VDD VSS n13792 NAND2X1
XU14290 g1547 n9381 VDD VSS n13794 NAND2X1
XU14291 g1544 VDD VSS n9381 INVX1
XU14292 g6573 n9395 VDD VSS n13793 NAND2X1
XU14293 g1545 VDD VSS n9395 INVX1
XU14294 g1546 n13374 VDD VSS n13791 NOR2X1
XU14295 n9376 VDD VSS n13361 INVX1
XU14296 n13795 n13796 VDD VSS n9376 NAND2X1
XU14297 g6782 n13797 VDD VSS n13796 NAND2X1
XU14298 n13798 n13799 VDD VSS n13795 NOR2X1
XU14299 g1554 n13290 VDD VSS n13799 NOR2X1
XU14300 g1553 n13291 VDD VSS n13798 NOR2X1
XU14301 n13800 n13612 VDD VSS n13770 NAND2X1
XU14302 n13588 VDD VSS n13612 INVX1
XU14303 g1563 n13801 VDD VSS n13588 NAND2X1
XU14304 n13802 n13803 VDD VSS n13800 NOR2X1
XU14305 n13767 n13804 VDD VSS n13803 XOR2X1
XU14306 n13805 n13806 VDD VSS n13804 NOR2X1
XU14307 n13807 n13808 VDD VSS n13806 NAND2X1
XU14308 g1547 n13164 VDD VSS n13808 NAND2X1
XU14309 g1511 VDD VSS n13164 INVX1
XU14310 g6573 n13159 VDD VSS n13807 NAND2X1
XU14311 g1512 VDD VSS n13159 INVX1
XU14312 g1513 n13374 VDD VSS n13805 NOR2X1
XU14313 n13557 n13809 VDD VSS n13802 XOR2X1
XU14314 n13810 n13811 VDD VSS n13809 NOR2X1
XU14315 n13812 n13813 VDD VSS n13811 NAND2X1
XU14316 g1547 n13172 VDD VSS n13813 NAND2X1
XU14317 g1514 VDD VSS n13172 INVX1
XU14318 g6573 n13167 VDD VSS n13812 NAND2X1
XU14319 g1515 VDD VSS n13167 INVX1
XU14320 g1516 n13374 VDD VSS n13810 NOR2X1
XU14321 n13814 n13815 VDD VSS n13768 NOR2X1
XU14322 n13816 n13817 VDD VSS n13815 NAND2X1
XU14323 n13818 n13819 VDD VSS n13817 NOR2X1
XU14324 n13765 n13820 VDD VSS n13819 NOR2X1
XU14325 g1535 n13821 VDD VSS n13820 NAND2X1
XU14326 g1501 n13821 VDD VSS n13818 NOR2X1
XU14327 n13822 VDD VSS n13821 INVX1
XU14328 n13823 n13824 VDD VSS n13816 NOR2X1
XU14329 n13825 n13826 VDD VSS n13824 NAND2X1
XU14330 n13827 n13828 VDD VSS n13826 NAND2X1
XU14331 n13829 g1496 VDD VSS n13825 NAND2X1
XU14332 n13827 n13209 VDD VSS n13829 NOR2X1
XU14333 n13830 n13831 VDD VSS n13823 NAND2X1
XU14334 n13832 n13291 VDD VSS n13831 NAND2X1
XU14335 n13833 n13834 VDD VSS n13832 NAND2X1
XU14336 n13835 n13836 VDD VSS n13834 NOR2X1
XU14337 n13837 n13838 VDD VSS n13836 NAND2X1
XU14338 n13777 g1486 VDD VSS n13838 NAND2X1
XU14339 n13839 n13840 VDD VSS n13777 AND2X1
XU14340 g6573 n13185 VDD VSS n13840 NAND2X1
XU14341 g1527 VDD VSS n13185 INVX1
XU14342 g6782 n13188 VDD VSS n13839 NAND2X1
XU14343 g1528 VDD VSS n13188 INVX1
XU14344 n13841 n13766 VDD VSS n13837 OR2X1
XU14345 n13842 n13843 VDD VSS n13835 NOR2X1
XU14346 n13844 n13845 VDD VSS n13833 NOR2X1
XU14347 n13846 n13847 VDD VSS n13845 NAND2X1
XU14348 n13848 n13542 VDD VSS n13847 OR2X1
XU14349 n13827 n13828 VDD VSS n13846 OR2X1
XU14350 n13849 n13850 VDD VSS n13827 NAND2X1
XU14351 g6573 n13203 VDD VSS n13850 NAND2X1
XU14352 g1533 VDD VSS n13203 INVX1
XU14353 g6782 n13206 VDD VSS n13849 NAND2X1
XU14354 g1534 VDD VSS n13206 INVX1
XU14355 n13765 n13822 VDD VSS n13844 NOR2X1
XU14356 n13851 n13852 VDD VSS n13822 NAND2X1
XU14357 g6573 n13212 VDD VSS n13852 NAND2X1
XU14358 g1536 VDD VSS n13212 INVX1
XU14359 g6782 n13215 VDD VSS n13851 NAND2X1
XU14360 g1537 VDD VSS n13215 INVX1
XU14361 g1547 n13853 VDD VSS n13830 NAND2X1
XU14362 n13854 n13855 VDD VSS n13853 NAND2X1
XU14363 n13856 n13857 VDD VSS n13855 NOR2X1
XU14364 n13858 n13859 VDD VSS n13857 NAND2X1
XU14365 n13542 n13182 VDD VSS n13859 NAND2X1
XU14366 n13522 n13191 VDD VSS n13858 NAND2X1
XU14367 g1526 VDD VSS n13191 INVX1
XU14368 g1529 g1491 VDD VSS n13856 NOR2X1
XU14369 n13860 n13861 VDD VSS n13854 NOR2X1
XU14370 n13862 n13863 VDD VSS n13861 NAND2X1
XU14371 n13828 n13209 VDD VSS n13863 NAND2X1
XU14372 g1532 VDD VSS n13209 INVX1
XU14373 n13765 n13218 VDD VSS n13862 NAND2X1
XU14374 g1535 VDD VSS n13218 INVX1
XU14375 g1538 g1506 VDD VSS n13860 NOR2X1
XU14376 n13864 n13865 VDD VSS n13814 NAND2X1
XU14377 n13866 n13867 VDD VSS n13865 NOR2X1
XU14378 n13842 n13868 VDD VSS n13867 NOR2X1
XU14379 g1538 n13869 VDD VSS n13868 NAND2X1
XU14380 g1506 n13869 VDD VSS n13866 NOR2X1
XU14381 n13843 VDD VSS n13869 INVX1
XU14382 n13870 n13871 VDD VSS n13843 NAND2X1
XU14383 g6573 n13369 VDD VSS n13871 NAND2X1
XU14384 g1539 VDD VSS n13369 INVX1
XU14385 g6782 n13373 VDD VSS n13870 NAND2X1
XU14386 g1540 VDD VSS n13373 INVX1
XU14387 n13872 n13873 VDD VSS n13864 NOR2X1
XU14388 n13874 n13875 VDD VSS n13873 NAND2X1
XU14389 n13841 n13766 VDD VSS n13875 NAND2X1
XU14390 n13876 g1491 VDD VSS n13874 NAND2X1
XU14391 n13841 n13200 VDD VSS n13876 NOR2X1
XU14392 g1529 VDD VSS n13200 INVX1
XU14393 n13877 n13878 VDD VSS n13841 NAND2X1
XU14394 g6573 n13194 VDD VSS n13878 NAND2X1
XU14395 g1530 VDD VSS n13194 INVX1
XU14396 g6782 n13197 VDD VSS n13877 NAND2X1
XU14397 g1531 VDD VSS n13197 INVX1
XU14398 n13879 n13880 VDD VSS n13872 NAND2X1
XU14399 n13848 n13542 VDD VSS n13880 NAND2X1
XU14400 n13881 g1481 VDD VSS n13879 NAND2X1
XU14401 n13848 n13182 VDD VSS n13881 NOR2X1
XU14402 g1523 VDD VSS n13182 INVX1
XU14403 n13882 n13883 VDD VSS n13848 NAND2X1
XU14404 g6573 n13175 VDD VSS n13883 NAND2X1
XU14405 g1524 VDD VSS n13175 INVX1
XU14406 g6782 n13179 VDD VSS n13882 NAND2X1
XU14407 g1525 VDD VSS n13179 INVX1
XU14408 n13801 n13370 VDD VSS n13320 NOR2X1
XU14409 n13884 n13885 VDD VSS n13801 NAND2X1
XU14410 g6782 n13886 VDD VSS n13885 NAND2X1
XU14411 n13887 n13888 VDD VSS n13884 NOR2X1
XU14412 g1551 n13290 VDD VSS n13888 NOR2X1
XU14413 g1550 n13291 VDD VSS n13887 NOR2X1
XU14414 n13889 n13890 VDD VSS n7710 NAND2X1
XU14415 g2879 n13891 VDD VSS n13890 NAND2X1
XU14416 n13842 n13892 VDD VSS n13889 NAND2X1
XU14417 n13893 n13894 VDD VSS n7709 NAND2X1
XU14418 g2879 n13895 VDD VSS n13894 NAND2X1
XU14419 n13765 n8609 VDD VSS n13893 NAND2X1
XU14420 g1501 VDD VSS n13765 INVX1
XU14421 n13896 n13897 VDD VSS n7708 NAND2X1
XU14422 g2879 n13898 VDD VSS n13897 NAND2X1
XU14423 n13828 n13892 VDD VSS n13896 NAND2X1
XU14424 g1496 VDD VSS n13828 INVX1
XU14425 n13899 n13900 VDD VSS n7707 NAND2X1
XU14426 g2879 n13901 VDD VSS n13900 NAND2X1
XU14427 n13766 n8609 VDD VSS n13899 NAND2X1
XU14428 n13902 n13903 VDD VSS n7706 NAND2X1
XU14429 g2879 n13904 VDD VSS n13903 NAND2X1
XU14430 n13522 n13892 VDD VSS n13902 NAND2X1
XU14431 g1486 VDD VSS n13522 INVX1
XU14432 n13905 n13906 VDD VSS n7705 NAND2X1
XU14433 g2879 n13907 VDD VSS n13906 NAND2X1
XU14434 n11376 n8609 VDD VSS n13905 NAND2X1
XU14435 g2170 VDD VSS n11376 INVX1
XU14436 n13908 n13909 VDD VSS n7704 NAND2X1
XU14437 g2879 n13910 VDD VSS n13909 NAND2X1
XU14438 n13542 n13892 VDD VSS n13908 NAND2X1
XU14439 g1481 VDD VSS n13542 INVX1
XU14440 n13911 n13912 VDD VSS n7703 NAND2X1
XU14441 g2879 n13913 VDD VSS n13912 NAND2X1
XU14442 n13557 n8609 VDD VSS n13911 NAND2X1
XU14443 g1476 VDD VSS n13557 INVX1
XU14444 n13914 n13915 VDD VSS n7702 NAND2X1
XU14445 g2879 n13916 VDD VSS n13915 NAND2X1
XU14446 n11361 n13892 VDD VSS n13914 NAND2X1
XU14447 g2175 VDD VSS n11361 INVX1
XU14448 n13917 n13918 VDD VSS n7701 NAND2X1
XU14449 g2879 n13919 VDD VSS n13918 NAND2X1
XU14450 n13767 n8609 VDD VSS n13917 NAND2X1
XU14451 g1471 VDD VSS n13767 INVX1
XU14452 n13920 n13921 VDD VSS n7700 NAND2X1
XU14453 g2879 n13922 VDD VSS n13921 NAND2X1
XU14454 n11661 n13892 VDD VSS n13920 NAND2X1
XU14455 g24890 VDD VSS n77 INVX1
XU14456 n13923 n13924 VDD VSS n7699 NAND2X1
XU14457 II20616 n8609 VDD VSS n13924 NAND2X1
XU14458 n13925 g2879 VDD VSS n13923 NAND2X1
XU14459 n13926 n13927 VDD VSS n7698 NAND2X1
XU14460 g2879 n13928 VDD VSS n13927 NAND2X1
XU14461 n11341 n13892 VDD VSS n13926 NAND2X1
XU14462 g2180 VDD VSS n11341 INVX1
XU14463 n13929 n13930 VDD VSS n7697 NAND2X1
XU14464 II20664 n8609 VDD VSS n13930 NAND2X1
XU14465 n13931 g2879 VDD VSS n13929 NAND2X1
XU14466 n13932 n13933 VDD VSS n7696 NAND2X1
XU14467 g2879 n13934 VDD VSS n13933 NAND2X1
XU14468 n11585 n13892 VDD VSS n13932 NAND2X1
XU14469 n13935 n13936 VDD VSS n7695 NAND2X1
XU14470 g2879 n13937 VDD VSS n13936 NAND2X1
XU14471 n11586 n8609 VDD VSS n13935 NAND2X1
XU14472 g2165 VDD VSS n11586 INVX1
XU14473 n13938 n13939 VDD VSS n7694 NAND2X1
XU14474 g2879 n13940 VDD VSS n13939 NAND2X1
XU14475 n11647 n13892 VDD VSS n13938 NAND2X1
XU14476 g2190 VDD VSS n11647 INVX1
XU14477 n13941 n13942 VDD VSS n7693 NAND2X1
XU14478 g2879 n13943 VDD VSS n13942 NAND2X1
XU14479 n11584 n8609 VDD VSS n13941 NAND2X1
XU14480 g2195 VDD VSS n11584 INVX1
XU14481 n13944 n13945 VDD VSS n7692 NAND2X1
XU14482 g6225 n8609 VDD VSS n13945 OR2X1
XU14483 n8609 n13928 VDD VSS n13944 NAND2X1
XU14484 g2972 VDD VSS n13928 INVX1
XU14485 n13946 n13947 VDD VSS n7691 NAND2X1
XU14486 g6442 n13892 VDD VSS n13947 OR2X1
XU14487 n13892 n13916 VDD VSS n13946 NAND2X1
XU14488 g2969 VDD VSS n13916 INVX1
XU14489 n13948 n13949 VDD VSS n7690 NAND2X1
XU14490 g6895 n8609 VDD VSS n13949 OR2X1
XU14491 n8609 n13907 VDD VSS n13948 NAND2X1
XU14492 g2966 VDD VSS n13907 INVX1
XU14493 n13950 n13951 VDD VSS n7689 NAND2X1
XU14494 g7334 n13892 VDD VSS n13951 OR2X1
XU14495 n13892 n13937 VDD VSS n13950 NAND2X1
XU14496 g2963 VDD VSS n13937 INVX1
XU14497 n13952 n13953 VDD VSS n7688 NAND2X1
XU14498 g7519 n8609 VDD VSS n13953 OR2X1
XU14499 n13931 n13892 VDD VSS n13952 NAND2X1
XU14500 n13954 n13955 VDD VSS n13931 NOR2X1
XU14501 n13956 n13957 VDD VSS n13955 AND2X1
XU14502 n13957 n13956 VDD VSS n13954 NOR2X1
XU14503 n13958 n13959 VDD VSS n7687 NAND2X1
XU14504 g8023 n13892 VDD VSS n13959 OR2X1
XU14505 n8609 n13901 VDD VSS n13958 NAND2X1
XU14506 g2947 VDD VSS n13901 INVX1
XU14507 n13960 n13961 VDD VSS n7686 NAND2X1
XU14508 g8096 n8609 VDD VSS n13961 OR2X1
XU14509 n13925 n8609 VDD VSS n13960 NAND2X1
XU14510 n13962 n13963 VDD VSS n13925 NOR2X1
XU14511 n13964 n13957 VDD VSS n13963 AND2X1
XU14512 n13957 n13964 VDD VSS n13962 NOR2X1
XU14513 g3139 n13965 VDD VSS n13957 NAND2X1
XU14514 n13966 n13967 VDD VSS n7685 NAND2X1
XU14515 g8175 n13892 VDD VSS n13967 OR2X1
XU14516 n13892 n13904 VDD VSS n13966 NAND2X1
XU14517 g2944 VDD VSS n13904 INVX1
XU14518 n13968 n13969 VDD VSS n7684 NAND2X1
XU14519 g8249 n8609 VDD VSS n13969 OR2X1
XU14520 n8609 n13891 VDD VSS n13968 NAND2X1
XU14521 g2959 VDD VSS n13891 INVX1
XU14522 n13970 n13971 VDD VSS n7683 NAND2X1
XU14523 g8251 n13892 VDD VSS n13971 OR2X1
XU14524 n13922 n13892 VDD VSS n13970 NAND2X1
XU14525 n13972 n13973 VDD VSS n7682 NAND2X1
XU14526 g3993 n8609 VDD VSS n13973 OR2X1
XU14527 n13892 n13910 VDD VSS n13972 NAND2X1
XU14528 g2941 VDD VSS n13910 INVX1
XU14529 n13974 n13975 VDD VSS n7681 NAND2X1
XU14530 g4088 n13892 VDD VSS n13975 OR2X1
XU14531 n8609 n13895 VDD VSS n13974 NAND2X1
XU14532 g2956 VDD VSS n13895 INVX1
XU14533 n13976 n13977 VDD VSS n7680 NAND2X1
XU14534 g4090 n8609 VDD VSS n13977 OR2X1
XU14535 n13892 n13943 VDD VSS n13976 NAND2X1
XU14536 g2981 VDD VSS n13943 INVX1
XU14537 n13978 n13979 VDD VSS n7679 NAND2X1
XU14538 g4200 n13892 VDD VSS n13979 OR2X1
XU14539 n8609 n13913 VDD VSS n13978 NAND2X1
XU14540 g2938 VDD VSS n13913 INVX1
XU14541 n13980 n13981 VDD VSS n7678 NAND2X1
XU14542 g4321 n8609 VDD VSS n13981 OR2X1
XU14543 n13892 n13898 VDD VSS n13980 NAND2X1
XU14544 g2953 VDD VSS n13898 INVX1
XU14545 n13982 n13983 VDD VSS n7677 NAND2X1
XU14546 g4323 n13892 VDD VSS n13983 OR2X1
XU14547 n8609 n13940 VDD VSS n13982 NAND2X1
XU14548 g2978 VDD VSS n13940 INVX1
XU14549 n13984 n13985 VDD VSS n7676 NAND2X1
XU14550 g4450 n8609 VDD VSS n13985 OR2X1
XU14551 n13892 n13919 VDD VSS n13984 NAND2X1
XU14552 n13986 n13987 VDD VSS n7675 NAND2X1
XU14553 g4590 n13892 VDD VSS n13987 OR2X1
XU14554 n8609 n13934 VDD VSS n13986 NAND2X1
XU14555 g2975 VDD VSS n13934 INVX1
XU14556 n13988 n13989 VDD VSS n7674 NAND2X1
XU14557 n13990 II18473 VDD VSS n13989 NAND2X1
XU14558 n13991 n13992 VDD VSS n13988 NAND2X1
XU14559 n13993 n13994 VDD VSS n7673 NAND2X1
XU14560 n13990 II18482 VDD VSS n13994 NAND2X1
XU14561 n13991 n13995 VDD VSS n13993 NAND2X1
XU14562 n13996 n13997 VDD VSS n7672 NAND2X1
XU14563 n13990 II18491 VDD VSS n13997 NAND2X1
XU14564 n13998 n13991 VDD VSS n13996 NAND2X1
XU14565 n13999 n14000 VDD VSS n7671 NAND2X1
XU14566 n14001 n13991 VDD VSS n14000 NAND2X1
XU14567 n13990 II18500 VDD VSS n13999 NAND2X1
XU14568 n13991 VDD VSS n13990 INVX1
XU14569 n11779 n7662 VDD VSS n13991 NOR2X1
XU14570 n14002 n14003 VDD VSS n7670 NAND2X1
XU14571 n14004 II18470 VDD VSS n14003 NAND2X1
XU14572 n14005 n13992 VDD VSS n14002 NAND2X1
XU14573 n14006 n14007 VDD VSS n7669 NAND2X1
XU14574 n14008 II18467 VDD VSS n14007 NAND2X1
XU14575 n14009 n13992 VDD VSS n14006 NAND2X1
XU14576 n14010 n14011 VDD VSS n13992 NAND2X1
XU14577 g3229 n14012 VDD VSS n14011 NAND2X1
XU14578 n14013 n14014 VDD VSS n14010 NOR2X1
XU14579 g3229 n14015 VDD VSS n14014 NOR2X1
XU14580 n14016 n14017 VDD VSS n14013 NOR2X1
XU14581 n122 n14018 VDD VSS n14017 NAND2X1
XU14582 n14015 VDD VSS n14016 INVX1
XU14583 n14019 n14020 VDD VSS n7668 NAND2X1
XU14584 n14004 II18479 VDD VSS n14020 NAND2X1
XU14585 n14005 n13995 VDD VSS n14019 NAND2X1
XU14586 n14021 n14022 VDD VSS n7667 NAND2X1
XU14587 n14008 II18476 VDD VSS n14022 NAND2X1
XU14588 n14009 n13995 VDD VSS n14021 NAND2X1
XU14589 n14015 n14023 VDD VSS n13995 NAND2X1
XU14590 n14024 n121 VDD VSS n14023 OR2X1
XU14591 n121 n14025 VDD VSS n14015 NAND2X1
XU14592 n14026 n14027 VDD VSS n7666 NAND2X1
XU14593 n14004 II18488 VDD VSS n14027 NAND2X1
XU14594 n14005 n13998 VDD VSS n14026 NAND2X1
XU14595 n14028 n14029 VDD VSS n7665 NAND2X1
XU14596 n14008 II18485 VDD VSS n14029 NAND2X1
XU14597 n14009 n13998 VDD VSS n14028 NAND2X1
XU14598 n14030 n14031 VDD VSS n13998 NAND2X1
XU14599 n14024 n14025 VDD VSS n14031 NAND2X1
XU14600 n14032 n120 VDD VSS n14030 NAND2X1
XU14601 n14024 n14012 VDD VSS n14032 NOR2X1
XU14602 n14033 n14034 VDD VSS n7664 NAND2X1
XU14603 n14005 n14001 VDD VSS n14034 NAND2X1
XU14604 n14004 II18497 VDD VSS n14033 NAND2X1
XU14605 n14005 VDD VSS n14004 INVX1
XU14606 n11793 n7662 VDD VSS n14005 NOR2X1
XU14607 n14035 n14036 VDD VSS n7663 NAND2X1
XU14608 n14008 II18494 VDD VSS n14036 NAND2X1
XU14609 n14009 VDD VSS n14008 INVX1
XU14610 n14009 n14001 VDD VSS n14035 NAND2X1
XU14611 n14037 n14024 VDD VSS n14001 AND2X1
XU14612 n9334 n119 VDD VSS n14024 XOR2X1
XU14613 n14038 n14025 VDD VSS n14037 NOR2X1
XU14614 n11773 n7662 VDD VSS n14009 NOR2X1
XU14615 n10202 n14039 VDD VSS n7662 NAND2X1
XU14616 n14040 n10193 VDD VSS n14039 NAND2X1
XU14617 n14041 n14042 VDD VSS n7661 NAND2X1
XU14618 n14043 II18554 VDD VSS n14042 NAND2X1
XU14619 n14044 n14045 VDD VSS n14041 NAND2X1
XU14620 n14046 n14047 VDD VSS n7660 NAND2X1
XU14621 n14043 II18563 VDD VSS n14047 NAND2X1
XU14622 n14044 n14048 VDD VSS n14046 NAND2X1
XU14623 n14049 n14050 VDD VSS n7659 NAND2X1
XU14624 n14043 II18572 VDD VSS n14050 NAND2X1
XU14625 n14051 n14044 VDD VSS n14049 NAND2X1
XU14626 n14052 n14053 VDD VSS n7658 NAND2X1
XU14627 n14054 n14044 VDD VSS n14053 NAND2X1
XU14628 n14043 II18581 VDD VSS n14052 NAND2X1
XU14629 n14044 VDD VSS n14043 INVX1
XU14630 n12512 n7649 VDD VSS n14044 NOR2X1
XU14631 n14055 n14056 VDD VSS n7657 NAND2X1
XU14632 n14057 II18551 VDD VSS n14056 NAND2X1
XU14633 n14058 n14045 VDD VSS n14055 NAND2X1
XU14634 n14059 n14060 VDD VSS n7656 NAND2X1
XU14635 n14061 II18548 VDD VSS n14060 NAND2X1
XU14636 n14062 n14045 VDD VSS n14059 NAND2X1
XU14637 n14063 n14064 VDD VSS n14045 NAND2X1
XU14638 g3229 n14065 VDD VSS n14064 NAND2X1
XU14639 n14066 n14067 VDD VSS n14063 NOR2X1
XU14640 g3229 n14068 VDD VSS n14067 NOR2X1
XU14641 n14069 n14070 VDD VSS n14066 NOR2X1
XU14642 n209 n14071 VDD VSS n14070 NAND2X1
XU14643 n14068 VDD VSS n14069 INVX1
XU14644 n14072 n14073 VDD VSS n7655 NAND2X1
XU14645 n14057 II18560 VDD VSS n14073 NAND2X1
XU14646 n14058 n14048 VDD VSS n14072 NAND2X1
XU14647 n14074 n14075 VDD VSS n7654 NAND2X1
XU14648 n14061 II18557 VDD VSS n14075 NAND2X1
XU14649 n14062 n14048 VDD VSS n14074 NAND2X1
XU14650 n14068 n14076 VDD VSS n14048 NAND2X1
XU14651 n14077 n208 VDD VSS n14076 OR2X1
XU14652 n208 n14078 VDD VSS n14068 NAND2X1
XU14653 n14079 n14080 VDD VSS n7653 NAND2X1
XU14654 n14057 II18569 VDD VSS n14080 NAND2X1
XU14655 n14058 n14051 VDD VSS n14079 NAND2X1
XU14656 n14081 n14082 VDD VSS n7652 NAND2X1
XU14657 n14061 II18566 VDD VSS n14082 NAND2X1
XU14658 n14062 n14051 VDD VSS n14081 NAND2X1
XU14659 n14083 n14084 VDD VSS n14051 NAND2X1
XU14660 n14077 n14078 VDD VSS n14084 NAND2X1
XU14661 n14085 n207 VDD VSS n14083 NAND2X1
XU14662 n14077 n14065 VDD VSS n14085 NOR2X1
XU14663 n14086 n14087 VDD VSS n7651 NAND2X1
XU14664 n14058 n14054 VDD VSS n14087 NAND2X1
XU14665 n14057 II18578 VDD VSS n14086 NAND2X1
XU14666 n14058 VDD VSS n14057 INVX1
XU14667 n10170 n7649 VDD VSS n14058 NOR2X1
XU14668 n14088 n14089 VDD VSS n7650 NAND2X1
XU14669 n14061 II18575 VDD VSS n14089 NAND2X1
XU14670 n14062 VDD VSS n14061 INVX1
XU14671 n14062 n14054 VDD VSS n14088 NAND2X1
XU14672 n14090 n14077 VDD VSS n14054 AND2X1
XU14673 n9334 n206 VDD VSS n14077 XOR2X1
XU14674 n14091 n14078 VDD VSS n14090 NOR2X1
XU14675 n12506 n7649 VDD VSS n14062 NOR2X1
XU14676 n9698 n14092 VDD VSS n7649 NAND2X1
XU14677 n14040 n9689 VDD VSS n14092 NAND2X1
XU14678 n14093 n14094 VDD VSS n7648 NAND2X1
XU14679 n14095 II18635 VDD VSS n14094 NAND2X1
XU14680 n14096 n14097 VDD VSS n14093 NAND2X1
XU14681 n14098 n14099 VDD VSS n7647 NAND2X1
XU14682 n14095 II18644 VDD VSS n14099 NAND2X1
XU14683 n14096 n14100 VDD VSS n14098 NAND2X1
XU14684 n14101 n14102 VDD VSS n7646 NAND2X1
XU14685 n14095 II18653 VDD VSS n14102 NAND2X1
XU14686 n14103 n14096 VDD VSS n14101 NAND2X1
XU14687 n14104 n14105 VDD VSS n7645 NAND2X1
XU14688 n14106 n14096 VDD VSS n14105 NAND2X1
XU14689 n14095 II18662 VDD VSS n14104 NAND2X1
XU14690 n14096 VDD VSS n14095 INVX1
XU14691 n13228 n7636 VDD VSS n14096 NOR2X1
XU14692 n14107 n14108 VDD VSS n7644 NAND2X1
XU14693 n14109 II18632 VDD VSS n14108 NAND2X1
XU14694 n14110 n14097 VDD VSS n14107 NAND2X1
XU14695 n14111 n14112 VDD VSS n7643 NAND2X1
XU14696 n14113 II18629 VDD VSS n14112 NAND2X1
XU14697 n14114 n14097 VDD VSS n14111 NAND2X1
XU14698 n14115 n14116 VDD VSS n14097 NAND2X1
XU14699 g3229 n14117 VDD VSS n14116 NAND2X1
XU14700 n14118 n14119 VDD VSS n14115 NOR2X1
XU14701 g3229 n14120 VDD VSS n14119 NOR2X1
XU14702 n14121 n14122 VDD VSS n14118 NOR2X1
XU14703 n267 n14123 VDD VSS n14122 NAND2X1
XU14704 n14120 VDD VSS n14121 INVX1
XU14705 n14124 n14125 VDD VSS n7642 NAND2X1
XU14706 n14109 II18641 VDD VSS n14125 NAND2X1
XU14707 n14110 n14100 VDD VSS n14124 NAND2X1
XU14708 n14126 n14127 VDD VSS n7641 NAND2X1
XU14709 n14113 II18638 VDD VSS n14127 NAND2X1
XU14710 n14114 n14100 VDD VSS n14126 NAND2X1
XU14711 n14120 n14128 VDD VSS n14100 NAND2X1
XU14712 n14129 n266 VDD VSS n14128 OR2X1
XU14713 n266 n14130 VDD VSS n14120 NAND2X1
XU14714 n14131 n14132 VDD VSS n7640 NAND2X1
XU14715 n14109 II18650 VDD VSS n14132 NAND2X1
XU14716 n14110 n14103 VDD VSS n14131 NAND2X1
XU14717 n14133 n14134 VDD VSS n7639 NAND2X1
XU14718 n14113 II18647 VDD VSS n14134 NAND2X1
XU14719 n14114 n14103 VDD VSS n14133 NAND2X1
XU14720 n14135 n14136 VDD VSS n14103 NAND2X1
XU14721 n14129 n14130 VDD VSS n14136 NAND2X1
XU14722 n14137 n265 VDD VSS n14135 NAND2X1
XU14723 n14129 n14117 VDD VSS n14137 NOR2X1
XU14724 n14138 n14139 VDD VSS n7638 NAND2X1
XU14725 n14110 n14106 VDD VSS n14139 NAND2X1
XU14726 n14109 II18659 VDD VSS n14138 NAND2X1
XU14727 n14110 VDD VSS n14109 INVX1
XU14728 n10163 n7636 VDD VSS n14110 NOR2X1
XU14729 n14140 n14141 VDD VSS n7637 NAND2X1
XU14730 n14113 II18656 VDD VSS n14141 NAND2X1
XU14731 n14114 VDD VSS n14113 INVX1
XU14732 n14114 n14106 VDD VSS n14140 NAND2X1
XU14733 n14142 n14129 VDD VSS n14106 AND2X1
XU14734 n9334 n264 VDD VSS n14129 XOR2X1
XU14735 n14143 n14130 VDD VSS n14142 NOR2X1
XU14736 n13222 n7636 VDD VSS n14114 NOR2X1
XU14737 n9347 n14144 VDD VSS n7636 NAND2X1
XU14738 n14040 n9338 VDD VSS n14144 NAND2X1
XU14739 n14145 n14146 VDD VSS n7635 NAND2X1
XU14740 n14147 II18716 VDD VSS n14146 NAND2X1
XU14741 n14148 n14149 VDD VSS n14145 NAND2X1
XU14742 n14150 n14151 VDD VSS n7634 NAND2X1
XU14743 n14147 II18725 VDD VSS n14151 NAND2X1
XU14744 n14148 n14152 VDD VSS n14150 NAND2X1
XU14745 n14153 n14154 VDD VSS n7633 NAND2X1
XU14746 n14147 II18734 VDD VSS n14154 NAND2X1
XU14747 n14155 n14148 VDD VSS n14153 NAND2X1
XU14748 n14156 n14157 VDD VSS n7632 NAND2X1
XU14749 n14158 n14148 VDD VSS n14157 NAND2X1
XU14750 n14147 II18743 VDD VSS n14156 NAND2X1
XU14751 n14148 VDD VSS n14147 INVX1
XU14752 n11047 n7623 VDD VSS n14148 NOR2X1
XU14753 n14159 n14160 VDD VSS n7631 NAND2X1
XU14754 n14161 II18713 VDD VSS n14160 NAND2X1
XU14755 n14162 n14149 VDD VSS n14159 NAND2X1
XU14756 n14163 n14164 VDD VSS n7630 NAND2X1
XU14757 n14165 II18710 VDD VSS n14164 NAND2X1
XU14758 n14166 n14149 VDD VSS n14163 NAND2X1
XU14759 n14167 n14168 VDD VSS n14149 NAND2X1
XU14760 g3229 n14169 VDD VSS n14168 NAND2X1
XU14761 n14170 n14171 VDD VSS n14167 NOR2X1
XU14762 g3229 n14172 VDD VSS n14171 NOR2X1
XU14763 n14173 n14174 VDD VSS n14170 NOR2X1
XU14764 n325 n14175 VDD VSS n14174 NAND2X1
XU14765 n14172 VDD VSS n14173 INVX1
XU14766 n14176 n14177 VDD VSS n7629 NAND2X1
XU14767 n14161 II18722 VDD VSS n14177 NAND2X1
XU14768 n14162 n14152 VDD VSS n14176 NAND2X1
XU14769 n14178 n14179 VDD VSS n7628 NAND2X1
XU14770 n14165 II18719 VDD VSS n14179 NAND2X1
XU14771 n14166 n14152 VDD VSS n14178 NAND2X1
XU14772 n14172 n14180 VDD VSS n14152 NAND2X1
XU14773 n14181 n324 VDD VSS n14180 OR2X1
XU14774 n324 n14182 VDD VSS n14172 NAND2X1
XU14775 n14183 n14184 VDD VSS n7627 NAND2X1
XU14776 n14161 II18731 VDD VSS n14184 NAND2X1
XU14777 n14162 n14155 VDD VSS n14183 NAND2X1
XU14778 n14185 n14186 VDD VSS n7626 NAND2X1
XU14779 n14165 II18728 VDD VSS n14186 NAND2X1
XU14780 n14166 n14155 VDD VSS n14185 NAND2X1
XU14781 n14187 n14188 VDD VSS n14155 NAND2X1
XU14782 n14181 n14182 VDD VSS n14188 NAND2X1
XU14783 n14189 n323 VDD VSS n14187 NAND2X1
XU14784 n14181 n14169 VDD VSS n14189 NOR2X1
XU14785 n14190 n14191 VDD VSS n7625 NAND2X1
XU14786 n14162 n14158 VDD VSS n14191 NAND2X1
XU14787 n14161 II18740 VDD VSS n14190 NAND2X1
XU14788 n14162 VDD VSS n14161 INVX1
XU14789 n10188 n7623 VDD VSS n14162 NOR2X1
XU14790 n14192 n14193 VDD VSS n7624 NAND2X1
XU14791 n14165 II18737 VDD VSS n14193 NAND2X1
XU14792 n14166 VDD VSS n14165 INVX1
XU14793 n14166 n14158 VDD VSS n14192 NAND2X1
XU14794 n14194 n14181 VDD VSS n14158 AND2X1
XU14795 n9334 n322 VDD VSS n14181 XOR2X1
XU14796 n14195 n14182 VDD VSS n14194 NOR2X1
XU14797 n11041 n7623 VDD VSS n14166 NOR2X1
XU14798 n8995 n14196 VDD VSS n7623 NAND2X1
XU14799 n14040 n8986 VDD VSS n14196 NAND2X1
XU14800 n14197 n14198 VDD VSS n7622 OR2X1
XU14801 g52 n14199 VDD VSS n14197 XOR2X1
XU14802 g56 n14200 VDD VSS n14199 NAND2X1
XU14803 n14201 n14202 VDD VSS n7621 NAND2X1
XU14804 g56 n14200 VDD VSS n14201 XOR2X1
XU14805 n14203 n14204 VDD VSS n7620 NAND2X1
XU14806 n14205 n14206 VDD VSS n14204 NAND2X1
XU14807 g65 n14207 VDD VSS n14205 NAND2X1
XU14808 n14200 n14198 VDD VSS n14203 NOR2X1
XU14809 n14208 g65 VDD VSS n14200 AND2X1
XU14810 n14209 n14206 VDD VSS n14208 NOR2X1
XU14811 n14210 n14202 VDD VSS n7619 NAND2X1
XU14812 g65 n14207 VDD VSS n14210 XOR2X1
XU14813 n14211 n14212 VDD VSS n7618 NAND2X1
XU14814 n14213 n14214 VDD VSS n14212 NAND2X1
XU14815 g74 n14215 VDD VSS n14213 NAND2X1
XU14816 n14207 n14198 VDD VSS n14211 NOR2X1
XU14817 n14209 VDD VSS n14207 INVX1
XU14818 n14216 g74 VDD VSS n14209 NAND2X1
XU14819 n14217 n14214 VDD VSS n14216 NOR2X1
XU14820 n14218 n14202 VDD VSS n7617 NAND2X1
XU14821 g74 n14215 VDD VSS n14218 XOR2X1
XU14822 n14219 n14220 VDD VSS n7616 NAND2X1
XU14823 n14221 n14222 VDD VSS n14220 NAND2X1
XU14824 g83 n14223 VDD VSS n14221 NAND2X1
XU14825 n14215 n14198 VDD VSS n14219 NOR2X1
XU14826 n14217 VDD VSS n14215 INVX1
XU14827 n14224 g83 VDD VSS n14217 NAND2X1
XU14828 n14225 n14222 VDD VSS n14224 NOR2X1
XU14829 g79 VDD VSS n14222 INVX1
XU14830 n14226 n14202 VDD VSS n7615 NAND2X1
XU14831 g83 n14223 VDD VSS n14226 XOR2X1
XU14832 n14227 n14228 VDD VSS n7614 NAND2X1
XU14833 n14229 n14230 VDD VSS n14228 NAND2X1
XU14834 g92 n14231 VDD VSS n14229 NAND2X1
XU14835 n14223 n14198 VDD VSS n14227 NOR2X1
XU14836 n14202 VDD VSS n14198 INVX1
XU14837 n14225 VDD VSS n14223 INVX1
XU14838 n14232 g92 VDD VSS n14225 NAND2X1
XU14839 n14231 g88 VDD VSS n14232 AND2X1
XU14840 n14233 n14202 VDD VSS n7613 NAND2X1
XU14841 n14040 n10234 VDD VSS n14202 NAND2X1
XU14842 n11843 n11922 VDD VSS n10234 NOR2X1
XU14843 g181 VDD VSS n11922 INVX1
XU14844 g92 n14231 VDD VSS n14233 XOR2X1
XU14845 n11843 n14040 VDD VSS n14231 NOR2X1
XU14846 n14234 n14235 VDD VSS n7612 OR2X1
XU14847 g740 n14236 VDD VSS n14234 XOR2X1
XU14848 g744 n14237 VDD VSS n14236 NAND2X1
XU14849 n14238 n14239 VDD VSS n7611 NAND2X1
XU14850 g744 n14237 VDD VSS n14238 XOR2X1
XU14851 n14240 n14241 VDD VSS n7610 NAND2X1
XU14852 n14242 n14243 VDD VSS n14241 NAND2X1
XU14853 g753 n14244 VDD VSS n14242 NAND2X1
XU14854 n14237 n14235 VDD VSS n14240 NOR2X1
XU14855 n14245 g753 VDD VSS n14237 AND2X1
XU14856 n14246 n14243 VDD VSS n14245 NOR2X1
XU14857 g749 VDD VSS n14243 INVX1
XU14858 n14247 n14239 VDD VSS n7609 NAND2X1
XU14859 g753 n14244 VDD VSS n14247 XOR2X1
XU14860 n14248 n14249 VDD VSS n7608 NAND2X1
XU14861 n14250 n14251 VDD VSS n14249 NAND2X1
XU14862 g762 n14252 VDD VSS n14250 NAND2X1
XU14863 n14244 n14235 VDD VSS n14248 NOR2X1
XU14864 n14246 VDD VSS n14244 INVX1
XU14865 n14253 g762 VDD VSS n14246 NAND2X1
XU14866 n14254 n14251 VDD VSS n14253 NOR2X1
XU14867 n14255 n14239 VDD VSS n7607 NAND2X1
XU14868 g762 n14252 VDD VSS n14255 XOR2X1
XU14869 n14256 n14257 VDD VSS n7606 NAND2X1
XU14870 n14258 n14259 VDD VSS n14257 NAND2X1
XU14871 g771 n14260 VDD VSS n14258 NAND2X1
XU14872 n14252 n14235 VDD VSS n14256 NOR2X1
XU14873 n14254 VDD VSS n14252 INVX1
XU14874 n14261 g771 VDD VSS n14254 NAND2X1
XU14875 n14262 n14259 VDD VSS n14261 NOR2X1
XU14876 n14263 n14239 VDD VSS n7605 NAND2X1
XU14877 g771 n14260 VDD VSS n14263 XOR2X1
XU14878 n14264 n14265 VDD VSS n7604 NAND2X1
XU14879 n14266 n14267 VDD VSS n14265 NAND2X1
XU14880 g780 n14268 VDD VSS n14266 NAND2X1
XU14881 n14260 n14235 VDD VSS n14264 NOR2X1
XU14882 n14239 VDD VSS n14235 INVX1
XU14883 n14262 VDD VSS n14260 INVX1
XU14884 n14269 g780 VDD VSS n14262 NAND2X1
XU14885 n14268 g776 VDD VSS n14269 AND2X1
XU14886 n14270 n14239 VDD VSS n7603 NAND2X1
XU14887 n14040 n9732 VDD VSS n14239 NAND2X1
XU14888 n13050 n12654 VDD VSS n9732 NOR2X1
XU14889 g869 VDD VSS n12654 INVX1
XU14890 g780 n14268 VDD VSS n14270 XOR2X1
XU14891 n13050 n14040 VDD VSS n14268 NOR2X1
XU14892 n14271 n14272 VDD VSS n7602 OR2X1
XU14893 g1426 n14273 VDD VSS n14271 XOR2X1
XU14894 g1430 n14274 VDD VSS n14273 NAND2X1
XU14895 n14275 n14276 VDD VSS n7601 NAND2X1
XU14896 g1430 n14274 VDD VSS n14275 XOR2X1
XU14897 n14277 n14278 VDD VSS n7600 NAND2X1
XU14898 n14279 n14280 VDD VSS n14278 NAND2X1
XU14899 g1439 n14281 VDD VSS n14279 NAND2X1
XU14900 n14274 n14272 VDD VSS n14277 NOR2X1
XU14901 n14282 g1439 VDD VSS n14274 AND2X1
XU14902 n14283 n14280 VDD VSS n14282 NOR2X1
XU14903 g23919 VDD VSS n76 INVX1
XU14904 n14284 n14276 VDD VSS n7599 NAND2X1
XU14905 g1439 n14281 VDD VSS n14284 XOR2X1
XU14906 n14285 n14286 VDD VSS n7598 NAND2X1
XU14907 n14287 n14288 VDD VSS n14286 NAND2X1
XU14908 g1448 n14289 VDD VSS n14287 NAND2X1
XU14909 n14281 n14272 VDD VSS n14285 NOR2X1
XU14910 n14283 VDD VSS n14281 INVX1
XU14911 n14290 g1448 VDD VSS n14283 NAND2X1
XU14912 n14291 n14288 VDD VSS n14290 NOR2X1
XU14913 n14292 n14276 VDD VSS n7597 NAND2X1
XU14914 g1448 n14289 VDD VSS n14292 XOR2X1
XU14915 n14293 n14294 VDD VSS n7596 NAND2X1
XU14916 n14295 n14296 VDD VSS n14294 NAND2X1
XU14917 g1457 n14297 VDD VSS n14295 NAND2X1
XU14918 n14289 n14272 VDD VSS n14293 NOR2X1
XU14919 n14291 VDD VSS n14289 INVX1
XU14920 n14298 g1457 VDD VSS n14291 NAND2X1
XU14921 n14299 n14296 VDD VSS n14298 NOR2X1
XU14922 g1453 VDD VSS n14296 INVX1
XU14923 n14300 n14276 VDD VSS n7595 NAND2X1
XU14924 g1457 n14297 VDD VSS n14300 XOR2X1
XU14925 n14301 n14302 VDD VSS n7594 NAND2X1
XU14926 n14303 n14304 VDD VSS n14302 NAND2X1
XU14927 g1466 n14305 VDD VSS n14303 NAND2X1
XU14928 n14297 n14272 VDD VSS n14301 NOR2X1
XU14929 n14276 VDD VSS n14272 INVX1
XU14930 n14299 VDD VSS n14297 INVX1
XU14931 n14306 g1466 VDD VSS n14299 NAND2X1
XU14932 n14305 g1462 VDD VSS n14306 AND2X1
XU14933 n14307 n14276 VDD VSS n7593 NAND2X1
XU14934 n14040 n9379 VDD VSS n14276 NAND2X1
XU14935 n13291 n13370 VDD VSS n9379 NOR2X1
XU14936 g1563 VDD VSS n13370 INVX1
XU14937 g1466 n14305 VDD VSS n14307 XOR2X1
XU14938 n13291 n14040 VDD VSS n14305 NOR2X1
XU14939 n14308 n14309 VDD VSS n7592 OR2X1
XU14940 g2120 n14310 VDD VSS n14308 XOR2X1
XU14941 g2124 n14311 VDD VSS n14310 NAND2X1
XU14942 n14312 n14313 VDD VSS n7591 NAND2X1
XU14943 g2124 n14311 VDD VSS n14312 XOR2X1
XU14944 n14314 n14315 VDD VSS n7590 NAND2X1
XU14945 n14316 n14317 VDD VSS n14315 NAND2X1
XU14946 g2133 n14318 VDD VSS n14316 NAND2X1
XU14947 n14311 n14309 VDD VSS n14314 NOR2X1
XU14948 n14319 g2133 VDD VSS n14311 AND2X1
XU14949 n14320 n14317 VDD VSS n14319 NOR2X1
XU14950 n14321 n14313 VDD VSS n7589 NAND2X1
XU14951 g2133 n14318 VDD VSS n14321 XOR2X1
XU14952 n14322 n14323 VDD VSS n7588 NAND2X1
XU14953 n14324 n14325 VDD VSS n14323 NAND2X1
XU14954 g2142 n14326 VDD VSS n14324 NAND2X1
XU14955 n14318 n14309 VDD VSS n14322 NOR2X1
XU14956 n14320 VDD VSS n14318 INVX1
XU14957 n14327 g2142 VDD VSS n14320 NAND2X1
XU14958 n14328 n14325 VDD VSS n14327 NOR2X1
XU14959 n14329 n14313 VDD VSS n7587 NAND2X1
XU14960 g2142 n14326 VDD VSS n14329 XOR2X1
XU14961 n14330 n14331 VDD VSS n7586 NAND2X1
XU14962 n14332 n14333 VDD VSS n14331 NAND2X1
XU14963 g2151 n14334 VDD VSS n14332 NAND2X1
XU14964 n14326 n14309 VDD VSS n14330 NOR2X1
XU14965 n14328 VDD VSS n14326 INVX1
XU14966 n14335 g2151 VDD VSS n14328 NAND2X1
XU14967 n14336 n14333 VDD VSS n14335 NOR2X1
XU14968 g2147 VDD VSS n14333 INVX1
XU14969 n14337 n14313 VDD VSS n7585 NAND2X1
XU14970 g2151 n14334 VDD VSS n14337 XOR2X1
XU14971 n14338 n14339 VDD VSS n7584 NAND2X1
XU14972 n14340 n14341 VDD VSS n14339 NAND2X1
XU14973 g2160 n14342 VDD VSS n14340 NAND2X1
XU14974 n14334 n14309 VDD VSS n14338 NOR2X1
XU14975 n14313 VDD VSS n14309 INVX1
XU14976 n14336 VDD VSS n14334 INVX1
XU14977 n14343 g2160 VDD VSS n14336 NAND2X1
XU14978 n14342 g2156 VDD VSS n14343 AND2X1
XU14979 n14344 n14313 VDD VSS n7583 NAND2X1
XU14980 n14040 n9027 VDD VSS n14313 NAND2X1
XU14981 n11110 n11189 VDD VSS n9027 NOR2X1
XU14982 g2257 VDD VSS n11189 INVX1
XU14983 g2160 n14342 VDD VSS n14344 XOR2X1
XU14984 n11110 n14040 VDD VSS n14342 NOR2X1
XU14985 n14345 n14346 VDD VSS n7581 NAND2X1
XU14986 n14347 g168 VDD VSS n14346 OR2X1
XU14987 n14347 n14348 VDD VSS n14345 NAND2X1
XU14988 n14349 n14350 VDD VSS n7580 NAND2X1
XU14989 n14347 g101 VDD VSS n14350 NAND2X1
XU14990 n14347 g171 VDD VSS n14349 OR2X1
XU14991 n14351 n14352 VDD VSS n7579 NAND2X1
XU14992 n14347 g97 VDD VSS n14352 NAND2X1
XU14993 n14347 g174 VDD VSS n14351 OR2X1
XU14994 n14353 n14354 VDD VSS n7578 NAND2X1
XU14995 n14347 n11835 VDD VSS n14354 NAND2X1
XU14996 n14347 g177 VDD VSS n14353 OR2X1
XU14997 n11843 n7582 VDD VSS n14347 NOR2X1
XU14998 n14355 n14356 VDD VSS n7577 NAND2X1
XU14999 n14357 n12438 VDD VSS n14356 NAND2X1
XU15000 g170 VDD VSS n12438 INVX1
XU15001 n14358 n14348 VDD VSS n14355 NAND2X1
XU15002 n14359 n14360 VDD VSS n7576 NAND2X1
XU15003 n14361 g169 VDD VSS n14360 OR2X1
XU15004 n14361 n14348 VDD VSS n14359 NAND2X1
XU15005 n14362 n14363 VDD VSS n14348 NAND2X1
XU15006 g121 g117 VDD VSS n14363 NOR2X1
XU15007 n12318 n12394 VDD VSS n14362 NOR2X1
XU15008 g125 VDD VSS n12394 INVX1
XU15009 g113 VDD VSS n12318 INVX1
XU15010 n14364 n14365 VDD VSS n7575 NAND2X1
XU15011 n14358 g101 VDD VSS n14365 NAND2X1
XU15012 n14357 n12349 VDD VSS n14364 NAND2X1
XU15013 g173 VDD VSS n12349 INVX1
XU15014 n14366 n14367 VDD VSS n7574 NAND2X1
XU15015 n14361 g101 VDD VSS n14367 NAND2X1
XU15016 n14361 g172 VDD VSS n14366 OR2X1
XU15017 n14368 n14369 VDD VSS n7573 NAND2X1
XU15018 n14358 g97 VDD VSS n14369 NAND2X1
XU15019 n14357 n12339 VDD VSS n14368 NAND2X1
XU15020 g176 VDD VSS n12339 INVX1
XU15021 n14370 n14371 VDD VSS n7572 NAND2X1
XU15022 n14361 g97 VDD VSS n14371 NAND2X1
XU15023 n14361 g175 VDD VSS n14370 OR2X1
XU15024 n14372 n14373 VDD VSS n7571 NAND2X1
XU15025 n14358 n11835 VDD VSS n14373 NAND2X1
XU15026 n14357 n11839 VDD VSS n14372 NAND2X1
XU15027 g179 VDD VSS n11839 INVX1
XU15028 n14358 VDD VSS n14357 INVX1
XU15029 n11926 n7582 VDD VSS n14358 NOR2X1
XU15030 g6313 VDD VSS n11926 INVX1
XU15031 n14374 n14375 VDD VSS n7570 NAND2X1
XU15032 n14361 g178 VDD VSS n14375 OR2X1
XU15033 n14361 n11835 VDD VSS n14374 NAND2X1
XU15034 n14376 n14377 VDD VSS n11835 AND2X1
XU15035 n14378 n14379 VDD VSS n14377 NOR2X1
XU15036 g109 g105 VDD VSS n14379 NAND2X1
XU15037 g101 g97 VDD VSS n14378 NAND2X1
XU15038 n14380 n14381 VDD VSS n14376 NOR2X1
XU15039 g125 g121 VDD VSS n14381 NAND2X1
XU15040 g117 g113 VDD VSS n14380 NAND2X1
XU15041 n11842 n7582 VDD VSS n14361 NOR2X1
XU15042 n14382 n14383 VDD VSS n7569 NAND2X1
XU15043 n14384 n13154 VDD VSS n14383 NAND2X1
XU15044 g856 VDD VSS n13154 INVX1
XU15045 n14385 n14386 VDD VSS n14382 NAND2X1
XU15046 n14387 n14388 VDD VSS n7568 NAND2X1
XU15047 n14385 g789 VDD VSS n14388 NAND2X1
XU15048 n14384 n13063 VDD VSS n14387 NAND2X1
XU15049 g859 VDD VSS n13063 INVX1
XU15050 n14389 n14390 VDD VSS n7567 NAND2X1
XU15051 n14385 g785 VDD VSS n14390 NAND2X1
XU15052 n14384 n13053 VDD VSS n14389 NAND2X1
XU15053 g862 VDD VSS n13053 INVX1
XU15054 n14391 n14392 VDD VSS n7566 NAND2X1
XU15055 n14385 n12567 VDD VSS n14392 NAND2X1
XU15056 n14384 n12571 VDD VSS n14391 NAND2X1
XU15057 g865 VDD VSS n12571 INVX1
XU15058 n14385 VDD VSS n14384 INVX1
XU15059 n13050 n7582 VDD VSS n14385 NOR2X1
XU15060 g853 VDD VSS n13050 INVX1
XU15061 n14393 n14394 VDD VSS n7565 NAND2X1
XU15062 n14395 g858 VDD VSS n14394 OR2X1
XU15063 n14395 n14386 VDD VSS n14393 NAND2X1
XU15064 n14396 n14397 VDD VSS n7564 NAND2X1
XU15065 n14398 g857 VDD VSS n14397 OR2X1
XU15066 n14398 n14386 VDD VSS n14396 NAND2X1
XU15067 n14399 n14400 VDD VSS n14386 NAND2X1
XU15068 g809 g805 VDD VSS n14400 NOR2X1
XU15069 n13110 n13015 VDD VSS n14399 NOR2X1
XU15070 g813 VDD VSS n13015 INVX1
XU15071 g801 VDD VSS n13110 INVX1
XU15072 n14401 n14402 VDD VSS n7563 NAND2X1
XU15073 n14395 g789 VDD VSS n14402 NAND2X1
XU15074 n14395 g861 VDD VSS n14401 OR2X1
XU15075 n14403 n14404 VDD VSS n7562 NAND2X1
XU15076 n14398 g789 VDD VSS n14404 NAND2X1
XU15077 n14398 g860 VDD VSS n14403 OR2X1
XU15078 n14405 n14406 VDD VSS n7561 NAND2X1
XU15079 n14395 g785 VDD VSS n14406 NAND2X1
XU15080 n14395 g864 VDD VSS n14405 OR2X1
XU15081 n14407 n14408 VDD VSS n7560 NAND2X1
XU15082 n14398 g785 VDD VSS n14408 NAND2X1
XU15083 n14398 g863 VDD VSS n14407 OR2X1
XU15084 n14409 n14410 VDD VSS n7559 NAND2X1
XU15085 n14395 n12567 VDD VSS n14410 NAND2X1
XU15086 n14395 g867 VDD VSS n14409 OR2X1
XU15087 n12574 n7582 VDD VSS n14395 NOR2X1
XU15088 n14411 n14412 VDD VSS n7558 NAND2X1
XU15089 n14398 g866 VDD VSS n14412 OR2X1
XU15090 n14398 n12567 VDD VSS n14411 NAND2X1
XU15091 n14413 n14414 VDD VSS n12567 AND2X1
XU15092 n14415 n14416 VDD VSS n14414 NOR2X1
XU15093 g797 g793 VDD VSS n14416 NAND2X1
XU15094 g789 g785 VDD VSS n14415 NAND2X1
XU15095 n14417 n14418 VDD VSS n14413 NOR2X1
XU15096 g813 g809 VDD VSS n14418 NAND2X1
XU15097 g805 g801 VDD VSS n14417 NAND2X1
XU15098 n12575 n7582 VDD VSS n14398 NOR2X1
XU15099 n14419 n14420 VDD VSS n7557 NAND2X1
XU15100 n14421 g1550 VDD VSS n14420 OR2X1
XU15101 n14421 n14422 VDD VSS n14419 NAND2X1
XU15102 n14423 n14424 VDD VSS n7556 NAND2X1
XU15103 n14421 g1476 VDD VSS n14424 NAND2X1
XU15104 n14421 g1553 VDD VSS n14423 OR2X1
XU15105 n14425 n14426 VDD VSS n7555 NAND2X1
XU15106 n14421 g1471 VDD VSS n14426 NAND2X1
XU15107 n14421 g1556 VDD VSS n14425 OR2X1
XU15108 n14427 n14428 VDD VSS n7554 NAND2X1
XU15109 n14421 n13283 VDD VSS n14428 NAND2X1
XU15110 n14421 g1559 VDD VSS n14427 OR2X1
XU15111 n13291 n7582 VDD VSS n14421 NOR2X1
XU15112 n14429 n14430 VDD VSS n7553 NAND2X1
XU15113 n14431 n13886 VDD VSS n14430 NAND2X1
XU15114 g1552 VDD VSS n13886 INVX1
XU15115 n14432 n14422 VDD VSS n14429 NAND2X1
XU15116 n14433 n14434 VDD VSS n7552 NAND2X1
XU15117 n14435 g1551 VDD VSS n14434 OR2X1
XU15118 n14435 n14422 VDD VSS n14433 NAND2X1
XU15119 n14436 n14437 VDD VSS n14422 NAND2X1
XU15120 g1501 g1496 VDD VSS n14437 NOR2X1
XU15121 n13766 n13842 VDD VSS n14436 NOR2X1
XU15122 g1506 VDD VSS n13842 INVX1
XU15123 g1491 VDD VSS n13766 INVX1
XU15124 n14438 n14439 VDD VSS n7551 NAND2X1
XU15125 n14432 g1476 VDD VSS n14439 NAND2X1
XU15126 n14431 n13797 VDD VSS n14438 NAND2X1
XU15127 g1555 VDD VSS n13797 INVX1
XU15128 n14440 n14441 VDD VSS n7550 NAND2X1
XU15129 n14435 g1476 VDD VSS n14441 NAND2X1
XU15130 n14435 g1554 VDD VSS n14440 OR2X1
XU15131 n14442 n14443 VDD VSS n7549 NAND2X1
XU15132 n14432 g1471 VDD VSS n14443 NAND2X1
XU15133 n14431 n13787 VDD VSS n14442 NAND2X1
XU15134 g1558 VDD VSS n13787 INVX1
XU15135 n14444 n14445 VDD VSS n7548 NAND2X1
XU15136 n14435 g1471 VDD VSS n14445 NAND2X1
XU15137 n14435 g1557 VDD VSS n14444 OR2X1
XU15138 n14446 n14447 VDD VSS n7547 NAND2X1
XU15139 n14432 n13283 VDD VSS n14447 NAND2X1
XU15140 n14431 n13287 VDD VSS n14446 NAND2X1
XU15141 g1561 VDD VSS n13287 INVX1
XU15142 n14432 VDD VSS n14431 INVX1
XU15143 n13374 n7582 VDD VSS n14432 NOR2X1
XU15144 g6782 VDD VSS n13374 INVX1
XU15145 n14448 n14449 VDD VSS n7546 NAND2X1
XU15146 n14435 g1560 VDD VSS n14449 OR2X1
XU15147 n14435 n13283 VDD VSS n14448 NAND2X1
XU15148 n14450 n14451 VDD VSS n13283 AND2X1
XU15149 n14452 n14453 VDD VSS n14451 NOR2X1
XU15150 g1486 g1481 VDD VSS n14453 NAND2X1
XU15151 g1476 g1471 VDD VSS n14452 NAND2X1
XU15152 n14454 n14455 VDD VSS n14450 NOR2X1
XU15153 g1506 g1501 VDD VSS n14455 NAND2X1
XU15154 g1496 g1491 VDD VSS n14454 NAND2X1
XU15155 n13290 n7582 VDD VSS n14435 NOR2X1
XU15156 n14456 n14457 VDD VSS n7545 NAND2X1
XU15157 n14458 g2244 VDD VSS n14457 OR2X1
XU15158 n14458 n14459 VDD VSS n14456 NAND2X1
XU15159 n14460 n14461 VDD VSS n7544 NAND2X1
XU15160 n14458 g2170 VDD VSS n14461 NAND2X1
XU15161 n14458 g2247 VDD VSS n14460 OR2X1
XU15162 n14462 n14463 VDD VSS n7543 NAND2X1
XU15163 n14458 g2165 VDD VSS n14463 NAND2X1
XU15164 n14458 g2250 VDD VSS n14462 OR2X1
XU15165 n14464 n14465 VDD VSS n7542 NAND2X1
XU15166 n14458 n11102 VDD VSS n14465 NAND2X1
XU15167 n14458 g2253 VDD VSS n14464 OR2X1
XU15168 n11110 n7582 VDD VSS n14458 NOR2X1
XU15169 n14466 n14467 VDD VSS n7541 NAND2X1
XU15170 n14468 n11705 VDD VSS n14467 NAND2X1
XU15171 g2246 VDD VSS n11705 INVX1
XU15172 n14469 n14459 VDD VSS n14466 NAND2X1
XU15173 n14470 n14471 VDD VSS n7540 NAND2X1
XU15174 n14472 g2245 VDD VSS n14471 OR2X1
XU15175 n14472 n14459 VDD VSS n14470 NAND2X1
XU15176 n14473 n14474 VDD VSS n14459 NAND2X1
XU15177 g2195 g2190 VDD VSS n14474 NOR2X1
XU15178 n11585 n11661 VDD VSS n14473 NOR2X1
XU15179 g2200 VDD VSS n11661 INVX1
XU15180 g2185 VDD VSS n11585 INVX1
XU15181 n14475 n14476 VDD VSS n7539 NAND2X1
XU15182 n14469 g2170 VDD VSS n14476 NAND2X1
XU15183 n14468 n11616 VDD VSS n14475 NAND2X1
XU15184 g2249 VDD VSS n11616 INVX1
XU15185 n14477 n14478 VDD VSS n7538 NAND2X1
XU15186 n14472 g2170 VDD VSS n14478 NAND2X1
XU15187 n14472 g2248 VDD VSS n14477 OR2X1
XU15188 n14479 n14480 VDD VSS n7537 NAND2X1
XU15189 n14469 g2165 VDD VSS n14480 NAND2X1
XU15190 n14468 n11606 VDD VSS n14479 NAND2X1
XU15191 g2252 VDD VSS n11606 INVX1
XU15192 n14481 n14482 VDD VSS n7536 NAND2X1
XU15193 n14472 g2165 VDD VSS n14482 NAND2X1
XU15194 n14472 g2251 VDD VSS n14481 OR2X1
XU15195 n14483 n14484 VDD VSS n7535 NAND2X1
XU15196 n14469 n11102 VDD VSS n14484 NAND2X1
XU15197 n14468 n11106 VDD VSS n14483 NAND2X1
XU15198 g2255 VDD VSS n11106 INVX1
XU15199 n14469 VDD VSS n14468 INVX1
XU15200 n11193 n7582 VDD VSS n14469 NOR2X1
XU15201 g7084 VDD VSS n11193 INVX1
XU15202 n14485 n14486 VDD VSS n7534 NAND2X1
XU15203 n14472 g2254 VDD VSS n14486 OR2X1
XU15204 n14472 n11102 VDD VSS n14485 NAND2X1
XU15205 n14487 n14488 VDD VSS n11102 AND2X1
XU15206 n14489 n14490 VDD VSS n14488 NOR2X1
XU15207 g2180 g2175 VDD VSS n14490 NAND2X1
XU15208 g2170 g2165 VDD VSS n14489 NAND2X1
XU15209 n14491 n14492 VDD VSS n14487 NOR2X1
XU15210 g2200 g2195 VDD VSS n14492 NAND2X1
XU15211 g2190 g2185 VDD VSS n14491 NAND2X1
XU15212 n11109 n7582 VDD VSS n14472 NOR2X1
XU15213 n14493 n14494 VDD VSS n7582 NAND2X1
XU15214 n14495 n14496 VDD VSS n14494 NOR2X1
XU15215 n14497 n14498 VDD VSS n14496 NAND2X1
XU15216 n14499 n14500 VDD VSS n14495 NAND2X1
XU15217 n14501 n14502 VDD VSS n14493 NOR2X1
XU15218 g2883 n14040 VDD VSS n14502 NAND2X1
XU15219 n14503 VDD VSS n14040 INVX1
XU15220 g2950 n386 VDD VSS n7533 NAND2X1
XU15221 g2817 n386 VDD VSS n7532 NAND2X1
XU15222 n14504 n14505 VDD VSS n7531 NAND2X1
XU15223 n14497 n14506 VDD VSS n14505 XOR2X1
XU15224 n14507 n14504 VDD VSS n7530 NAND2X1
XU15225 n14508 n14509 VDD VSS n14507 NOR2X1
XU15226 g2896 n14510 VDD VSS n14509 NOR2X1
XU15227 n14511 n14504 VDD VSS n7529 NAND2X1
XU15228 n14512 n14513 VDD VSS n14511 NOR2X1
XU15229 g2892 n14508 VDD VSS n14513 NOR2X1
XU15230 n14514 n14504 VDD VSS n7528 NAND2X1
XU15231 n14515 n14516 VDD VSS n14514 NOR2X1
XU15232 g2903 n14512 VDD VSS n14516 NOR2X1
XU15233 n14504 n14517 VDD VSS n7527 NAND2X1
XU15234 g2900 n14515 VDD VSS n14517 XOR2X1
XU15235 n14504 n14518 VDD VSS n7526 NAND2X1
XU15236 g2908 n14519 VDD VSS n14518 XOR2X1
XU15237 g2900 n14515 VDD VSS n14519 AND2X1
XU15238 n14512 g2903 VDD VSS n14515 AND2X1
XU15239 n14508 g2892 VDD VSS n14512 AND2X1
XU15240 n14510 g2896 VDD VSS n14508 AND2X1
XU15241 n14497 n14506 VDD VSS n14510 NOR2X1
XU15242 g2888 VDD VSS n14497 INVX1
XU15243 n14520 VDD VSS n14504 INVX1
XU15244 n14521 n14522 VDD VSS n7525 NAND2X1
XU15245 g2917 n14523 VDD VSS n14521 XOR2X1
XU15246 n14524 n14525 VDD VSS n7524 NAND2X1
XU15247 n14526 n14501 VDD VSS n14525 NAND2X1
XU15248 n14523 g2917 VDD VSS n14526 NAND2X1
XU15249 n14527 n14522 VDD VSS n14524 AND2X1
XU15250 n14528 n14522 VDD VSS n7523 NAND2X1
XU15251 n14500 n14527 VDD VSS n14528 XOR2X1
XU15252 n14529 n14523 VDD VSS n14527 NAND2X1
XU15253 n14501 n14499 VDD VSS n14529 NOR2X1
XU15254 g2917 VDD VSS n14499 INVX1
XU15255 g2924 VDD VSS n14501 INVX1
XU15256 g25566 VDD VSS n75 INVX1
XU15257 g25520 VDD VSS n74 INVX1
XU15258 g51 VDD VSS n386 INVX1
XU15259 g3232 VDD VSS n384 INVX1
XU15260 g3228 VDD VSS n379 INVX1
XU15261 g3227 VDD VSS n378 INVX1
XU15262 g3226 VDD VSS n377 INVX1
XU15263 g3225 VDD VSS n376 INVX1
XU15264 g3224 VDD VSS n375 INVX1
XU15265 g3223 VDD VSS n374 INVX1
XU15266 g3222 VDD VSS n373 INVX1
XU15267 g3221 VDD VSS n372 INVX1
XU15268 g3220 VDD VSS n371 INVX1
XU15269 g3219 VDD VSS n370 INVX1
XU15270 g3218 VDD VSS n369 INVX1
XU15271 g3217 VDD VSS n368 INVX1
XU15272 g3216 VDD VSS n367 INVX1
XU15273 g3215 VDD VSS n366 INVX1
XU15274 g3214 VDD VSS n365 INVX1
XU15275 g3213 VDD VSS n364 INVX1
XU15276 g3212 VDD VSS n363 INVX1
XU15277 g16496 VDD VSS n359 INVX1
XU15278 n8946 VDD VSS n335 INVX1
XU15279 n14530 n14531 VDD VSS n8946 NAND2X1
XU15280 g7390 n8927 VDD VSS n14531 NAND2X1
XU15281 g2660 VDD VSS n8927 INVX1
XU15282 n14532 n14533 VDD VSS n14530 NOR2X1
XU15283 g2659 n8880 VDD VSS n14533 NOR2X1
XU15284 g2658 n8870 VDD VSS n14532 NOR2X1
XU15285 n8957 VDD VSS n334 INVX1
XU15286 n14534 n14535 VDD VSS n8957 NAND2X1
XU15287 g7390 n8924 VDD VSS n14535 NAND2X1
XU15288 g2657 VDD VSS n8924 INVX1
XU15289 n14536 n14537 VDD VSS n14534 NOR2X1
XU15290 g2656 n8880 VDD VSS n14537 NOR2X1
XU15291 g2655 n8870 VDD VSS n14536 NOR2X1
XU15292 n8958 VDD VSS n333 INVX1
XU15293 n14538 n14539 VDD VSS n8958 NAND2X1
XU15294 g7390 n8921 VDD VSS n14539 NAND2X1
XU15295 g2654 VDD VSS n8921 INVX1
XU15296 n14540 n14541 VDD VSS n14538 NOR2X1
XU15297 g2653 n8880 VDD VSS n14541 NOR2X1
XU15298 g2652 n8870 VDD VSS n14540 NOR2X1
XU15299 n8952 VDD VSS n331 INVX1
XU15300 n14542 n14543 VDD VSS n8952 NAND2X1
XU15301 g7390 n8917 VDD VSS n14543 NAND2X1
XU15302 g2651 VDD VSS n8917 INVX1
XU15303 n14544 n14545 VDD VSS n14542 NOR2X1
XU15304 g2650 n8880 VDD VSS n14545 NOR2X1
XU15305 g2649 n8870 VDD VSS n14544 NOR2X1
XU15306 n14169 VDD VSS n325 INVX1
XU15307 n14546 n14547 VDD VSS n14169 NAND2X1
XU15308 g5555 II18737 VDD VSS n14547 NAND2X1
XU15309 n14548 n14549 VDD VSS n14546 NOR2X1
XU15310 g2466 n11047 VDD VSS n14549 NOR2X1
XU15311 g2463 n10188 VDD VSS n14548 NOR2X1
XU15312 n14195 VDD VSS n324 INVX1
XU15313 n14550 n14551 VDD VSS n14195 NAND2X1
XU15314 g5555 II18728 VDD VSS n14551 NAND2X1
XU15315 n14552 n14553 VDD VSS n14550 NOR2X1
XU15316 g2451 n11047 VDD VSS n14553 NOR2X1
XU15317 g2448 n10188 VDD VSS n14552 NOR2X1
XU15318 n14182 VDD VSS n323 INVX1
XU15319 n14554 n14555 VDD VSS n14182 NAND2X1
XU15320 g5555 II18719 VDD VSS n14555 NAND2X1
XU15321 n14556 n14557 VDD VSS n14554 NOR2X1
XU15322 g2436 n11047 VDD VSS n14557 NOR2X1
XU15323 g2433 n10188 VDD VSS n14556 NOR2X1
XU15324 n14175 VDD VSS n322 INVX1
XU15325 n14558 n14559 VDD VSS n14175 NAND2X1
XU15326 g5555 II18710 VDD VSS n14559 NAND2X1
XU15327 n14560 n14561 VDD VSS n14558 NOR2X1
XU15328 g2421 n11047 VDD VSS n14561 NOR2X1
XU15329 g2418 n10188 VDD VSS n14560 NOR2X1
XU15330 n9009 VDD VSS n321 INVX1
XU15331 n14562 n14563 VDD VSS n9009 NAND2X1
XU15332 g2495 g7264 VDD VSS n14563 NAND2X1
XU15333 n14564 n14565 VDD VSS n14562 NOR2X1
XU15334 n11041 n11117 VDD VSS n14565 NOR2X1
XU15335 g2492 VDD VSS n11117 INVX1
XU15336 n11047 n11123 VDD VSS n14564 NOR2X1
XU15337 g2498 VDD VSS n11123 INVX1
XU15338 g2476 VDD VSS n11047 INVX1
XU15339 n9296 VDD VSS n277 INVX1
XU15340 n14566 n14567 VDD VSS n9296 NAND2X1
XU15341 g7194 n9277 VDD VSS n14567 NAND2X1
XU15342 g1966 VDD VSS n9277 INVX1
XU15343 n14568 n14569 VDD VSS n14566 NOR2X1
XU15344 g1965 n9230 VDD VSS n14569 NOR2X1
XU15345 g1964 n9220 VDD VSS n14568 NOR2X1
XU15346 n9307 VDD VSS n276 INVX1
XU15347 n14570 n14571 VDD VSS n9307 NAND2X1
XU15348 g7194 n9274 VDD VSS n14571 NAND2X1
XU15349 g1963 VDD VSS n9274 INVX1
XU15350 n14572 n14573 VDD VSS n14570 NOR2X1
XU15351 g1962 n9230 VDD VSS n14573 NOR2X1
XU15352 g1961 n9220 VDD VSS n14572 NOR2X1
XU15353 n9308 VDD VSS n275 INVX1
XU15354 n14574 n14575 VDD VSS n9308 NAND2X1
XU15355 g7194 n9271 VDD VSS n14575 NAND2X1
XU15356 g1960 VDD VSS n9271 INVX1
XU15357 n14576 n14577 VDD VSS n14574 NOR2X1
XU15358 g1959 n9230 VDD VSS n14577 NOR2X1
XU15359 g1958 n9220 VDD VSS n14576 NOR2X1
XU15360 n9302 VDD VSS n273 INVX1
XU15361 n14578 n14579 VDD VSS n9302 NAND2X1
XU15362 g7194 n9267 VDD VSS n14579 NAND2X1
XU15363 g1957 VDD VSS n9267 INVX1
XU15364 n14580 n14581 VDD VSS n14578 NOR2X1
XU15365 g1956 n9230 VDD VSS n14581 NOR2X1
XU15366 g1955 n9220 VDD VSS n14580 NOR2X1
XU15367 g25490 VDD VSS n27 INVX1
XU15368 n14117 VDD VSS n267 INVX1
XU15369 n14582 n14583 VDD VSS n14117 NAND2X1
XU15370 g5511 II18656 VDD VSS n14583 NAND2X1
XU15371 n14584 n14585 VDD VSS n14582 NOR2X1
XU15372 g1772 n13228 VDD VSS n14585 NOR2X1
XU15373 g1769 n10163 VDD VSS n14584 NOR2X1
XU15374 n14143 VDD VSS n266 INVX1
XU15375 n14586 n14587 VDD VSS n14143 NAND2X1
XU15376 g5511 II18647 VDD VSS n14587 NAND2X1
XU15377 n14588 n14589 VDD VSS n14586 NOR2X1
XU15378 g1757 n13228 VDD VSS n14589 NOR2X1
XU15379 g1754 n10163 VDD VSS n14588 NOR2X1
XU15380 n14130 VDD VSS n265 INVX1
XU15381 n14590 n14591 VDD VSS n14130 NAND2X1
XU15382 g5511 II18638 VDD VSS n14591 NAND2X1
XU15383 n14592 n14593 VDD VSS n14590 NOR2X1
XU15384 g1742 n13228 VDD VSS n14593 NOR2X1
XU15385 g1739 n10163 VDD VSS n14592 NOR2X1
XU15386 n14123 VDD VSS n264 INVX1
XU15387 n14594 n14595 VDD VSS n14123 NAND2X1
XU15388 g5511 II18629 VDD VSS n14595 NAND2X1
XU15389 n14596 n14597 VDD VSS n14594 NOR2X1
XU15390 g1727 n13228 VDD VSS n14597 NOR2X1
XU15391 g1724 n10163 VDD VSS n14596 NOR2X1
XU15392 n9361 VDD VSS n263 INVX1
XU15393 n14598 n14599 VDD VSS n9361 NAND2X1
XU15394 g1801 g7014 VDD VSS n14599 NAND2X1
XU15395 n14600 n14601 VDD VSS n14598 NOR2X1
XU15396 n13222 n13298 VDD VSS n14601 NOR2X1
XU15397 g1798 VDD VSS n13298 INVX1
XU15398 n13228 n13304 VDD VSS n14600 NOR2X1
XU15399 g1804 VDD VSS n13304 INVX1
XU15400 g1782 VDD VSS n13228 INVX1
XU15401 n9648 VDD VSS n219 INVX1
XU15402 n14602 n14603 VDD VSS n9648 NAND2X1
XU15403 g6944 n9629 VDD VSS n14603 NAND2X1
XU15404 g1272 VDD VSS n9629 INVX1
XU15405 n14604 n14605 VDD VSS n14602 NOR2X1
XU15406 g1271 n9582 VDD VSS n14605 NOR2X1
XU15407 g1270 n9572 VDD VSS n14604 NOR2X1
XU15408 n9659 VDD VSS n218 INVX1
XU15409 n14606 n14607 VDD VSS n9659 NAND2X1
XU15410 g6944 n9626 VDD VSS n14607 NAND2X1
XU15411 g1269 VDD VSS n9626 INVX1
XU15412 n14608 n14609 VDD VSS n14606 NOR2X1
XU15413 g1268 n9582 VDD VSS n14609 NOR2X1
XU15414 g1267 n9572 VDD VSS n14608 NOR2X1
XU15415 n9660 VDD VSS n217 INVX1
XU15416 n14610 n14611 VDD VSS n9660 NAND2X1
XU15417 g6944 n9623 VDD VSS n14611 NAND2X1
XU15418 g1266 VDD VSS n9623 INVX1
XU15419 n14612 n14613 VDD VSS n14610 NOR2X1
XU15420 g1265 n9582 VDD VSS n14613 NOR2X1
XU15421 g1264 n9572 VDD VSS n14612 NOR2X1
XU15422 n9654 VDD VSS n215 INVX1
XU15423 n14614 n14615 VDD VSS n9654 NAND2X1
XU15424 g6944 n9619 VDD VSS n14615 NAND2X1
XU15425 g1263 VDD VSS n9619 INVX1
XU15426 n14616 n14617 VDD VSS n14614 NOR2X1
XU15427 g1262 n9582 VDD VSS n14617 NOR2X1
XU15428 g1261 n9572 VDD VSS n14616 NOR2X1
XU15429 n14065 VDD VSS n209 INVX1
XU15430 n14618 n14619 VDD VSS n14065 NAND2X1
XU15431 g5472 II18575 VDD VSS n14619 NAND2X1
XU15432 n14620 n14621 VDD VSS n14618 NOR2X1
XU15433 g1078 n12512 VDD VSS n14621 NOR2X1
XU15434 g1075 n10170 VDD VSS n14620 NOR2X1
XU15435 n14091 VDD VSS n208 INVX1
XU15436 n14622 n14623 VDD VSS n14091 NAND2X1
XU15437 g5472 II18566 VDD VSS n14623 NAND2X1
XU15438 n14624 n14625 VDD VSS n14622 NOR2X1
XU15439 g1063 n12512 VDD VSS n14625 NOR2X1
XU15440 g1060 n10170 VDD VSS n14624 NOR2X1
XU15441 n14078 VDD VSS n207 INVX1
XU15442 n14626 n14627 VDD VSS n14078 NAND2X1
XU15443 g5472 II18557 VDD VSS n14627 NAND2X1
XU15444 n14628 n14629 VDD VSS n14626 NOR2X1
XU15445 g1048 n12512 VDD VSS n14629 NOR2X1
XU15446 g1045 n10170 VDD VSS n14628 NOR2X1
XU15447 n14071 VDD VSS n206 INVX1
XU15448 n14630 n14631 VDD VSS n14071 NAND2X1
XU15449 g5472 II18548 VDD VSS n14631 NAND2X1
XU15450 n14632 n14633 VDD VSS n14630 NOR2X1
XU15451 g1033 n12512 VDD VSS n14633 NOR2X1
XU15452 g1030 n10170 VDD VSS n14632 NOR2X1
XU15453 n9712 VDD VSS n205 INVX1
XU15454 n14634 n14635 VDD VSS n9712 NAND2X1
XU15455 g1107 g6712 VDD VSS n14635 NAND2X1
XU15456 n14636 n14637 VDD VSS n14634 NOR2X1
XU15457 n12506 n12582 VDD VSS n14637 NOR2X1
XU15458 g1104 VDD VSS n12582 INVX1
XU15459 n12512 n12588 VDD VSS n14636 NOR2X1
XU15460 g1110 VDD VSS n12588 INVX1
XU15461 n14638 VDD VSS n162 INVX1
XU15462 n10099 VDD VSS n148 INVX1
XU15463 n14639 n14640 VDD VSS n10099 NAND2X1
XU15464 g6642 n10080 VDD VSS n14640 NAND2X1
XU15465 g586 VDD VSS n10080 INVX1
XU15466 n14641 n14642 VDD VSS n14639 NOR2X1
XU15467 g585 n10033 VDD VSS n14642 NOR2X1
XU15468 g584 n9923 VDD VSS n14641 NOR2X1
XU15469 n10110 VDD VSS n147 INVX1
XU15470 n14643 n14644 VDD VSS n10110 NAND2X1
XU15471 g6642 n10077 VDD VSS n14644 NAND2X1
XU15472 g583 VDD VSS n10077 INVX1
XU15473 n14645 n14646 VDD VSS n14643 NOR2X1
XU15474 g582 n10033 VDD VSS n14646 NOR2X1
XU15475 g581 n9923 VDD VSS n14645 NOR2X1
XU15476 n10111 VDD VSS n146 INVX1
XU15477 n14647 n14648 VDD VSS n10111 NAND2X1
XU15478 g6642 n10074 VDD VSS n14648 NAND2X1
XU15479 g580 VDD VSS n10074 INVX1
XU15480 n14649 n14650 VDD VSS n14647 NOR2X1
XU15481 g579 n10033 VDD VSS n14650 NOR2X1
XU15482 g578 n9923 VDD VSS n14649 NOR2X1
XU15483 n10105 VDD VSS n144 INVX1
XU15484 n14651 n14652 VDD VSS n10105 NAND2X1
XU15485 g6642 n10070 VDD VSS n14652 NAND2X1
XU15486 g577 VDD VSS n10070 INVX1
XU15487 n14653 n14654 VDD VSS n14651 NOR2X1
XU15488 g576 n10033 VDD VSS n14654 NOR2X1
XU15489 g575 n9923 VDD VSS n14653 NOR2X1
XU15490 n10189 VDD VSS n140 INVX1
XU15491 n14655 n14656 VDD VSS n10189 NOR2X1
XU15492 n10159 n14657 VDD VSS n14656 NOR2X1
XU15493 n14658 n14659 VDD VSS n14657 NOR2X1
XU15494 n139 g7014 VDD VSS n14659 AND2X1
XU15495 g7014 g1677 VDD VSS n14658 NOR2X1
XU15496 g1683 g1680 VDD VSS n14655 NOR2X1
XU15497 n14660 n14661 VDD VSS n139 NAND2X1
XU15498 g989 g986 VDD VSS n14661 OR2X1
XU15499 n14662 n14663 VDD VSS n14660 NOR2X1
XU15500 n14664 n14665 VDD VSS n14663 NOR2X1
XU15501 g983 n14666 VDD VSS n14662 NOR2X1
XU15502 n14665 VDD VSS n138 INVX1
XU15503 n14667 n14668 VDD VSS n14665 NAND2X1
XU15504 g296 n10173 VDD VSS n14668 NAND2X1
XU15505 g302 n14669 VDD VSS n14667 NAND2X1
XU15506 n14670 VDD VSS n137 INVX1
XU15507 n10183 VDD VSS n135 INVX1
XU15508 n14671 n14672 VDD VSS n10183 NOR2X1
XU15509 n10159 n14673 VDD VSS n14672 NOR2X1
XU15510 n14674 n14675 VDD VSS n14673 NOR2X1
XU15511 n136 g7014 VDD VSS n14675 AND2X1
XU15512 n14676 n14677 VDD VSS n136 NAND2X1
XU15513 g990 g986 VDD VSS n14677 OR2X1
XU15514 n14678 n14679 VDD VSS n14676 NOR2X1
XU15515 n14664 n14670 VDD VSS n14679 NOR2X1
XU15516 n14680 n14681 VDD VSS n14670 NAND2X1
XU15517 g295 n10173 VDD VSS n14681 NAND2X1
XU15518 g303 n14669 VDD VSS n14680 NAND2X1
XU15519 g982 n14666 VDD VSS n14678 NOR2X1
XU15520 g7014 g1676 VDD VSS n14674 NOR2X1
XU15521 g1684 g1680 VDD VSS n14671 NOR2X1
XU15522 n14682 VDD VSS n134 INVX1
XU15523 n10178 VDD VSS n132 INVX1
XU15524 n14683 n14684 VDD VSS n10178 NOR2X1
XU15525 n10159 n14685 VDD VSS n14684 NOR2X1
XU15526 n14686 n14687 VDD VSS n14685 NOR2X1
XU15527 n133 g7014 VDD VSS n14687 AND2X1
XU15528 n14688 n14689 VDD VSS n133 NAND2X1
XU15529 g991 g986 VDD VSS n14689 OR2X1
XU15530 n14690 n14691 VDD VSS n14688 NOR2X1
XU15531 n14664 n14682 VDD VSS n14691 NOR2X1
XU15532 n14692 n14693 VDD VSS n14682 NAND2X1
XU15533 g294 n10173 VDD VSS n14693 NAND2X1
XU15534 g304 n14669 VDD VSS n14692 NAND2X1
XU15535 g981 n14666 VDD VSS n14690 NOR2X1
XU15536 g7014 g1675 VDD VSS n14686 NOR2X1
XU15537 g1685 g1680 VDD VSS n14683 NOR2X1
XU15538 n14694 VDD VSS n130 INVX1
XU15539 n10150 VDD VSS n128 INVX1
XU15540 n14695 n14696 VDD VSS n10150 NOR2X1
XU15541 n10159 n14697 VDD VSS n14696 NOR2X1
XU15542 n14698 n14699 VDD VSS n14697 NOR2X1
XU15543 n129 g7014 VDD VSS n14699 AND2X1
XU15544 n14700 n14701 VDD VSS n129 NAND2X1
XU15545 g987 g986 VDD VSS n14701 OR2X1
XU15546 n14702 n14703 VDD VSS n14700 NOR2X1
XU15547 n14664 n14694 VDD VSS n14703 NOR2X1
XU15548 n14704 n14705 VDD VSS n14694 NAND2X1
XU15549 g308 n10173 VDD VSS n14705 NAND2X1
XU15550 g300 n14669 VDD VSS n14704 NAND2X1
XU15551 g995 n14666 VDD VSS n14702 NOR2X1
XU15552 g7014 g1689 VDD VSS n14698 NOR2X1
XU15553 g1681 g1680 VDD VSS n14695 NOR2X1
XU15554 n14706 VDD VSS n127 INVX1
XU15555 n10144 VDD VSS n126 INVX1
XU15556 n14707 n14708 VDD VSS n10144 NOR2X1
XU15557 n14709 n10159 VDD VSS n14708 NOR2X1
XU15558 g1680 VDD VSS n10159 INVX1
XU15559 n14710 n14711 VDD VSS n14709 NOR2X1
XU15560 n125 g7014 VDD VSS n14711 AND2X1
XU15561 g7014 g1678 VDD VSS n14710 NOR2X1
XU15562 g1682 g1680 VDD VSS n14707 NOR2X1
XU15563 n14712 n14713 VDD VSS n125 NAND2X1
XU15564 g988 g986 VDD VSS n14713 OR2X1
XU15565 n14714 n14715 VDD VSS n14712 NOR2X1
XU15566 n14706 n14664 VDD VSS n14715 NOR2X1
XU15567 g986 g6712 VDD VSS n14664 NAND2X1
XU15568 n14716 n14717 VDD VSS n14706 NAND2X1
XU15569 g297 n10173 VDD VSS n14717 NAND2X1
XU15570 n14669 g6447 VDD VSS n10173 NOR2X1
XU15571 g301 n14669 VDD VSS n14716 NAND2X1
XU15572 g299 VDD VSS n14669 INVX1
XU15573 g984 n14666 VDD VSS n14714 NOR2X1
XU15574 g986 n10170 VDD VSS n14666 NAND2X1
XU15575 n14012 VDD VSS n122 INVX1
XU15576 n14718 n14719 VDD VSS n14012 NAND2X1
XU15577 g5437 II18494 VDD VSS n14719 NAND2X1
XU15578 n14720 n14721 VDD VSS n14718 NOR2X1
XU15579 g391 n11779 VDD VSS n14721 NOR2X1
XU15580 g388 n11793 VDD VSS n14720 NOR2X1
XU15581 n14038 VDD VSS n121 INVX1
XU15582 n14722 n14723 VDD VSS n14038 NAND2X1
XU15583 g5437 II18485 VDD VSS n14723 NAND2X1
XU15584 n14724 n14725 VDD VSS n14722 NOR2X1
XU15585 g376 n11779 VDD VSS n14725 NOR2X1
XU15586 g373 n11793 VDD VSS n14724 NOR2X1
XU15587 n14025 VDD VSS n120 INVX1
XU15588 n14726 n14727 VDD VSS n14025 NAND2X1
XU15589 g5437 II18476 VDD VSS n14727 NAND2X1
XU15590 n14728 n14729 VDD VSS n14726 NOR2X1
XU15591 g361 n11779 VDD VSS n14729 NOR2X1
XU15592 g358 n11793 VDD VSS n14728 NOR2X1
XU15593 n14018 VDD VSS n119 INVX1
XU15594 n14730 n14731 VDD VSS n14018 NAND2X1
XU15595 g5437 II18467 VDD VSS n14731 NAND2X1
XU15596 n14732 n14733 VDD VSS n14730 NOR2X1
XU15597 g346 n11779 VDD VSS n14733 NOR2X1
XU15598 g343 n11793 VDD VSS n14732 NOR2X1
XU15599 n10216 VDD VSS n118 INVX1
XU15600 n14734 n14735 VDD VSS n10216 NAND2X1
XU15601 g420 g6447 VDD VSS n14735 NAND2X1
XU15602 n14736 n14737 VDD VSS n14734 NOR2X1
XU15603 n11773 n11850 VDD VSS n14737 NOR2X1
XU15604 g417 VDD VSS n11850 INVX1
XU15605 n11779 n11856 VDD VSS n14736 NOR2X1
XU15606 g423 VDD VSS n11856 INVX1
XU15607 g401 VDD VSS n11779 INVX1
XU15608 n14738 n14739 VDD VSS g30970 NOR2X1
XU15609 n14740 n14741 VDD VSS n14739 NAND2X1
XU15610 n14742 n14743 VDD VSS n14741 NAND2X1
XU15611 n14744 n14745 VDD VSS n14743 NOR2X1
XU15612 g2612 n9334 VDD VSS n14745 NOR2X1
XU15613 g3229 g2615 VDD VSS n14744 NOR2X1
XU15614 n14746 n14747 VDD VSS n14742 NOR2X1
XU15615 g2631 n14748 VDD VSS n14740 NAND2X1
XU15616 n14749 n14750 VDD VSS n14748 XOR2X1
XU15617 n14751 n8864 VDD VSS n14738 NOR2X1
XU15618 n14752 n14753 VDD VSS n14751 XOR2X1
XU15619 n14754 n14755 VDD VSS n14753 XOR2X1
XU15620 n14756 n14757 VDD VSS n14755 XOR2X1
XU15621 n14758 n14759 VDD VSS n14754 XOR2X1
XU15622 n14760 n14761 VDD VSS n14752 XOR2X1
XU15623 n14762 n14763 VDD VSS n14761 XOR2X1
XU15624 n14764 n14765 VDD VSS n14760 XOR2X1
XU15625 n14766 n14767 VDD VSS g30961 NOR2X1
XU15626 n14747 n14768 VDD VSS n14767 NOR2X1
XU15627 n14769 n14770 VDD VSS n14768 NAND2X1
XU15628 n14764 n14771 VDD VSS n14770 OR2X1
XU15629 n14772 n14773 VDD VSS n14764 NAND2X1
XU15630 n14774 n14775 VDD VSS n14772 NOR2X1
XU15631 n8826 n14776 VDD VSS n14775 NOR2X1
XU15632 n8970 n14777 VDD VSS n14774 NOR2X1
XU15633 n14778 n8826 VDD VSS n14777 NOR2X1
XU15634 g2608 n14746 VDD VSS n14769 OR2X1
XU15635 n14779 n14780 VDD VSS g30960 NOR2X1
XU15636 n14747 n14781 VDD VSS n14779 NOR2X1
XU15637 n14782 n14783 VDD VSS n14781 NAND2X1
XU15638 n14765 n14784 VDD VSS n14783 NAND2X1
XU15639 n14785 n14773 VDD VSS n14765 AND2X1
XU15640 n14786 n14787 VDD VSS n14785 NOR2X1
XU15641 n8840 n14776 VDD VSS n14787 NOR2X1
XU15642 n8970 n14788 VDD VSS n14786 NOR2X1
XU15643 g2604 n14746 VDD VSS n14782 OR2X1
XU15644 n14766 n14789 VDD VSS g30959 NOR2X1
XU15645 n14747 n14790 VDD VSS n14789 NOR2X1
XU15646 n14791 n14792 VDD VSS n14790 NAND2X1
XU15647 n14763 n14784 VDD VSS n14792 NAND2X1
XU15648 n14793 n14794 VDD VSS n14763 AND2X1
XU15649 n14795 n14796 VDD VSS n14794 NOR2X1
XU15650 n8833 n14797 VDD VSS n14796 NOR2X1
XU15651 n14798 VDD VSS n8833 INVX1
XU15652 n14799 n14798 VDD VSS n14795 NOR2X1
XU15653 g2607 n14746 VDD VSS n14791 OR2X1
XU15654 n14800 VDD VSS n14766 INVX1
XU15655 n14801 n14802 VDD VSS g30958 NOR2X1
XU15656 n14750 n14803 VDD VSS n14802 NOR2X1
XU15657 n14804 n14773 VDD VSS n14750 AND2X1
XU15658 n14805 n14806 VDD VSS n14804 NOR2X1
XU15659 n8843 n14776 VDD VSS n14806 NOR2X1
XU15660 n14807 n8970 VDD VSS n14805 NOR2X1
XU15661 n8843 n14778 VDD VSS n14807 NOR2X1
XU15662 n14747 n14808 VDD VSS n14801 NOR2X1
XU15663 n14809 n14810 VDD VSS n14808 NAND2X1
XU15664 n14762 n14784 VDD VSS n14810 NAND2X1
XU15665 n14811 n14773 VDD VSS n14762 AND2X1
XU15666 n14812 n14813 VDD VSS n14811 NOR2X1
XU15667 n14814 n14776 VDD VSS n14813 NOR2X1
XU15668 n8834 VDD VSS n14814 INVX1
XU15669 n8970 n8834 VDD VSS n14812 NOR2X1
XU15670 g2611 n14746 VDD VSS n14809 OR2X1
XU15671 n14815 n14816 VDD VSS g30957 NOR2X1
XU15672 n14749 n14803 VDD VSS n14816 NOR2X1
XU15673 n14793 n14817 VDD VSS n14749 AND2X1
XU15674 n14818 n14819 VDD VSS n14817 NOR2X1
XU15675 n14820 n14797 VDD VSS n14819 NOR2X1
XU15676 n8846 VDD VSS n14820 INVX1
XU15677 n14799 n8846 VDD VSS n14818 NOR2X1
XU15678 n14747 n14821 VDD VSS n14815 NOR2X1
XU15679 n14822 n14823 VDD VSS n14821 NAND2X1
XU15680 n14757 n14784 VDD VSS n14823 NAND2X1
XU15681 n14793 n14824 VDD VSS n14757 AND2X1
XU15682 n14825 n14826 VDD VSS n14824 NOR2X1
XU15683 n8827 n14797 VDD VSS n14826 NOR2X1
XU15684 n14827 VDD VSS n8827 INVX1
XU15685 n14799 n14827 VDD VSS n14825 NOR2X1
XU15686 n14828 n14829 VDD VSS n14793 NOR2X1
XU15687 n14773 VDD VSS n14829 INVX1
XU15688 n14830 n14799 VDD VSS n14828 NOR2X1
XU15689 g2610 n14746 VDD VSS n14822 OR2X1
XU15690 n14831 n14832 VDD VSS g30956 NOR2X1
XU15691 n14747 n14833 VDD VSS n14832 NOR2X1
XU15692 n14834 n14835 VDD VSS n14833 NAND2X1
XU15693 n14756 n14784 VDD VSS n14835 NAND2X1
XU15694 n14836 n14773 VDD VSS n14756 AND2X1
XU15695 n14837 n14838 VDD VSS n14836 NOR2X1
XU15696 n8830 n14776 VDD VSS n14838 NOR2X1
XU15697 n8970 n14830 VDD VSS n14776 NAND2X1
XU15698 n8970 n14839 VDD VSS n14837 NOR2X1
XU15699 n8936 VDD VSS n8970 INVX1
XU15700 n14840 n14841 VDD VSS n8936 NAND2X1
XU15701 g2691 g7390 VDD VSS n14841 NAND2X1
XU15702 n14842 n14843 VDD VSS n14840 NOR2X1
XU15703 n8880 n10752 VDD VSS n14843 NOR2X1
XU15704 g2688 VDD VSS n10752 INVX1
XU15705 n8870 n10758 VDD VSS n14842 NOR2X1
XU15706 g2694 VDD VSS n10758 INVX1
XU15707 g2606 n14746 VDD VSS n14834 OR2X1
XU15708 n14831 n14844 VDD VSS g30955 NOR2X1
XU15709 n14747 n14845 VDD VSS n14844 NOR2X1
XU15710 n14846 n14847 VDD VSS n14845 NAND2X1
XU15711 n14759 n14784 VDD VSS n14847 NAND2X1
XU15712 n14848 n14773 VDD VSS n14759 AND2X1
XU15713 n14849 n14850 VDD VSS n14848 NOR2X1
XU15714 n8839 n14797 VDD VSS n14850 NOR2X1
XU15715 n14851 VDD VSS n8839 INVX1
XU15716 n14799 n14851 VDD VSS n14849 NOR2X1
XU15717 g2603 n14746 VDD VSS n14846 OR2X1
XU15718 n14852 n14853 VDD VSS n14831 AND2X1
XU15719 n14773 n14854 VDD VSS n14853 NAND2X1
XU15720 n14855 n14780 VDD VSS g30954 NOR2X1
XU15721 n14800 n14856 VDD VSS n14780 NAND2X1
XU15722 n14857 n14852 VDD VSS n14856 NAND2X1
XU15723 g2574 n14854 VDD VSS n14857 AND2X1
XU15724 n14858 n14859 VDD VSS n14854 NAND2X1
XU15725 n14778 n14860 VDD VSS n14859 NOR2X1
XU15726 g2808 n8730 VDD VSS n14860 NOR2X1
XU15727 n14830 VDD VSS n14778 INVX1
XU15728 n14861 n14862 VDD VSS n14858 NOR2X1
XU15729 g2810 n8852 VDD VSS n14862 NOR2X1
XU15730 g7487 VDD VSS n8852 INVX1
XU15731 g2809 n8849 VDD VSS n14861 NOR2X1
XU15732 n14852 n14863 VDD VSS n14800 NAND2X1
XU15733 n14803 VDD VSS n14852 INVX1
XU15734 n14771 n14747 VDD VSS n14803 NAND2X1
XU15735 n14784 VDD VSS n14771 INVX1
XU15736 n14747 n14864 VDD VSS n14855 NOR2X1
XU15737 n14865 n14866 VDD VSS n14864 NAND2X1
XU15738 g2605 n14746 VDD VSS n14866 OR2X1
XU15739 n14784 n14863 VDD VSS n14746 OR2X1
XU15740 n14758 n14784 VDD VSS n14865 NAND2X1
XU15741 n14867 n8864 VDD VSS n14784 NAND2X1
XU15742 n8871 n8861 VDD VSS n14867 NAND2X1
XU15743 n14868 n14773 VDD VSS n14758 AND2X1
XU15744 n14863 II15517 VDD VSS n14773 NOR2X1
XU15745 n14869 n8174 VDD VSS n14863 NAND2X1
XU15746 n14870 n14871 VDD VSS n8174 OR2X1
XU15747 g2574 n14872 VDD VSS n14871 NOR2X1
XU15748 n14873 n14874 VDD VSS n14872 NOR2X1
XU15749 n8880 n14875 VDD VSS n14874 NOR2X1
XU15750 g7302 g2622 VDD VSS n14873 NOR2X1
XU15751 g2618 II15517 VDD VSS n14870 NOR2X1
XU15752 g2637 g2633 VDD VSS n14869 NOR2X1
XU15753 n14876 n14877 VDD VSS n14868 NOR2X1
XU15754 n8847 n14797 VDD VSS n14877 NOR2X1
XU15755 n14799 n14830 VDD VSS n14797 NAND2X1
XU15756 n14878 n14879 VDD VSS n14830 NAND2X1
XU15757 n14880 n14881 VDD VSS n14879 NOR2X1
XU15758 n14882 n8846 VDD VSS n14881 NAND2X1
XU15759 n14883 n14884 VDD VSS n8846 NAND2X1
XU15760 g7487 n8771 VDD VSS n14884 NAND2X1
XU15761 g2801 VDD VSS n8771 INVX1
XU15762 n14885 n14886 VDD VSS n14883 NOR2X1
XU15763 g2800 n8849 VDD VSS n14886 NOR2X1
XU15764 g2799 n8730 VDD VSS n14885 NOR2X1
XU15765 n8826 n8843 VDD VSS n14882 NOR2X1
XU15766 n14887 n14888 VDD VSS n8843 AND2X1
XU15767 g7487 n8857 VDD VSS n14888 NAND2X1
XU15768 g2798 VDD VSS n8857 INVX1
XU15769 n14889 n14890 VDD VSS n14887 NOR2X1
XU15770 g2797 n8849 VDD VSS n14890 NOR2X1
XU15771 g2796 n8730 VDD VSS n14889 NOR2X1
XU15772 n14891 n14892 VDD VSS n8826 AND2X1
XU15773 g7487 n8784 VDD VSS n14892 NAND2X1
XU15774 g2780 VDD VSS n8784 INVX1
XU15775 n14893 n14894 VDD VSS n14891 NOR2X1
XU15776 g2779 n8849 VDD VSS n14894 NOR2X1
XU15777 g2778 n8730 VDD VSS n14893 NOR2X1
XU15778 n14895 n14827 VDD VSS n14880 NAND2X1
XU15779 n14896 n14897 VDD VSS n14827 NAND2X1
XU15780 g7487 n8777 VDD VSS n14897 NAND2X1
XU15781 g2777 VDD VSS n8777 INVX1
XU15782 n14898 n14899 VDD VSS n14896 NOR2X1
XU15783 g2776 n8849 VDD VSS n14899 NOR2X1
XU15784 g2775 n8730 VDD VSS n14898 NOR2X1
XU15785 n8851 n14798 VDD VSS n14895 AND2X1
XU15786 n14900 n14901 VDD VSS n14798 NAND2X1
XU15787 g7487 n8789 VDD VSS n14901 NAND2X1
XU15788 g2783 VDD VSS n8789 INVX1
XU15789 n14902 n14903 VDD VSS n14900 NOR2X1
XU15790 g2782 n8849 VDD VSS n14903 NOR2X1
XU15791 g2781 n8730 VDD VSS n14902 NOR2X1
XU15792 n14904 n14905 VDD VSS n8851 NAND2X1
XU15793 g7487 n8897 VDD VSS n14905 NAND2X1
XU15794 g2807 VDD VSS n8897 INVX1
XU15795 n14906 n14907 VDD VSS n14904 NOR2X1
XU15796 g2806 n8849 VDD VSS n14907 NOR2X1
XU15797 g2805 n8730 VDD VSS n14906 NOR2X1
XU15798 n14908 n14909 VDD VSS n14878 NOR2X1
XU15799 n14910 n8840 VDD VSS n14909 NAND2X1
XU15800 n14788 VDD VSS n8840 INVX1
XU15801 n14911 n14912 VDD VSS n14788 NAND2X1
XU15802 g7487 n8804 VDD VSS n14912 NAND2X1
XU15803 g2792 VDD VSS n8804 INVX1
XU15804 n14913 n14914 VDD VSS n14911 NOR2X1
XU15805 g2791 n8849 VDD VSS n14914 NOR2X1
XU15806 g2790 n8730 VDD VSS n14913 NOR2X1
XU15807 n14915 n14851 VDD VSS n14910 NOR2X1
XU15808 n14916 n14917 VDD VSS n14851 NAND2X1
XU15809 g7487 n8811 VDD VSS n14917 NAND2X1
XU15810 g2795 VDD VSS n8811 INVX1
XU15811 n14918 n14919 VDD VSS n14916 NOR2X1
XU15812 g2794 n8849 VDD VSS n14919 NOR2X1
XU15813 g2793 n8730 VDD VSS n14918 NOR2X1
XU15814 n14920 n8830 VDD VSS n14908 NAND2X1
XU15815 n14839 VDD VSS n8830 INVX1
XU15816 n14921 n14922 VDD VSS n14839 NAND2X1
XU15817 g7487 n8794 VDD VSS n14922 NAND2X1
XU15818 g2786 VDD VSS n8794 INVX1
XU15819 n14923 n14924 VDD VSS n14921 NOR2X1
XU15820 g2785 n8849 VDD VSS n14924 NOR2X1
XU15821 g2784 n8730 VDD VSS n14923 NOR2X1
XU15822 n14925 n8834 VDD VSS n14920 NOR2X1
XU15823 n14926 n14927 VDD VSS n8834 NAND2X1
XU15824 g7487 n8768 VDD VSS n14927 NAND2X1
XU15825 g2774 VDD VSS n8768 INVX1
XU15826 n14928 n14929 VDD VSS n14926 NOR2X1
XU15827 g2773 n8849 VDD VSS n14929 NOR2X1
XU15828 g2772 n8730 VDD VSS n14928 NOR2X1
XU15829 n14930 n14931 VDD VSS n14925 NOR2X1
XU15830 n14932 n14933 VDD VSS n14931 NAND2X1
XU15831 g7425 n8740 VDD VSS n14933 NAND2X1
XU15832 g2812 VDD VSS n8740 INVX1
XU15833 g7487 n8736 VDD VSS n14932 NAND2X1
XU15834 g2813 VDD VSS n8736 INVX1
XU15835 g2811 n8730 VDD VSS n14930 NOR2X1
XU15836 n14915 VDD VSS n8847 INVX1
XU15837 n14799 n14915 VDD VSS n14876 NOR2X1
XU15838 n14934 n14935 VDD VSS n14915 NAND2X1
XU15839 g7487 n8799 VDD VSS n14935 NAND2X1
XU15840 g2789 VDD VSS n8799 INVX1
XU15841 n14936 n14937 VDD VSS n14934 NOR2X1
XU15842 g2788 n8849 VDD VSS n14937 NOR2X1
XU15843 g7425 VDD VSS n8849 INVX1
XU15844 g2787 n8730 VDD VSS n14936 NOR2X1
XU15845 g2703 VDD VSS n8730 INVX1
XU15846 n8894 VDD VSS n14799 INVX1
XU15847 n14938 n14939 VDD VSS n8894 NAND2X1
XU15848 g2682 g7390 VDD VSS n14939 NAND2X1
XU15849 n14940 n14941 VDD VSS n14938 NOR2X1
XU15850 n8880 n10735 VDD VSS n14941 NOR2X1
XU15851 g2679 VDD VSS n10735 INVX1
XU15852 g7302 VDD VSS n8880 INVX1
XU15853 n8870 n10741 VDD VSS n14940 NOR2X1
XU15854 g2685 VDD VSS n10741 INVX1
XU15855 g2624 VDD VSS n8870 INVX1
XU15856 n14942 n8871 VDD VSS n14747 NAND2X1
XU15857 g2631 VDD VSS n8871 INVX1
XU15858 n8861 n8864 VDD VSS n14942 NAND2X1
XU15859 g2584 VDD VSS n8864 INVX1
XU15860 g2599 VDD VSS n8861 INVX1
XU15861 n14943 n14944 VDD VSS g30685 NOR2X1
XU15862 n14945 n14946 VDD VSS n14944 NAND2X1
XU15863 n14947 n14948 VDD VSS n14946 NAND2X1
XU15864 n14949 n14950 VDD VSS n14948 NOR2X1
XU15865 g1918 n9334 VDD VSS n14950 NOR2X1
XU15866 g3229 g1921 VDD VSS n14949 NOR2X1
XU15867 n14951 n14952 VDD VSS n14947 NOR2X1
XU15868 g1937 n14953 VDD VSS n14945 NAND2X1
XU15869 n14954 n14955 VDD VSS n14953 XOR2X1
XU15870 n14956 n9215 VDD VSS n14943 NOR2X1
XU15871 n14957 n14958 VDD VSS n14956 XOR2X1
XU15872 n14959 n14960 VDD VSS n14958 XOR2X1
XU15873 n14961 n14962 VDD VSS n14960 XOR2X1
XU15874 n14963 n14964 VDD VSS n14959 XOR2X1
XU15875 n14965 n14966 VDD VSS n14957 XOR2X1
XU15876 n14967 n14968 VDD VSS n14966 XOR2X1
XU15877 n14969 n14970 VDD VSS n14965 XOR2X1
XU15878 n14971 n14972 VDD VSS g30406 NOR2X1
XU15879 n14952 n14973 VDD VSS n14972 NOR2X1
XU15880 n14974 n14975 VDD VSS n14973 NAND2X1
XU15881 n14969 n14976 VDD VSS n14975 OR2X1
XU15882 n14977 n14978 VDD VSS n14969 NAND2X1
XU15883 n14979 n14980 VDD VSS n14977 NOR2X1
XU15884 n9177 n14981 VDD VSS n14980 NOR2X1
XU15885 n9320 n14982 VDD VSS n14979 NOR2X1
XU15886 n14983 n9177 VDD VSS n14982 NOR2X1
XU15887 g1914 n14951 VDD VSS n14974 OR2X1
XU15888 n14984 n14985 VDD VSS g30405 NOR2X1
XU15889 n14952 n14986 VDD VSS n14984 NOR2X1
XU15890 n14987 n14988 VDD VSS n14986 NAND2X1
XU15891 n14970 n14989 VDD VSS n14988 NAND2X1
XU15892 n14990 n14978 VDD VSS n14970 AND2X1
XU15893 n14991 n14992 VDD VSS n14990 NOR2X1
XU15894 n9191 n14981 VDD VSS n14992 NOR2X1
XU15895 n9320 n14993 VDD VSS n14991 NOR2X1
XU15896 g1910 n14951 VDD VSS n14987 OR2X1
XU15897 n14971 n14994 VDD VSS g30404 NOR2X1
XU15898 n14952 n14995 VDD VSS n14994 NOR2X1
XU15899 n14996 n14997 VDD VSS n14995 NAND2X1
XU15900 n14968 n14989 VDD VSS n14997 NAND2X1
XU15901 n14998 n14999 VDD VSS n14968 AND2X1
XU15902 n15000 n15001 VDD VSS n14999 NOR2X1
XU15903 n9184 n15002 VDD VSS n15001 NOR2X1
XU15904 n15003 VDD VSS n9184 INVX1
XU15905 n15004 n15003 VDD VSS n15000 NOR2X1
XU15906 g1913 n14951 VDD VSS n14996 OR2X1
XU15907 n15005 VDD VSS n14971 INVX1
XU15908 n15006 n15007 VDD VSS g30403 NOR2X1
XU15909 n14955 n15008 VDD VSS n15007 NOR2X1
XU15910 n15009 n14978 VDD VSS n14955 AND2X1
XU15911 n15010 n15011 VDD VSS n15009 NOR2X1
XU15912 n9194 n14981 VDD VSS n15011 NOR2X1
XU15913 n15012 n9320 VDD VSS n15010 NOR2X1
XU15914 n9194 n14983 VDD VSS n15012 NOR2X1
XU15915 n14952 n15013 VDD VSS n15006 NOR2X1
XU15916 n15014 n15015 VDD VSS n15013 NAND2X1
XU15917 n14967 n14989 VDD VSS n15015 NAND2X1
XU15918 n15016 n14978 VDD VSS n14967 AND2X1
XU15919 n15017 n15018 VDD VSS n15016 NOR2X1
XU15920 n15019 n14981 VDD VSS n15018 NOR2X1
XU15921 n9185 VDD VSS n15019 INVX1
XU15922 n9320 n9185 VDD VSS n15017 NOR2X1
XU15923 g1917 n14951 VDD VSS n15014 OR2X1
XU15924 n15020 n15021 VDD VSS g30402 NOR2X1
XU15925 n14954 n15008 VDD VSS n15021 NOR2X1
XU15926 n14998 n15022 VDD VSS n14954 AND2X1
XU15927 n15023 n15024 VDD VSS n15022 NOR2X1
XU15928 n15025 n15002 VDD VSS n15024 NOR2X1
XU15929 n9197 VDD VSS n15025 INVX1
XU15930 n15004 n9197 VDD VSS n15023 NOR2X1
XU15931 n14952 n15026 VDD VSS n15020 NOR2X1
XU15932 n15027 n15028 VDD VSS n15026 NAND2X1
XU15933 n14962 n14989 VDD VSS n15028 NAND2X1
XU15934 n14998 n15029 VDD VSS n14962 AND2X1
XU15935 n15030 n15031 VDD VSS n15029 NOR2X1
XU15936 n9178 n15002 VDD VSS n15031 NOR2X1
XU15937 n15032 VDD VSS n9178 INVX1
XU15938 n15004 n15032 VDD VSS n15030 NOR2X1
XU15939 n15033 n15034 VDD VSS n14998 NOR2X1
XU15940 n14978 VDD VSS n15034 INVX1
XU15941 n15035 n15004 VDD VSS n15033 NOR2X1
XU15942 g1916 n14951 VDD VSS n15027 OR2X1
XU15943 n15036 n15037 VDD VSS g30401 NOR2X1
XU15944 n14952 n15038 VDD VSS n15037 NOR2X1
XU15945 n15039 n15040 VDD VSS n15038 NAND2X1
XU15946 n14961 n14989 VDD VSS n15040 NAND2X1
XU15947 n15041 n14978 VDD VSS n14961 AND2X1
XU15948 n15042 n15043 VDD VSS n15041 NOR2X1
XU15949 n9181 n14981 VDD VSS n15043 NOR2X1
XU15950 n9320 n15035 VDD VSS n14981 NAND2X1
XU15951 n9320 n15044 VDD VSS n15042 NOR2X1
XU15952 n9286 VDD VSS n9320 INVX1
XU15953 n15045 n15046 VDD VSS n9286 NAND2X1
XU15954 g1997 g7194 VDD VSS n15046 NAND2X1
XU15955 n15047 n15048 VDD VSS n15045 NOR2X1
XU15956 n9230 n10610 VDD VSS n15048 NOR2X1
XU15957 g1994 VDD VSS n10610 INVX1
XU15958 n9220 n10616 VDD VSS n15047 NOR2X1
XU15959 g2000 VDD VSS n10616 INVX1
XU15960 g1912 n14951 VDD VSS n15039 OR2X1
XU15961 n15036 n15049 VDD VSS g30400 NOR2X1
XU15962 n14952 n15050 VDD VSS n15049 NOR2X1
XU15963 n15051 n15052 VDD VSS n15050 NAND2X1
XU15964 n14964 n14989 VDD VSS n15052 NAND2X1
XU15965 n15053 n14978 VDD VSS n14964 AND2X1
XU15966 n15054 n15055 VDD VSS n15053 NOR2X1
XU15967 n9190 n15002 VDD VSS n15055 NOR2X1
XU15968 n15056 VDD VSS n9190 INVX1
XU15969 n15004 n15056 VDD VSS n15054 NOR2X1
XU15970 g1909 n14951 VDD VSS n15051 OR2X1
XU15971 n15057 n15058 VDD VSS n15036 AND2X1
XU15972 n14978 n15059 VDD VSS n15058 NAND2X1
XU15973 n15060 n14985 VDD VSS g30399 NOR2X1
XU15974 n15005 n15061 VDD VSS n14985 NAND2X1
XU15975 n15062 n15057 VDD VSS n15061 NAND2X1
XU15976 g1880 n15059 VDD VSS n15062 AND2X1
XU15977 n15063 n15064 VDD VSS n15059 NAND2X1
XU15978 n14983 n15065 VDD VSS n15064 NOR2X1
XU15979 g2114 n9081 VDD VSS n15065 NOR2X1
XU15980 n15035 VDD VSS n14983 INVX1
XU15981 n15066 n15067 VDD VSS n15063 NOR2X1
XU15982 g2116 n9203 VDD VSS n15067 NOR2X1
XU15983 g7357 VDD VSS n9203 INVX1
XU15984 g2115 n9200 VDD VSS n15066 NOR2X1
XU15985 n15057 n15068 VDD VSS n15005 NAND2X1
XU15986 n15008 VDD VSS n15057 INVX1
XU15987 n14976 n14952 VDD VSS n15008 NAND2X1
XU15988 n14989 VDD VSS n14976 INVX1
XU15989 n14952 n15069 VDD VSS n15060 NOR2X1
XU15990 n15070 n15071 VDD VSS n15069 NAND2X1
XU15991 g1911 n14951 VDD VSS n15071 OR2X1
XU15992 n14989 n15068 VDD VSS n14951 OR2X1
XU15993 n14963 n14989 VDD VSS n15070 NAND2X1
XU15994 n15072 n9215 VDD VSS n14989 NAND2X1
XU15995 n9221 n9212 VDD VSS n15072 NAND2X1
XU15996 n15073 n14978 VDD VSS n14963 AND2X1
XU15997 n15068 II15511 VDD VSS n14978 NOR2X1
XU15998 n15074 n8175 VDD VSS n15068 NAND2X1
XU15999 n14875 VDD VSS n8175 INVX1
XU16000 n15075 n15076 VDD VSS n14875 NOR2X1
XU16001 g1880 n15077 VDD VSS n15076 NOR2X1
XU16002 n15078 n15079 VDD VSS n15077 NOR2X1
XU16003 n9230 n15080 VDD VSS n15079 NOR2X1
XU16004 g7052 g1928 VDD VSS n15078 NOR2X1
XU16005 g1924 II15511 VDD VSS n15075 NOR2X1
XU16006 g1943 g1939 VDD VSS n15074 NOR2X1
XU16007 n15081 n15082 VDD VSS n15073 NOR2X1
XU16008 n9198 n15002 VDD VSS n15082 NOR2X1
XU16009 n15004 n15035 VDD VSS n15002 NAND2X1
XU16010 n15083 n15084 VDD VSS n15035 NAND2X1
XU16011 n15085 n15086 VDD VSS n15084 NOR2X1
XU16012 n15087 n9197 VDD VSS n15086 NAND2X1
XU16013 n15088 n15089 VDD VSS n9197 NAND2X1
XU16014 g7357 n9122 VDD VSS n15089 NAND2X1
XU16015 g2107 VDD VSS n9122 INVX1
XU16016 n15090 n15091 VDD VSS n15088 NOR2X1
XU16017 g2106 n9200 VDD VSS n15091 NOR2X1
XU16018 g2105 n9081 VDD VSS n15090 NOR2X1
XU16019 n9177 n9194 VDD VSS n15087 NOR2X1
XU16020 n15092 n15093 VDD VSS n9194 AND2X1
XU16021 g7357 n9208 VDD VSS n15093 NAND2X1
XU16022 g2104 VDD VSS n9208 INVX1
XU16023 n15094 n15095 VDD VSS n15092 NOR2X1
XU16024 g2103 n9200 VDD VSS n15095 NOR2X1
XU16025 g2102 n9081 VDD VSS n15094 NOR2X1
XU16026 n15096 n15097 VDD VSS n9177 AND2X1
XU16027 g7357 n9135 VDD VSS n15097 NAND2X1
XU16028 g2086 VDD VSS n9135 INVX1
XU16029 n15098 n15099 VDD VSS n15096 NOR2X1
XU16030 g2085 n9200 VDD VSS n15099 NOR2X1
XU16031 g2084 n9081 VDD VSS n15098 NOR2X1
XU16032 n15100 n15032 VDD VSS n15085 NAND2X1
XU16033 n15101 n15102 VDD VSS n15032 NAND2X1
XU16034 g7357 n9128 VDD VSS n15102 NAND2X1
XU16035 g2083 VDD VSS n9128 INVX1
XU16036 n15103 n15104 VDD VSS n15101 NOR2X1
XU16037 g2082 n9200 VDD VSS n15104 NOR2X1
XU16038 g2081 n9081 VDD VSS n15103 NOR2X1
XU16039 n9202 n15003 VDD VSS n15100 AND2X1
XU16040 n15105 n15106 VDD VSS n15003 NAND2X1
XU16041 g7357 n9140 VDD VSS n15106 NAND2X1
XU16042 g2089 VDD VSS n9140 INVX1
XU16043 n15107 n15108 VDD VSS n15105 NOR2X1
XU16044 g2088 n9200 VDD VSS n15108 NOR2X1
XU16045 g2087 n9081 VDD VSS n15107 NOR2X1
XU16046 n15109 n15110 VDD VSS n9202 NAND2X1
XU16047 g7357 n9247 VDD VSS n15110 NAND2X1
XU16048 g2113 VDD VSS n9247 INVX1
XU16049 n15111 n15112 VDD VSS n15109 NOR2X1
XU16050 g2112 n9200 VDD VSS n15112 NOR2X1
XU16051 g2111 n9081 VDD VSS n15111 NOR2X1
XU16052 n15113 n15114 VDD VSS n15083 NOR2X1
XU16053 n15115 n9191 VDD VSS n15114 NAND2X1
XU16054 n14993 VDD VSS n9191 INVX1
XU16055 n15116 n15117 VDD VSS n14993 NAND2X1
XU16056 g7357 n9155 VDD VSS n15117 NAND2X1
XU16057 g2098 VDD VSS n9155 INVX1
XU16058 n15118 n15119 VDD VSS n15116 NOR2X1
XU16059 g2097 n9200 VDD VSS n15119 NOR2X1
XU16060 g2096 n9081 VDD VSS n15118 NOR2X1
XU16061 n15120 n15056 VDD VSS n15115 NOR2X1
XU16062 n15121 n15122 VDD VSS n15056 NAND2X1
XU16063 g7357 n9162 VDD VSS n15122 NAND2X1
XU16064 g2101 VDD VSS n9162 INVX1
XU16065 n15123 n15124 VDD VSS n15121 NOR2X1
XU16066 g2100 n9200 VDD VSS n15124 NOR2X1
XU16067 g2099 n9081 VDD VSS n15123 NOR2X1
XU16068 n15125 n9181 VDD VSS n15113 NAND2X1
XU16069 n15044 VDD VSS n9181 INVX1
XU16070 n15126 n15127 VDD VSS n15044 NAND2X1
XU16071 g7357 n9145 VDD VSS n15127 NAND2X1
XU16072 g2092 VDD VSS n9145 INVX1
XU16073 n15128 n15129 VDD VSS n15126 NOR2X1
XU16074 g2091 n9200 VDD VSS n15129 NOR2X1
XU16075 g2090 n9081 VDD VSS n15128 NOR2X1
XU16076 n15130 n9185 VDD VSS n15125 NOR2X1
XU16077 n15131 n15132 VDD VSS n9185 NAND2X1
XU16078 g7357 n9119 VDD VSS n15132 NAND2X1
XU16079 g2080 VDD VSS n9119 INVX1
XU16080 n15133 n15134 VDD VSS n15131 NOR2X1
XU16081 g2079 n9200 VDD VSS n15134 NOR2X1
XU16082 g2078 n9081 VDD VSS n15133 NOR2X1
XU16083 n15135 n15136 VDD VSS n15130 NOR2X1
XU16084 n15137 n15138 VDD VSS n15136 NAND2X1
XU16085 g7229 n9091 VDD VSS n15138 NAND2X1
XU16086 g2118 VDD VSS n9091 INVX1
XU16087 g7357 n9087 VDD VSS n15137 NAND2X1
XU16088 g2119 VDD VSS n9087 INVX1
XU16089 g2117 n9081 VDD VSS n15135 NOR2X1
XU16090 n15120 VDD VSS n9198 INVX1
XU16091 n15004 n15120 VDD VSS n15081 NOR2X1
XU16092 n15139 n15140 VDD VSS n15120 NAND2X1
XU16093 g7357 n9150 VDD VSS n15140 NAND2X1
XU16094 g2095 VDD VSS n9150 INVX1
XU16095 n15141 n15142 VDD VSS n15139 NOR2X1
XU16096 g2094 n9200 VDD VSS n15142 NOR2X1
XU16097 g7229 VDD VSS n9200 INVX1
XU16098 g2093 n9081 VDD VSS n15141 NOR2X1
XU16099 g2009 VDD VSS n9081 INVX1
XU16100 n9244 VDD VSS n15004 INVX1
XU16101 n15143 n15144 VDD VSS n9244 NAND2X1
XU16102 g1988 g7194 VDD VSS n15144 NAND2X1
XU16103 n15145 n15146 VDD VSS n15143 NOR2X1
XU16104 n9230 n10593 VDD VSS n15146 NOR2X1
XU16105 g1985 VDD VSS n10593 INVX1
XU16106 g7052 VDD VSS n9230 INVX1
XU16107 n9220 n10599 VDD VSS n15145 NOR2X1
XU16108 g1991 VDD VSS n10599 INVX1
XU16109 g1930 VDD VSS n9220 INVX1
XU16110 n15147 n9221 VDD VSS n14952 NAND2X1
XU16111 g1937 VDD VSS n9221 INVX1
XU16112 n9212 n9215 VDD VSS n15147 NAND2X1
XU16113 g1890 VDD VSS n9215 INVX1
XU16114 g1905 VDD VSS n9212 INVX1
XU16115 n15148 n15149 VDD VSS g29761 NOR2X1
XU16116 n15150 n15151 VDD VSS n15149 NAND2X1
XU16117 n15152 n15153 VDD VSS n15151 NAND2X1
XU16118 n15154 n15155 VDD VSS n15153 NOR2X1
XU16119 g1224 n9334 VDD VSS n15155 NOR2X1
XU16120 g3229 g1227 VDD VSS n15154 NOR2X1
XU16121 n15156 n15157 VDD VSS n15152 NOR2X1
XU16122 g1243 n15158 VDD VSS n15150 NAND2X1
XU16123 n15159 n15160 VDD VSS n15158 XOR2X1
XU16124 n15161 n9567 VDD VSS n15148 NOR2X1
XU16125 n15162 n15163 VDD VSS n15161 XOR2X1
XU16126 n15164 n15165 VDD VSS n15163 XOR2X1
XU16127 n15166 n15167 VDD VSS n15165 XOR2X1
XU16128 n15168 n15169 VDD VSS n15164 XOR2X1
XU16129 n15170 n15171 VDD VSS n15162 XOR2X1
XU16130 n15172 n15173 VDD VSS n15171 XOR2X1
XU16131 n15174 n15175 VDD VSS n15170 XOR2X1
XU16132 n15176 n15177 VDD VSS g29578 NOR2X1
XU16133 n15156 n15178 VDD VSS n15177 NOR2X1
XU16134 n15179 n15180 VDD VSS n15178 NAND2X1
XU16135 n15175 n15181 VDD VSS n15180 NAND2X1
XU16136 n15182 n15183 VDD VSS n15175 AND2X1
XU16137 n15184 n15185 VDD VSS n15182 NOR2X1
XU16138 n9529 n15186 VDD VSS n15185 NOR2X1
XU16139 n15187 n9672 VDD VSS n15184 NOR2X1
XU16140 n9529 n15188 VDD VSS n15187 NOR2X1
XU16141 g1220 n15157 VDD VSS n15179 OR2X1
XU16142 n15189 n15190 VDD VSS g29577 NOR2X1
XU16143 n15156 n15191 VDD VSS n15189 NOR2X1
XU16144 n15192 n15193 VDD VSS n15191 NAND2X1
XU16145 n15194 n15181 VDD VSS n15193 NAND2X1
XU16146 n15174 VDD VSS n15194 INVX1
XU16147 n15195 n15183 VDD VSS n15174 NAND2X1
XU16148 n15196 n15197 VDD VSS n15195 NOR2X1
XU16149 n9543 n15186 VDD VSS n15197 NOR2X1
XU16150 n9672 n15198 VDD VSS n15196 NOR2X1
XU16151 g1216 n15157 VDD VSS n15192 OR2X1
XU16152 n15176 n15199 VDD VSS g29576 NOR2X1
XU16153 n15156 n15200 VDD VSS n15199 NOR2X1
XU16154 n15201 n15202 VDD VSS n15200 NAND2X1
XU16155 n15173 n15181 VDD VSS n15202 NAND2X1
XU16156 n15203 n15183 VDD VSS n15173 AND2X1
XU16157 n15204 n15205 VDD VSS n15203 NOR2X1
XU16158 n9536 n15206 VDD VSS n15205 NOR2X1
XU16159 n15207 n15208 VDD VSS n15204 NOR2X1
XU16160 n9536 n15188 VDD VSS n15208 NOR2X1
XU16161 g1219 n15157 VDD VSS n15201 OR2X1
XU16162 n15209 VDD VSS n15176 INVX1
XU16163 n15210 n15211 VDD VSS g29574 NOR2X1
XU16164 n15160 n15212 VDD VSS n15211 NOR2X1
XU16165 n15213 n15183 VDD VSS n15160 AND2X1
XU16166 n15214 n15215 VDD VSS n15213 NOR2X1
XU16167 n9546 n15186 VDD VSS n15215 NOR2X1
XU16168 n15216 n9672 VDD VSS n15214 NOR2X1
XU16169 n9546 n15188 VDD VSS n15216 NOR2X1
XU16170 n15156 n15217 VDD VSS n15210 NOR2X1
XU16171 n15218 n15219 VDD VSS n15217 NAND2X1
XU16172 n15172 n15181 VDD VSS n15219 NAND2X1
XU16173 n15220 n15183 VDD VSS n15172 AND2X1
XU16174 n15221 n15222 VDD VSS n15220 NOR2X1
XU16175 n15223 n15186 VDD VSS n15222 NOR2X1
XU16176 n9537 VDD VSS n15223 INVX1
XU16177 n9672 n9537 VDD VSS n15221 NOR2X1
XU16178 g1223 n15157 VDD VSS n15218 OR2X1
XU16179 n15224 n15225 VDD VSS g29571 NOR2X1
XU16180 n15159 n15212 VDD VSS n15225 NOR2X1
XU16181 n15226 VDD VSS n15212 INVX1
XU16182 n15227 n15183 VDD VSS n15159 AND2X1
XU16183 n15228 n15229 VDD VSS n15227 NOR2X1
XU16184 n15230 n15206 VDD VSS n15229 NOR2X1
XU16185 n15207 n15231 VDD VSS n15228 NOR2X1
XU16186 n15230 n15188 VDD VSS n15231 NOR2X1
XU16187 n9549 VDD VSS n15230 INVX1
XU16188 n15156 n15232 VDD VSS n15224 NOR2X1
XU16189 n15233 n15234 VDD VSS n15232 NAND2X1
XU16190 n15167 n15181 VDD VSS n15234 NAND2X1
XU16191 n15235 n15183 VDD VSS n15167 AND2X1
XU16192 n15236 n15237 VDD VSS n15235 NOR2X1
XU16193 n9530 n15206 VDD VSS n15237 NOR2X1
XU16194 n15207 n15238 VDD VSS n15236 NOR2X1
XU16195 n9530 n15188 VDD VSS n15238 NOR2X1
XU16196 n15239 VDD VSS n9530 INVX1
XU16197 g1222 n15157 VDD VSS n15233 OR2X1
XU16198 n15240 n15241 VDD VSS g29570 NOR2X1
XU16199 n15156 n15242 VDD VSS n15241 NOR2X1
XU16200 n15243 n15244 VDD VSS n15242 NAND2X1
XU16201 n15166 n15181 VDD VSS n15244 NAND2X1
XU16202 n15245 n15183 VDD VSS n15166 AND2X1
XU16203 n15246 n15247 VDD VSS n15245 NOR2X1
XU16204 n9533 n15186 VDD VSS n15247 NOR2X1
XU16205 n9672 n15248 VDD VSS n15186 NAND2X1
XU16206 n9672 n15249 VDD VSS n15246 NOR2X1
XU16207 n9638 VDD VSS n9672 INVX1
XU16208 n15250 n15251 VDD VSS n9638 NAND2X1
XU16209 g1303 g6944 VDD VSS n15251 NAND2X1
XU16210 n15252 n15253 VDD VSS n15250 NOR2X1
XU16211 n9582 n10468 VDD VSS n15253 NOR2X1
XU16212 g1300 VDD VSS n10468 INVX1
XU16213 n9572 n10474 VDD VSS n15252 NOR2X1
XU16214 g1306 VDD VSS n10474 INVX1
XU16215 g1218 n15157 VDD VSS n15243 OR2X1
XU16216 n15240 n15254 VDD VSS g29569 NOR2X1
XU16217 n15156 n15255 VDD VSS n15254 NOR2X1
XU16218 n15256 n15257 VDD VSS n15255 NAND2X1
XU16219 n15169 n15181 VDD VSS n15257 NAND2X1
XU16220 n15258 n15183 VDD VSS n15169 AND2X1
XU16221 n15259 n15260 VDD VSS n15258 NOR2X1
XU16222 n9542 n15206 VDD VSS n15260 NOR2X1
XU16223 n15261 VDD VSS n9542 INVX1
XU16224 n15207 n15261 VDD VSS n15259 NOR2X1
XU16225 g1215 n15157 VDD VSS n15256 OR2X1
XU16226 n15226 n15262 VDD VSS n15240 AND2X1
XU16227 n15183 n15263 VDD VSS n15262 NAND2X1
XU16228 n15264 n15190 VDD VSS g29552 NOR2X1
XU16229 n15209 n15265 VDD VSS n15190 NAND2X1
XU16230 n15266 n15226 VDD VSS n15265 NAND2X1
XU16231 g1186 n15263 VDD VSS n15266 AND2X1
XU16232 n15267 n15268 VDD VSS n15263 NAND2X1
XU16233 n15188 n15269 VDD VSS n15268 NOR2X1
XU16234 g1420 n9433 VDD VSS n15269 NOR2X1
XU16235 n15248 VDD VSS n15188 INVX1
XU16236 n15270 n15271 VDD VSS n15267 NOR2X1
XU16237 g1422 n9555 VDD VSS n15271 NOR2X1
XU16238 g7161 VDD VSS n9555 INVX1
XU16239 g1421 n9552 VDD VSS n15270 NOR2X1
XU16240 n15226 n15272 VDD VSS n15209 NAND2X1
XU16241 n15273 n15181 VDD VSS n15226 NOR2X1
XU16242 n15156 n15274 VDD VSS n15264 NOR2X1
XU16243 n15275 n15276 VDD VSS n15274 NAND2X1
XU16244 n15168 n15181 VDD VSS n15276 NAND2X1
XU16245 n15277 n15183 VDD VSS n15168 AND2X1
XU16246 n15272 II15505 VDD VSS n15183 NOR2X1
XU16247 n15278 n15279 VDD VSS n15277 NOR2X1
XU16248 n9550 n15206 VDD VSS n15279 NOR2X1
XU16249 n15207 n15248 VDD VSS n15206 NAND2X1
XU16250 n15280 n15281 VDD VSS n15248 NAND2X1
XU16251 n15282 n15283 VDD VSS n15281 NOR2X1
XU16252 n15284 n9549 VDD VSS n15283 NAND2X1
XU16253 n15285 n15286 VDD VSS n9549 NAND2X1
XU16254 g7161 n9474 VDD VSS n15286 NAND2X1
XU16255 g1413 VDD VSS n9474 INVX1
XU16256 n15287 n15288 VDD VSS n15285 NOR2X1
XU16257 g1412 n9552 VDD VSS n15288 NOR2X1
XU16258 g1411 n9433 VDD VSS n15287 NOR2X1
XU16259 n9529 n9546 VDD VSS n15284 NOR2X1
XU16260 n15289 n15290 VDD VSS n9546 AND2X1
XU16261 g7161 n9560 VDD VSS n15290 NAND2X1
XU16262 g1410 VDD VSS n9560 INVX1
XU16263 n15291 n15292 VDD VSS n15289 NOR2X1
XU16264 g1409 n9552 VDD VSS n15292 NOR2X1
XU16265 g1408 n9433 VDD VSS n15291 NOR2X1
XU16266 n15293 n15294 VDD VSS n9529 AND2X1
XU16267 g7161 n9487 VDD VSS n15294 NAND2X1
XU16268 g1392 VDD VSS n9487 INVX1
XU16269 n15295 n15296 VDD VSS n15293 NOR2X1
XU16270 g1391 n9552 VDD VSS n15296 NOR2X1
XU16271 g1390 n9433 VDD VSS n15295 NOR2X1
XU16272 n15297 n15239 VDD VSS n15282 NAND2X1
XU16273 n15298 n15299 VDD VSS n15239 NAND2X1
XU16274 g7161 n9480 VDD VSS n15299 NAND2X1
XU16275 g1389 VDD VSS n9480 INVX1
XU16276 n15300 n15301 VDD VSS n15298 NOR2X1
XU16277 g1388 n9552 VDD VSS n15301 NOR2X1
XU16278 g1387 n9433 VDD VSS n15300 NOR2X1
XU16279 n15302 n9536 VDD VSS n15297 NOR2X1
XU16280 n15303 n15304 VDD VSS n9536 AND2X1
XU16281 g7161 n9492 VDD VSS n15304 NAND2X1
XU16282 g1395 VDD VSS n9492 INVX1
XU16283 n15305 n15306 VDD VSS n15303 NOR2X1
XU16284 g1394 n9552 VDD VSS n15306 NOR2X1
XU16285 g1393 n9433 VDD VSS n15305 NOR2X1
XU16286 n9554 VDD VSS n15302 INVX1
XU16287 n15307 n15308 VDD VSS n9554 NAND2X1
XU16288 g7161 n9599 VDD VSS n15308 NAND2X1
XU16289 g1419 VDD VSS n9599 INVX1
XU16290 n15309 n15310 VDD VSS n15307 NOR2X1
XU16291 g1418 n9552 VDD VSS n15310 NOR2X1
XU16292 g1417 n9433 VDD VSS n15309 NOR2X1
XU16293 n15311 n15312 VDD VSS n15280 NOR2X1
XU16294 n15313 n9543 VDD VSS n15312 NAND2X1
XU16295 n15198 VDD VSS n9543 INVX1
XU16296 n15314 n15315 VDD VSS n15198 NAND2X1
XU16297 g7161 n9507 VDD VSS n15315 NAND2X1
XU16298 g1404 VDD VSS n9507 INVX1
XU16299 n15316 n15317 VDD VSS n15314 NOR2X1
XU16300 g1403 n9552 VDD VSS n15317 NOR2X1
XU16301 g1402 n9433 VDD VSS n15316 NOR2X1
XU16302 n15318 n15261 VDD VSS n15313 NOR2X1
XU16303 n15319 n15320 VDD VSS n15261 NAND2X1
XU16304 g7161 n9514 VDD VSS n15320 NAND2X1
XU16305 g1407 VDD VSS n9514 INVX1
XU16306 n15321 n15322 VDD VSS n15319 NOR2X1
XU16307 g1406 n9552 VDD VSS n15322 NOR2X1
XU16308 g1405 n9433 VDD VSS n15321 NOR2X1
XU16309 n15323 n9533 VDD VSS n15311 NAND2X1
XU16310 n15249 VDD VSS n9533 INVX1
XU16311 n15324 n15325 VDD VSS n15249 NAND2X1
XU16312 g7161 n9497 VDD VSS n15325 NAND2X1
XU16313 g1398 VDD VSS n9497 INVX1
XU16314 n15326 n15327 VDD VSS n15324 NOR2X1
XU16315 g1397 n9552 VDD VSS n15327 NOR2X1
XU16316 g1396 n9433 VDD VSS n15326 NOR2X1
XU16317 n15328 n9537 VDD VSS n15323 NOR2X1
XU16318 n15329 n15330 VDD VSS n9537 NAND2X1
XU16319 g7161 n9471 VDD VSS n15330 NAND2X1
XU16320 g1386 VDD VSS n9471 INVX1
XU16321 n15331 n15332 VDD VSS n15329 NOR2X1
XU16322 g1385 n9552 VDD VSS n15332 NOR2X1
XU16323 g1384 n9433 VDD VSS n15331 NOR2X1
XU16324 n15333 n15334 VDD VSS n15328 NOR2X1
XU16325 n15335 n15336 VDD VSS n15334 NAND2X1
XU16326 g6979 n9443 VDD VSS n15336 NAND2X1
XU16327 g1424 VDD VSS n9443 INVX1
XU16328 g7161 n9439 VDD VSS n15335 NAND2X1
XU16329 g1425 VDD VSS n9439 INVX1
XU16330 g1423 n9433 VDD VSS n15333 NOR2X1
XU16331 n15318 VDD VSS n9550 INVX1
XU16332 n15207 n15318 VDD VSS n15278 NOR2X1
XU16333 n15337 n15338 VDD VSS n15318 NAND2X1
XU16334 g7161 n9502 VDD VSS n15338 NAND2X1
XU16335 g1401 VDD VSS n9502 INVX1
XU16336 n15339 n15340 VDD VSS n15337 NOR2X1
XU16337 g1400 n9552 VDD VSS n15340 NOR2X1
XU16338 g6979 VDD VSS n9552 INVX1
XU16339 g1399 n9433 VDD VSS n15339 NOR2X1
XU16340 g1315 VDD VSS n9433 INVX1
XU16341 n9596 VDD VSS n15207 INVX1
XU16342 n15341 n15342 VDD VSS n9596 NAND2X1
XU16343 g1294 g6944 VDD VSS n15342 NAND2X1
XU16344 n15343 n15344 VDD VSS n15341 NOR2X1
XU16345 n9582 n10451 VDD VSS n15344 NOR2X1
XU16346 g1291 VDD VSS n10451 INVX1
XU16347 n9572 n10457 VDD VSS n15343 NOR2X1
XU16348 g1297 VDD VSS n10457 INVX1
XU16349 g1236 VDD VSS n9572 INVX1
XU16350 g1217 n15157 VDD VSS n15275 OR2X1
XU16351 n15181 n15272 VDD VSS n15157 OR2X1
XU16352 n15345 n8176 VDD VSS n15272 NAND2X1
XU16353 n15080 VDD VSS n8176 INVX1
XU16354 n15346 n15347 VDD VSS n15080 NOR2X1
XU16355 g1186 n15348 VDD VSS n15347 NOR2X1
XU16356 n15349 n15350 VDD VSS n15348 NOR2X1
XU16357 n9582 n14638 VDD VSS n15350 NOR2X1
XU16358 g6750 VDD VSS n9582 INVX1
XU16359 g6750 g1234 VDD VSS n15349 NOR2X1
XU16360 g1230 II15505 VDD VSS n15346 NOR2X1
XU16361 g1249 g1245 VDD VSS n15345 NOR2X1
XU16362 n15351 n9567 VDD VSS n15181 NAND2X1
XU16363 g1196 VDD VSS n9567 INVX1
XU16364 n9573 n9564 VDD VSS n15351 NAND2X1
XU16365 g1211 VDD VSS n9564 INVX1
XU16366 n15273 VDD VSS n15156 INVX1
XU16367 n15352 n15353 VDD VSS n15273 NAND2X1
XU16368 g1211 n9573 VDD VSS n15353 NAND2X1
XU16369 g1196 n9573 VDD VSS n15352 NAND2X1
XU16370 g1243 VDD VSS n9573 INVX1
XU16371 n15354 n15355 VDD VSS g28954 NOR2X1
XU16372 n15356 n15357 VDD VSS n15355 NAND2X1
XU16373 n15358 n15359 VDD VSS n15357 NAND2X1
XU16374 n15360 n15361 VDD VSS n15359 NOR2X1
XU16375 g541 g3229 VDD VSS n15361 NOR2X1
XU16376 g538 n9334 VDD VSS n15360 NOR2X1
XU16377 g3229 VDD VSS n9334 INVX1
XU16378 n15362 n15363 VDD VSS n15358 NOR2X1
XU16379 g557 n15364 VDD VSS n15356 NAND2X1
XU16380 n15365 n15366 VDD VSS n15364 XOR2X1
XU16381 n15367 n9918 VDD VSS n15354 NOR2X1
XU16382 n15368 n15369 VDD VSS n15367 XOR2X1
XU16383 n15370 n15371 VDD VSS n15369 XOR2X1
XU16384 n15372 n15373 VDD VSS n15371 XOR2X1
XU16385 n15374 n15375 VDD VSS n15370 XOR2X1
XU16386 n15376 n15377 VDD VSS n15368 XOR2X1
XU16387 n15378 n15379 VDD VSS n15377 XOR2X1
XU16388 n15380 n15381 VDD VSS n15376 XOR2X1
XU16389 n15382 n15383 VDD VSS g28528 NOR2X1
XU16390 n15362 n15384 VDD VSS n15383 NOR2X1
XU16391 n15385 n15386 VDD VSS n15384 NAND2X1
XU16392 n15381 n15387 VDD VSS n15386 NAND2X1
XU16393 n15388 n15389 VDD VSS n15381 AND2X1
XU16394 n15390 n15391 VDD VSS n15388 NOR2X1
XU16395 n9880 n15392 VDD VSS n15391 NOR2X1
XU16396 n15393 n10123 VDD VSS n15390 NOR2X1
XU16397 n9880 n15394 VDD VSS n15393 NOR2X1
XU16398 g534 n15363 VDD VSS n15385 OR2X1
XU16399 n15395 n15396 VDD VSS g28525 NOR2X1
XU16400 n15362 n15397 VDD VSS n15395 NOR2X1
XU16401 n15398 n15399 VDD VSS n15397 NAND2X1
XU16402 n15400 n15387 VDD VSS n15399 NAND2X1
XU16403 n15380 VDD VSS n15400 INVX1
XU16404 n15401 n15389 VDD VSS n15380 NAND2X1
XU16405 n15402 n15403 VDD VSS n15401 NOR2X1
XU16406 n9894 n15392 VDD VSS n15403 NOR2X1
XU16407 n10123 n15404 VDD VSS n15402 NOR2X1
XU16408 g530 n15363 VDD VSS n15398 OR2X1
XU16409 n15382 n15405 VDD VSS g28499 NOR2X1
XU16410 n15362 n15406 VDD VSS n15405 NOR2X1
XU16411 n15407 n15408 VDD VSS n15406 NAND2X1
XU16412 n15379 n15387 VDD VSS n15408 NAND2X1
XU16413 n15409 n15389 VDD VSS n15379 AND2X1
XU16414 n15410 n15411 VDD VSS n15409 NOR2X1
XU16415 n9887 n15412 VDD VSS n15411 NOR2X1
XU16416 n15413 n15414 VDD VSS n15410 NOR2X1
XU16417 n9887 n15394 VDD VSS n15414 NOR2X1
XU16418 g533 n15363 VDD VSS n15407 OR2X1
XU16419 n15415 VDD VSS n15382 INVX1
XU16420 n15416 n15417 VDD VSS g28495 NOR2X1
XU16421 n15366 n15418 VDD VSS n15417 NOR2X1
XU16422 n15419 n15389 VDD VSS n15366 AND2X1
XU16423 n15420 n15421 VDD VSS n15419 NOR2X1
XU16424 n9897 n15392 VDD VSS n15421 NOR2X1
XU16425 n15422 n10123 VDD VSS n15420 NOR2X1
XU16426 n9897 n15394 VDD VSS n15422 NOR2X1
XU16427 n15362 n15423 VDD VSS n15416 NOR2X1
XU16428 n15424 n15425 VDD VSS n15423 NAND2X1
XU16429 n15378 n15387 VDD VSS n15425 NAND2X1
XU16430 n15426 n15389 VDD VSS n15378 AND2X1
XU16431 n15427 n15428 VDD VSS n15426 NOR2X1
XU16432 n15429 n15392 VDD VSS n15428 NOR2X1
XU16433 n9888 VDD VSS n15429 INVX1
XU16434 n10123 n9888 VDD VSS n15427 NOR2X1
XU16435 g537 n15363 VDD VSS n15424 OR2X1
XU16436 n15430 n15431 VDD VSS g28490 NOR2X1
XU16437 n15365 n15418 VDD VSS n15431 NOR2X1
XU16438 n15432 VDD VSS n15418 INVX1
XU16439 n15433 n15389 VDD VSS n15365 AND2X1
XU16440 n15434 n15435 VDD VSS n15433 NOR2X1
XU16441 n15436 n15412 VDD VSS n15435 NOR2X1
XU16442 n15413 n15437 VDD VSS n15434 NOR2X1
XU16443 n15436 n15394 VDD VSS n15437 NOR2X1
XU16444 n9900 VDD VSS n15436 INVX1
XU16445 n15362 n15438 VDD VSS n15430 NOR2X1
XU16446 n15439 n15440 VDD VSS n15438 NAND2X1
XU16447 n15373 n15387 VDD VSS n15440 NAND2X1
XU16448 n15441 n15389 VDD VSS n15373 AND2X1
XU16449 n15442 n15443 VDD VSS n15441 NOR2X1
XU16450 n9881 n15412 VDD VSS n15443 NOR2X1
XU16451 n15413 n15444 VDD VSS n15442 NOR2X1
XU16452 n9881 n15394 VDD VSS n15444 NOR2X1
XU16453 n15445 VDD VSS n9881 INVX1
XU16454 g536 n15363 VDD VSS n15439 OR2X1
XU16455 n15446 n15447 VDD VSS g28489 NOR2X1
XU16456 n15362 n15448 VDD VSS n15447 NOR2X1
XU16457 n15449 n15450 VDD VSS n15448 NAND2X1
XU16458 n15372 n15387 VDD VSS n15450 NAND2X1
XU16459 n15451 n15389 VDD VSS n15372 AND2X1
XU16460 n15452 n15453 VDD VSS n15451 NOR2X1
XU16461 n9884 n15392 VDD VSS n15453 NOR2X1
XU16462 n10123 n15454 VDD VSS n15392 NAND2X1
XU16463 n10123 n15455 VDD VSS n15452 NOR2X1
XU16464 n10089 VDD VSS n10123 INVX1
XU16465 n15456 n15457 VDD VSS n10089 NAND2X1
XU16466 g617 g6642 VDD VSS n15457 NAND2X1
XU16467 n15458 n15459 VDD VSS n15456 NOR2X1
XU16468 n10033 n10315 VDD VSS n15459 NOR2X1
XU16469 g614 VDD VSS n10315 INVX1
XU16470 n9923 n10321 VDD VSS n15458 NOR2X1
XU16471 g620 VDD VSS n10321 INVX1
XU16472 g532 n15363 VDD VSS n15449 OR2X1
XU16473 n15446 n15460 VDD VSS g28488 NOR2X1
XU16474 n15362 n15461 VDD VSS n15460 NOR2X1
XU16475 n15462 n15463 VDD VSS n15461 NAND2X1
XU16476 n15375 n15387 VDD VSS n15463 NAND2X1
XU16477 n15464 n15389 VDD VSS n15375 AND2X1
XU16478 n15465 n15466 VDD VSS n15464 NOR2X1
XU16479 n9893 n15412 VDD VSS n15466 NOR2X1
XU16480 n15467 VDD VSS n9893 INVX1
XU16481 n15413 n15467 VDD VSS n15465 NOR2X1
XU16482 g529 n15363 VDD VSS n15462 OR2X1
XU16483 n15432 n15468 VDD VSS n15446 AND2X1
XU16484 n15389 n15469 VDD VSS n15468 NAND2X1
XU16485 n15470 n15396 VDD VSS g28470 NOR2X1
XU16486 n15415 n15471 VDD VSS n15396 NAND2X1
XU16487 n15472 n15432 VDD VSS n15471 NAND2X1
XU16488 g499 n15469 VDD VSS n15472 AND2X1
XU16489 n15473 n15474 VDD VSS n15469 NAND2X1
XU16490 n15394 n15475 VDD VSS n15474 NOR2X1
XU16491 g734 n9784 VDD VSS n15475 NOR2X1
XU16492 n15454 VDD VSS n15394 INVX1
XU16493 n15476 n15477 VDD VSS n15473 NOR2X1
XU16494 g736 n9906 VDD VSS n15477 NOR2X1
XU16495 g6911 VDD VSS n9906 INVX1
XU16496 g735 n9903 VDD VSS n15476 NOR2X1
XU16497 n15432 n15478 VDD VSS n15415 NAND2X1
XU16498 n15479 n15387 VDD VSS n15432 NOR2X1
XU16499 n15362 n15480 VDD VSS n15470 NOR2X1
XU16500 n15481 n15482 VDD VSS n15480 NAND2X1
XU16501 n15374 n15387 VDD VSS n15482 NAND2X1
XU16502 n15483 n15389 VDD VSS n15374 AND2X1
XU16503 n15478 II15499 VDD VSS n15389 NOR2X1
XU16504 n15484 n15485 VDD VSS n15483 NOR2X1
XU16505 n9901 n15412 VDD VSS n15485 NOR2X1
XU16506 n15413 n15454 VDD VSS n15412 NAND2X1
XU16507 n15486 n15487 VDD VSS n15454 NAND2X1
XU16508 n15488 n15489 VDD VSS n15487 NOR2X1
XU16509 n15490 n9900 VDD VSS n15489 NAND2X1
XU16510 n15491 n15492 VDD VSS n9900 NAND2X1
XU16511 g6911 n9825 VDD VSS n15492 NAND2X1
XU16512 g727 VDD VSS n9825 INVX1
XU16513 n15493 n15494 VDD VSS n15491 NOR2X1
XU16514 g726 n9903 VDD VSS n15494 NOR2X1
XU16515 g725 n9784 VDD VSS n15493 NOR2X1
XU16516 n9880 n9897 VDD VSS n15490 NOR2X1
XU16517 n15495 n15496 VDD VSS n9897 AND2X1
XU16518 g6911 n9911 VDD VSS n15496 NAND2X1
XU16519 g724 VDD VSS n9911 INVX1
XU16520 n15497 n15498 VDD VSS n15495 NOR2X1
XU16521 g723 n9903 VDD VSS n15498 NOR2X1
XU16522 g722 n9784 VDD VSS n15497 NOR2X1
XU16523 n15499 n15500 VDD VSS n9880 AND2X1
XU16524 g6911 n9838 VDD VSS n15500 NAND2X1
XU16525 g706 VDD VSS n9838 INVX1
XU16526 n15501 n15502 VDD VSS n15499 NOR2X1
XU16527 g705 n9903 VDD VSS n15502 NOR2X1
XU16528 g704 n9784 VDD VSS n15501 NOR2X1
XU16529 n15503 n15445 VDD VSS n15488 NAND2X1
XU16530 n15504 n15505 VDD VSS n15445 NAND2X1
XU16531 g6911 n9831 VDD VSS n15505 NAND2X1
XU16532 g703 VDD VSS n9831 INVX1
XU16533 n15506 n15507 VDD VSS n15504 NOR2X1
XU16534 g702 n9903 VDD VSS n15507 NOR2X1
XU16535 g701 n9784 VDD VSS n15506 NOR2X1
XU16536 n15508 n9887 VDD VSS n15503 NOR2X1
XU16537 n15509 n15510 VDD VSS n9887 AND2X1
XU16538 g6911 n9843 VDD VSS n15510 NAND2X1
XU16539 g709 VDD VSS n9843 INVX1
XU16540 n15511 n15512 VDD VSS n15509 NOR2X1
XU16541 g708 n9903 VDD VSS n15512 NOR2X1
XU16542 g707 n9784 VDD VSS n15511 NOR2X1
XU16543 n9905 VDD VSS n15508 INVX1
XU16544 n15513 n15514 VDD VSS n9905 NAND2X1
XU16545 g6911 n10050 VDD VSS n15514 NAND2X1
XU16546 g733 VDD VSS n10050 INVX1
XU16547 n15515 n15516 VDD VSS n15513 NOR2X1
XU16548 g732 n9903 VDD VSS n15516 NOR2X1
XU16549 g731 n9784 VDD VSS n15515 NOR2X1
XU16550 n15517 n15518 VDD VSS n15486 NOR2X1
XU16551 n15519 n9894 VDD VSS n15518 NAND2X1
XU16552 n15404 VDD VSS n9894 INVX1
XU16553 n15520 n15521 VDD VSS n15404 NAND2X1
XU16554 g6911 n9858 VDD VSS n15521 NAND2X1
XU16555 g718 VDD VSS n9858 INVX1
XU16556 n15522 n15523 VDD VSS n15520 NOR2X1
XU16557 g717 n9903 VDD VSS n15523 NOR2X1
XU16558 g716 n9784 VDD VSS n15522 NOR2X1
XU16559 n15524 n15467 VDD VSS n15519 NOR2X1
XU16560 n15525 n15526 VDD VSS n15467 NAND2X1
XU16561 g6911 n9865 VDD VSS n15526 NAND2X1
XU16562 g721 VDD VSS n9865 INVX1
XU16563 n15527 n15528 VDD VSS n15525 NOR2X1
XU16564 g720 n9903 VDD VSS n15528 NOR2X1
XU16565 g719 n9784 VDD VSS n15527 NOR2X1
XU16566 n15529 n9884 VDD VSS n15517 NAND2X1
XU16567 n15455 VDD VSS n9884 INVX1
XU16568 n15530 n15531 VDD VSS n15455 NAND2X1
XU16569 g6911 n9848 VDD VSS n15531 NAND2X1
XU16570 g712 VDD VSS n9848 INVX1
XU16571 n15532 n15533 VDD VSS n15530 NOR2X1
XU16572 g711 n9903 VDD VSS n15533 NOR2X1
XU16573 g710 n9784 VDD VSS n15532 NOR2X1
XU16574 n15534 n9888 VDD VSS n15529 NOR2X1
XU16575 n15535 n15536 VDD VSS n9888 NAND2X1
XU16576 g6911 n9822 VDD VSS n15536 NAND2X1
XU16577 g700 VDD VSS n9822 INVX1
XU16578 n15537 n15538 VDD VSS n15535 NOR2X1
XU16579 g699 n9903 VDD VSS n15538 NOR2X1
XU16580 g698 n9784 VDD VSS n15537 NOR2X1
XU16581 n15539 n15540 VDD VSS n15534 NOR2X1
XU16582 n15541 n15542 VDD VSS n15540 NAND2X1
XU16583 g6677 n9794 VDD VSS n15542 NAND2X1
XU16584 g738 VDD VSS n9794 INVX1
XU16585 g6911 n9790 VDD VSS n15541 NAND2X1
XU16586 g739 VDD VSS n9790 INVX1
XU16587 g737 n9784 VDD VSS n15539 NOR2X1
XU16588 n15524 VDD VSS n9901 INVX1
XU16589 n15413 n15524 VDD VSS n15484 NOR2X1
XU16590 n15543 n15544 VDD VSS n15524 NAND2X1
XU16591 g6911 n9853 VDD VSS n15544 NAND2X1
XU16592 g715 VDD VSS n9853 INVX1
XU16593 n15545 n15546 VDD VSS n15543 NOR2X1
XU16594 g714 n9903 VDD VSS n15546 NOR2X1
XU16595 g6677 VDD VSS n9903 INVX1
XU16596 g713 n9784 VDD VSS n15545 NOR2X1
XU16597 g629 VDD VSS n9784 INVX1
XU16598 n10047 VDD VSS n15413 INVX1
XU16599 n15547 n15548 VDD VSS n10047 NAND2X1
XU16600 g608 g6642 VDD VSS n15548 NAND2X1
XU16601 n15549 n15550 VDD VSS n15547 NOR2X1
XU16602 n10033 n10298 VDD VSS n15550 NOR2X1
XU16603 g605 VDD VSS n10298 INVX1
XU16604 n9923 n10304 VDD VSS n15549 NOR2X1
XU16605 g611 VDD VSS n10304 INVX1
XU16606 g550 VDD VSS n9923 INVX1
XU16607 g531 n15363 VDD VSS n15481 OR2X1
XU16608 n15387 n15478 VDD VSS n15363 OR2X1
XU16609 n15551 n15552 VDD VSS n15478 NAND2X1
XU16610 g563 g559 VDD VSS n15552 NOR2X1
XU16611 n15553 n14638 VDD VSS n15551 NOR2X1
XU16612 n15554 n15555 VDD VSS n14638 NAND2X1
XU16613 g499 n15556 VDD VSS n15555 OR2X1
XU16614 g548 n10033 VDD VSS n15556 NAND2X1
XU16615 g544 g499 VDD VSS n15554 NAND2X1
XU16616 g499 n10033 VDD VSS n15553 NOR2X1
XU16617 g6485 VDD VSS n10033 INVX1
XU16618 n15557 n9918 VDD VSS n15387 NAND2X1
XU16619 g510 VDD VSS n9918 INVX1
XU16620 n9924 n9915 VDD VSS n15557 NAND2X1
XU16621 g525 VDD VSS n9915 INVX1
XU16622 n15479 VDD VSS n15362 INVX1
XU16623 n15558 n15559 VDD VSS n15479 NAND2X1
XU16624 g525 n9924 VDD VSS n15559 NAND2X1
XU16625 g510 n9924 VDD VSS n15558 NAND2X1
XU16626 g557 VDD VSS n9924 INVX1
XU16627 n28 VDD VSS g26974 INVX1
XU16628 n15560 n15561 VDD VSS n28 NOR2X1
XU16629 n15562 n15563 VDD VSS n15561 NAND2X1
XU16630 n15564 n15565 VDD VSS n15562 NOR2X1
XU16631 n15566 g3151 VDD VSS n15565 AND2X1
XU16632 n15567 n15568 VDD VSS n15564 NOR2X1
XU16633 n15569 n15570 VDD VSS n15567 NOR2X1
XU16634 n15571 n15572 VDD VSS n15569 NOR2X1
XU16635 n15573 g185 VDD VSS n15572 OR2X1
XU16636 n15574 n15575 VDD VSS n15560 NAND2X1
XU16637 n15576 n15577 VDD VSS n15575 NOR2X1
XU16638 g3133 n15578 VDD VSS n15577 NOR2X1
XU16639 g3139 n15579 VDD VSS n15576 AND2X1
XU16640 n15580 n15581 VDD VSS n15574 NOR2X1
XU16641 n15582 n15583 VDD VSS n15581 NOR2X1
XU16642 n15584 n15585 VDD VSS n15580 NOR2X1
XU16643 n15586 n15587 VDD VSS n15585 NAND2X1
XU16644 n15588 n15589 VDD VSS n15584 NAND2X1
XU16645 g3114 n15590 VDD VSS n15589 NAND2X1
XU16646 n15591 VDD VSS n15590 INVX1
XU16647 g3188 n15592 VDD VSS n15588 NOR2X1
XU16648 n15593 g3120 VDD VSS n15592 AND2X1
XU16649 n15594 n15595 VDD VSS g25566 NAND2X1
XU16650 n15596 n15597 VDD VSS n15595 NOR2X1
XU16651 n15598 n15599 VDD VSS n15597 NAND2X1
XU16652 n15600 n15601 VDD VSS n15599 NOR2X1
XU16653 n15602 n10966 VDD VSS n15601 NOR2X1
XU16654 g3173 VDD VSS n10966 INVX1
XU16655 n15603 n10909 VDD VSS n15600 NOR2X1
XU16656 g3088 VDD VSS n10909 INVX1
XU16657 n15604 n15605 VDD VSS n15598 NOR2X1
XU16658 n15606 n10972 VDD VSS n15605 NOR2X1
XU16659 g3182 VDD VSS n10972 INVX1
XU16660 n15607 n10897 VDD VSS n15604 NOR2X1
XU16661 g3170 VDD VSS n10897 INVX1
XU16662 n15608 n15609 VDD VSS n15596 NAND2X1
XU16663 n15610 n15611 VDD VSS n15609 NOR2X1
XU16664 n15612 n10934 VDD VSS n15611 NOR2X1
XU16665 g3176 VDD VSS n10934 INVX1
XU16666 n15613 n15582 VDD VSS n15610 NOR2X1
XU16667 n15614 n15615 VDD VSS n15613 NOR2X1
XU16668 n15616 n10956 VDD VSS n15615 NOR2X1
XU16669 g3155 VDD VSS n10956 INVX1
XU16670 n15573 n10928 VDD VSS n15614 NOR2X1
XU16671 g3167 VDD VSS n10928 INVX1
XU16672 n15617 n15618 VDD VSS n15608 NOR2X1
XU16673 n15619 n10940 VDD VSS n15618 NOR2X1
XU16674 g3185 VDD VSS n10940 INVX1
XU16675 n15620 n10903 VDD VSS n15617 NOR2X1
XU16676 g3179 VDD VSS n10903 INVX1
XU16677 n15621 n15622 VDD VSS n15594 AND2X1
XU16678 n15623 n15624 VDD VSS n15622 NOR2X1
XU16679 n15625 n15626 VDD VSS n15624 NAND2X1
XU16680 g3135 n15579 VDD VSS n15626 NAND2X1
XU16681 g3158 n15627 VDD VSS n15625 NAND2X1
XU16682 n15628 n15629 VDD VSS n15623 NAND2X1
XU16683 g3164 n15630 VDD VSS n15629 NAND2X1
XU16684 g3161 n15631 VDD VSS n15628 NAND2X1
XU16685 n15632 n15633 VDD VSS n15621 NOR2X1
XU16686 n15634 n15635 VDD VSS n15633 NAND2X1
XU16687 g3113 n15636 VDD VSS n15635 NAND2X1
XU16688 g3127 n15637 VDD VSS n15634 NAND2X1
XU16689 n15638 n15639 VDD VSS g25520 NAND2X1
XU16690 n15640 n15641 VDD VSS n15639 NOR2X1
XU16691 n15642 n15643 VDD VSS n15641 NAND2X1
XU16692 n15644 n15645 VDD VSS n15643 NOR2X1
XU16693 n15636 g3114 VDD VSS n15645 AND2X1
XU16694 n15627 g3098 VDD VSS n15644 AND2X1
XU16695 n15646 n15647 VDD VSS n15642 NOR2X1
XU16696 n15648 n15582 VDD VSS n15647 NOR2X1
XU16697 n15649 n15650 VDD VSS n15648 NOR2X1
XU16698 n15573 n10925 VDD VSS n15650 NOR2X1
XU16699 g3101 VDD VSS n10925 INVX1
XU16700 n15591 n15583 VDD VSS n15649 NOR2X1
XU16701 g3128 n15578 VDD VSS n15646 NOR2X1
XU16702 n15651 n15652 VDD VSS n15640 NAND2X1
XU16703 n15653 n15654 VDD VSS n15652 NOR2X1
XU16704 n15655 n15656 VDD VSS n15654 NAND2X1
XU16705 n15657 g3097 VDD VSS n15656 NAND2X1
XU16706 n15582 n15616 VDD VSS n15657 NOR2X1
XU16707 g3100 n15630 VDD VSS n15655 NAND2X1
XU16708 n15658 n10889 VDD VSS n15653 NOR2X1
XU16709 g3099 VDD VSS n10889 INVX1
XU16710 n15659 n15660 VDD VSS n15651 AND2X1
XU16711 g3134 n15579 VDD VSS n15660 NAND2X1
XU16712 g3147 n15566 VDD VSS n15659 NAND2X1
XU16713 n15661 n15662 VDD VSS n15638 NOR2X1
XU16714 n15663 n15664 VDD VSS n15662 NAND2X1
XU16715 n15665 n15666 VDD VSS n15664 NOR2X1
XU16716 n15619 n10937 VDD VSS n15666 NOR2X1
XU16717 g3107 VDD VSS n10937 INVX1
XU16718 n15620 n10900 VDD VSS n15665 NOR2X1
XU16719 g3105 VDD VSS n10900 INVX1
XU16720 n15667 n15632 VDD VSS n15663 NOR2X1
XU16721 n15603 n10906 VDD VSS n15667 NOR2X1
XU16722 g3108 VDD VSS n10906 INVX1
XU16723 n15668 n15669 VDD VSS n15661 NAND2X1
XU16724 n15670 n15671 VDD VSS n15669 NOR2X1
XU16725 n15607 n10894 VDD VSS n15671 NOR2X1
XU16726 g3102 VDD VSS n10894 INVX1
XU16727 n15602 n10963 VDD VSS n15670 NOR2X1
XU16728 g3103 VDD VSS n10963 INVX1
XU16729 n15672 n15673 VDD VSS n15668 NOR2X1
XU16730 n15612 n10931 VDD VSS n15673 NOR2X1
XU16731 g3104 VDD VSS n10931 INVX1
XU16732 n15606 n10969 VDD VSS n15672 NOR2X1
XU16733 g3106 VDD VSS n10969 INVX1
XU16734 n15674 n15675 VDD VSS g25490 NAND2X1
XU16735 n15676 n15677 VDD VSS n15675 NOR2X1
XU16736 n15678 n15679 VDD VSS n15677 NAND2X1
XU16737 n15680 n15681 VDD VSS n15679 NOR2X1
XU16738 n15602 n10947 VDD VSS n15681 NOR2X1
XU16739 g3091 VDD VSS n10947 INVX1
XU16740 n15682 n15683 VDD VSS n15602 NAND2X1
XU16741 g3188 n15573 VDD VSS n15682 NOR2X1
XU16742 n15603 n10885 VDD VSS n15680 NOR2X1
XU16743 g3096 VDD VSS n10885 INVX1
XU16744 n15684 n15685 VDD VSS n15603 NAND2X1
XU16745 n15686 n15571 VDD VSS n15684 NOR2X1
XU16746 n15687 n15688 VDD VSS n15678 NOR2X1
XU16747 n15606 n10951 VDD VSS n15688 NOR2X1
XU16748 g3094 VDD VSS n10951 INVX1
XU16749 n15689 n15685 VDD VSS n15606 NAND2X1
XU16750 g3207 n15571 VDD VSS n15689 NOR2X1
XU16751 n15607 n10876 VDD VSS n15687 NOR2X1
XU16752 g3087 VDD VSS n10876 INVX1
XU16753 n15690 n15573 VDD VSS n15607 OR2X1
XU16754 n15691 n15692 VDD VSS n15676 NAND2X1
XU16755 n15693 n15694 VDD VSS n15692 NOR2X1
XU16756 n15612 n10914 VDD VSS n15694 NOR2X1
XU16757 g3092 VDD VSS n10914 INVX1
XU16758 n15695 g3188 VDD VSS n15612 NAND2X1
XU16759 n15573 n15696 VDD VSS n15695 NOR2X1
XU16760 n15697 n15582 VDD VSS n15693 NOR2X1
XU16761 n15698 n15699 VDD VSS n15697 NOR2X1
XU16762 n15700 n15701 VDD VSS n15699 NAND2X1
XU16763 n15570 n15593 VDD VSS n15701 NAND2X1
XU16764 n15583 VDD VSS n15570 INVX1
XU16765 g3086 n15587 VDD VSS n15700 NAND2X1
XU16766 n15573 VDD VSS n15587 INVX1
XU16767 n15702 g3197 VDD VSS n15573 NAND2X1
XU16768 n15703 g3204 VDD VSS n15702 AND2X1
XU16769 n15616 n10975 VDD VSS n15698 NOR2X1
XU16770 g3210 VDD VSS n10975 INVX1
XU16771 n15704 n15705 VDD VSS n15691 NOR2X1
XU16772 n15619 n10918 VDD VSS n15705 NOR2X1
XU16773 g3095 VDD VSS n10918 INVX1
XU16774 n15616 n15706 VDD VSS n15619 OR2X1
XU16775 n15620 n10881 VDD VSS n15704 NOR2X1
XU16776 g3093 VDD VSS n10881 INVX1
XU16777 n15707 n15685 VDD VSS n15620 NAND2X1
XU16778 n15616 n15708 VDD VSS n15685 NOR2X1
XU16779 g3207 g3188 VDD VSS n15707 NOR2X1
XU16780 n15709 n15710 VDD VSS n15674 AND2X1
XU16781 n15711 n15712 VDD VSS n15710 NOR2X1
XU16782 n15713 n15714 VDD VSS n15712 NAND2X1
XU16783 g3136 n15579 VDD VSS n15714 NAND2X1
XU16784 n15715 n15586 VDD VSS n15579 AND2X1
XU16785 n15568 VDD VSS n15586 INVX1
XU16786 g3201 n15686 VDD VSS n15568 NAND2X1
XU16787 g3207 VDD VSS n15686 INVX1
XU16788 g3188 n15716 VDD VSS n15715 NOR2X1
XU16789 g3142 n15566 VDD VSS n15713 NAND2X1
XU16790 n15706 n15716 VDD VSS n15566 NOR2X1
XU16791 n15717 n15718 VDD VSS n15711 NAND2X1
XU16792 g3085 n15630 VDD VSS n15718 NAND2X1
XU16793 n15719 g3188 VDD VSS n15630 AND2X1
XU16794 n15616 n15696 VDD VSS n15719 NOR2X1
XU16795 g3084 n15631 VDD VSS n15717 NAND2X1
XU16796 n15658 VDD VSS n15631 INVX1
XU16797 n15720 n15683 VDD VSS n15658 NAND2X1
XU16798 n15696 VDD VSS n15683 INVX1
XU16799 g3207 n15708 VDD VSS n15696 NAND2X1
XU16800 g3188 n15616 VDD VSS n15720 NOR2X1
XU16801 n15721 n15722 VDD VSS n15709 NOR2X1
XU16802 n15563 n15723 VDD VSS n15722 NAND2X1
XU16803 g3132 n15637 VDD VSS n15723 NAND2X1
XU16804 n15724 n15725 VDD VSS n15721 NAND2X1
XU16805 g3211 n15627 VDD VSS n15725 NAND2X1
XU16806 n15690 n15616 VDD VSS n15627 NOR2X1
XU16807 n15726 g3197 VDD VSS n15616 NAND2X1
XU16808 g3204 n15727 VDD VSS n15726 NOR2X1
XU16809 n15728 g3188 VDD VSS n15690 NAND2X1
XU16810 g3120 n15636 VDD VSS n15724 NAND2X1
XU16811 n15729 n15730 VDD VSS g25489 NAND2X1
XU16812 n15731 n15732 VDD VSS n15730 NAND2X1
XU16813 g3147 VDD VSS n15732 INVX1
XU16814 n15733 n15734 VDD VSS n15731 NAND2X1
XU16815 n15735 n15736 VDD VSS n15734 NAND2X1
XU16816 g3151 VDD VSS n15736 INVX1
XU16817 n15591 g3142 VDD VSS n15735 NAND2X1
XU16818 g2991 g2992 VDD VSS n15591 NOR2X1
XU16819 n15593 n15737 VDD VSS n15733 NAND2X1
XU16820 g2984 g2985 VDD VSS n15593 OR2X1
XU16821 n15738 g3147 VDD VSS n15729 NAND2X1
XU16822 n15737 n15739 VDD VSS n15738 NOR2X1
XU16823 g3151 g3097 VDD VSS n15739 NAND2X1
XU16824 g3142 VDD VSS n15737 INVX1
XU16825 n15740 n15563 VDD VSS g24925 NAND2X1
XU16826 n15741 n15742 VDD VSS n15740 AND2X1
XU16827 g3111 n15636 VDD VSS n15742 NAND2X1
XU16828 g3124 n15637 VDD VSS n15741 NAND2X1
XU16829 n15743 n15563 VDD VSS g24909 NAND2X1
XU16830 n15744 n15745 VDD VSS n15743 NOR2X1
XU16831 g3125 n15578 VDD VSS n15745 NOR2X1
XU16832 g3110 n15636 VDD VSS n15744 AND2X1
XU16833 n15746 n15563 VDD VSS g24890 NAND2X1
XU16834 n15747 n15748 VDD VSS n15746 AND2X1
XU16835 g3112 n15636 VDD VSS n15748 NAND2X1
XU16836 n15716 n15582 VDD VSS n15636 NOR2X1
XU16837 n15728 n15571 VDD VSS n15582 NAND2X1
XU16838 g3188 VDD VSS n15571 INVX1
XU16839 g3207 g3201 VDD VSS n15728 NOR2X1
XU16840 n15749 g3204 VDD VSS n15716 NAND2X1
XU16841 g3197 n15727 VDD VSS n15749 NOR2X1
XU16842 n15703 VDD VSS n15727 INVX1
XU16843 g3126 n15637 VDD VSS n15747 NAND2X1
XU16844 n15563 n15750 VDD VSS g23919 NAND2X1
XU16845 g3123 n15578 VDD VSS n15750 OR2X1
XU16846 n15637 VDD VSS n15578 INVX1
XU16847 n15583 n15706 VDD VSS n15637 NOR2X1
XU16848 n15751 g3207 VDD VSS n15706 NAND2X1
XU16849 g3188 n15708 VDD VSS n15751 NOR2X1
XU16850 g3201 VDD VSS n15708 INVX1
XU16851 n15752 n15703 VDD VSS n15583 NAND2X1
XU16852 g3191 n15753 VDD VSS n15703 NOR2X1
XU16853 g3198 g3194 VDD VSS n15753 OR2X1
XU16854 g3204 g3197 VDD VSS n15752 NOR2X1
XU16855 n15632 VDD VSS n15563 INVX1
XU16856 g3233 n15754 VDD VSS n15632 NAND2X1
XU16857 g3230 VDD VSS n15754 INVX1
XU16858 g2987 n15755 VDD VSS g16496 NAND2X1
XU16859 g5388 n15756 VDD VSS n15755 NAND2X1
XU16860 g2986 VDD VSS n15756 INVX1
XU16861 n15757 n8611 VDD VSS N930 XOR2X1
XU16862 n15758 n15759 VDD VSS n8611 XOR2X1
XU16863 n15760 n15761 VDD VSS n15759 XOR2X1
XU16864 g23 g20 VDD VSS n15761 XOR2X1
XU16865 g8 g5 VDD VSS n15760 XOR2X1
XU16866 n15762 n15763 VDD VSS n15758 XOR2X1
XU16867 g2 g17 VDD VSS n15763 XOR2X1
XU16868 g11 g14 VDD VSS n15762 XOR2X1
XU16869 n15757 n8613 VDD VSS N478 XOR2X1
XU16870 n15764 n15765 VDD VSS n8613 XOR2X1
XU16871 n15766 n15767 VDD VSS n15765 XOR2X1
XU16872 g42 g39 VDD VSS n15767 XOR2X1
XU16873 g48 g45 VDD VSS n15766 XOR2X1
XU16874 n15768 n15769 VDD VSS n15764 XOR2X1
XU16875 g36 g33 VDD VSS n15769 XOR2X1
XU16876 g27 g30 VDD VSS n15768 XOR2X1
XU16877 g3136 n13965 VDD VSS n15757 NAND2X1
XU16878 g3231 VDD VSS n13965 INVX1
XU16879 n13964 g2934 VDD VSS N466 XOR2X1
XU16880 n15770 n15771 VDD VSS n13964 XOR2X1
XU16881 n15772 n15773 VDD VSS n15771 XOR2X1
XU16882 g2953 g2947 VDD VSS n15773 XOR2X1
XU16883 g2959 g2956 VDD VSS n15772 XOR2X1
XU16884 n15774 n15775 VDD VSS n15770 XOR2X1
XU16885 g2944 g2941 VDD VSS n15775 XOR2X1
XU16886 n13919 g2938 VDD VSS n15774 XOR2X1
XU16887 g2935 VDD VSS n13919 INVX1
XU16888 n13956 g2962 VDD VSS N461 XOR2X1
XU16889 n15776 n15777 VDD VSS n13956 XOR2X1
XU16890 n15778 n15779 VDD VSS n15777 XOR2X1
XU16891 g2975 g2972 VDD VSS n15779 XOR2X1
XU16892 g2981 g2978 VDD VSS n15778 XOR2X1
XU16893 n15780 n15781 VDD VSS n15776 XOR2X1
XU16894 g2969 g2966 VDD VSS n15781 XOR2X1
XU16895 n13922 g2963 VDD VSS n15780 XOR2X1
XU16896 g2874 VDD VSS n13922 INVX1
XU16897 n15782 n15783 VDD VSS N1768 NAND2X1
XU16898 n15784 n15785 VDD VSS n15783 NAND2X1
XU16899 n15786 n15787 VDD VSS n15785 NOR2X1
XU16900 n15788 n15789 VDD VSS n15787 NAND2X1
XU16901 g2151 n11363 VDD VSS n15789 XOR2X1
XU16902 n15790 n15791 VDD VSS n15788 NOR2X1
XU16903 g2120 n11303 VDD VSS n15791 XOR2X1
XU16904 g2124 n11307 VDD VSS n15790 XOR2X1
XU16905 n15792 n15793 VDD VSS n15786 NAND2X1
XU16906 g2147 n11344 VDD VSS n15793 XOR2X1
XU16907 n8995 n14503 VDD VSS n15792 AND2X1
XU16908 n15794 n11226 VDD VSS n8995 NAND2X1
XU16909 n11422 VDD VSS n11226 INVX1
XU16910 n11433 n11418 VDD VSS n15794 NOR2X1
XU16911 n11402 VDD VSS n11418 INVX1
XU16912 n15795 n15796 VDD VSS n15784 NOR2X1
XU16913 n15797 n15798 VDD VSS n15796 NAND2X1
XU16914 g2160 n11287 VDD VSS n15798 XOR2X1
XU16915 n11382 VDD VSS n11287 INVX1
XU16916 n15799 n15800 VDD VSS n15797 NOR2X1
XU16917 n14341 n11518 VDD VSS n15800 XOR2X1
XU16918 g2156 VDD VSS n14341 INVX1
XU16919 g2142 n11273 VDD VSS n15799 XOR2X1
XU16920 n15801 n15802 VDD VSS n15795 NAND2X1
XU16921 n14325 n11259 VDD VSS n15802 XOR2X1
XU16922 g2138 VDD VSS n14325 INVX1
XU16923 n15803 n15804 VDD VSS n15801 NOR2X1
XU16924 n14317 n11327 VDD VSS n15804 XOR2X1
XU16925 n11329 VDD VSS n11327 INVX1
XU16926 g2129 VDD VSS n14317 INVX1
XU16927 g2133 n11241 VDD VSS n15803 XOR2X1
XU16928 n8986 n11536 VDD VSS n15782 OR2X1
XU16929 n15805 n15806 VDD VSS n11536 NAND2X1
XU16930 n11303 n15807 VDD VSS n15806 NOR2X1
XU16931 n11363 n15808 VDD VSS n15807 NAND2X1
XU16932 n11307 VDD VSS n15808 INVX1
XU16933 n15809 n15810 VDD VSS n11307 NAND2X1
XU16934 g2300 g7084 VDD VSS n15810 NAND2X1
XU16935 n15811 n15812 VDD VSS n15809 NOR2X1
XU16936 n11109 n11311 VDD VSS n15812 NOR2X1
XU16937 g2297 VDD VSS n11311 INVX1
XU16938 n11110 n11317 VDD VSS n15811 NOR2X1
XU16939 g2303 VDD VSS n11317 INVX1
XU16940 n11520 VDD VSS n11363 INVX1
XU16941 n15813 n15814 VDD VSS n11520 NAND2X1
XU16942 g2273 g7084 VDD VSS n15814 NAND2X1
XU16943 n15815 n15816 VDD VSS n15813 NOR2X1
XU16944 n11109 n11350 VDD VSS n15816 NOR2X1
XU16945 g2270 VDD VSS n11350 INVX1
XU16946 n11110 n11356 VDD VSS n15815 NOR2X1
XU16947 g2276 VDD VSS n11356 INVX1
XU16948 n15817 n15818 VDD VSS n11303 NAND2X1
XU16949 g2345 g7084 VDD VSS n15818 NAND2X1
XU16950 n15819 n15820 VDD VSS n15817 NOR2X1
XU16951 n11109 n11291 VDD VSS n15820 NOR2X1
XU16952 g2342 VDD VSS n11291 INVX1
XU16953 n11110 n11297 VDD VSS n15819 NOR2X1
XU16954 g2348 VDD VSS n11297 INVX1
XU16955 n11542 n15821 VDD VSS n15805 NOR2X1
XU16956 n11518 n11344 VDD VSS n15821 NAND2X1
XU16957 n11511 VDD VSS n11344 INVX1
XU16958 n15822 n15823 VDD VSS n11511 NAND2X1
XU16959 g2318 g7084 VDD VSS n15823 NAND2X1
XU16960 n15824 n15825 VDD VSS n15822 NOR2X1
XU16961 n11109 n11332 VDD VSS n15825 NOR2X1
XU16962 g2315 VDD VSS n11332 INVX1
XU16963 n11110 n11338 VDD VSS n15824 NOR2X1
XU16964 g2321 VDD VSS n11338 INVX1
XU16965 n11379 VDD VSS n11518 INVX1
XU16966 n15826 n15827 VDD VSS n11379 NAND2X1
XU16967 g2309 g7084 VDD VSS n15827 NAND2X1
XU16968 n15828 n15829 VDD VSS n15826 NOR2X1
XU16969 n11109 n11367 VDD VSS n15829 NOR2X1
XU16970 g2306 VDD VSS n11367 INVX1
XU16971 n11110 n11373 VDD VSS n15828 NOR2X1
XU16972 g2312 VDD VSS n11373 INVX1
XU16973 n15830 n15831 VDD VSS n11542 NAND2X1
XU16974 n11382 n15832 VDD VSS n15831 NOR2X1
XU16975 n11508 n11521 VDD VSS n15832 NAND2X1
XU16976 n11241 VDD VSS n11521 INVX1
XU16977 n15833 n15834 VDD VSS n11241 NAND2X1
XU16978 g2291 g7084 VDD VSS n15834 NAND2X1
XU16979 n15835 n15836 VDD VSS n15833 NOR2X1
XU16980 n11109 n11230 VDD VSS n15836 NOR2X1
XU16981 g2288 VDD VSS n11230 INVX1
XU16982 n11110 n11236 VDD VSS n15835 NOR2X1
XU16983 g2294 VDD VSS n11236 INVX1
XU16984 n11273 VDD VSS n11508 INVX1
XU16985 n15837 n15838 VDD VSS n11273 NAND2X1
XU16986 g2282 g7084 VDD VSS n15838 NAND2X1
XU16987 n15839 n15840 VDD VSS n15837 NOR2X1
XU16988 n11109 n11263 VDD VSS n15840 NOR2X1
XU16989 g2279 VDD VSS n11263 INVX1
XU16990 n11110 n11269 VDD VSS n15839 NOR2X1
XU16991 g2285 VDD VSS n11269 INVX1
XU16992 n15841 n15842 VDD VSS n11382 NAND2X1
XU16993 g2264 g7084 VDD VSS n15842 NAND2X1
XU16994 n15843 n15844 VDD VSS n15841 NOR2X1
XU16995 n11109 n11277 VDD VSS n15844 NOR2X1
XU16996 g2261 VDD VSS n11277 INVX1
XU16997 n11110 n11283 VDD VSS n15843 NOR2X1
XU16998 g2267 VDD VSS n11283 INVX1
XU16999 n11329 n11259 VDD VSS n15830 NOR2X1
XU17000 n15845 n15846 VDD VSS n11259 NAND2X1
XU17001 g2327 g7084 VDD VSS n15846 NAND2X1
XU17002 n15847 n15848 VDD VSS n15845 NOR2X1
XU17003 n11109 n11250 VDD VSS n15848 NOR2X1
XU17004 g2324 VDD VSS n11250 INVX1
XU17005 n11110 n11246 VDD VSS n15847 NOR2X1
XU17006 g2330 VDD VSS n11246 INVX1
XU17007 n15849 n15850 VDD VSS n11329 NAND2X1
XU17008 g2336 g7084 VDD VSS n15850 NAND2X1
XU17009 n15851 n15852 VDD VSS n15849 NOR2X1
XU17010 n11109 n11496 VDD VSS n15852 NOR2X1
XU17011 g2333 VDD VSS n11496 INVX1
XU17012 g6837 VDD VSS n11109 INVX1
XU17013 n11110 n11493 VDD VSS n15851 NOR2X1
XU17014 g2339 VDD VSS n11493 INVX1
XU17015 g2241 VDD VSS n11110 INVX1
XU17016 n15853 n11433 VDD VSS n8986 NAND2X1
XU17017 n11427 VDD VSS n11433 INVX1
XU17018 n15854 n15855 VDD VSS n11427 NAND2X1
XU17019 g2476 n11447 VDD VSS n15855 NAND2X1
XU17020 g2392 VDD VSS n11447 INVX1
XU17021 n15856 n15857 VDD VSS n15854 NOR2X1
XU17022 g2391 n10188 VDD VSS n15857 NOR2X1
XU17023 g2390 n11041 VDD VSS n15856 NOR2X1
XU17024 n11422 n11402 VDD VSS n15853 NOR2X1
XU17025 n15858 n15859 VDD VSS n11402 NAND2X1
XU17026 g2476 n11415 VDD VSS n15859 NAND2X1
XU17027 g2395 VDD VSS n11415 INVX1
XU17028 n15860 n15861 VDD VSS n15858 NOR2X1
XU17029 g2394 n10188 VDD VSS n15861 NOR2X1
XU17030 g2393 n11041 VDD VSS n15860 NOR2X1
XU17031 n15862 n15863 VDD VSS n11422 NAND2X1
XU17032 g2476 n11219 VDD VSS n15863 NAND2X1
XU17033 g2389 VDD VSS n11219 INVX1
XU17034 n15864 n15865 VDD VSS n15862 NOR2X1
XU17035 g2388 n10188 VDD VSS n15865 NOR2X1
XU17036 g7264 VDD VSS n10188 INVX1
XU17037 g2387 n11041 VDD VSS n15864 NOR2X1
XU17038 g5555 VDD VSS n11041 INVX1
XU17039 n15866 n15867 VDD VSS N1766 NAND2X1
XU17040 n15868 n15869 VDD VSS n15867 NAND2X1
XU17041 n15870 n15871 VDD VSS n15869 NOR2X1
XU17042 n15872 n15873 VDD VSS n15871 NAND2X1
XU17043 g1457 n13544 VDD VSS n15873 XOR2X1
XU17044 n15874 n15875 VDD VSS n15872 NOR2X1
XU17045 g1426 n13484 VDD VSS n15875 XOR2X1
XU17046 g1430 n13488 VDD VSS n15874 XOR2X1
XU17047 n15876 n15877 VDD VSS n15870 NAND2X1
XU17048 g1453 n13525 VDD VSS n15877 XOR2X1
XU17049 n9347 n14503 VDD VSS n15876 AND2X1
XU17050 n15878 n13407 VDD VSS n9347 NAND2X1
XU17051 n13603 VDD VSS n13407 INVX1
XU17052 n13614 n13599 VDD VSS n15878 NOR2X1
XU17053 n13583 VDD VSS n13599 INVX1
XU17054 n15879 n15880 VDD VSS n15868 NOR2X1
XU17055 n15881 n15882 VDD VSS n15880 NAND2X1
XU17056 g1466 n13468 VDD VSS n15882 XOR2X1
XU17057 n13563 VDD VSS n13468 INVX1
XU17058 n15883 n15884 VDD VSS n15881 NOR2X1
XU17059 n14304 n13699 VDD VSS n15884 XOR2X1
XU17060 g1462 VDD VSS n14304 INVX1
XU17061 g1448 n13454 VDD VSS n15883 XOR2X1
XU17062 n15885 n15886 VDD VSS n15879 NAND2X1
XU17063 n14288 n13440 VDD VSS n15886 XOR2X1
XU17064 g1444 VDD VSS n14288 INVX1
XU17065 n15887 n15888 VDD VSS n15885 NOR2X1
XU17066 n14280 n13508 VDD VSS n15888 XOR2X1
XU17067 n13510 VDD VSS n13508 INVX1
XU17068 g1435 VDD VSS n14280 INVX1
XU17069 g1439 n13422 VDD VSS n15887 XOR2X1
XU17070 n9338 n13717 VDD VSS n15866 OR2X1
XU17071 n15889 n15890 VDD VSS n13717 NAND2X1
XU17072 n13484 n15891 VDD VSS n15890 NOR2X1
XU17073 n13544 n15892 VDD VSS n15891 NAND2X1
XU17074 n13488 VDD VSS n15892 INVX1
XU17075 n15893 n15894 VDD VSS n13488 NAND2X1
XU17076 g1606 g6782 VDD VSS n15894 NAND2X1
XU17077 n15895 n15896 VDD VSS n15893 NOR2X1
XU17078 n13290 n13492 VDD VSS n15896 NOR2X1
XU17079 g1603 VDD VSS n13492 INVX1
XU17080 n13291 n13498 VDD VSS n15895 NOR2X1
XU17081 g1609 VDD VSS n13498 INVX1
XU17082 n13701 VDD VSS n13544 INVX1
XU17083 n15897 n15898 VDD VSS n13701 NAND2X1
XU17084 g1579 g6782 VDD VSS n15898 NAND2X1
XU17085 n15899 n15900 VDD VSS n15897 NOR2X1
XU17086 n13290 n13531 VDD VSS n15900 NOR2X1
XU17087 g1576 VDD VSS n13531 INVX1
XU17088 n13291 n13537 VDD VSS n15899 NOR2X1
XU17089 g1582 VDD VSS n13537 INVX1
XU17090 n15901 n15902 VDD VSS n13484 NAND2X1
XU17091 g1651 g6782 VDD VSS n15902 NAND2X1
XU17092 n15903 n15904 VDD VSS n15901 NOR2X1
XU17093 n13290 n13478 VDD VSS n15904 NOR2X1
XU17094 g1648 VDD VSS n13478 INVX1
XU17095 n13291 n13475 VDD VSS n15903 NOR2X1
XU17096 g1654 VDD VSS n13475 INVX1
XU17097 n13723 n15905 VDD VSS n15889 NOR2X1
XU17098 n13699 n13525 VDD VSS n15905 NAND2X1
XU17099 n13692 VDD VSS n13525 INVX1
XU17100 n15906 n15907 VDD VSS n13692 NAND2X1
XU17101 g1624 g6782 VDD VSS n15907 NAND2X1
XU17102 n15908 n15909 VDD VSS n15906 NOR2X1
XU17103 n13290 n13513 VDD VSS n15909 NOR2X1
XU17104 g1621 VDD VSS n13513 INVX1
XU17105 n13291 n13519 VDD VSS n15908 NOR2X1
XU17106 g1627 VDD VSS n13519 INVX1
XU17107 n13560 VDD VSS n13699 INVX1
XU17108 n15910 n15911 VDD VSS n13560 NAND2X1
XU17109 g1615 g6782 VDD VSS n15911 NAND2X1
XU17110 n15912 n15913 VDD VSS n15910 NOR2X1
XU17111 n13290 n13548 VDD VSS n15913 NOR2X1
XU17112 g1612 VDD VSS n13548 INVX1
XU17113 n13291 n13554 VDD VSS n15912 NOR2X1
XU17114 g1618 VDD VSS n13554 INVX1
XU17115 n15914 n15915 VDD VSS n13723 NAND2X1
XU17116 n13563 n15916 VDD VSS n15915 NOR2X1
XU17117 n13689 n13702 VDD VSS n15916 NAND2X1
XU17118 n13422 VDD VSS n13702 INVX1
XU17119 n15917 n15918 VDD VSS n13422 NAND2X1
XU17120 g1597 g6782 VDD VSS n15918 NAND2X1
XU17121 n15919 n15920 VDD VSS n15917 NOR2X1
XU17122 n13290 n13411 VDD VSS n15920 NOR2X1
XU17123 g1594 VDD VSS n13411 INVX1
XU17124 n13291 n13417 VDD VSS n15919 NOR2X1
XU17125 g1600 VDD VSS n13417 INVX1
XU17126 n13454 VDD VSS n13689 INVX1
XU17127 n15921 n15922 VDD VSS n13454 NAND2X1
XU17128 g1588 g6782 VDD VSS n15922 NAND2X1
XU17129 n15923 n15924 VDD VSS n15921 NOR2X1
XU17130 n13290 n13444 VDD VSS n15924 NOR2X1
XU17131 g1585 VDD VSS n13444 INVX1
XU17132 n13291 n13450 VDD VSS n15923 NOR2X1
XU17133 g1591 VDD VSS n13450 INVX1
XU17134 n15925 n15926 VDD VSS n13563 NAND2X1
XU17135 g1570 g6782 VDD VSS n15926 NAND2X1
XU17136 n15927 n15928 VDD VSS n15925 NOR2X1
XU17137 n13290 n13464 VDD VSS n15928 NOR2X1
XU17138 g1567 VDD VSS n13464 INVX1
XU17139 n13291 n13461 VDD VSS n15927 NOR2X1
XU17140 g1573 VDD VSS n13461 INVX1
XU17141 n13510 n13440 VDD VSS n15914 NOR2X1
XU17142 n15929 n15930 VDD VSS n13440 NAND2X1
XU17143 g1633 g6782 VDD VSS n15930 NAND2X1
XU17144 n15931 n15932 VDD VSS n15929 NOR2X1
XU17145 n13290 n13427 VDD VSS n15932 NOR2X1
XU17146 g1630 VDD VSS n13427 INVX1
XU17147 n13291 n13433 VDD VSS n15931 NOR2X1
XU17148 g1636 VDD VSS n13433 INVX1
XU17149 n15933 n15934 VDD VSS n13510 NAND2X1
XU17150 g1642 g6782 VDD VSS n15934 NAND2X1
XU17151 n15935 n15936 VDD VSS n15933 NOR2X1
XU17152 n13290 n13675 VDD VSS n15936 NOR2X1
XU17153 g1639 VDD VSS n13675 INVX1
XU17154 g6573 VDD VSS n13290 INVX1
XU17155 n13291 n13671 VDD VSS n15935 NOR2X1
XU17156 g1645 VDD VSS n13671 INVX1
XU17157 g1547 VDD VSS n13291 INVX1
XU17158 n15937 n13614 VDD VSS n9338 NAND2X1
XU17159 n13608 VDD VSS n13614 INVX1
XU17160 n15938 n15939 VDD VSS n13608 NAND2X1
XU17161 g1782 n13628 VDD VSS n15939 NAND2X1
XU17162 g1698 VDD VSS n13628 INVX1
XU17163 n15940 n15941 VDD VSS n15938 NOR2X1
XU17164 g1697 n10163 VDD VSS n15941 NOR2X1
XU17165 g1696 n13222 VDD VSS n15940 NOR2X1
XU17166 n13603 n13583 VDD VSS n15937 NOR2X1
XU17167 n15942 n15943 VDD VSS n13583 NAND2X1
XU17168 g1782 n13596 VDD VSS n15943 NAND2X1
XU17169 g1701 VDD VSS n13596 INVX1
XU17170 n15944 n15945 VDD VSS n15942 NOR2X1
XU17171 g1700 n10163 VDD VSS n15945 NOR2X1
XU17172 g1699 n13222 VDD VSS n15944 NOR2X1
XU17173 n15946 n15947 VDD VSS n13603 NAND2X1
XU17174 g1782 n13400 VDD VSS n15947 NAND2X1
XU17175 g1695 VDD VSS n13400 INVX1
XU17176 n15948 n15949 VDD VSS n15946 NOR2X1
XU17177 g1694 n10163 VDD VSS n15949 NOR2X1
XU17178 g7014 VDD VSS n10163 INVX1
XU17179 g1693 n13222 VDD VSS n15948 NOR2X1
XU17180 g5511 VDD VSS n13222 INVX1
XU17181 n15950 n15951 VDD VSS N1764 NAND2X1
XU17182 n15952 n15953 VDD VSS n15951 NAND2X1
XU17183 n15954 n15955 VDD VSS n15953 NOR2X1
XU17184 n15956 n15957 VDD VSS n15955 NAND2X1
XU17185 g771 n12965 VDD VSS n15957 XOR2X1
XU17186 n15958 n15959 VDD VSS n15956 NOR2X1
XU17187 g740 n12767 VDD VSS n15959 XOR2X1
XU17188 g744 n12787 VDD VSS n15958 XOR2X1
XU17189 n15960 n15961 VDD VSS n15954 NAND2X1
XU17190 n14259 n12805 VDD VSS n15961 XOR2X1
XU17191 g767 VDD VSS n14259 INVX1
XU17192 n9698 n14503 VDD VSS n15960 AND2X1
XU17193 n15962 n12690 VDD VSS n9698 NAND2X1
XU17194 n12879 VDD VSS n12690 INVX1
XU17195 n12890 n12875 VDD VSS n15962 NOR2X1
XU17196 n12859 VDD VSS n12875 INVX1
XU17197 n15963 n15964 VDD VSS n15952 NOR2X1
XU17198 n15965 n15966 VDD VSS n15964 NAND2X1
XU17199 n15967 n12751 VDD VSS n15966 XOR2X1
XU17200 g780 VDD VSS n15967 INVX1
XU17201 n15968 n15969 VDD VSS n15965 NOR2X1
XU17202 n14267 n12990 VDD VSS n15969 XOR2X1
XU17203 n12838 VDD VSS n12990 INVX1
XU17204 g776 VDD VSS n14267 INVX1
XU17205 g762 n12737 VDD VSS n15968 XOR2X1
XU17206 n15970 n15971 VDD VSS n15963 NAND2X1
XU17207 n14251 n12723 VDD VSS n15971 XOR2X1
XU17208 g758 VDD VSS n14251 INVX1
XU17209 n15972 n15973 VDD VSS n15970 NOR2X1
XU17210 g749 n12790 VDD VSS n15973 XOR2X1
XU17211 g753 n12705 VDD VSS n15972 XOR2X1
XU17212 n9689 n12982 VDD VSS n15950 OR2X1
XU17213 n15974 n15975 VDD VSS n12982 NAND2X1
XU17214 n12767 n15976 VDD VSS n15975 NOR2X1
XU17215 n12965 n12771 VDD VSS n15976 NAND2X1
XU17216 n12787 VDD VSS n12771 INVX1
XU17217 n15977 n15978 VDD VSS n12787 NAND2X1
XU17218 g915 g853 VDD VSS n15978 NAND2X1
XU17219 n15979 n15980 VDD VSS n15977 NOR2X1
XU17220 n12574 n12778 VDD VSS n15980 NOR2X1
XU17221 g912 VDD VSS n12778 INVX1
XU17222 n12575 n12774 VDD VSS n15979 NOR2X1
XU17223 g909 VDD VSS n12774 INVX1
XU17224 n12823 VDD VSS n12965 INVX1
XU17225 n15981 n15982 VDD VSS n12823 NAND2X1
XU17226 g888 g853 VDD VSS n15982 NAND2X1
XU17227 n15983 n15984 VDD VSS n15981 NOR2X1
XU17228 n12574 n12809 VDD VSS n15984 NOR2X1
XU17229 g885 VDD VSS n12809 INVX1
XU17230 n12575 n12815 VDD VSS n15983 NOR2X1
XU17231 g882 VDD VSS n12815 INVX1
XU17232 n15985 n15986 VDD VSS n12767 NAND2X1
XU17233 g960 g853 VDD VSS n15986 NAND2X1
XU17234 n15987 n15988 VDD VSS n15985 NOR2X1
XU17235 n12574 n12761 VDD VSS n15988 NOR2X1
XU17236 g957 VDD VSS n12761 INVX1
XU17237 n12575 n12758 VDD VSS n15987 NOR2X1
XU17238 g954 VDD VSS n12758 INVX1
XU17239 n12989 n15989 VDD VSS n15974 NOR2X1
XU17240 n12838 n12805 VDD VSS n15989 OR2X1
XU17241 n15990 n15991 VDD VSS n12805 NAND2X1
XU17242 g933 g853 VDD VSS n15991 NAND2X1
XU17243 n15992 n15993 VDD VSS n15990 NOR2X1
XU17244 n12574 n12797 VDD VSS n15993 NOR2X1
XU17245 g930 VDD VSS n12797 INVX1
XU17246 n12575 n12793 VDD VSS n15992 NOR2X1
XU17247 g927 VDD VSS n12793 INVX1
XU17248 n15994 n15995 VDD VSS n12838 NAND2X1
XU17249 g924 g853 VDD VSS n15995 NAND2X1
XU17250 n15996 n15997 VDD VSS n15994 NOR2X1
XU17251 n12574 n12830 VDD VSS n15997 NOR2X1
XU17252 g921 VDD VSS n12830 INVX1
XU17253 n12575 n12826 VDD VSS n15996 NOR2X1
XU17254 g918 VDD VSS n12826 INVX1
XU17255 n15998 n15999 VDD VSS n12989 NAND2X1
XU17256 n12751 n16000 VDD VSS n15999 NOR2X1
XU17257 n12737 n12705 VDD VSS n16000 OR2X1
XU17258 n16001 n16002 VDD VSS n12705 NAND2X1
XU17259 g906 g853 VDD VSS n16002 NAND2X1
XU17260 n16003 n16004 VDD VSS n16001 NOR2X1
XU17261 n12574 n12698 VDD VSS n16004 NOR2X1
XU17262 g903 VDD VSS n12698 INVX1
XU17263 n12575 n12694 VDD VSS n16003 NOR2X1
XU17264 g900 VDD VSS n12694 INVX1
XU17265 n16005 n16006 VDD VSS n12737 NAND2X1
XU17266 g897 g853 VDD VSS n16006 NAND2X1
XU17267 n16007 n16008 VDD VSS n16005 NOR2X1
XU17268 n12574 n12731 VDD VSS n16008 NOR2X1
XU17269 g894 VDD VSS n12731 INVX1
XU17270 n12575 n12727 VDD VSS n16007 NOR2X1
XU17271 g891 VDD VSS n12727 INVX1
XU17272 n16009 n16010 VDD VSS n12751 NAND2X1
XU17273 g879 g853 VDD VSS n16010 NAND2X1
XU17274 n16011 n16012 VDD VSS n16009 NOR2X1
XU17275 n12574 n12747 VDD VSS n16012 NOR2X1
XU17276 g876 VDD VSS n12747 INVX1
XU17277 n12575 n12744 VDD VSS n16011 NOR2X1
XU17278 g873 VDD VSS n12744 INVX1
XU17279 n12790 n12723 VDD VSS n15998 NOR2X1
XU17280 n16013 n16014 VDD VSS n12723 NAND2X1
XU17281 g942 g853 VDD VSS n16014 NAND2X1
XU17282 n16015 n16016 VDD VSS n16013 NOR2X1
XU17283 n12574 n12714 VDD VSS n16016 NOR2X1
XU17284 g939 VDD VSS n12714 INVX1
XU17285 n12575 n12710 VDD VSS n16015 NOR2X1
XU17286 g936 VDD VSS n12710 INVX1
XU17287 n16017 n16018 VDD VSS n12790 NAND2X1
XU17288 g951 g853 VDD VSS n16018 NAND2X1
XU17289 n16019 n16020 VDD VSS n16017 NOR2X1
XU17290 n12574 n12951 VDD VSS n16020 NOR2X1
XU17291 g948 VDD VSS n12951 INVX1
XU17292 g6518 VDD VSS n12574 INVX1
XU17293 n12575 n12947 VDD VSS n16019 NOR2X1
XU17294 g945 VDD VSS n12947 INVX1
XU17295 g6368 VDD VSS n12575 INVX1
XU17296 n16021 n12890 VDD VSS n9689 NAND2X1
XU17297 n12884 VDD VSS n12890 INVX1
XU17298 n16022 n16023 VDD VSS n12884 NAND2X1
XU17299 g1088 n12904 VDD VSS n16023 NAND2X1
XU17300 g1004 VDD VSS n12904 INVX1
XU17301 n16024 n16025 VDD VSS n16022 NOR2X1
XU17302 g1003 n10170 VDD VSS n16025 NOR2X1
XU17303 g1002 n12506 VDD VSS n16024 NOR2X1
XU17304 n12879 n12859 VDD VSS n16021 NOR2X1
XU17305 n16026 n16027 VDD VSS n12859 NAND2X1
XU17306 g1088 n12872 VDD VSS n16027 NAND2X1
XU17307 g1007 VDD VSS n12872 INVX1
XU17308 n16028 n16029 VDD VSS n16026 NOR2X1
XU17309 g1006 n10170 VDD VSS n16029 NOR2X1
XU17310 g1005 n12506 VDD VSS n16028 NOR2X1
XU17311 g5472 VDD VSS n12506 INVX1
XU17312 n16030 n16031 VDD VSS n12879 NAND2X1
XU17313 g5472 n12678 VDD VSS n16031 NAND2X1
XU17314 g999 VDD VSS n12678 INVX1
XU17315 n16032 n16033 VDD VSS n16030 NOR2X1
XU17316 g1001 n12512 VDD VSS n16033 NOR2X1
XU17317 g1088 VDD VSS n12512 INVX1
XU17318 g1000 n10170 VDD VSS n16032 NOR2X1
XU17319 g6712 VDD VSS n10170 INVX1
XU17320 n16034 n16035 VDD VSS N1762 NAND2X1
XU17321 n16036 n16037 VDD VSS n16035 NAND2X1
XU17322 n16038 n16039 VDD VSS n16037 NOR2X1
XU17323 n16040 n16041 VDD VSS n16039 NAND2X1
XU17324 g83 n12096 VDD VSS n16041 XOR2X1
XU17325 n16042 n16043 VDD VSS n16040 NOR2X1
XU17326 g52 n12036 VDD VSS n16043 XOR2X1
XU17327 g56 n12040 VDD VSS n16042 XOR2X1
XU17328 n16044 n16045 VDD VSS n16038 NAND2X1
XU17329 g79 n12077 VDD VSS n16045 XOR2X1
XU17330 n10202 n14503 VDD VSS n16044 AND2X1
XU17331 n16046 n16047 VDD VSS n14503 NAND2X1
XU17332 g2900 n16048 VDD VSS n16047 NOR2X1
XU17333 g2903 g2908 VDD VSS n16048 OR2X1
XU17334 g2896 g2892 VDD VSS n16046 NOR2X1
XU17335 n16049 n11959 VDD VSS n10202 NAND2X1
XU17336 n12155 VDD VSS n11959 INVX1
XU17337 n12166 n12151 VDD VSS n16049 NOR2X1
XU17338 n12135 VDD VSS n12151 INVX1
XU17339 n16050 n16051 VDD VSS n16036 NOR2X1
XU17340 n16052 n16053 VDD VSS n16051 NAND2X1
XU17341 g92 n12020 VDD VSS n16053 XOR2X1
XU17342 n12115 VDD VSS n12020 INVX1
XU17343 n16054 n16055 VDD VSS n16052 NOR2X1
XU17344 n14230 n12251 VDD VSS n16055 XOR2X1
XU17345 g88 VDD VSS n14230 INVX1
XU17346 g74 n12006 VDD VSS n16054 XOR2X1
XU17347 n16056 n16057 VDD VSS n16050 NAND2X1
XU17348 n14214 n11992 VDD VSS n16057 XOR2X1
XU17349 g70 VDD VSS n14214 INVX1
XU17350 n16058 n16059 VDD VSS n16056 NOR2X1
XU17351 n14206 n12060 VDD VSS n16059 XOR2X1
XU17352 n12062 VDD VSS n12060 INVX1
XU17353 g61 VDD VSS n14206 INVX1
XU17354 g65 n11974 VDD VSS n16058 XOR2X1
XU17355 n10193 n12269 VDD VSS n16034 OR2X1
XU17356 n16060 n16061 VDD VSS n12269 NAND2X1
XU17357 n12036 n16062 VDD VSS n16061 NOR2X1
XU17358 n12096 n16063 VDD VSS n16062 NAND2X1
XU17359 n12040 VDD VSS n16063 INVX1
XU17360 n16064 n16065 VDD VSS n12040 NAND2X1
XU17361 g225 g6313 VDD VSS n16065 NAND2X1
XU17362 n16066 n16067 VDD VSS n16064 NOR2X1
XU17363 n11842 n12044 VDD VSS n16067 NOR2X1
XU17364 g222 VDD VSS n12044 INVX1
XU17365 n11843 n12050 VDD VSS n16066 NOR2X1
XU17366 g228 VDD VSS n12050 INVX1
XU17367 n12253 VDD VSS n12096 INVX1
XU17368 n16068 n16069 VDD VSS n12253 NAND2X1
XU17369 g198 g6313 VDD VSS n16069 NAND2X1
XU17370 n16070 n16071 VDD VSS n16068 NOR2X1
XU17371 n11842 n12087 VDD VSS n16071 NOR2X1
XU17372 g195 VDD VSS n12087 INVX1
XU17373 n11843 n12083 VDD VSS n16070 NOR2X1
XU17374 g201 VDD VSS n12083 INVX1
XU17375 n16072 n16073 VDD VSS n12036 NAND2X1
XU17376 g270 g6313 VDD VSS n16073 NAND2X1
XU17377 n16074 n16075 VDD VSS n16072 NOR2X1
XU17378 n11842 n12024 VDD VSS n16075 NOR2X1
XU17379 g267 VDD VSS n12024 INVX1
XU17380 n11843 n12030 VDD VSS n16074 NOR2X1
XU17381 g273 VDD VSS n12030 INVX1
XU17382 n12275 n16076 VDD VSS n16060 NOR2X1
XU17383 n12251 n12077 VDD VSS n16076 NAND2X1
XU17384 n12244 VDD VSS n12077 INVX1
XU17385 n16077 n16078 VDD VSS n12244 NAND2X1
XU17386 g243 g6313 VDD VSS n16078 NAND2X1
XU17387 n16079 n16080 VDD VSS n16077 NOR2X1
XU17388 n11842 n12065 VDD VSS n16080 NOR2X1
XU17389 g240 VDD VSS n12065 INVX1
XU17390 n11843 n12071 VDD VSS n16079 NOR2X1
XU17391 g246 VDD VSS n12071 INVX1
XU17392 n12112 VDD VSS n12251 INVX1
XU17393 n16081 n16082 VDD VSS n12112 NAND2X1
XU17394 g234 g6313 VDD VSS n16082 NAND2X1
XU17395 n16083 n16084 VDD VSS n16081 NOR2X1
XU17396 n11842 n12100 VDD VSS n16084 NOR2X1
XU17397 g231 VDD VSS n12100 INVX1
XU17398 n11843 n12106 VDD VSS n16083 NOR2X1
XU17399 g237 VDD VSS n12106 INVX1
XU17400 n16085 n16086 VDD VSS n12275 NAND2X1
XU17401 n12115 n16087 VDD VSS n16086 NOR2X1
XU17402 n12241 n12254 VDD VSS n16087 NAND2X1
XU17403 n11974 VDD VSS n12254 INVX1
XU17404 n16088 n16089 VDD VSS n11974 NAND2X1
XU17405 g216 g6313 VDD VSS n16089 NAND2X1
XU17406 n16090 n16091 VDD VSS n16088 NOR2X1
XU17407 n11842 n11963 VDD VSS n16091 NOR2X1
XU17408 g213 VDD VSS n11963 INVX1
XU17409 n11843 n11969 VDD VSS n16090 NOR2X1
XU17410 g219 VDD VSS n11969 INVX1
XU17411 n12006 VDD VSS n12241 INVX1
XU17412 n16092 n16093 VDD VSS n12006 NAND2X1
XU17413 g207 g6313 VDD VSS n16093 NAND2X1
XU17414 n16094 n16095 VDD VSS n16092 NOR2X1
XU17415 n11842 n12002 VDD VSS n16095 NOR2X1
XU17416 g204 VDD VSS n12002 INVX1
XU17417 n11843 n11999 VDD VSS n16094 NOR2X1
XU17418 g210 VDD VSS n11999 INVX1
XU17419 n16096 n16097 VDD VSS n12115 NAND2X1
XU17420 g189 g6313 VDD VSS n16097 NAND2X1
XU17421 n16098 n16099 VDD VSS n16096 NOR2X1
XU17422 n11842 n12010 VDD VSS n16099 NOR2X1
XU17423 g186 VDD VSS n12010 INVX1
XU17424 n11843 n12016 VDD VSS n16098 NOR2X1
XU17425 g192 VDD VSS n12016 INVX1
XU17426 n12062 n11992 VDD VSS n16085 NOR2X1
XU17427 n16100 n16101 VDD VSS n11992 NAND2X1
XU17428 g252 g6313 VDD VSS n16101 NAND2X1
XU17429 n16102 n16103 VDD VSS n16100 NOR2X1
XU17430 n11842 n11979 VDD VSS n16103 NOR2X1
XU17431 g249 VDD VSS n11979 INVX1
XU17432 n11843 n11985 VDD VSS n16102 NOR2X1
XU17433 g255 VDD VSS n11985 INVX1
XU17434 n16104 n16105 VDD VSS n12062 NAND2X1
XU17435 g261 g6313 VDD VSS n16105 NAND2X1
XU17436 n16106 n16107 VDD VSS n16104 NOR2X1
XU17437 n11842 n12223 VDD VSS n16107 NOR2X1
XU17438 g258 VDD VSS n12223 INVX1
XU17439 g6231 VDD VSS n11842 INVX1
XU17440 n11843 n12229 VDD VSS n16106 NOR2X1
XU17441 g264 VDD VSS n12229 INVX1
XU17442 g165 VDD VSS n11843 INVX1
XU17443 n16108 n12166 VDD VSS n10193 NAND2X1
XU17444 n12160 VDD VSS n12166 INVX1
XU17445 n16109 n16110 VDD VSS n12160 NAND2X1
XU17446 g401 n12180 VDD VSS n16110 NAND2X1
XU17447 g317 VDD VSS n12180 INVX1
XU17448 n16111 n16112 VDD VSS n16109 NOR2X1
XU17449 g316 n11793 VDD VSS n16112 NOR2X1
XU17450 g315 n11773 VDD VSS n16111 NOR2X1
XU17451 n12155 n12135 VDD VSS n16108 NOR2X1
XU17452 n16113 n16114 VDD VSS n12135 NAND2X1
XU17453 g401 n12148 VDD VSS n16114 NAND2X1
XU17454 g320 VDD VSS n12148 INVX1
XU17455 n16115 n16116 VDD VSS n16113 NOR2X1
XU17456 g319 n11793 VDD VSS n16116 NOR2X1
XU17457 g318 n11773 VDD VSS n16115 NOR2X1
XU17458 n16117 n16118 VDD VSS n12155 NAND2X1
XU17459 g401 n11952 VDD VSS n16118 NAND2X1
XU17460 g314 VDD VSS n11952 INVX1
XU17461 n16119 n16120 VDD VSS n16117 NOR2X1
XU17462 g313 n11793 VDD VSS n16120 NOR2X1
XU17463 g6447 VDD VSS n11793 INVX1
XU17464 g312 n11773 VDD VSS n16119 NOR2X1
XU17465 g5437 VDD VSS n11773 INVX1
XU17466 n16121 n8609 VDD VSS N159 NOR2X1
XU17467 g2879 VDD VSS n13892 INVX1
XU17468 g2929 n16122 VDD VSS n16121 NOR2X1
XU17469 g8021 VDD VSS n16122 INVX1
XU17470 n8659 n16123 VDD VSS N1285 NOR2X1
XU17471 n16124 n8658 VDD VSS n16123 NOR2X1
XU17472 n8661 VDD VSS n8658 INVX1
XU17473 n16125 g3018 VDD VSS n8661 NAND2X1
XU17474 g3018 n16125 VDD VSS n16124 NOR2X1
XU17475 n8652 VDD VSS n8659 INVX1
XU17476 n8686 n16126 VDD VSS n8652 NAND2X1
XU17477 n16127 n385 VDD VSS n16126 NAND2X1
XU17478 g3234 VDD VSS n385 INVX1
XU17479 n16128 n16129 VDD VSS n16127 NAND2X1
XU17480 g3036 g3028 VDD VSS n16129 NOR2X1
XU17481 n10867 n10869 VDD VSS n16128 NOR2X1
XU17482 g3032 VDD VSS n10869 INVX1
XU17483 g3018 VDD VSS n10867 INVX1
XU17484 n8664 VDD VSS n8686 INVX1
XU17485 n16125 g3234 VDD VSS n8664 NOR2X1
XU17486 n10870 II20523 VDD VSS n16125 NOR2X1
XU17487 n16130 n16131 VDD VSS n10870 NAND2X1
XU17488 n16132 n16133 VDD VSS n16131 NOR2X1
XU17489 g2998 n8691 VDD VSS n16133 NAND2X1
XU17490 g2993 VDD VSS n8691 INVX1
XU17491 g3006 g3010 VDD VSS n16132 OR2X1
XU17492 n8666 n16134 VDD VSS n16130 NOR2X1
XU17493 g3013 g3002 VDD VSS n16134 NAND2X1
XU17494 g3024 VDD VSS n8666 INVX1
XU17495 n16135 n16136 VDD VSS N1282 NOR2X1
XU17496 n16137 n14523 VDD VSS n16136 NOR2X1
XU17497 n16138 n14498 VDD VSS n14523 NOR2X1
XU17498 n14498 n16138 VDD VSS n16137 AND2X1
XU17499 n14522 VDD VSS n16135 INVX1
XU17500 n14520 n16139 VDD VSS n14522 NAND2X1
XU17501 n16140 n16141 VDD VSS n16139 NAND2X1
XU17502 n16142 n16143 VDD VSS n16140 NAND2X1
XU17503 g2924 g2917 VDD VSS n16143 NOR2X1
XU17504 n14498 n14500 VDD VSS n16142 NOR2X1
XU17505 g2920 VDD VSS n14500 INVX1
XU17506 g2912 VDD VSS n14498 INVX1
XU17507 n16144 n14520 VDD VSS N1202 NOR2X1
XU17508 n16141 n16138 VDD VSS n14520 NAND2X1
XU17509 n16145 n16146 VDD VSS n16138 NAND2X1
XU17510 n16147 n16148 VDD VSS n16146 NOR2X1
XU17511 II20514 g2883 VDD VSS n16148 OR2X1
XU17512 g2896 g2900 VDD VSS n16147 OR2X1
XU17513 n16149 n16150 VDD VSS n16145 NOR2X1
XU17514 g2908 g2903 VDD VSS n16150 NAND2X1
XU17515 g2892 g2888 VDD VSS n16149 NAND2X1
XU17516 g2814 VDD VSS n16141 INVX1
XU17517 n16151 n16152 VDD VSS n16144 NOR2X1
XU17518 n14506 VDD VSS n16152 INVX1
XU17519 g2883 g2950 VDD VSS n14506 NAND2X1
XU17520 g2950 g2883 VDD VSS n16151 NOR2X1
XU17521 g3234 g3079 VDD VSS N1181 NOR2X1
XU17522 g51 g2933 VDD VSS N1004 NOR2X1
XU17523 g2878 VDD VSS II20664 INVX1
XU17524 g2877 VDD VSS II20616 INVX1
XU17525 g2873 VDD VSS II20568 INVX1
XU17526 g3080 VDD VSS II20523 INVX1
XU17527 g2857 VDD VSS II20520 INVX1
XU17528 g2950 VDD VSS II20514 INVX1
XU17529 g2540 VDD VSS II18770 INVX1
XU17530 g2536 VDD VSS II18767 INVX1
XU17531 g2533 VDD VSS II18764 INVX1
XU17532 g2546 VDD VSS II18761 INVX1
XU17533 g2543 VDD VSS II18758 INVX1
XU17534 g2530 VDD VSS II18755 INVX1
XU17535 g2466 VDD VSS II18743 INVX1
XU17536 g2463 VDD VSS II18740 INVX1
XU17537 g2473 VDD VSS II18737 INVX1
XU17538 g2451 VDD VSS II18734 INVX1
XU17539 g2448 VDD VSS II18731 INVX1
XU17540 g2459 VDD VSS II18728 INVX1
XU17541 g2436 VDD VSS II18725 INVX1
XU17542 g2433 VDD VSS II18722 INVX1
XU17543 g2444 VDD VSS II18719 INVX1
XU17544 g2421 VDD VSS II18716 INVX1
XU17545 g2418 VDD VSS II18713 INVX1
XU17546 g2429 VDD VSS II18710 INVX1
XU17547 g1846 VDD VSS II18689 INVX1
XU17548 g1842 VDD VSS II18686 INVX1
XU17549 g1839 VDD VSS II18683 INVX1
XU17550 g1852 VDD VSS II18680 INVX1
XU17551 g1849 VDD VSS II18677 INVX1
XU17552 g1836 VDD VSS II18674 INVX1
XU17553 g1772 VDD VSS II18662 INVX1
XU17554 g1769 VDD VSS II18659 INVX1
XU17555 g1779 VDD VSS II18656 INVX1
XU17556 g1757 VDD VSS II18653 INVX1
XU17557 g1754 VDD VSS II18650 INVX1
XU17558 g1765 VDD VSS II18647 INVX1
XU17559 g1742 VDD VSS II18644 INVX1
XU17560 g1739 VDD VSS II18641 INVX1
XU17561 g1750 VDD VSS II18638 INVX1
XU17562 g1727 VDD VSS II18635 INVX1
XU17563 g1724 VDD VSS II18632 INVX1
XU17564 g1735 VDD VSS II18629 INVX1
XU17565 g1152 VDD VSS II18608 INVX1
XU17566 g1148 VDD VSS II18605 INVX1
XU17567 g1145 VDD VSS II18602 INVX1
XU17568 g1158 VDD VSS II18599 INVX1
XU17569 g1155 VDD VSS II18596 INVX1
XU17570 g1142 VDD VSS II18593 INVX1
XU17571 g1078 VDD VSS II18581 INVX1
XU17572 g1075 VDD VSS II18578 INVX1
XU17573 g1085 VDD VSS II18575 INVX1
XU17574 g1063 VDD VSS II18572 INVX1
XU17575 g1060 VDD VSS II18569 INVX1
XU17576 g1071 VDD VSS II18566 INVX1
XU17577 g1048 VDD VSS II18563 INVX1
XU17578 g1045 VDD VSS II18560 INVX1
XU17579 g1056 VDD VSS II18557 INVX1
XU17580 g1033 VDD VSS II18554 INVX1
XU17581 g1030 VDD VSS II18551 INVX1
XU17582 g1041 VDD VSS II18548 INVX1
XU17583 g465 VDD VSS II18527 INVX1
XU17584 g461 VDD VSS II18524 INVX1
XU17585 g458 VDD VSS II18521 INVX1
XU17586 g471 VDD VSS II18518 INVX1
XU17587 g468 VDD VSS II18515 INVX1
XU17588 g455 VDD VSS II18512 INVX1
XU17589 g391 VDD VSS II18500 INVX1
XU17590 g388 VDD VSS II18497 INVX1
XU17591 g398 VDD VSS II18494 INVX1
XU17592 g376 VDD VSS II18491 INVX1
XU17593 g373 VDD VSS II18488 INVX1
XU17594 g384 VDD VSS II18485 INVX1
XU17595 g361 VDD VSS II18482 INVX1
XU17596 g358 VDD VSS II18479 INVX1
XU17597 g369 VDD VSS II18476 INVX1
XU17598 g346 VDD VSS II18473 INVX1
XU17599 g343 VDD VSS II18470 INVX1
XU17600 g354 VDD VSS II18467 INVX1
XU17601 g2574 VDD VSS II15517 INVX1
XU17602 g1880 VDD VSS II15511 INVX1
XU17603 g1186 VDD VSS II15505 INVX1
XU17604 g499 VDD VSS II15499 INVX1
XU17605 g5637 VDD VSS II14094 INVX1
XU17606 g5612 VDD VSS II14069 INVX1
XU17607 g5595 VDD VSS II14052 INVX1
XU17608 g5549 VDD VSS II14030 INVX1
.ENDS
