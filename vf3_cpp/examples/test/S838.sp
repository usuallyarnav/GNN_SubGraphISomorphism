.SUBCKT s838 CK C_0 C_1 C_10 C_11 C_12 C_13 C_14 C_15 C_16 C_17 C_18 C_19 C_2 C_20 C_21 C_22 C_23 C_24 C_25 C_26 C_27 C_28 C_29 C_3 C_30 C_31 C_32 C_4 C_5 C_6 C_7 C_8 C_9 P_0 Z VDD VSS
M1 I700 NOR2_14/net6 VSS VSS nmos W=0.31u L=0.04u
M2 NOR2_14/X_u2-net6 n123 VSS VSS nmos W=0.31u L=0.04u
M3 NOR2_14/net6 n122 NOR2_14/X_u2-net6 VSS nmos W=0.31u L=0.04u
M4 I700 NOR2_14/net6 VDD VDD pmos W=0.41u L=0.04u
M5 NOR2_14/net6 n123 VDD VDD pmos W=0.41u L=0.04u
M6 NOR2_14/net6 n122 VDD VDD pmos W=0.41u L=0.04u
M7 I602 NOR2_12/net6 VSS VSS nmos W=0.31u L=0.04u
M8 NOR2_12/X_u2-net6 n25 VSS VSS nmos W=0.31u L=0.04u
M9 NOR2_12/net6 n121 NOR2_12/X_u2-net6 VSS nmos W=0.31u L=0.04u
M10 I602 NOR2_12/net6 VDD VDD pmos W=0.41u L=0.04u
M11 NOR2_12/net6 n25 VDD VDD pmos W=0.41u L=0.04u
M12 NOR2_12/net6 n121 VDD VDD pmos W=0.41u L=0.04u
M13 I504 NOR2_10/net6 VSS VSS nmos W=0.31u L=0.04u
M14 NOR2_10/X_u2-net6 n26 VSS VSS nmos W=0.31u L=0.04u
M15 NOR2_10/net6 n120 NOR2_10/X_u2-net6 VSS nmos W=0.31u L=0.04u
M16 I504 NOR2_10/net6 VDD VDD pmos W=0.41u L=0.04u
M17 NOR2_10/net6 n26 VDD VDD pmos W=0.41u L=0.04u
M18 NOR2_10/net6 n120 VDD VDD pmos W=0.41u L=0.04u
M19 I406 NOR2_8/net6 VSS VSS nmos W=0.31u L=0.04u
M20 NOR2_8/X_u2-net6 n27 VSS VSS nmos W=0.31u L=0.04u
M21 NOR2_8/net6 n119 NOR2_8/X_u2-net6 VSS nmos W=0.31u L=0.04u
M22 I406 NOR2_8/net6 VDD VDD pmos W=0.41u L=0.04u
M23 NOR2_8/net6 n27 VDD VDD pmos W=0.41u L=0.04u
M24 NOR2_8/net6 n119 VDD VDD pmos W=0.41u L=0.04u
M25 I308 NOR2_6/net6 VSS VSS nmos W=0.31u L=0.04u
M26 NOR2_6/X_u2-net6 n28 VSS VSS nmos W=0.31u L=0.04u
M27 NOR2_6/net6 n118 NOR2_6/X_u2-net6 VSS nmos W=0.31u L=0.04u
M28 I308 NOR2_6/net6 VDD VDD pmos W=0.41u L=0.04u
M29 NOR2_6/net6 n28 VDD VDD pmos W=0.41u L=0.04u
M30 NOR2_6/net6 n118 VDD VDD pmos W=0.41u L=0.04u
M31 I210 NOR2_4/net6 VSS VSS nmos W=0.31u L=0.04u
M32 NOR2_4/X_u2-net6 n29 VSS VSS nmos W=0.31u L=0.04u
M33 NOR2_4/net6 n117 NOR2_4/X_u2-net6 VSS nmos W=0.31u L=0.04u
M34 I210 NOR2_4/net6 VDD VDD pmos W=0.41u L=0.04u
M35 NOR2_4/net6 n29 VDD VDD pmos W=0.41u L=0.04u
M36 NOR2_4/net6 n117 VDD VDD pmos W=0.41u L=0.04u
M37 I112 NOR2_2/net6 VSS VSS nmos W=0.31u L=0.04u
M38 NOR2_2/X_u2-net6 n30 VSS VSS nmos W=0.31u L=0.04u
M39 NOR2_2/net6 n116 NOR2_2/X_u2-net6 VSS nmos W=0.31u L=0.04u
M40 I112 NOR2_2/net6 VDD VDD pmos W=0.41u L=0.04u
M41 NOR2_2/net6 n30 VDD VDD pmos W=0.41u L=0.04u
M42 NOR2_2/net6 n116 VDD VDD pmos W=0.41u L=0.04u
M43 I14 NOR2_0/net6 VSS VSS nmos W=0.31u L=0.04u
M44 NOR2_0/X_u2-net6 n124 VSS VSS nmos W=0.31u L=0.04u
M45 NOR2_0/net6 n125 NOR2_0/X_u2-net6 VSS nmos W=0.31u L=0.04u
M46 I14 NOR2_0/net6 VDD VDD pmos W=0.41u L=0.04u
M47 NOR2_0/net6 n124 VDD VDD pmos W=0.41u L=0.04u
M48 NOR2_0/net6 n125 VDD VDD pmos W=0.41u L=0.04u
M49 I701 OR2_15/net7 VSS VSS nmos W=0.31u L=0.04u
M50 OR2_15/net7 I770_3 VSS VSS nmos W=0.155u L=0.04u
M51 OR2_15/net7 I770_4 VSS VSS nmos W=0.155u L=0.04u
M52 I701 OR2_15/net7 VDD VDD pmos W=0.41u L=0.04u
M53 OR2_15/X_u7-net8 I770_4 VDD VDD pmos W=0.41u L=0.04u
M54 OR2_15/net7 I770_3 OR2_15/X_u7-net8 VDD pmos W=0.41u L=0.04u
M55 I603 OR2_13/net7 VSS VSS nmos W=0.31u L=0.04u
M56 OR2_13/net7 I676_3 VSS VSS nmos W=0.155u L=0.04u
M57 OR2_13/net7 I676_4 VSS VSS nmos W=0.155u L=0.04u
M58 I603 OR2_13/net7 VDD VDD pmos W=0.41u L=0.04u
M59 OR2_13/X_u7-net8 I676_4 VDD VDD pmos W=0.41u L=0.04u
M60 OR2_13/net7 I676_3 OR2_13/X_u7-net8 VDD pmos W=0.41u L=0.04u
M61 I601 OR2_12/net7 VSS VSS nmos W=0.31u L=0.04u
M62 OR2_12/net7 I661_3 VSS VSS nmos W=0.155u L=0.04u
M63 OR2_12/net7 I661_4 VSS VSS nmos W=0.155u L=0.04u
M64 I601 OR2_12/net7 VDD VDD pmos W=0.41u L=0.04u
M65 OR2_12/X_u7-net8 I661_4 VDD VDD pmos W=0.41u L=0.04u
M66 OR2_12/net7 I661_3 OR2_12/X_u7-net8 VDD pmos W=0.41u L=0.04u
M67 I505 OR2_11/net7 VSS VSS nmos W=0.31u L=0.04u
M68 OR2_11/net7 I578_3 VSS VSS nmos W=0.155u L=0.04u
M69 OR2_11/net7 I578_4 VSS VSS nmos W=0.155u L=0.04u
M70 I505 OR2_11/net7 VDD VDD pmos W=0.41u L=0.04u
M71 OR2_11/X_u7-net8 I578_4 VDD VDD pmos W=0.41u L=0.04u
M72 OR2_11/net7 I578_3 OR2_11/X_u7-net8 VDD pmos W=0.41u L=0.04u
M73 I503 OR2_10/net7 VSS VSS nmos W=0.31u L=0.04u
M74 OR2_10/net7 I563_3 VSS VSS nmos W=0.155u L=0.04u
M75 OR2_10/net7 I563_4 VSS VSS nmos W=0.155u L=0.04u
M76 I503 OR2_10/net7 VDD VDD pmos W=0.41u L=0.04u
M77 OR2_10/X_u7-net8 I563_4 VDD VDD pmos W=0.41u L=0.04u
M78 OR2_10/net7 I563_3 OR2_10/X_u7-net8 VDD pmos W=0.41u L=0.04u
M79 I407 OR2_9/net7 VSS VSS nmos W=0.31u L=0.04u
M80 OR2_9/net7 I480_3 VSS VSS nmos W=0.155u L=0.04u
M81 OR2_9/net7 I480_4 VSS VSS nmos W=0.155u L=0.04u
M82 I407 OR2_9/net7 VDD VDD pmos W=0.41u L=0.04u
M83 OR2_9/X_u7-net8 I480_4 VDD VDD pmos W=0.41u L=0.04u
M84 OR2_9/net7 I480_3 OR2_9/X_u7-net8 VDD pmos W=0.41u L=0.04u
M85 I405 OR2_8/net7 VSS VSS nmos W=0.31u L=0.04u
M86 OR2_8/net7 I465_3 VSS VSS nmos W=0.155u L=0.04u
M87 OR2_8/net7 I465_4 VSS VSS nmos W=0.155u L=0.04u
M88 I405 OR2_8/net7 VDD VDD pmos W=0.41u L=0.04u
M89 OR2_8/X_u7-net8 I465_4 VDD VDD pmos W=0.41u L=0.04u
M90 OR2_8/net7 I465_3 OR2_8/X_u7-net8 VDD pmos W=0.41u L=0.04u
M91 I309 OR2_7/net7 VSS VSS nmos W=0.31u L=0.04u
M92 OR2_7/net7 I382_3 VSS VSS nmos W=0.155u L=0.04u
M93 OR2_7/net7 I382_4 VSS VSS nmos W=0.155u L=0.04u
M94 I309 OR2_7/net7 VDD VDD pmos W=0.41u L=0.04u
M95 OR2_7/X_u7-net8 I382_4 VDD VDD pmos W=0.41u L=0.04u
M96 OR2_7/net7 I382_3 OR2_7/X_u7-net8 VDD pmos W=0.41u L=0.04u
M97 I307 OR2_6/net7 VSS VSS nmos W=0.31u L=0.04u
M98 OR2_6/net7 I367_3 VSS VSS nmos W=0.155u L=0.04u
M99 OR2_6/net7 I367_4 VSS VSS nmos W=0.155u L=0.04u
M100 I307 OR2_6/net7 VDD VDD pmos W=0.41u L=0.04u
M101 OR2_6/X_u7-net8 I367_4 VDD VDD pmos W=0.41u L=0.04u
M102 OR2_6/net7 I367_3 OR2_6/X_u7-net8 VDD pmos W=0.41u L=0.04u
M103 I211 OR2_5/net7 VSS VSS nmos W=0.31u L=0.04u
M104 OR2_5/net7 I284_3 VSS VSS nmos W=0.155u L=0.04u
M105 OR2_5/net7 I284_4 VSS VSS nmos W=0.155u L=0.04u
M106 I211 OR2_5/net7 VDD VDD pmos W=0.41u L=0.04u
M107 OR2_5/X_u7-net8 I284_4 VDD VDD pmos W=0.41u L=0.04u
M108 OR2_5/net7 I284_3 OR2_5/X_u7-net8 VDD pmos W=0.41u L=0.04u
M109 I209 OR2_4/net7 VSS VSS nmos W=0.31u L=0.04u
M110 OR2_4/net7 I269_3 VSS VSS nmos W=0.155u L=0.04u
M111 OR2_4/net7 I269_4 VSS VSS nmos W=0.155u L=0.04u
M112 I209 OR2_4/net7 VDD VDD pmos W=0.41u L=0.04u
M113 OR2_4/X_u7-net8 I269_4 VDD VDD pmos W=0.41u L=0.04u
M114 OR2_4/net7 I269_3 OR2_4/X_u7-net8 VDD pmos W=0.41u L=0.04u
M115 I113 OR2_3/net7 VSS VSS nmos W=0.31u L=0.04u
M116 OR2_3/net7 I186_3 VSS VSS nmos W=0.155u L=0.04u
M117 OR2_3/net7 I186_4 VSS VSS nmos W=0.155u L=0.04u
M118 I113 OR2_3/net7 VDD VDD pmos W=0.41u L=0.04u
M119 OR2_3/X_u7-net8 I186_4 VDD VDD pmos W=0.41u L=0.04u
M120 OR2_3/net7 I186_3 OR2_3/X_u7-net8 VDD pmos W=0.41u L=0.04u
M121 I111 OR2_2/net7 VSS VSS nmos W=0.31u L=0.04u
M122 OR2_2/net7 I171_3 VSS VSS nmos W=0.155u L=0.04u
M123 OR2_2/net7 I171_4 VSS VSS nmos W=0.155u L=0.04u
M124 I111 OR2_2/net7 VDD VDD pmos W=0.41u L=0.04u
M125 OR2_2/X_u7-net8 I171_4 VDD VDD pmos W=0.41u L=0.04u
M126 OR2_2/net7 I171_3 OR2_2/X_u7-net8 VDD pmos W=0.41u L=0.04u
M127 I15 OR2_1/net7 VSS VSS nmos W=0.31u L=0.04u
M128 OR2_1/net7 I88_3 VSS VSS nmos W=0.155u L=0.04u
M129 OR2_1/net7 I88_4 VSS VSS nmos W=0.155u L=0.04u
M130 I15 OR2_1/net7 VDD VDD pmos W=0.41u L=0.04u
M131 OR2_1/X_u7-net8 I88_4 VDD VDD pmos W=0.41u L=0.04u
M132 OR2_1/net7 I88_3 OR2_1/X_u7-net8 VDD pmos W=0.41u L=0.04u
M133 I13 OR2_0/net7 VSS VSS nmos W=0.31u L=0.04u
M134 OR2_0/net7 I73_3 VSS VSS nmos W=0.155u L=0.04u
M135 OR2_0/net7 I73_4 VSS VSS nmos W=0.155u L=0.04u
M136 I13 OR2_0/net7 VDD VDD pmos W=0.41u L=0.04u
M137 OR2_0/X_u7-net8 I73_4 VDD VDD pmos W=0.41u L=0.04u
M138 OR2_0/net7 I73_3 OR2_0/X_u7-net8 VDD pmos W=0.41u L=0.04u
M139 I699 N29 VSS VSS nmos W=0.31u L=0.04u
M140 I699 N29 VDD VDD pmos W=0.41u L=0.04u
M141 I698 N28 VSS VSS nmos W=0.31u L=0.04u
M142 I698 N28 VDD VDD pmos W=0.41u L=0.04u
M143 I12 N0 VSS VSS nmos W=0.31u L=0.04u
M144 I12 N0 VDD VDD pmos W=0.41u L=0.04u
M145 I110 N4 VSS VSS nmos W=0.31u L=0.04u
M146 I110 N4 VDD VDD pmos W=0.41u L=0.04u
M147 I208 N8 VSS VSS nmos W=0.31u L=0.04u
M148 I208 N8 VDD VDD pmos W=0.41u L=0.04u
M149 I306 N12 VSS VSS nmos W=0.31u L=0.04u
M150 I306 N12 VDD VDD pmos W=0.41u L=0.04u
M151 I404 N16 VSS VSS nmos W=0.31u L=0.04u
M152 I404 N16 VDD VDD pmos W=0.41u L=0.04u
M153 I502 N20 VSS VSS nmos W=0.31u L=0.04u
M154 I502 N20 VDD VDD pmos W=0.41u L=0.04u
M155 I600 N24 VSS VSS nmos W=0.31u L=0.04u
M156 I600 N24 VDD VDD pmos W=0.41u L=0.04u
M157 U145/net32 X_1 VSS VSS nmos W=0.155u L=0.04u
M158 U145/net59 P_0 U145/net32 VSS nmos W=0.155u L=0.04u
M159 U145/net59 X_2 VSS VSS nmos W=0.155u L=0.04u
M160 n125 U145/net59 VSS VSS nmos W=0.155u L=0.04u
M161 n125 U145/net59 VDD VDD pmos W=0.2u L=0.04u
M162 U145/net59 P_0 U145/net22 VDD pmos W=0.205u L=0.04u
M163 U145/net59 X_1 U145/net22 VDD pmos W=0.205u L=0.04u
M164 U145/net22 X_2 VDD VDD pmos W=0.2u L=0.04u
M165 n123 n126 VSS VSS nmos W=0.135u L=0.04u
M166 n123 n126 VDD VDD pmos W=0.205u L=0.04u
M167 n122 n127 U147/net15 VSS nmos W=0.155u L=0.04u
M168 n122 n128 U147/net15 VSS nmos W=0.155u L=0.04u
M169 U147/net15 n129 VSS VSS nmos W=0.155u L=0.04u
M170 n122 n129 VDD VDD pmos W=0.205u L=0.04u
M171 n122 n127 U147/XI16-net11 VDD pmos W=0.205u L=0.04u
M172 U147/XI16-net11 n128 VDD VDD pmos W=0.205u L=0.04u
M173 n121 n130 U148/net15 VSS nmos W=0.155u L=0.04u
M174 n121 n131 U148/net15 VSS nmos W=0.155u L=0.04u
M175 U148/net15 n132 VSS VSS nmos W=0.155u L=0.04u
M176 n121 n132 VDD VDD pmos W=0.205u L=0.04u
M177 n121 n130 U148/XI16-net11 VDD pmos W=0.205u L=0.04u
M178 U148/XI16-net11 n131 VDD VDD pmos W=0.205u L=0.04u
M179 n120 n133 U149/net15 VSS nmos W=0.155u L=0.04u
M180 n120 n134 U149/net15 VSS nmos W=0.155u L=0.04u
M181 U149/net15 n135 VSS VSS nmos W=0.155u L=0.04u
M182 n120 n135 VDD VDD pmos W=0.205u L=0.04u
M183 n120 n133 U149/XI16-net11 VDD pmos W=0.205u L=0.04u
M184 U149/XI16-net11 n134 VDD VDD pmos W=0.205u L=0.04u
M185 n119 n136 U150/net15 VSS nmos W=0.155u L=0.04u
M186 n119 n137 U150/net15 VSS nmos W=0.155u L=0.04u
M187 U150/net15 n138 VSS VSS nmos W=0.155u L=0.04u
M188 n119 n138 VDD VDD pmos W=0.205u L=0.04u
M189 n119 n136 U150/XI16-net11 VDD pmos W=0.205u L=0.04u
M190 U150/XI16-net11 n137 VDD VDD pmos W=0.205u L=0.04u
M191 n118 n139 U151/net15 VSS nmos W=0.155u L=0.04u
M192 n118 n140 U151/net15 VSS nmos W=0.155u L=0.04u
M193 U151/net15 n141 VSS VSS nmos W=0.155u L=0.04u
M194 n118 n141 VDD VDD pmos W=0.205u L=0.04u
M195 n118 n139 U151/XI16-net11 VDD pmos W=0.205u L=0.04u
M196 U151/XI16-net11 n140 VDD VDD pmos W=0.205u L=0.04u
M197 n117 n142 U152/net15 VSS nmos W=0.155u L=0.04u
M198 n117 n143 U152/net15 VSS nmos W=0.155u L=0.04u
M199 U152/net15 n144 VSS VSS nmos W=0.155u L=0.04u
M200 n117 n144 VDD VDD pmos W=0.205u L=0.04u
M201 n117 n142 U152/XI16-net11 VDD pmos W=0.205u L=0.04u
M202 U152/XI16-net11 n143 VDD VDD pmos W=0.205u L=0.04u
M203 n116 n145 U153/net15 VSS nmos W=0.155u L=0.04u
M204 n116 n146 U153/net15 VSS nmos W=0.155u L=0.04u
M205 U153/net15 n147 VSS VSS nmos W=0.155u L=0.04u
M206 n116 n147 VDD VDD pmos W=0.205u L=0.04u
M207 n116 n145 U153/XI16-net11 VDD pmos W=0.205u L=0.04u
M208 U153/XI16-net11 n146 VDD VDD pmos W=0.205u L=0.04u
M209 Z n148 U154/net10 VSS nmos W=0.155u L=0.04u
M210 U154/net10 n151 VSS VSS nmos W=0.155u L=0.04u
M211 Z n149 U154/net10 VSS nmos W=0.155u L=0.04u
M212 U154/net10 n150 VSS VSS nmos W=0.155u L=0.04u
M213 U154/net30 n151 VDD VDD pmos W=0.205u L=0.04u
M214 Z n148 U154/net24 VDD pmos W=0.205u L=0.04u
M215 U154/net24 n149 VDD VDD pmos W=0.205u L=0.04u
M216 Z n150 U154/net30 VDD pmos W=0.205u L=0.04u
M217 U155/PG2 C_2 VSS VSS nmos W=0.31u L=0.04u
M218 U155/net55 C_3 VSS VSS nmos W=0.31u L=0.04u
M219 U155/net51 X_3 VSS VSS nmos W=0.155u L=0.04u
M220 U155/net53 n152 VSS VSS nmos W=0.155u L=0.04u
M221 U155/net29 X_2 VSS VSS nmos W=0.155u L=0.04u
M222 U155/net53 U155/net51 U155/PG1 VSS nmos W=0.155u L=0.04u
M223 U155/net55 X_3 U155/PG1 VSS nmos W=0.21u L=0.04u
M224 U155/PG2 X_2 n151 VSS nmos W=0.22u L=0.04u
M225 U155/PG1 U155/net29 n151 VSS nmos W=0.155u L=0.04u
M226 U155/PG2 C_2 VDD VDD pmos W=0.41u L=0.04u
M227 U155/net55 C_3 VDD VDD pmos W=0.41u L=0.04u
M228 U155/net51 X_3 VDD VDD pmos W=0.205u L=0.04u
M229 U155/net53 n152 VDD VDD pmos W=0.28u L=0.04u
M230 U155/net29 X_2 VDD VDD pmos W=0.205u L=0.04u
M231 U155/net53 X_3 U155/PG1 VDD pmos W=0.27u L=0.04u
M232 U155/net55 U155/net51 U155/PG1 VDD pmos W=0.285u L=0.04u
M233 U155/PG2 U155/net29 n151 VDD pmos W=0.205u L=0.04u
M234 U155/PG1 X_2 n151 VDD pmos W=0.28u L=0.04u
M235 U156/PG2 C_4 VSS VSS nmos W=0.155u L=0.04u
M236 U156/net55 n153 VSS VSS nmos W=0.155u L=0.04u
M237 U156/net51 n146 VSS VSS nmos W=0.155u L=0.04u
M238 n152 U156/OUT VSS VSS nmos W=0.155u L=0.04u
M239 U156/net53 C_5 VSS VSS nmos W=0.155u L=0.04u
M240 U156/net29 X_4 VSS VSS nmos W=0.155u L=0.04u
M241 U156/net53 U156/net51 U156/PG1 VSS nmos W=0.155u L=0.04u
M242 U156/net55 n146 U156/PG1 VSS nmos W=0.155u L=0.04u
M243 U156/PG2 X_4 U156/OUT VSS nmos W=0.155u L=0.04u
M244 U156/PG1 U156/net29 U156/OUT VSS nmos W=0.155u L=0.04u
M245 U156/PG2 C_4 VDD VDD pmos W=0.205u L=0.04u
M246 U156/net55 n153 VDD VDD pmos W=0.21u L=0.04u
M247 U156/net51 n146 VDD VDD pmos W=0.205u L=0.04u
M248 n152 U156/OUT VDD VDD pmos W=0.205u L=0.04u
M249 U156/net53 C_5 VDD VDD pmos W=0.205u L=0.04u
M250 U156/net29 X_4 VDD VDD pmos W=0.205u L=0.04u
M251 U156/net53 n146 U156/PG1 VDD pmos W=0.205u L=0.04u
M252 U156/net55 U156/net51 U156/PG1 VDD pmos W=0.21u L=0.04u
M253 U156/PG2 U156/net29 U156/OUT VDD pmos W=0.205u L=0.04u
M254 U156/PG1 X_4 U156/OUT VDD pmos W=0.205u L=0.04u
M255 U157/PG2 C_6 VSS VSS nmos W=0.155u L=0.04u
M256 U157/net55 n154 VSS VSS nmos W=0.155u L=0.04u
M257 U157/net51 n155 VSS VSS nmos W=0.155u L=0.04u
M258 n153 U157/OUT VSS VSS nmos W=0.155u L=0.04u
M259 U157/net53 C_7 VSS VSS nmos W=0.155u L=0.04u
M260 U157/net29 X_6 VSS VSS nmos W=0.155u L=0.04u
M261 U157/net53 U157/net51 U157/PG1 VSS nmos W=0.155u L=0.04u
M262 U157/net55 n155 U157/PG1 VSS nmos W=0.155u L=0.04u
M263 U157/PG2 X_6 U157/OUT VSS nmos W=0.155u L=0.04u
M264 U157/PG1 U157/net29 U157/OUT VSS nmos W=0.155u L=0.04u
M265 U157/PG2 C_6 VDD VDD pmos W=0.205u L=0.04u
M266 U157/net55 n154 VDD VDD pmos W=0.21u L=0.04u
M267 U157/net51 n155 VDD VDD pmos W=0.205u L=0.04u
M268 n153 U157/OUT VDD VDD pmos W=0.205u L=0.04u
M269 U157/net53 C_7 VDD VDD pmos W=0.205u L=0.04u
M270 U157/net29 X_6 VDD VDD pmos W=0.205u L=0.04u
M271 U157/net53 n155 U157/PG1 VDD pmos W=0.205u L=0.04u
M272 U157/net55 U157/net51 U157/PG1 VDD pmos W=0.21u L=0.04u
M273 U157/PG2 U157/net29 U157/OUT VDD pmos W=0.205u L=0.04u
M274 U157/PG1 X_6 U157/OUT VDD pmos W=0.205u L=0.04u
M275 n154 U158/net6 VSS VSS nmos W=0.155u L=0.04u
M276 U158/X_u2-net6 X_8 VSS VSS nmos W=0.155u L=0.04u
M277 U158/net6 C_8 U158/X_u2-net6 VSS nmos W=0.155u L=0.04u
M278 n154 U158/net6 VDD VDD pmos W=0.205u L=0.04u
M279 U158/net6 X_8 VDD VDD pmos W=0.205u L=0.04u
M280 U158/net6 C_8 VDD VDD pmos W=0.205u L=0.04u
M281 n150 I88_4 VSS VSS nmos W=0.135u L=0.04u
M282 n150 I88_4 VDD VDD pmos W=0.205u L=0.04u
M283 U160/net11 n156 n148 VDD pmos W=0.205u L=0.04u
M284 U160/net11 n157 n148 VDD pmos W=0.205u L=0.04u
M285 U160/net11 n158 U160/XI16-net11 VDD pmos W=0.205u L=0.04u
M286 U160/XI16-net11 C_0 VDD VDD pmos W=0.205u L=0.04u
M287 n148 C_0 VSS VSS nmos W=0.155u L=0.04u
M288 n148 n158 VSS VSS nmos W=0.155u L=0.04u
M289 n148 n156 U160/XI12-net17 VSS nmos W=0.155u L=0.04u
M290 U160/XI12-net17 n157 VSS VSS nmos W=0.155u L=0.04u
M291 U161/net8 C_1 U161/net26 VSS nmos W=0.155u L=0.04u
M292 U161/net26 X_1 VSS VSS nmos W=0.155u L=0.04u
M293 U161/net29 U161/net8 VSS VSS nmos W=0.155u L=0.04u
M294 U161/net29 n159 n158 VSS nmos W=0.155u L=0.04u
M295 U161/net29 n160 n158 VSS nmos W=0.155u L=0.04u
M296 U161/net8 X_1 VDD VDD pmos W=0.205u L=0.04u
M297 U161/net8 C_1 VDD VDD pmos W=0.205u L=0.04u
M298 n158 U161/net8 VDD VDD pmos W=0.205u L=0.04u
M299 n158 n159 U161/net20 VDD pmos W=0.205u L=0.04u
M300 U161/net20 n160 VDD VDD pmos W=0.205u L=0.04u
M301 U162/net19 n143 VSS VSS nmos W=0.155u L=0.04u
M302 n160 n143 U162/net40 VSS nmos W=0.155u L=0.04u
M303 n160 U162/net19 U162/net36 VSS nmos W=0.155u L=0.04u
M304 U162/net40 n161 VSS VSS nmos W=0.31u L=0.04u
M305 U162/net36 C_9 VSS VSS nmos W=0.155u L=0.04u
M306 U162/net19 n143 VDD VDD pmos W=0.205u L=0.04u
M307 n160 U162/net19 U162/net26 VDD pmos W=0.325u L=0.04u
M308 U162/net26 n161 VDD VDD pmos W=0.41u L=0.04u
M309 n160 n143 U162/net30 VDD pmos W=0.325u L=0.04u
M310 U162/net30 C_9 VDD VDD pmos W=0.205u L=0.04u
M311 U163/PG2 C_10 VSS VSS nmos W=0.155u L=0.04u
M312 U163/net55 n162 VSS VSS nmos W=0.155u L=0.04u
M313 U163/net51 n163 VSS VSS nmos W=0.155u L=0.04u
M314 n161 U163/OUT VSS VSS nmos W=0.155u L=0.04u
M315 U163/net53 C_11 VSS VSS nmos W=0.155u L=0.04u
M316 U163/net29 X_10 VSS VSS nmos W=0.155u L=0.04u
M317 U163/net53 U163/net51 U163/PG1 VSS nmos W=0.155u L=0.04u
M318 U163/net55 n163 U163/PG1 VSS nmos W=0.155u L=0.04u
M319 U163/PG2 X_10 U163/OUT VSS nmos W=0.155u L=0.04u
M320 U163/PG1 U163/net29 U163/OUT VSS nmos W=0.155u L=0.04u
M321 U163/PG2 C_10 VDD VDD pmos W=0.205u L=0.04u
M322 U163/net55 n162 VDD VDD pmos W=0.21u L=0.04u
M323 U163/net51 n163 VDD VDD pmos W=0.205u L=0.04u
M324 n161 U163/OUT VDD VDD pmos W=0.205u L=0.04u
M325 U163/net53 C_11 VDD VDD pmos W=0.205u L=0.04u
M326 U163/net29 X_10 VDD VDD pmos W=0.205u L=0.04u
M327 U163/net53 n163 U163/PG1 VDD pmos W=0.205u L=0.04u
M328 U163/net55 U163/net51 U163/PG1 VDD pmos W=0.21u L=0.04u
M329 U163/PG2 U163/net29 U163/OUT VDD pmos W=0.205u L=0.04u
M330 U163/PG1 X_10 U163/OUT VDD pmos W=0.205u L=0.04u
M331 U164/PG2 C_12 VSS VSS nmos W=0.155u L=0.04u
M332 U164/net55 n164 VSS VSS nmos W=0.155u L=0.04u
M333 U164/net51 n140 VSS VSS nmos W=0.155u L=0.04u
M334 n162 U164/OUT VSS VSS nmos W=0.155u L=0.04u
M335 U164/net53 C_13 VSS VSS nmos W=0.155u L=0.04u
M336 U164/net29 X_12 VSS VSS nmos W=0.155u L=0.04u
M337 U164/net53 U164/net51 U164/PG1 VSS nmos W=0.155u L=0.04u
M338 U164/net55 n140 U164/PG1 VSS nmos W=0.155u L=0.04u
M339 U164/PG2 X_12 U164/OUT VSS nmos W=0.155u L=0.04u
M340 U164/PG1 U164/net29 U164/OUT VSS nmos W=0.155u L=0.04u
M341 U164/PG2 C_12 VDD VDD pmos W=0.205u L=0.04u
M342 U164/net55 n164 VDD VDD pmos W=0.21u L=0.04u
M343 U164/net51 n140 VDD VDD pmos W=0.205u L=0.04u
M344 n162 U164/OUT VDD VDD pmos W=0.205u L=0.04u
M345 U164/net53 C_13 VDD VDD pmos W=0.205u L=0.04u
M346 U164/net29 X_12 VDD VDD pmos W=0.205u L=0.04u
M347 U164/net53 n140 U164/PG1 VDD pmos W=0.205u L=0.04u
M348 U164/net55 U164/net51 U164/PG1 VDD pmos W=0.21u L=0.04u
M349 U164/PG2 U164/net29 U164/OUT VDD pmos W=0.205u L=0.04u
M350 U164/PG1 X_12 U164/OUT VDD pmos W=0.205u L=0.04u
M351 U165/PG2 C_14 VSS VSS nmos W=0.155u L=0.04u
M352 U165/net55 n165 VSS VSS nmos W=0.155u L=0.04u
M353 U165/net51 n166 VSS VSS nmos W=0.155u L=0.04u
M354 n164 U165/OUT VSS VSS nmos W=0.155u L=0.04u
M355 U165/net53 C_15 VSS VSS nmos W=0.155u L=0.04u
M356 U165/net29 X_14 VSS VSS nmos W=0.155u L=0.04u
M357 U165/net53 U165/net51 U165/PG1 VSS nmos W=0.155u L=0.04u
M358 U165/net55 n166 U165/PG1 VSS nmos W=0.155u L=0.04u
M359 U165/PG2 X_14 U165/OUT VSS nmos W=0.155u L=0.04u
M360 U165/PG1 U165/net29 U165/OUT VSS nmos W=0.155u L=0.04u
M361 U165/PG2 C_14 VDD VDD pmos W=0.205u L=0.04u
M362 U165/net55 n165 VDD VDD pmos W=0.21u L=0.04u
M363 U165/net51 n166 VDD VDD pmos W=0.205u L=0.04u
M364 n164 U165/OUT VDD VDD pmos W=0.205u L=0.04u
M365 U165/net53 C_15 VDD VDD pmos W=0.205u L=0.04u
M366 U165/net29 X_14 VDD VDD pmos W=0.205u L=0.04u
M367 U165/net53 n166 U165/PG1 VDD pmos W=0.205u L=0.04u
M368 U165/net55 U165/net51 U165/PG1 VDD pmos W=0.21u L=0.04u
M369 U165/PG2 U165/net29 U165/OUT VDD pmos W=0.205u L=0.04u
M370 U165/PG1 X_14 U165/OUT VDD pmos W=0.205u L=0.04u
M371 n165 U166/net6 VSS VSS nmos W=0.155u L=0.04u
M372 U166/X_u2-net6 X_16 VSS VSS nmos W=0.155u L=0.04u
M373 U166/net6 C_16 U166/X_u2-net6 VSS nmos W=0.155u L=0.04u
M374 n165 U166/net6 VDD VDD pmos W=0.205u L=0.04u
M375 U166/net6 X_16 VDD VDD pmos W=0.205u L=0.04u
M376 U166/net6 C_16 VDD VDD pmos W=0.205u L=0.04u
M377 n157 X_16 VSS VSS nmos W=0.155u L=0.04u
M378 n157 X_9 VSS VSS nmos W=0.155u L=0.04u
M379 n157 X_15 VSS VSS nmos W=0.155u L=0.04u
M380 n157 n167 VSS VSS nmos W=0.155u L=0.04u
M381 U167/net49 X_9 U167/net52 VDD pmos W=0.41u L=0.04u
M382 U167/net52 X_16 VDD VDD pmos W=0.41u L=0.04u
M383 U167/net46 X_15 U167/net49 VDD pmos W=0.41u L=0.04u
M384 n157 n167 U167/net46 VDD pmos W=0.41u L=0.04u
M385 U168/XU1-net6 n141 VSS VSS nmos W=0.155u L=0.04u
M386 n167 n140 U168/XU1-net6 VSS nmos W=0.155u L=0.04u
M387 n167 n141 VDD VDD pmos W=0.155u L=0.04u
M388 n167 n140 VDD VDD pmos W=0.155u L=0.04u
M389 n156 X_11 VSS VSS nmos W=0.155u L=0.04u
M390 n156 X_12 VSS VSS nmos W=0.155u L=0.04u
M391 n156 X_10 VSS VSS nmos W=0.155u L=0.04u
M392 n156 n168 VSS VSS nmos W=0.155u L=0.04u
M393 U169/net49 X_12 U169/net52 VDD pmos W=0.41u L=0.04u
M394 U169/net52 X_11 VDD VDD pmos W=0.41u L=0.04u
M395 U169/net46 X_10 U169/net49 VDD pmos W=0.41u L=0.04u
M396 n156 n168 U169/net46 VDD pmos W=0.41u L=0.04u
M397 U170/net13 n159 VSS VSS nmos W=0.155u L=0.04u
M398 U170/net16 U170/net13 VSS VSS nmos W=0.155u L=0.04u
M399 n168 n169 U170/net16 VSS nmos W=0.155u L=0.04u
M400 U170/net13 n159 VDD VDD pmos W=0.205u L=0.04u
M401 VDD U170/net13 n168 VDD pmos W=0.205u L=0.04u
M402 VDD n169 n168 VDD pmos W=0.205u L=0.04u
M403 n169 X_17 U171/net15 VSS nmos W=0.155u L=0.04u
M404 n169 n170 U171/net15 VSS nmos W=0.155u L=0.04u
M405 U171/net15 n171 VSS VSS nmos W=0.155u L=0.04u
M406 n169 n171 VDD VDD pmos W=0.205u L=0.04u
M407 n169 X_17 U171/XI16-net11 VDD pmos W=0.205u L=0.04u
M408 U171/XI16-net11 n170 VDD VDD pmos W=0.205u L=0.04u
M409 U172/net19 n137 VSS VSS nmos W=0.155u L=0.04u
M410 n171 n137 U172/net40 VSS nmos W=0.155u L=0.04u
M411 n171 U172/net19 U172/net36 VSS nmos W=0.155u L=0.04u
M412 U172/net40 n172 VSS VSS nmos W=0.31u L=0.04u
M413 U172/net36 C_17 VSS VSS nmos W=0.155u L=0.04u
M414 U172/net19 n137 VDD VDD pmos W=0.205u L=0.04u
M415 n171 U172/net19 U172/net26 VDD pmos W=0.325u L=0.04u
M416 U172/net26 n172 VDD VDD pmos W=0.41u L=0.04u
M417 n171 n137 U172/net30 VDD pmos W=0.325u L=0.04u
M418 U172/net30 C_17 VDD VDD pmos W=0.205u L=0.04u
M419 n172 n175 VSS VSS nmos W=0.155u L=0.04u
M420 n172 X_18 VSS VSS nmos W=0.155u L=0.04u
M421 n172 n174 VSS VSS nmos W=0.155u L=0.04u
M422 n172 n173 VSS VSS nmos W=0.155u L=0.04u
M423 U173/net49 X_18 U173/net52 VDD pmos W=0.41u L=0.04u
M424 U173/net52 n175 VDD VDD pmos W=0.41u L=0.04u
M425 U173/net46 n174 U173/net49 VDD pmos W=0.41u L=0.04u
M426 n172 n173 U173/net46 VDD pmos W=0.41u L=0.04u
M427 U174/net19 n131 VSS VSS nmos W=0.155u L=0.04u
M428 n175 n131 U174/net40 VSS nmos W=0.155u L=0.04u
M429 n175 U174/net19 U174/net36 VSS nmos W=0.155u L=0.04u
M430 U174/net40 n176 VSS VSS nmos W=0.31u L=0.04u
M431 U174/net36 C_25 VSS VSS nmos W=0.155u L=0.04u
M432 U174/net19 n131 VDD VDD pmos W=0.205u L=0.04u
M433 n175 U174/net19 U174/net26 VDD pmos W=0.325u L=0.04u
M434 U174/net26 n176 VDD VDD pmos W=0.41u L=0.04u
M435 n175 n131 U174/net30 VDD pmos W=0.325u L=0.04u
M436 U174/net30 C_25 VDD VDD pmos W=0.205u L=0.04u
M437 U175/PG2 C_26 VSS VSS nmos W=0.155u L=0.04u
M438 U175/net55 n177 VSS VSS nmos W=0.155u L=0.04u
M439 U175/net51 n178 VSS VSS nmos W=0.155u L=0.04u
M440 n176 U175/OUT VSS VSS nmos W=0.155u L=0.04u
M441 U175/net53 C_27 VSS VSS nmos W=0.155u L=0.04u
M442 U175/net29 X_26 VSS VSS nmos W=0.155u L=0.04u
M443 U175/net53 U175/net51 U175/PG1 VSS nmos W=0.155u L=0.04u
M444 U175/net55 n178 U175/PG1 VSS nmos W=0.155u L=0.04u
M445 U175/PG2 X_26 U175/OUT VSS nmos W=0.155u L=0.04u
M446 U175/PG1 U175/net29 U175/OUT VSS nmos W=0.155u L=0.04u
M447 U175/PG2 C_26 VDD VDD pmos W=0.205u L=0.04u
M448 U175/net55 n177 VDD VDD pmos W=0.21u L=0.04u
M449 U175/net51 n178 VDD VDD pmos W=0.205u L=0.04u
M450 n176 U175/OUT VDD VDD pmos W=0.205u L=0.04u
M451 U175/net53 C_27 VDD VDD pmos W=0.205u L=0.04u
M452 U175/net29 X_26 VDD VDD pmos W=0.205u L=0.04u
M453 U175/net53 n178 U175/PG1 VDD pmos W=0.205u L=0.04u
M454 U175/net55 U175/net51 U175/PG1 VDD pmos W=0.21u L=0.04u
M455 U175/PG2 U175/net29 U175/OUT VDD pmos W=0.205u L=0.04u
M456 U175/PG1 X_26 U175/OUT VDD pmos W=0.205u L=0.04u
M457 U176/PG2 C_28 VSS VSS nmos W=0.155u L=0.04u
M458 U176/net55 n179 VSS VSS nmos W=0.155u L=0.04u
M459 U176/net51 n128 VSS VSS nmos W=0.155u L=0.04u
M460 n177 U176/OUT VSS VSS nmos W=0.155u L=0.04u
M461 U176/net53 C_29 VSS VSS nmos W=0.155u L=0.04u
M462 U176/net29 X_28 VSS VSS nmos W=0.155u L=0.04u
M463 U176/net53 U176/net51 U176/PG1 VSS nmos W=0.155u L=0.04u
M464 U176/net55 n128 U176/PG1 VSS nmos W=0.155u L=0.04u
M465 U176/PG2 X_28 U176/OUT VSS nmos W=0.155u L=0.04u
M466 U176/PG1 U176/net29 U176/OUT VSS nmos W=0.155u L=0.04u
M467 U176/PG2 C_28 VDD VDD pmos W=0.205u L=0.04u
M468 U176/net55 n179 VDD VDD pmos W=0.21u L=0.04u
M469 U176/net51 n128 VDD VDD pmos W=0.205u L=0.04u
M470 n177 U176/OUT VDD VDD pmos W=0.205u L=0.04u
M471 U176/net53 C_29 VDD VDD pmos W=0.205u L=0.04u
M472 U176/net29 X_28 VDD VDD pmos W=0.205u L=0.04u
M473 U176/net53 n128 U176/PG1 VDD pmos W=0.205u L=0.04u
M474 U176/net55 U176/net51 U176/PG1 VDD pmos W=0.21u L=0.04u
M475 U176/PG2 U176/net29 U176/OUT VDD pmos W=0.205u L=0.04u
M476 U176/PG1 X_28 U176/OUT VDD pmos W=0.205u L=0.04u
M477 U177/PG2 C_30 VSS VSS nmos W=0.155u L=0.04u
M478 U177/net55 C_31 VSS VSS nmos W=0.155u L=0.04u
M479 U177/net51 X_31 VSS VSS nmos W=0.155u L=0.04u
M480 n179 U177/OUT VSS VSS nmos W=0.155u L=0.04u
M481 U177/net53 n180 VSS VSS nmos W=0.155u L=0.04u
M482 U177/net29 X_30 VSS VSS nmos W=0.155u L=0.04u
M483 U177/net53 U177/net51 U177/PG1 VSS nmos W=0.155u L=0.04u
M484 U177/net55 X_31 U177/PG1 VSS nmos W=0.155u L=0.04u
M485 U177/PG2 X_30 U177/OUT VSS nmos W=0.155u L=0.04u
M486 U177/PG1 U177/net29 U177/OUT VSS nmos W=0.155u L=0.04u
M487 U177/PG2 C_30 VDD VDD pmos W=0.205u L=0.04u
M488 U177/net55 C_31 VDD VDD pmos W=0.21u L=0.04u
M489 U177/net51 X_31 VDD VDD pmos W=0.205u L=0.04u
M490 n179 U177/OUT VDD VDD pmos W=0.205u L=0.04u
M491 U177/net53 n180 VDD VDD pmos W=0.205u L=0.04u
M492 U177/net29 X_30 VDD VDD pmos W=0.205u L=0.04u
M493 U177/net53 X_31 U177/PG1 VDD pmos W=0.205u L=0.04u
M494 U177/net55 U177/net51 U177/PG1 VDD pmos W=0.21u L=0.04u
M495 U177/PG2 U177/net29 U177/OUT VDD pmos W=0.205u L=0.04u
M496 U177/PG1 X_30 U177/OUT VDD pmos W=0.205u L=0.04u
M497 n180 U178/net6 VSS VSS nmos W=0.155u L=0.04u
M498 U178/X_u2-net6 C_32 VSS VSS nmos W=0.155u L=0.04u
M499 U178/net6 X_32 U178/X_u2-net6 VSS nmos W=0.155u L=0.04u
M500 n180 U178/net6 VDD VDD pmos W=0.205u L=0.04u
M501 U178/net6 C_32 VDD VDD pmos W=0.205u L=0.04u
M502 U178/net6 X_32 VDD VDD pmos W=0.205u L=0.04u
M503 U179/net13 X_20 VSS VSS nmos W=0.155u L=0.04u
M504 U179/net16 U179/net13 VSS VSS nmos W=0.155u L=0.04u
M505 n174 n181 U179/net16 VSS nmos W=0.155u L=0.04u
M506 U179/net13 X_20 VDD VDD pmos W=0.205u L=0.04u
M507 VDD U179/net13 n174 VDD pmos W=0.205u L=0.04u
M508 VDD n181 n174 VDD pmos W=0.205u L=0.04u
M509 U180/net14 X_24 VSS VSS nmos W=0.155u L=0.04u
M510 U180/net14 X_21 VSS VSS nmos W=0.155u L=0.04u
M511 U180/net14 X_22 VSS VSS nmos W=0.155u L=0.04u
M512 U180/net14 X_23 VSS VSS nmos W=0.155u L=0.04u
M513 n173 U180/net14 VSS VSS nmos W=0.155u L=0.04u
M514 U180/net14 X_23 U180/XU8-net7 VDD pmos W=0.205u L=0.04u
M515 U180/XU8-net7 X_22 U180/XU8-net10 VDD pmos W=0.205u L=0.04u
M516 U180/XU8-net10 X_21 U180/XU8-net13 VDD pmos W=0.205u L=0.04u
M517 U180/XU8-net13 X_24 VDD VDD pmos W=0.205u L=0.04u
M518 n173 U180/net14 VDD VDD pmos W=0.205u L=0.04u
M519 U181/PG2 C_18 VSS VSS nmos W=0.31u L=0.04u
M520 U181/net55 n182 VSS VSS nmos W=0.31u L=0.04u
M521 U181/net51 n181 VSS VSS nmos W=0.155u L=0.04u
M522 U181/net53 C_19 VSS VSS nmos W=0.155u L=0.04u
M523 U181/net29 X_18 VSS VSS nmos W=0.155u L=0.04u
M524 U181/net53 U181/net51 U181/PG1 VSS nmos W=0.155u L=0.04u
M525 U181/net55 n181 U181/PG1 VSS nmos W=0.21u L=0.04u
M526 U181/PG2 X_18 n170 VSS nmos W=0.22u L=0.04u
M527 U181/PG1 U181/net29 n170 VSS nmos W=0.155u L=0.04u
M528 U181/PG2 C_18 VDD VDD pmos W=0.41u L=0.04u
M529 U181/net55 n182 VDD VDD pmos W=0.41u L=0.04u
M530 U181/net51 n181 VDD VDD pmos W=0.205u L=0.04u
M531 U181/net53 C_19 VDD VDD pmos W=0.28u L=0.04u
M532 U181/net29 X_18 VDD VDD pmos W=0.205u L=0.04u
M533 U181/net53 n181 U181/PG1 VDD pmos W=0.27u L=0.04u
M534 U181/net55 U181/net51 U181/PG1 VDD pmos W=0.285u L=0.04u
M535 U181/PG2 U181/net29 n170 VDD pmos W=0.205u L=0.04u
M536 U181/PG1 X_18 n170 VDD pmos W=0.28u L=0.04u
M537 U182/PG2 C_20 VSS VSS nmos W=0.155u L=0.04u
M538 U182/net55 n183 VSS VSS nmos W=0.155u L=0.04u
M539 U182/net51 n134 VSS VSS nmos W=0.155u L=0.04u
M540 n182 U182/OUT VSS VSS nmos W=0.155u L=0.04u
M541 U182/net53 C_21 VSS VSS nmos W=0.155u L=0.04u
M542 U182/net29 X_20 VSS VSS nmos W=0.155u L=0.04u
M543 U182/net53 U182/net51 U182/PG1 VSS nmos W=0.155u L=0.04u
M544 U182/net55 n134 U182/PG1 VSS nmos W=0.155u L=0.04u
M545 U182/PG2 X_20 U182/OUT VSS nmos W=0.155u L=0.04u
M546 U182/PG1 U182/net29 U182/OUT VSS nmos W=0.155u L=0.04u
M547 U182/PG2 C_20 VDD VDD pmos W=0.205u L=0.04u
M548 U182/net55 n183 VDD VDD pmos W=0.21u L=0.04u
M549 U182/net51 n134 VDD VDD pmos W=0.205u L=0.04u
M550 n182 U182/OUT VDD VDD pmos W=0.205u L=0.04u
M551 U182/net53 C_21 VDD VDD pmos W=0.205u L=0.04u
M552 U182/net29 X_20 VDD VDD pmos W=0.205u L=0.04u
M553 U182/net53 n134 U182/PG1 VDD pmos W=0.205u L=0.04u
M554 U182/net55 U182/net51 U182/PG1 VDD pmos W=0.21u L=0.04u
M555 U182/PG2 U182/net29 U182/OUT VDD pmos W=0.205u L=0.04u
M556 U182/PG1 X_20 U182/OUT VDD pmos W=0.205u L=0.04u
M557 U183/PG2 C_22 VSS VSS nmos W=0.155u L=0.04u
M558 U183/net55 n184 VSS VSS nmos W=0.155u L=0.04u
M559 U183/net51 n185 VSS VSS nmos W=0.155u L=0.04u
M560 n183 U183/OUT VSS VSS nmos W=0.155u L=0.04u
M561 U183/net53 C_23 VSS VSS nmos W=0.155u L=0.04u
M562 U183/net29 X_22 VSS VSS nmos W=0.155u L=0.04u
M563 U183/net53 U183/net51 U183/PG1 VSS nmos W=0.155u L=0.04u
M564 U183/net55 n185 U183/PG1 VSS nmos W=0.155u L=0.04u
M565 U183/PG2 X_22 U183/OUT VSS nmos W=0.155u L=0.04u
M566 U183/PG1 U183/net29 U183/OUT VSS nmos W=0.155u L=0.04u
M567 U183/PG2 C_22 VDD VDD pmos W=0.205u L=0.04u
M568 U183/net55 n184 VDD VDD pmos W=0.21u L=0.04u
M569 U183/net51 n185 VDD VDD pmos W=0.205u L=0.04u
M570 n183 U183/OUT VDD VDD pmos W=0.205u L=0.04u
M571 U183/net53 C_23 VDD VDD pmos W=0.205u L=0.04u
M572 U183/net29 X_22 VDD VDD pmos W=0.205u L=0.04u
M573 U183/net53 n185 U183/PG1 VDD pmos W=0.205u L=0.04u
M574 U183/net55 U183/net51 U183/PG1 VDD pmos W=0.21u L=0.04u
M575 U183/PG2 U183/net29 U183/OUT VDD pmos W=0.205u L=0.04u
M576 U183/PG1 X_22 U183/OUT VDD pmos W=0.205u L=0.04u
M577 n184 U184/net6 VSS VSS nmos W=0.155u L=0.04u
M578 U184/X_u2-net6 X_24 VSS VSS nmos W=0.155u L=0.04u
M579 U184/net6 C_24 U184/X_u2-net6 VSS nmos W=0.155u L=0.04u
M580 n184 U184/net6 VDD VDD pmos W=0.205u L=0.04u
M581 U184/net6 X_24 VDD VDD pmos W=0.205u L=0.04u
M582 U184/net6 C_24 VDD VDD pmos W=0.205u L=0.04u
M583 U185/XU1-net6 n187 VSS VSS nmos W=0.155u L=0.04u
M584 n159 n186 U185/XU1-net6 VSS nmos W=0.155u L=0.04u
M585 n159 n187 VDD VDD pmos W=0.155u L=0.04u
M586 n159 n186 VDD VDD pmos W=0.155u L=0.04u
M587 n187 X_5 VSS VSS nmos W=0.155u L=0.04u
M588 n187 X_6 VSS VSS nmos W=0.155u L=0.04u
M589 n187 X_7 VSS VSS nmos W=0.155u L=0.04u
M590 n187 X_8 VSS VSS nmos W=0.155u L=0.04u
M591 U186/net49 X_6 U186/net52 VDD pmos W=0.41u L=0.04u
M592 U186/net52 X_5 VDD VDD pmos W=0.41u L=0.04u
M593 U186/net46 X_7 U186/net49 VDD pmos W=0.41u L=0.04u
M594 n187 X_8 U186/net46 VDD pmos W=0.41u L=0.04u
M595 n186 X_1 VSS VSS nmos W=0.155u L=0.04u
M596 n186 X_2 VSS VSS nmos W=0.155u L=0.04u
M597 n186 X_3 VSS VSS nmos W=0.155u L=0.04u
M598 n186 X_4 VSS VSS nmos W=0.155u L=0.04u
M599 U187/net49 X_2 U187/net52 VDD pmos W=0.41u L=0.04u
M600 U187/net52 X_1 VDD VDD pmos W=0.41u L=0.04u
M601 U187/net46 X_3 U187/net49 VDD pmos W=0.41u L=0.04u
M602 n186 X_4 U187/net46 VDD pmos W=0.41u L=0.04u
M603 N8 X_12 U188/net15 VSS nmos W=0.155u L=0.04u
M604 N8 n188 U188/net15 VSS nmos W=0.155u L=0.04u
M605 U188/net15 n139 VSS VSS nmos W=0.155u L=0.04u
M606 N8 n139 VDD VDD pmos W=0.205u L=0.04u
M607 N8 X_12 U188/XI16-net11 VDD pmos W=0.205u L=0.04u
M608 U188/XI16-net11 n188 VDD VDD pmos W=0.205u L=0.04u
M609 N4 X_8 U189/net15 VSS nmos W=0.155u L=0.04u
M610 N4 n189 U189/net15 VSS nmos W=0.155u L=0.04u
M611 U189/net15 n142 VSS VSS nmos W=0.155u L=0.04u
M612 N4 n142 VDD VDD pmos W=0.205u L=0.04u
M613 N4 X_8 U189/XI16-net11 VDD pmos W=0.205u L=0.04u
M614 U189/XI16-net11 n189 VDD VDD pmos W=0.205u L=0.04u
M615 U190/net4 n126 U190/net14 VSS nmos W=0.155u L=0.04u
M616 U190/net6 U190/net10 U190/net14 VSS nmos W=0.17u L=0.04u
M617 U190/net4 X_31 VSS VSS nmos W=0.155u L=0.04u
M618 U190/net6 U190/net4 VSS VSS nmos W=0.17u L=0.04u
M619 N29 U190/net14 VSS VSS nmos W=0.155u L=0.04u
M620 U190/net10 n126 VSS VSS nmos W=0.155u L=0.04u
M621 U190/net4 U190/net10 U190/net14 VDD pmos W=0.255u L=0.04u
M622 U190/net6 n126 U190/net14 VDD pmos W=0.28u L=0.04u
M623 U190/net4 X_31 VDD VDD pmos W=0.205u L=0.04u
M624 U190/net6 U190/net4 VDD VDD pmos W=0.24u L=0.04u
M625 N29 U190/net14 VDD VDD pmos W=0.205u L=0.04u
M626 U190/net10 n126 VDD VDD pmos W=0.205u L=0.04u
M627 U191/net4 U191/net10 U191/net14 VSS nmos W=0.155u L=0.04u
M628 U191/net6 X_32 U191/net14 VSS nmos W=0.155u L=0.04u
M629 U191/net4 n190 VSS VSS nmos W=0.155u L=0.04u
M630 U191/net6 U191/net4 VSS VSS nmos W=0.155u L=0.04u
M631 N28 U191/net14 VSS VSS nmos W=0.155u L=0.04u
M632 U191/net10 X_32 VSS VSS nmos W=0.155u L=0.04u
M633 U191/net4 X_32 U191/net14 VDD pmos W=0.205u L=0.04u
M634 U191/net6 U191/net10 U191/net14 VDD pmos W=0.205u L=0.04u
M635 U191/net4 n190 VDD VDD pmos W=0.205u L=0.04u
M636 U191/net6 U191/net4 VDD VDD pmos W=0.205u L=0.04u
M637 N28 U191/net14 VDD VDD pmos W=0.205u L=0.04u
M638 U191/net10 X_32 VDD VDD pmos W=0.205u L=0.04u
M639 U192/XU1-net6 n126 VSS VSS nmos W=0.155u L=0.04u
M640 n190 X_31 U192/XU1-net6 VSS nmos W=0.155u L=0.04u
M641 n190 n126 VDD VDD pmos W=0.155u L=0.04u
M642 n190 X_31 VDD VDD pmos W=0.155u L=0.04u
M643 n126 n129 VSS VSS nmos W=0.155u L=0.04u
M644 n126 n127 VSS VSS nmos W=0.155u L=0.04u
M645 n126 n128 VSS VSS nmos W=0.155u L=0.04u
M646 U193/net25 n129 VDD VDD pmos W=0.41u L=0.04u
M647 U193/net28 n127 U193/net25 VDD pmos W=0.41u L=0.04u
M648 n126 n128 U193/net28 VDD pmos W=0.41u L=0.04u
M649 n129 X_30 VSS VSS nmos W=0.135u L=0.04u
M650 n129 X_30 VDD VDD pmos W=0.205u L=0.04u
M651 n128 X_29 VSS VSS nmos W=0.135u L=0.04u
M652 n128 X_29 VDD VDD pmos W=0.205u L=0.04u
M653 N24 X_28 U196/net15 VSS nmos W=0.155u L=0.04u
M654 N24 n191 U196/net15 VSS nmos W=0.155u L=0.04u
M655 U196/net15 n127 VSS VSS nmos W=0.155u L=0.04u
M656 N24 n127 VDD VDD pmos W=0.205u L=0.04u
M657 N24 X_28 U196/XI16-net11 VDD pmos W=0.205u L=0.04u
M658 U196/XI16-net11 n191 VDD VDD pmos W=0.205u L=0.04u
M659 N20 X_24 U197/net15 VSS nmos W=0.155u L=0.04u
M660 N20 n192 U197/net15 VSS nmos W=0.155u L=0.04u
M661 U197/net15 n130 VSS VSS nmos W=0.155u L=0.04u
M662 N20 n130 VDD VDD pmos W=0.205u L=0.04u
M663 N20 X_24 U197/XI16-net11 VDD pmos W=0.205u L=0.04u
M664 U197/XI16-net11 n192 VDD VDD pmos W=0.205u L=0.04u
M665 N16 X_20 U198/net15 VSS nmos W=0.155u L=0.04u
M666 N16 n193 U198/net15 VSS nmos W=0.155u L=0.04u
M667 U198/net15 n133 VSS VSS nmos W=0.155u L=0.04u
M668 N16 n133 VDD VDD pmos W=0.205u L=0.04u
M669 N16 X_20 U198/XI16-net11 VDD pmos W=0.205u L=0.04u
M670 U198/XI16-net11 n193 VDD VDD pmos W=0.205u L=0.04u
M671 N12 X_16 U199/net15 VSS nmos W=0.155u L=0.04u
M672 N12 n194 U199/net15 VSS nmos W=0.155u L=0.04u
M673 U199/net15 n136 VSS VSS nmos W=0.155u L=0.04u
M674 N12 n136 VDD VDD pmos W=0.205u L=0.04u
M675 N12 X_16 U199/XI16-net11 VDD pmos W=0.205u L=0.04u
M676 U199/XI16-net11 n194 VDD VDD pmos W=0.205u L=0.04u
M677 N0 X_4 U200/net15 VSS nmos W=0.155u L=0.04u
M678 N0 n195 U200/net15 VSS nmos W=0.155u L=0.04u
M679 U200/net15 n145 VSS VSS nmos W=0.155u L=0.04u
M680 N0 n145 VDD VDD pmos W=0.205u L=0.04u
M681 N0 X_4 U200/XI16-net11 VDD pmos W=0.205u L=0.04u
M682 U200/XI16-net11 n195 VDD VDD pmos W=0.205u L=0.04u
M683 I88_4 n149 VSS VSS nmos W=0.155u L=0.04u
M684 I88_4 X_1 VSS VSS nmos W=0.155u L=0.04u
M685 U201/XI1-net8 X_1 VDD VDD pmos W=0.205u L=0.04u
M686 I88_4 n149 U201/XI1-net8 VDD pmos W=0.205u L=0.04u
M687 I88_3 U202/net6 VSS VSS nmos W=0.155u L=0.04u
M688 U202/X_u2-net6 n149 VSS VSS nmos W=0.155u L=0.04u
M689 U202/net6 X_1 U202/X_u2-net6 VSS nmos W=0.155u L=0.04u
M690 I88_3 U202/net6 VDD VDD pmos W=0.205u L=0.04u
M691 U202/net6 n149 VDD VDD pmos W=0.205u L=0.04u
M692 U202/net6 X_1 VDD VDD pmos W=0.205u L=0.04u
M693 n149 P_0 VSS VSS nmos W=0.135u L=0.04u
M694 n149 P_0 VDD VDD pmos W=0.205u L=0.04u
M695 I770_4 X_29 VSS VSS nmos W=0.155u L=0.04u
M696 I770_4 n127 VSS VSS nmos W=0.155u L=0.04u
M697 U204/XI1-net8 n127 VDD VDD pmos W=0.205u L=0.04u
M698 I770_4 X_29 U204/XI1-net8 VDD pmos W=0.205u L=0.04u
M699 I770_3 U205/net6 VSS VSS nmos W=0.155u L=0.04u
M700 U205/X_u2-net6 X_29 VSS VSS nmos W=0.155u L=0.04u
M701 U205/net6 n127 U205/X_u2-net6 VSS nmos W=0.155u L=0.04u
M702 I770_3 U205/net6 VDD VDD pmos W=0.205u L=0.04u
M703 U205/net6 X_29 VDD VDD pmos W=0.205u L=0.04u
M704 U205/net6 n127 VDD VDD pmos W=0.205u L=0.04u
M705 U206/XU1-net6 n191 VSS VSS nmos W=0.155u L=0.04u
M706 n127 X_28 U206/XU1-net6 VSS nmos W=0.155u L=0.04u
M707 n127 n191 VDD VDD pmos W=0.155u L=0.04u
M708 n127 X_28 VDD VDD pmos W=0.155u L=0.04u
M709 n191 n178 VSS VSS nmos W=0.155u L=0.04u
M710 n191 n25 VSS VSS nmos W=0.155u L=0.04u
M711 U207/XI1-net8 n25 VDD VDD pmos W=0.205u L=0.04u
M712 n191 n178 U207/XI1-net8 VDD pmos W=0.205u L=0.04u
M713 I73_4 U208/net6 VSS VSS nmos W=0.155u L=0.04u
M714 U208/X_u2-net6 X_3 VSS VSS nmos W=0.155u L=0.04u
M715 U208/net6 n124 U208/X_u2-net6 VSS nmos W=0.155u L=0.04u
M716 I73_4 U208/net6 VDD VDD pmos W=0.205u L=0.04u
M717 U208/net6 X_3 VDD VDD pmos W=0.205u L=0.04u
M718 U208/net6 n124 VDD VDD pmos W=0.205u L=0.04u
M719 I73_3 X_3 VSS VSS nmos W=0.155u L=0.04u
M720 I73_3 n124 VSS VSS nmos W=0.155u L=0.04u
M721 U209/XI1-net8 n124 VDD VDD pmos W=0.205u L=0.04u
M722 I73_3 X_3 U209/XI1-net8 VDD pmos W=0.205u L=0.04u
M723 I676_4 X_25 VSS VSS nmos W=0.155u L=0.04u
M724 I676_4 n130 VSS VSS nmos W=0.155u L=0.04u
M725 U210/XI1-net8 n130 VDD VDD pmos W=0.205u L=0.04u
M726 I676_4 X_25 U210/XI1-net8 VDD pmos W=0.205u L=0.04u
M727 I676_3 U211/net6 VSS VSS nmos W=0.155u L=0.04u
M728 U211/X_u2-net6 X_25 VSS VSS nmos W=0.155u L=0.04u
M729 U211/net6 n130 U211/X_u2-net6 VSS nmos W=0.155u L=0.04u
M730 I676_3 U211/net6 VDD VDD pmos W=0.205u L=0.04u
M731 U211/net6 X_25 VDD VDD pmos W=0.205u L=0.04u
M732 U211/net6 n130 VDD VDD pmos W=0.205u L=0.04u
M733 I661_4 n196 VSS VSS nmos W=0.155u L=0.04u
M734 I661_4 n178 VSS VSS nmos W=0.155u L=0.04u
M735 U212/XI1-net8 n178 VDD VDD pmos W=0.205u L=0.04u
M736 I661_4 n196 U212/XI1-net8 VDD pmos W=0.205u L=0.04u
M737 n178 X_27 VSS VSS nmos W=0.135u L=0.04u
M738 n178 X_27 VDD VDD pmos W=0.205u L=0.04u
M739 I661_3 X_27 VSS VSS nmos W=0.155u L=0.04u
M740 I661_3 n25 VSS VSS nmos W=0.155u L=0.04u
M741 U214/XI1-net8 n25 VDD VDD pmos W=0.205u L=0.04u
M742 I661_3 X_27 U214/XI1-net8 VDD pmos W=0.205u L=0.04u
M743 n25 n196 VSS VSS nmos W=0.135u L=0.04u
M744 n25 n196 VDD VDD pmos W=0.205u L=0.04u
M745 n196 n132 VSS VSS nmos W=0.155u L=0.04u
M746 n196 n130 VSS VSS nmos W=0.155u L=0.04u
M747 n196 n131 VSS VSS nmos W=0.155u L=0.04u
M748 U216/net25 n132 VDD VDD pmos W=0.41u L=0.04u
M749 U216/net28 n130 U216/net25 VDD pmos W=0.41u L=0.04u
M750 n196 n131 U216/net28 VDD pmos W=0.41u L=0.04u
M751 n132 X_26 VSS VSS nmos W=0.135u L=0.04u
M752 n132 X_26 VDD VDD pmos W=0.205u L=0.04u
M753 U218/XU1-net6 n192 VSS VSS nmos W=0.155u L=0.04u
M754 n130 X_24 U218/XU1-net6 VSS nmos W=0.155u L=0.04u
M755 n130 n192 VDD VDD pmos W=0.155u L=0.04u
M756 n130 X_24 VDD VDD pmos W=0.155u L=0.04u
M757 n192 n185 VSS VSS nmos W=0.155u L=0.04u
M758 n192 n26 VSS VSS nmos W=0.155u L=0.04u
M759 U219/XI1-net8 n26 VDD VDD pmos W=0.205u L=0.04u
M760 n192 n185 U219/XI1-net8 VDD pmos W=0.205u L=0.04u
M761 n131 X_25 VSS VSS nmos W=0.135u L=0.04u
M762 n131 X_25 VDD VDD pmos W=0.205u L=0.04u
M763 I578_4 X_21 VSS VSS nmos W=0.155u L=0.04u
M764 I578_4 n133 VSS VSS nmos W=0.155u L=0.04u
M765 U221/XI1-net8 n133 VDD VDD pmos W=0.205u L=0.04u
M766 I578_4 X_21 U221/XI1-net8 VDD pmos W=0.205u L=0.04u
M767 I578_3 U222/net6 VSS VSS nmos W=0.155u L=0.04u
M768 U222/X_u2-net6 X_21 VSS VSS nmos W=0.155u L=0.04u
M769 U222/net6 n133 U222/X_u2-net6 VSS nmos W=0.155u L=0.04u
M770 I578_3 U222/net6 VDD VDD pmos W=0.205u L=0.04u
M771 U222/net6 X_21 VDD VDD pmos W=0.205u L=0.04u
M772 U222/net6 n133 VDD VDD pmos W=0.205u L=0.04u
M773 I563_4 n197 VSS VSS nmos W=0.155u L=0.04u
M774 I563_4 n185 VSS VSS nmos W=0.155u L=0.04u
M775 U223/XI1-net8 n185 VDD VDD pmos W=0.205u L=0.04u
M776 I563_4 n197 U223/XI1-net8 VDD pmos W=0.205u L=0.04u
M777 n185 X_23 VSS VSS nmos W=0.135u L=0.04u
M778 n185 X_23 VDD VDD pmos W=0.205u L=0.04u
M779 I563_3 X_23 VSS VSS nmos W=0.155u L=0.04u
M780 I563_3 n26 VSS VSS nmos W=0.155u L=0.04u
M781 U225/XI1-net8 n26 VDD VDD pmos W=0.205u L=0.04u
M782 I563_3 X_23 U225/XI1-net8 VDD pmos W=0.205u L=0.04u
M783 n26 n197 VSS VSS nmos W=0.135u L=0.04u
M784 n26 n197 VDD VDD pmos W=0.205u L=0.04u
M785 n197 n135 VSS VSS nmos W=0.155u L=0.04u
M786 n197 n133 VSS VSS nmos W=0.155u L=0.04u
M787 n197 n134 VSS VSS nmos W=0.155u L=0.04u
M788 U227/net25 n135 VDD VDD pmos W=0.41u L=0.04u
M789 U227/net28 n133 U227/net25 VDD pmos W=0.41u L=0.04u
M790 n197 n134 U227/net28 VDD pmos W=0.41u L=0.04u
M791 n135 X_22 VSS VSS nmos W=0.135u L=0.04u
M792 n135 X_22 VDD VDD pmos W=0.205u L=0.04u
M793 U229/XU1-net6 n193 VSS VSS nmos W=0.155u L=0.04u
M794 n133 X_20 U229/XU1-net6 VSS nmos W=0.155u L=0.04u
M795 n133 n193 VDD VDD pmos W=0.155u L=0.04u
M796 n133 X_20 VDD VDD pmos W=0.155u L=0.04u
M797 n193 n181 VSS VSS nmos W=0.155u L=0.04u
M798 n193 n27 VSS VSS nmos W=0.155u L=0.04u
M799 U230/XI1-net8 n27 VDD VDD pmos W=0.205u L=0.04u
M800 n193 n181 U230/XI1-net8 VDD pmos W=0.205u L=0.04u
M801 n134 X_21 VSS VSS nmos W=0.135u L=0.04u
M802 n134 X_21 VDD VDD pmos W=0.205u L=0.04u
M803 I480_4 X_17 VSS VSS nmos W=0.155u L=0.04u
M804 I480_4 n136 VSS VSS nmos W=0.155u L=0.04u
M805 U232/XI1-net8 n136 VDD VDD pmos W=0.205u L=0.04u
M806 I480_4 X_17 U232/XI1-net8 VDD pmos W=0.205u L=0.04u
M807 I480_3 U233/net6 VSS VSS nmos W=0.155u L=0.04u
M808 U233/X_u2-net6 X_17 VSS VSS nmos W=0.155u L=0.04u
M809 U233/net6 n136 U233/X_u2-net6 VSS nmos W=0.155u L=0.04u
M810 I480_3 U233/net6 VDD VDD pmos W=0.205u L=0.04u
M811 U233/net6 X_17 VDD VDD pmos W=0.205u L=0.04u
M812 U233/net6 n136 VDD VDD pmos W=0.205u L=0.04u
M813 I465_4 n198 VSS VSS nmos W=0.155u L=0.04u
M814 I465_4 n181 VSS VSS nmos W=0.155u L=0.04u
M815 U234/XI1-net8 n181 VDD VDD pmos W=0.205u L=0.04u
M816 I465_4 n198 U234/XI1-net8 VDD pmos W=0.205u L=0.04u
M817 n181 X_19 VSS VSS nmos W=0.135u L=0.04u
M818 n181 X_19 VDD VDD pmos W=0.205u L=0.04u
M819 I465_3 X_19 VSS VSS nmos W=0.155u L=0.04u
M820 I465_3 n27 VSS VSS nmos W=0.155u L=0.04u
M821 U236/XI1-net8 n27 VDD VDD pmos W=0.205u L=0.04u
M822 I465_3 X_19 U236/XI1-net8 VDD pmos W=0.205u L=0.04u
M823 n27 n198 VSS VSS nmos W=0.135u L=0.04u
M824 n27 n198 VDD VDD pmos W=0.205u L=0.04u
M825 n198 n138 VSS VSS nmos W=0.155u L=0.04u
M826 n198 n136 VSS VSS nmos W=0.155u L=0.04u
M827 n198 n137 VSS VSS nmos W=0.155u L=0.04u
M828 U238/net25 n138 VDD VDD pmos W=0.41u L=0.04u
M829 U238/net28 n136 U238/net25 VDD pmos W=0.41u L=0.04u
M830 n198 n137 U238/net28 VDD pmos W=0.41u L=0.04u
M831 n138 X_18 VSS VSS nmos W=0.135u L=0.04u
M832 n138 X_18 VDD VDD pmos W=0.205u L=0.04u
M833 U240/XU1-net6 n194 VSS VSS nmos W=0.155u L=0.04u
M834 n136 X_16 U240/XU1-net6 VSS nmos W=0.155u L=0.04u
M835 n136 n194 VDD VDD pmos W=0.155u L=0.04u
M836 n136 X_16 VDD VDD pmos W=0.155u L=0.04u
M837 n194 n166 VSS VSS nmos W=0.155u L=0.04u
M838 n194 n28 VSS VSS nmos W=0.155u L=0.04u
M839 U241/XI1-net8 n28 VDD VDD pmos W=0.205u L=0.04u
M840 n194 n166 U241/XI1-net8 VDD pmos W=0.205u L=0.04u
M841 n137 X_17 VSS VSS nmos W=0.135u L=0.04u
M842 n137 X_17 VDD VDD pmos W=0.205u L=0.04u
M843 I382_4 X_13 VSS VSS nmos W=0.155u L=0.04u
M844 I382_4 n139 VSS VSS nmos W=0.155u L=0.04u
M845 U243/XI1-net8 n139 VDD VDD pmos W=0.205u L=0.04u
M846 I382_4 X_13 U243/XI1-net8 VDD pmos W=0.205u L=0.04u
M847 I382_3 U244/net6 VSS VSS nmos W=0.155u L=0.04u
M848 U244/X_u2-net6 X_13 VSS VSS nmos W=0.155u L=0.04u
M849 U244/net6 n139 U244/X_u2-net6 VSS nmos W=0.155u L=0.04u
M850 I382_3 U244/net6 VDD VDD pmos W=0.205u L=0.04u
M851 U244/net6 X_13 VDD VDD pmos W=0.205u L=0.04u
M852 U244/net6 n139 VDD VDD pmos W=0.205u L=0.04u
M853 I367_4 n199 VSS VSS nmos W=0.155u L=0.04u
M854 I367_4 n166 VSS VSS nmos W=0.155u L=0.04u
M855 U245/XI1-net8 n166 VDD VDD pmos W=0.205u L=0.04u
M856 I367_4 n199 U245/XI1-net8 VDD pmos W=0.205u L=0.04u
M857 n166 X_15 VSS VSS nmos W=0.135u L=0.04u
M858 n166 X_15 VDD VDD pmos W=0.205u L=0.04u
M859 I367_3 X_15 VSS VSS nmos W=0.155u L=0.04u
M860 I367_3 n28 VSS VSS nmos W=0.155u L=0.04u
M861 U247/XI1-net8 n28 VDD VDD pmos W=0.205u L=0.04u
M862 I367_3 X_15 U247/XI1-net8 VDD pmos W=0.205u L=0.04u
M863 n28 n199 VSS VSS nmos W=0.135u L=0.04u
M864 n28 n199 VDD VDD pmos W=0.205u L=0.04u
M865 n199 n141 VSS VSS nmos W=0.155u L=0.04u
M866 n199 n139 VSS VSS nmos W=0.155u L=0.04u
M867 n199 n140 VSS VSS nmos W=0.155u L=0.04u
M868 U249/net25 n141 VDD VDD pmos W=0.41u L=0.04u
M869 U249/net28 n139 U249/net25 VDD pmos W=0.41u L=0.04u
M870 n199 n140 U249/net28 VDD pmos W=0.41u L=0.04u
M871 n141 X_14 VSS VSS nmos W=0.135u L=0.04u
M872 n141 X_14 VDD VDD pmos W=0.205u L=0.04u
M873 U251/XU1-net6 n188 VSS VSS nmos W=0.155u L=0.04u
M874 n139 X_12 U251/XU1-net6 VSS nmos W=0.155u L=0.04u
M875 n139 n188 VDD VDD pmos W=0.155u L=0.04u
M876 n139 X_12 VDD VDD pmos W=0.155u L=0.04u
M877 n188 n163 VSS VSS nmos W=0.155u L=0.04u
M878 n188 n29 VSS VSS nmos W=0.155u L=0.04u
M879 U252/XI1-net8 n29 VDD VDD pmos W=0.205u L=0.04u
M880 n188 n163 U252/XI1-net8 VDD pmos W=0.205u L=0.04u
M881 n140 X_13 VSS VSS nmos W=0.135u L=0.04u
M882 n140 X_13 VDD VDD pmos W=0.205u L=0.04u
M883 I284_4 X_9 VSS VSS nmos W=0.155u L=0.04u
M884 I284_4 n142 VSS VSS nmos W=0.155u L=0.04u
M885 U254/XI1-net8 n142 VDD VDD pmos W=0.205u L=0.04u
M886 I284_4 X_9 U254/XI1-net8 VDD pmos W=0.205u L=0.04u
M887 I284_3 U255/net6 VSS VSS nmos W=0.155u L=0.04u
M888 U255/X_u2-net6 X_9 VSS VSS nmos W=0.155u L=0.04u
M889 U255/net6 n142 U255/X_u2-net6 VSS nmos W=0.155u L=0.04u
M890 I284_3 U255/net6 VDD VDD pmos W=0.205u L=0.04u
M891 U255/net6 X_9 VDD VDD pmos W=0.205u L=0.04u
M892 U255/net6 n142 VDD VDD pmos W=0.205u L=0.04u
M893 I269_4 n200 VSS VSS nmos W=0.155u L=0.04u
M894 I269_4 n163 VSS VSS nmos W=0.155u L=0.04u
M895 U256/XI1-net8 n163 VDD VDD pmos W=0.205u L=0.04u
M896 I269_4 n200 U256/XI1-net8 VDD pmos W=0.205u L=0.04u
M897 n163 X_11 VSS VSS nmos W=0.135u L=0.04u
M898 n163 X_11 VDD VDD pmos W=0.205u L=0.04u
M899 I269_3 X_11 VSS VSS nmos W=0.155u L=0.04u
M900 I269_3 n29 VSS VSS nmos W=0.155u L=0.04u
M901 U258/XI1-net8 n29 VDD VDD pmos W=0.205u L=0.04u
M902 I269_3 X_11 U258/XI1-net8 VDD pmos W=0.205u L=0.04u
M903 n29 n200 VSS VSS nmos W=0.135u L=0.04u
M904 n29 n200 VDD VDD pmos W=0.205u L=0.04u
M905 n200 n143 VSS VSS nmos W=0.155u L=0.04u
M906 n200 n142 VSS VSS nmos W=0.155u L=0.04u
M907 n200 n144 VSS VSS nmos W=0.155u L=0.04u
M908 U260/net25 n143 VDD VDD pmos W=0.41u L=0.04u
M909 U260/net28 n142 U260/net25 VDD pmos W=0.41u L=0.04u
M910 n200 n144 U260/net28 VDD pmos W=0.41u L=0.04u
M911 n143 X_9 VSS VSS nmos W=0.135u L=0.04u
M912 n143 X_9 VDD VDD pmos W=0.205u L=0.04u
M913 U262/XU1-net6 n189 VSS VSS nmos W=0.155u L=0.04u
M914 n142 X_8 U262/XU1-net6 VSS nmos W=0.155u L=0.04u
M915 n142 n189 VDD VDD pmos W=0.155u L=0.04u
M916 n142 X_8 VDD VDD pmos W=0.155u L=0.04u
M917 n189 n155 VSS VSS nmos W=0.155u L=0.04u
M918 n189 n30 VSS VSS nmos W=0.155u L=0.04u
M919 U263/XI1-net8 n30 VDD VDD pmos W=0.205u L=0.04u
M920 n189 n155 U263/XI1-net8 VDD pmos W=0.205u L=0.04u
M921 n144 X_10 VSS VSS nmos W=0.135u L=0.04u
M922 n144 X_10 VDD VDD pmos W=0.205u L=0.04u
M923 I186_4 X_5 VSS VSS nmos W=0.155u L=0.04u
M924 I186_4 n145 VSS VSS nmos W=0.155u L=0.04u
M925 U265/XI1-net8 n145 VDD VDD pmos W=0.205u L=0.04u
M926 I186_4 X_5 U265/XI1-net8 VDD pmos W=0.205u L=0.04u
M927 I186_3 U266/net6 VSS VSS nmos W=0.155u L=0.04u
M928 U266/X_u2-net6 X_5 VSS VSS nmos W=0.155u L=0.04u
M929 U266/net6 n145 U266/X_u2-net6 VSS nmos W=0.155u L=0.04u
M930 I186_3 U266/net6 VDD VDD pmos W=0.205u L=0.04u
M931 U266/net6 X_5 VDD VDD pmos W=0.205u L=0.04u
M932 U266/net6 n145 VDD VDD pmos W=0.205u L=0.04u
M933 I171_4 n201 VSS VSS nmos W=0.155u L=0.04u
M934 I171_4 n155 VSS VSS nmos W=0.155u L=0.04u
M935 U267/XI1-net8 n155 VDD VDD pmos W=0.205u L=0.04u
M936 I171_4 n201 U267/XI1-net8 VDD pmos W=0.205u L=0.04u
M937 n155 X_7 VSS VSS nmos W=0.135u L=0.04u
M938 n155 X_7 VDD VDD pmos W=0.205u L=0.04u
M939 I171_3 X_7 VSS VSS nmos W=0.155u L=0.04u
M940 I171_3 n30 VSS VSS nmos W=0.155u L=0.04u
M941 U269/XI1-net8 n30 VDD VDD pmos W=0.205u L=0.04u
M942 I171_3 X_7 U269/XI1-net8 VDD pmos W=0.205u L=0.04u
M943 n30 n201 VSS VSS nmos W=0.135u L=0.04u
M944 n30 n201 VDD VDD pmos W=0.205u L=0.04u
M945 n201 n147 VSS VSS nmos W=0.155u L=0.04u
M946 n201 n145 VSS VSS nmos W=0.155u L=0.04u
M947 n201 n146 VSS VSS nmos W=0.155u L=0.04u
M948 U271/net25 n147 VDD VDD pmos W=0.41u L=0.04u
M949 U271/net28 n145 U271/net25 VDD pmos W=0.41u L=0.04u
M950 n201 n146 U271/net28 VDD pmos W=0.41u L=0.04u
M951 n147 X_6 VSS VSS nmos W=0.135u L=0.04u
M952 n147 X_6 VDD VDD pmos W=0.205u L=0.04u
M953 U273/XU1-net6 n195 VSS VSS nmos W=0.155u L=0.04u
M954 n145 X_4 U273/XU1-net6 VSS nmos W=0.155u L=0.04u
M955 n145 n195 VDD VDD pmos W=0.155u L=0.04u
M956 n145 X_4 VDD VDD pmos W=0.155u L=0.04u
M957 n195 n124 VSS VSS nmos W=0.155u L=0.04u
M958 n195 U274/net4 VSS VSS nmos W=0.155u L=0.04u
M959 U274/net4 X_3 VSS VSS nmos W=0.155u L=0.04u
M960 U274/XU1-net8 U274/net4 VDD VDD pmos W=0.205u L=0.04u
M961 n195 n124 U274/XU1-net8 VDD pmos W=0.205u L=0.04u
M962 U274/net4 X_3 VDD VDD pmos W=0.205u L=0.04u
M963 n124 X_1 U275/XI0-net10 VSS nmos W=0.155u L=0.04u
M964 U275/XI0-net10 P_0 U275/XI0-net13 VSS nmos W=0.155u L=0.04u
M965 U275/XI0-net13 X_2 VSS VSS nmos W=0.155u L=0.04u
M966 n124 X_2 VDD VDD pmos W=0.205u L=0.04u
M967 n124 X_1 VDD VDD pmos W=0.205u L=0.04u
M968 n124 P_0 VDD VDD pmos W=0.205u L=0.04u
M969 n146 X_5 VSS VSS nmos W=0.135u L=0.04u
M970 n146 X_5 VDD VDD pmos W=0.205u L=0.04u
.ENDS
