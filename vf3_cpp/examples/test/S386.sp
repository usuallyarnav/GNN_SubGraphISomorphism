.SUBCKT s386 CK v0 v1 Lv13_D_10 Lv13_D_11 Lv13_D_12 Lv13_D_6 Lv13_D_7 Lv13_D_8 Lv13_D_9 v2 v3 v4 v5 v6 VDD VSS
M1 v13_D_3 n66 VSS VSS nmos W=0.31u L=0.04u
M2 v13_D_3 n66 VDD VDD pmos W=0.41u L=0.04u
M3 v13_D_4 n64 VSS VSS nmos W=0.31u L=0.04u
M4 v13_D_4 n64 VDD VDD pmos W=0.41u L=0.04u
M5 v13_D_2 n67 VSS VSS nmos W=0.31u L=0.04u
M6 v13_D_2 n67 VDD VDD pmos W=0.41u L=0.04u
M7 v13_D_5 n62 VSS VSS nmos W=0.31u L=0.04u
M8 v13_D_5 n62 VDD VDD pmos W=0.41u L=0.04u
M9 v13_D_0 n65 VSS VSS nmos W=0.31u L=0.04u
M10 v13_D_0 n65 VDD VDD pmos W=0.41u L=0.04u
M11 v13_D_1 n63 VSS VSS nmos W=0.31u L=0.04u
M12 v13_D_1 n63 VDD VDD pmos W=0.41u L=0.04u
M13 U69/net36 n70 U69/net24 VSS nmos W=0.155u L=0.04u
M14 U69/net24 n71 VSS VSS nmos W=0.155u L=0.04u
M15 n67 n68 U69/net36 VSS nmos W=0.155u L=0.04u
M16 n67 n69 U69/net36 VSS nmos W=0.155u L=0.04u
M17 n67 n69 U69/net35 VDD pmos W=0.205u L=0.04u
M18 U69/net35 n68 VDD VDD pmos W=0.205u L=0.04u
M19 n67 n71 VDD VDD pmos W=0.205u L=0.04u
M20 n67 n70 VDD VDD pmos W=0.205u L=0.04u
M21 n71 v0 U70/net19 VDD pmos W=0.205u L=0.04u
M22 n71 v9 U70/net19 VDD pmos W=0.205u L=0.04u
M23 n71 n72 U70/net19 VDD pmos W=0.205u L=0.04u
M24 U70/net19 n73 VDD VDD pmos W=0.205u L=0.04u
M25 n71 n73 VSS VSS nmos W=0.155u L=0.04u
M26 U70/XI20-net13 v9 VSS VSS nmos W=0.155u L=0.04u
M27 n71 v0 U70/XI20-net17 VSS nmos W=0.155u L=0.04u
M28 U70/XI20-net17 n72 U70/XI20-net13 VSS nmos W=0.155u L=0.04u
M29 n70 n74 U71/net15 VSS nmos W=0.155u L=0.04u
M30 n70 n72 U71/net15 VSS nmos W=0.155u L=0.04u
M31 U71/net15 v10 VSS VSS nmos W=0.155u L=0.04u
M32 n70 v10 VDD VDD pmos W=0.205u L=0.04u
M33 n70 n74 U71/XI16-net11 VDD pmos W=0.205u L=0.04u
M34 U71/XI16-net11 n72 VDD VDD pmos W=0.205u L=0.04u
M35 n74 v9 U72/net27 VSS nmos W=0.155u L=0.04u
M36 U72/net27 n75 VSS VSS nmos W=0.155u L=0.04u
M37 n74 v0 VSS VSS nmos W=0.155u L=0.04u
M38 n74 n75 U72/net13 VDD pmos W=0.205u L=0.04u
M39 U72/net13 v0 VDD VDD pmos W=0.205u L=0.04u
M40 n74 v9 U72/net13 VDD pmos W=0.205u L=0.04u
M41 n66 n78 VSS VSS nmos W=0.155u L=0.04u
M42 n66 n77 VSS VSS nmos W=0.155u L=0.04u
M43 n66 n76 VSS VSS nmos W=0.155u L=0.04u
M44 U73/net25 n78 VDD VDD pmos W=0.41u L=0.04u
M45 U73/net28 n77 U73/net25 VDD pmos W=0.41u L=0.04u
M46 n66 n76 U73/net28 VDD pmos W=0.41u L=0.04u
M47 n78 n81 VSS VSS nmos W=0.155u L=0.04u
M48 n78 n80 VSS VSS nmos W=0.155u L=0.04u
M49 n78 n79 VSS VSS nmos W=0.155u L=0.04u
M50 n78 v5 VSS VSS nmos W=0.155u L=0.04u
M51 U74/net49 n80 U74/net52 VDD pmos W=0.41u L=0.04u
M52 U74/net52 n81 VDD VDD pmos W=0.41u L=0.04u
M53 U74/net46 n79 U74/net49 VDD pmos W=0.41u L=0.04u
M54 n78 v5 U74/net46 VDD pmos W=0.41u L=0.04u
M55 n76 n73 U75/net10 VSS nmos W=0.155u L=0.04u
M56 U75/net10 n81 VSS VSS nmos W=0.155u L=0.04u
M57 n76 n82 U75/net10 VSS nmos W=0.155u L=0.04u
M58 U75/net10 n83 VSS VSS nmos W=0.155u L=0.04u
M59 U75/net30 n81 VDD VDD pmos W=0.205u L=0.04u
M60 n76 n73 U75/net24 VDD pmos W=0.205u L=0.04u
M61 U75/net24 n82 VDD VDD pmos W=0.205u L=0.04u
M62 n76 n83 U75/net30 VDD pmos W=0.205u L=0.04u
M63 n73 n84 VSS VSS nmos W=0.135u L=0.04u
M64 n73 n84 VDD VDD pmos W=0.205u L=0.04u
M65 U77/net36 n69 U77/net24 VSS nmos W=0.155u L=0.04u
M66 U77/net24 n86 VSS VSS nmos W=0.155u L=0.04u
M67 n65 v11 U77/net36 VSS nmos W=0.155u L=0.04u
M68 n65 n85 U77/net36 VSS nmos W=0.155u L=0.04u
M69 n65 n85 U77/net35 VDD pmos W=0.205u L=0.04u
M70 U77/net35 v11 VDD VDD pmos W=0.205u L=0.04u
M71 n65 n86 VDD VDD pmos W=0.205u L=0.04u
M72 n65 n69 VDD VDD pmos W=0.205u L=0.04u
M73 U78/XU1-net6 n88 VSS VSS nmos W=0.155u L=0.04u
M74 n64 n87 U78/XU1-net6 VSS nmos W=0.155u L=0.04u
M75 n64 n88 VDD VDD pmos W=0.155u L=0.04u
M76 n64 n87 VDD VDD pmos W=0.155u L=0.04u
M77 n87 n89 U79/net23 VDD pmos W=0.205u L=0.04u
M78 n87 n91 U79/net23 VDD pmos W=0.205u L=0.04u
M79 n87 n90 U79/net23 VDD pmos W=0.205u L=0.04u
M80 U79/net23 v12 VDD VDD pmos W=0.205u L=0.04u
M81 U79/net23 n92 VDD VDD pmos W=0.205u L=0.04u
M82 U79/XI20-net13 n91 VSS VSS nmos W=0.155u L=0.04u
M83 n87 n89 U79/XI20-net17 VSS nmos W=0.155u L=0.04u
M84 U79/XI20-net17 n90 U79/XI20-net13 VSS nmos W=0.155u L=0.04u
M85 n87 v12 U79/XI17-net17 VSS nmos W=0.155u L=0.04u
M86 U79/XI17-net17 n92 VSS VSS nmos W=0.155u L=0.04u
M87 U80/XU1-net6 n75 VSS VSS nmos W=0.155u L=0.04u
M88 n92 n93 U80/XU1-net6 VSS nmos W=0.155u L=0.04u
M89 n92 n75 VDD VDD pmos W=0.155u L=0.04u
M90 n92 n93 VDD VDD pmos W=0.155u L=0.04u
M91 n91 v2 U81/net15 VSS nmos W=0.155u L=0.04u
M92 n91 v12 U81/net15 VSS nmos W=0.155u L=0.04u
M93 U81/net15 n94 VSS VSS nmos W=0.155u L=0.04u
M94 n91 n94 VDD VDD pmos W=0.205u L=0.04u
M95 n91 v2 U81/XI16-net11 VDD pmos W=0.205u L=0.04u
M96 U81/XI16-net11 v12 VDD VDD pmos W=0.205u L=0.04u
M97 U82/p2 n97 VSS VSS nmos W=0.155u L=0.04u
M98 U82/p0 n96 U82/p1 VSS nmos W=0.155u L=0.04u
M99 U82/p1 n86 U82/p2 VSS nmos W=0.155u L=0.04u
M100 n63 n95 U82/p0 VSS nmos W=0.155u L=0.04u
M101 n63 n86 VDD VDD pmos W=0.205u L=0.04u
M102 n63 n96 VDD VDD pmos W=0.205u L=0.04u
M103 n63 n95 VDD VDD pmos W=0.205u L=0.04u
M104 n63 n97 VDD VDD pmos W=0.205u L=0.04u
M105 U83/net19 n68 VSS VSS nmos W=0.155u L=0.04u
M106 n96 n68 U83/net40 VSS nmos W=0.155u L=0.04u
M107 n96 U83/net19 U83/net36 VSS nmos W=0.155u L=0.04u
M108 U83/net40 n98 VSS VSS nmos W=0.31u L=0.04u
M109 U83/net36 v12 VSS VSS nmos W=0.155u L=0.04u
M110 U83/net19 n68 VDD VDD pmos W=0.205u L=0.04u
M111 n96 U83/net19 U83/net26 VDD pmos W=0.325u L=0.04u
M112 U83/net26 n98 VDD VDD pmos W=0.41u L=0.04u
M113 n96 n68 U83/net30 VDD pmos W=0.325u L=0.04u
M114 U83/net30 v12 VDD VDD pmos W=0.205u L=0.04u
M115 n98 v2 VSS VSS nmos W=0.155u L=0.04u
M116 n98 v12 VSS VSS nmos W=0.155u L=0.04u
M117 U84/XI1-net8 v12 VDD VDD pmos W=0.205u L=0.04u
M118 n98 v2 U84/XI1-net8 VDD pmos W=0.205u L=0.04u
M119 U85/net19 v11 VSS VSS nmos W=0.155u L=0.04u
M120 n95 v11 U85/net40 VSS nmos W=0.155u L=0.04u
M121 n95 U85/net19 U85/net36 VSS nmos W=0.155u L=0.04u
M122 U85/net40 n100 VSS VSS nmos W=0.31u L=0.04u
M123 U85/net36 n99 VSS VSS nmos W=0.155u L=0.04u
M124 U85/net19 v11 VDD VDD pmos W=0.205u L=0.04u
M125 n95 U85/net19 U85/net26 VDD pmos W=0.325u L=0.04u
M126 U85/net26 n100 VDD VDD pmos W=0.41u L=0.04u
M127 n95 v11 U85/net30 VDD pmos W=0.325u L=0.04u
M128 U85/net30 n99 VDD VDD pmos W=0.205u L=0.04u
M129 n100 v5 U86/net15 VSS nmos W=0.155u L=0.04u
M130 n100 n90 U86/net15 VSS nmos W=0.155u L=0.04u
M131 U86/net15 n101 VSS VSS nmos W=0.155u L=0.04u
M132 n100 n101 VDD VDD pmos W=0.205u L=0.04u
M133 n100 v5 U86/XI16-net11 VDD pmos W=0.205u L=0.04u
M134 U86/XI16-net11 n90 VDD VDD pmos W=0.205u L=0.04u
M135 n99 n94 U87/net14 VSS nmos W=0.155u L=0.04u
M136 U87/net14 n103 VSS VSS nmos W=0.155u L=0.04u
M137 U87/net14 v4 VSS VSS nmos W=0.155u L=0.04u
M138 n99 n102 U87/net14 VSS nmos W=0.155u L=0.04u
M139 n99 v7 U87/net14 VSS nmos W=0.155u L=0.04u
M140 n99 n103 U87/XI16-net11 VDD pmos W=0.205u L=0.04u
M141 U87/XI16-net11 v4 VDD VDD pmos W=0.205u L=0.04u
M142 n99 n102 U87/XI15-net11 VDD pmos W=0.205u L=0.04u
M143 U87/XI15-net11 v7 U87/XI15-net18 VDD pmos W=0.205u L=0.04u
M144 U87/XI15-net18 n94 VDD VDD pmos W=0.205u L=0.04u
M145 U88/net29 n105 VSS VSS nmos W=0.155u L=0.04u
M146 n103 v7 U88/net29 VSS nmos W=0.155u L=0.04u
M147 n103 n104 U88/net23 VSS nmos W=0.155u L=0.04u
M148 U88/net23 n94 VSS VSS nmos W=0.155u L=0.04u
M149 U88/net20 n94 n103 VDD pmos W=0.205u L=0.04u
M150 U88/net20 n104 n103 VDD pmos W=0.205u L=0.04u
M151 VDD v7 U88/net20 VDD pmos W=0.205u L=0.04u
M152 VDD n105 U88/net20 VDD pmos W=0.205u L=0.04u
M153 n102 v2 VSS VSS nmos W=0.155u L=0.04u
M154 n102 n105 VSS VSS nmos W=0.155u L=0.04u
M155 U89/XI1-net8 n105 VDD VDD pmos W=0.205u L=0.04u
M156 n102 v2 U89/XI1-net8 VDD pmos W=0.205u L=0.04u
M157 U90/net36 n106 U90/net24 VSS nmos W=0.155u L=0.04u
M158 U90/net24 n88 VSS VSS nmos W=0.155u L=0.04u
M159 n62 v8 U90/net36 VSS nmos W=0.155u L=0.04u
M160 n62 n93 U90/net36 VSS nmos W=0.155u L=0.04u
M161 n62 n93 U90/net35 VDD pmos W=0.205u L=0.04u
M162 U90/net35 v8 VDD VDD pmos W=0.205u L=0.04u
M163 n62 n88 VDD VDD pmos W=0.205u L=0.04u
M164 n62 n106 VDD VDD pmos W=0.205u L=0.04u
M165 n88 n108 VSS VSS nmos W=0.155u L=0.04u
M166 n88 n84 VSS VSS nmos W=0.155u L=0.04u
M167 n88 U91/net12 VSS VSS nmos W=0.155u L=0.04u
M168 U91/net12 n107 VSS VSS nmos W=0.155u L=0.04u
M169 U91/XU9-net9 U91/net12 VDD VDD pmos W=0.41u L=0.04u
M170 U91/XU9-net12 n84 U91/XU9-net9 VDD pmos W=0.41u L=0.04u
M171 n88 n108 U91/XU9-net12 VDD pmos W=0.41u L=0.04u
M172 U91/net12 n107 VDD VDD pmos W=0.31u L=0.04u
M173 U92/net19 v12 VSS VSS nmos W=0.155u L=0.04u
M174 n107 v12 U92/net40 VSS nmos W=0.155u L=0.04u
M175 n107 U92/net19 U92/net36 VSS nmos W=0.155u L=0.04u
M176 U92/net40 v8 VSS VSS nmos W=0.31u L=0.04u
M177 U92/net36 n93 VSS VSS nmos W=0.155u L=0.04u
M178 U92/net19 v12 VDD VDD pmos W=0.205u L=0.04u
M179 n107 U92/net19 U92/net26 VDD pmos W=0.325u L=0.04u
M180 U92/net26 v8 VDD VDD pmos W=0.41u L=0.04u
M181 n107 v12 U92/net30 VDD pmos W=0.325u L=0.04u
M182 U92/net30 n93 VDD VDD pmos W=0.205u L=0.04u
M183 VSS n110 U93/net22 VSS nmos W=0.155u L=0.04u
M184 U93/net22 n105 n106 VSS nmos W=0.155u L=0.04u
M185 U93/net22 v7 n106 VSS nmos W=0.155u L=0.04u
M186 U93/net22 n109 n106 VSS nmos W=0.155u L=0.04u
M187 U93/net38 n109 VDD VDD pmos W=0.205u L=0.04u
M188 U93/net35 v7 U93/net38 VDD pmos W=0.205u L=0.04u
M189 n106 n105 U93/net35 VDD pmos W=0.205u L=0.04u
M190 n106 n110 VDD VDD pmos W=0.205u L=0.04u
M191 n105 v3 VSS VSS nmos W=0.135u L=0.04u
M192 n105 v3 VDD VDD pmos W=0.205u L=0.04u
M193 VSS n114 U95/net22 VSS nmos W=0.155u L=0.04u
M194 U95/net22 n113 Lv13_D_9 VSS nmos W=0.155u L=0.04u
M195 U95/net22 n112 Lv13_D_9 VSS nmos W=0.155u L=0.04u
M196 U95/net22 n111 Lv13_D_9 VSS nmos W=0.155u L=0.04u
M197 U95/net38 n111 VDD VDD pmos W=0.205u L=0.04u
M198 U95/net35 n112 U95/net38 VDD pmos W=0.205u L=0.04u
M199 Lv13_D_9 n113 U95/net35 VDD pmos W=0.205u L=0.04u
M200 Lv13_D_9 n114 VDD VDD pmos W=0.205u L=0.04u
M201 n111 n80 U96/XI0-net10 VSS nmos W=0.155u L=0.04u
M202 U96/XI0-net10 n90 U96/XI0-net13 VSS nmos W=0.155u L=0.04u
M203 U96/XI0-net13 n115 VSS VSS nmos W=0.155u L=0.04u
M204 n111 n115 VDD VDD pmos W=0.205u L=0.04u
M205 n111 n80 VDD VDD pmos W=0.205u L=0.04u
M206 n111 n90 VDD VDD pmos W=0.205u L=0.04u
M207 Lv13_D_8 v6 VSS VSS nmos W=0.155u L=0.04u
M208 Lv13_D_8 n114 VSS VSS nmos W=0.155u L=0.04u
M209 U97/XI1-net8 n114 VDD VDD pmos W=0.205u L=0.04u
M210 Lv13_D_8 v6 U97/XI1-net8 VDD pmos W=0.205u L=0.04u
M211 n114 n116 VSS VSS nmos W=0.135u L=0.04u
M212 n114 n116 VDD VDD pmos W=0.205u L=0.04u
M213 Lv13_D_7 n84 VSS VSS nmos W=0.155u L=0.04u
M214 Lv13_D_7 n82 VSS VSS nmos W=0.155u L=0.04u
M215 Lv13_D_7 n117 VSS VSS nmos W=0.155u L=0.04u
M216 U99/net25 n84 VDD VDD pmos W=0.41u L=0.04u
M217 U99/net28 n82 U99/net25 VDD pmos W=0.41u L=0.04u
M218 Lv13_D_7 n117 U99/net28 VDD pmos W=0.41u L=0.04u
M219 U100/net19 v11 VSS VSS nmos W=0.155u L=0.04u
M220 n117 v11 U100/net40 VSS nmos W=0.155u L=0.04u
M221 n117 U100/net19 U100/net36 VSS nmos W=0.155u L=0.04u
M222 U100/net40 n118 VSS VSS nmos W=0.31u L=0.04u
M223 U100/net36 n85 VSS VSS nmos W=0.155u L=0.04u
M224 U100/net19 v11 VDD VDD pmos W=0.205u L=0.04u
M225 n117 U100/net19 U100/net26 VDD pmos W=0.325u L=0.04u
M226 U100/net26 n118 VDD VDD pmos W=0.41u L=0.04u
M227 n117 v11 U100/net30 VDD pmos W=0.325u L=0.04u
M228 U100/net30 n85 VDD VDD pmos W=0.205u L=0.04u
M229 n118 v8 VSS VSS nmos W=0.155u L=0.04u
M230 n118 n90 VSS VSS nmos W=0.155u L=0.04u
M231 U101/XI1-net8 n90 VDD VDD pmos W=0.205u L=0.04u
M232 n118 v8 U101/XI1-net8 VDD pmos W=0.205u L=0.04u
M233 Lv13_D_6 n119 VSS VSS nmos W=0.155u L=0.04u
M234 Lv13_D_6 n84 VSS VSS nmos W=0.155u L=0.04u
M235 U102/XI1-net8 n84 VDD VDD pmos W=0.205u L=0.04u
M236 Lv13_D_6 n119 U102/XI1-net8 VDD pmos W=0.205u L=0.04u
M237 n119 v5 U103/net23 VDD pmos W=0.205u L=0.04u
M238 n119 n120 U103/net23 VDD pmos W=0.205u L=0.04u
M239 n119 n93 U103/net23 VDD pmos W=0.205u L=0.04u
M240 U103/net23 n121 VDD VDD pmos W=0.205u L=0.04u
M241 U103/net23 n122 VDD VDD pmos W=0.205u L=0.04u
M242 U103/XI20-net13 n120 VSS VSS nmos W=0.155u L=0.04u
M243 n119 v5 U103/XI20-net17 VSS nmos W=0.155u L=0.04u
M244 U103/XI20-net17 n93 U103/XI20-net13 VSS nmos W=0.155u L=0.04u
M245 n119 n121 U103/XI17-net17 VSS nmos W=0.155u L=0.04u
M246 U103/XI17-net17 n122 VSS VSS nmos W=0.155u L=0.04u
M247 n122 n85 U104/net10 VSS nmos W=0.155u L=0.04u
M248 U104/net10 n109 VSS VSS nmos W=0.155u L=0.04u
M249 n122 n90 U104/net10 VSS nmos W=0.155u L=0.04u
M250 U104/net10 n115 VSS VSS nmos W=0.155u L=0.04u
M251 U104/net30 n109 VDD VDD pmos W=0.205u L=0.04u
M252 n122 n85 U104/net24 VDD pmos W=0.205u L=0.04u
M253 U104/net24 n90 VDD VDD pmos W=0.205u L=0.04u
M254 n122 n115 U104/net30 VDD pmos W=0.205u L=0.04u
M255 n109 v2 VSS VSS nmos W=0.135u L=0.04u
M256 n109 v2 VDD VDD pmos W=0.205u L=0.04u
M257 n85 n89 VSS VSS nmos W=0.135u L=0.04u
M258 n85 n89 VDD VDD pmos W=0.205u L=0.04u
M259 n121 n112 VSS VSS nmos W=0.135u L=0.04u
M260 n121 n112 VDD VDD pmos W=0.205u L=0.04u
M261 n120 n108 VSS VSS nmos W=0.155u L=0.04u
M262 n120 v8 VSS VSS nmos W=0.155u L=0.04u
M263 n120 n104 VSS VSS nmos W=0.155u L=0.04u
M264 U108/net25 n108 VDD VDD pmos W=0.41u L=0.04u
M265 U108/net28 v8 U108/net25 VDD pmos W=0.41u L=0.04u
M266 n120 n104 U108/net28 VDD pmos W=0.41u L=0.04u
M267 n93 n110 VSS VSS nmos W=0.155u L=0.04u
M268 n93 v7 VSS VSS nmos W=0.155u L=0.04u
M269 U109/XI1-net8 v7 VDD VDD pmos W=0.205u L=0.04u
M270 n93 n110 U109/XI1-net8 VDD pmos W=0.205u L=0.04u
M271 Lv13_D_12 n75 VSS VSS nmos W=0.155u L=0.04u
M272 Lv13_D_12 n81 VSS VSS nmos W=0.155u L=0.04u
M273 Lv13_D_12 n123 VSS VSS nmos W=0.155u L=0.04u
M274 Lv13_D_12 n79 VSS VSS nmos W=0.155u L=0.04u
M275 U110/net49 n81 U110/net52 VDD pmos W=0.41u L=0.04u
M276 U110/net52 n75 VDD VDD pmos W=0.41u L=0.04u
M277 U110/net46 n123 U110/net49 VDD pmos W=0.41u L=0.04u
M278 Lv13_D_12 n79 U110/net46 VDD pmos W=0.41u L=0.04u
M279 n75 v5 VSS VSS nmos W=0.135u L=0.04u
M280 n75 v5 VDD VDD pmos W=0.205u L=0.04u
M281 U112/XU1-net6 n124 VSS VSS nmos W=0.155u L=0.04u
M282 n123 v9 U112/XU1-net6 VSS nmos W=0.155u L=0.04u
M283 n123 n124 VDD VDD pmos W=0.155u L=0.04u
M284 n123 v9 VDD VDD pmos W=0.155u L=0.04u
M285 Lv13_D_11 n89 U113/net26 VSS nmos W=0.155u L=0.04u
M286 Lv13_D_11 n112 U113/net26 VSS nmos W=0.155u L=0.04u
M287 U113/net29 n125 VSS VSS nmos W=0.155u L=0.04u
M288 U113/net26 n86 U113/net29 VSS nmos W=0.155u L=0.04u
M289 U113/net26 n82 U113/net29 VSS nmos W=0.155u L=0.04u
M290 Lv13_D_11 n112 U113/net43 VDD pmos W=0.205u L=0.04u
M291 Lv13_D_11 n82 U113/net49 VDD pmos W=0.205u L=0.04u
M292 U113/net49 n86 VDD VDD pmos W=0.205u L=0.04u
M293 U113/net43 n89 VDD VDD pmos W=0.205u L=0.04u
M294 Lv13_D_11 n125 VDD VDD pmos W=0.205u L=0.04u
M295 n125 n77 VSS VSS nmos W=0.155u L=0.04u
M296 n125 n116 VSS VSS nmos W=0.155u L=0.04u
M297 U114/XI1-net8 n116 VDD VDD pmos W=0.205u L=0.04u
M298 n125 n77 U114/XI1-net8 VDD pmos W=0.205u L=0.04u
M299 n116 v9 VSS VSS nmos W=0.155u L=0.04u
M300 n116 n124 VSS VSS nmos W=0.155u L=0.04u
M301 n116 n79 VSS VSS nmos W=0.155u L=0.04u
M302 n116 n81 VSS VSS nmos W=0.155u L=0.04u
M303 U115/net49 n124 U115/net52 VDD pmos W=0.41u L=0.04u
M304 U115/net52 v9 VDD VDD pmos W=0.41u L=0.04u
M305 U115/net46 n79 U115/net49 VDD pmos W=0.41u L=0.04u
M306 n116 n81 U115/net46 VDD pmos W=0.41u L=0.04u
M307 n77 n101 VSS VSS nmos W=0.155u L=0.04u
M308 n77 v10 VSS VSS nmos W=0.155u L=0.04u
M309 n77 n83 VSS VSS nmos W=0.155u L=0.04u
M310 U116/net25 n101 VDD VDD pmos W=0.41u L=0.04u
M311 U116/net28 v10 U116/net25 VDD pmos W=0.41u L=0.04u
M312 n77 n83 U116/net28 VDD pmos W=0.41u L=0.04u
M313 n83 n126 U117/net27 VSS nmos W=0.155u L=0.04u
M314 U117/net27 v1 VSS VSS nmos W=0.155u L=0.04u
M315 n83 n124 VSS VSS nmos W=0.155u L=0.04u
M316 n83 v1 U117/net13 VDD pmos W=0.205u L=0.04u
M317 U117/net13 n124 VDD VDD pmos W=0.205u L=0.04u
M318 n83 n126 U117/net13 VDD pmos W=0.205u L=0.04u
M319 n124 v0 VSS VSS nmos W=0.135u L=0.04u
M320 n124 v0 VDD VDD pmos W=0.205u L=0.04u
M321 n86 v8 U119/net19 VDD pmos W=0.205u L=0.04u
M322 n86 v7 U119/net19 VDD pmos W=0.205u L=0.04u
M323 n86 v11 U119/net19 VDD pmos W=0.205u L=0.04u
M324 U119/net19 n84 VDD VDD pmos W=0.205u L=0.04u
M325 n86 n84 VSS VSS nmos W=0.155u L=0.04u
M326 U119/XI20-net13 v7 VSS VSS nmos W=0.155u L=0.04u
M327 n86 v8 U119/XI20-net17 VSS nmos W=0.155u L=0.04u
M328 U119/XI20-net17 v11 U119/XI20-net13 VSS nmos W=0.155u L=0.04u
M329 U120/XU1-net6 n80 VSS VSS nmos W=0.155u L=0.04u
M330 n84 v0 U120/XU1-net6 VSS nmos W=0.155u L=0.04u
M331 n84 n80 VDD VDD pmos W=0.155u L=0.04u
M332 n84 v0 VDD VDD pmos W=0.155u L=0.04u
M333 U121/XU1-net6 n113 VSS VSS nmos W=0.155u L=0.04u
M334 n89 n115 U121/XU1-net6 VSS nmos W=0.155u L=0.04u
M335 n89 n113 VDD VDD pmos W=0.155u L=0.04u
M336 n89 n115 VDD VDD pmos W=0.155u L=0.04u
M337 n113 v4 VSS VSS nmos W=0.135u L=0.04u
M338 n113 v4 VDD VDD pmos W=0.205u L=0.04u
M339 n115 n94 VSS VSS nmos W=0.155u L=0.04u
M340 n115 v3 VSS VSS nmos W=0.155u L=0.04u
M341 U123/XI1-net8 v3 VDD VDD pmos W=0.205u L=0.04u
M342 n115 n94 U123/XI1-net8 VDD pmos W=0.205u L=0.04u
M343 U124/XU1-net6 n110 VSS VSS nmos W=0.155u L=0.04u
M344 n112 n69 U124/XU1-net6 VSS nmos W=0.155u L=0.04u
M345 n112 n110 VDD VDD pmos W=0.155u L=0.04u
M346 n112 n69 VDD VDD pmos W=0.155u L=0.04u
M347 n69 n82 VSS VSS nmos W=0.135u L=0.04u
M348 n69 n82 VDD VDD pmos W=0.205u L=0.04u
M349 U126/XU1-net6 n104 VSS VSS nmos W=0.155u L=0.04u
M350 n82 n97 U126/XU1-net6 VSS nmos W=0.155u L=0.04u
M351 n82 n104 VDD VDD pmos W=0.155u L=0.04u
M352 n82 n97 VDD VDD pmos W=0.155u L=0.04u
M353 n97 n108 VSS VSS nmos W=0.135u L=0.04u
M354 n97 n108 VDD VDD pmos W=0.205u L=0.04u
M355 U128/XU1-net6 n126 VSS VSS nmos W=0.155u L=0.04u
M356 n108 n79 U128/XU1-net6 VSS nmos W=0.155u L=0.04u
M357 n108 n126 VDD VDD pmos W=0.155u L=0.04u
M358 n108 n79 VDD VDD pmos W=0.155u L=0.04u
M359 Lv13_D_10 n81 VSS VSS nmos W=0.155u L=0.04u
M360 Lv13_D_10 n80 VSS VSS nmos W=0.155u L=0.04u
M361 Lv13_D_10 n126 VSS VSS nmos W=0.155u L=0.04u
M362 Lv13_D_10 n127 VSS VSS nmos W=0.155u L=0.04u
M363 U129/net49 n80 U129/net52 VDD pmos W=0.41u L=0.04u
M364 U129/net52 n81 VDD VDD pmos W=0.41u L=0.04u
M365 U129/net46 n126 U129/net49 VDD pmos W=0.41u L=0.04u
M366 Lv13_D_10 n127 U129/net46 VDD pmos W=0.41u L=0.04u
M367 U130/net13 n72 VSS VSS nmos W=0.155u L=0.04u
M368 U130/net16 U130/net13 VSS VSS nmos W=0.155u L=0.04u
M369 n81 n68 U130/net16 VSS nmos W=0.155u L=0.04u
M370 U130/net13 n72 VDD VDD pmos W=0.205u L=0.04u
M371 VDD U130/net13 n81 VDD pmos W=0.205u L=0.04u
M372 VDD n68 n81 VDD pmos W=0.205u L=0.04u
M373 n68 n101 VSS VSS nmos W=0.135u L=0.04u
M374 n68 n101 VDD VDD pmos W=0.205u L=0.04u
M375 U132/XU1-net6 n94 VSS VSS nmos W=0.155u L=0.04u
M376 n101 n90 U132/XU1-net6 VSS nmos W=0.155u L=0.04u
M377 n101 n94 VDD VDD pmos W=0.155u L=0.04u
M378 n101 n90 VDD VDD pmos W=0.155u L=0.04u
M379 n94 v8 VSS VSS nmos W=0.135u L=0.04u
M380 n94 v8 VDD VDD pmos W=0.205u L=0.04u
M381 n90 v7 VSS VSS nmos W=0.135u L=0.04u
M382 n90 v7 VDD VDD pmos W=0.205u L=0.04u
M383 U135/XU1-net6 n110 VSS VSS nmos W=0.155u L=0.04u
M384 n72 n104 U135/XU1-net6 VSS nmos W=0.155u L=0.04u
M385 n72 n110 VDD VDD pmos W=0.155u L=0.04u
M386 n72 n104 VDD VDD pmos W=0.155u L=0.04u
M387 n110 v11 VSS VSS nmos W=0.135u L=0.04u
M388 n110 v11 VDD VDD pmos W=0.205u L=0.04u
M389 n104 v12 VSS VSS nmos W=0.135u L=0.04u
M390 n104 v12 VDD VDD pmos W=0.205u L=0.04u
M391 n80 v1 VSS VSS nmos W=0.135u L=0.04u
M392 n80 v1 VDD VDD pmos W=0.205u L=0.04u
M393 n126 v9 VSS VSS nmos W=0.135u L=0.04u
M394 n126 v9 VDD VDD pmos W=0.205u L=0.04u
M395 n127 v5 U140/net27 VSS nmos W=0.155u L=0.04u
M396 U140/net27 v0 VSS VSS nmos W=0.155u L=0.04u
M397 n127 n79 VSS VSS nmos W=0.155u L=0.04u
M398 n127 v0 U140/net13 VDD pmos W=0.205u L=0.04u
M399 U140/net13 n79 VDD VDD pmos W=0.205u L=0.04u
M400 n127 v5 U140/net13 VDD pmos W=0.205u L=0.04u
M401 n79 v10 VSS VSS nmos W=0.135u L=0.04u
M402 n79 v10 VDD VDD pmos W=0.205u L=0.04u
.ENDS
