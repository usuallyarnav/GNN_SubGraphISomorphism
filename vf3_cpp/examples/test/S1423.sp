.SUBCKT s1423 CK G0 G1 G10 G11 G12 G13 G14 G15 G16 G2 G3 G4 G5 G6 G7 G701BF G702 G93 G727 G95 G8 G9 VDD VSS
M1 G693 OR2_132/net7 VSS VSS nmos W=0.31u L=0.04u
M2 OR2_132/net7 G692 VSS VSS nmos W=0.155u L=0.04u
M3 OR2_132/net7 G699 VSS VSS nmos W=0.155u L=0.04u
M4 G693 OR2_132/net7 VDD VDD pmos W=0.41u L=0.04u
M5 OR2_132/X_u7-net8 G699 VDD VDD pmos W=0.41u L=0.04u
M6 OR2_132/net7 G692 OR2_132/X_u7-net8 VDD pmos W=0.41u L=0.04u
M7 G687 OR2_129/net7 VSS VSS nmos W=0.31u L=0.04u
M8 OR2_129/net7 G686 VSS VSS nmos W=0.155u L=0.04u
M9 OR2_129/net7 G699 VSS VSS nmos W=0.155u L=0.04u
M10 G687 OR2_129/net7 VDD VDD pmos W=0.41u L=0.04u
M11 OR2_129/X_u7-net8 G699 VDD VDD pmos W=0.41u L=0.04u
M12 OR2_129/net7 G686 OR2_129/X_u7-net8 VDD pmos W=0.41u L=0.04u
M13 G682 OR2_127/net7 VSS VSS nmos W=0.31u L=0.04u
M14 OR2_127/net7 G681 VSS VSS nmos W=0.155u L=0.04u
M15 OR2_127/net7 G699 VSS VSS nmos W=0.155u L=0.04u
M16 G682 OR2_127/net7 VDD VDD pmos W=0.41u L=0.04u
M17 OR2_127/X_u7-net8 G699 VDD VDD pmos W=0.41u L=0.04u
M18 OR2_127/net7 G681 OR2_127/X_u7-net8 VDD pmos W=0.41u L=0.04u
M19 G713 AND2_193/net6 VSS VSS nmos W=0.31u L=0.04u
M20 AND2_193/X_u2-net6 G14 VSS VSS nmos W=0.31u L=0.04u
M21 AND2_193/net6 G599 AND2_193/X_u2-net6 VSS nmos W=0.31u L=0.04u
M22 G713 AND2_193/net6 VDD VDD pmos W=0.41u L=0.04u
M23 AND2_193/net6 G14 VDD VDD pmos W=0.41u L=0.04u
M24 AND2_193/net6 G599 VDD VDD pmos W=0.41u L=0.04u
M25 G707 AND2_191/net6 VSS VSS nmos W=0.31u L=0.04u
M26 AND2_191/X_u2-net6 G14 VSS VSS nmos W=0.31u L=0.04u
M27 AND2_191/net6 G708 AND2_191/X_u2-net6 VSS nmos W=0.31u L=0.04u
M28 G707 AND2_191/net6 VDD VDD pmos W=0.41u L=0.04u
M29 AND2_191/net6 G14 VDD VDD pmos W=0.41u L=0.04u
M30 AND2_191/net6 G708 VDD VDD pmos W=0.41u L=0.04u
M31 G705 AND2_190/net6 VSS VSS nmos W=0.31u L=0.04u
M32 AND2_190/X_u2-net6 G14 VSS VSS nmos W=0.31u L=0.04u
M33 AND2_190/net6 n223 AND2_190/X_u2-net6 VSS nmos W=0.31u L=0.04u
M34 G705 AND2_190/net6 VDD VDD pmos W=0.41u L=0.04u
M35 AND2_190/net6 G14 VDD VDD pmos W=0.41u L=0.04u
M36 AND2_190/net6 n223 VDD VDD pmos W=0.41u L=0.04u
M37 G675 AND2_184/net6 VSS VSS nmos W=0.31u L=0.04u
M38 AND2_184/X_u2-net6 G14 VSS VSS nmos W=0.31u L=0.04u
M39 AND2_184/net6 G676 AND2_184/X_u2-net6 VSS nmos W=0.31u L=0.04u
M40 G675 AND2_184/net6 VDD VDD pmos W=0.41u L=0.04u
M41 AND2_184/net6 G14 VDD VDD pmos W=0.41u L=0.04u
M42 AND2_184/net6 G676 VDD VDD pmos W=0.41u L=0.04u
M43 G669 AND2_182/net6 VSS VSS nmos W=0.31u L=0.04u
M44 AND2_182/X_u2-net6 G14 VSS VSS nmos W=0.31u L=0.04u
M45 AND2_182/net6 G670 AND2_182/X_u2-net6 VSS nmos W=0.31u L=0.04u
M46 G669 AND2_182/net6 VDD VDD pmos W=0.41u L=0.04u
M47 AND2_182/net6 G14 VDD VDD pmos W=0.41u L=0.04u
M48 AND2_182/net6 G670 VDD VDD pmos W=0.41u L=0.04u
M49 G663 AND2_180/net6 VSS VSS nmos W=0.31u L=0.04u
M50 AND2_180/X_u2-net6 G14 VSS VSS nmos W=0.31u L=0.04u
M51 AND2_180/net6 G664 AND2_180/X_u2-net6 VSS nmos W=0.31u L=0.04u
M52 G663 AND2_180/net6 VDD VDD pmos W=0.41u L=0.04u
M53 AND2_180/net6 G14 VDD VDD pmos W=0.41u L=0.04u
M54 AND2_180/net6 G664 VDD VDD pmos W=0.41u L=0.04u
M55 G657 AND2_179/net6 VSS VSS nmos W=0.31u L=0.04u
M56 AND2_179/X_u2-net6 G14 VSS VSS nmos W=0.31u L=0.04u
M57 AND2_179/net6 G13 AND2_179/X_u2-net6 VSS nmos W=0.31u L=0.04u
M58 G657 AND2_179/net6 VDD VDD pmos W=0.41u L=0.04u
M59 AND2_179/net6 G14 VDD VDD pmos W=0.41u L=0.04u
M60 AND2_179/net6 G13 VDD VDD pmos W=0.41u L=0.04u
M61 G613 AND2_170/net6 VSS VSS nmos W=0.31u L=0.04u
M62 AND2_170/X_u2-net6 G612 VSS VSS nmos W=0.31u L=0.04u
M63 AND2_170/net6 G611 AND2_170/X_u2-net6 VSS nmos W=0.31u L=0.04u
M64 G613 AND2_170/net6 VDD VDD pmos W=0.41u L=0.04u
M65 AND2_170/net6 G612 VDD VDD pmos W=0.41u L=0.04u
M66 AND2_170/net6 G611 VDD VDD pmos W=0.41u L=0.04u
M67 G608 AND2_169/net6 VSS VSS nmos W=0.31u L=0.04u
M68 AND2_169/X_u2-net6 G607 VSS VSS nmos W=0.31u L=0.04u
M69 AND2_169/net6 G606 AND2_169/X_u2-net6 VSS nmos W=0.31u L=0.04u
M70 G608 AND2_169/net6 VDD VDD pmos W=0.41u L=0.04u
M71 AND2_169/net6 G607 VDD VDD pmos W=0.41u L=0.04u
M72 AND2_169/net6 G606 VDD VDD pmos W=0.41u L=0.04u
M73 G590 AND2_165/net6 VSS VSS nmos W=0.31u L=0.04u
M74 AND2_165/X_u2-net6 n224 VSS VSS nmos W=0.31u L=0.04u
M75 AND2_165/net6 G591 AND2_165/X_u2-net6 VSS nmos W=0.31u L=0.04u
M76 G590 AND2_165/net6 VDD VDD pmos W=0.41u L=0.04u
M77 AND2_165/net6 n224 VDD VDD pmos W=0.41u L=0.04u
M78 AND2_165/net6 G591 VDD VDD pmos W=0.41u L=0.04u
M79 G577 AND2_163/net6 VSS VSS nmos W=0.31u L=0.04u
M80 AND2_163/X_u2-net6 G576 VSS VSS nmos W=0.31u L=0.04u
M81 AND2_163/net6 G575 AND2_163/X_u2-net6 VSS nmos W=0.31u L=0.04u
M82 G577 AND2_163/net6 VDD VDD pmos W=0.41u L=0.04u
M83 AND2_163/net6 G576 VDD VDD pmos W=0.41u L=0.04u
M84 AND2_163/net6 G575 VDD VDD pmos W=0.41u L=0.04u
M85 G573 AND2_162/net6 VSS VSS nmos W=0.31u L=0.04u
M86 AND2_162/X_u2-net6 G572 VSS VSS nmos W=0.31u L=0.04u
M87 AND2_162/net6 G571 AND2_162/X_u2-net6 VSS nmos W=0.31u L=0.04u
M88 G573 AND2_162/net6 VDD VDD pmos W=0.41u L=0.04u
M89 AND2_162/net6 G572 VDD VDD pmos W=0.41u L=0.04u
M90 AND2_162/net6 G571 VDD VDD pmos W=0.41u L=0.04u
M91 G569 AND2_161/net6 VSS VSS nmos W=0.31u L=0.04u
M92 AND2_161/X_u2-net6 G568 VSS VSS nmos W=0.31u L=0.04u
M93 AND2_161/net6 G567 AND2_161/X_u2-net6 VSS nmos W=0.31u L=0.04u
M94 G569 AND2_161/net6 VDD VDD pmos W=0.41u L=0.04u
M95 AND2_161/net6 G568 VDD VDD pmos W=0.41u L=0.04u
M96 AND2_161/net6 G567 VDD VDD pmos W=0.41u L=0.04u
M97 G565 AND2_160/net6 VSS VSS nmos W=0.31u L=0.04u
M98 AND2_160/X_u2-net6 G564 VSS VSS nmos W=0.31u L=0.04u
M99 AND2_160/net6 G563 AND2_160/X_u2-net6 VSS nmos W=0.31u L=0.04u
M100 G565 AND2_160/net6 VDD VDD pmos W=0.41u L=0.04u
M101 AND2_160/net6 G564 VDD VDD pmos W=0.41u L=0.04u
M102 AND2_160/net6 G563 VDD VDD pmos W=0.41u L=0.04u
M103 G548 AND2_154/net6 VSS VSS nmos W=0.31u L=0.04u
M104 AND2_154/X_u2-net6 n224 VSS VSS nmos W=0.31u L=0.04u
M105 AND2_154/net6 G545 AND2_154/X_u2-net6 VSS nmos W=0.31u L=0.04u
M106 G548 AND2_154/net6 VDD VDD pmos W=0.41u L=0.04u
M107 AND2_154/net6 n224 VDD VDD pmos W=0.41u L=0.04u
M108 AND2_154/net6 G545 VDD VDD pmos W=0.41u L=0.04u
M109 G541 AND2_152/net6 VSS VSS nmos W=0.31u L=0.04u
M110 AND2_152/X_u2-net6 n224 VSS VSS nmos W=0.31u L=0.04u
M111 AND2_152/net6 G542 AND2_152/X_u2-net6 VSS nmos W=0.31u L=0.04u
M112 G541 AND2_152/net6 VDD VDD pmos W=0.41u L=0.04u
M113 AND2_152/net6 n224 VDD VDD pmos W=0.41u L=0.04u
M114 AND2_152/net6 G542 VDD VDD pmos W=0.41u L=0.04u
M115 G536 AND2_150/net6 VSS VSS nmos W=0.31u L=0.04u
M116 AND2_150/X_u2-net6 n224 VSS VSS nmos W=0.31u L=0.04u
M117 AND2_150/net6 G537 AND2_150/X_u2-net6 VSS nmos W=0.31u L=0.04u
M118 G536 AND2_150/net6 VDD VDD pmos W=0.41u L=0.04u
M119 AND2_150/net6 n224 VDD VDD pmos W=0.41u L=0.04u
M120 AND2_150/net6 G537 VDD VDD pmos W=0.41u L=0.04u
M121 G531 AND2_148/net6 VSS VSS nmos W=0.31u L=0.04u
M122 AND2_148/X_u2-net6 n224 VSS VSS nmos W=0.31u L=0.04u
M123 AND2_148/net6 G532 AND2_148/X_u2-net6 VSS nmos W=0.31u L=0.04u
M124 G531 AND2_148/net6 VDD VDD pmos W=0.41u L=0.04u
M125 AND2_148/net6 n224 VDD VDD pmos W=0.41u L=0.04u
M126 AND2_148/net6 G532 VDD VDD pmos W=0.41u L=0.04u
M127 G526 AND2_146/net6 VSS VSS nmos W=0.31u L=0.04u
M128 AND2_146/X_u2-net6 n224 VSS VSS nmos W=0.31u L=0.04u
M129 AND2_146/net6 G527 AND2_146/X_u2-net6 VSS nmos W=0.31u L=0.04u
M130 G526 AND2_146/net6 VDD VDD pmos W=0.41u L=0.04u
M131 AND2_146/net6 n224 VDD VDD pmos W=0.41u L=0.04u
M132 AND2_146/net6 G527 VDD VDD pmos W=0.41u L=0.04u
M133 G503 AND2_145/net6 VSS VSS nmos W=0.31u L=0.04u
M134 AND2_145/X_u2-net6 G502 VSS VSS nmos W=0.31u L=0.04u
M135 AND2_145/net6 G501 AND2_145/X_u2-net6 VSS nmos W=0.31u L=0.04u
M136 G503 AND2_145/net6 VDD VDD pmos W=0.41u L=0.04u
M137 AND2_145/net6 G502 VDD VDD pmos W=0.41u L=0.04u
M138 AND2_145/net6 G501 VDD VDD pmos W=0.41u L=0.04u
M139 G498 AND2_144/net6 VSS VSS nmos W=0.31u L=0.04u
M140 AND2_144/X_u2-net6 G497 VSS VSS nmos W=0.31u L=0.04u
M141 AND2_144/net6 G496 AND2_144/X_u2-net6 VSS nmos W=0.31u L=0.04u
M142 G498 AND2_144/net6 VDD VDD pmos W=0.41u L=0.04u
M143 AND2_144/net6 G497 VDD VDD pmos W=0.41u L=0.04u
M144 AND2_144/net6 G496 VDD VDD pmos W=0.41u L=0.04u
M145 G494 AND2_143/net6 VSS VSS nmos W=0.31u L=0.04u
M146 AND2_143/X_u2-net6 G493 VSS VSS nmos W=0.31u L=0.04u
M147 AND2_143/net6 G492 AND2_143/X_u2-net6 VSS nmos W=0.31u L=0.04u
M148 G494 AND2_143/net6 VDD VDD pmos W=0.41u L=0.04u
M149 AND2_143/net6 G493 VDD VDD pmos W=0.41u L=0.04u
M150 AND2_143/net6 G492 VDD VDD pmos W=0.41u L=0.04u
M151 G477 AND2_135/net6 VSS VSS nmos W=0.31u L=0.04u
M152 AND2_135/X_u2-net6 n53 VSS VSS nmos W=0.31u L=0.04u
M153 AND2_135/net6 G473 AND2_135/X_u2-net6 VSS nmos W=0.31u L=0.04u
M154 G477 AND2_135/net6 VDD VDD pmos W=0.41u L=0.04u
M155 AND2_135/net6 n53 VDD VDD pmos W=0.41u L=0.04u
M156 AND2_135/net6 G473 VDD VDD pmos W=0.41u L=0.04u
M157 G469 AND2_133/net6 VSS VSS nmos W=0.31u L=0.04u
M158 AND2_133/X_u2-net6 n53 VSS VSS nmos W=0.31u L=0.04u
M159 AND2_133/net6 G470 AND2_133/X_u2-net6 VSS nmos W=0.31u L=0.04u
M160 G469 AND2_133/net6 VDD VDD pmos W=0.41u L=0.04u
M161 AND2_133/net6 n53 VDD VDD pmos W=0.41u L=0.04u
M162 AND2_133/net6 G470 VDD VDD pmos W=0.41u L=0.04u
M163 G464 AND2_131/net6 VSS VSS nmos W=0.31u L=0.04u
M164 AND2_131/X_u2-net6 n53 VSS VSS nmos W=0.31u L=0.04u
M165 AND2_131/net6 G465 AND2_131/X_u2-net6 VSS nmos W=0.31u L=0.04u
M166 G464 AND2_131/net6 VDD VDD pmos W=0.41u L=0.04u
M167 AND2_131/net6 n53 VDD VDD pmos W=0.41u L=0.04u
M168 AND2_131/net6 G465 VDD VDD pmos W=0.41u L=0.04u
M169 G459 AND2_129/net6 VSS VSS nmos W=0.31u L=0.04u
M170 AND2_129/X_u2-net6 n53 VSS VSS nmos W=0.31u L=0.04u
M171 AND2_129/net6 G460 AND2_129/X_u2-net6 VSS nmos W=0.31u L=0.04u
M172 G459 AND2_129/net6 VDD VDD pmos W=0.41u L=0.04u
M173 AND2_129/net6 n53 VDD VDD pmos W=0.41u L=0.04u
M174 AND2_129/net6 G460 VDD VDD pmos W=0.41u L=0.04u
M175 G451 AND2_127/net6 VSS VSS nmos W=0.31u L=0.04u
M176 AND2_127/X_u2-net6 G14 VSS VSS nmos W=0.31u L=0.04u
M177 AND2_127/net6 G452 AND2_127/X_u2-net6 VSS nmos W=0.31u L=0.04u
M178 G451 AND2_127/net6 VDD VDD pmos W=0.41u L=0.04u
M179 AND2_127/net6 G14 VDD VDD pmos W=0.41u L=0.04u
M180 AND2_127/net6 G452 VDD VDD pmos W=0.41u L=0.04u
M181 G447 AND2_126/net6 VSS VSS nmos W=0.31u L=0.04u
M182 AND2_126/X_u2-net6 G14 VSS VSS nmos W=0.31u L=0.04u
M183 AND2_126/net6 G448 AND2_126/X_u2-net6 VSS nmos W=0.31u L=0.04u
M184 G447 AND2_126/net6 VDD VDD pmos W=0.41u L=0.04u
M185 AND2_126/net6 G14 VDD VDD pmos W=0.41u L=0.04u
M186 AND2_126/net6 G448 VDD VDD pmos W=0.41u L=0.04u
M187 G441 AND2_124/net6 VSS VSS nmos W=0.31u L=0.04u
M188 AND2_124/X_u2-net6 G14 VSS VSS nmos W=0.31u L=0.04u
M189 AND2_124/net6 G442 AND2_124/X_u2-net6 VSS nmos W=0.31u L=0.04u
M190 G441 AND2_124/net6 VDD VDD pmos W=0.41u L=0.04u
M191 AND2_124/net6 G14 VDD VDD pmos W=0.41u L=0.04u
M192 AND2_124/net6 G442 VDD VDD pmos W=0.41u L=0.04u
M193 G438 AND2_123/net6 VSS VSS nmos W=0.31u L=0.04u
M194 AND2_123/X_u2-net6 G14 VSS VSS nmos W=0.31u L=0.04u
M195 AND2_123/net6 G439 AND2_123/X_u2-net6 VSS nmos W=0.31u L=0.04u
M196 G438 AND2_123/net6 VDD VDD pmos W=0.41u L=0.04u
M197 AND2_123/net6 G14 VDD VDD pmos W=0.41u L=0.04u
M198 AND2_123/net6 G439 VDD VDD pmos W=0.41u L=0.04u
M199 G427 AND2_116/net6 VSS VSS nmos W=0.31u L=0.04u
M200 AND2_116/X_u2-net6 G14 VSS VSS nmos W=0.31u L=0.04u
M201 AND2_116/net6 G428 AND2_116/X_u2-net6 VSS nmos W=0.31u L=0.04u
M202 G427 AND2_116/net6 VDD VDD pmos W=0.41u L=0.04u
M203 AND2_116/net6 G14 VDD VDD pmos W=0.41u L=0.04u
M204 AND2_116/net6 G428 VDD VDD pmos W=0.41u L=0.04u
M205 G424 AND2_114/net6 VSS VSS nmos W=0.31u L=0.04u
M206 AND2_114/X_u2-net6 n219 VSS VSS nmos W=0.31u L=0.04u
M207 AND2_114/net6 G420 AND2_114/X_u2-net6 VSS nmos W=0.31u L=0.04u
M208 G424 AND2_114/net6 VDD VDD pmos W=0.41u L=0.04u
M209 AND2_114/net6 n219 VDD VDD pmos W=0.41u L=0.04u
M210 AND2_114/net6 G420 VDD VDD pmos W=0.41u L=0.04u
M211 G416 AND2_112/net6 VSS VSS nmos W=0.31u L=0.04u
M212 AND2_112/X_u2-net6 n219 VSS VSS nmos W=0.31u L=0.04u
M213 AND2_112/net6 G417 AND2_112/X_u2-net6 VSS nmos W=0.31u L=0.04u
M214 G416 AND2_112/net6 VDD VDD pmos W=0.41u L=0.04u
M215 AND2_112/net6 n219 VDD VDD pmos W=0.41u L=0.04u
M216 AND2_112/net6 G417 VDD VDD pmos W=0.41u L=0.04u
M217 G408 AND2_107/net6 VSS VSS nmos W=0.31u L=0.04u
M218 AND2_107/X_u2-net6 G14 VSS VSS nmos W=0.31u L=0.04u
M219 AND2_107/net6 G409 AND2_107/X_u2-net6 VSS nmos W=0.31u L=0.04u
M220 G408 AND2_107/net6 VDD VDD pmos W=0.41u L=0.04u
M221 AND2_107/net6 G14 VDD VDD pmos W=0.41u L=0.04u
M222 AND2_107/net6 G409 VDD VDD pmos W=0.41u L=0.04u
M223 G405 AND2_105/net6 VSS VSS nmos W=0.31u L=0.04u
M224 AND2_105/X_u2-net6 n217 VSS VSS nmos W=0.31u L=0.04u
M225 AND2_105/net6 G401 AND2_105/X_u2-net6 VSS nmos W=0.31u L=0.04u
M226 G405 AND2_105/net6 VDD VDD pmos W=0.41u L=0.04u
M227 AND2_105/net6 n217 VDD VDD pmos W=0.41u L=0.04u
M228 AND2_105/net6 G401 VDD VDD pmos W=0.41u L=0.04u
M229 G397 AND2_103/net6 VSS VSS nmos W=0.31u L=0.04u
M230 AND2_103/X_u2-net6 n217 VSS VSS nmos W=0.31u L=0.04u
M231 AND2_103/net6 G398 AND2_103/X_u2-net6 VSS nmos W=0.31u L=0.04u
M232 G397 AND2_103/net6 VDD VDD pmos W=0.41u L=0.04u
M233 AND2_103/net6 n217 VDD VDD pmos W=0.41u L=0.04u
M234 AND2_103/net6 G398 VDD VDD pmos W=0.41u L=0.04u
M235 G392 AND2_99/net6 VSS VSS nmos W=0.31u L=0.04u
M236 AND2_99/X_u2-net6 n220 VSS VSS nmos W=0.31u L=0.04u
M237 AND2_99/net6 G388 AND2_99/X_u2-net6 VSS nmos W=0.31u L=0.04u
M238 G392 AND2_99/net6 VDD VDD pmos W=0.41u L=0.04u
M239 AND2_99/net6 n220 VDD VDD pmos W=0.41u L=0.04u
M240 AND2_99/net6 G388 VDD VDD pmos W=0.41u L=0.04u
M241 G384 AND2_97/net6 VSS VSS nmos W=0.31u L=0.04u
M242 AND2_97/X_u2-net6 n220 VSS VSS nmos W=0.31u L=0.04u
M243 AND2_97/net6 G385 AND2_97/X_u2-net6 VSS nmos W=0.31u L=0.04u
M244 G384 AND2_97/net6 VDD VDD pmos W=0.41u L=0.04u
M245 AND2_97/net6 n220 VDD VDD pmos W=0.41u L=0.04u
M246 AND2_97/net6 G385 VDD VDD pmos W=0.41u L=0.04u
M247 G379 AND2_95/net6 VSS VSS nmos W=0.31u L=0.04u
M248 AND2_95/X_u2-net6 n220 VSS VSS nmos W=0.31u L=0.04u
M249 AND2_95/net6 G380 AND2_95/X_u2-net6 VSS nmos W=0.31u L=0.04u
M250 G379 AND2_95/net6 VDD VDD pmos W=0.41u L=0.04u
M251 AND2_95/net6 n220 VDD VDD pmos W=0.41u L=0.04u
M252 AND2_95/net6 G380 VDD VDD pmos W=0.41u L=0.04u
M253 G373 AND2_91/net6 VSS VSS nmos W=0.31u L=0.04u
M254 AND2_91/X_u2-net6 n218 VSS VSS nmos W=0.31u L=0.04u
M255 AND2_91/net6 G369 AND2_91/X_u2-net6 VSS nmos W=0.31u L=0.04u
M256 G373 AND2_91/net6 VDD VDD pmos W=0.41u L=0.04u
M257 AND2_91/net6 n218 VDD VDD pmos W=0.41u L=0.04u
M258 AND2_91/net6 G369 VDD VDD pmos W=0.41u L=0.04u
M259 G365 AND2_89/net6 VSS VSS nmos W=0.31u L=0.04u
M260 AND2_89/X_u2-net6 n218 VSS VSS nmos W=0.31u L=0.04u
M261 AND2_89/net6 G366 AND2_89/X_u2-net6 VSS nmos W=0.31u L=0.04u
M262 G365 AND2_89/net6 VDD VDD pmos W=0.41u L=0.04u
M263 AND2_89/net6 n218 VDD VDD pmos W=0.41u L=0.04u
M264 AND2_89/net6 G366 VDD VDD pmos W=0.41u L=0.04u
M265 G360 AND2_87/net6 VSS VSS nmos W=0.31u L=0.04u
M266 AND2_87/X_u2-net6 n218 VSS VSS nmos W=0.31u L=0.04u
M267 AND2_87/net6 G361 AND2_87/X_u2-net6 VSS nmos W=0.31u L=0.04u
M268 G360 AND2_87/net6 VDD VDD pmos W=0.41u L=0.04u
M269 AND2_87/net6 n218 VDD VDD pmos W=0.41u L=0.04u
M270 AND2_87/net6 G361 VDD VDD pmos W=0.41u L=0.04u
M271 G321 AND2_79/net6 VSS VSS nmos W=0.31u L=0.04u
M272 AND2_79/X_u2-net6 G14 VSS VSS nmos W=0.31u L=0.04u
M273 AND2_79/net6 G322 AND2_79/X_u2-net6 VSS nmos W=0.31u L=0.04u
M274 G321 AND2_79/net6 VDD VDD pmos W=0.41u L=0.04u
M275 AND2_79/net6 G14 VDD VDD pmos W=0.41u L=0.04u
M276 AND2_79/net6 G322 VDD VDD pmos W=0.41u L=0.04u
M277 G315 AND2_77/net6 VSS VSS nmos W=0.31u L=0.04u
M278 AND2_77/X_u2-net6 G14 VSS VSS nmos W=0.31u L=0.04u
M279 AND2_77/net6 G316 AND2_77/X_u2-net6 VSS nmos W=0.31u L=0.04u
M280 G315 AND2_77/net6 VDD VDD pmos W=0.41u L=0.04u
M281 AND2_77/net6 G14 VDD VDD pmos W=0.41u L=0.04u
M282 AND2_77/net6 G316 VDD VDD pmos W=0.41u L=0.04u
M283 G309 AND2_75/net6 VSS VSS nmos W=0.31u L=0.04u
M284 AND2_75/X_u2-net6 G14 VSS VSS nmos W=0.31u L=0.04u
M285 AND2_75/net6 G310 AND2_75/X_u2-net6 VSS nmos W=0.31u L=0.04u
M286 G309 AND2_75/net6 VDD VDD pmos W=0.41u L=0.04u
M287 AND2_75/net6 G14 VDD VDD pmos W=0.41u L=0.04u
M288 AND2_75/net6 G310 VDD VDD pmos W=0.41u L=0.04u
M289 G303 AND2_73/net6 VSS VSS nmos W=0.31u L=0.04u
M290 AND2_73/X_u2-net6 G14 VSS VSS nmos W=0.31u L=0.04u
M291 AND2_73/net6 G304 AND2_73/X_u2-net6 VSS nmos W=0.31u L=0.04u
M292 G303 AND2_73/net6 VDD VDD pmos W=0.41u L=0.04u
M293 AND2_73/net6 G14 VDD VDD pmos W=0.41u L=0.04u
M294 AND2_73/net6 G304 VDD VDD pmos W=0.41u L=0.04u
M295 G260 AND2_63/net6 VSS VSS nmos W=0.31u L=0.04u
M296 AND2_63/X_u2-net6 n225 VSS VSS nmos W=0.31u L=0.04u
M297 AND2_63/net6 G256 AND2_63/X_u2-net6 VSS nmos W=0.31u L=0.04u
M298 G260 AND2_63/net6 VDD VDD pmos W=0.41u L=0.04u
M299 AND2_63/net6 n225 VDD VDD pmos W=0.41u L=0.04u
M300 AND2_63/net6 G256 VDD VDD pmos W=0.41u L=0.04u
M301 G252 AND2_60/net6 VSS VSS nmos W=0.31u L=0.04u
M302 AND2_60/X_u2-net6 n225 VSS VSS nmos W=0.31u L=0.04u
M303 AND2_60/net6 G253 AND2_60/X_u2-net6 VSS nmos W=0.31u L=0.04u
M304 G252 AND2_60/net6 VDD VDD pmos W=0.41u L=0.04u
M305 AND2_60/net6 n225 VDD VDD pmos W=0.41u L=0.04u
M306 AND2_60/net6 G253 VDD VDD pmos W=0.41u L=0.04u
M307 G247 AND2_58/net6 VSS VSS nmos W=0.31u L=0.04u
M308 AND2_58/X_u2-net6 n225 VSS VSS nmos W=0.31u L=0.04u
M309 AND2_58/net6 G248 AND2_58/X_u2-net6 VSS nmos W=0.31u L=0.04u
M310 G247 AND2_58/net6 VDD VDD pmos W=0.41u L=0.04u
M311 AND2_58/net6 n225 VDD VDD pmos W=0.41u L=0.04u
M312 AND2_58/net6 G248 VDD VDD pmos W=0.41u L=0.04u
M313 G242 AND2_56/net6 VSS VSS nmos W=0.31u L=0.04u
M314 AND2_56/X_u2-net6 n225 VSS VSS nmos W=0.31u L=0.04u
M315 AND2_56/net6 G243 AND2_56/X_u2-net6 VSS nmos W=0.31u L=0.04u
M316 G242 AND2_56/net6 VDD VDD pmos W=0.41u L=0.04u
M317 AND2_56/net6 n225 VDD VDD pmos W=0.41u L=0.04u
M318 AND2_56/net6 G243 VDD VDD pmos W=0.41u L=0.04u
M319 G237 AND2_54/net6 VSS VSS nmos W=0.31u L=0.04u
M320 AND2_54/X_u2-net6 n225 VSS VSS nmos W=0.31u L=0.04u
M321 AND2_54/net6 G238 AND2_54/X_u2-net6 VSS nmos W=0.31u L=0.04u
M322 G237 AND2_54/net6 VDD VDD pmos W=0.41u L=0.04u
M323 AND2_54/net6 n225 VDD VDD pmos W=0.41u L=0.04u
M324 AND2_54/net6 G238 VDD VDD pmos W=0.41u L=0.04u
M325 G218 AND2_44/net6 VSS VSS nmos W=0.31u L=0.04u
M326 AND2_44/X_u2-net6 G14 VSS VSS nmos W=0.31u L=0.04u
M327 AND2_44/net6 G219 AND2_44/X_u2-net6 VSS nmos W=0.31u L=0.04u
M328 G218 AND2_44/net6 VDD VDD pmos W=0.41u L=0.04u
M329 AND2_44/net6 G14 VDD VDD pmos W=0.41u L=0.04u
M330 AND2_44/net6 G219 VDD VDD pmos W=0.41u L=0.04u
M331 G214 AND2_43/net6 VSS VSS nmos W=0.31u L=0.04u
M332 AND2_43/X_u2-net6 G14 VSS VSS nmos W=0.31u L=0.04u
M333 AND2_43/net6 n221 AND2_43/X_u2-net6 VSS nmos W=0.31u L=0.04u
M334 G214 AND2_43/net6 VDD VDD pmos W=0.41u L=0.04u
M335 AND2_43/net6 G14 VDD VDD pmos W=0.41u L=0.04u
M336 AND2_43/net6 n221 VDD VDD pmos W=0.41u L=0.04u
M337 G208 AND2_42/net6 VSS VSS nmos W=0.31u L=0.04u
M338 AND2_42/X_u2-net6 G14 VSS VSS nmos W=0.31u L=0.04u
M339 AND2_42/net6 n216 AND2_42/X_u2-net6 VSS nmos W=0.31u L=0.04u
M340 G208 AND2_42/net6 VDD VDD pmos W=0.41u L=0.04u
M341 AND2_42/net6 G14 VDD VDD pmos W=0.41u L=0.04u
M342 AND2_42/net6 n216 VDD VDD pmos W=0.41u L=0.04u
M343 G198 AND2_38/net6 VSS VSS nmos W=0.31u L=0.04u
M344 AND2_38/X_u2-net6 G14 VSS VSS nmos W=0.31u L=0.04u
M345 AND2_38/net6 G199 AND2_38/X_u2-net6 VSS nmos W=0.31u L=0.04u
M346 G198 AND2_38/net6 VDD VDD pmos W=0.41u L=0.04u
M347 AND2_38/net6 G14 VDD VDD pmos W=0.41u L=0.04u
M348 AND2_38/net6 G199 VDD VDD pmos W=0.41u L=0.04u
M349 G193 AND2_36/net6 VSS VSS nmos W=0.31u L=0.04u
M350 AND2_36/X_u2-net6 G14 VSS VSS nmos W=0.31u L=0.04u
M351 AND2_36/net6 G194 AND2_36/X_u2-net6 VSS nmos W=0.31u L=0.04u
M352 G193 AND2_36/net6 VDD VDD pmos W=0.41u L=0.04u
M353 AND2_36/net6 G14 VDD VDD pmos W=0.41u L=0.04u
M354 AND2_36/net6 G194 VDD VDD pmos W=0.41u L=0.04u
M355 G189 AND2_35/net6 VSS VSS nmos W=0.31u L=0.04u
M356 AND2_35/X_u2-net6 G14 VSS VSS nmos W=0.31u L=0.04u
M357 AND2_35/net6 n222 AND2_35/X_u2-net6 VSS nmos W=0.31u L=0.04u
M358 G189 AND2_35/net6 VDD VDD pmos W=0.41u L=0.04u
M359 AND2_35/net6 G14 VDD VDD pmos W=0.41u L=0.04u
M360 AND2_35/net6 n222 VDD VDD pmos W=0.41u L=0.04u
M361 G175 AND2_33/net6 VSS VSS nmos W=0.31u L=0.04u
M362 AND2_33/X_u2-net6 G14 VSS VSS nmos W=0.31u L=0.04u
M363 AND2_33/net6 G176 AND2_33/X_u2-net6 VSS nmos W=0.31u L=0.04u
M364 G175 AND2_33/net6 VDD VDD pmos W=0.41u L=0.04u
M365 AND2_33/net6 G14 VDD VDD pmos W=0.41u L=0.04u
M366 AND2_33/net6 G176 VDD VDD pmos W=0.41u L=0.04u
M367 G166 AND2_26/net6 VSS VSS nmos W=0.31u L=0.04u
M368 AND2_26/X_u2-net6 G14 VSS VSS nmos W=0.31u L=0.04u
M369 AND2_26/net6 n215 AND2_26/X_u2-net6 VSS nmos W=0.31u L=0.04u
M370 G166 AND2_26/net6 VDD VDD pmos W=0.41u L=0.04u
M371 AND2_26/net6 G14 VDD VDD pmos W=0.41u L=0.04u
M372 AND2_26/net6 n215 VDD VDD pmos W=0.41u L=0.04u
M373 G159 AND2_24/net6 VSS VSS nmos W=0.31u L=0.04u
M374 AND2_24/X_u2-net6 G14 VSS VSS nmos W=0.31u L=0.04u
M375 AND2_24/net6 G160 AND2_24/X_u2-net6 VSS nmos W=0.31u L=0.04u
M376 G159 AND2_24/net6 VDD VDD pmos W=0.41u L=0.04u
M377 AND2_24/net6 G14 VDD VDD pmos W=0.41u L=0.04u
M378 AND2_24/net6 G160 VDD VDD pmos W=0.41u L=0.04u
M379 G154 AND2_22/net6 VSS VSS nmos W=0.31u L=0.04u
M380 AND2_22/X_u2-net6 G14 VSS VSS nmos W=0.31u L=0.04u
M381 AND2_22/net6 G155 AND2_22/X_u2-net6 VSS nmos W=0.31u L=0.04u
M382 G154 AND2_22/net6 VDD VDD pmos W=0.41u L=0.04u
M383 AND2_22/net6 G14 VDD VDD pmos W=0.41u L=0.04u
M384 AND2_22/net6 G155 VDD VDD pmos W=0.41u L=0.04u
M385 G149 AND2_20/net6 VSS VSS nmos W=0.31u L=0.04u
M386 AND2_20/X_u2-net6 G14 VSS VSS nmos W=0.31u L=0.04u
M387 AND2_20/net6 G150 AND2_20/X_u2-net6 VSS nmos W=0.31u L=0.04u
M388 G149 AND2_20/net6 VDD VDD pmos W=0.41u L=0.04u
M389 AND2_20/net6 G14 VDD VDD pmos W=0.41u L=0.04u
M390 AND2_20/net6 G150 VDD VDD pmos W=0.41u L=0.04u
M391 G144 AND2_18/net6 VSS VSS nmos W=0.31u L=0.04u
M392 AND2_18/X_u2-net6 G14 VSS VSS nmos W=0.31u L=0.04u
M393 AND2_18/net6 G145 AND2_18/X_u2-net6 VSS nmos W=0.31u L=0.04u
M394 G144 AND2_18/net6 VDD VDD pmos W=0.41u L=0.04u
M395 AND2_18/net6 G14 VDD VDD pmos W=0.41u L=0.04u
M396 AND2_18/net6 G145 VDD VDD pmos W=0.41u L=0.04u
M397 G140 AND2_17/net6 VSS VSS nmos W=0.31u L=0.04u
M398 AND2_17/X_u2-net6 G14 VSS VSS nmos W=0.31u L=0.04u
M399 AND2_17/net6 n214 AND2_17/X_u2-net6 VSS nmos W=0.31u L=0.04u
M400 G140 AND2_17/net6 VDD VDD pmos W=0.41u L=0.04u
M401 AND2_17/net6 G14 VDD VDD pmos W=0.41u L=0.04u
M402 AND2_17/net6 n214 VDD VDD pmos W=0.41u L=0.04u
M403 G129 AND2_11/net6 VSS VSS nmos W=0.31u L=0.04u
M404 AND2_11/X_u2-net6 G14 VSS VSS nmos W=0.31u L=0.04u
M405 AND2_11/net6 G130 AND2_11/X_u2-net6 VSS nmos W=0.31u L=0.04u
M406 G129 AND2_11/net6 VDD VDD pmos W=0.41u L=0.04u
M407 AND2_11/net6 G14 VDD VDD pmos W=0.41u L=0.04u
M408 AND2_11/net6 G130 VDD VDD pmos W=0.41u L=0.04u
M409 G125 AND2_10/net6 VSS VSS nmos W=0.31u L=0.04u
M410 AND2_10/X_u2-net6 G14 VSS VSS nmos W=0.31u L=0.04u
M411 AND2_10/net6 n213 AND2_10/X_u2-net6 VSS nmos W=0.31u L=0.04u
M412 G125 AND2_10/net6 VDD VDD pmos W=0.41u L=0.04u
M413 AND2_10/net6 G14 VDD VDD pmos W=0.41u L=0.04u
M414 AND2_10/net6 n213 VDD VDD pmos W=0.41u L=0.04u
M415 G118 AND2_8/net6 VSS VSS nmos W=0.31u L=0.04u
M416 AND2_8/X_u2-net6 G14 VSS VSS nmos W=0.31u L=0.04u
M417 AND2_8/net6 G119 AND2_8/X_u2-net6 VSS nmos W=0.31u L=0.04u
M418 G118 AND2_8/net6 VDD VDD pmos W=0.41u L=0.04u
M419 AND2_8/net6 G14 VDD VDD pmos W=0.41u L=0.04u
M420 AND2_8/net6 G119 VDD VDD pmos W=0.41u L=0.04u
M421 G113 AND2_6/net6 VSS VSS nmos W=0.31u L=0.04u
M422 AND2_6/X_u2-net6 G14 VSS VSS nmos W=0.31u L=0.04u
M423 AND2_6/net6 G114 AND2_6/X_u2-net6 VSS nmos W=0.31u L=0.04u
M424 G113 AND2_6/net6 VDD VDD pmos W=0.41u L=0.04u
M425 AND2_6/net6 G14 VDD VDD pmos W=0.41u L=0.04u
M426 AND2_6/net6 G114 VDD VDD pmos W=0.41u L=0.04u
M427 G109 AND2_5/net6 VSS VSS nmos W=0.31u L=0.04u
M428 AND2_5/X_u2-net6 G14 VSS VSS nmos W=0.31u L=0.04u
M429 AND2_5/net6 n212 AND2_5/X_u2-net6 VSS nmos W=0.31u L=0.04u
M430 G109 AND2_5/net6 VDD VDD pmos W=0.41u L=0.04u
M431 AND2_5/net6 G14 VDD VDD pmos W=0.41u L=0.04u
M432 AND2_5/net6 n212 VDD VDD pmos W=0.41u L=0.04u
M433 G328BF n211 VSS VSS nmos W=0.31u L=0.04u
M434 G328BF n211 VDD VDD pmos W=0.41u L=0.04u
M435 G332BF N38 VSS VSS nmos W=0.31u L=0.04u
M436 G332BF N38 VDD VDD pmos W=0.41u L=0.04u
M437 U262/net19 G90 VSS VSS nmos W=0.155u L=0.04u
M438 n225 G90 U262/net40 VSS nmos W=0.155u L=0.04u
M439 n225 U262/net19 U262/net36 VSS nmos W=0.155u L=0.04u
M440 U262/net40 n226 VSS VSS nmos W=0.31u L=0.04u
M441 U262/net36 G7 VSS VSS nmos W=0.155u L=0.04u
M442 U262/net19 G90 VDD VDD pmos W=0.205u L=0.04u
M443 n225 U262/net19 U262/net26 VDD pmos W=0.325u L=0.04u
M444 U262/net26 n226 VDD VDD pmos W=0.41u L=0.04u
M445 n225 G90 U262/net30 VDD pmos W=0.325u L=0.04u
M446 U262/net30 G7 VDD VDD pmos W=0.205u L=0.04u
M447 U263/net19 G90 VSS VSS nmos W=0.155u L=0.04u
M448 n224 G90 U263/net40 VSS nmos W=0.155u L=0.04u
M449 n224 U263/net19 U263/net36 VSS nmos W=0.155u L=0.04u
M450 U263/net40 n226 VSS VSS nmos W=0.31u L=0.04u
M451 U263/net36 G9 VSS VSS nmos W=0.155u L=0.04u
M452 U263/net19 G90 VDD VDD pmos W=0.205u L=0.04u
M453 n224 U263/net19 U263/net26 VDD pmos W=0.325u L=0.04u
M454 U263/net26 n226 VDD VDD pmos W=0.41u L=0.04u
M455 n224 G90 U263/net30 VDD pmos W=0.325u L=0.04u
M456 U263/net30 G9 VDD VDD pmos W=0.205u L=0.04u
M457 U264/net15 n231 VSS VSS nmos W=0.155u L=0.04u
M458 U264/net15 n230 VSS VSS nmos W=0.155u L=0.04u
M459 n223 n229 U264/net15 VSS nmos W=0.155u L=0.04u
M460 n223 n228 U264/net15 VSS nmos W=0.155u L=0.04u
M461 U264/net15 n232 VSS VSS nmos W=0.155u L=0.04u
M462 n223 n227 U264/net15 VSS nmos W=0.155u L=0.04u
M463 n223 n232 U264/XI1-net11 VDD pmos W=0.205u L=0.04u
M464 U264/XI1-net11 n231 U264/XI1-net18 VDD pmos W=0.205u L=0.04u
M465 U264/XI1-net18 n230 VDD VDD pmos W=0.205u L=0.04u
M466 n223 n229 U264/XI7-net11 VDD pmos W=0.205u L=0.04u
M467 U264/XI7-net11 n228 U264/XI7-net18 VDD pmos W=0.205u L=0.04u
M468 U264/XI7-net18 n227 VDD VDD pmos W=0.205u L=0.04u
M469 U265/net19 G90 VSS VSS nmos W=0.155u L=0.04u
M470 n230 G90 U265/net40 VSS nmos W=0.155u L=0.04u
M471 n230 U265/net19 U265/net36 VSS nmos W=0.155u L=0.04u
M472 U265/net40 n233 VSS VSS nmos W=0.31u L=0.04u
M473 U265/net36 G35 VSS VSS nmos W=0.155u L=0.04u
M474 U265/net19 G90 VDD VDD pmos W=0.205u L=0.04u
M475 n230 U265/net19 U265/net26 VDD pmos W=0.325u L=0.04u
M476 U265/net26 n233 VDD VDD pmos W=0.41u L=0.04u
M477 n230 G90 U265/net30 VDD pmos W=0.325u L=0.04u
M478 U265/net30 G35 VDD VDD pmos W=0.205u L=0.04u
M479 n233 U266/net28 VSS VSS nmos W=0.155u L=0.04u
M480 U266/net47 G62 VSS VSS nmos W=0.155u L=0.04u
M481 U266/net28 U266/net6 U266/net47 VSS nmos W=0.155u L=0.04u
M482 U266/net44 G59 VSS VSS nmos W=0.155u L=0.04u
M483 U266/net28 n234 U266/net44 VSS nmos W=0.155u L=0.04u
M484 U266/net6 n234 VSS VSS nmos W=0.155u L=0.04u
M485 n233 U266/net28 VDD VDD pmos W=0.205u L=0.04u
M486 VDD G62 U266/net47 VDD pmos W=0.205u L=0.04u
M487 U266/net47 n234 U266/net28 VDD pmos W=0.205u L=0.04u
M488 U266/net44 U266/net6 U266/net28 VDD pmos W=0.205u L=0.04u
M489 VDD G59 U266/net44 VDD pmos W=0.205u L=0.04u
M490 VDD n234 U266/net6 VDD pmos W=0.205u L=0.04u
M491 n229 n235 U267/net27 VSS nmos W=0.155u L=0.04u
M492 U267/net27 n236 VSS VSS nmos W=0.155u L=0.04u
M493 n229 n237 VSS VSS nmos W=0.155u L=0.04u
M494 n229 n236 U267/net13 VDD pmos W=0.205u L=0.04u
M495 U267/net13 n237 VDD VDD pmos W=0.205u L=0.04u
M496 n229 n235 U267/net13 VDD pmos W=0.205u L=0.04u
M497 U268/net36 n239 U268/net24 VSS nmos W=0.155u L=0.04u
M498 U268/net24 n240 VSS VSS nmos W=0.155u L=0.04u
M499 n236 G42 U268/net36 VSS nmos W=0.155u L=0.04u
M500 n236 n238 U268/net36 VSS nmos W=0.155u L=0.04u
M501 n236 n238 U268/net35 VDD pmos W=0.205u L=0.04u
M502 U268/net35 G42 VDD VDD pmos W=0.205u L=0.04u
M503 n236 n240 VDD VDD pmos W=0.205u L=0.04u
M504 n236 n239 VDD VDD pmos W=0.205u L=0.04u
M505 U269/net7 n241 U269/X_u4-net10 VSS nmos W=0.155u L=0.04u
M506 U269/X_u4-net10 n242 U269/X_u4-net13 VSS nmos W=0.155u L=0.04u
M507 U269/X_u4-net13 n243 VSS VSS nmos W=0.155u L=0.04u
M508 n240 U269/net7 VSS VSS nmos W=0.155u L=0.04u
M509 U269/net7 n243 VDD VDD pmos W=0.205u L=0.04u
M510 U269/net7 n241 VDD VDD pmos W=0.205u L=0.04u
M511 U269/net7 n242 VDD VDD pmos W=0.205u L=0.04u
M512 n240 U269/net7 VDD VDD pmos W=0.205u L=0.04u
M513 n241 n244 VSS VSS nmos W=0.135u L=0.04u
M514 n241 n244 VDD VDD pmos W=0.205u L=0.04u
M515 U271/net19 G90 VSS VSS nmos W=0.155u L=0.04u
M516 n235 G90 U271/net40 VSS nmos W=0.155u L=0.04u
M517 n235 U271/net19 U271/net36 VSS nmos W=0.155u L=0.04u
M518 U271/net40 n245 VSS VSS nmos W=0.31u L=0.04u
M519 U271/net36 G5 VSS VSS nmos W=0.155u L=0.04u
M520 U271/net19 G90 VDD VDD pmos W=0.205u L=0.04u
M521 n235 U271/net19 U271/net26 VDD pmos W=0.325u L=0.04u
M522 U271/net26 n245 VDD VDD pmos W=0.41u L=0.04u
M523 n235 G90 U271/net30 VDD pmos W=0.325u L=0.04u
M524 U271/net30 G5 VDD VDD pmos W=0.205u L=0.04u
M525 n245 n246 VSS VSS nmos W=0.135u L=0.04u
M526 n245 n246 VDD VDD pmos W=0.205u L=0.04u
M527 n227 n231 VSS VSS nmos W=0.155u L=0.04u
M528 n227 n232 VSS VSS nmos W=0.155u L=0.04u
M529 U273/XI1-net8 n232 VDD VDD pmos W=0.205u L=0.04u
M530 n227 n231 U273/XI1-net8 VDD pmos W=0.205u L=0.04u
M531 n231 G6 VSS VSS nmos W=0.155u L=0.04u
M532 n231 G90 VSS VSS nmos W=0.155u L=0.04u
M533 U274/XI1-net8 G90 VDD VDD pmos W=0.205u L=0.04u
M534 n231 G6 U274/XI1-net8 VDD pmos W=0.205u L=0.04u
M535 n222 U275/net26 VDD VDD pmos W=0.205u L=0.04u
M536 U275/net26 G36 U275/net19 VDD pmos W=0.205u L=0.04u
M537 U275/net26 n247 U275/net19 VDD pmos W=0.205u L=0.04u
M538 U275/net26 G91 U275/net19 VDD pmos W=0.205u L=0.04u
M539 U275/net19 n248 VDD VDD pmos W=0.205u L=0.04u
M540 U275/net26 n248 VSS VSS nmos W=0.155u L=0.04u
M541 n222 U275/net26 VSS VSS nmos W=0.155u L=0.04u
M542 U275/XI20-net13 G91 VSS VSS nmos W=0.155u L=0.04u
M543 U275/net26 G36 U275/XI20-net17 VSS nmos W=0.155u L=0.04u
M544 U275/XI20-net17 n247 U275/XI20-net13 VSS nmos W=0.155u L=0.04u
M545 U276/net32 G40 VSS VSS nmos W=0.155u L=0.04u
M546 U276/net59 n249 U276/net32 VSS nmos W=0.155u L=0.04u
M547 U276/net59 n250 VSS VSS nmos W=0.155u L=0.04u
M548 n221 U276/net59 VSS VSS nmos W=0.155u L=0.04u
M549 n221 U276/net59 VDD VDD pmos W=0.2u L=0.04u
M550 U276/net59 n249 U276/net22 VDD pmos W=0.205u L=0.04u
M551 U276/net59 G40 U276/net22 VDD pmos W=0.205u L=0.04u
M552 U276/net22 n250 VDD VDD pmos W=0.2u L=0.04u
M553 n220 G56 U277/net27 VSS nmos W=0.155u L=0.04u
M554 U277/net27 n251 VSS VSS nmos W=0.155u L=0.04u
M555 n220 n252 VSS VSS nmos W=0.155u L=0.04u
M556 n220 n251 U277/net13 VDD pmos W=0.205u L=0.04u
M557 U277/net13 n252 VDD VDD pmos W=0.205u L=0.04u
M558 n220 G56 U277/net13 VDD pmos W=0.205u L=0.04u
M559 n219 n253 VSS VSS nmos W=0.155u L=0.04u
M560 n219 n252 VSS VSS nmos W=0.155u L=0.04u
M561 U278/XI1-net8 n252 VDD VDD pmos W=0.205u L=0.04u
M562 n219 n253 U278/XI1-net8 VDD pmos W=0.205u L=0.04u
M563 n218 n254 VSS VSS nmos W=0.155u L=0.04u
M564 n218 n252 VSS VSS nmos W=0.155u L=0.04u
M565 U279/XI1-net8 n252 VDD VDD pmos W=0.205u L=0.04u
M566 n218 n254 U279/XI1-net8 VDD pmos W=0.205u L=0.04u
M567 n217 n255 VSS VSS nmos W=0.155u L=0.04u
M568 n217 n252 VSS VSS nmos W=0.155u L=0.04u
M569 U280/XI1-net8 n252 VDD VDD pmos W=0.205u L=0.04u
M570 n217 n255 U280/XI1-net8 VDD pmos W=0.205u L=0.04u
M571 n252 G14 VSS VSS nmos W=0.135u L=0.04u
M572 n252 G14 VDD VDD pmos W=0.205u L=0.04u
M573 U282/XU35-net6 G39 VSS VSS nmos W=0.155u L=0.04u
M574 U282/net5 n256 U282/XU35-net6 VSS nmos W=0.155u L=0.04u
M575 U282/XU36-net6 U282/net5 VSS VSS nmos W=0.155u L=0.04u
M576 n216 n249 U282/XU36-net6 VSS nmos W=0.155u L=0.04u
M577 U282/net5 G39 VDD VDD pmos W=0.205u L=0.04u
M578 U282/net5 n256 VDD VDD pmos W=0.205u L=0.04u
M579 n216 U282/net5 VDD VDD pmos W=0.205u L=0.04u
M580 n216 n249 VDD VDD pmos W=0.205u L=0.04u
M581 n215 n257 U283/net15 VSS nmos W=0.155u L=0.04u
M582 n215 n258 U283/net15 VSS nmos W=0.155u L=0.04u
M583 U283/net15 n259 VSS VSS nmos W=0.155u L=0.04u
M584 n215 n259 VDD VDD pmos W=0.205u L=0.04u
M585 n215 n257 U283/XI16-net11 VDD pmos W=0.205u L=0.04u
M586 U283/XI16-net11 n258 VDD VDD pmos W=0.205u L=0.04u
M587 VSS n263 U284/net22 VSS nmos W=0.155u L=0.04u
M588 U284/net22 n262 n214 VSS nmos W=0.155u L=0.04u
M589 U284/net22 n261 n214 VSS nmos W=0.155u L=0.04u
M590 U284/net22 n260 n214 VSS nmos W=0.155u L=0.04u
M591 U284/net38 n260 VDD VDD pmos W=0.205u L=0.04u
M592 U284/net35 n261 U284/net38 VDD pmos W=0.205u L=0.04u
M593 n214 n262 U284/net35 VDD pmos W=0.205u L=0.04u
M594 n214 n263 VDD VDD pmos W=0.205u L=0.04u
M595 n213 n264 U285/net15 VSS nmos W=0.155u L=0.04u
M596 n213 n265 U285/net15 VSS nmos W=0.155u L=0.04u
M597 U285/net15 n266 VSS VSS nmos W=0.155u L=0.04u
M598 n213 n266 VDD VDD pmos W=0.205u L=0.04u
M599 n213 n264 U285/XI16-net11 VDD pmos W=0.205u L=0.04u
M600 U285/XI16-net11 n265 VDD VDD pmos W=0.205u L=0.04u
M601 U286/XU35-net6 G24 VSS VSS nmos W=0.155u L=0.04u
M602 U286/net5 n228 U286/XU35-net6 VSS nmos W=0.155u L=0.04u
M603 U286/XU36-net6 U286/net5 VSS VSS nmos W=0.155u L=0.04u
M604 n212 n267 U286/XU36-net6 VSS nmos W=0.155u L=0.04u
M605 U286/net5 G24 VDD VDD pmos W=0.205u L=0.04u
M606 U286/net5 n228 VDD VDD pmos W=0.205u L=0.04u
M607 n212 U286/net5 VDD VDD pmos W=0.205u L=0.04u
M608 n212 n267 VDD VDD pmos W=0.205u L=0.04u
M609 G727 G90 VSS VSS nmos W=0.155u L=0.04u
M610 G727 n53 VSS VSS nmos W=0.155u L=0.04u
M611 U287/XI1-net8 n53 VDD VDD pmos W=0.205u L=0.04u
M612 G727 G90 U287/XI1-net8 VDD pmos W=0.205u L=0.04u
M613 U288/net19 G11 VSS VSS nmos W=0.155u L=0.04u
M614 G708 G11 U288/net40 VSS nmos W=0.155u L=0.04u
M615 G708 U288/net19 U288/net36 VSS nmos W=0.155u L=0.04u
M616 U288/net40 G89 VSS VSS nmos W=0.31u L=0.04u
M617 U288/net36 n268 VSS VSS nmos W=0.155u L=0.04u
M618 U288/net19 G11 VDD VDD pmos W=0.205u L=0.04u
M619 G708 U288/net19 U288/net26 VDD pmos W=0.325u L=0.04u
M620 U288/net26 G89 VDD VDD pmos W=0.41u L=0.04u
M621 G708 G11 U288/net30 VDD pmos W=0.325u L=0.04u
M622 U288/net30 n268 VDD VDD pmos W=0.205u L=0.04u
M623 G702 n270 VSS VSS nmos W=0.155u L=0.04u
M624 G702 G89 U289/XI17-net17 VSS nmos W=0.155u L=0.04u
M625 U289/XI17-net17 n269 VSS VSS nmos W=0.155u L=0.04u
M626 G702 n261 U289/XI10-net17 VSS nmos W=0.155u L=0.04u
M627 U289/XI10-net17 n268 VSS VSS nmos W=0.155u L=0.04u
M628 U289/net30 n261 G702 VDD pmos W=0.205u L=0.04u
M629 U289/net30 n268 G702 VDD pmos W=0.205u L=0.04u
M630 VDD n270 U289/net36 VDD pmos W=0.205u L=0.04u
M631 U289/net36 n269 U289/net30 VDD pmos W=0.205u L=0.04u
M632 U289/net36 G89 U289/net30 VDD pmos W=0.205u L=0.04u
M633 n270 n271 U290/net26 VSS nmos W=0.155u L=0.04u
M634 n270 n247 U290/net26 VSS nmos W=0.155u L=0.04u
M635 U290/net29 n273 VSS VSS nmos W=0.155u L=0.04u
M636 U290/net26 n259 U290/net29 VSS nmos W=0.155u L=0.04u
M637 U290/net26 n272 U290/net29 VSS nmos W=0.155u L=0.04u
M638 n270 n247 U290/net43 VDD pmos W=0.205u L=0.04u
M639 n270 n272 U290/net49 VDD pmos W=0.205u L=0.04u
M640 U290/net49 n259 VDD VDD pmos W=0.205u L=0.04u
M641 U290/net43 n271 VDD VDD pmos W=0.205u L=0.04u
M642 n270 n273 VDD VDD pmos W=0.205u L=0.04u
M643 n268 G94 VSS VSS nmos W=0.135u L=0.04u
M644 n268 G94 VDD VDD pmos W=0.205u L=0.04u
M645 U292/XU1-net6 G14 VSS VSS nmos W=0.155u L=0.04u
M646 G699 G13 U292/XU1-net6 VSS nmos W=0.155u L=0.04u
M647 G699 G14 VDD VDD pmos W=0.155u L=0.04u
M648 G699 G13 VDD VDD pmos W=0.155u L=0.04u
M649 G692 n262 U293/net14 VSS nmos W=0.155u L=0.04u
M650 U293/net14 n275 VSS VSS nmos W=0.155u L=0.04u
M651 U293/net14 n234 VSS VSS nmos W=0.155u L=0.04u
M652 G692 n274 U293/net14 VSS nmos W=0.155u L=0.04u
M653 G692 G10 U293/net14 VSS nmos W=0.155u L=0.04u
M654 G692 n275 U293/XI16-net11 VDD pmos W=0.205u L=0.04u
M655 U293/XI16-net11 n234 VDD VDD pmos W=0.205u L=0.04u
M656 G692 n274 U293/XI15-net11 VDD pmos W=0.205u L=0.04u
M657 U293/XI15-net11 G10 U293/XI15-net18 VDD pmos W=0.205u L=0.04u
M658 U293/XI15-net18 n262 VDD VDD pmos W=0.205u L=0.04u
M659 G686 n234 U294/net14 VSS nmos W=0.155u L=0.04u
M660 U294/net14 n275 VSS VSS nmos W=0.155u L=0.04u
M661 U294/net14 n273 VSS VSS nmos W=0.155u L=0.04u
M662 G686 n274 U294/net14 VSS nmos W=0.155u L=0.04u
M663 G686 G10 U294/net14 VSS nmos W=0.155u L=0.04u
M664 G686 n275 U294/XI16-net11 VDD pmos W=0.205u L=0.04u
M665 U294/XI16-net11 n273 VDD VDD pmos W=0.205u L=0.04u
M666 G686 n274 U294/XI15-net11 VDD pmos W=0.205u L=0.04u
M667 U294/XI15-net11 G10 U294/XI15-net18 VDD pmos W=0.205u L=0.04u
M668 U294/XI15-net18 n234 VDD VDD pmos W=0.205u L=0.04u
M669 G681 n274 U295/net15 VSS nmos W=0.155u L=0.04u
M670 G681 n273 U295/net15 VSS nmos W=0.155u L=0.04u
M671 U295/net15 n275 VSS VSS nmos W=0.155u L=0.04u
M672 G681 n275 VDD VDD pmos W=0.205u L=0.04u
M673 G681 n274 U295/XI16-net11 VDD pmos W=0.205u L=0.04u
M674 U295/XI16-net11 n273 VDD VDD pmos W=0.205u L=0.04u
M675 U296/net13 n274 VSS VSS nmos W=0.155u L=0.04u
M676 U296/net16 U296/net13 VSS VSS nmos W=0.155u L=0.04u
M677 n275 G10 U296/net16 VSS nmos W=0.155u L=0.04u
M678 U296/net13 n274 VDD VDD pmos W=0.205u L=0.04u
M679 VDD U296/net13 n275 VDD pmos W=0.205u L=0.04u
M680 VDD G10 n275 VDD pmos W=0.205u L=0.04u
M681 n274 G86 VSS VSS nmos W=0.155u L=0.04u
M682 n274 U297/net4 VSS VSS nmos W=0.155u L=0.04u
M683 U297/net4 G13 VSS VSS nmos W=0.155u L=0.04u
M684 U297/XU1-net8 U297/net4 VDD VDD pmos W=0.205u L=0.04u
M685 n274 G86 U297/XU1-net8 VDD pmos W=0.205u L=0.04u
M686 U297/net4 G13 VDD VDD pmos W=0.205u L=0.04u
M687 G676 U298/net28 VSS VSS nmos W=0.155u L=0.04u
M688 U298/net47 G88 VSS VSS nmos W=0.155u L=0.04u
M689 U298/net28 U298/net6 U298/net47 VSS nmos W=0.155u L=0.04u
M690 U298/net44 G89 VSS VSS nmos W=0.155u L=0.04u
M691 U298/net28 n276 U298/net44 VSS nmos W=0.155u L=0.04u
M692 U298/net6 n276 VSS VSS nmos W=0.155u L=0.04u
M693 G676 U298/net28 VDD VDD pmos W=0.205u L=0.04u
M694 VDD G88 U298/net47 VDD pmos W=0.205u L=0.04u
M695 U298/net47 n276 U298/net28 VDD pmos W=0.205u L=0.04u
M696 U298/net44 U298/net6 U298/net28 VDD pmos W=0.205u L=0.04u
M697 VDD G89 U298/net44 VDD pmos W=0.205u L=0.04u
M698 VDD n276 U298/net6 VDD pmos W=0.205u L=0.04u
M699 U299/net19 G11 VSS VSS nmos W=0.155u L=0.04u
M700 G670 G11 U299/net40 VSS nmos W=0.155u L=0.04u
M701 G670 U299/net19 U299/net36 VSS nmos W=0.155u L=0.04u
M702 U299/net40 n272 VSS VSS nmos W=0.31u L=0.04u
M703 U299/net36 n271 VSS VSS nmos W=0.155u L=0.04u
M704 U299/net19 G11 VDD VDD pmos W=0.205u L=0.04u
M705 G670 U299/net19 U299/net26 VDD pmos W=0.325u L=0.04u
M706 U299/net26 n272 VDD VDD pmos W=0.41u L=0.04u
M707 G670 G11 U299/net30 VDD pmos W=0.325u L=0.04u
M708 U299/net30 n271 VDD VDD pmos W=0.205u L=0.04u
M709 n271 G88 VSS VSS nmos W=0.135u L=0.04u
M710 n271 G88 VDD VDD pmos W=0.205u L=0.04u
M711 U301/net19 G11 VSS VSS nmos W=0.155u L=0.04u
M712 G664 G11 U301/net40 VSS nmos W=0.155u L=0.04u
M713 G664 U301/net19 U301/net36 VSS nmos W=0.155u L=0.04u
M714 U301/net40 G94 VSS VSS nmos W=0.31u L=0.04u
M715 U301/net36 n272 VSS VSS nmos W=0.155u L=0.04u
M716 U301/net19 G11 VDD VDD pmos W=0.205u L=0.04u
M717 G664 U301/net19 U301/net26 VDD pmos W=0.325u L=0.04u
M718 U301/net26 G94 VDD VDD pmos W=0.41u L=0.04u
M719 G664 G11 U301/net30 VDD pmos W=0.325u L=0.04u
M720 U301/net30 n272 VDD VDD pmos W=0.205u L=0.04u
M721 n272 G87 VSS VSS nmos W=0.135u L=0.04u
M722 n272 G87 VDD VDD pmos W=0.205u L=0.04u
M723 U303/XU1-net6 n277 VSS VSS nmos W=0.155u L=0.04u
M724 G612 n276 U303/XU1-net6 VSS nmos W=0.155u L=0.04u
M725 G612 n277 VDD VDD pmos W=0.155u L=0.04u
M726 G612 n276 VDD VDD pmos W=0.155u L=0.04u
M727 n276 G11 VSS VSS nmos W=0.135u L=0.04u
M728 n276 G11 VDD VDD pmos W=0.205u L=0.04u
M729 U305/XU1-net6 n279 VSS VSS nmos W=0.155u L=0.04u
M730 G611 n278 U305/XU1-net6 VSS nmos W=0.155u L=0.04u
M731 G611 n279 VDD VDD pmos W=0.155u L=0.04u
M732 G611 n278 VDD VDD pmos W=0.155u L=0.04u
M733 G607 U306/net7 VSS VSS nmos W=0.155u L=0.04u
M734 U306/net7 G10 VSS VSS nmos W=0.155u L=0.04u
M735 U306/net7 n278 VSS VSS nmos W=0.155u L=0.04u
M736 G607 U306/net7 VDD VDD pmos W=0.205u L=0.04u
M737 U306/X_u7-net8 n278 VDD VDD pmos W=0.205u L=0.04u
M738 U306/net7 G10 U306/X_u7-net8 VDD pmos W=0.205u L=0.04u
M739 U307/XU1-net6 n280 VSS VSS nmos W=0.155u L=0.04u
M740 G606 n278 U307/XU1-net6 VSS nmos W=0.155u L=0.04u
M741 G606 n280 VDD VDD pmos W=0.155u L=0.04u
M742 G606 n278 VDD VDD pmos W=0.155u L=0.04u
M743 G599 U308/net6 VSS VSS nmos W=0.155u L=0.04u
M744 U308/net6 n281 U308/XU30-net23 VSS nmos W=0.155u L=0.04u
M745 U308/XU30-net23 n282 U308/XU30-net26 VSS nmos W=0.155u L=0.04u
M746 U308/XU30-net26 G83 U308/XU30-net29 VSS nmos W=0.155u L=0.04u
M747 U308/XU30-net29 n283 VSS VSS nmos W=0.155u L=0.04u
M748 G599 U308/net6 VDD VDD pmos W=0.205u L=0.04u
M749 U308/net6 n283 VDD VDD pmos W=0.205u L=0.04u
M750 U308/net6 G83 VDD VDD pmos W=0.205u L=0.04u
M751 U308/net6 n282 VDD VDD pmos W=0.205u L=0.04u
M752 U308/net6 n281 VDD VDD pmos W=0.205u L=0.04u
M753 G591 n284 U309/net15 VSS nmos W=0.155u L=0.04u
M754 G591 n285 U309/net15 VSS nmos W=0.155u L=0.04u
M755 U309/net15 n286 VSS VSS nmos W=0.155u L=0.04u
M756 G591 n286 VDD VDD pmos W=0.205u L=0.04u
M757 G591 n284 U309/XI16-net11 VDD pmos W=0.205u L=0.04u
M758 U309/XI16-net11 n285 VDD VDD pmos W=0.205u L=0.04u
M759 n285 G83 VSS VSS nmos W=0.135u L=0.04u
M760 n285 G83 VDD VDD pmos W=0.205u L=0.04u
M761 n284 n283 VSS VSS nmos W=0.155u L=0.04u
M762 n284 n287 VSS VSS nmos W=0.155u L=0.04u
M763 U311/XI1-net8 n287 VDD VDD pmos W=0.205u L=0.04u
M764 n284 n283 U311/XI1-net8 VDD pmos W=0.205u L=0.04u
M765 G576 U312/net7 VSS VSS nmos W=0.155u L=0.04u
M766 U312/net7 G9 VSS VSS nmos W=0.155u L=0.04u
M767 U312/net7 n278 VSS VSS nmos W=0.155u L=0.04u
M768 G576 U312/net7 VDD VDD pmos W=0.205u L=0.04u
M769 U312/X_u7-net8 n278 VDD VDD pmos W=0.205u L=0.04u
M770 U312/net7 G9 U312/X_u7-net8 VDD pmos W=0.205u L=0.04u
M771 U313/net13 G82 VSS VSS nmos W=0.155u L=0.04u
M772 U313/net16 U313/net13 VSS VSS nmos W=0.155u L=0.04u
M773 G575 n278 U313/net16 VSS nmos W=0.155u L=0.04u
M774 U313/net13 G82 VDD VDD pmos W=0.205u L=0.04u
M775 VDD U313/net13 G575 VDD pmos W=0.205u L=0.04u
M776 VDD n278 G575 VDD pmos W=0.205u L=0.04u
M777 U314/XU1-net6 n277 VSS VSS nmos W=0.155u L=0.04u
M778 G572 n288 U314/XU1-net6 VSS nmos W=0.155u L=0.04u
M779 G572 n277 VDD VDD pmos W=0.155u L=0.04u
M780 G572 n288 VDD VDD pmos W=0.155u L=0.04u
M781 U315/XU1-net6 n289 VSS VSS nmos W=0.155u L=0.04u
M782 G571 n278 U315/XU1-net6 VSS nmos W=0.155u L=0.04u
M783 G571 n289 VDD VDD pmos W=0.155u L=0.04u
M784 G571 n278 VDD VDD pmos W=0.155u L=0.04u
M785 G568 U316/net7 VSS VSS nmos W=0.155u L=0.04u
M786 U316/net7 G7 VSS VSS nmos W=0.155u L=0.04u
M787 U316/net7 n278 VSS VSS nmos W=0.155u L=0.04u
M788 G568 U316/net7 VDD VDD pmos W=0.205u L=0.04u
M789 U316/X_u7-net8 n278 VDD VDD pmos W=0.205u L=0.04u
M790 U316/net7 G7 U316/X_u7-net8 VDD pmos W=0.205u L=0.04u
M791 U317/XU1-net6 n290 VSS VSS nmos W=0.155u L=0.04u
M792 G567 n278 U317/XU1-net6 VSS nmos W=0.155u L=0.04u
M793 G567 n290 VDD VDD pmos W=0.155u L=0.04u
M794 G567 n278 VDD VDD pmos W=0.155u L=0.04u
M795 G564 U318/net7 VSS VSS nmos W=0.155u L=0.04u
M796 U318/net7 G6 VSS VSS nmos W=0.155u L=0.04u
M797 U318/net7 n278 VSS VSS nmos W=0.155u L=0.04u
M798 G564 U318/net7 VDD VDD pmos W=0.205u L=0.04u
M799 U318/X_u7-net8 n278 VDD VDD pmos W=0.205u L=0.04u
M800 U318/net7 G6 U318/X_u7-net8 VDD pmos W=0.205u L=0.04u
M801 U319/XU1-net6 n291 VSS VSS nmos W=0.155u L=0.04u
M802 G563 n278 U319/XU1-net6 VSS nmos W=0.155u L=0.04u
M803 G563 n291 VDD VDD pmos W=0.155u L=0.04u
M804 G563 n278 VDD VDD pmos W=0.155u L=0.04u
M805 n278 n277 VSS VSS nmos W=0.135u L=0.04u
M806 n278 n277 VDD VDD pmos W=0.205u L=0.04u
M807 n277 n53 U321/net15 VSS nmos W=0.155u L=0.04u
M808 n277 n234 U321/net15 VSS nmos W=0.155u L=0.04u
M809 U321/net15 G14 VSS VSS nmos W=0.155u L=0.04u
M810 n277 G14 VDD VDD pmos W=0.205u L=0.04u
M811 n277 n53 U321/XI16-net11 VDD pmos W=0.205u L=0.04u
M812 U321/XI16-net11 n234 VDD VDD pmos W=0.205u L=0.04u
M813 U322/net4 U322/net10 U322/net14 VSS nmos W=0.155u L=0.04u
M814 U322/net6 n292 U322/net14 VSS nmos W=0.155u L=0.04u
M815 U322/net4 G78 VSS VSS nmos W=0.155u L=0.04u
M816 U322/net6 U322/net4 VSS VSS nmos W=0.155u L=0.04u
M817 G545 U322/net14 VSS VSS nmos W=0.155u L=0.04u
M818 U322/net10 n292 VSS VSS nmos W=0.155u L=0.04u
M819 U322/net4 n292 U322/net14 VDD pmos W=0.205u L=0.04u
M820 U322/net6 U322/net10 U322/net14 VDD pmos W=0.205u L=0.04u
M821 U322/net4 G78 VDD VDD pmos W=0.205u L=0.04u
M822 U322/net6 U322/net4 VDD VDD pmos W=0.205u L=0.04u
M823 G545 U322/net14 VDD VDD pmos W=0.205u L=0.04u
M824 U322/net10 n292 VDD VDD pmos W=0.205u L=0.04u
M825 G542 n292 VSS VSS nmos W=0.155u L=0.04u
M826 G542 n293 VSS VSS nmos W=0.155u L=0.04u
M827 U323/XI1-net8 n293 VDD VDD pmos W=0.205u L=0.04u
M828 G542 n292 U323/XI1-net8 VDD pmos W=0.205u L=0.04u
M829 n293 n294 U324/net27 VSS nmos W=0.155u L=0.04u
M830 U324/net27 G76 VSS VSS nmos W=0.155u L=0.04u
M831 n293 G77 VSS VSS nmos W=0.155u L=0.04u
M832 n293 G76 U324/net13 VDD pmos W=0.205u L=0.04u
M833 U324/net13 G77 VDD VDD pmos W=0.205u L=0.04u
M834 n293 n294 U324/net13 VDD pmos W=0.205u L=0.04u
M835 U325/net7 n294 U325/X_u4-net10 VSS nmos W=0.155u L=0.04u
M836 U325/X_u4-net10 G77 U325/X_u4-net13 VSS nmos W=0.155u L=0.04u
M837 U325/X_u4-net13 G76 VSS VSS nmos W=0.155u L=0.04u
M838 n292 U325/net7 VSS VSS nmos W=0.155u L=0.04u
M839 U325/net7 G76 VDD VDD pmos W=0.205u L=0.04u
M840 U325/net7 n294 VDD VDD pmos W=0.205u L=0.04u
M841 U325/net7 G77 VDD VDD pmos W=0.205u L=0.04u
M842 n292 U325/net7 VDD VDD pmos W=0.205u L=0.04u
M843 U326/net4 U326/net10 U326/net14 VSS nmos W=0.155u L=0.04u
M844 U326/net6 G76 U326/net14 VSS nmos W=0.155u L=0.04u
M845 U326/net4 n294 VSS VSS nmos W=0.155u L=0.04u
M846 U326/net6 U326/net4 VSS VSS nmos W=0.155u L=0.04u
M847 G537 U326/net14 VSS VSS nmos W=0.155u L=0.04u
M848 U326/net10 G76 VSS VSS nmos W=0.155u L=0.04u
M849 U326/net4 G76 U326/net14 VDD pmos W=0.205u L=0.04u
M850 U326/net6 U326/net10 U326/net14 VDD pmos W=0.205u L=0.04u
M851 U326/net4 n294 VDD VDD pmos W=0.205u L=0.04u
M852 U326/net6 U326/net4 VDD VDD pmos W=0.205u L=0.04u
M853 G537 U326/net14 VDD VDD pmos W=0.205u L=0.04u
M854 U326/net10 G76 VDD VDD pmos W=0.205u L=0.04u
M855 G532 n294 VSS VSS nmos W=0.155u L=0.04u
M856 G532 n295 VSS VSS nmos W=0.155u L=0.04u
M857 U327/XI1-net8 n295 VDD VDD pmos W=0.205u L=0.04u
M858 G532 n294 U327/XI1-net8 VDD pmos W=0.205u L=0.04u
M859 U328/net11 n286 VSS VSS nmos W=0.155u L=0.04u
M860 U328/net11 n296 VSS VSS nmos W=0.155u L=0.04u
M861 n295 G75 VSS VSS nmos W=0.155u L=0.04u
M862 n295 U328/net11 VSS VSS nmos W=0.155u L=0.04u
M863 U328/XI1-net8 n296 VDD VDD pmos W=0.205u L=0.04u
M864 U328/net11 n286 U328/XI1-net8 VDD pmos W=0.205u L=0.04u
M865 U328/XU39-net8 U328/net11 VDD VDD pmos W=0.205u L=0.04u
M866 n295 G75 U328/XU39-net8 VDD pmos W=0.205u L=0.04u
M867 n294 n286 VSS VSS nmos W=0.155u L=0.04u
M868 n294 n297 VSS VSS nmos W=0.155u L=0.04u
M869 n294 n296 VSS VSS nmos W=0.155u L=0.04u
M870 U329/net25 n286 VDD VDD pmos W=0.41u L=0.04u
M871 U329/net28 n297 U329/net25 VDD pmos W=0.41u L=0.04u
M872 n294 n296 U329/net28 VDD pmos W=0.41u L=0.04u
M873 U330/net4 U330/net10 U330/net14 VSS nmos W=0.155u L=0.04u
M874 U330/net6 n286 U330/net14 VSS nmos W=0.155u L=0.04u
M875 U330/net4 n296 VSS VSS nmos W=0.155u L=0.04u
M876 U330/net6 U330/net4 VSS VSS nmos W=0.155u L=0.04u
M877 G527 U330/net14 VSS VSS nmos W=0.155u L=0.04u
M878 U330/net10 n286 VSS VSS nmos W=0.155u L=0.04u
M879 U330/net4 n286 U330/net14 VDD pmos W=0.205u L=0.04u
M880 U330/net6 U330/net10 U330/net14 VDD pmos W=0.205u L=0.04u
M881 U330/net4 n296 VDD VDD pmos W=0.205u L=0.04u
M882 U330/net6 U330/net4 VDD VDD pmos W=0.205u L=0.04u
M883 G527 U330/net14 VDD VDD pmos W=0.205u L=0.04u
M884 U330/net10 n286 VDD VDD pmos W=0.205u L=0.04u
M885 n296 G74 VSS VSS nmos W=0.135u L=0.04u
M886 n296 G74 VDD VDD pmos W=0.205u L=0.04u
M887 U332/XU1-net6 n287 VSS VSS nmos W=0.155u L=0.04u
M888 n286 n298 U332/XU1-net6 VSS nmos W=0.155u L=0.04u
M889 n286 n287 VDD VDD pmos W=0.155u L=0.04u
M890 n286 n298 VDD VDD pmos W=0.155u L=0.04u
M891 U333/net19 n232 VSS VSS nmos W=0.155u L=0.04u
M892 n298 n232 U333/net40 VSS nmos W=0.155u L=0.04u
M893 n298 U333/net19 U333/net36 VSS nmos W=0.155u L=0.04u
M894 U333/net40 n300 VSS VSS nmos W=0.31u L=0.04u
M895 U333/net36 n299 VSS VSS nmos W=0.155u L=0.04u
M896 U333/net19 n232 VDD VDD pmos W=0.205u L=0.04u
M897 n298 U333/net19 U333/net26 VDD pmos W=0.325u L=0.04u
M898 U333/net26 n300 VDD VDD pmos W=0.41u L=0.04u
M899 n298 n232 U333/net30 VDD pmos W=0.325u L=0.04u
M900 U333/net30 n299 VDD VDD pmos W=0.205u L=0.04u
M901 U334/XU1-net6 n302 VSS VSS nmos W=0.155u L=0.04u
M902 n300 n301 U334/XU1-net6 VSS nmos W=0.155u L=0.04u
M903 n300 n302 VDD VDD pmos W=0.155u L=0.04u
M904 n300 n301 VDD VDD pmos W=0.155u L=0.04u
M905 n299 n257 U335/net27 VSS nmos W=0.155u L=0.04u
M906 U335/net27 G34 VSS VSS nmos W=0.155u L=0.04u
M907 n299 n262 VSS VSS nmos W=0.155u L=0.04u
M908 n299 G34 U335/net13 VDD pmos W=0.205u L=0.04u
M909 U335/net13 n262 VDD VDD pmos W=0.205u L=0.04u
M910 n299 n257 U335/net13 VDD pmos W=0.205u L=0.04u
M911 U336/XU1-net6 n304 VSS VSS nmos W=0.155u L=0.04u
M912 G502 n303 U336/XU1-net6 VSS nmos W=0.155u L=0.04u
M913 G502 n304 VDD VDD pmos W=0.155u L=0.04u
M914 G502 n303 VDD VDD pmos W=0.155u L=0.04u
M915 U337/net19 G63 VSS VSS nmos W=0.155u L=0.04u
M916 n303 G63 U337/net40 VSS nmos W=0.155u L=0.04u
M917 n303 U337/net19 U337/net36 VSS nmos W=0.155u L=0.04u
M918 U337/net40 G5 VSS VSS nmos W=0.31u L=0.04u
M919 U337/net36 G2 VSS VSS nmos W=0.155u L=0.04u
M920 U337/net19 G63 VDD VDD pmos W=0.205u L=0.04u
M921 n303 U337/net19 U337/net26 VDD pmos W=0.325u L=0.04u
M922 U337/net26 G5 VDD VDD pmos W=0.41u L=0.04u
M923 n303 G63 U337/net30 VDD pmos W=0.325u L=0.04u
M924 U337/net30 G2 VDD VDD pmos W=0.205u L=0.04u
M925 U338/net13 G73 VSS VSS nmos W=0.155u L=0.04u
M926 U338/net16 U338/net13 VSS VSS nmos W=0.155u L=0.04u
M927 G501 n305 U338/net16 VSS nmos W=0.155u L=0.04u
M928 U338/net13 G73 VDD VDD pmos W=0.205u L=0.04u
M929 VDD U338/net13 G501 VDD pmos W=0.205u L=0.04u
M930 VDD n305 G501 VDD pmos W=0.205u L=0.04u
M931 n305 n304 VSS VSS nmos W=0.135u L=0.04u
M932 n305 n304 VDD VDD pmos W=0.205u L=0.04u
M933 U340/XU1-net6 n304 VSS VSS nmos W=0.155u L=0.04u
M934 G497 n306 U340/XU1-net6 VSS nmos W=0.155u L=0.04u
M935 G497 n304 VDD VDD pmos W=0.155u L=0.04u
M936 G497 n306 VDD VDD pmos W=0.155u L=0.04u
M937 U341/net19 G63 VSS VSS nmos W=0.155u L=0.04u
M938 n306 G63 U341/net40 VSS nmos W=0.155u L=0.04u
M939 n306 U341/net19 U341/net36 VSS nmos W=0.155u L=0.04u
M940 U341/net40 G4 VSS VSS nmos W=0.31u L=0.04u
M941 U341/net36 G1 VSS VSS nmos W=0.155u L=0.04u
M942 U341/net19 G63 VDD VDD pmos W=0.205u L=0.04u
M943 n306 U341/net19 U341/net26 VDD pmos W=0.325u L=0.04u
M944 U341/net26 G4 VDD VDD pmos W=0.41u L=0.04u
M945 n306 G63 U341/net30 VDD pmos W=0.325u L=0.04u
M946 U341/net30 G1 VDD VDD pmos W=0.205u L=0.04u
M947 G496 U342/net7 VSS VSS nmos W=0.155u L=0.04u
M948 U342/net7 G72 VSS VSS nmos W=0.155u L=0.04u
M949 U342/net7 n304 VSS VSS nmos W=0.155u L=0.04u
M950 G496 U342/net7 VDD VDD pmos W=0.205u L=0.04u
M951 U342/X_u7-net8 n304 VDD VDD pmos W=0.205u L=0.04u
M952 U342/net7 G72 U342/X_u7-net8 VDD pmos W=0.205u L=0.04u
M953 U343/XU1-net6 n304 VSS VSS nmos W=0.155u L=0.04u
M954 G493 n307 U343/XU1-net6 VSS nmos W=0.155u L=0.04u
M955 G493 n304 VDD VDD pmos W=0.155u L=0.04u
M956 G493 n307 VDD VDD pmos W=0.155u L=0.04u
M957 U344/net19 G63 VSS VSS nmos W=0.155u L=0.04u
M958 n307 G63 U344/net40 VSS nmos W=0.155u L=0.04u
M959 n307 U344/net19 U344/net36 VSS nmos W=0.155u L=0.04u
M960 U344/net40 G3 VSS VSS nmos W=0.31u L=0.04u
M961 U344/net36 G0 VSS VSS nmos W=0.155u L=0.04u
M962 U344/net19 G63 VDD VDD pmos W=0.205u L=0.04u
M963 n307 U344/net19 U344/net26 VDD pmos W=0.325u L=0.04u
M964 U344/net26 G3 VDD VDD pmos W=0.41u L=0.04u
M965 n307 G63 U344/net30 VDD pmos W=0.325u L=0.04u
M966 U344/net30 G0 VDD VDD pmos W=0.205u L=0.04u
M967 G492 U345/net7 VSS VSS nmos W=0.155u L=0.04u
M968 U345/net7 G71 VSS VSS nmos W=0.155u L=0.04u
M969 U345/net7 n304 VSS VSS nmos W=0.155u L=0.04u
M970 G492 U345/net7 VDD VDD pmos W=0.205u L=0.04u
M971 U345/X_u7-net8 n304 VDD VDD pmos W=0.205u L=0.04u
M972 U345/net7 G71 U345/X_u7-net8 VDD pmos W=0.205u L=0.04u
M973 n304 n53 U346/net15 VSS nmos W=0.155u L=0.04u
M974 n304 n273 U346/net15 VSS nmos W=0.155u L=0.04u
M975 U346/net15 G14 VSS VSS nmos W=0.155u L=0.04u
M976 n304 G14 VDD VDD pmos W=0.205u L=0.04u
M977 n304 n53 U346/XI16-net11 VDD pmos W=0.205u L=0.04u
M978 U346/XI16-net11 n273 VDD VDD pmos W=0.205u L=0.04u
M979 n53 n226 VSS VSS nmos W=0.135u L=0.04u
M980 n53 n226 VDD VDD pmos W=0.205u L=0.04u
M981 U348/XU1-net6 n308 VSS VSS nmos W=0.155u L=0.04u
M982 n226 G14 U348/XU1-net6 VSS nmos W=0.155u L=0.04u
M983 n226 n308 VDD VDD pmos W=0.155u L=0.04u
M984 n226 G14 VDD VDD pmos W=0.155u L=0.04u
M985 U349/net4 U349/net10 U349/net14 VSS nmos W=0.155u L=0.04u
M986 U349/net6 G70 U349/net14 VSS nmos W=0.155u L=0.04u
M987 U349/net4 n309 VSS VSS nmos W=0.155u L=0.04u
M988 U349/net6 U349/net4 VSS VSS nmos W=0.155u L=0.04u
M989 G473 U349/net14 VSS VSS nmos W=0.155u L=0.04u
M990 U349/net10 G70 VSS VSS nmos W=0.155u L=0.04u
M991 U349/net4 G70 U349/net14 VDD pmos W=0.205u L=0.04u
M992 U349/net6 U349/net10 U349/net14 VDD pmos W=0.205u L=0.04u
M993 U349/net4 n309 VDD VDD pmos W=0.205u L=0.04u
M994 U349/net6 U349/net4 VDD VDD pmos W=0.205u L=0.04u
M995 G473 U349/net14 VDD VDD pmos W=0.205u L=0.04u
M996 U349/net10 G70 VDD VDD pmos W=0.205u L=0.04u
M997 n309 n310 VSS VSS nmos W=0.155u L=0.04u
M998 n309 n311 VSS VSS nmos W=0.155u L=0.04u
M999 U350/XI1-net8 n311 VDD VDD pmos W=0.205u L=0.04u
M1000 n309 n310 U350/XI1-net8 VDD pmos W=0.205u L=0.04u
M1001 U351/net4 U351/net10 U351/net14 VSS nmos W=0.155u L=0.04u
M1002 U351/net6 n311 U351/net14 VSS nmos W=0.155u L=0.04u
M1003 U351/net4 n310 VSS VSS nmos W=0.155u L=0.04u
M1004 U351/net6 U351/net4 VSS VSS nmos W=0.155u L=0.04u
M1005 G470 U351/net14 VSS VSS nmos W=0.155u L=0.04u
M1006 U351/net10 n311 VSS VSS nmos W=0.155u L=0.04u
M1007 U351/net4 n311 U351/net14 VDD pmos W=0.205u L=0.04u
M1008 U351/net6 U351/net10 U351/net14 VDD pmos W=0.205u L=0.04u
M1009 U351/net4 n310 VDD VDD pmos W=0.205u L=0.04u
M1010 U351/net6 U351/net4 VDD VDD pmos W=0.205u L=0.04u
M1011 G470 U351/net14 VDD VDD pmos W=0.205u L=0.04u
M1012 U351/net10 n311 VDD VDD pmos W=0.205u L=0.04u
M1013 G465 n312 VSS VSS nmos W=0.155u L=0.04u
M1014 G465 U352/net4 VSS VSS nmos W=0.155u L=0.04u
M1015 U352/net4 n311 VSS VSS nmos W=0.155u L=0.04u
M1016 U352/XU1-net8 U352/net4 VDD VDD pmos W=0.205u L=0.04u
M1017 G465 n312 U352/XU1-net8 VDD pmos W=0.205u L=0.04u
M1018 U352/net4 n311 VDD VDD pmos W=0.205u L=0.04u
M1019 n312 G67 U353/net27 VSS nmos W=0.155u L=0.04u
M1020 U353/net27 n313 VSS VSS nmos W=0.155u L=0.04u
M1021 n312 G68 VSS VSS nmos W=0.155u L=0.04u
M1022 n312 n313 U353/net13 VDD pmos W=0.205u L=0.04u
M1023 U353/net13 G68 VDD VDD pmos W=0.205u L=0.04u
M1024 n312 G67 U353/net13 VDD pmos W=0.205u L=0.04u
M1025 n311 G67 U354/XI0-net10 VSS nmos W=0.155u L=0.04u
M1026 U354/XI0-net10 n313 U354/XI0-net13 VSS nmos W=0.155u L=0.04u
M1027 U354/XI0-net13 G68 VSS VSS nmos W=0.155u L=0.04u
M1028 n311 G68 VDD VDD pmos W=0.205u L=0.04u
M1029 n311 G67 VDD VDD pmos W=0.205u L=0.04u
M1030 n311 n313 VDD VDD pmos W=0.205u L=0.04u
M1031 U355/net4 U355/net10 U355/net14 VSS nmos W=0.155u L=0.04u
M1032 U355/net6 G67 U355/net14 VSS nmos W=0.155u L=0.04u
M1033 U355/net4 n313 VSS VSS nmos W=0.155u L=0.04u
M1034 U355/net6 U355/net4 VSS VSS nmos W=0.155u L=0.04u
M1035 G460 U355/net14 VSS VSS nmos W=0.155u L=0.04u
M1036 U355/net10 G67 VSS VSS nmos W=0.155u L=0.04u
M1037 U355/net4 G67 U355/net14 VDD pmos W=0.205u L=0.04u
M1038 U355/net6 U355/net10 U355/net14 VDD pmos W=0.205u L=0.04u
M1039 U355/net4 n313 VDD VDD pmos W=0.205u L=0.04u
M1040 U355/net6 U355/net4 VDD VDD pmos W=0.205u L=0.04u
M1041 G460 U355/net14 VDD VDD pmos W=0.205u L=0.04u
M1042 U355/net10 G67 VDD VDD pmos W=0.205u L=0.04u
M1043 n313 n314 U356/net15 VSS nmos W=0.155u L=0.04u
M1044 n313 n315 U356/net15 VSS nmos W=0.155u L=0.04u
M1045 U356/net15 G90 VSS VSS nmos W=0.155u L=0.04u
M1046 n313 G90 VDD VDD pmos W=0.205u L=0.04u
M1047 n313 n314 U356/XI16-net11 VDD pmos W=0.205u L=0.04u
M1048 U356/XI16-net11 n315 VDD VDD pmos W=0.205u L=0.04u
M1049 n314 n269 VSS VSS nmos W=0.155u L=0.04u
M1050 n314 n234 VSS VSS nmos W=0.155u L=0.04u
M1051 U357/XI1-net8 n234 VDD VDD pmos W=0.205u L=0.04u
M1052 n314 n269 U357/XI1-net8 VDD pmos W=0.205u L=0.04u
M1053 U358/net19 n308 VSS VSS nmos W=0.155u L=0.04u
M1054 G452 n308 U358/net40 VSS nmos W=0.155u L=0.04u
M1055 G452 U358/net19 U358/net36 VSS nmos W=0.155u L=0.04u
M1056 U358/net40 n317 VSS VSS nmos W=0.31u L=0.04u
M1057 U358/net36 n316 VSS VSS nmos W=0.155u L=0.04u
M1058 U358/net19 n308 VDD VDD pmos W=0.205u L=0.04u
M1059 G452 U358/net19 U358/net26 VDD pmos W=0.325u L=0.04u
M1060 U358/net26 n317 VDD VDD pmos W=0.41u L=0.04u
M1061 G452 n308 U358/net30 VDD pmos W=0.325u L=0.04u
M1062 U358/net30 n316 VDD VDD pmos W=0.205u L=0.04u
M1063 U359/XU1-net6 n308 VSS VSS nmos W=0.155u L=0.04u
M1064 G448 n316 U359/XU1-net6 VSS nmos W=0.155u L=0.04u
M1065 G448 n308 VDD VDD pmos W=0.155u L=0.04u
M1066 G448 n316 VDD VDD pmos W=0.155u L=0.04u
M1067 n316 G65 VSS VSS nmos W=0.135u L=0.04u
M1068 n316 G65 VDD VDD pmos W=0.205u L=0.04u
M1069 U361/net19 n308 VSS VSS nmos W=0.155u L=0.04u
M1070 G442 n308 U361/net40 VSS nmos W=0.155u L=0.04u
M1071 G442 U361/net19 U361/net36 VSS nmos W=0.155u L=0.04u
M1072 U361/net40 n319 VSS VSS nmos W=0.31u L=0.04u
M1073 U361/net36 n318 VSS VSS nmos W=0.155u L=0.04u
M1074 U361/net19 n308 VDD VDD pmos W=0.205u L=0.04u
M1075 G442 U361/net19 U361/net26 VDD pmos W=0.325u L=0.04u
M1076 U361/net26 n319 VDD VDD pmos W=0.41u L=0.04u
M1077 G442 n308 U361/net30 VDD pmos W=0.325u L=0.04u
M1078 U361/net30 n318 VDD VDD pmos W=0.205u L=0.04u
M1079 U362/p2 n323 VSS VSS nmos W=0.155u L=0.04u
M1080 U362/p0 n321 U362/p1 VSS nmos W=0.155u L=0.04u
M1081 U362/p1 n322 U362/p2 VSS nmos W=0.155u L=0.04u
M1082 n308 n320 U362/p0 VSS nmos W=0.155u L=0.04u
M1083 n308 n322 VDD VDD pmos W=0.205u L=0.04u
M1084 n308 n321 VDD VDD pmos W=0.205u L=0.04u
M1085 n308 n320 VDD VDD pmos W=0.205u L=0.04u
M1086 n308 n323 VDD VDD pmos W=0.205u L=0.04u
M1087 U363/net4 n324 U363/net14 VSS nmos W=0.155u L=0.04u
M1088 U363/net6 U363/net10 U363/net14 VSS nmos W=0.17u L=0.04u
M1089 U363/net4 G70 VSS VSS nmos W=0.155u L=0.04u
M1090 U363/net6 U363/net4 VSS VSS nmos W=0.17u L=0.04u
M1091 n323 U363/net14 VSS VSS nmos W=0.155u L=0.04u
M1092 U363/net10 n324 VSS VSS nmos W=0.155u L=0.04u
M1093 U363/net4 U363/net10 U363/net14 VDD pmos W=0.255u L=0.04u
M1094 U363/net6 n324 U363/net14 VDD pmos W=0.28u L=0.04u
M1095 U363/net4 G70 VDD VDD pmos W=0.205u L=0.04u
M1096 U363/net6 U363/net4 VDD VDD pmos W=0.24u L=0.04u
M1097 n323 U363/net14 VDD VDD pmos W=0.205u L=0.04u
M1098 U363/net10 n324 VDD VDD pmos W=0.205u L=0.04u
M1099 n324 G72 VSS VSS nmos W=0.155u L=0.04u
M1100 n324 G73 VSS VSS nmos W=0.155u L=0.04u
M1101 n324 G71 VSS VSS nmos W=0.155u L=0.04u
M1102 U364/net25 G72 VDD VDD pmos W=0.41u L=0.04u
M1103 U364/net28 G73 U364/net25 VDD pmos W=0.41u L=0.04u
M1104 n324 G71 U364/net28 VDD pmos W=0.41u L=0.04u
M1105 U365/net4 G67 U365/net14 VSS nmos W=0.155u L=0.04u
M1106 U365/net6 U365/net10 U365/net14 VSS nmos W=0.17u L=0.04u
M1107 U365/net4 G71 VSS VSS nmos W=0.155u L=0.04u
M1108 U365/net6 U365/net4 VSS VSS nmos W=0.17u L=0.04u
M1109 n322 U365/net14 VSS VSS nmos W=0.155u L=0.04u
M1110 U365/net10 G67 VSS VSS nmos W=0.155u L=0.04u
M1111 U365/net4 U365/net10 U365/net14 VDD pmos W=0.255u L=0.04u
M1112 U365/net6 G67 U365/net14 VDD pmos W=0.28u L=0.04u
M1113 U365/net4 G71 VDD VDD pmos W=0.205u L=0.04u
M1114 U365/net6 U365/net4 VDD VDD pmos W=0.24u L=0.04u
M1115 n322 U365/net14 VDD VDD pmos W=0.205u L=0.04u
M1116 U365/net10 G67 VDD VDD pmos W=0.205u L=0.04u
M1117 U366/net4 G72 U366/net14 VSS nmos W=0.155u L=0.04u
M1118 U366/net6 U366/net10 U366/net14 VSS nmos W=0.17u L=0.04u
M1119 U366/net4 G68 VSS VSS nmos W=0.155u L=0.04u
M1120 U366/net6 U366/net4 VSS VSS nmos W=0.17u L=0.04u
M1121 n321 U366/net14 VSS VSS nmos W=0.155u L=0.04u
M1122 U366/net10 G72 VSS VSS nmos W=0.155u L=0.04u
M1123 U366/net4 U366/net10 U366/net14 VDD pmos W=0.255u L=0.04u
M1124 U366/net6 G72 U366/net14 VDD pmos W=0.28u L=0.04u
M1125 U366/net4 G68 VDD VDD pmos W=0.205u L=0.04u
M1126 U366/net6 U366/net4 VDD VDD pmos W=0.24u L=0.04u
M1127 n321 U366/net14 VDD VDD pmos W=0.205u L=0.04u
M1128 U366/net10 G72 VDD VDD pmos W=0.205u L=0.04u
M1129 U367/net4 U367/net10 U367/net14 VSS nmos W=0.155u L=0.04u
M1130 U367/net6 G73 U367/net14 VSS nmos W=0.155u L=0.04u
M1131 U367/net4 n310 VSS VSS nmos W=0.155u L=0.04u
M1132 U367/net6 U367/net4 VSS VSS nmos W=0.155u L=0.04u
M1133 n320 U367/net14 VSS VSS nmos W=0.155u L=0.04u
M1134 U367/net10 G73 VSS VSS nmos W=0.155u L=0.04u
M1135 U367/net4 G73 U367/net14 VDD pmos W=0.205u L=0.04u
M1136 U367/net6 U367/net10 U367/net14 VDD pmos W=0.205u L=0.04u
M1137 U367/net4 n310 VDD VDD pmos W=0.205u L=0.04u
M1138 U367/net6 U367/net4 VDD VDD pmos W=0.205u L=0.04u
M1139 n320 U367/net14 VDD VDD pmos W=0.205u L=0.04u
M1140 U367/net10 G73 VDD VDD pmos W=0.205u L=0.04u
M1141 n310 G69 VSS VSS nmos W=0.135u L=0.04u
M1142 n310 G69 VDD VDD pmos W=0.205u L=0.04u
M1143 U369/XU1-net6 n318 VSS VSS nmos W=0.155u L=0.04u
M1144 G439 n237 U369/XU1-net6 VSS nmos W=0.155u L=0.04u
M1145 G439 n318 VDD VDD pmos W=0.155u L=0.04u
M1146 G439 n237 VDD VDD pmos W=0.155u L=0.04u
M1147 n318 G63 VSS VSS nmos W=0.135u L=0.04u
M1148 n318 G63 VDD VDD pmos W=0.205u L=0.04u
M1149 n237 n283 VSS VSS nmos W=0.135u L=0.04u
M1150 n237 n283 VDD VDD pmos W=0.205u L=0.04u
M1151 U372/PG2 n302 VSS VSS nmos W=0.31u L=0.04u
M1152 U372/net55 G34 VSS VSS nmos W=0.31u L=0.04u
M1153 U372/net51 G92 VSS VSS nmos W=0.155u L=0.04u
M1154 U372/net53 G176 VSS VSS nmos W=0.155u L=0.04u
M1155 U372/net29 n232 VSS VSS nmos W=0.155u L=0.04u
M1156 U372/net53 U372/net51 U372/PG1 VSS nmos W=0.155u L=0.04u
M1157 U372/net55 G92 U372/PG1 VSS nmos W=0.21u L=0.04u
M1158 U372/PG2 n232 n283 VSS nmos W=0.22u L=0.04u
M1159 U372/PG1 U372/net29 n283 VSS nmos W=0.155u L=0.04u
M1160 U372/PG2 n302 VDD VDD pmos W=0.41u L=0.04u
M1161 U372/net55 G34 VDD VDD pmos W=0.41u L=0.04u
M1162 U372/net51 G92 VDD VDD pmos W=0.205u L=0.04u
M1163 U372/net53 G176 VDD VDD pmos W=0.28u L=0.04u
M1164 U372/net29 n232 VDD VDD pmos W=0.205u L=0.04u
M1165 U372/net53 G92 U372/PG1 VDD pmos W=0.27u L=0.04u
M1166 U372/net55 U372/net51 U372/PG1 VDD pmos W=0.285u L=0.04u
M1167 U372/PG2 U372/net29 n283 VDD pmos W=0.205u L=0.04u
M1168 U372/PG1 n232 n283 VDD pmos W=0.28u L=0.04u
M1169 n302 G38 VSS VSS nmos W=0.135u L=0.04u
M1170 n302 G38 VDD VDD pmos W=0.205u L=0.04u
M1171 G428 n325 U374/net27 VSS nmos W=0.155u L=0.04u
M1172 U374/net27 n326 VSS VSS nmos W=0.155u L=0.04u
M1173 G428 n269 VSS VSS nmos W=0.155u L=0.04u
M1174 G428 n326 U374/net13 VDD pmos W=0.205u L=0.04u
M1175 U374/net13 n269 VDD VDD pmos W=0.205u L=0.04u
M1176 G428 n325 U374/net13 VDD pmos W=0.205u L=0.04u
M1177 n269 n325 VSS VSS nmos W=0.155u L=0.04u
M1178 n269 n326 VSS VSS nmos W=0.155u L=0.04u
M1179 U375/XI1-net8 n326 VDD VDD pmos W=0.205u L=0.04u
M1180 n269 n325 U375/XI1-net8 VDD pmos W=0.205u L=0.04u
M1181 n325 G62 VSS VSS nmos W=0.135u L=0.04u
M1182 n325 G62 VDD VDD pmos W=0.205u L=0.04u
M1183 G420 n327 U377/net14 VSS nmos W=0.155u L=0.04u
M1184 U377/net14 n330 VSS VSS nmos W=0.155u L=0.04u
M1185 U377/net14 n329 VSS VSS nmos W=0.155u L=0.04u
M1186 G420 n328 U377/net14 VSS nmos W=0.155u L=0.04u
M1187 G420 n253 U377/net14 VSS nmos W=0.155u L=0.04u
M1188 G420 n330 U377/XI16-net11 VDD pmos W=0.205u L=0.04u
M1189 U377/XI16-net11 n329 VDD VDD pmos W=0.205u L=0.04u
M1190 G420 n328 U377/XI15-net11 VDD pmos W=0.205u L=0.04u
M1191 U377/XI15-net11 n253 U377/XI15-net18 VDD pmos W=0.205u L=0.04u
M1192 U377/XI15-net18 n327 VDD VDD pmos W=0.205u L=0.04u
M1193 n330 G61 VSS VSS nmos W=0.135u L=0.04u
M1194 n330 G61 VDD VDD pmos W=0.205u L=0.04u
M1195 n329 n326 VSS VSS nmos W=0.155u L=0.04u
M1196 n329 n327 VSS VSS nmos W=0.155u L=0.04u
M1197 U379/XI1-net8 n327 VDD VDD pmos W=0.205u L=0.04u
M1198 n329 n326 U379/XI1-net8 VDD pmos W=0.205u L=0.04u
M1199 n253 n326 VSS VSS nmos W=0.135u L=0.04u
M1200 n253 n326 VDD VDD pmos W=0.205u L=0.04u
M1201 U381/XU1-net6 n254 VSS VSS nmos W=0.155u L=0.04u
M1202 n326 G61 U381/XU1-net6 VSS nmos W=0.155u L=0.04u
M1203 n326 n254 VDD VDD pmos W=0.155u L=0.04u
M1204 n326 G61 VDD VDD pmos W=0.155u L=0.04u
M1205 n327 G60 VSS VSS nmos W=0.135u L=0.04u
M1206 n327 G60 VDD VDD pmos W=0.205u L=0.04u
M1207 U383/net4 U383/net10 U383/net14 VSS nmos W=0.155u L=0.04u
M1208 U383/net6 G60 U383/net14 VSS nmos W=0.155u L=0.04u
M1209 U383/net4 n254 VSS VSS nmos W=0.155u L=0.04u
M1210 U383/net6 U383/net4 VSS VSS nmos W=0.155u L=0.04u
M1211 G417 U383/net14 VSS VSS nmos W=0.155u L=0.04u
M1212 U383/net10 G60 VSS VSS nmos W=0.155u L=0.04u
M1213 U383/net4 G60 U383/net14 VDD pmos W=0.205u L=0.04u
M1214 U383/net6 U383/net10 U383/net14 VDD pmos W=0.205u L=0.04u
M1215 U383/net4 n254 VDD VDD pmos W=0.205u L=0.04u
M1216 U383/net6 U383/net4 VDD VDD pmos W=0.205u L=0.04u
M1217 G417 U383/net14 VDD VDD pmos W=0.205u L=0.04u
M1218 U383/net10 G60 VDD VDD pmos W=0.205u L=0.04u
M1219 n254 n328 VSS VSS nmos W=0.135u L=0.04u
M1220 n254 n328 VDD VDD pmos W=0.205u L=0.04u
M1221 U385/XU1-net6 n331 VSS VSS nmos W=0.155u L=0.04u
M1222 n328 G53 U385/XU1-net6 VSS nmos W=0.155u L=0.04u
M1223 n328 n331 VDD VDD pmos W=0.155u L=0.04u
M1224 n328 G53 VDD VDD pmos W=0.155u L=0.04u
M1225 U386/net14 n255 U386/net20 VSS nmos W=0.155u L=0.04u
M1226 U386/net14 G59 U386/net20 VSS nmos W=0.155u L=0.04u
M1227 U386/net20 n315 VSS VSS nmos W=0.155u L=0.04u
M1228 G409 U386/net14 VSS VSS nmos W=0.155u L=0.04u
M1229 G409 U386/net14 VDD VDD pmos W=0.205u L=0.04u
M1230 U386/net14 n315 VDD VDD pmos W=0.205u L=0.04u
M1231 U386/net24 n255 VDD VDD pmos W=0.205u L=0.04u
M1232 U386/net14 G59 U386/net24 VDD pmos W=0.205u L=0.04u
M1233 G401 U387/net27 VDD VDD pmos W=0.205u L=0.04u
M1234 U387/net27 G57 U387/net23 VDD pmos W=0.205u L=0.04u
M1235 U387/net27 n333 U387/net23 VDD pmos W=0.205u L=0.04u
M1236 U387/net27 n332 U387/net23 VDD pmos W=0.205u L=0.04u
M1237 U387/net23 n334 VDD VDD pmos W=0.205u L=0.04u
M1238 U387/net23 G58 VDD VDD pmos W=0.205u L=0.04u
M1239 G401 U387/net27 VSS VSS nmos W=0.155u L=0.04u
M1240 U387/XI20-net13 n333 VSS VSS nmos W=0.155u L=0.04u
M1241 U387/net27 G57 U387/XI20-net17 VSS nmos W=0.155u L=0.04u
M1242 U387/XI20-net17 n332 U387/XI20-net13 VSS nmos W=0.155u L=0.04u
M1243 U387/net27 n334 U387/XI17-net17 VSS nmos W=0.155u L=0.04u
M1244 U387/XI17-net17 G58 VSS VSS nmos W=0.155u L=0.04u
M1245 U388/XU1-net6 G57 VSS VSS nmos W=0.155u L=0.04u
M1246 n334 n255 U388/XU1-net6 VSS nmos W=0.155u L=0.04u
M1247 n334 G57 VDD VDD pmos W=0.155u L=0.04u
M1248 n334 n255 VDD VDD pmos W=0.155u L=0.04u
M1249 U389/net4 U389/net10 U389/net14 VSS nmos W=0.155u L=0.04u
M1250 U389/net6 G57 U389/net14 VSS nmos W=0.155u L=0.04u
M1251 U389/net4 n333 VSS VSS nmos W=0.155u L=0.04u
M1252 U389/net6 U389/net4 VSS VSS nmos W=0.155u L=0.04u
M1253 G398 U389/net14 VSS VSS nmos W=0.155u L=0.04u
M1254 U389/net10 G57 VSS VSS nmos W=0.155u L=0.04u
M1255 U389/net4 G57 U389/net14 VDD pmos W=0.205u L=0.04u
M1256 U389/net6 U389/net10 U389/net14 VDD pmos W=0.205u L=0.04u
M1257 U389/net4 n333 VDD VDD pmos W=0.205u L=0.04u
M1258 U389/net6 U389/net4 VDD VDD pmos W=0.205u L=0.04u
M1259 G398 U389/net14 VDD VDD pmos W=0.205u L=0.04u
M1260 U389/net10 G57 VDD VDD pmos W=0.205u L=0.04u
M1261 U390/net4 U390/net10 U390/net14 VSS nmos W=0.155u L=0.04u
M1262 U390/net6 n335 U390/net14 VSS nmos W=0.155u L=0.04u
M1263 U390/net4 G56 VSS VSS nmos W=0.155u L=0.04u
M1264 U390/net6 U390/net4 VSS VSS nmos W=0.155u L=0.04u
M1265 G388 U390/net14 VSS VSS nmos W=0.155u L=0.04u
M1266 U390/net10 n335 VSS VSS nmos W=0.155u L=0.04u
M1267 U390/net4 n335 U390/net14 VDD pmos W=0.205u L=0.04u
M1268 U390/net6 U390/net10 U390/net14 VDD pmos W=0.205u L=0.04u
M1269 U390/net4 G56 VDD VDD pmos W=0.205u L=0.04u
M1270 U390/net6 U390/net4 VDD VDD pmos W=0.205u L=0.04u
M1271 G388 U390/net14 VDD VDD pmos W=0.205u L=0.04u
M1272 U390/net10 n335 VDD VDD pmos W=0.205u L=0.04u
M1273 G385 n336 U391/net27 VSS nmos W=0.155u L=0.04u
M1274 U391/net27 n337 VSS VSS nmos W=0.155u L=0.04u
M1275 G385 n335 VSS VSS nmos W=0.155u L=0.04u
M1276 G385 n337 U391/net13 VDD pmos W=0.205u L=0.04u
M1277 U391/net13 n335 VDD VDD pmos W=0.205u L=0.04u
M1278 G385 n336 U391/net13 VDD pmos W=0.205u L=0.04u
M1279 n335 n336 VSS VSS nmos W=0.155u L=0.04u
M1280 n335 n337 VSS VSS nmos W=0.155u L=0.04u
M1281 U392/XI1-net8 n337 VDD VDD pmos W=0.205u L=0.04u
M1282 n335 n336 U392/XI1-net8 VDD pmos W=0.205u L=0.04u
M1283 n336 G55 VSS VSS nmos W=0.135u L=0.04u
M1284 n336 G55 VDD VDD pmos W=0.205u L=0.04u
M1285 U394/net4 U394/net10 U394/net14 VSS nmos W=0.155u L=0.04u
M1286 U394/net6 n338 U394/net14 VSS nmos W=0.155u L=0.04u
M1287 U394/net4 G54 VSS VSS nmos W=0.155u L=0.04u
M1288 U394/net6 U394/net4 VSS VSS nmos W=0.155u L=0.04u
M1289 G380 U394/net14 VSS VSS nmos W=0.155u L=0.04u
M1290 U394/net10 n338 VSS VSS nmos W=0.155u L=0.04u
M1291 U394/net4 n338 U394/net14 VDD pmos W=0.205u L=0.04u
M1292 U394/net6 U394/net10 U394/net14 VDD pmos W=0.205u L=0.04u
M1293 U394/net4 G54 VDD VDD pmos W=0.205u L=0.04u
M1294 U394/net6 U394/net4 VDD VDD pmos W=0.205u L=0.04u
M1295 G380 U394/net14 VDD VDD pmos W=0.205u L=0.04u
M1296 U394/net10 n338 VDD VDD pmos W=0.205u L=0.04u
M1297 U395/net4 U395/net10 U395/net14 VSS nmos W=0.155u L=0.04u
M1298 U395/net6 G53 U395/net14 VSS nmos W=0.155u L=0.04u
M1299 U395/net4 n339 VSS VSS nmos W=0.155u L=0.04u
M1300 U395/net6 U395/net4 VSS VSS nmos W=0.155u L=0.04u
M1301 G369 U395/net14 VSS VSS nmos W=0.155u L=0.04u
M1302 U395/net10 G53 VSS VSS nmos W=0.155u L=0.04u
M1303 U395/net4 G53 U395/net14 VDD pmos W=0.205u L=0.04u
M1304 U395/net6 U395/net10 U395/net14 VDD pmos W=0.205u L=0.04u
M1305 U395/net4 n339 VDD VDD pmos W=0.205u L=0.04u
M1306 U395/net6 U395/net4 VDD VDD pmos W=0.205u L=0.04u
M1307 G369 U395/net14 VDD VDD pmos W=0.205u L=0.04u
M1308 U395/net10 G53 VDD VDD pmos W=0.205u L=0.04u
M1309 G366 n340 U396/net27 VSS nmos W=0.155u L=0.04u
M1310 U396/net27 n341 VSS VSS nmos W=0.155u L=0.04u
M1311 G366 n339 VSS VSS nmos W=0.155u L=0.04u
M1312 G366 n341 U396/net13 VDD pmos W=0.205u L=0.04u
M1313 U396/net13 n339 VDD VDD pmos W=0.205u L=0.04u
M1314 G366 n340 U396/net13 VDD pmos W=0.205u L=0.04u
M1315 U397/net7 G51 U397/X_u4-net10 VSS nmos W=0.155u L=0.04u
M1316 U397/X_u4-net10 n331 U397/X_u4-net13 VSS nmos W=0.155u L=0.04u
M1317 U397/X_u4-net13 G52 VSS VSS nmos W=0.155u L=0.04u
M1318 n339 U397/net7 VSS VSS nmos W=0.155u L=0.04u
M1319 U397/net7 G52 VDD VDD pmos W=0.205u L=0.04u
M1320 U397/net7 G51 VDD VDD pmos W=0.205u L=0.04u
M1321 U397/net7 n331 VDD VDD pmos W=0.205u L=0.04u
M1322 n339 U397/net7 VDD VDD pmos W=0.205u L=0.04u
M1323 U398/XU1-net6 n331 VSS VSS nmos W=0.155u L=0.04u
M1324 n341 G51 U398/XU1-net6 VSS nmos W=0.155u L=0.04u
M1325 n341 n331 VDD VDD pmos W=0.155u L=0.04u
M1326 n341 G51 VDD VDD pmos W=0.155u L=0.04u
M1327 n340 G52 VSS VSS nmos W=0.135u L=0.04u
M1328 n340 G52 VDD VDD pmos W=0.205u L=0.04u
M1329 U400/net4 U400/net10 U400/net14 VSS nmos W=0.155u L=0.04u
M1330 U400/net6 n331 U400/net14 VSS nmos W=0.155u L=0.04u
M1331 U400/net4 G51 VSS VSS nmos W=0.155u L=0.04u
M1332 U400/net6 U400/net4 VSS VSS nmos W=0.155u L=0.04u
M1333 G361 U400/net14 VSS VSS nmos W=0.155u L=0.04u
M1334 U400/net10 n331 VSS VSS nmos W=0.155u L=0.04u
M1335 U400/net4 n331 U400/net14 VDD pmos W=0.205u L=0.04u
M1336 U400/net6 U400/net10 U400/net14 VDD pmos W=0.205u L=0.04u
M1337 U400/net4 G51 VDD VDD pmos W=0.205u L=0.04u
M1338 U400/net6 U400/net4 VDD VDD pmos W=0.205u L=0.04u
M1339 G361 U400/net14 VDD VDD pmos W=0.205u L=0.04u
M1340 U400/net10 n331 VDD VDD pmos W=0.205u L=0.04u
M1341 U401/XU1-net6 n315 VSS VSS nmos W=0.155u L=0.04u
M1342 n331 G91 U401/XU1-net6 VSS nmos W=0.155u L=0.04u
M1343 n331 n315 VDD VDD pmos W=0.155u L=0.04u
M1344 n331 G91 VDD VDD pmos W=0.155u L=0.04u
M1345 U402/XU1-net6 n255 VSS VSS nmos W=0.155u L=0.04u
M1346 n315 G59 U402/XU1-net6 VSS nmos W=0.155u L=0.04u
M1347 n315 n255 VDD VDD pmos W=0.155u L=0.04u
M1348 n315 G59 VDD VDD pmos W=0.155u L=0.04u
M1349 n255 n332 VSS VSS nmos W=0.135u L=0.04u
M1350 n255 n332 VDD VDD pmos W=0.205u L=0.04u
M1351 U404/XU1-net6 n333 VSS VSS nmos W=0.155u L=0.04u
M1352 n332 G58 U404/XU1-net6 VSS nmos W=0.155u L=0.04u
M1353 n332 n333 VDD VDD pmos W=0.155u L=0.04u
M1354 n332 G58 VDD VDD pmos W=0.155u L=0.04u
M1355 U405/net19 n232 VSS VSS nmos W=0.155u L=0.04u
M1356 n333 n232 U405/net40 VSS nmos W=0.155u L=0.04u
M1357 n333 U405/net19 U405/net36 VSS nmos W=0.155u L=0.04u
M1358 U405/net40 n342 VSS VSS nmos W=0.31u L=0.04u
M1359 U405/net36 n256 VSS VSS nmos W=0.155u L=0.04u
M1360 U405/net19 n232 VDD VDD pmos W=0.205u L=0.04u
M1361 n333 U405/net19 U405/net26 VDD pmos W=0.325u L=0.04u
M1362 U405/net26 n342 VDD VDD pmos W=0.41u L=0.04u
M1363 n333 n232 U405/net30 VDD pmos W=0.325u L=0.04u
M1364 U405/net30 n256 VDD VDD pmos W=0.205u L=0.04u
M1365 n232 n246 U406/net19 VDD pmos W=0.205u L=0.04u
M1366 n232 G16 U406/net19 VDD pmos W=0.205u L=0.04u
M1367 n232 n317 U406/net19 VDD pmos W=0.205u L=0.04u
M1368 U406/net19 n273 VDD VDD pmos W=0.205u L=0.04u
M1369 n232 n273 VSS VSS nmos W=0.155u L=0.04u
M1370 U406/XI20-net13 G16 VSS VSS nmos W=0.155u L=0.04u
M1371 n232 n246 U406/XI20-net17 VSS nmos W=0.155u L=0.04u
M1372 U406/XI20-net17 n317 U406/XI20-net13 VSS nmos W=0.155u L=0.04u
M1373 n273 G90 VSS VSS nmos W=0.135u L=0.04u
M1374 n273 G90 VDD VDD pmos W=0.205u L=0.04u
M1375 n317 G66 VSS VSS nmos W=0.135u L=0.04u
M1376 n317 G66 VDD VDD pmos W=0.205u L=0.04u
M1377 n246 n287 VSS VSS nmos W=0.155u L=0.04u
M1378 n246 G83 VSS VSS nmos W=0.155u L=0.04u
M1379 U409/XI1-net8 G83 VDD VDD pmos W=0.205u L=0.04u
M1380 n246 n287 U409/XI1-net8 VDD pmos W=0.205u L=0.04u
M1381 n287 n343 U410/XI0-net10 VSS nmos W=0.155u L=0.04u
M1382 U410/XI0-net10 n344 U410/XI0-net13 VSS nmos W=0.155u L=0.04u
M1383 U410/XI0-net13 n345 VSS VSS nmos W=0.155u L=0.04u
M1384 n287 n345 VDD VDD pmos W=0.205u L=0.04u
M1385 n287 n343 VDD VDD pmos W=0.205u L=0.04u
M1386 n287 n344 VDD VDD pmos W=0.205u L=0.04u
M1387 U411/net11 G78 n345 VDD pmos W=0.205u L=0.04u
M1388 U411/net11 n346 n345 VDD pmos W=0.205u L=0.04u
M1389 U411/net11 n347 U411/XI16-net11 VDD pmos W=0.205u L=0.04u
M1390 U411/XI16-net11 n348 VDD VDD pmos W=0.205u L=0.04u
M1391 n345 n348 VSS VSS nmos W=0.155u L=0.04u
M1392 n345 n347 VSS VSS nmos W=0.155u L=0.04u
M1393 n345 G78 U411/XI12-net17 VSS nmos W=0.155u L=0.04u
M1394 U411/XI12-net17 n346 VSS VSS nmos W=0.155u L=0.04u
M1395 U412/net4 U412/net10 U412/net14 VSS nmos W=0.155u L=0.04u
M1396 U412/net6 G80 U412/net14 VSS nmos W=0.155u L=0.04u
M1397 U412/net4 G75 VSS VSS nmos W=0.155u L=0.04u
M1398 U412/net6 U412/net4 VSS VSS nmos W=0.155u L=0.04u
M1399 n348 U412/net14 VSS VSS nmos W=0.155u L=0.04u
M1400 U412/net10 G80 VSS VSS nmos W=0.155u L=0.04u
M1401 U412/net4 G80 U412/net14 VDD pmos W=0.205u L=0.04u
M1402 U412/net6 U412/net10 U412/net14 VDD pmos W=0.205u L=0.04u
M1403 U412/net4 G75 VDD VDD pmos W=0.205u L=0.04u
M1404 U412/net6 U412/net4 VDD VDD pmos W=0.205u L=0.04u
M1405 n348 U412/net14 VDD VDD pmos W=0.205u L=0.04u
M1406 U412/net10 G80 VDD VDD pmos W=0.205u L=0.04u
M1407 U413/net4 U413/net10 U413/net14 VSS nmos W=0.155u L=0.04u
M1408 U413/net6 G79 U413/net14 VSS nmos W=0.155u L=0.04u
M1409 U413/net4 G74 VSS VSS nmos W=0.155u L=0.04u
M1410 U413/net6 U413/net4 VSS VSS nmos W=0.155u L=0.04u
M1411 n347 U413/net14 VSS VSS nmos W=0.155u L=0.04u
M1412 U413/net10 G79 VSS VSS nmos W=0.155u L=0.04u
M1413 U413/net4 G79 U413/net14 VDD pmos W=0.205u L=0.04u
M1414 U413/net6 U413/net10 U413/net14 VDD pmos W=0.205u L=0.04u
M1415 U413/net4 G74 VDD VDD pmos W=0.205u L=0.04u
M1416 U413/net6 U413/net4 VDD VDD pmos W=0.205u L=0.04u
M1417 n347 U413/net14 VDD VDD pmos W=0.205u L=0.04u
M1418 U413/net10 G79 VDD VDD pmos W=0.205u L=0.04u
M1419 U414/net4 U414/net10 U414/net14 VSS nmos W=0.155u L=0.04u
M1420 U414/net6 n289 U414/net14 VSS nmos W=0.155u L=0.04u
M1421 U414/net4 G76 VSS VSS nmos W=0.155u L=0.04u
M1422 U414/net6 U414/net4 VSS VSS nmos W=0.155u L=0.04u
M1423 n344 U414/net14 VSS VSS nmos W=0.155u L=0.04u
M1424 U414/net10 n289 VSS VSS nmos W=0.155u L=0.04u
M1425 U414/net4 n289 U414/net14 VDD pmos W=0.205u L=0.04u
M1426 U414/net6 U414/net10 U414/net14 VDD pmos W=0.205u L=0.04u
M1427 U414/net4 G76 VDD VDD pmos W=0.205u L=0.04u
M1428 U414/net6 U414/net4 VDD VDD pmos W=0.205u L=0.04u
M1429 n344 U414/net14 VDD VDD pmos W=0.205u L=0.04u
M1430 U414/net10 n289 VDD VDD pmos W=0.205u L=0.04u
M1431 U415/net19 G82 VSS VSS nmos W=0.155u L=0.04u
M1432 n343 G82 U415/net40 VSS nmos W=0.155u L=0.04u
M1433 n343 U415/net19 U415/net36 VSS nmos W=0.155u L=0.04u
M1434 U415/net40 n350 VSS VSS nmos W=0.31u L=0.04u
M1435 U415/net36 n349 VSS VSS nmos W=0.155u L=0.04u
M1436 U415/net19 G82 VDD VDD pmos W=0.205u L=0.04u
M1437 n343 U415/net19 U415/net26 VDD pmos W=0.325u L=0.04u
M1438 U415/net26 n350 VDD VDD pmos W=0.41u L=0.04u
M1439 n343 G82 U415/net30 VDD pmos W=0.325u L=0.04u
M1440 U415/net30 n349 VDD VDD pmos W=0.205u L=0.04u
M1441 VSS n350 U416/net22 VSS nmos W=0.155u L=0.04u
M1442 U416/net22 n352 n349 VSS nmos W=0.155u L=0.04u
M1443 U416/net22 G79 n349 VSS nmos W=0.155u L=0.04u
M1444 U416/net22 n351 n349 VSS nmos W=0.155u L=0.04u
M1445 U416/net38 n351 VDD VDD pmos W=0.205u L=0.04u
M1446 U416/net35 G79 U416/net38 VDD pmos W=0.205u L=0.04u
M1447 n349 n352 U416/net35 VDD pmos W=0.205u L=0.04u
M1448 n349 n350 VDD VDD pmos W=0.205u L=0.04u
M1449 n350 G77 VSS VSS nmos W=0.135u L=0.04u
M1450 n350 G77 VDD VDD pmos W=0.205u L=0.04u
M1451 n352 n346 VSS VSS nmos W=0.135u L=0.04u
M1452 n352 n346 VDD VDD pmos W=0.205u L=0.04u
M1453 U419/p2 n290 VSS VSS nmos W=0.155u L=0.04u
M1454 U419/p0 n291 U419/p1 VSS nmos W=0.155u L=0.04u
M1455 U419/p1 n353 U419/p2 VSS nmos W=0.155u L=0.04u
M1456 n346 G78 U419/p0 VSS nmos W=0.155u L=0.04u
M1457 n346 n353 VDD VDD pmos W=0.205u L=0.04u
M1458 n346 n291 VDD VDD pmos W=0.205u L=0.04u
M1459 n346 G78 VDD VDD pmos W=0.205u L=0.04u
M1460 n346 n290 VDD VDD pmos W=0.205u L=0.04u
M1461 n353 G82 VSS VSS nmos W=0.155u L=0.04u
M1462 n353 G81 VSS VSS nmos W=0.155u L=0.04u
M1463 U420/XI1-net8 G81 VDD VDD pmos W=0.205u L=0.04u
M1464 n353 G82 U420/XI1-net8 VDD pmos W=0.205u L=0.04u
M1465 n291 G79 VSS VSS nmos W=0.135u L=0.04u
M1466 n291 G79 VDD VDD pmos W=0.205u L=0.04u
M1467 U422/XU1-net6 n289 VSS VSS nmos W=0.155u L=0.04u
M1468 n351 n290 U422/XU1-net6 VSS nmos W=0.155u L=0.04u
M1469 n351 n289 VDD VDD pmos W=0.155u L=0.04u
M1470 n351 n290 VDD VDD pmos W=0.155u L=0.04u
M1471 n289 G81 VSS VSS nmos W=0.135u L=0.04u
M1472 n289 G81 VDD VDD pmos W=0.205u L=0.04u
M1473 n290 G80 VSS VSS nmos W=0.135u L=0.04u
M1474 n290 G80 VDD VDD pmos W=0.205u L=0.04u
M1475 U425/XU1-net6 n301 VSS VSS nmos W=0.155u L=0.04u
M1476 n342 G38 U425/XU1-net6 VSS nmos W=0.155u L=0.04u
M1477 n342 n301 VDD VDD pmos W=0.155u L=0.04u
M1478 n342 G38 VDD VDD pmos W=0.155u L=0.04u
M1479 n256 n338 VSS VSS nmos W=0.135u L=0.04u
M1480 n256 n338 VDD VDD pmos W=0.205u L=0.04u
M1481 U427/net19 n356 VSS VSS nmos W=0.155u L=0.04u
M1482 G322 n356 U427/net40 VSS nmos W=0.155u L=0.04u
M1483 G322 U427/net19 U427/net36 VSS nmos W=0.155u L=0.04u
M1484 U427/net40 n355 VSS VSS nmos W=0.31u L=0.04u
M1485 U427/net36 n354 VSS VSS nmos W=0.155u L=0.04u
M1486 U427/net19 n356 VDD VDD pmos W=0.205u L=0.04u
M1487 G322 U427/net19 U427/net26 VDD pmos W=0.325u L=0.04u
M1488 U427/net26 n355 VDD VDD pmos W=0.41u L=0.04u
M1489 G322 n356 U427/net30 VDD pmos W=0.325u L=0.04u
M1490 U427/net30 n354 VDD VDD pmos W=0.205u L=0.04u
M1491 U428/net19 n356 VSS VSS nmos W=0.155u L=0.04u
M1492 G316 n356 U428/net40 VSS nmos W=0.155u L=0.04u
M1493 G316 U428/net19 U428/net36 VSS nmos W=0.155u L=0.04u
M1494 U428/net40 n354 VSS VSS nmos W=0.31u L=0.04u
M1495 U428/net36 n357 VSS VSS nmos W=0.155u L=0.04u
M1496 U428/net19 n356 VDD VDD pmos W=0.205u L=0.04u
M1497 G316 U428/net19 U428/net26 VDD pmos W=0.325u L=0.04u
M1498 U428/net26 n354 VDD VDD pmos W=0.41u L=0.04u
M1499 G316 n356 U428/net30 VDD pmos W=0.325u L=0.04u
M1500 U428/net30 n357 VDD VDD pmos W=0.205u L=0.04u
M1501 U429/net19 n356 VSS VSS nmos W=0.155u L=0.04u
M1502 G310 n356 U429/net40 VSS nmos W=0.155u L=0.04u
M1503 G310 U429/net19 U429/net36 VSS nmos W=0.155u L=0.04u
M1504 U429/net40 n357 VSS VSS nmos W=0.31u L=0.04u
M1505 U429/net36 n358 VSS VSS nmos W=0.155u L=0.04u
M1506 U429/net19 n356 VDD VDD pmos W=0.205u L=0.04u
M1507 G310 U429/net19 U429/net26 VDD pmos W=0.325u L=0.04u
M1508 U429/net26 n357 VDD VDD pmos W=0.41u L=0.04u
M1509 G310 n356 U429/net30 VDD pmos W=0.325u L=0.04u
M1510 U429/net30 n358 VDD VDD pmos W=0.205u L=0.04u
M1511 G304 U430/net28 VSS VSS nmos W=0.155u L=0.04u
M1512 U430/net47 G12 VSS VSS nmos W=0.155u L=0.04u
M1513 U430/net28 U430/net6 U430/net47 VSS nmos W=0.155u L=0.04u
M1514 U430/net44 G47 VSS VSS nmos W=0.155u L=0.04u
M1515 U430/net28 n356 U430/net44 VSS nmos W=0.155u L=0.04u
M1516 U430/net6 n356 VSS VSS nmos W=0.155u L=0.04u
M1517 G304 U430/net28 VDD VDD pmos W=0.205u L=0.04u
M1518 VDD G12 U430/net47 VDD pmos W=0.205u L=0.04u
M1519 U430/net47 n356 U430/net28 VDD pmos W=0.205u L=0.04u
M1520 U430/net44 U430/net6 U430/net28 VDD pmos W=0.205u L=0.04u
M1521 VDD G47 U430/net44 VDD pmos W=0.205u L=0.04u
M1522 VDD n356 U430/net6 VDD pmos W=0.205u L=0.04u
M1523 n356 n251 U431/net27 VSS nmos W=0.155u L=0.04u
M1524 U431/net27 G56 VSS VSS nmos W=0.155u L=0.04u
M1525 n356 n234 VSS VSS nmos W=0.155u L=0.04u
M1526 n356 G56 U431/net13 VDD pmos W=0.205u L=0.04u
M1527 U431/net13 n234 VDD VDD pmos W=0.205u L=0.04u
M1528 n356 n251 U431/net13 VDD pmos W=0.205u L=0.04u
M1529 n234 G91 VSS VSS nmos W=0.135u L=0.04u
M1530 n234 G91 VDD VDD pmos W=0.205u L=0.04u
M1531 n251 n337 VSS VSS nmos W=0.135u L=0.04u
M1532 n251 n337 VDD VDD pmos W=0.205u L=0.04u
M1533 U434/XU1-net6 n338 VSS VSS nmos W=0.155u L=0.04u
M1534 n337 G54 U434/XU1-net6 VSS nmos W=0.155u L=0.04u
M1535 n337 n338 VDD VDD pmos W=0.155u L=0.04u
M1536 n337 G54 VDD VDD pmos W=0.155u L=0.04u
M1537 U435/net4 n359 U435/net14 VSS nmos W=0.155u L=0.04u
M1538 U435/net6 U435/net10 U435/net14 VSS nmos W=0.17u L=0.04u
M1539 U435/net4 G46 VSS VSS nmos W=0.155u L=0.04u
M1540 U435/net6 U435/net4 VSS VSS nmos W=0.17u L=0.04u
M1541 G256 U435/net14 VSS VSS nmos W=0.155u L=0.04u
M1542 U435/net10 n359 VSS VSS nmos W=0.155u L=0.04u
M1543 U435/net4 U435/net10 U435/net14 VDD pmos W=0.255u L=0.04u
M1544 U435/net6 n359 U435/net14 VDD pmos W=0.28u L=0.04u
M1545 U435/net4 G46 VDD VDD pmos W=0.205u L=0.04u
M1546 U435/net6 U435/net4 VDD VDD pmos W=0.24u L=0.04u
M1547 G256 U435/net14 VDD VDD pmos W=0.205u L=0.04u
M1548 U435/net10 n359 VDD VDD pmos W=0.205u L=0.04u
M1549 G253 n360 VSS VSS nmos W=0.155u L=0.04u
M1550 G253 U436/net4 VSS VSS nmos W=0.155u L=0.04u
M1551 U436/net4 n359 VSS VSS nmos W=0.155u L=0.04u
M1552 U436/XU1-net8 U436/net4 VDD VDD pmos W=0.205u L=0.04u
M1553 G253 n360 U436/XU1-net8 VDD pmos W=0.205u L=0.04u
M1554 U436/net4 n359 VDD VDD pmos W=0.205u L=0.04u
M1555 n360 n361 U437/net27 VSS nmos W=0.155u L=0.04u
M1556 U437/net27 G44 VSS VSS nmos W=0.155u L=0.04u
M1557 n360 G45 VSS VSS nmos W=0.155u L=0.04u
M1558 n360 G44 U437/net13 VDD pmos W=0.205u L=0.04u
M1559 U437/net13 G45 VDD VDD pmos W=0.205u L=0.04u
M1560 n360 n361 U437/net13 VDD pmos W=0.205u L=0.04u
M1561 n359 G45 U438/XI0-net10 VSS nmos W=0.155u L=0.04u
M1562 U438/XI0-net10 G44 U438/XI0-net13 VSS nmos W=0.155u L=0.04u
M1563 U438/XI0-net13 n361 VSS VSS nmos W=0.155u L=0.04u
M1564 n359 n361 VDD VDD pmos W=0.205u L=0.04u
M1565 n359 G45 VDD VDD pmos W=0.205u L=0.04u
M1566 n359 G44 VDD VDD pmos W=0.205u L=0.04u
M1567 U439/net4 U439/net10 U439/net14 VSS nmos W=0.155u L=0.04u
M1568 U439/net6 G44 U439/net14 VSS nmos W=0.155u L=0.04u
M1569 U439/net4 n361 VSS VSS nmos W=0.155u L=0.04u
M1570 U439/net6 U439/net4 VSS VSS nmos W=0.155u L=0.04u
M1571 G248 U439/net14 VSS VSS nmos W=0.155u L=0.04u
M1572 U439/net10 G44 VSS VSS nmos W=0.155u L=0.04u
M1573 U439/net4 G44 U439/net14 VDD pmos W=0.205u L=0.04u
M1574 U439/net6 U439/net10 U439/net14 VDD pmos W=0.205u L=0.04u
M1575 U439/net4 n361 VDD VDD pmos W=0.205u L=0.04u
M1576 U439/net6 U439/net4 VDD VDD pmos W=0.205u L=0.04u
M1577 G248 U439/net14 VDD VDD pmos W=0.205u L=0.04u
M1578 U439/net10 G44 VDD VDD pmos W=0.205u L=0.04u
M1579 G243 n361 VSS VSS nmos W=0.155u L=0.04u
M1580 G243 n362 VSS VSS nmos W=0.155u L=0.04u
M1581 U440/XI1-net8 n362 VDD VDD pmos W=0.205u L=0.04u
M1582 G243 n361 U440/XI1-net8 VDD pmos W=0.205u L=0.04u
M1583 U441/net11 n363 VSS VSS nmos W=0.155u L=0.04u
M1584 U441/net11 n364 VSS VSS nmos W=0.155u L=0.04u
M1585 n362 G43 VSS VSS nmos W=0.155u L=0.04u
M1586 n362 U441/net11 VSS VSS nmos W=0.155u L=0.04u
M1587 U441/XI1-net8 n364 VDD VDD pmos W=0.205u L=0.04u
M1588 U441/net11 n363 U441/XI1-net8 VDD pmos W=0.205u L=0.04u
M1589 U441/XU39-net8 U441/net11 VDD VDD pmos W=0.205u L=0.04u
M1590 n362 G43 U441/XU39-net8 VDD pmos W=0.205u L=0.04u
M1591 n361 n363 VSS VSS nmos W=0.155u L=0.04u
M1592 n361 n364 VSS VSS nmos W=0.155u L=0.04u
M1593 n361 n365 VSS VSS nmos W=0.155u L=0.04u
M1594 U442/net25 n363 VDD VDD pmos W=0.41u L=0.04u
M1595 U442/net28 n364 U442/net25 VDD pmos W=0.41u L=0.04u
M1596 n361 n365 U442/net28 VDD pmos W=0.41u L=0.04u
M1597 U443/net4 U443/net10 U443/net14 VSS nmos W=0.155u L=0.04u
M1598 U443/net6 n363 U443/net14 VSS nmos W=0.155u L=0.04u
M1599 U443/net4 n364 VSS VSS nmos W=0.155u L=0.04u
M1600 U443/net6 U443/net4 VSS VSS nmos W=0.155u L=0.04u
M1601 G238 U443/net14 VSS VSS nmos W=0.155u L=0.04u
M1602 U443/net10 n363 VSS VSS nmos W=0.155u L=0.04u
M1603 U443/net4 n363 U443/net14 VDD pmos W=0.205u L=0.04u
M1604 U443/net6 U443/net10 U443/net14 VDD pmos W=0.205u L=0.04u
M1605 U443/net4 n364 VDD VDD pmos W=0.205u L=0.04u
M1606 U443/net6 U443/net4 VDD VDD pmos W=0.205u L=0.04u
M1607 G238 U443/net14 VDD VDD pmos W=0.205u L=0.04u
M1608 U443/net10 n363 VDD VDD pmos W=0.205u L=0.04u
M1609 n364 G42 VSS VSS nmos W=0.135u L=0.04u
M1610 n364 G42 VDD VDD pmos W=0.205u L=0.04u
M1611 U445/XU1-net6 n211 VSS VSS nmos W=0.155u L=0.04u
M1612 n363 n366 U445/XU1-net6 VSS nmos W=0.155u L=0.04u
M1613 n363 n211 VDD VDD pmos W=0.155u L=0.04u
M1614 n363 n366 VDD VDD pmos W=0.155u L=0.04u
M1615 U446/net19 G701BF VSS VSS nmos W=0.155u L=0.04u
M1616 n211 G701BF U446/net40 VSS nmos W=0.155u L=0.04u
M1617 n211 U446/net19 U446/net36 VSS nmos W=0.155u L=0.04u
M1618 U446/net40 G23 VSS VSS nmos W=0.31u L=0.04u
M1619 U446/net36 n367 VSS VSS nmos W=0.155u L=0.04u
M1620 U446/net19 G701BF VDD VDD pmos W=0.205u L=0.04u
M1621 n211 U446/net19 U446/net26 VDD pmos W=0.325u L=0.04u
M1622 U446/net26 G23 VDD VDD pmos W=0.41u L=0.04u
M1623 n211 G701BF U446/net30 VDD pmos W=0.325u L=0.04u
M1624 U446/net30 n367 VDD VDD pmos W=0.205u L=0.04u
M1625 n367 N38 VSS VSS nmos W=0.135u L=0.04u
M1626 n367 N38 VDD VDD pmos W=0.205u L=0.04u
M1627 U448/net29 n368 VSS VSS nmos W=0.155u L=0.04u
M1628 N38 G22 U448/net29 VSS nmos W=0.155u L=0.04u
M1629 N38 G701BF U448/net23 VSS nmos W=0.155u L=0.04u
M1630 U448/net23 n366 VSS VSS nmos W=0.155u L=0.04u
M1631 U448/net20 n366 N38 VDD pmos W=0.205u L=0.04u
M1632 U448/net20 G701BF N38 VDD pmos W=0.205u L=0.04u
M1633 VDD G22 U448/net20 VDD pmos W=0.205u L=0.04u
M1634 VDD n368 U448/net20 VDD pmos W=0.205u L=0.04u
M1635 U449/p2 n357 VSS VSS nmos W=0.155u L=0.04u
M1636 U449/p0 n358 U449/p1 VSS nmos W=0.155u L=0.04u
M1637 U449/p1 n369 U449/p2 VSS nmos W=0.155u L=0.04u
M1638 n368 G701BF U449/p0 VSS nmos W=0.155u L=0.04u
M1639 n368 n369 VDD VDD pmos W=0.205u L=0.04u
M1640 n368 n358 VDD VDD pmos W=0.205u L=0.04u
M1641 n368 G701BF VDD VDD pmos W=0.205u L=0.04u
M1642 n368 n357 VDD VDD pmos W=0.205u L=0.04u
M1643 n369 G50 VSS VSS nmos W=0.155u L=0.04u
M1644 n369 G49 VSS VSS nmos W=0.155u L=0.04u
M1645 U450/XI1-net8 G49 VDD VDD pmos W=0.205u L=0.04u
M1646 n369 G50 U450/XI1-net8 VDD pmos W=0.205u L=0.04u
M1647 G701BF G15 VSS VSS nmos W=0.135u L=0.04u
M1648 G701BF G15 VDD VDD pmos W=0.205u L=0.04u
M1649 n366 n358 VSS VSS nmos W=0.155u L=0.04u
M1650 n366 n357 VSS VSS nmos W=0.155u L=0.04u
M1651 n366 n354 VSS VSS nmos W=0.155u L=0.04u
M1652 n366 n355 VSS VSS nmos W=0.155u L=0.04u
M1653 U452/net49 n357 U452/net52 VDD pmos W=0.41u L=0.04u
M1654 U452/net52 n358 VDD VDD pmos W=0.41u L=0.04u
M1655 U452/net46 n354 U452/net49 VDD pmos W=0.41u L=0.04u
M1656 n366 n355 U452/net46 VDD pmos W=0.41u L=0.04u
M1657 n358 G47 VSS VSS nmos W=0.135u L=0.04u
M1658 n358 G47 VDD VDD pmos W=0.205u L=0.04u
M1659 n357 G48 VSS VSS nmos W=0.135u L=0.04u
M1660 n357 G48 VDD VDD pmos W=0.205u L=0.04u
M1661 n354 G49 VSS VSS nmos W=0.135u L=0.04u
M1662 n354 G49 VDD VDD pmos W=0.205u L=0.04u
M1663 n355 G50 VSS VSS nmos W=0.135u L=0.04u
M1664 n355 G50 VDD VDD pmos W=0.205u L=0.04u
M1665 U457/net4 U457/net10 U457/net14 VSS nmos W=0.155u L=0.04u
M1666 U457/net6 n250 U457/net14 VSS nmos W=0.155u L=0.04u
M1667 U457/net4 G41 VSS VSS nmos W=0.155u L=0.04u
M1668 U457/net6 U457/net4 VSS VSS nmos W=0.155u L=0.04u
M1669 G219 U457/net14 VSS VSS nmos W=0.155u L=0.04u
M1670 U457/net10 n250 VSS VSS nmos W=0.155u L=0.04u
M1671 U457/net4 n250 U457/net14 VDD pmos W=0.205u L=0.04u
M1672 U457/net6 U457/net10 U457/net14 VDD pmos W=0.205u L=0.04u
M1673 U457/net4 G41 VDD VDD pmos W=0.205u L=0.04u
M1674 U457/net6 U457/net4 VDD VDD pmos W=0.205u L=0.04u
M1675 G219 U457/net14 VDD VDD pmos W=0.205u L=0.04u
M1676 U457/net10 n250 VDD VDD pmos W=0.205u L=0.04u
M1677 U458/net4 U458/net10 U458/net14 VSS nmos W=0.155u L=0.04u
M1678 U458/net6 G38 U458/net14 VSS nmos W=0.155u L=0.04u
M1679 U458/net4 n301 VSS VSS nmos W=0.155u L=0.04u
M1680 U458/net6 U458/net4 VSS VSS nmos W=0.155u L=0.04u
M1681 G199 U458/net14 VSS VSS nmos W=0.155u L=0.04u
M1682 U458/net10 G38 VSS VSS nmos W=0.155u L=0.04u
M1683 U458/net4 G38 U458/net14 VDD pmos W=0.205u L=0.04u
M1684 U458/net6 U458/net10 U458/net14 VDD pmos W=0.205u L=0.04u
M1685 U458/net4 n301 VDD VDD pmos W=0.205u L=0.04u
M1686 U458/net6 U458/net4 VDD VDD pmos W=0.205u L=0.04u
M1687 G199 U458/net14 VDD VDD pmos W=0.205u L=0.04u
M1688 U458/net10 G38 VDD VDD pmos W=0.205u L=0.04u
M1689 G194 n370 U459/net27 VSS nmos W=0.155u L=0.04u
M1690 U459/net27 n371 VSS VSS nmos W=0.155u L=0.04u
M1691 G194 n301 VSS VSS nmos W=0.155u L=0.04u
M1692 G194 n371 U459/net13 VDD pmos W=0.205u L=0.04u
M1693 U459/net13 n301 VDD VDD pmos W=0.205u L=0.04u
M1694 G194 n370 U459/net13 VDD pmos W=0.205u L=0.04u
M1695 n301 n370 VSS VSS nmos W=0.155u L=0.04u
M1696 n301 n371 VSS VSS nmos W=0.155u L=0.04u
M1697 U460/XI1-net8 n371 VDD VDD pmos W=0.205u L=0.04u
M1698 n301 n370 U460/XI1-net8 VDD pmos W=0.205u L=0.04u
M1699 n371 n248 VSS VSS nmos W=0.135u L=0.04u
M1700 n371 n248 VDD VDD pmos W=0.205u L=0.04u
M1701 n248 n247 U462/net27 VSS nmos W=0.155u L=0.04u
M1702 U462/net27 G91 VSS VSS nmos W=0.155u L=0.04u
M1703 n248 G36 VSS VSS nmos W=0.155u L=0.04u
M1704 n248 G91 U462/net13 VDD pmos W=0.205u L=0.04u
M1705 U462/net13 G36 VDD VDD pmos W=0.205u L=0.04u
M1706 n248 n247 U462/net13 VDD pmos W=0.205u L=0.04u
M1707 U463/XU1-net6 n250 VSS VSS nmos W=0.155u L=0.04u
M1708 n247 G41 U463/XU1-net6 VSS nmos W=0.155u L=0.04u
M1709 n247 n250 VDD VDD pmos W=0.155u L=0.04u
M1710 n247 G41 VDD VDD pmos W=0.155u L=0.04u
M1711 n250 n249 VSS VSS nmos W=0.155u L=0.04u
M1712 n250 G40 VSS VSS nmos W=0.155u L=0.04u
M1713 U464/XI1-net8 G40 VDD VDD pmos W=0.205u L=0.04u
M1714 n250 n249 U464/XI1-net8 VDD pmos W=0.205u L=0.04u
M1715 U465/net13 G39 VSS VSS nmos W=0.155u L=0.04u
M1716 U465/net16 U465/net13 VSS VSS nmos W=0.155u L=0.04u
M1717 n249 n338 U465/net16 VSS nmos W=0.155u L=0.04u
M1718 U465/net13 G39 VDD VDD pmos W=0.205u L=0.04u
M1719 VDD U465/net13 n249 VDD pmos W=0.205u L=0.04u
M1720 VDD n338 n249 VDD pmos W=0.205u L=0.04u
M1721 U466/XU1-net6 n259 VSS VSS nmos W=0.155u L=0.04u
M1722 n338 G92 U466/XU1-net6 VSS nmos W=0.155u L=0.04u
M1723 n338 n259 VDD VDD pmos W=0.155u L=0.04u
M1724 n338 G92 VDD VDD pmos W=0.155u L=0.04u
M1725 U467/XU1-net6 n258 VSS VSS nmos W=0.155u L=0.04u
M1726 n259 n257 U467/XU1-net6 VSS nmos W=0.155u L=0.04u
M1727 n259 n258 VDD VDD pmos W=0.155u L=0.04u
M1728 n259 n257 VDD VDD pmos W=0.155u L=0.04u
M1729 n258 G34 VSS VSS nmos W=0.135u L=0.04u
M1730 n258 G34 VDD VDD pmos W=0.205u L=0.04u
M1731 n257 U469/net6 VSS VSS nmos W=0.155u L=0.04u
M1732 U469/X_u2-net6 n372 VSS VSS nmos W=0.155u L=0.04u
M1733 U469/net6 G33 U469/X_u2-net6 VSS nmos W=0.155u L=0.04u
M1734 n257 U469/net6 VDD VDD pmos W=0.205u L=0.04u
M1735 U469/net6 n372 VDD VDD pmos W=0.205u L=0.04u
M1736 U469/net6 G33 VDD VDD pmos W=0.205u L=0.04u
M1737 n370 G37 VSS VSS nmos W=0.135u L=0.04u
M1738 n370 G37 VDD VDD pmos W=0.205u L=0.04u
M1739 G176 G35 VSS VSS nmos W=0.135u L=0.04u
M1740 G176 G35 VDD VDD pmos W=0.205u L=0.04u
M1741 U472/net4 U472/net10 U472/net14 VSS nmos W=0.155u L=0.04u
M1742 U472/net6 G33 U472/net14 VSS nmos W=0.155u L=0.04u
M1743 U472/net4 n372 VSS VSS nmos W=0.155u L=0.04u
M1744 U472/net6 U472/net4 VSS VSS nmos W=0.155u L=0.04u
M1745 G160 U472/net14 VSS VSS nmos W=0.155u L=0.04u
M1746 U472/net10 G33 VSS VSS nmos W=0.155u L=0.04u
M1747 U472/net4 G33 U472/net14 VDD pmos W=0.205u L=0.04u
M1748 U472/net6 U472/net10 U472/net14 VDD pmos W=0.205u L=0.04u
M1749 U472/net4 n372 VDD VDD pmos W=0.205u L=0.04u
M1750 U472/net6 U472/net4 VDD VDD pmos W=0.205u L=0.04u
M1751 G160 U472/net14 VDD VDD pmos W=0.205u L=0.04u
M1752 U472/net10 G33 VDD VDD pmos W=0.205u L=0.04u
M1753 G155 n373 U473/net27 VSS nmos W=0.155u L=0.04u
M1754 U473/net27 n374 VSS VSS nmos W=0.155u L=0.04u
M1755 G155 n372 VSS VSS nmos W=0.155u L=0.04u
M1756 G155 n374 U473/net13 VDD pmos W=0.205u L=0.04u
M1757 U473/net13 n372 VDD VDD pmos W=0.205u L=0.04u
M1758 G155 n373 U473/net13 VDD pmos W=0.205u L=0.04u
M1759 U474/net7 G31 U474/X_u4-net10 VSS nmos W=0.155u L=0.04u
M1760 U474/X_u4-net10 n375 U474/X_u4-net13 VSS nmos W=0.155u L=0.04u
M1761 U474/X_u4-net13 G32 VSS VSS nmos W=0.155u L=0.04u
M1762 n372 U474/net7 VSS VSS nmos W=0.155u L=0.04u
M1763 U474/net7 G32 VDD VDD pmos W=0.205u L=0.04u
M1764 U474/net7 G31 VDD VDD pmos W=0.205u L=0.04u
M1765 U474/net7 n375 VDD VDD pmos W=0.205u L=0.04u
M1766 n372 U474/net7 VDD VDD pmos W=0.205u L=0.04u
M1767 U475/XU1-net6 n375 VSS VSS nmos W=0.155u L=0.04u
M1768 n374 G31 U475/XU1-net6 VSS nmos W=0.155u L=0.04u
M1769 n374 n375 VDD VDD pmos W=0.155u L=0.04u
M1770 n374 G31 VDD VDD pmos W=0.155u L=0.04u
M1771 n373 G32 VSS VSS nmos W=0.135u L=0.04u
M1772 n373 G32 VDD VDD pmos W=0.205u L=0.04u
M1773 U477/net4 U477/net10 U477/net14 VSS nmos W=0.155u L=0.04u
M1774 U477/net6 n375 U477/net14 VSS nmos W=0.155u L=0.04u
M1775 U477/net4 G31 VSS VSS nmos W=0.155u L=0.04u
M1776 U477/net6 U477/net4 VSS VSS nmos W=0.155u L=0.04u
M1777 G150 U477/net14 VSS VSS nmos W=0.155u L=0.04u
M1778 U477/net10 n375 VSS VSS nmos W=0.155u L=0.04u
M1779 U477/net4 n375 U477/net14 VDD pmos W=0.205u L=0.04u
M1780 U477/net6 U477/net10 U477/net14 VDD pmos W=0.205u L=0.04u
M1781 U477/net4 G31 VDD VDD pmos W=0.205u L=0.04u
M1782 U477/net6 U477/net4 VDD VDD pmos W=0.205u L=0.04u
M1783 G150 U477/net14 VDD VDD pmos W=0.205u L=0.04u
M1784 U477/net10 n375 VDD VDD pmos W=0.205u L=0.04u
M1785 G145 n376 U478/net27 VSS nmos W=0.155u L=0.04u
M1786 U478/net27 n263 VSS VSS nmos W=0.155u L=0.04u
M1787 G145 n375 VSS VSS nmos W=0.155u L=0.04u
M1788 G145 n263 U478/net13 VDD pmos W=0.205u L=0.04u
M1789 U478/net13 n375 VDD VDD pmos W=0.205u L=0.04u
M1790 G145 n376 U478/net13 VDD pmos W=0.205u L=0.04u
M1791 n375 n376 VSS VSS nmos W=0.155u L=0.04u
M1792 n375 n263 VSS VSS nmos W=0.155u L=0.04u
M1793 U479/XI1-net8 n263 VDD VDD pmos W=0.205u L=0.04u
M1794 n375 n376 U479/XI1-net8 VDD pmos W=0.205u L=0.04u
M1795 n263 n261 U480/net15 VSS nmos W=0.155u L=0.04u
M1796 n263 n262 U480/net15 VSS nmos W=0.155u L=0.04u
M1797 U480/net15 n260 VSS VSS nmos W=0.155u L=0.04u
M1798 n263 n260 VDD VDD pmos W=0.205u L=0.04u
M1799 n263 n261 U480/XI16-net11 VDD pmos W=0.205u L=0.04u
M1800 U480/XI16-net11 n262 VDD VDD pmos W=0.205u L=0.04u
M1801 n260 G29 VSS VSS nmos W=0.135u L=0.04u
M1802 n260 G29 VDD VDD pmos W=0.205u L=0.04u
M1803 n262 G92 VSS VSS nmos W=0.135u L=0.04u
M1804 n262 G92 VDD VDD pmos W=0.205u L=0.04u
M1805 n261 n266 VSS VSS nmos W=0.155u L=0.04u
M1806 n261 U483/net4 VSS VSS nmos W=0.155u L=0.04u
M1807 U483/net4 G28 VSS VSS nmos W=0.155u L=0.04u
M1808 U483/XU1-net8 U483/net4 VDD VDD pmos W=0.205u L=0.04u
M1809 n261 n266 U483/XU1-net8 VDD pmos W=0.205u L=0.04u
M1810 U483/net4 G28 VDD VDD pmos W=0.205u L=0.04u
M1811 n376 G30 VSS VSS nmos W=0.135u L=0.04u
M1812 n376 G30 VDD VDD pmos W=0.205u L=0.04u
M1813 U485/net4 n266 U485/net14 VSS nmos W=0.155u L=0.04u
M1814 U485/net6 U485/net10 U485/net14 VSS nmos W=0.17u L=0.04u
M1815 U485/net4 G28 VSS VSS nmos W=0.155u L=0.04u
M1816 U485/net6 U485/net4 VSS VSS nmos W=0.17u L=0.04u
M1817 G130 U485/net14 VSS VSS nmos W=0.155u L=0.04u
M1818 U485/net10 n266 VSS VSS nmos W=0.155u L=0.04u
M1819 U485/net4 U485/net10 U485/net14 VDD pmos W=0.255u L=0.04u
M1820 U485/net6 n266 U485/net14 VDD pmos W=0.28u L=0.04u
M1821 U485/net4 G28 VDD VDD pmos W=0.205u L=0.04u
M1822 U485/net6 U485/net4 VDD VDD pmos W=0.24u L=0.04u
M1823 G130 U485/net14 VDD VDD pmos W=0.205u L=0.04u
M1824 U485/net10 n266 VDD VDD pmos W=0.205u L=0.04u
M1825 U486/XU1-net6 n265 VSS VSS nmos W=0.155u L=0.04u
M1826 n266 n264 U486/XU1-net6 VSS nmos W=0.155u L=0.04u
M1827 n266 n265 VDD VDD pmos W=0.155u L=0.04u
M1828 n266 n264 VDD VDD pmos W=0.155u L=0.04u
M1829 n265 G27 VSS VSS nmos W=0.135u L=0.04u
M1830 n265 G27 VDD VDD pmos W=0.205u L=0.04u
M1831 n264 U488/net6 VSS VSS nmos W=0.155u L=0.04u
M1832 U488/X_u2-net6 n377 VSS VSS nmos W=0.155u L=0.04u
M1833 U488/net6 G26 U488/X_u2-net6 VSS nmos W=0.155u L=0.04u
M1834 n264 U488/net6 VDD VDD pmos W=0.205u L=0.04u
M1835 U488/net6 n377 VDD VDD pmos W=0.205u L=0.04u
M1836 U488/net6 G26 VDD VDD pmos W=0.205u L=0.04u
M1837 U489/net4 U489/net10 U489/net14 VSS nmos W=0.155u L=0.04u
M1838 U489/net6 n377 U489/net14 VSS nmos W=0.155u L=0.04u
M1839 U489/net4 G26 VSS VSS nmos W=0.155u L=0.04u
M1840 U489/net6 U489/net4 VSS VSS nmos W=0.155u L=0.04u
M1841 G119 U489/net14 VSS VSS nmos W=0.155u L=0.04u
M1842 U489/net10 n377 VSS VSS nmos W=0.155u L=0.04u
M1843 U489/net4 n377 U489/net14 VDD pmos W=0.205u L=0.04u
M1844 U489/net6 U489/net10 U489/net14 VDD pmos W=0.205u L=0.04u
M1845 U489/net4 G26 VDD VDD pmos W=0.205u L=0.04u
M1846 U489/net6 U489/net4 VDD VDD pmos W=0.205u L=0.04u
M1847 G119 U489/net14 VDD VDD pmos W=0.205u L=0.04u
M1848 U489/net10 n377 VDD VDD pmos W=0.205u L=0.04u
M1849 G114 n378 U490/net27 VSS nmos W=0.155u L=0.04u
M1850 U490/net27 n267 VSS VSS nmos W=0.155u L=0.04u
M1851 G114 n377 VSS VSS nmos W=0.155u L=0.04u
M1852 G114 n267 U490/net13 VDD pmos W=0.205u L=0.04u
M1853 U490/net13 n377 VDD VDD pmos W=0.205u L=0.04u
M1854 G114 n378 U490/net13 VDD pmos W=0.205u L=0.04u
M1855 n377 n378 VSS VSS nmos W=0.155u L=0.04u
M1856 n377 n267 VSS VSS nmos W=0.155u L=0.04u
M1857 U491/XI1-net8 n267 VDD VDD pmos W=0.205u L=0.04u
M1858 n377 n378 U491/XI1-net8 VDD pmos W=0.205u L=0.04u
M1859 n267 U492/net7 VSS VSS nmos W=0.155u L=0.04u
M1860 U492/net7 n228 VSS VSS nmos W=0.155u L=0.04u
M1861 U492/net7 G24 VSS VSS nmos W=0.155u L=0.04u
M1862 n267 U492/net7 VDD VDD pmos W=0.205u L=0.04u
M1863 U492/X_u7-net8 G24 VDD VDD pmos W=0.205u L=0.04u
M1864 U492/net7 n228 U492/X_u7-net8 VDD pmos W=0.205u L=0.04u
M1865 U493/net17 n380 VSS VSS nmos W=0.155u L=0.04u
M1866 U493/net17 G46 VSS VSS nmos W=0.155u L=0.04u
M1867 U493/net63 n239 VSS VSS nmos W=0.155u L=0.04u
M1868 n228 U493/net17 VSS VSS nmos W=0.155u L=0.04u
M1869 n228 n379 U493/net63 VSS nmos W=0.155u L=0.04u
M1870 n228 n239 U493/net31 VDD pmos W=0.205u L=0.04u
M1871 U493/net39 n380 VDD VDD pmos W=0.195u L=0.04u
M1872 U493/net31 U493/net17 VDD VDD pmos W=0.195u L=0.04u
M1873 n228 n379 U493/net31 VDD pmos W=0.195u L=0.04u
M1874 U493/net17 G46 U493/net39 VDD pmos W=0.195u L=0.04u
M1875 U494/net4 U494/net10 U494/net14 VSS nmos W=0.155u L=0.04u
M1876 U494/net6 n380 U494/net14 VSS nmos W=0.155u L=0.04u
M1877 U494/net4 G46 VSS VSS nmos W=0.155u L=0.04u
M1878 U494/net6 U494/net4 VSS VSS nmos W=0.155u L=0.04u
M1879 n239 U494/net14 VSS VSS nmos W=0.155u L=0.04u
M1880 U494/net10 n380 VSS VSS nmos W=0.155u L=0.04u
M1881 U494/net4 n380 U494/net14 VDD pmos W=0.205u L=0.04u
M1882 U494/net6 U494/net10 U494/net14 VDD pmos W=0.205u L=0.04u
M1883 U494/net4 G46 VDD VDD pmos W=0.205u L=0.04u
M1884 U494/net6 U494/net4 VDD VDD pmos W=0.205u L=0.04u
M1885 n239 U494/net14 VDD VDD pmos W=0.205u L=0.04u
M1886 U494/net10 n380 VDD VDD pmos W=0.205u L=0.04u
M1887 U495/net17 G90 VSS VSS nmos W=0.155u L=0.04u
M1888 U495/net17 G4 VSS VSS nmos W=0.155u L=0.04u
M1889 U495/net63 n381 VSS VSS nmos W=0.155u L=0.04u
M1890 n380 U495/net17 VSS VSS nmos W=0.155u L=0.04u
M1891 n380 G78 U495/net63 VSS nmos W=0.155u L=0.04u
M1892 n380 n381 U495/net31 VDD pmos W=0.205u L=0.04u
M1893 U495/net39 G90 VDD VDD pmos W=0.195u L=0.04u
M1894 U495/net31 U495/net17 VDD VDD pmos W=0.195u L=0.04u
M1895 n380 G78 U495/net31 VDD pmos W=0.195u L=0.04u
M1896 U495/net17 G4 U495/net39 VDD pmos W=0.195u L=0.04u
M1897 U496/net8 n242 U496/net26 VSS nmos W=0.155u L=0.04u
M1898 U496/net26 n383 VSS VSS nmos W=0.155u L=0.04u
M1899 U496/net29 U496/net8 VSS VSS nmos W=0.155u L=0.04u
M1900 U496/net29 n382 n379 VSS nmos W=0.155u L=0.04u
M1901 U496/net29 G45 n379 VSS nmos W=0.155u L=0.04u
M1902 U496/net8 n383 VDD VDD pmos W=0.205u L=0.04u
M1903 U496/net8 n242 VDD VDD pmos W=0.205u L=0.04u
M1904 n379 U496/net8 VDD VDD pmos W=0.205u L=0.04u
M1905 n379 n382 U496/net20 VDD pmos W=0.205u L=0.04u
M1906 U496/net20 G45 VDD VDD pmos W=0.205u L=0.04u
M1907 n383 G44 U497/net10 VSS nmos W=0.155u L=0.04u
M1908 U497/net10 n244 VSS VSS nmos W=0.155u L=0.04u
M1909 n383 n384 U497/net10 VSS nmos W=0.155u L=0.04u
M1910 U497/net10 n385 VSS VSS nmos W=0.155u L=0.04u
M1911 U497/net30 n244 VDD VDD pmos W=0.205u L=0.04u
M1912 n383 G44 U497/net24 VDD pmos W=0.205u L=0.04u
M1913 U497/net24 n384 VDD VDD pmos W=0.205u L=0.04u
M1914 n383 n385 U497/net30 VDD pmos W=0.205u L=0.04u
M1915 U498/net4 n384 U498/net14 VSS nmos W=0.155u L=0.04u
M1916 U498/net6 U498/net10 U498/net14 VSS nmos W=0.17u L=0.04u
M1917 U498/net4 G44 VSS VSS nmos W=0.155u L=0.04u
M1918 U498/net6 U498/net4 VSS VSS nmos W=0.17u L=0.04u
M1919 n244 U498/net14 VSS VSS nmos W=0.155u L=0.04u
M1920 U498/net10 n384 VSS VSS nmos W=0.155u L=0.04u
M1921 U498/net4 U498/net10 U498/net14 VDD pmos W=0.255u L=0.04u
M1922 U498/net6 n384 U498/net14 VDD pmos W=0.28u L=0.04u
M1923 U498/net4 G44 VDD VDD pmos W=0.205u L=0.04u
M1924 U498/net6 U498/net4 VDD VDD pmos W=0.24u L=0.04u
M1925 n244 U498/net14 VDD VDD pmos W=0.205u L=0.04u
M1926 U498/net10 n384 VDD VDD pmos W=0.205u L=0.04u
M1927 U499/net29 n365 VSS VSS nmos W=0.155u L=0.04u
M1928 n385 n387 U499/net29 VSS nmos W=0.155u L=0.04u
M1929 n385 n243 U499/net23 VSS nmos W=0.155u L=0.04u
M1930 U499/net23 n386 VSS VSS nmos W=0.155u L=0.04u
M1931 U499/net20 n386 n385 VDD pmos W=0.205u L=0.04u
M1932 U499/net20 n243 n385 VDD pmos W=0.205u L=0.04u
M1933 VDD n387 U499/net20 VDD pmos W=0.205u L=0.04u
M1934 VDD n365 U499/net20 VDD pmos W=0.205u L=0.04u
M1935 U500/XU1-net6 n238 VSS VSS nmos W=0.155u L=0.04u
M1936 n386 G42 U500/XU1-net6 VSS nmos W=0.155u L=0.04u
M1937 n386 n238 VDD VDD pmos W=0.155u L=0.04u
M1938 n386 G42 VDD VDD pmos W=0.155u L=0.04u
M1939 U501/net17 G90 VSS VSS nmos W=0.155u L=0.04u
M1940 U501/net17 G0 VSS VSS nmos W=0.155u L=0.04u
M1941 U501/net63 n381 VSS VSS nmos W=0.155u L=0.04u
M1942 n238 U501/net17 VSS VSS nmos W=0.155u L=0.04u
M1943 n238 G74 U501/net63 VSS nmos W=0.155u L=0.04u
M1944 n238 n381 U501/net31 VDD pmos W=0.205u L=0.04u
M1945 U501/net39 G90 VDD VDD pmos W=0.195u L=0.04u
M1946 U501/net31 U501/net17 VDD VDD pmos W=0.195u L=0.04u
M1947 n238 G74 U501/net31 VDD pmos W=0.195u L=0.04u
M1948 U501/net17 G0 U501/net39 VDD pmos W=0.195u L=0.04u
M1949 U502/net4 U502/net10 U502/net14 VSS nmos W=0.155u L=0.04u
M1950 U502/net6 n387 U502/net14 VSS nmos W=0.155u L=0.04u
M1951 U502/net4 n365 VSS VSS nmos W=0.155u L=0.04u
M1952 U502/net6 U502/net4 VSS VSS nmos W=0.155u L=0.04u
M1953 n243 U502/net14 VSS VSS nmos W=0.155u L=0.04u
M1954 U502/net10 n387 VSS VSS nmos W=0.155u L=0.04u
M1955 U502/net4 n387 U502/net14 VDD pmos W=0.205u L=0.04u
M1956 U502/net6 U502/net10 U502/net14 VDD pmos W=0.205u L=0.04u
M1957 U502/net4 n365 VDD VDD pmos W=0.205u L=0.04u
M1958 U502/net6 U502/net4 VDD VDD pmos W=0.205u L=0.04u
M1959 n243 U502/net14 VDD VDD pmos W=0.205u L=0.04u
M1960 U502/net10 n387 VDD VDD pmos W=0.205u L=0.04u
M1961 n365 G43 VSS VSS nmos W=0.135u L=0.04u
M1962 n365 G43 VDD VDD pmos W=0.205u L=0.04u
M1963 n387 G1 U504/net10 VSS nmos W=0.155u L=0.04u
M1964 U504/net10 n388 VSS VSS nmos W=0.155u L=0.04u
M1965 n387 G90 U504/net10 VSS nmos W=0.155u L=0.04u
M1966 U504/net10 n297 VSS VSS nmos W=0.155u L=0.04u
M1967 U504/net30 n388 VDD VDD pmos W=0.205u L=0.04u
M1968 n387 G1 U504/net24 VDD pmos W=0.205u L=0.04u
M1969 U504/net24 G90 VDD VDD pmos W=0.205u L=0.04u
M1970 n387 n297 U504/net30 VDD pmos W=0.205u L=0.04u
M1971 n297 G75 VSS VSS nmos W=0.135u L=0.04u
M1972 n297 G75 VDD VDD pmos W=0.205u L=0.04u
M1973 U506/net17 G90 VSS VSS nmos W=0.155u L=0.04u
M1974 U506/net17 G2 VSS VSS nmos W=0.155u L=0.04u
M1975 U506/net63 n381 VSS VSS nmos W=0.155u L=0.04u
M1976 n384 U506/net17 VSS VSS nmos W=0.155u L=0.04u
M1977 n384 G76 U506/net63 VSS nmos W=0.155u L=0.04u
M1978 n384 n381 U506/net31 VDD pmos W=0.205u L=0.04u
M1979 U506/net39 G90 VDD VDD pmos W=0.195u L=0.04u
M1980 U506/net31 U506/net17 VDD VDD pmos W=0.195u L=0.04u
M1981 n384 G76 U506/net31 VDD pmos W=0.195u L=0.04u
M1982 U506/net17 G2 U506/net39 VDD pmos W=0.195u L=0.04u
M1983 U507/net4 U507/net10 U507/net14 VSS nmos W=0.155u L=0.04u
M1984 U507/net6 n382 U507/net14 VSS nmos W=0.155u L=0.04u
M1985 U507/net4 G45 VSS VSS nmos W=0.155u L=0.04u
M1986 U507/net6 U507/net4 VSS VSS nmos W=0.155u L=0.04u
M1987 n242 U507/net14 VSS VSS nmos W=0.155u L=0.04u
M1988 U507/net10 n382 VSS VSS nmos W=0.155u L=0.04u
M1989 U507/net4 n382 U507/net14 VDD pmos W=0.205u L=0.04u
M1990 U507/net6 U507/net10 U507/net14 VDD pmos W=0.205u L=0.04u
M1991 U507/net4 G45 VDD VDD pmos W=0.205u L=0.04u
M1992 U507/net6 U507/net4 VDD VDD pmos W=0.205u L=0.04u
M1993 n242 U507/net14 VDD VDD pmos W=0.205u L=0.04u
M1994 U507/net10 n382 VDD VDD pmos W=0.205u L=0.04u
M1995 U508/net17 G90 VSS VSS nmos W=0.155u L=0.04u
M1996 U508/net17 G3 VSS VSS nmos W=0.155u L=0.04u
M1997 U508/net63 G77 VSS VSS nmos W=0.155u L=0.04u
M1998 n382 U508/net17 VSS VSS nmos W=0.155u L=0.04u
M1999 n382 n381 U508/net63 VSS nmos W=0.155u L=0.04u
M2000 n382 G77 U508/net31 VDD pmos W=0.205u L=0.04u
M2001 U508/net39 G90 VDD VDD pmos W=0.195u L=0.04u
M2002 U508/net31 U508/net17 VDD VDD pmos W=0.195u L=0.04u
M2003 n382 n381 U508/net31 VDD pmos W=0.195u L=0.04u
M2004 U508/net17 G3 U508/net39 VDD pmos W=0.195u L=0.04u
M2005 n381 n388 VSS VSS nmos W=0.135u L=0.04u
M2006 n381 n388 VDD VDD pmos W=0.205u L=0.04u
M2007 n388 n282 U510/XI0-net10 VSS nmos W=0.155u L=0.04u
M2008 U510/XI0-net10 n281 U510/XI0-net13 VSS nmos W=0.155u L=0.04u
M2009 U510/XI0-net13 G90 VSS VSS nmos W=0.155u L=0.04u
M2010 n388 G90 VDD VDD pmos W=0.205u L=0.04u
M2011 n388 n282 VDD VDD pmos W=0.205u L=0.04u
M2012 n388 n281 VDD VDD pmos W=0.205u L=0.04u
M2013 U511/XU1-net6 n279 VSS VSS nmos W=0.155u L=0.04u
M2014 n281 n389 U511/XU1-net6 VSS nmos W=0.155u L=0.04u
M2015 n281 n279 VDD VDD pmos W=0.155u L=0.04u
M2016 n281 n389 VDD VDD pmos W=0.155u L=0.04u
M2017 n279 G85 VSS VSS nmos W=0.135u L=0.04u
M2018 n279 G85 VDD VDD pmos W=0.205u L=0.04u
M2019 U513/net19 G90 VSS VSS nmos W=0.155u L=0.04u
M2020 n389 G90 U513/net40 VSS nmos W=0.155u L=0.04u
M2021 n389 U513/net19 U513/net36 VSS nmos W=0.155u L=0.04u
M2022 U513/net40 n319 VSS VSS nmos W=0.31u L=0.04u
M2023 U513/net36 G8 VSS VSS nmos W=0.155u L=0.04u
M2024 U513/net19 G90 VDD VDD pmos W=0.205u L=0.04u
M2025 n389 U513/net19 U513/net26 VDD pmos W=0.325u L=0.04u
M2026 U513/net26 n319 VDD VDD pmos W=0.41u L=0.04u
M2027 n389 G90 U513/net30 VDD pmos W=0.325u L=0.04u
M2028 U513/net30 G8 VDD VDD pmos W=0.205u L=0.04u
M2029 n319 G64 VSS VSS nmos W=0.135u L=0.04u
M2030 n319 G64 VDD VDD pmos W=0.205u L=0.04u
M2031 U515/XU1-net6 n280 VSS VSS nmos W=0.155u L=0.04u
M2032 n282 n390 U515/XU1-net6 VSS nmos W=0.155u L=0.04u
M2033 n282 n280 VDD VDD pmos W=0.155u L=0.04u
M2034 n282 n390 VDD VDD pmos W=0.155u L=0.04u
M2035 n280 G84 VSS VSS nmos W=0.135u L=0.04u
M2036 n280 G84 VDD VDD pmos W=0.205u L=0.04u
M2037 U517/net19 G90 VSS VSS nmos W=0.155u L=0.04u
M2038 n390 G90 U517/net40 VSS nmos W=0.155u L=0.04u
M2039 n390 U517/net19 U517/net36 VSS nmos W=0.155u L=0.04u
M2040 U517/net40 G64 VSS VSS nmos W=0.31u L=0.04u
M2041 U517/net36 n288 VSS VSS nmos W=0.155u L=0.04u
M2042 U517/net19 G90 VDD VDD pmos W=0.205u L=0.04u
M2043 n390 U517/net19 U517/net26 VDD pmos W=0.325u L=0.04u
M2044 U517/net26 G64 VDD VDD pmos W=0.41u L=0.04u
M2045 n390 G90 U517/net30 VDD pmos W=0.325u L=0.04u
M2046 U517/net30 n288 VDD VDD pmos W=0.205u L=0.04u
M2047 n288 G8 VSS VSS nmos W=0.135u L=0.04u
M2048 n288 G8 VDD VDD pmos W=0.205u L=0.04u
M2049 n378 G25 VSS VSS nmos W=0.135u L=0.04u
M2050 n378 G25 VDD VDD pmos W=0.205u L=0.04u
.ENDS
