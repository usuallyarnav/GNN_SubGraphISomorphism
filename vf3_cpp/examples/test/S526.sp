.SUBCKT s526 CK G0 G1 G23 G24 G25 G26 G2 G27 G28 VDD VSS
M1 NOR3_10/net7 n88 NOR3_10/X_u4-net10 VSS nmos W=0.31u L=0.04u
M2 NOR3_10/X_u4-net10 n87 NOR3_10/X_u4-net13 VSS nmos W=0.31u L=0.04u
M3 NOR3_10/X_u4-net13 n18 VSS VSS nmos W=0.31u L=0.04u
M4 G206 NOR3_10/net7 VSS VSS nmos W=0.31u L=0.04u
M5 NOR3_10/net7 n18 VDD VDD pmos W=0.41u L=0.04u
M6 NOR3_10/net7 n88 VDD VDD pmos W=0.41u L=0.04u
M7 NOR3_10/net7 n87 VDD VDD pmos W=0.41u L=0.04u
M8 G206 NOR3_10/net7 VDD VDD pmos W=0.41u L=0.04u
M9 NOR3_9/net7 n86 NOR3_9/X_u4-net10 VSS nmos W=0.31u L=0.04u
M10 NOR3_9/X_u4-net10 n85 NOR3_9/X_u4-net13 VSS nmos W=0.31u L=0.04u
M11 NOR3_9/X_u4-net13 n18 VSS VSS nmos W=0.31u L=0.04u
M12 G200 NOR3_9/net7 VSS VSS nmos W=0.31u L=0.04u
M13 NOR3_9/net7 n18 VDD VDD pmos W=0.41u L=0.04u
M14 NOR3_9/net7 n86 VDD VDD pmos W=0.41u L=0.04u
M15 NOR3_9/net7 n85 VDD VDD pmos W=0.41u L=0.04u
M16 G200 NOR3_9/net7 VDD VDD pmos W=0.41u L=0.04u
M17 G194 NOR2_15/net6 VSS VSS nmos W=0.31u L=0.04u
M18 NOR2_15/X_u2-net6 N21 VSS VSS nmos W=0.31u L=0.04u
M19 NOR2_15/net6 n77 NOR2_15/X_u2-net6 VSS nmos W=0.31u L=0.04u
M20 G194 NOR2_15/net6 VDD VDD pmos W=0.41u L=0.04u
M21 NOR2_15/net6 N21 VDD VDD pmos W=0.41u L=0.04u
M22 NOR2_15/net6 n77 VDD VDD pmos W=0.41u L=0.04u
M23 G188 NOR2_13/net6 VSS VSS nmos W=0.31u L=0.04u
M24 NOR2_13/X_u2-net6 n73 VSS VSS nmos W=0.31u L=0.04u
M25 NOR2_13/net6 n68 NOR2_13/X_u2-net6 VSS nmos W=0.31u L=0.04u
M26 G188 NOR2_13/net6 VDD VDD pmos W=0.41u L=0.04u
M27 NOR2_13/net6 n73 VDD VDD pmos W=0.41u L=0.04u
M28 NOR2_13/net6 n68 VDD VDD pmos W=0.41u L=0.04u
M29 G183 NOR2_11/net6 VSS VSS nmos W=0.31u L=0.04u
M30 NOR2_11/X_u2-net6 N19 VSS VSS nmos W=0.31u L=0.04u
M31 NOR2_11/net6 n70 NOR2_11/X_u2-net6 VSS nmos W=0.31u L=0.04u
M32 G183 NOR2_11/net6 VDD VDD pmos W=0.41u L=0.04u
M33 NOR2_11/net6 N19 VDD VDD pmos W=0.41u L=0.04u
M34 NOR2_11/net6 n70 VDD VDD pmos W=0.41u L=0.04u
M35 G179 NOR2_10/net6 VSS VSS nmos W=0.31u L=0.04u
M36 NOR2_10/X_u2-net6 N18 VSS VSS nmos W=0.31u L=0.04u
M37 NOR2_10/net6 n78 NOR2_10/X_u2-net6 VSS nmos W=0.31u L=0.04u
M38 G179 NOR2_10/net6 VDD VDD pmos W=0.41u L=0.04u
M39 NOR2_10/net6 N18 VDD VDD pmos W=0.41u L=0.04u
M40 NOR2_10/net6 n78 VDD VDD pmos W=0.41u L=0.04u
M41 NOR3_8/net7 n69 NOR3_8/X_u4-net10 VSS nmos W=0.31u L=0.04u
M42 NOR3_8/X_u4-net10 n16 NOR3_8/X_u4-net13 VSS nmos W=0.31u L=0.04u
M43 NOR3_8/X_u4-net13 N17 VSS VSS nmos W=0.31u L=0.04u
M44 G173 NOR3_8/net7 VSS VSS nmos W=0.31u L=0.04u
M45 NOR3_8/net7 N17 VDD VDD pmos W=0.41u L=0.04u
M46 NOR3_8/net7 n69 VDD VDD pmos W=0.41u L=0.04u
M47 NOR3_8/net7 n16 VDD VDD pmos W=0.41u L=0.04u
M48 G173 NOR3_8/net7 VDD VDD pmos W=0.41u L=0.04u
M49 NOR3_7/net7 n76 NOR3_7/X_u4-net10 VSS nmos W=0.31u L=0.04u
M50 NOR3_7/X_u4-net10 n75 NOR3_7/X_u4-net13 VSS nmos W=0.31u L=0.04u
M51 NOR3_7/X_u4-net13 n18 VSS VSS nmos W=0.31u L=0.04u
M52 G137 NOR3_7/net7 VSS VSS nmos W=0.31u L=0.04u
M53 NOR3_7/net7 n18 VDD VDD pmos W=0.41u L=0.04u
M54 NOR3_7/net7 n76 VDD VDD pmos W=0.41u L=0.04u
M55 NOR3_7/net7 n75 VDD VDD pmos W=0.41u L=0.04u
M56 G137 NOR3_7/net7 VDD VDD pmos W=0.41u L=0.04u
M57 NOR3_2/net7 n65 NOR3_2/X_u4-net10 VSS nmos W=0.31u L=0.04u
M58 NOR3_2/X_u4-net10 n56 NOR3_2/X_u4-net13 VSS nmos W=0.31u L=0.04u
M59 NOR3_2/X_u4-net13 n83 VSS VSS nmos W=0.31u L=0.04u
M60 G101 NOR3_2/net7 VSS VSS nmos W=0.31u L=0.04u
M61 NOR3_2/net7 n83 VDD VDD pmos W=0.41u L=0.04u
M62 NOR3_2/net7 n65 VDD VDD pmos W=0.41u L=0.04u
M63 NOR3_2/net7 n56 VDD VDD pmos W=0.41u L=0.04u
M64 G101 NOR3_2/net7 VDD VDD pmos W=0.41u L=0.04u
M65 NOR3_1/net7 n61 NOR3_1/X_u4-net10 VSS nmos W=0.31u L=0.04u
M66 NOR3_1/X_u4-net10 n57 NOR3_1/X_u4-net13 VSS nmos W=0.31u L=0.04u
M67 NOR3_1/X_u4-net13 N8 VSS VSS nmos W=0.31u L=0.04u
M68 G96 NOR3_1/net7 VSS VSS nmos W=0.31u L=0.04u
M69 NOR3_1/net7 N8 VDD VDD pmos W=0.41u L=0.04u
M70 NOR3_1/net7 n61 VDD VDD pmos W=0.41u L=0.04u
M71 NOR3_1/net7 n57 VDD VDD pmos W=0.41u L=0.04u
M72 G96 NOR3_1/net7 VDD VDD pmos W=0.41u L=0.04u
M73 NOR3_0/net7 n62 NOR3_0/X_u4-net10 VSS nmos W=0.31u L=0.04u
M74 NOR3_0/X_u4-net10 n58 NOR3_0/X_u4-net13 VSS nmos W=0.31u L=0.04u
M75 NOR3_0/X_u4-net13 n84 VSS VSS nmos W=0.31u L=0.04u
M76 G89 NOR3_0/net7 VSS VSS nmos W=0.31u L=0.04u
M77 NOR3_0/net7 n84 VDD VDD pmos W=0.41u L=0.04u
M78 NOR3_0/net7 n62 VDD VDD pmos W=0.41u L=0.04u
M79 NOR3_0/net7 n58 VDD VDD pmos W=0.41u L=0.04u
M80 G89 NOR3_0/net7 VDD VDD pmos W=0.41u L=0.04u
M81 G84 NOR2_3/net6 VSS VSS nmos W=0.31u L=0.04u
M82 NOR2_3/X_u2-net6 N7 VSS VSS nmos W=0.31u L=0.04u
M83 NOR2_3/net6 n59 NOR2_3/X_u2-net6 VSS nmos W=0.31u L=0.04u
M84 G84 NOR2_3/net6 VDD VDD pmos W=0.41u L=0.04u
M85 NOR2_3/net6 N7 VDD VDD pmos W=0.41u L=0.04u
M86 NOR2_3/net6 n59 VDD VDD pmos W=0.41u L=0.04u
M87 G60 NOR2_1/net6 VSS VSS nmos W=0.31u L=0.04u
M88 NOR2_1/X_u2-net6 n18 VSS VSS nmos W=0.31u L=0.04u
M89 NOR2_1/net6 N28 NOR2_1/X_u2-net6 VSS nmos W=0.31u L=0.04u
M90 G60 NOR2_1/net6 VDD VDD pmos W=0.41u L=0.04u
M91 NOR2_1/net6 n18 VDD VDD pmos W=0.41u L=0.04u
M92 NOR2_1/net6 N28 VDD VDD pmos W=0.41u L=0.04u
M93 G62 N1 VSS VSS nmos W=0.31u L=0.04u
M94 G62 N1 VDD VDD pmos W=0.41u L=0.04u
M95 G127 N12 VSS VSS nmos W=0.31u L=0.04u
M96 G127 N12 VDD VDD pmos W=0.41u L=0.04u
M97 G167 NOR4_7/net6 VSS VSS nmos W=0.31u L=0.04u
M98 NOR4_7/net6 n79 NOR4_7/XU30-net23 VSS nmos W=0.155u L=0.04u
M99 NOR4_7/XU30-net23 n72 NOR4_7/XU30-net26 VSS nmos W=0.155u L=0.04u
M100 NOR4_7/XU30-net26 n71 NOR4_7/XU30-net29 VSS nmos W=0.155u L=0.04u
M101 NOR4_7/XU30-net29 n74 VSS VSS nmos W=0.155u L=0.04u
M102 G167 NOR4_7/net6 VDD VDD pmos W=0.41u L=0.04u
M103 NOR4_7/net6 n74 VDD VDD pmos W=0.205u L=0.04u
M104 NOR4_7/net6 n71 VDD VDD pmos W=0.205u L=0.04u
M105 NOR4_7/net6 n72 VDD VDD pmos W=0.205u L=0.04u
M106 NOR4_7/net6 n79 VDD VDD pmos W=0.205u L=0.04u
M107 G61 NOR4_1/net6 VSS VSS nmos W=0.31u L=0.04u
M108 NOR4_1/net6 n64 NOR4_1/XU30-net23 VSS nmos W=0.155u L=0.04u
M109 NOR4_1/XU30-net23 n63 NOR4_1/XU30-net26 VSS nmos W=0.155u L=0.04u
M110 NOR4_1/XU30-net26 n67 NOR4_1/XU30-net29 VSS nmos W=0.155u L=0.04u
M111 NOR4_1/XU30-net29 n18 VSS VSS nmos W=0.155u L=0.04u
M112 G61 NOR4_1/net6 VDD VDD pmos W=0.41u L=0.04u
M113 NOR4_1/net6 n18 VDD VDD pmos W=0.205u L=0.04u
M114 NOR4_1/net6 n67 VDD VDD pmos W=0.205u L=0.04u
M115 NOR4_1/net6 n63 VDD VDD pmos W=0.205u L=0.04u
M116 NOR4_1/net6 n64 VDD VDD pmos W=0.205u L=0.04u
M117 G69 N4 VSS VSS nmos W=0.31u L=0.04u
M118 G69 N4 VDD VDD pmos W=0.41u L=0.04u
M119 G106 NOR4_5/net6 VSS VSS nmos W=0.31u L=0.04u
M120 NOR4_5/net6 n60 NOR4_5/XU30-net23 VSS nmos W=0.155u L=0.04u
M121 NOR4_5/XU30-net23 n55 NOR4_5/XU30-net26 VSS nmos W=0.155u L=0.04u
M122 NOR4_5/XU30-net26 n81 NOR4_5/XU30-net29 VSS nmos W=0.155u L=0.04u
M123 NOR4_5/XU30-net29 n82 VSS VSS nmos W=0.155u L=0.04u
M124 G106 NOR4_5/net6 VDD VDD pmos W=0.41u L=0.04u
M125 NOR4_5/net6 n82 VDD VDD pmos W=0.205u L=0.04u
M126 NOR4_5/net6 n81 VDD VDD pmos W=0.205u L=0.04u
M127 NOR4_5/net6 n55 VDD VDD pmos W=0.205u L=0.04u
M128 NOR4_5/net6 n60 VDD VDD pmos W=0.205u L=0.04u
M129 G79 NOR4_4/net6 VSS VSS nmos W=0.31u L=0.04u
M130 NOR4_4/net6 n11 NOR4_4/XU30-net23 VSS nmos W=0.155u L=0.04u
M131 NOR4_4/XU30-net23 n66 NOR4_4/XU30-net26 VSS nmos W=0.155u L=0.04u
M132 NOR4_4/XU30-net26 n14 NOR4_4/XU30-net29 VSS nmos W=0.155u L=0.04u
M133 NOR4_4/XU30-net29 n18 VSS VSS nmos W=0.155u L=0.04u
M134 G79 NOR4_4/net6 VDD VDD pmos W=0.41u L=0.04u
M135 NOR4_4/net6 n18 VDD VDD pmos W=0.205u L=0.04u
M136 NOR4_4/net6 n14 VDD VDD pmos W=0.205u L=0.04u
M137 NOR4_4/net6 n66 VDD VDD pmos W=0.205u L=0.04u
M138 NOR4_4/net6 n11 VDD VDD pmos W=0.205u L=0.04u
M139 G115 NOR4_6/net6 VSS VSS nmos W=0.31u L=0.04u
M140 NOR4_6/net6 n12 NOR4_6/XU30-net23 VSS nmos W=0.155u L=0.04u
M141 NOR4_6/XU30-net23 n54 NOR4_6/XU30-net26 VSS nmos W=0.155u L=0.04u
M142 NOR4_6/XU30-net26 n80 NOR4_6/XU30-net29 VSS nmos W=0.155u L=0.04u
M143 NOR4_6/XU30-net29 n18 VSS VSS nmos W=0.155u L=0.04u
M144 G115 NOR4_6/net6 VDD VDD pmos W=0.41u L=0.04u
M145 NOR4_6/net6 n18 VDD VDD pmos W=0.205u L=0.04u
M146 NOR4_6/net6 n80 VDD VDD pmos W=0.205u L=0.04u
M147 NOR4_6/net6 n54 VDD VDD pmos W=0.205u L=0.04u
M148 NOR4_6/net6 n12 VDD VDD pmos W=0.205u L=0.04u
M149 n88 U89/net7 VSS VSS nmos W=0.155u L=0.04u
M150 U89/net7 G1 VSS VSS nmos W=0.155u L=0.04u
M151 U89/net7 G30 VSS VSS nmos W=0.155u L=0.04u
M152 n88 U89/net7 VDD VDD pmos W=0.205u L=0.04u
M153 U89/X_u7-net8 G30 VDD VDD pmos W=0.205u L=0.04u
M154 U89/net7 G1 U89/X_u7-net8 VDD pmos W=0.205u L=0.04u
M155 U90/XU1-net6 G1 VSS VSS nmos W=0.155u L=0.04u
M156 n87 G30 U90/XU1-net6 VSS nmos W=0.155u L=0.04u
M157 n87 G1 VDD VDD pmos W=0.155u L=0.04u
M158 n87 G30 VDD VDD pmos W=0.155u L=0.04u
M159 n86 U91/net7 VSS VSS nmos W=0.155u L=0.04u
M160 U91/net7 G2 VSS VSS nmos W=0.155u L=0.04u
M161 U91/net7 G29 VSS VSS nmos W=0.155u L=0.04u
M162 n86 U91/net7 VDD VDD pmos W=0.205u L=0.04u
M163 U91/X_u7-net8 G29 VDD VDD pmos W=0.205u L=0.04u
M164 U91/net7 G2 U91/X_u7-net8 VDD pmos W=0.205u L=0.04u
M165 U92/XU1-net6 G2 VSS VSS nmos W=0.155u L=0.04u
M166 n85 G29 U92/XU1-net6 VSS nmos W=0.155u L=0.04u
M167 n85 G2 VDD VDD pmos W=0.155u L=0.04u
M168 n85 G29 VDD VDD pmos W=0.155u L=0.04u
M169 n83 G0 U93/net15 VSS nmos W=0.155u L=0.04u
M170 n83 n89 U93/net15 VSS nmos W=0.155u L=0.04u
M171 U93/net15 n90 VSS VSS nmos W=0.155u L=0.04u
M172 n83 n90 VDD VDD pmos W=0.205u L=0.04u
M173 n83 G0 U93/XI16-net11 VDD pmos W=0.205u L=0.04u
M174 U93/XI16-net11 n89 VDD VDD pmos W=0.205u L=0.04u
M175 n82 G0 U94/net10 VSS nmos W=0.155u L=0.04u
M176 U94/net10 n90 VSS VSS nmos W=0.155u L=0.04u
M177 n82 n91 U94/net10 VSS nmos W=0.155u L=0.04u
M178 U94/net10 n89 VSS VSS nmos W=0.155u L=0.04u
M179 U94/net30 n90 VDD VDD pmos W=0.205u L=0.04u
M180 n82 G0 U94/net24 VDD pmos W=0.205u L=0.04u
M181 U94/net24 n91 VDD VDD pmos W=0.205u L=0.04u
M182 n82 n89 U94/net30 VDD pmos W=0.205u L=0.04u
M183 n90 G16 U95/XI0-net10 VSS nmos W=0.155u L=0.04u
M184 U95/XI0-net10 n18 U95/XI0-net13 VSS nmos W=0.155u L=0.04u
M185 U95/XI0-net13 G17 VSS VSS nmos W=0.155u L=0.04u
M186 n90 G17 VDD VDD pmos W=0.205u L=0.04u
M187 n90 G16 VDD VDD pmos W=0.205u L=0.04u
M188 n90 n18 VDD VDD pmos W=0.205u L=0.04u
M189 U96/XU1-net6 n93 VSS VSS nmos W=0.155u L=0.04u
M190 n81 n92 U96/XU1-net6 VSS nmos W=0.155u L=0.04u
M191 n81 n93 VDD VDD pmos W=0.155u L=0.04u
M192 n81 n92 VDD VDD pmos W=0.155u L=0.04u
M193 U97/XU35-net6 n95 VSS VSS nmos W=0.155u L=0.04u
M194 U97/net5 n94 U97/XU35-net6 VSS nmos W=0.155u L=0.04u
M195 U97/XU36-net6 U97/net5 VSS VSS nmos W=0.155u L=0.04u
M196 n80 n96 U97/XU36-net6 VSS nmos W=0.155u L=0.04u
M197 U97/net5 n95 VDD VDD pmos W=0.205u L=0.04u
M198 U97/net5 n94 VDD VDD pmos W=0.205u L=0.04u
M199 n80 U97/net5 VDD VDD pmos W=0.205u L=0.04u
M200 n80 n96 VDD VDD pmos W=0.205u L=0.04u
M201 n79 U98/net7 VSS VSS nmos W=0.155u L=0.04u
M202 U98/net7 G23 VSS VSS nmos W=0.155u L=0.04u
M203 U98/net7 n97 VSS VSS nmos W=0.155u L=0.04u
M204 n79 U98/net7 VDD VDD pmos W=0.205u L=0.04u
M205 U98/X_u7-net8 n97 VDD VDD pmos W=0.205u L=0.04u
M206 U98/net7 G23 U98/X_u7-net8 VDD pmos W=0.205u L=0.04u
M207 n78 G13 U99/XI0-net10 VSS nmos W=0.155u L=0.04u
M208 U99/XI0-net10 n98 U99/XI0-net13 VSS nmos W=0.155u L=0.04u
M209 U99/XI0-net13 G21 VSS VSS nmos W=0.155u L=0.04u
M210 n78 G21 VDD VDD pmos W=0.205u L=0.04u
M211 n78 G13 VDD VDD pmos W=0.205u L=0.04u
M212 n78 n98 VDD VDD pmos W=0.205u L=0.04u
M213 n77 U100/net7 VSS VSS nmos W=0.155u L=0.04u
M214 U100/net7 G28 VSS VSS nmos W=0.155u L=0.04u
M215 U100/net7 n97 VSS VSS nmos W=0.155u L=0.04u
M216 n77 U100/net7 VDD VDD pmos W=0.205u L=0.04u
M217 U100/X_u7-net8 n97 VDD VDD pmos W=0.205u L=0.04u
M218 U100/net7 G28 U100/X_u7-net8 VDD pmos W=0.205u L=0.04u
M219 U101/XU1-net6 n99 VSS VSS nmos W=0.155u L=0.04u
M220 n72 n97 U101/XU1-net6 VSS nmos W=0.155u L=0.04u
M221 n72 n99 VDD VDD pmos W=0.155u L=0.04u
M222 n72 n97 VDD VDD pmos W=0.155u L=0.04u
M223 U102/net36 n74 U102/net24 VSS nmos W=0.155u L=0.04u
M224 U102/net24 n99 VSS VSS nmos W=0.155u L=0.04u
M225 n70 n97 U102/net36 VSS nmos W=0.155u L=0.04u
M226 n70 n100 U102/net36 VSS nmos W=0.155u L=0.04u
M227 n70 n100 U102/net35 VDD pmos W=0.205u L=0.04u
M228 U102/net35 n97 VDD VDD pmos W=0.205u L=0.04u
M229 n70 n99 VDD VDD pmos W=0.205u L=0.04u
M230 n70 n74 VDD VDD pmos W=0.205u L=0.04u
M231 U103/net19 n101 VSS VSS nmos W=0.155u L=0.04u
M232 n100 n101 U103/net40 VSS nmos W=0.155u L=0.04u
M233 n100 U103/net19 U103/net36 VSS nmos W=0.155u L=0.04u
M234 U103/net40 n96 VSS VSS nmos W=0.31u L=0.04u
M235 U103/net36 G26 VSS VSS nmos W=0.155u L=0.04u
M236 U103/net19 n101 VDD VDD pmos W=0.205u L=0.04u
M237 n100 U103/net19 U103/net26 VDD pmos W=0.325u L=0.04u
M238 U103/net26 n96 VDD VDD pmos W=0.41u L=0.04u
M239 n100 n101 U103/net30 VDD pmos W=0.325u L=0.04u
M240 U103/net30 G26 VDD VDD pmos W=0.205u L=0.04u
M241 U104/net13 G24 VSS VSS nmos W=0.155u L=0.04u
M242 U104/net16 U104/net13 VSS VSS nmos W=0.155u L=0.04u
M243 n69 G12 U104/net16 VSS nmos W=0.155u L=0.04u
M244 U104/net13 G24 VDD VDD pmos W=0.205u L=0.04u
M245 VDD U104/net13 n69 VDD pmos W=0.205u L=0.04u
M246 VDD G12 n69 VDD pmos W=0.205u L=0.04u
M247 n68 n97 U105/net15 VSS nmos W=0.155u L=0.04u
M248 n68 n102 U105/net15 VSS nmos W=0.155u L=0.04u
M249 U105/net15 n74 VSS VSS nmos W=0.155u L=0.04u
M250 n68 n74 VDD VDD pmos W=0.205u L=0.04u
M251 n68 n97 U105/XI16-net11 VDD pmos W=0.205u L=0.04u
M252 U105/XI16-net11 n102 VDD VDD pmos W=0.205u L=0.04u
M253 U106/net19 n71 VSS VSS nmos W=0.155u L=0.04u
M254 n102 n71 U106/net40 VSS nmos W=0.155u L=0.04u
M255 n102 U106/net19 U106/net36 VSS nmos W=0.155u L=0.04u
M256 U106/net40 G27 VSS VSS nmos W=0.31u L=0.04u
M257 U106/net36 n96 VSS VSS nmos W=0.155u L=0.04u
M258 U106/net19 n71 VDD VDD pmos W=0.205u L=0.04u
M259 n102 U106/net19 U106/net26 VDD pmos W=0.325u L=0.04u
M260 U106/net26 G27 VDD VDD pmos W=0.41u L=0.04u
M261 n102 n71 U106/net30 VDD pmos W=0.325u L=0.04u
M262 U106/net30 n96 VDD VDD pmos W=0.205u L=0.04u
M263 n67 U107/net7 VSS VSS nmos W=0.155u L=0.04u
M264 U107/net7 G11 VSS VSS nmos W=0.155u L=0.04u
M265 U107/net7 G10 VSS VSS nmos W=0.155u L=0.04u
M266 n67 U107/net7 VDD VDD pmos W=0.205u L=0.04u
M267 U107/X_u7-net8 G10 VDD VDD pmos W=0.205u L=0.04u
M268 U107/net7 G11 U107/X_u7-net8 VDD pmos W=0.205u L=0.04u
M269 U108/XU1-net6 N28 VSS VSS nmos W=0.155u L=0.04u
M270 n66 n103 U108/XU1-net6 VSS nmos W=0.155u L=0.04u
M271 n66 N28 VDD VDD pmos W=0.155u L=0.04u
M272 n66 n103 VDD VDD pmos W=0.155u L=0.04u
M273 U109/p2 n104 VSS VSS nmos W=0.155u L=0.04u
M274 U109/p0 G18 U109/p1 VSS nmos W=0.155u L=0.04u
M275 U109/p1 G16 U109/p2 VSS nmos W=0.155u L=0.04u
M276 n65 G17 U109/p0 VSS nmos W=0.155u L=0.04u
M277 n65 G16 VDD VDD pmos W=0.205u L=0.04u
M278 n65 G18 VDD VDD pmos W=0.205u L=0.04u
M279 n65 G17 VDD VDD pmos W=0.205u L=0.04u
M280 n65 n104 VDD VDD pmos W=0.205u L=0.04u
M281 n61 G17 U110/net15 VSS nmos W=0.155u L=0.04u
M282 n61 n95 U110/net15 VSS nmos W=0.155u L=0.04u
M283 U110/net15 n105 VSS VSS nmos W=0.155u L=0.04u
M284 n61 n105 VDD VDD pmos W=0.205u L=0.04u
M285 n61 G17 U110/XI16-net11 VDD pmos W=0.205u L=0.04u
M286 U110/XI16-net11 n95 VDD VDD pmos W=0.205u L=0.04u
M287 U111/XU1-net6 n105 VSS VSS nmos W=0.155u L=0.04u
M288 n60 n93 U111/XU1-net6 VSS nmos W=0.155u L=0.04u
M289 n60 n105 VDD VDD pmos W=0.155u L=0.04u
M290 n60 n93 VDD VDD pmos W=0.155u L=0.04u
M291 n105 n62 VSS VSS nmos W=0.135u L=0.04u
M292 n105 n62 VDD VDD pmos W=0.205u L=0.04u
M293 U113/XU1-net6 G16 VSS VSS nmos W=0.155u L=0.04u
M294 n62 n106 U113/XU1-net6 VSS nmos W=0.155u L=0.04u
M295 n62 G16 VDD VDD pmos W=0.155u L=0.04u
M296 n62 n106 VDD VDD pmos W=0.155u L=0.04u
M297 n93 U114/net28 VSS VSS nmos W=0.155u L=0.04u
M298 U114/net47 n107 VSS VSS nmos W=0.155u L=0.04u
M299 U114/net28 U114/net6 U114/net47 VSS nmos W=0.155u L=0.04u
M300 U114/net44 n108 VSS VSS nmos W=0.155u L=0.04u
M301 U114/net28 G18 U114/net44 VSS nmos W=0.155u L=0.04u
M302 U114/net6 G18 VSS VSS nmos W=0.155u L=0.04u
M303 n93 U114/net28 VDD VDD pmos W=0.205u L=0.04u
M304 VDD n107 U114/net47 VDD pmos W=0.205u L=0.04u
M305 U114/net47 G18 U114/net28 VDD pmos W=0.205u L=0.04u
M306 U114/net44 U114/net6 U114/net28 VDD pmos W=0.205u L=0.04u
M307 VDD n108 U114/net44 VDD pmos W=0.205u L=0.04u
M308 VDD G18 U114/net6 VDD pmos W=0.205u L=0.04u
M309 n108 n107 VSS VSS nmos W=0.155u L=0.04u
M310 n108 n91 VSS VSS nmos W=0.155u L=0.04u
M311 U115/XI1-net8 n91 VDD VDD pmos W=0.205u L=0.04u
M312 n108 n107 U115/XI1-net8 VDD pmos W=0.205u L=0.04u
M313 n59 U116/net7 VSS VSS nmos W=0.155u L=0.04u
M314 U116/net7 G15 VSS VSS nmos W=0.155u L=0.04u
M315 U116/net7 n109 VSS VSS nmos W=0.155u L=0.04u
M316 n59 U116/net7 VDD VDD pmos W=0.205u L=0.04u
M317 U116/X_u7-net8 n109 VDD VDD pmos W=0.205u L=0.04u
M318 U116/net7 G15 U116/X_u7-net8 VDD pmos W=0.205u L=0.04u
M319 U117/XU1-net6 n111 VSS VSS nmos W=0.155u L=0.04u
M320 n58 n110 U117/XU1-net6 VSS nmos W=0.155u L=0.04u
M321 n58 n111 VDD VDD pmos W=0.155u L=0.04u
M322 n58 n110 VDD VDD pmos W=0.155u L=0.04u
M323 U118/XU1-net6 n107 VSS VSS nmos W=0.155u L=0.04u
M324 n57 n110 U118/XU1-net6 VSS nmos W=0.155u L=0.04u
M325 n57 n107 VDD VDD pmos W=0.155u L=0.04u
M326 n57 n110 VDD VDD pmos W=0.155u L=0.04u
M327 n107 G17 VSS VSS nmos W=0.135u L=0.04u
M328 n107 G17 VDD VDD pmos W=0.205u L=0.04u
M329 U120/XU1-net6 n89 VSS VSS nmos W=0.155u L=0.04u
M330 n56 n110 U120/XU1-net6 VSS nmos W=0.155u L=0.04u
M331 n56 n89 VDD VDD pmos W=0.155u L=0.04u
M332 n56 n110 VDD VDD pmos W=0.155u L=0.04u
M333 n89 G18 VSS VSS nmos W=0.135u L=0.04u
M334 n89 G18 VDD VDD pmos W=0.205u L=0.04u
M335 U122/XU1-net6 n91 VSS VSS nmos W=0.155u L=0.04u
M336 n55 n110 U122/XU1-net6 VSS nmos W=0.155u L=0.04u
M337 n55 n91 VDD VDD pmos W=0.155u L=0.04u
M338 n55 n110 VDD VDD pmos W=0.155u L=0.04u
M339 U123/XU1-net6 n96 VSS VSS nmos W=0.155u L=0.04u
M340 n54 n110 U123/XU1-net6 VSS nmos W=0.155u L=0.04u
M341 n54 n96 VDD VDD pmos W=0.155u L=0.04u
M342 n54 n110 VDD VDD pmos W=0.155u L=0.04u
M343 n14 n112 VSS VSS nmos W=0.135u L=0.04u
M344 n14 n112 VDD VDD pmos W=0.205u L=0.04u
M345 n11 n109 VSS VSS nmos W=0.135u L=0.04u
M346 n11 n109 VDD VDD pmos W=0.205u L=0.04u
M347 N8 n95 U126/net27 VSS nmos W=0.155u L=0.04u
M348 U126/net27 n92 VSS VSS nmos W=0.155u L=0.04u
M349 N8 n113 VSS VSS nmos W=0.155u L=0.04u
M350 N8 n92 U126/net13 VDD pmos W=0.205u L=0.04u
M351 U126/net13 n113 VDD VDD pmos W=0.205u L=0.04u
M352 N8 n95 U126/net13 VDD pmos W=0.205u L=0.04u
M353 U127/net29 n18 VSS VSS nmos W=0.155u L=0.04u
M354 n113 n94 U127/net29 VSS nmos W=0.155u L=0.04u
M355 n113 n84 U127/net23 VSS nmos W=0.155u L=0.04u
M356 U127/net23 G17 VSS VSS nmos W=0.155u L=0.04u
M357 U127/net20 G17 n113 VDD pmos W=0.205u L=0.04u
M358 U127/net20 n84 n113 VDD pmos W=0.205u L=0.04u
M359 VDD n94 U127/net20 VDD pmos W=0.205u L=0.04u
M360 VDD n18 U127/net20 VDD pmos W=0.205u L=0.04u
M361 n84 n92 VSS VSS nmos W=0.155u L=0.04u
M362 n84 G0 VSS VSS nmos W=0.155u L=0.04u
M363 U128/XI1-net8 G0 VDD VDD pmos W=0.205u L=0.04u
M364 n84 n92 U128/XI1-net8 VDD pmos W=0.205u L=0.04u
M365 n92 n111 VSS VSS nmos W=0.155u L=0.04u
M366 n92 U129/net4 VSS VSS nmos W=0.155u L=0.04u
M367 U129/net4 G30 VSS VSS nmos W=0.155u L=0.04u
M368 U129/XU1-net8 U129/net4 VDD VDD pmos W=0.205u L=0.04u
M369 n92 n111 U129/XU1-net8 VDD pmos W=0.205u L=0.04u
M370 U129/net4 G30 VDD VDD pmos W=0.205u L=0.04u
M371 N7 G0 VSS VSS nmos W=0.155u L=0.04u
M372 N7 G15 U130/XI17-net17 VSS nmos W=0.155u L=0.04u
M373 U130/XI17-net17 n109 VSS VSS nmos W=0.155u L=0.04u
M374 N7 G10 U130/XI10-net17 VSS nmos W=0.155u L=0.04u
M375 U130/XI10-net17 n112 VSS VSS nmos W=0.155u L=0.04u
M376 U130/net30 G10 N7 VDD pmos W=0.205u L=0.04u
M377 U130/net30 n112 N7 VDD pmos W=0.205u L=0.04u
M378 VDD G0 U130/net36 VDD pmos W=0.205u L=0.04u
M379 U130/net36 n109 U130/net30 VDD pmos W=0.205u L=0.04u
M380 U130/net36 G15 U130/net30 VDD pmos W=0.205u L=0.04u
M381 n109 n103 VSS VSS nmos W=0.155u L=0.04u
M382 n109 n63 VSS VSS nmos W=0.155u L=0.04u
M383 U131/XI1-net8 n63 VDD VDD pmos W=0.205u L=0.04u
M384 n109 n103 U131/XI1-net8 VDD pmos W=0.205u L=0.04u
M385 U132/XU1-net6 G10 VSS VSS nmos W=0.155u L=0.04u
M386 n63 G11 U132/XU1-net6 VSS nmos W=0.155u L=0.04u
M387 n63 G10 VDD VDD pmos W=0.155u L=0.04u
M388 n63 G11 VDD VDD pmos W=0.155u L=0.04u
M389 n112 G11 VSS VSS nmos W=0.155u L=0.04u
M390 n112 G14 VSS VSS nmos W=0.155u L=0.04u
M391 U133/XI1-net8 G14 VDD VDD pmos W=0.205u L=0.04u
M392 n112 G11 U133/XI1-net8 VDD pmos W=0.205u L=0.04u
M393 N4 n114 U134/net23 VDD pmos W=0.205u L=0.04u
M394 N4 G13 U134/net23 VDD pmos W=0.205u L=0.04u
M395 N4 n18 U134/net23 VDD pmos W=0.205u L=0.04u
M396 U134/net23 n115 VDD VDD pmos W=0.205u L=0.04u
M397 U134/net23 n116 VDD VDD pmos W=0.205u L=0.04u
M398 U134/XI20-net13 G13 VSS VSS nmos W=0.155u L=0.04u
M399 N4 n114 U134/XI20-net17 VSS nmos W=0.155u L=0.04u
M400 U134/XI20-net17 n18 U134/XI20-net13 VSS nmos W=0.155u L=0.04u
M401 N4 n115 U134/XI17-net17 VSS nmos W=0.155u L=0.04u
M402 U134/XI17-net17 n116 VSS VSS nmos W=0.155u L=0.04u
M403 n18 G0 VSS VSS nmos W=0.135u L=0.04u
M404 n18 G0 VDD VDD pmos W=0.205u L=0.04u
M405 U136/XU1-net6 n118 VSS VSS nmos W=0.155u L=0.04u
M406 n114 n117 U136/XU1-net6 VSS nmos W=0.155u L=0.04u
M407 n114 n118 VDD VDD pmos W=0.155u L=0.04u
M408 n114 n117 VDD VDD pmos W=0.155u L=0.04u
M409 U137/net4 n101 U137/net14 VSS nmos W=0.155u L=0.04u
M410 U137/net6 U137/net10 U137/net14 VSS nmos W=0.17u L=0.04u
M411 U137/net4 n99 VSS VSS nmos W=0.155u L=0.04u
M412 U137/net6 U137/net4 VSS VSS nmos W=0.17u L=0.04u
M413 n117 U137/net14 VSS VSS nmos W=0.155u L=0.04u
M414 U137/net10 n101 VSS VSS nmos W=0.155u L=0.04u
M415 U137/net4 U137/net10 U137/net14 VDD pmos W=0.255u L=0.04u
M416 U137/net6 n101 U137/net14 VDD pmos W=0.28u L=0.04u
M417 U137/net4 n99 VDD VDD pmos W=0.205u L=0.04u
M418 U137/net6 U137/net4 VDD VDD pmos W=0.24u L=0.04u
M419 n117 U137/net14 VDD VDD pmos W=0.205u L=0.04u
M420 U137/net10 n101 VDD VDD pmos W=0.205u L=0.04u
M421 N28 G10 VSS VSS nmos W=0.135u L=0.04u
M422 N28 G10 VDD VDD pmos W=0.205u L=0.04u
M423 N21 n121 VSS VSS nmos W=0.155u L=0.04u
M424 N21 n120 VSS VSS nmos W=0.155u L=0.04u
M425 N21 n119 VSS VSS nmos W=0.155u L=0.04u
M426 N21 n116 VSS VSS nmos W=0.155u L=0.04u
M427 U139/net49 n120 U139/net52 VDD pmos W=0.41u L=0.04u
M428 U139/net52 n121 VDD VDD pmos W=0.41u L=0.04u
M429 U139/net46 n119 U139/net49 VDD pmos W=0.41u L=0.04u
M430 N21 n116 U139/net46 VDD pmos W=0.41u L=0.04u
M431 N19 n122 VSS VSS nmos W=0.155u L=0.04u
M432 N19 U140/net4 VSS VSS nmos W=0.155u L=0.04u
M433 U140/net4 n73 VSS VSS nmos W=0.155u L=0.04u
M434 U140/XU1-net8 U140/net4 VDD VDD pmos W=0.205u L=0.04u
M435 N19 n122 U140/XU1-net8 VDD pmos W=0.205u L=0.04u
M436 U140/net4 n73 VDD VDD pmos W=0.205u L=0.04u
M437 n122 n99 VSS VSS nmos W=0.155u L=0.04u
M438 n122 n97 VSS VSS nmos W=0.155u L=0.04u
M439 n122 n119 VSS VSS nmos W=0.155u L=0.04u
M440 n122 G26 VSS VSS nmos W=0.155u L=0.04u
M441 U141/net49 n97 U141/net52 VDD pmos W=0.41u L=0.04u
M442 U141/net52 n99 VDD VDD pmos W=0.41u L=0.04u
M443 U141/net46 n119 U141/net49 VDD pmos W=0.41u L=0.04u
M444 n122 G26 U141/net46 VDD pmos W=0.41u L=0.04u
M445 U142/XU1-net6 n119 VSS VSS nmos W=0.155u L=0.04u
M446 n73 G18 U142/XU1-net6 VSS nmos W=0.155u L=0.04u
M447 n73 n119 VDD VDD pmos W=0.155u L=0.04u
M448 n73 G18 VDD VDD pmos W=0.155u L=0.04u
M449 U143/net11 G12 N18 VDD pmos W=0.205u L=0.04u
M450 U143/net11 n98 N18 VDD pmos W=0.205u L=0.04u
M451 U143/net11 n123 U143/XI16-net11 VDD pmos W=0.205u L=0.04u
M452 U143/XI16-net11 n119 VDD VDD pmos W=0.205u L=0.04u
M453 N18 n119 VSS VSS nmos W=0.155u L=0.04u
M454 N18 n123 VSS VSS nmos W=0.155u L=0.04u
M455 N18 G12 U143/XI12-net17 VSS nmos W=0.155u L=0.04u
M456 U143/XI12-net17 n98 VSS VSS nmos W=0.155u L=0.04u
M457 U144/net13 n124 VSS VSS nmos W=0.155u L=0.04u
M458 U144/net16 U144/net13 VSS VSS nmos W=0.155u L=0.04u
M459 n123 n16 U144/net16 VSS nmos W=0.155u L=0.04u
M460 U144/net13 n124 VDD VDD pmos W=0.205u L=0.04u
M461 VDD U144/net13 n123 VDD pmos W=0.205u L=0.04u
M462 VDD n16 n123 VDD pmos W=0.205u L=0.04u
M463 n98 G25 VSS VSS nmos W=0.135u L=0.04u
M464 n98 G25 VDD VDD pmos W=0.205u L=0.04u
M465 U146/net11 n125 N17 VDD pmos W=0.205u L=0.04u
M466 U146/net11 G21 N17 VDD pmos W=0.205u L=0.04u
M467 U146/net11 n124 U146/XI16-net11 VDD pmos W=0.205u L=0.04u
M468 U146/XI16-net11 n119 VDD VDD pmos W=0.205u L=0.04u
M469 N17 n119 VSS VSS nmos W=0.155u L=0.04u
M470 N17 n124 VSS VSS nmos W=0.155u L=0.04u
M471 N17 n125 U146/XI12-net17 VSS nmos W=0.155u L=0.04u
M472 U146/XI12-net17 G21 VSS VSS nmos W=0.155u L=0.04u
M473 n119 n74 VSS VSS nmos W=0.135u L=0.04u
M474 n119 n74 VDD VDD pmos W=0.205u L=0.04u
M475 U148/XU1-net6 n75 VSS VSS nmos W=0.155u L=0.04u
M476 n74 n76 U148/XU1-net6 VSS nmos W=0.155u L=0.04u
M477 n74 n75 VDD VDD pmos W=0.155u L=0.04u
M478 n74 n76 VDD VDD pmos W=0.155u L=0.04u
M479 n75 U149/net26 VDD VDD pmos W=0.205u L=0.04u
M480 U149/net26 G29 U149/net19 VDD pmos W=0.205u L=0.04u
M481 U149/net26 n116 U149/net19 VDD pmos W=0.205u L=0.04u
M482 U149/net26 n126 U149/net19 VDD pmos W=0.205u L=0.04u
M483 U149/net19 G22 VDD VDD pmos W=0.205u L=0.04u
M484 U149/net26 G22 VSS VSS nmos W=0.155u L=0.04u
M485 n75 U149/net26 VSS VSS nmos W=0.155u L=0.04u
M486 U149/XI20-net13 n126 VSS VSS nmos W=0.155u L=0.04u
M487 U149/net26 G29 U149/XI20-net17 VSS nmos W=0.155u L=0.04u
M488 U149/XI20-net17 n116 U149/XI20-net13 VSS nmos W=0.155u L=0.04u
M489 n126 G21 VSS VSS nmos W=0.155u L=0.04u
M490 n126 G20 VSS VSS nmos W=0.155u L=0.04u
M491 U150/XI1-net8 G20 VDD VDD pmos W=0.205u L=0.04u
M492 n126 G21 U150/XI1-net8 VDD pmos W=0.205u L=0.04u
M493 U151/net14 G29 VSS VSS nmos W=0.155u L=0.04u
M494 U151/net14 n96 VSS VSS nmos W=0.155u L=0.04u
M495 U151/net14 n16 VSS VSS nmos W=0.155u L=0.04u
M496 U151/net14 G21 VSS VSS nmos W=0.155u L=0.04u
M497 n76 U151/net14 VSS VSS nmos W=0.155u L=0.04u
M498 U151/net14 G21 U151/XU8-net7 VDD pmos W=0.205u L=0.04u
M499 U151/XU8-net7 n16 U151/XU8-net10 VDD pmos W=0.205u L=0.04u
M500 U151/XU8-net10 n96 U151/XU8-net13 VDD pmos W=0.205u L=0.04u
M501 U151/XU8-net13 G29 VDD VDD pmos W=0.205u L=0.04u
M502 n76 U151/net14 VDD VDD pmos W=0.205u L=0.04u
M503 n16 n116 VSS VSS nmos W=0.135u L=0.04u
M504 n16 n116 VDD VDD pmos W=0.205u L=0.04u
M505 n116 n99 VSS VSS nmos W=0.155u L=0.04u
M506 n116 G13 VSS VSS nmos W=0.155u L=0.04u
M507 U153/XI1-net8 G13 VDD VDD pmos W=0.205u L=0.04u
M508 n116 n99 U153/XI1-net8 VDD pmos W=0.205u L=0.04u
M509 n96 G20 VSS VSS nmos W=0.135u L=0.04u
M510 n96 G20 VDD VDD pmos W=0.205u L=0.04u
M511 n124 n97 VSS VSS nmos W=0.155u L=0.04u
M512 n124 G20 VSS VSS nmos W=0.155u L=0.04u
M513 n124 n71 VSS VSS nmos W=0.155u L=0.04u
M514 U155/net25 n97 VDD VDD pmos W=0.41u L=0.04u
M515 U155/net28 G20 U155/net25 VDD pmos W=0.41u L=0.04u
M516 n124 n71 U155/net28 VDD pmos W=0.41u L=0.04u
M517 n97 G13 VSS VSS nmos W=0.135u L=0.04u
M518 n97 G13 VDD VDD pmos W=0.205u L=0.04u
M519 n71 n120 VSS VSS nmos W=0.135u L=0.04u
M520 n71 n120 VDD VDD pmos W=0.205u L=0.04u
M521 n120 G21 VSS VSS nmos W=0.155u L=0.04u
M522 n120 G12 VSS VSS nmos W=0.155u L=0.04u
M523 U158/XI1-net8 G12 VDD VDD pmos W=0.205u L=0.04u
M524 n120 G21 U158/XI1-net8 VDD pmos W=0.205u L=0.04u
M525 n125 G24 U159/net27 VSS nmos W=0.155u L=0.04u
M526 U159/net27 G13 VSS VSS nmos W=0.155u L=0.04u
M527 n125 n121 VSS VSS nmos W=0.155u L=0.04u
M528 n125 G13 U159/net13 VDD pmos W=0.205u L=0.04u
M529 U159/net13 n121 VDD VDD pmos W=0.205u L=0.04u
M530 n125 G24 U159/net13 VDD pmos W=0.205u L=0.04u
M531 n121 G20 VSS VSS nmos W=0.155u L=0.04u
M532 n121 G13 VSS VSS nmos W=0.155u L=0.04u
M533 U160/XI1-net8 G13 VDD VDD pmos W=0.205u L=0.04u
M534 n121 G20 U160/XI1-net8 VDD pmos W=0.205u L=0.04u
M535 U161/net19 n12 VSS VSS nmos W=0.155u L=0.04u
M536 N12 n12 U161/net40 VSS nmos W=0.155u L=0.04u
M537 N12 U161/net19 U161/net36 VSS nmos W=0.155u L=0.04u
M538 U161/net40 n128 VSS VSS nmos W=0.31u L=0.04u
M539 U161/net36 n127 VSS VSS nmos W=0.155u L=0.04u
M540 U161/net19 n12 VDD VDD pmos W=0.205u L=0.04u
M541 N12 U161/net19 U161/net26 VDD pmos W=0.325u L=0.04u
M542 U161/net26 n128 VDD VDD pmos W=0.41u L=0.04u
M543 N12 n12 U161/net30 VDD pmos W=0.325u L=0.04u
M544 U161/net30 n127 VDD VDD pmos W=0.205u L=0.04u
M545 U162/net11 G13 n127 VDD pmos W=0.205u L=0.04u
M546 U162/net11 n99 n127 VDD pmos W=0.205u L=0.04u
M547 U162/net11 G21 U162/XI16-net11 VDD pmos W=0.205u L=0.04u
M548 U162/XI16-net11 G0 VDD VDD pmos W=0.205u L=0.04u
M549 n127 G0 VSS VSS nmos W=0.155u L=0.04u
M550 n127 G21 VSS VSS nmos W=0.155u L=0.04u
M551 n127 G13 U162/XI12-net17 VSS nmos W=0.155u L=0.04u
M552 U162/XI12-net17 n99 VSS VSS nmos W=0.155u L=0.04u
M553 U163/net19 n99 VSS VSS nmos W=0.155u L=0.04u
M554 N1 n99 U163/net40 VSS nmos W=0.155u L=0.04u
M555 N1 U163/net19 U163/net36 VSS nmos W=0.155u L=0.04u
M556 U163/net40 n115 VSS VSS nmos W=0.31u L=0.04u
M557 U163/net36 n129 VSS VSS nmos W=0.155u L=0.04u
M558 U163/net19 n99 VDD VDD pmos W=0.205u L=0.04u
M559 N1 U163/net19 U163/net26 VDD pmos W=0.325u L=0.04u
M560 U163/net26 n115 VDD VDD pmos W=0.41u L=0.04u
M561 N1 n99 U163/net30 VDD pmos W=0.325u L=0.04u
M562 U163/net30 n129 VDD VDD pmos W=0.205u L=0.04u
M563 n99 G12 VSS VSS nmos W=0.135u L=0.04u
M564 n99 G12 VDD VDD pmos W=0.205u L=0.04u
M565 n115 U165/net6 VSS VSS nmos W=0.155u L=0.04u
M566 U165/X_u2-net6 n118 VSS VSS nmos W=0.155u L=0.04u
M567 U165/net6 n128 U165/X_u2-net6 VSS nmos W=0.155u L=0.04u
M568 n115 U165/net6 VDD VDD pmos W=0.205u L=0.04u
M569 U165/net6 n118 VDD VDD pmos W=0.205u L=0.04u
M570 U165/net6 n128 VDD VDD pmos W=0.205u L=0.04u
M571 n128 n101 VSS VSS nmos W=0.155u L=0.04u
M572 n128 G0 VSS VSS nmos W=0.155u L=0.04u
M573 U166/XI1-net8 G0 VDD VDD pmos W=0.205u L=0.04u
M574 n128 n101 U166/XI1-net8 VDD pmos W=0.205u L=0.04u
M575 n101 G21 VSS VSS nmos W=0.135u L=0.04u
M576 n101 G21 VDD VDD pmos W=0.205u L=0.04u
M577 n129 G21 U168/net27 VSS nmos W=0.155u L=0.04u
M578 U168/net27 n118 VSS VSS nmos W=0.155u L=0.04u
M579 n129 G0 VSS VSS nmos W=0.155u L=0.04u
M580 n129 n118 U168/net13 VDD pmos W=0.205u L=0.04u
M581 U168/net13 G0 VDD VDD pmos W=0.205u L=0.04u
M582 n129 G21 U168/net13 VDD pmos W=0.205u L=0.04u
M583 n118 n12 VSS VSS nmos W=0.135u L=0.04u
M584 n118 n12 VDD VDD pmos W=0.205u L=0.04u
M585 U170/p2 n104 VSS VSS nmos W=0.155u L=0.04u
M586 U170/p0 n95 U170/p1 VSS nmos W=0.155u L=0.04u
M587 U170/p1 n94 U170/p2 VSS nmos W=0.155u L=0.04u
M588 n12 G20 U170/p0 VSS nmos W=0.155u L=0.04u
M589 n12 n94 VDD VDD pmos W=0.205u L=0.04u
M590 n12 n95 VDD VDD pmos W=0.205u L=0.04u
M591 n12 G20 VDD VDD pmos W=0.205u L=0.04u
M592 n12 n104 VDD VDD pmos W=0.205u L=0.04u
M593 n104 n110 VSS VSS nmos W=0.135u L=0.04u
M594 n104 n110 VDD VDD pmos W=0.205u L=0.04u
M595 n110 n106 VSS VSS nmos W=0.155u L=0.04u
M596 n110 G30 VSS VSS nmos W=0.155u L=0.04u
M597 U172/XI1-net8 G30 VDD VDD pmos W=0.205u L=0.04u
M598 n110 n106 U172/XI1-net8 VDD pmos W=0.205u L=0.04u
M599 n106 n64 VSS VSS nmos W=0.155u L=0.04u
M600 n106 G11 VSS VSS nmos W=0.155u L=0.04u
M601 U173/XI1-net8 G11 VDD VDD pmos W=0.205u L=0.04u
M602 n106 n64 U173/XI1-net8 VDD pmos W=0.205u L=0.04u
M603 n64 G10 U174/XI0-net10 VSS nmos W=0.155u L=0.04u
M604 U174/XI0-net10 n103 U174/XI0-net13 VSS nmos W=0.155u L=0.04u
M605 U174/XI0-net13 G15 VSS VSS nmos W=0.155u L=0.04u
M606 n64 G15 VDD VDD pmos W=0.205u L=0.04u
M607 n64 G10 VDD VDD pmos W=0.205u L=0.04u
M608 n64 n103 VDD VDD pmos W=0.205u L=0.04u
M609 n103 G14 VSS VSS nmos W=0.135u L=0.04u
M610 n103 G14 VDD VDD pmos W=0.205u L=0.04u
M611 n94 n111 VSS VSS nmos W=0.155u L=0.04u
M612 n94 G17 VSS VSS nmos W=0.155u L=0.04u
M613 U176/XI1-net8 G17 VDD VDD pmos W=0.205u L=0.04u
M614 n94 n111 U176/XI1-net8 VDD pmos W=0.205u L=0.04u
M615 n111 G16 VSS VSS nmos W=0.135u L=0.04u
M616 n111 G16 VDD VDD pmos W=0.205u L=0.04u
M617 n95 n91 VSS VSS nmos W=0.155u L=0.04u
M618 n95 G18 VSS VSS nmos W=0.155u L=0.04u
M619 U178/XI1-net8 G18 VDD VDD pmos W=0.205u L=0.04u
M620 n95 n91 U178/XI1-net8 VDD pmos W=0.205u L=0.04u
M621 n91 G19 VSS VSS nmos W=0.135u L=0.04u
M622 n91 G19 VDD VDD pmos W=0.205u L=0.04u
.ENDS
