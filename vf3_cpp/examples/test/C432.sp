.SUBCKT c432 N1 N4 N8 N11 N14 N17 N21 N24 N27 N30 N34 N37 N40 N43 N47 N50 N53 N56 N60 N63 N66 N69 N73 N76 N79 N82 N86 N89 N92 N95 N99 N102 N105 N108 N112 N115 N223 N329 N370 N421 N430 N431 N432 VDD VSS
M1 N432 n93 U94/net15 VSS nmos W=0.155u L=0.04u
M2 N432 n94 U94/net15 VSS nmos W=0.155u L=0.04u
M3 U94/net15 n95 VSS VSS nmos W=0.155u L=0.04u
M4 N432 n95 VDD VDD pmos W=0.205u L=0.04u
M5 N432 n93 U94/XI16-net11 VDD pmos W=0.205u L=0.04u
M6 U94/XI16-net11 n94 VDD VDD pmos W=0.205u L=0.04u
M7 n94 n100 VSS VSS nmos W=0.155u L=0.04u
M8 n94 n98 U95/XI17-net17 VSS nmos W=0.155u L=0.04u
M9 U95/XI17-net17 n99 VSS VSS nmos W=0.155u L=0.04u
M10 n94 n96 U95/XI10-net17 VSS nmos W=0.155u L=0.04u
M11 U95/XI10-net17 n97 VSS VSS nmos W=0.155u L=0.04u
M12 U95/net30 n96 n94 VDD pmos W=0.205u L=0.04u
M13 U95/net30 n97 n94 VDD pmos W=0.205u L=0.04u
M14 VDD n100 U95/net36 VDD pmos W=0.205u L=0.04u
M15 U95/net36 n99 U95/net30 VDD pmos W=0.205u L=0.04u
M16 U95/net36 n98 U95/net30 VDD pmos W=0.205u L=0.04u
M17 n98 n101 VSS VSS nmos W=0.135u L=0.04u
M18 n98 n101 VDD VDD pmos W=0.205u L=0.04u
M19 n93 n102 VSS VSS nmos W=0.135u L=0.04u
M20 n93 n102 VDD VDD pmos W=0.205u L=0.04u
M21 U98/net36 n95 U98/net24 VSS nmos W=0.155u L=0.04u
M22 U98/net24 n102 VSS VSS nmos W=0.155u L=0.04u
M23 N431 n103 U98/net36 VSS nmos W=0.155u L=0.04u
M24 N431 n104 U98/net36 VSS nmos W=0.155u L=0.04u
M25 N431 n104 U98/net35 VDD pmos W=0.205u L=0.04u
M26 U98/net35 n103 VDD VDD pmos W=0.205u L=0.04u
M27 N431 n102 VDD VDD pmos W=0.205u L=0.04u
M28 N431 n95 VDD VDD pmos W=0.205u L=0.04u
M29 U99/XU1-net6 n105 VSS VSS nmos W=0.155u L=0.04u
M30 n104 n97 U99/XU1-net6 VSS nmos W=0.155u L=0.04u
M31 n104 n105 VDD VDD pmos W=0.155u L=0.04u
M32 n104 n97 VDD VDD pmos W=0.155u L=0.04u
M33 N421 n103 U100/net23 VDD pmos W=0.205u L=0.04u
M34 N421 n106 U100/net23 VDD pmos W=0.205u L=0.04u
M35 N421 n101 U100/net23 VDD pmos W=0.205u L=0.04u
M36 U100/net23 n107 VDD VDD pmos W=0.205u L=0.04u
M37 U100/net23 n108 VDD VDD pmos W=0.205u L=0.04u
M38 U100/XI20-net13 n106 VSS VSS nmos W=0.155u L=0.04u
M39 N421 n103 U100/XI20-net17 VSS nmos W=0.155u L=0.04u
M40 U100/XI20-net17 n101 U100/XI20-net13 VSS nmos W=0.155u L=0.04u
M41 N421 n107 U100/XI17-net17 VSS nmos W=0.155u L=0.04u
M42 U100/XI17-net17 n108 VSS VSS nmos W=0.155u L=0.04u
M43 U101/net29 N223 VSS VSS nmos W=0.155u L=0.04u
M44 n107 N1 U101/net29 VSS nmos W=0.155u L=0.04u
M45 n107 N14 U101/net23 VSS nmos W=0.155u L=0.04u
M46 U101/net23 N370 VSS VSS nmos W=0.155u L=0.04u
M47 U101/net20 N370 n107 VDD pmos W=0.205u L=0.04u
M48 U101/net20 N14 n107 VDD pmos W=0.205u L=0.04u
M49 VDD N1 U101/net20 VDD pmos W=0.205u L=0.04u
M50 VDD N223 U101/net20 VDD pmos W=0.205u L=0.04u
M51 n106 N108 VSS VSS nmos W=0.155u L=0.04u
M52 n106 N430 VSS VSS nmos W=0.155u L=0.04u
M53 U102/XI1-net8 N430 VDD VDD pmos W=0.205u L=0.04u
M54 n106 N108 U102/XI1-net8 VDD pmos W=0.205u L=0.04u
M55 U103/p2 n105 VSS VSS nmos W=0.155u L=0.04u
M56 U103/p0 n95 U103/p1 VSS nmos W=0.155u L=0.04u
M57 U103/p1 n102 U103/p2 VSS nmos W=0.155u L=0.04u
M58 N430 n97 U103/p0 VSS nmos W=0.155u L=0.04u
M59 N430 n102 VDD VDD pmos W=0.205u L=0.04u
M60 N430 n95 VDD VDD pmos W=0.205u L=0.04u
M61 N430 n97 VDD VDD pmos W=0.205u L=0.04u
M62 N430 n105 VDD VDD pmos W=0.205u L=0.04u
M63 n105 n100 VSS VSS nmos W=0.135u L=0.04u
M64 n105 n100 VDD VDD pmos W=0.205u L=0.04u
M65 n100 n109 VSS VSS nmos W=0.155u L=0.04u
M66 n100 N329 U105/XI17-net17 VSS nmos W=0.155u L=0.04u
M67 U105/XI17-net17 N47 VSS VSS nmos W=0.155u L=0.04u
M68 n100 N370 U105/XI10-net17 VSS nmos W=0.155u L=0.04u
M69 U105/XI10-net17 N53 VSS VSS nmos W=0.155u L=0.04u
M70 U105/net30 N370 n100 VDD pmos W=0.205u L=0.04u
M71 U105/net30 N53 n100 VDD pmos W=0.205u L=0.04u
M72 VDD n109 U105/net36 VDD pmos W=0.205u L=0.04u
M73 U105/net36 N47 U105/net30 VDD pmos W=0.205u L=0.04u
M74 U105/net36 N329 U105/net30 VDD pmos W=0.205u L=0.04u
M75 n109 n110 U106/net27 VSS nmos W=0.155u L=0.04u
M76 U106/net27 N43 VSS VSS nmos W=0.155u L=0.04u
M77 n109 n111 VSS VSS nmos W=0.155u L=0.04u
M78 n109 N43 U106/net13 VDD pmos W=0.205u L=0.04u
M79 U106/net13 n111 VDD VDD pmos W=0.205u L=0.04u
M80 n109 n110 U106/net13 VDD pmos W=0.205u L=0.04u
M81 U107/net36 n114 U107/net24 VSS nmos W=0.155u L=0.04u
M82 U107/net24 n115 VSS VSS nmos W=0.155u L=0.04u
M83 n102 n112 U107/net36 VSS nmos W=0.155u L=0.04u
M84 n102 n113 U107/net36 VSS nmos W=0.155u L=0.04u
M85 n102 n113 U107/net35 VDD pmos W=0.205u L=0.04u
M86 U107/net35 n112 VDD VDD pmos W=0.205u L=0.04u
M87 n102 n115 VDD VDD pmos W=0.205u L=0.04u
M88 n102 n114 VDD VDD pmos W=0.205u L=0.04u
M89 n115 N24 U108/net27 VSS nmos W=0.155u L=0.04u
M90 U108/net27 N223 VSS VSS nmos W=0.155u L=0.04u
M91 n115 n116 VSS VSS nmos W=0.155u L=0.04u
M92 n115 N223 U108/net13 VDD pmos W=0.205u L=0.04u
M93 U108/net13 n116 VDD VDD pmos W=0.205u L=0.04u
M94 n115 N24 U108/net13 VDD pmos W=0.205u L=0.04u
M95 U109/net36 n118 U109/net24 VSS nmos W=0.155u L=0.04u
M96 U109/net24 n119 VSS VSS nmos W=0.155u L=0.04u
M97 n95 n112 U109/net36 VSS nmos W=0.155u L=0.04u
M98 n95 n117 U109/net36 VSS nmos W=0.155u L=0.04u
M99 n95 n117 U109/net35 VDD pmos W=0.205u L=0.04u
M100 U109/net35 n112 VDD VDD pmos W=0.205u L=0.04u
M101 n95 n119 VDD VDD pmos W=0.205u L=0.04u
M102 n95 n118 VDD VDD pmos W=0.205u L=0.04u
M103 n119 N21 U110/net27 VSS nmos W=0.155u L=0.04u
M104 U110/net27 N329 VSS VSS nmos W=0.155u L=0.04u
M105 n119 n120 VSS VSS nmos W=0.155u L=0.04u
M106 n119 N329 U110/net13 VDD pmos W=0.205u L=0.04u
M107 U110/net13 n120 VDD VDD pmos W=0.205u L=0.04u
M108 n119 N21 U110/net13 VDD pmos W=0.205u L=0.04u
M109 U111/net36 n122 U111/net24 VSS nmos W=0.155u L=0.04u
M110 U111/net24 n123 VSS VSS nmos W=0.155u L=0.04u
M111 n97 n112 U111/net36 VSS nmos W=0.155u L=0.04u
M112 n97 n121 U111/net36 VSS nmos W=0.155u L=0.04u
M113 n97 n121 U111/net35 VDD pmos W=0.205u L=0.04u
M114 U111/net35 n112 VDD VDD pmos W=0.205u L=0.04u
M115 n97 n123 VDD VDD pmos W=0.205u L=0.04u
M116 n97 n122 VDD VDD pmos W=0.205u L=0.04u
M117 n123 N60 U112/net27 VSS nmos W=0.155u L=0.04u
M118 U112/net27 N329 VSS VSS nmos W=0.155u L=0.04u
M119 n123 n124 VSS VSS nmos W=0.155u L=0.04u
M120 n123 N329 U112/net13 VDD pmos W=0.205u L=0.04u
M121 U112/net13 n124 VDD VDD pmos W=0.205u L=0.04u
M122 n123 N60 U112/net13 VDD pmos W=0.205u L=0.04u
M123 n101 n126 U113/net26 VSS nmos W=0.155u L=0.04u
M124 n101 n125 U113/net26 VSS nmos W=0.155u L=0.04u
M125 U113/net29 n128 VSS VSS nmos W=0.155u L=0.04u
M126 U113/net26 n112 U113/net29 VSS nmos W=0.155u L=0.04u
M127 U113/net26 n127 U113/net29 VSS nmos W=0.155u L=0.04u
M128 n101 n125 U113/net43 VDD pmos W=0.205u L=0.04u
M129 n101 n127 U113/net49 VDD pmos W=0.205u L=0.04u
M130 U113/net49 n112 VDD VDD pmos W=0.205u L=0.04u
M131 U113/net43 n126 VDD VDD pmos W=0.205u L=0.04u
M132 n101 n128 VDD VDD pmos W=0.205u L=0.04u
M133 n128 N223 U114/net15 VSS nmos W=0.155u L=0.04u
M134 n128 n129 U114/net15 VSS nmos W=0.155u L=0.04u
M135 U114/net15 n130 VSS VSS nmos W=0.155u L=0.04u
M136 n128 n130 VDD VDD pmos W=0.205u L=0.04u
M137 n128 N223 U114/XI16-net11 VDD pmos W=0.205u L=0.04u
M138 U114/XI16-net11 n129 VDD VDD pmos W=0.205u L=0.04u
M139 n103 n96 VSS VSS nmos W=0.155u L=0.04u
M140 n103 U115/net4 VSS VSS nmos W=0.155u L=0.04u
M141 U115/net4 n99 VSS VSS nmos W=0.155u L=0.04u
M142 U115/XU1-net8 U115/net4 VDD VDD pmos W=0.205u L=0.04u
M143 n103 n96 U115/XU1-net8 VDD pmos W=0.205u L=0.04u
M144 U115/net4 n99 VDD VDD pmos W=0.205u L=0.04u
M145 n96 n131 VSS VSS nmos W=0.155u L=0.04u
M146 n96 N329 U116/XI17-net17 VSS nmos W=0.155u L=0.04u
M147 U116/XI17-net17 N73 VSS VSS nmos W=0.155u L=0.04u
M148 n96 N370 U116/XI10-net17 VSS nmos W=0.155u L=0.04u
M149 U116/XI10-net17 N79 VSS VSS nmos W=0.155u L=0.04u
M150 U116/net30 N370 n96 VDD pmos W=0.205u L=0.04u
M151 U116/net30 N79 n96 VDD pmos W=0.205u L=0.04u
M152 VDD n131 U116/net36 VDD pmos W=0.205u L=0.04u
M153 U116/net36 N73 U116/net30 VDD pmos W=0.205u L=0.04u
M154 U116/net36 N329 U116/net30 VDD pmos W=0.205u L=0.04u
M155 n131 n110 U117/net27 VSS nmos W=0.155u L=0.04u
M156 U117/net27 N69 VSS VSS nmos W=0.155u L=0.04u
M157 n131 n132 VSS VSS nmos W=0.155u L=0.04u
M158 n131 N69 U117/net13 VDD pmos W=0.205u L=0.04u
M159 U117/net13 n132 VDD VDD pmos W=0.205u L=0.04u
M160 n131 n110 U117/net13 VDD pmos W=0.205u L=0.04u
M161 U118/net36 n134 U118/net24 VSS nmos W=0.155u L=0.04u
M162 U118/net24 n135 VSS VSS nmos W=0.155u L=0.04u
M163 n99 n112 U118/net36 VSS nmos W=0.155u L=0.04u
M164 n99 n133 U118/net36 VSS nmos W=0.155u L=0.04u
M165 n99 n133 U118/net35 VDD pmos W=0.205u L=0.04u
M166 U118/net35 n112 VDD VDD pmos W=0.205u L=0.04u
M167 n99 n135 VDD VDD pmos W=0.205u L=0.04u
M168 n99 n134 VDD VDD pmos W=0.205u L=0.04u
M169 n135 N86 U119/net27 VSS nmos W=0.155u L=0.04u
M170 U119/net27 N329 VSS VSS nmos W=0.155u L=0.04u
M171 n135 n136 VSS VSS nmos W=0.155u L=0.04u
M172 n135 N329 U119/net13 VDD pmos W=0.205u L=0.04u
M173 U119/net13 n136 VDD VDD pmos W=0.205u L=0.04u
M174 n135 N86 U119/net13 VDD pmos W=0.205u L=0.04u
M175 n112 N370 VSS VSS nmos W=0.135u L=0.04u
M176 n112 N370 VDD VDD pmos W=0.205u L=0.04u
M177 U121/p2 n140 VSS VSS nmos W=0.155u L=0.04u
M178 U121/p0 n138 U121/p1 VSS nmos W=0.155u L=0.04u
M179 U121/p1 n139 U121/p2 VSS nmos W=0.155u L=0.04u
M180 N370 n137 U121/p0 VSS nmos W=0.155u L=0.04u
M181 N370 n139 VDD VDD pmos W=0.205u L=0.04u
M182 N370 n138 VDD VDD pmos W=0.205u L=0.04u
M183 N370 n137 VDD VDD pmos W=0.205u L=0.04u
M184 N370 n140 VDD VDD pmos W=0.205u L=0.04u
M185 n140 n144 VSS VSS nmos W=0.155u L=0.04u
M186 n140 n143 VSS VSS nmos W=0.155u L=0.04u
M187 n140 n142 VSS VSS nmos W=0.155u L=0.04u
M188 n140 n141 VSS VSS nmos W=0.155u L=0.04u
M189 U122/net49 n143 U122/net52 VDD pmos W=0.41u L=0.04u
M190 U122/net52 n144 VDD VDD pmos W=0.41u L=0.04u
M191 U122/net46 n142 U122/net49 VDD pmos W=0.41u L=0.04u
M192 n140 n141 U122/net46 VDD pmos W=0.41u L=0.04u
M193 n144 n147 VSS VSS nmos W=0.155u L=0.04u
M194 n144 n146 VSS VSS nmos W=0.155u L=0.04u
M195 n144 n145 VSS VSS nmos W=0.155u L=0.04u
M196 n144 N79 VSS VSS nmos W=0.155u L=0.04u
M197 U123/net49 n146 U123/net52 VDD pmos W=0.41u L=0.04u
M198 U123/net52 n147 VDD VDD pmos W=0.41u L=0.04u
M199 U123/net46 n145 U123/net49 VDD pmos W=0.41u L=0.04u
M200 n144 N79 U123/net46 VDD pmos W=0.41u L=0.04u
M201 n146 n148 VSS VSS nmos W=0.155u L=0.04u
M202 n146 n125 VSS VSS nmos W=0.155u L=0.04u
M203 U124/XI1-net8 n125 VDD VDD pmos W=0.205u L=0.04u
M204 n146 n148 U124/XI1-net8 VDD pmos W=0.205u L=0.04u
M205 U125/net11 N50 n143 VDD pmos W=0.205u L=0.04u
M206 U125/net11 N223 n143 VDD pmos W=0.205u L=0.04u
M207 U125/net11 n149 U125/XI16-net11 VDD pmos W=0.205u L=0.04u
M208 U125/XI16-net11 n124 VDD VDD pmos W=0.205u L=0.04u
M209 n143 n124 VSS VSS nmos W=0.155u L=0.04u
M210 n143 n149 VSS VSS nmos W=0.155u L=0.04u
M211 n143 N50 U125/XI12-net17 VSS nmos W=0.155u L=0.04u
M212 U125/XI12-net17 N223 VSS VSS nmos W=0.155u L=0.04u
M213 n149 n150 U126/net15 VSS nmos W=0.155u L=0.04u
M214 n149 n125 U126/net15 VSS nmos W=0.155u L=0.04u
M215 U126/net15 n121 VSS VSS nmos W=0.155u L=0.04u
M216 n149 n121 VDD VDD pmos W=0.205u L=0.04u
M217 n149 n150 U126/XI16-net11 VDD pmos W=0.205u L=0.04u
M218 U126/XI16-net11 n125 VDD VDD pmos W=0.205u L=0.04u
M219 n121 N66 VSS VSS nmos W=0.135u L=0.04u
M220 n121 N66 VDD VDD pmos W=0.205u L=0.04u
M221 n142 n153 VSS VSS nmos W=0.155u L=0.04u
M222 n142 n152 VSS VSS nmos W=0.155u L=0.04u
M223 n142 n151 VSS VSS nmos W=0.155u L=0.04u
M224 n142 N53 VSS VSS nmos W=0.155u L=0.04u
M225 U128/net49 n152 U128/net52 VDD pmos W=0.41u L=0.04u
M226 U128/net52 n153 VDD VDD pmos W=0.41u L=0.04u
M227 U128/net46 n151 U128/net49 VDD pmos W=0.41u L=0.04u
M228 n142 N53 U128/net46 VDD pmos W=0.41u L=0.04u
M229 n152 n154 VSS VSS nmos W=0.155u L=0.04u
M230 n152 n125 VSS VSS nmos W=0.155u L=0.04u
M231 U129/XI1-net8 n125 VDD VDD pmos W=0.205u L=0.04u
M232 n152 n154 U129/XI1-net8 VDD pmos W=0.205u L=0.04u
M233 n141 U130/net6 VSS VSS nmos W=0.155u L=0.04u
M234 U130/net6 n113 U130/XU30-net23 VSS nmos W=0.155u L=0.04u
M235 U130/XU30-net23 n155 U130/XU30-net26 VSS nmos W=0.155u L=0.04u
M236 U130/XU30-net26 n114 U130/XU30-net29 VSS nmos W=0.155u L=0.04u
M237 U130/XU30-net29 N30 VSS VSS nmos W=0.155u L=0.04u
M238 n141 U130/net6 VDD VDD pmos W=0.205u L=0.04u
M239 U130/net6 N30 VDD VDD pmos W=0.205u L=0.04u
M240 U130/net6 n114 VDD VDD pmos W=0.205u L=0.04u
M241 U130/net6 n155 VDD VDD pmos W=0.205u L=0.04u
M242 U130/net6 n113 VDD VDD pmos W=0.205u L=0.04u
M243 U131/XU1-net6 N329 VSS VSS nmos W=0.155u L=0.04u
M244 n114 N34 U131/XU1-net6 VSS nmos W=0.155u L=0.04u
M245 n114 N329 VDD VDD pmos W=0.155u L=0.04u
M246 n114 N34 VDD VDD pmos W=0.155u L=0.04u
M247 n113 N40 VSS VSS nmos W=0.135u L=0.04u
M248 n113 N40 VDD VDD pmos W=0.205u L=0.04u
M249 U133/net40 n157 n139 VDD pmos W=0.205u L=0.04u
M250 U133/net40 n156 n139 VDD pmos W=0.205u L=0.04u
M251 VDD n158 U133/net40 VDD pmos W=0.205u L=0.04u
M252 VDD n118 U133/net40 VDD pmos W=0.205u L=0.04u
M253 U133/net40 n108 n139 VDD pmos W=0.205u L=0.04u
M254 VDD n117 U133/net40 VDD pmos W=0.205u L=0.04u
M255 U133/XI13-net13 n108 VSS VSS nmos W=0.155u L=0.04u
M256 n139 n156 U133/XI13-net17 VSS nmos W=0.155u L=0.04u
M257 U133/XI13-net17 n157 U133/XI13-net13 VSS nmos W=0.155u L=0.04u
M258 U133/XI7-net13 n158 VSS VSS nmos W=0.155u L=0.04u
M259 n139 n118 U133/XI7-net17 VSS nmos W=0.155u L=0.04u
M260 U133/XI7-net17 n117 U133/XI7-net13 VSS nmos W=0.155u L=0.04u
M261 n158 n159 U134/net27 VSS nmos W=0.155u L=0.04u
M262 U134/net27 N329 VSS VSS nmos W=0.155u L=0.04u
M263 n158 n120 VSS VSS nmos W=0.155u L=0.04u
M264 n158 N329 U134/net13 VDD pmos W=0.205u L=0.04u
M265 U134/net13 n120 VDD VDD pmos W=0.205u L=0.04u
M266 n158 n159 U134/net13 VDD pmos W=0.205u L=0.04u
M267 n117 N27 VSS VSS nmos W=0.135u L=0.04u
M268 n117 N27 VDD VDD pmos W=0.205u L=0.04u
M269 U136/net14 n160 U136/net20 VSS nmos W=0.155u L=0.04u
M270 U136/net14 n125 U136/net20 VSS nmos W=0.155u L=0.04u
M271 U136/net20 N4 VSS VSS nmos W=0.155u L=0.04u
M272 n108 U136/net14 VSS VSS nmos W=0.155u L=0.04u
M273 n108 U136/net14 VDD VDD pmos W=0.205u L=0.04u
M274 U136/net14 N4 VDD VDD pmos W=0.205u L=0.04u
M275 U136/net24 n160 VDD VDD pmos W=0.205u L=0.04u
M276 U136/net14 n125 U136/net24 VDD pmos W=0.205u L=0.04u
M277 n157 N14 VSS VSS nmos W=0.135u L=0.04u
M278 n157 N14 VDD VDD pmos W=0.205u L=0.04u
M279 U138/net36 N108 U138/net24 VSS nmos W=0.155u L=0.04u
M280 U138/net24 n162 VSS VSS nmos W=0.155u L=0.04u
M281 n138 n110 U138/net36 VSS nmos W=0.155u L=0.04u
M282 n138 n161 U138/net36 VSS nmos W=0.155u L=0.04u
M283 n138 n161 U138/net35 VDD pmos W=0.205u L=0.04u
M284 U138/net35 n110 VDD VDD pmos W=0.205u L=0.04u
M285 n138 n162 VDD VDD pmos W=0.205u L=0.04u
M286 n138 N108 VDD VDD pmos W=0.205u L=0.04u
M287 U139/net11 n125 VSS VSS nmos W=0.155u L=0.04u
M288 U139/net11 n163 VSS VSS nmos W=0.155u L=0.04u
M289 n162 N115 VSS VSS nmos W=0.155u L=0.04u
M290 n162 U139/net11 VSS VSS nmos W=0.155u L=0.04u
M291 U139/XI1-net8 n163 VDD VDD pmos W=0.205u L=0.04u
M292 U139/net11 n125 U139/XI1-net8 VDD pmos W=0.205u L=0.04u
M293 U139/XU39-net8 U139/net11 VDD VDD pmos W=0.205u L=0.04u
M294 n162 N115 U139/XU39-net8 VDD pmos W=0.205u L=0.04u
M295 n125 N329 VSS VSS nmos W=0.135u L=0.04u
M296 n125 N329 VDD VDD pmos W=0.205u L=0.04u
M297 U141/net40 n127 n137 VDD pmos W=0.205u L=0.04u
M298 U141/net40 n164 n137 VDD pmos W=0.205u L=0.04u
M299 VDD n166 U141/net40 VDD pmos W=0.205u L=0.04u
M300 VDD n134 U141/net40 VDD pmos W=0.205u L=0.04u
M301 U141/net40 n165 n137 VDD pmos W=0.205u L=0.04u
M302 VDD n133 U141/net40 VDD pmos W=0.205u L=0.04u
M303 U141/XI13-net13 n165 VSS VSS nmos W=0.155u L=0.04u
M304 n137 n164 U141/XI13-net17 VSS nmos W=0.155u L=0.04u
M305 U141/XI13-net17 n127 U141/XI13-net13 VSS nmos W=0.155u L=0.04u
M306 U141/XI7-net13 n166 VSS VSS nmos W=0.155u L=0.04u
M307 n137 n134 U141/XI7-net17 VSS nmos W=0.155u L=0.04u
M308 U141/XI7-net17 n133 U141/XI7-net13 VSS nmos W=0.155u L=0.04u
M309 n166 N329 U142/net27 VSS nmos W=0.155u L=0.04u
M310 U142/net27 n167 VSS VSS nmos W=0.155u L=0.04u
M311 n166 n136 VSS VSS nmos W=0.155u L=0.04u
M312 n166 n167 U142/net13 VDD pmos W=0.205u L=0.04u
M313 U142/net13 n136 VDD VDD pmos W=0.205u L=0.04u
M314 n166 N329 U142/net13 VDD pmos W=0.205u L=0.04u
M315 n133 N92 VSS VSS nmos W=0.135u L=0.04u
M316 n133 N92 VDD VDD pmos W=0.205u L=0.04u
M317 n165 N329 U144/net27 VSS nmos W=0.155u L=0.04u
M318 U144/net27 n168 VSS VSS nmos W=0.155u L=0.04u
M319 n165 n129 VSS VSS nmos W=0.155u L=0.04u
M320 n165 n168 U144/net13 VDD pmos W=0.205u L=0.04u
M321 U144/net13 n129 VDD VDD pmos W=0.205u L=0.04u
M322 n165 N329 U144/net13 VDD pmos W=0.205u L=0.04u
M323 n129 N95 VSS VSS nmos W=0.135u L=0.04u
M324 n129 N95 VDD VDD pmos W=0.205u L=0.04u
M325 n127 N105 VSS VSS nmos W=0.135u L=0.04u
M326 n127 N105 VDD VDD pmos W=0.205u L=0.04u
M327 U147/net20 n154 VSS VSS nmos W=0.155u L=0.04u
M328 N329 n170 U147/p0 VSS nmos W=0.155u L=0.04u
M329 U147/p2 U147/net20 VSS VSS nmos W=0.155u L=0.04u
M330 U147/p1 n159 U147/p2 VSS nmos W=0.155u L=0.04u
M331 U147/p0 n169 U147/p1 VSS nmos W=0.155u L=0.04u
M332 U147/net20 n154 VDD VDD pmos W=0.205u L=0.04u
M333 N329 n159 VDD VDD pmos W=0.205u L=0.04u
M334 N329 n170 VDD VDD pmos W=0.205u L=0.04u
M335 N329 n169 VDD VDD pmos W=0.205u L=0.04u
M336 N329 U147/net20 VDD VDD pmos W=0.205u L=0.04u
M337 n170 U148/net15 VSS VSS nmos W=0.155u L=0.04u
M338 n170 n171 VSS VSS nmos W=0.155u L=0.04u
M339 n170 n163 VSS VSS nmos W=0.155u L=0.04u
M340 n170 n150 VSS VSS nmos W=0.155u L=0.04u
M341 U148/net15 n168 VSS VSS nmos W=0.155u L=0.04u
M342 n170 n150 U148/XU8-net7 VDD pmos W=0.41u L=0.04u
M343 U148/XU8-net7 n163 U148/XU8-net10 VDD pmos W=0.41u L=0.04u
M344 U148/XU8-net10 n171 U148/XU8-net13 VDD pmos W=0.41u L=0.04u
M345 U148/XU8-net13 U148/net15 VDD VDD pmos W=0.41u L=0.04u
M346 U148/net15 n168 VDD VDD pmos W=0.31u L=0.04u
M347 n150 n124 VSS VSS nmos W=0.155u L=0.04u
M348 n150 N60 VSS VSS nmos W=0.155u L=0.04u
M349 n150 U149/net12 VSS VSS nmos W=0.155u L=0.04u
M350 U149/net12 n122 VSS VSS nmos W=0.155u L=0.04u
M351 U149/XU9-net9 U149/net12 VDD VDD pmos W=0.41u L=0.04u
M352 U149/XU9-net12 N60 U149/XU9-net9 VDD pmos W=0.41u L=0.04u
M353 n150 n124 U149/XU9-net12 VDD pmos W=0.41u L=0.04u
M354 U149/net12 n122 VDD VDD pmos W=0.31u L=0.04u
M355 U150/XU1-net6 N223 VSS VSS nmos W=0.155u L=0.04u
M356 n122 N50 U150/XU1-net6 VSS nmos W=0.155u L=0.04u
M357 n122 N223 VDD VDD pmos W=0.155u L=0.04u
M358 n122 N50 VDD VDD pmos W=0.155u L=0.04u
M359 U151/net11 N102 n163 VDD pmos W=0.205u L=0.04u
M360 U151/net11 N223 n163 VDD pmos W=0.205u L=0.04u
M361 U151/net11 N112 U151/XI16-net11 VDD pmos W=0.205u L=0.04u
M362 U151/XI16-net11 n172 VDD VDD pmos W=0.205u L=0.04u
M363 n163 n172 VSS VSS nmos W=0.155u L=0.04u
M364 n163 N112 VSS VSS nmos W=0.155u L=0.04u
M365 n163 N102 U151/XI12-net17 VSS nmos W=0.155u L=0.04u
M366 U151/XI12-net17 N223 VSS VSS nmos W=0.155u L=0.04u
M367 n172 N108 VSS VSS nmos W=0.135u L=0.04u
M368 n172 N108 VDD VDD pmos W=0.205u L=0.04u
M369 U153/net13 n148 VSS VSS nmos W=0.155u L=0.04u
M370 U153/net16 U153/net13 VSS VSS nmos W=0.155u L=0.04u
M371 n171 n167 U153/net16 VSS nmos W=0.155u L=0.04u
M372 U153/net13 n148 VDD VDD pmos W=0.205u L=0.04u
M373 VDD U153/net13 n171 VDD pmos W=0.205u L=0.04u
M374 VDD n167 n171 VDD pmos W=0.205u L=0.04u
M375 U154/net30 N86 VSS VSS nmos W=0.155u L=0.04u
M376 n167 N82 U154/net23 VSS nmos W=0.155u L=0.04u
M377 U154/net20 U154/net30 VSS VSS nmos W=0.155u L=0.04u
M378 U154/net23 n134 U154/net20 VSS nmos W=0.155u L=0.04u
M379 U154/net30 N86 VDD VDD pmos W=0.205u L=0.04u
M380 VDD N82 n167 VDD pmos W=0.205u L=0.04u
M381 VDD n134 n167 VDD pmos W=0.205u L=0.04u
M382 VDD U154/net30 n167 VDD pmos W=0.205u L=0.04u
M383 n134 U155/net7 VSS VSS nmos W=0.155u L=0.04u
M384 U155/net7 n173 VSS VSS nmos W=0.155u L=0.04u
M385 U155/net7 n110 VSS VSS nmos W=0.155u L=0.04u
M386 n134 U155/net7 VDD VDD pmos W=0.205u L=0.04u
M387 U155/X_u7-net8 n110 VDD VDD pmos W=0.205u L=0.04u
M388 U155/net7 n173 U155/X_u7-net8 VDD pmos W=0.205u L=0.04u
M389 n148 n147 VSS VSS nmos W=0.155u L=0.04u
M390 n148 N73 VSS VSS nmos W=0.155u L=0.04u
M391 n148 n145 VSS VSS nmos W=0.155u L=0.04u
M392 U156/net25 n147 VDD VDD pmos W=0.41u L=0.04u
M393 U156/net28 N73 U156/net25 VDD pmos W=0.41u L=0.04u
M394 n148 n145 U156/net28 VDD pmos W=0.41u L=0.04u
M395 n145 n110 VSS VSS nmos W=0.155u L=0.04u
M396 n145 n132 VSS VSS nmos W=0.155u L=0.04u
M397 U157/XI1-net8 n132 VDD VDD pmos W=0.205u L=0.04u
M398 n145 n110 U157/XI1-net8 VDD pmos W=0.205u L=0.04u
M399 n168 n164 U158/XI0-net10 VSS nmos W=0.155u L=0.04u
M400 U158/XI0-net10 n126 U158/XI0-net13 VSS nmos W=0.155u L=0.04u
M401 U158/XI0-net13 N95 VSS VSS nmos W=0.155u L=0.04u
M402 n168 N95 VDD VDD pmos W=0.205u L=0.04u
M403 n168 n164 VDD VDD pmos W=0.205u L=0.04u
M404 n168 n126 VDD VDD pmos W=0.205u L=0.04u
M405 n126 N99 VSS VSS nmos W=0.135u L=0.04u
M406 n126 N99 VDD VDD pmos W=0.205u L=0.04u
M407 U160/XU1-net6 n130 VSS VSS nmos W=0.155u L=0.04u
M408 n164 N223 U160/XU1-net6 VSS nmos W=0.155u L=0.04u
M409 n164 n130 VDD VDD pmos W=0.155u L=0.04u
M410 n164 N223 VDD VDD pmos W=0.155u L=0.04u
M411 U161/net40 n160 n169 VDD pmos W=0.205u L=0.04u
M412 U161/net40 n156 n169 VDD pmos W=0.205u L=0.04u
M413 VDD N30 U161/net40 VDD pmos W=0.205u L=0.04u
M414 VDD n155 U161/net40 VDD pmos W=0.205u L=0.04u
M415 U161/net40 N4 n169 VDD pmos W=0.205u L=0.04u
M416 VDD n174 U161/net40 VDD pmos W=0.205u L=0.04u
M417 U161/XI13-net13 N4 VSS VSS nmos W=0.155u L=0.04u
M418 n169 n156 U161/XI13-net17 VSS nmos W=0.155u L=0.04u
M419 U161/XI13-net17 n160 U161/XI13-net13 VSS nmos W=0.155u L=0.04u
M420 U161/XI7-net13 N30 VSS VSS nmos W=0.155u L=0.04u
M421 n169 n155 U161/XI7-net17 VSS nmos W=0.155u L=0.04u
M422 U161/XI7-net17 n174 U161/XI7-net13 VSS nmos W=0.155u L=0.04u
M423 n174 N34 VSS VSS nmos W=0.135u L=0.04u
M424 n174 N34 VDD VDD pmos W=0.205u L=0.04u
M425 U163/XU1-net6 N223 VSS VSS nmos W=0.155u L=0.04u
M426 n155 N24 U163/XU1-net6 VSS nmos W=0.155u L=0.04u
M427 n155 N223 VDD VDD pmos W=0.155u L=0.04u
M428 n155 N24 VDD VDD pmos W=0.155u L=0.04u
M429 n160 N8 VSS VSS nmos W=0.135u L=0.04u
M430 n160 N8 VDD VDD pmos W=0.205u L=0.04u
M431 U165/XU1-net6 n175 VSS VSS nmos W=0.155u L=0.04u
M432 n156 N223 U165/XU1-net6 VSS nmos W=0.155u L=0.04u
M433 n156 n175 VDD VDD pmos W=0.155u L=0.04u
M434 n156 N223 VDD VDD pmos W=0.155u L=0.04u
M435 U166/net30 N21 VSS VSS nmos W=0.155u L=0.04u
M436 n159 N17 U166/net23 VSS nmos W=0.155u L=0.04u
M437 U166/net20 U166/net30 VSS VSS nmos W=0.155u L=0.04u
M438 U166/net23 n118 U166/net20 VSS nmos W=0.155u L=0.04u
M439 U166/net30 N21 VDD VDD pmos W=0.205u L=0.04u
M440 VDD N17 n159 VDD pmos W=0.205u L=0.04u
M441 VDD n118 n159 VDD pmos W=0.205u L=0.04u
M442 VDD U166/net30 n159 VDD pmos W=0.205u L=0.04u
M443 n118 U167/net7 VSS VSS nmos W=0.155u L=0.04u
M444 U167/net7 n176 VSS VSS nmos W=0.155u L=0.04u
M445 U167/net7 n110 VSS VSS nmos W=0.155u L=0.04u
M446 n118 U167/net7 VDD VDD pmos W=0.205u L=0.04u
M447 U167/X_u7-net8 n110 VDD VDD pmos W=0.205u L=0.04u
M448 U167/net7 n176 U167/X_u7-net8 VDD pmos W=0.205u L=0.04u
M449 n154 n153 VSS VSS nmos W=0.155u L=0.04u
M450 n154 N47 VSS VSS nmos W=0.155u L=0.04u
M451 n154 n151 VSS VSS nmos W=0.155u L=0.04u
M452 U168/net25 n153 VDD VDD pmos W=0.41u L=0.04u
M453 U168/net28 N47 U168/net25 VDD pmos W=0.41u L=0.04u
M454 n154 n151 U168/net28 VDD pmos W=0.41u L=0.04u
M455 n151 n110 VSS VSS nmos W=0.155u L=0.04u
M456 n151 n111 VSS VSS nmos W=0.155u L=0.04u
M457 U169/XI1-net8 n111 VDD VDD pmos W=0.205u L=0.04u
M458 n151 n110 U169/XI1-net8 VDD pmos W=0.205u L=0.04u
M459 n110 N223 VSS VSS nmos W=0.135u L=0.04u
M460 n110 N223 VDD VDD pmos W=0.205u L=0.04u
M461 U171/p2 n178 VSS VSS nmos W=0.155u L=0.04u
M462 U171/p0 n130 U171/p1 VSS nmos W=0.155u L=0.04u
M463 U171/p1 n177 U171/p2 VSS nmos W=0.155u L=0.04u
M464 N223 n175 U171/p0 VSS nmos W=0.155u L=0.04u
M465 N223 n177 VDD VDD pmos W=0.205u L=0.04u
M466 N223 n130 VDD VDD pmos W=0.205u L=0.04u
M467 N223 n175 VDD VDD pmos W=0.205u L=0.04u
M468 N223 n178 VDD VDD pmos W=0.205u L=0.04u
M469 U172/net11 N108 n178 VDD pmos W=0.205u L=0.04u
M470 U172/net11 n161 n178 VDD pmos W=0.205u L=0.04u
M471 U172/net11 n179 U172/XI16-net11 VDD pmos W=0.205u L=0.04u
M472 U172/XI16-net11 n132 VDD VDD pmos W=0.205u L=0.04u
M473 n178 n132 VSS VSS nmos W=0.155u L=0.04u
M474 n178 n179 VSS VSS nmos W=0.155u L=0.04u
M475 n178 N108 U172/XI12-net17 VSS nmos W=0.155u L=0.04u
M476 U172/XI12-net17 n161 VSS VSS nmos W=0.155u L=0.04u
M477 n132 N63 VSS VSS nmos W=0.155u L=0.04u
M478 n132 n147 VSS VSS nmos W=0.155u L=0.04u
M479 U173/XI1-net8 n147 VDD VDD pmos W=0.205u L=0.04u
M480 n132 N63 U173/XI1-net8 VDD pmos W=0.205u L=0.04u
M481 n147 N69 VSS VSS nmos W=0.135u L=0.04u
M482 n147 N69 VDD VDD pmos W=0.205u L=0.04u
M483 n179 N50 U175/net10 VSS nmos W=0.155u L=0.04u
M484 U175/net10 n116 VSS VSS nmos W=0.155u L=0.04u
M485 n179 n124 U175/net10 VSS nmos W=0.155u L=0.04u
M486 U175/net10 N24 VSS VSS nmos W=0.155u L=0.04u
M487 U175/net30 n116 VDD VDD pmos W=0.205u L=0.04u
M488 n179 N50 U175/net24 VDD pmos W=0.205u L=0.04u
M489 U175/net24 n124 VDD VDD pmos W=0.205u L=0.04u
M490 n179 N24 U175/net30 VDD pmos W=0.205u L=0.04u
M491 n116 N30 VSS VSS nmos W=0.135u L=0.04u
M492 n116 N30 VDD VDD pmos W=0.205u L=0.04u
M493 n124 N56 VSS VSS nmos W=0.135u L=0.04u
M494 n124 N56 VDD VDD pmos W=0.205u L=0.04u
M495 n161 N102 VSS VSS nmos W=0.135u L=0.04u
M496 n161 N102 VDD VDD pmos W=0.205u L=0.04u
M497 n177 n176 VSS VSS nmos W=0.155u L=0.04u
M498 n177 n111 VSS VSS nmos W=0.155u L=0.04u
M499 n177 n173 VSS VSS nmos W=0.155u L=0.04u
M500 U179/net25 n176 VDD VDD pmos W=0.41u L=0.04u
M501 U179/net28 n111 U179/net25 VDD pmos W=0.41u L=0.04u
M502 n177 n173 U179/net28 VDD pmos W=0.41u L=0.04u
M503 n176 N11 VSS VSS nmos W=0.155u L=0.04u
M504 n176 n120 VSS VSS nmos W=0.155u L=0.04u
M505 U180/XI1-net8 n120 VDD VDD pmos W=0.205u L=0.04u
M506 n176 N11 U180/XI1-net8 VDD pmos W=0.205u L=0.04u
M507 n120 N17 VSS VSS nmos W=0.135u L=0.04u
M508 n120 N17 VDD VDD pmos W=0.205u L=0.04u
M509 n111 N37 VSS VSS nmos W=0.155u L=0.04u
M510 n111 n153 VSS VSS nmos W=0.155u L=0.04u
M511 U182/XI1-net8 n153 VDD VDD pmos W=0.205u L=0.04u
M512 n111 N37 U182/XI1-net8 VDD pmos W=0.205u L=0.04u
M513 n153 N43 VSS VSS nmos W=0.135u L=0.04u
M514 n153 N43 VDD VDD pmos W=0.205u L=0.04u
M515 n173 N76 VSS VSS nmos W=0.155u L=0.04u
M516 n173 n136 VSS VSS nmos W=0.155u L=0.04u
M517 U184/XI1-net8 n136 VDD VDD pmos W=0.205u L=0.04u
M518 n173 N76 U184/XI1-net8 VDD pmos W=0.205u L=0.04u
M519 n136 N82 VSS VSS nmos W=0.135u L=0.04u
M520 n136 N82 VDD VDD pmos W=0.205u L=0.04u
M521 U186/net13 N89 VSS VSS nmos W=0.155u L=0.04u
M522 U186/net16 U186/net13 VSS VSS nmos W=0.155u L=0.04u
M523 n130 N95 U186/net16 VSS nmos W=0.155u L=0.04u
M524 U186/net13 N89 VDD VDD pmos W=0.205u L=0.04u
M525 VDD U186/net13 n130 VDD pmos W=0.205u L=0.04u
M526 VDD N95 n130 VDD pmos W=0.205u L=0.04u
M527 U187/net13 N1 VSS VSS nmos W=0.155u L=0.04u
M528 U187/net16 U187/net13 VSS VSS nmos W=0.155u L=0.04u
M529 n175 N4 U187/net16 VSS nmos W=0.155u L=0.04u
M530 U187/net13 N1 VDD VDD pmos W=0.205u L=0.04u
M531 VDD U187/net13 n175 VDD pmos W=0.205u L=0.04u
M532 VDD N4 n175 VDD pmos W=0.205u L=0.04u
.ENDS
