.SUBCKT s953 CK ActBmHS1 ActRtHS1 DumpIIHS1 FullIIHS1 FullOHS1 GoBmHS1 GoRtHS1 IInDoneHS1 LdProgHS1 LoadIIHHS1 LoadOHHS1 LxHIInHS1 Mode0HS1 Mode1HS1 Mode2HS1 NewLineHS1 NewTrHS1 OutAvHS1 OutputHS1 Prog_0 Prog_1 Prog_2 Rdy1BmHS1 Rdy1RtHS1 Rdy2BmHS1 Rdy2RtHS1 ReRtTSHS1 ReWhBufHS1 RtTSHS1 SeFullIIHS1 SeFullOHS1 SeOutAvHS1 ShftIIRHS1 ShftORHS1 TgWhBufHS1 TpArrayHS1 TxHIInHS1 WantBmHS1 WantRtHS1 VDD VSS
M1 NOR3_4/net7 N182 NOR3_4/X_u4-net10 VSS nmos W=0.31u L=0.04u
M2 NOR3_4/X_u4-net10 N183 NOR3_4/X_u4-net13 VSS nmos W=0.31u L=0.04u
M3 NOR3_4/X_u4-net13 n8 VSS VSS nmos W=0.31u L=0.04u
M4 II29 NOR3_4/net7 VSS VSS nmos W=0.31u L=0.04u
M5 NOR3_4/net7 n8 VDD VDD pmos W=0.41u L=0.04u
M6 NOR3_4/net7 N182 VDD VDD pmos W=0.41u L=0.04u
M7 NOR3_4/net7 N183 VDD VDD pmos W=0.41u L=0.04u
M8 II29 NOR3_4/net7 VDD VDD pmos W=0.41u L=0.04u
M9 II24 NOR2_5/net6 VSS VSS nmos W=0.31u L=0.04u
M10 NOR2_5/X_u2-net6 n190 VSS VSS nmos W=0.31u L=0.04u
M11 NOR2_5/net6 n28 NOR2_5/X_u2-net6 VSS nmos W=0.31u L=0.04u
M12 II24 NOR2_5/net6 VDD VDD pmos W=0.41u L=0.04u
M13 NOR2_5/net6 n190 VDD VDD pmos W=0.41u L=0.04u
M14 NOR2_5/net6 n28 VDD VDD pmos W=0.41u L=0.04u
M15 II27 NOR2_4/net6 VSS VSS nmos W=0.31u L=0.04u
M16 NOR2_4/X_u2-net6 FullIIHS1 VSS VSS nmos W=0.31u L=0.04u
M17 NOR2_4/net6 n28 NOR2_4/X_u2-net6 VSS nmos W=0.31u L=0.04u
M18 II27 NOR2_4/net6 VDD VDD pmos W=0.41u L=0.04u
M19 NOR2_4/net6 FullIIHS1 VDD VDD pmos W=0.41u L=0.04u
M20 NOR2_4/net6 n28 VDD VDD pmos W=0.41u L=0.04u
M21 II28 NOR2_1/net6 VSS VSS nmos W=0.31u L=0.04u
M22 NOR2_1/X_u2-net6 n24 VSS VSS nmos W=0.31u L=0.04u
M23 NOR2_1/net6 n28 NOR2_1/X_u2-net6 VSS nmos W=0.31u L=0.04u
M24 II28 NOR2_1/net6 VDD VDD pmos W=0.41u L=0.04u
M25 NOR2_1/net6 n24 VDD VDD pmos W=0.41u L=0.04u
M26 NOR2_1/net6 n28 VDD VDD pmos W=0.41u L=0.04u
M27 II30 N109 VSS VSS nmos W=0.31u L=0.04u
M28 II30 N109 VDD VDD pmos W=0.41u L=0.04u
M29 II3 N104 VSS VSS nmos W=0.31u L=0.04u
M30 II3 N104 VDD VDD pmos W=0.41u L=0.04u
M31 II22 N107 VSS VSS nmos W=0.31u L=0.04u
M32 II22 N107 VDD VDD pmos W=0.41u L=0.04u
M33 II7 II311 VSS VSS nmos W=0.31u L=0.04u
M34 II7 II311 VDD VDD pmos W=0.41u L=0.04u
M35 II10 II287 VSS VSS nmos W=0.31u L=0.04u
M36 II10 II287 VDD VDD pmos W=0.41u L=0.04u
M37 II20 II297 VSS VSS nmos W=0.31u L=0.04u
M38 II20 II297 VDD VDD pmos W=0.41u L=0.04u
M39 II21 N98 VSS VSS nmos W=0.31u L=0.04u
M40 II21 N98 VDD VDD pmos W=0.41u L=0.04u
M41 II5 N85 VSS VSS nmos W=0.31u L=0.04u
M42 II5 N85 VDD VDD pmos W=0.41u L=0.04u
M43 II9 N100 VSS VSS nmos W=0.31u L=0.04u
M44 II9 N100 VDD VDD pmos W=0.41u L=0.04u
M45 II25 N113 VSS VSS nmos W=0.31u L=0.04u
M46 II25 N113 VDD VDD pmos W=0.41u L=0.04u
M47 II12 N73 VSS VSS nmos W=0.31u L=0.04u
M48 II12 N73 VDD VDD pmos W=0.41u L=0.04u
M49 II15 N83 VSS VSS nmos W=0.31u L=0.04u
M50 II15 N83 VDD VDD pmos W=0.41u L=0.04u
M51 II26 II303 VSS VSS nmos W=0.31u L=0.04u
M52 II26 II303 VDD VDD pmos W=0.41u L=0.04u
M53 II6 N112 VSS VSS nmos W=0.31u L=0.04u
M54 II6 N112 VDD VDD pmos W=0.41u L=0.04u
M55 II17 II294 VSS VSS nmos W=0.31u L=0.04u
M56 II17 II294 VDD VDD pmos W=0.41u L=0.04u
M57 II8 N92 VSS VSS nmos W=0.31u L=0.04u
M58 II8 N92 VDD VDD pmos W=0.41u L=0.04u
M59 II11 N101 VSS VSS nmos W=0.31u L=0.04u
M60 II11 N101 VDD VDD pmos W=0.41u L=0.04u
M61 II18 II295 VSS VSS nmos W=0.31u L=0.04u
M62 II18 II295 VDD VDD pmos W=0.41u L=0.04u
M63 II2 N99 VSS VSS nmos W=0.31u L=0.04u
M64 II2 N99 VDD VDD pmos W=0.41u L=0.04u
M65 II23 II300 VSS VSS nmos W=0.31u L=0.04u
M66 II23 II300 VDD VDD pmos W=0.41u L=0.04u
M67 II4 N84 VSS VSS nmos W=0.31u L=0.04u
M68 II4 N84 VDD VDD pmos W=0.41u L=0.04u
M69 II14 N93 VSS VSS nmos W=0.31u L=0.04u
M70 II14 N93 VDD VDD pmos W=0.41u L=0.04u
M71 II16 n188 VSS VSS nmos W=0.31u L=0.04u
M72 II16 n188 VDD VDD pmos W=0.41u L=0.04u
M73 II19 N67 VSS VSS nmos W=0.31u L=0.04u
M74 II19 N67 VDD VDD pmos W=0.41u L=0.04u
M75 II13 n189 VSS VSS nmos W=0.31u L=0.04u
M76 II13 n189 VDD VDD pmos W=0.41u L=0.04u
M77 n28 OutAvHS1 VSS VSS nmos W=0.135u L=0.04u
M78 n28 OutAvHS1 VDD VDD pmos W=0.205u L=0.04u
M79 N99 n194 VSS VSS nmos W=0.155u L=0.04u
M80 N99 n193 VSS VSS nmos W=0.155u L=0.04u
M81 N99 n192 VSS VSS nmos W=0.155u L=0.04u
M82 N99 n191 VSS VSS nmos W=0.155u L=0.04u
M83 U211/net49 n193 U211/net52 VDD pmos W=0.41u L=0.04u
M84 U211/net52 n194 VDD VDD pmos W=0.41u L=0.04u
M85 U211/net46 n192 U211/net49 VDD pmos W=0.41u L=0.04u
M86 N99 n191 U211/net46 VDD pmos W=0.41u L=0.04u
M87 n194 n189 U212/net10 VSS nmos W=0.155u L=0.04u
M88 U212/net10 n197 VSS VSS nmos W=0.155u L=0.04u
M89 n194 n195 U212/net10 VSS nmos W=0.155u L=0.04u
M90 U212/net10 n196 VSS VSS nmos W=0.155u L=0.04u
M91 U212/net30 n197 VDD VDD pmos W=0.205u L=0.04u
M92 n194 n189 U212/net24 VDD pmos W=0.205u L=0.04u
M93 U212/net24 n195 VDD VDD pmos W=0.205u L=0.04u
M94 n194 n196 U212/net30 VDD pmos W=0.205u L=0.04u
M95 n197 Prog_0 U213/net27 VSS nmos W=0.155u L=0.04u
M96 U213/net27 n198 VSS VSS nmos W=0.155u L=0.04u
M97 n197 n199 VSS VSS nmos W=0.155u L=0.04u
M98 n197 n198 U213/net13 VDD pmos W=0.205u L=0.04u
M99 U213/net13 n199 VDD VDD pmos W=0.205u L=0.04u
M100 n197 Prog_0 U213/net13 VDD pmos W=0.205u L=0.04u
M101 VSS n203 U214/net22 VSS nmos W=0.155u L=0.04u
M102 U214/net22 n202 n192 VSS nmos W=0.155u L=0.04u
M103 U214/net22 n201 n192 VSS nmos W=0.155u L=0.04u
M104 U214/net22 n200 n192 VSS nmos W=0.155u L=0.04u
M105 U214/net38 n200 VDD VDD pmos W=0.205u L=0.04u
M106 U214/net35 n201 U214/net38 VDD pmos W=0.205u L=0.04u
M107 n192 n202 U214/net35 VDD pmos W=0.205u L=0.04u
M108 n192 n203 VDD VDD pmos W=0.205u L=0.04u
M109 U215/net20 n204 VSS VSS nmos W=0.155u L=0.04u
M110 n191 n206 U215/p0 VSS nmos W=0.155u L=0.04u
M111 U215/p2 U215/net20 VSS VSS nmos W=0.155u L=0.04u
M112 U215/p1 n188 U215/p2 VSS nmos W=0.155u L=0.04u
M113 U215/p0 n205 U215/p1 VSS nmos W=0.155u L=0.04u
M114 U215/net20 n204 VDD VDD pmos W=0.205u L=0.04u
M115 n191 n188 VDD VDD pmos W=0.205u L=0.04u
M116 n191 n206 VDD VDD pmos W=0.205u L=0.04u
M117 n191 n205 VDD VDD pmos W=0.205u L=0.04u
M118 n191 U215/net20 VDD VDD pmos W=0.205u L=0.04u
M119 U216/net29 n210 VSS VSS nmos W=0.155u L=0.04u
M120 n206 n209 U216/net29 VSS nmos W=0.155u L=0.04u
M121 n206 n207 U216/net23 VSS nmos W=0.155u L=0.04u
M122 U216/net23 n208 VSS VSS nmos W=0.155u L=0.04u
M123 U216/net20 n208 n206 VDD pmos W=0.205u L=0.04u
M124 U216/net20 n207 n206 VDD pmos W=0.205u L=0.04u
M125 VDD n209 U216/net20 VDD pmos W=0.205u L=0.04u
M126 VDD n210 U216/net20 VDD pmos W=0.205u L=0.04u
M127 n210 Rdy1RtHS1 U217/net10 VSS nmos W=0.155u L=0.04u
M128 U217/net10 n211 VSS VSS nmos W=0.155u L=0.04u
M129 n210 Rdy1BmHS1 U217/net10 VSS nmos W=0.155u L=0.04u
M130 U217/net10 n201 VSS VSS nmos W=0.155u L=0.04u
M131 U217/net30 n211 VDD VDD pmos W=0.205u L=0.04u
M132 n210 Rdy1RtHS1 U217/net24 VDD pmos W=0.205u L=0.04u
M133 U217/net24 Rdy1BmHS1 VDD VDD pmos W=0.205u L=0.04u
M134 n210 n201 U217/net30 VDD pmos W=0.205u L=0.04u
M135 U218/XU1-net6 n213 VSS VSS nmos W=0.155u L=0.04u
M136 n207 n212 U218/XU1-net6 VSS nmos W=0.155u L=0.04u
M137 n207 n213 VDD VDD pmos W=0.155u L=0.04u
M138 n207 n212 VDD VDD pmos W=0.155u L=0.04u
M139 N98 n216 VSS VSS nmos W=0.155u L=0.04u
M140 N98 n8 VSS VSS nmos W=0.155u L=0.04u
M141 N98 n215 VSS VSS nmos W=0.155u L=0.04u
M142 N98 n214 VSS VSS nmos W=0.155u L=0.04u
M143 U219/net49 n8 U219/net52 VDD pmos W=0.41u L=0.04u
M144 U219/net52 n216 VDD VDD pmos W=0.41u L=0.04u
M145 U219/net46 n215 U219/net49 VDD pmos W=0.41u L=0.04u
M146 N98 n214 U219/net46 VDD pmos W=0.41u L=0.04u
M147 U220/net11 n217 n215 VDD pmos W=0.205u L=0.04u
M148 U220/net11 n218 n215 VDD pmos W=0.205u L=0.04u
M149 U220/net11 n219 U220/XI16-net11 VDD pmos W=0.205u L=0.04u
M150 U220/XI16-net11 Prog_2 VDD VDD pmos W=0.205u L=0.04u
M151 n215 Prog_2 VSS VSS nmos W=0.155u L=0.04u
M152 n215 n219 VSS VSS nmos W=0.155u L=0.04u
M153 n215 n217 U220/XI12-net17 VSS nmos W=0.155u L=0.04u
M154 U220/XI12-net17 n218 VSS VSS nmos W=0.155u L=0.04u
M155 U221/XU1-net6 n221 VSS VSS nmos W=0.155u L=0.04u
M156 n218 n220 U221/XU1-net6 VSS nmos W=0.155u L=0.04u
M157 n218 n221 VDD VDD pmos W=0.155u L=0.04u
M158 n218 n220 VDD VDD pmos W=0.155u L=0.04u
M159 U222/net19 n224 VSS VSS nmos W=0.155u L=0.04u
M160 n217 n224 U222/net40 VSS nmos W=0.155u L=0.04u
M161 n217 U222/net19 U222/net36 VSS nmos W=0.155u L=0.04u
M162 U222/net40 n223 VSS VSS nmos W=0.31u L=0.04u
M163 U222/net36 n222 VSS VSS nmos W=0.155u L=0.04u
M164 U222/net19 n224 VDD VDD pmos W=0.205u L=0.04u
M165 n217 U222/net19 U222/net26 VDD pmos W=0.325u L=0.04u
M166 U222/net26 n223 VDD VDD pmos W=0.41u L=0.04u
M167 n217 n224 U222/net30 VDD pmos W=0.325u L=0.04u
M168 U222/net30 n222 VDD VDD pmos W=0.205u L=0.04u
M169 n223 FullOHS1 U223/net10 VSS nmos W=0.155u L=0.04u
M170 U223/net10 FullIIHS1 VSS VSS nmos W=0.155u L=0.04u
M171 n223 n225 U223/net10 VSS nmos W=0.155u L=0.04u
M172 U223/net10 Rdy1BmHS1 VSS VSS nmos W=0.155u L=0.04u
M173 U223/net30 FullIIHS1 VDD VDD pmos W=0.205u L=0.04u
M174 n223 FullOHS1 U223/net24 VDD pmos W=0.205u L=0.04u
M175 U223/net24 n225 VDD VDD pmos W=0.205u L=0.04u
M176 n223 Rdy1BmHS1 U223/net30 VDD pmos W=0.205u L=0.04u
M177 n222 FullIIHS1 VSS VSS nmos W=0.155u L=0.04u
M178 n222 n226 VSS VSS nmos W=0.155u L=0.04u
M179 U224/XI1-net8 n226 VDD VDD pmos W=0.205u L=0.04u
M180 n222 FullIIHS1 U224/XI1-net8 VDD pmos W=0.205u L=0.04u
M181 U225/net11 n227 N93 VDD pmos W=0.205u L=0.04u
M182 U225/net11 n228 N93 VDD pmos W=0.205u L=0.04u
M183 U225/net11 n229 U225/XI16-net11 VDD pmos W=0.205u L=0.04u
M184 U225/XI16-net11 n230 VDD VDD pmos W=0.205u L=0.04u
M185 N93 n230 VSS VSS nmos W=0.155u L=0.04u
M186 N93 n229 VSS VSS nmos W=0.155u L=0.04u
M187 N93 n227 U225/XI12-net17 VSS nmos W=0.155u L=0.04u
M188 U225/XI12-net17 n228 VSS VSS nmos W=0.155u L=0.04u
M189 U226/net19 n224 VSS VSS nmos W=0.155u L=0.04u
M190 n229 n224 U226/net40 VSS nmos W=0.155u L=0.04u
M191 n229 U226/net19 U226/net36 VSS nmos W=0.155u L=0.04u
M192 U226/net40 n231 VSS VSS nmos W=0.31u L=0.04u
M193 U226/net36 n188 VSS VSS nmos W=0.155u L=0.04u
M194 U226/net19 n224 VDD VDD pmos W=0.205u L=0.04u
M195 n229 U226/net19 U226/net26 VDD pmos W=0.325u L=0.04u
M196 U226/net26 n231 VDD VDD pmos W=0.41u L=0.04u
M197 n229 n224 U226/net30 VDD pmos W=0.325u L=0.04u
M198 U226/net30 n188 VDD VDD pmos W=0.205u L=0.04u
M199 N92 n227 VSS VSS nmos W=0.155u L=0.04u
M200 N92 n233 VSS VSS nmos W=0.155u L=0.04u
M201 N92 n232 VSS VSS nmos W=0.155u L=0.04u
M202 N92 n230 VSS VSS nmos W=0.155u L=0.04u
M203 U227/net49 n233 U227/net52 VDD pmos W=0.41u L=0.04u
M204 U227/net52 n227 VDD VDD pmos W=0.41u L=0.04u
M205 U227/net46 n232 U227/net49 VDD pmos W=0.41u L=0.04u
M206 N92 n230 U227/net46 VDD pmos W=0.41u L=0.04u
M207 n227 U228/net6 VSS VSS nmos W=0.155u L=0.04u
M208 U228/X_u2-net6 State_2 VSS VSS nmos W=0.155u L=0.04u
M209 U228/net6 n199 U228/X_u2-net6 VSS nmos W=0.155u L=0.04u
M210 n227 U228/net6 VDD VDD pmos W=0.205u L=0.04u
M211 U228/net6 State_2 VDD VDD pmos W=0.205u L=0.04u
M212 U228/net6 n199 VDD VDD pmos W=0.205u L=0.04u
M213 n232 n224 VSS VSS nmos W=0.155u L=0.04u
M214 n232 n231 VSS VSS nmos W=0.155u L=0.04u
M215 U229/XI1-net8 n231 VDD VDD pmos W=0.205u L=0.04u
M216 n232 n224 U229/XI1-net8 VDD pmos W=0.205u L=0.04u
M217 n230 U230/net6 VSS VSS nmos W=0.155u L=0.04u
M218 U230/net6 Prog_0 U230/XU30-net23 VSS nmos W=0.155u L=0.04u
M219 U230/XU30-net23 n209 U230/XU30-net26 VSS nmos W=0.155u L=0.04u
M220 U230/XU30-net26 n234 U230/XU30-net29 VSS nmos W=0.155u L=0.04u
M221 U230/XU30-net29 n211 VSS VSS nmos W=0.155u L=0.04u
M222 n230 U230/net6 VDD VDD pmos W=0.205u L=0.04u
M223 U230/net6 n211 VDD VDD pmos W=0.205u L=0.04u
M224 U230/net6 n234 VDD VDD pmos W=0.205u L=0.04u
M225 U230/net6 n209 VDD VDD pmos W=0.205u L=0.04u
M226 U230/net6 Prog_0 VDD VDD pmos W=0.205u L=0.04u
M227 N85 n238 VSS VSS nmos W=0.155u L=0.04u
M228 N85 n237 VSS VSS nmos W=0.155u L=0.04u
M229 N85 n236 VSS VSS nmos W=0.155u L=0.04u
M230 N85 n235 VSS VSS nmos W=0.155u L=0.04u
M231 U231/net49 n237 U231/net52 VDD pmos W=0.41u L=0.04u
M232 U231/net52 n238 VDD VDD pmos W=0.41u L=0.04u
M233 U231/net46 n236 U231/net49 VDD pmos W=0.41u L=0.04u
M234 N85 n235 U231/net46 VDD pmos W=0.41u L=0.04u
M235 n235 n240 U232/net26 VSS nmos W=0.155u L=0.04u
M236 n235 n239 U232/net26 VSS nmos W=0.155u L=0.04u
M237 U232/net29 n242 VSS VSS nmos W=0.155u L=0.04u
M238 U232/net26 IInDoneHS1 U232/net29 VSS nmos W=0.155u L=0.04u
M239 U232/net26 n241 U232/net29 VSS nmos W=0.155u L=0.04u
M240 n235 n239 U232/net43 VDD pmos W=0.205u L=0.04u
M241 n235 n241 U232/net49 VDD pmos W=0.205u L=0.04u
M242 U232/net49 IInDoneHS1 VDD VDD pmos W=0.205u L=0.04u
M243 U232/net43 n240 VDD VDD pmos W=0.205u L=0.04u
M244 n235 n242 VDD VDD pmos W=0.205u L=0.04u
M245 U233/net11 n243 N84 VDD pmos W=0.205u L=0.04u
M246 U233/net11 n234 N84 VDD pmos W=0.205u L=0.04u
M247 U233/net11 n244 U233/XI16-net11 VDD pmos W=0.205u L=0.04u
M248 U233/XI16-net11 n245 VDD VDD pmos W=0.205u L=0.04u
M249 N84 n245 VSS VSS nmos W=0.155u L=0.04u
M250 N84 n244 VSS VSS nmos W=0.155u L=0.04u
M251 N84 n243 U233/XI12-net17 VSS nmos W=0.155u L=0.04u
M252 U233/XI12-net17 n234 VSS VSS nmos W=0.155u L=0.04u
M253 U234/net32 n214 VSS VSS nmos W=0.155u L=0.04u
M254 U234/net59 n246 U234/net32 VSS nmos W=0.155u L=0.04u
M255 U234/net59 n247 VSS VSS nmos W=0.155u L=0.04u
M256 n244 U234/net59 VSS VSS nmos W=0.155u L=0.04u
M257 n244 U234/net59 VDD VDD pmos W=0.2u L=0.04u
M258 U234/net59 n246 U234/net22 VDD pmos W=0.205u L=0.04u
M259 U234/net59 n214 U234/net22 VDD pmos W=0.205u L=0.04u
M260 U234/net22 n247 VDD VDD pmos W=0.2u L=0.04u
M261 U235/net36 n248 U235/net24 VSS nmos W=0.155u L=0.04u
M262 U235/net24 n205 VSS VSS nmos W=0.155u L=0.04u
M263 U235/net33 n195 U235/net36 VSS nmos W=0.155u L=0.04u
M264 U235/net33 n188 U235/net36 VSS nmos W=0.155u L=0.04u
M265 N83 U235/net33 VSS VSS nmos W=0.155u L=0.04u
M266 N83 U235/net33 VDD VDD pmos W=0.205u L=0.04u
M267 U235/net33 n188 U235/net35 VDD pmos W=0.205u L=0.04u
M268 U235/net35 n195 VDD VDD pmos W=0.205u L=0.04u
M269 U235/net33 n205 VDD VDD pmos W=0.205u L=0.04u
M270 U235/net33 n248 VDD VDD pmos W=0.205u L=0.04u
M271 n205 n249 U236/XI0-net10 VSS nmos W=0.155u L=0.04u
M272 U236/XI0-net10 n250 U236/XI0-net13 VSS nmos W=0.155u L=0.04u
M273 U236/XI0-net13 n251 VSS VSS nmos W=0.155u L=0.04u
M274 n205 n251 VDD VDD pmos W=0.205u L=0.04u
M275 n205 n249 VDD VDD pmos W=0.205u L=0.04u
M276 n205 n250 VDD VDD pmos W=0.205u L=0.04u
M277 n195 Prog_1 VSS VSS nmos W=0.135u L=0.04u
M278 n195 Prog_1 VDD VDD pmos W=0.205u L=0.04u
M279 N73 n252 VSS VSS nmos W=0.135u L=0.04u
M280 N73 n252 VDD VDD pmos W=0.205u L=0.04u
M281 U239/net11 n253 N113 VDD pmos W=0.205u L=0.04u
M282 U239/net11 n221 N113 VDD pmos W=0.205u L=0.04u
M283 U239/net11 n254 U239/XI16-net11 VDD pmos W=0.205u L=0.04u
M284 U239/XI16-net11 n255 VDD VDD pmos W=0.205u L=0.04u
M285 N113 n255 VSS VSS nmos W=0.155u L=0.04u
M286 N113 n254 VSS VSS nmos W=0.155u L=0.04u
M287 N113 n253 U239/XI12-net17 VSS nmos W=0.155u L=0.04u
M288 U239/XI12-net17 n221 VSS VSS nmos W=0.155u L=0.04u
M289 U240/net36 n258 U240/net24 VSS nmos W=0.155u L=0.04u
M290 U240/net24 n259 VSS VSS nmos W=0.155u L=0.04u
M291 n254 n256 U240/net36 VSS nmos W=0.155u L=0.04u
M292 n254 n257 U240/net36 VSS nmos W=0.155u L=0.04u
M293 n254 n257 U240/net35 VDD pmos W=0.205u L=0.04u
M294 U240/net35 n256 VDD VDD pmos W=0.205u L=0.04u
M295 n254 n259 VDD VDD pmos W=0.205u L=0.04u
M296 n254 n258 VDD VDD pmos W=0.205u L=0.04u
M297 U241/p2 n221 VSS VSS nmos W=0.155u L=0.04u
M298 U241/p0 n220 U241/p1 VSS nmos W=0.155u L=0.04u
M299 U241/p1 Rdy2RtHS1 U241/p2 VSS nmos W=0.155u L=0.04u
M300 n258 n260 U241/p0 VSS nmos W=0.155u L=0.04u
M301 n258 Rdy2RtHS1 VDD VDD pmos W=0.205u L=0.04u
M302 n258 n220 VDD VDD pmos W=0.205u L=0.04u
M303 n258 n260 VDD VDD pmos W=0.205u L=0.04u
M304 n258 n221 VDD VDD pmos W=0.205u L=0.04u
M305 n256 OutputHS1 U242/net27 VSS nmos W=0.155u L=0.04u
M306 U242/net27 n233 VSS VSS nmos W=0.155u L=0.04u
M307 n256 n261 VSS VSS nmos W=0.155u L=0.04u
M308 n256 n233 U242/net13 VDD pmos W=0.205u L=0.04u
M309 U242/net13 n261 VDD VDD pmos W=0.205u L=0.04u
M310 n256 OutputHS1 U242/net13 VDD pmos W=0.205u L=0.04u
M311 N112 U243/net15 VSS VSS nmos W=0.155u L=0.04u
M312 N112 n263 VSS VSS nmos W=0.155u L=0.04u
M313 N112 n264 VSS VSS nmos W=0.155u L=0.04u
M314 N112 n265 VSS VSS nmos W=0.155u L=0.04u
M315 U243/net15 n262 VSS VSS nmos W=0.155u L=0.04u
M316 N112 n265 U243/XU8-net7 VDD pmos W=0.41u L=0.04u
M317 U243/XU8-net7 n264 U243/XU8-net10 VDD pmos W=0.41u L=0.04u
M318 U243/XU8-net10 n263 U243/XU8-net13 VDD pmos W=0.41u L=0.04u
M319 U243/XU8-net13 U243/net15 VDD VDD pmos W=0.41u L=0.04u
M320 U243/net15 n262 VDD VDD pmos W=0.31u L=0.04u
M321 n264 n266 U244/net15 VSS nmos W=0.155u L=0.04u
M322 n264 n225 U244/net15 VSS nmos W=0.155u L=0.04u
M323 U244/net15 n267 VSS VSS nmos W=0.155u L=0.04u
M324 n264 n267 VDD VDD pmos W=0.205u L=0.04u
M325 n264 n266 U244/XI16-net11 VDD pmos W=0.205u L=0.04u
M326 U244/XI16-net11 n225 VDD VDD pmos W=0.205u L=0.04u
M327 U245/net29 n270 VSS VSS nmos W=0.155u L=0.04u
M328 n266 WantBmHS1 U245/net29 VSS nmos W=0.155u L=0.04u
M329 n266 n268 U245/net23 VSS nmos W=0.155u L=0.04u
M330 U245/net23 n269 VSS VSS nmos W=0.155u L=0.04u
M331 U245/net20 n269 n266 VDD pmos W=0.205u L=0.04u
M332 U245/net20 n268 n266 VDD pmos W=0.205u L=0.04u
M333 VDD WantBmHS1 U245/net20 VDD pmos W=0.205u L=0.04u
M334 VDD n270 U245/net20 VDD pmos W=0.205u L=0.04u
M335 n270 State_1 U246/net15 VSS nmos W=0.155u L=0.04u
M336 n270 n271 U246/net15 VSS nmos W=0.155u L=0.04u
M337 U246/net15 n272 VSS VSS nmos W=0.155u L=0.04u
M338 n270 n272 VDD VDD pmos W=0.205u L=0.04u
M339 n270 State_1 U246/XI16-net11 VDD pmos W=0.205u L=0.04u
M340 U246/XI16-net11 n271 VDD VDD pmos W=0.205u L=0.04u
M341 U247/net36 n275 U247/net24 VSS nmos W=0.155u L=0.04u
M342 U247/net24 n276 VSS VSS nmos W=0.155u L=0.04u
M343 n263 n273 U247/net36 VSS nmos W=0.155u L=0.04u
M344 n263 n274 U247/net36 VSS nmos W=0.155u L=0.04u
M345 n263 n274 U247/net35 VDD pmos W=0.205u L=0.04u
M346 U247/net35 n273 VDD VDD pmos W=0.205u L=0.04u
M347 n263 n276 VDD VDD pmos W=0.205u L=0.04u
M348 n263 n275 VDD VDD pmos W=0.205u L=0.04u
M349 n276 State_1 U248/net23 VDD pmos W=0.205u L=0.04u
M350 n276 n278 U248/net23 VDD pmos W=0.205u L=0.04u
M351 n276 n277 U248/net23 VDD pmos W=0.205u L=0.04u
M352 U248/net23 n245 VDD VDD pmos W=0.205u L=0.04u
M353 U248/net23 n257 VDD VDD pmos W=0.205u L=0.04u
M354 U248/XI20-net13 n278 VSS VSS nmos W=0.155u L=0.04u
M355 n276 State_1 U248/XI20-net17 VSS nmos W=0.155u L=0.04u
M356 U248/XI20-net17 n277 U248/XI20-net13 VSS nmos W=0.155u L=0.04u
M357 n276 n245 U248/XI17-net17 VSS nmos W=0.155u L=0.04u
M358 U248/XI17-net17 n257 VSS VSS nmos W=0.155u L=0.04u
M359 n278 N182 VSS VSS nmos W=0.155u L=0.04u
M360 n278 n196 VSS VSS nmos W=0.155u L=0.04u
M361 U249/XI1-net8 n196 VDD VDD pmos W=0.205u L=0.04u
M362 n278 N182 U249/XI1-net8 VDD pmos W=0.205u L=0.04u
M363 U250/net36 n281 U250/net24 VSS nmos W=0.155u L=0.04u
M364 U250/net24 n199 VSS VSS nmos W=0.155u L=0.04u
M365 n275 n279 U250/net36 VSS nmos W=0.155u L=0.04u
M366 n275 n280 U250/net36 VSS nmos W=0.155u L=0.04u
M367 n275 n280 U250/net35 VDD pmos W=0.205u L=0.04u
M368 U250/net35 n279 VDD VDD pmos W=0.205u L=0.04u
M369 n275 n199 VDD VDD pmos W=0.205u L=0.04u
M370 n275 n281 VDD VDD pmos W=0.205u L=0.04u
M371 n281 n282 VSS VSS nmos W=0.135u L=0.04u
M372 n281 n282 VDD VDD pmos W=0.205u L=0.04u
M373 N109 n283 VSS VSS nmos W=0.155u L=0.04u
M374 N109 n284 VSS VSS nmos W=0.155u L=0.04u
M375 U252/XI1-net8 n284 VDD VDD pmos W=0.205u L=0.04u
M376 N109 n283 U252/XI1-net8 VDD pmos W=0.205u L=0.04u
M377 n284 n285 VSS VSS nmos W=0.155u L=0.04u
M378 n284 n272 VSS VSS nmos W=0.155u L=0.04u
M379 n284 Prog_0 VSS VSS nmos W=0.155u L=0.04u
M380 n284 WantBmHS1 VSS VSS nmos W=0.155u L=0.04u
M381 U253/net49 n272 U253/net52 VDD pmos W=0.41u L=0.04u
M382 U253/net52 n285 VDD VDD pmos W=0.41u L=0.04u
M383 U253/net46 Prog_0 U253/net49 VDD pmos W=0.41u L=0.04u
M384 n284 WantBmHS1 U253/net46 VDD pmos W=0.41u L=0.04u
M385 N107 U254/net15 VSS VSS nmos W=0.155u L=0.04u
M386 N107 n287 VSS VSS nmos W=0.155u L=0.04u
M387 N107 n288 VSS VSS nmos W=0.155u L=0.04u
M388 N107 n289 VSS VSS nmos W=0.155u L=0.04u
M389 U254/net15 n286 VSS VSS nmos W=0.155u L=0.04u
M390 N107 n289 U254/XU8-net7 VDD pmos W=0.41u L=0.04u
M391 U254/XU8-net7 n288 U254/XU8-net10 VDD pmos W=0.41u L=0.04u
M392 U254/XU8-net10 n287 U254/XU8-net13 VDD pmos W=0.41u L=0.04u
M393 U254/XU8-net13 U254/net15 VDD VDD pmos W=0.41u L=0.04u
M394 U254/net15 n286 VDD VDD pmos W=0.31u L=0.04u
M395 n288 WantBmHS1 U255/net15 VSS nmos W=0.155u L=0.04u
M396 n288 n290 U255/net15 VSS nmos W=0.155u L=0.04u
M397 U255/net15 n259 VSS VSS nmos W=0.155u L=0.04u
M398 n288 n259 VDD VDD pmos W=0.205u L=0.04u
M399 n288 WantBmHS1 U255/XI16-net11 VDD pmos W=0.205u L=0.04u
M400 U255/XI16-net11 n290 VDD VDD pmos W=0.205u L=0.04u
M401 U256/net17 Rdy2RtHS1 VSS VSS nmos W=0.155u L=0.04u
M402 U256/net17 n271 VSS VSS nmos W=0.155u L=0.04u
M403 U256/net63 n285 VSS VSS nmos W=0.155u L=0.04u
M404 n290 U256/net17 VSS VSS nmos W=0.155u L=0.04u
M405 n290 n291 U256/net63 VSS nmos W=0.155u L=0.04u
M406 n290 n285 U256/net31 VDD pmos W=0.205u L=0.04u
M407 U256/net39 Rdy2RtHS1 VDD VDD pmos W=0.195u L=0.04u
M408 U256/net31 U256/net17 VDD VDD pmos W=0.195u L=0.04u
M409 n290 n291 U256/net31 VDD pmos W=0.195u L=0.04u
M410 U256/net17 n271 U256/net39 VDD pmos W=0.195u L=0.04u
M411 U257/net36 n293 U257/net24 VSS nmos W=0.155u L=0.04u
M412 U257/net24 n294 VSS VSS nmos W=0.155u L=0.04u
M413 n287 FullOHS1 U257/net36 VSS nmos W=0.155u L=0.04u
M414 n287 n292 U257/net36 VSS nmos W=0.155u L=0.04u
M415 n287 n292 U257/net35 VDD pmos W=0.205u L=0.04u
M416 U257/net35 FullOHS1 VDD VDD pmos W=0.205u L=0.04u
M417 n287 n294 VDD VDD pmos W=0.205u L=0.04u
M418 n287 n293 VDD VDD pmos W=0.205u L=0.04u
M419 n294 n255 VSS VSS nmos W=0.135u L=0.04u
M420 n294 n255 VDD VDD pmos W=0.205u L=0.04u
M421 n255 n295 U259/net14 VSS nmos W=0.155u L=0.04u
M422 U259/net14 n246 VSS VSS nmos W=0.155u L=0.04u
M423 U259/net14 n242 VSS VSS nmos W=0.155u L=0.04u
M424 n255 n296 U259/net14 VSS nmos W=0.155u L=0.04u
M425 n255 N183 U259/net14 VSS nmos W=0.155u L=0.04u
M426 n255 n246 U259/XI16-net11 VDD pmos W=0.205u L=0.04u
M427 U259/XI16-net11 n242 VDD VDD pmos W=0.205u L=0.04u
M428 n255 n296 U259/XI15-net11 VDD pmos W=0.205u L=0.04u
M429 U259/XI15-net11 N183 U259/XI15-net18 VDD pmos W=0.205u L=0.04u
M430 U259/XI15-net18 n295 VDD VDD pmos W=0.205u L=0.04u
M431 n246 TpArrayHS1 VSS VSS nmos W=0.135u L=0.04u
M432 n246 TpArrayHS1 VDD VDD pmos W=0.205u L=0.04u
M433 U261/XU1-net6 State_1 VSS VSS nmos W=0.155u L=0.04u
M434 n242 n214 U261/XU1-net6 VSS nmos W=0.155u L=0.04u
M435 n242 State_1 VDD VDD pmos W=0.155u L=0.04u
M436 n242 n214 VDD VDD pmos W=0.155u L=0.04u
M437 U262/net20 n297 VSS VSS nmos W=0.155u L=0.04u
M438 n293 n221 U262/p0 VSS nmos W=0.155u L=0.04u
M439 U262/p2 U262/net20 VSS VSS nmos W=0.155u L=0.04u
M440 U262/p1 n298 U262/p2 VSS nmos W=0.155u L=0.04u
M441 U262/p0 n208 U262/p1 VSS nmos W=0.155u L=0.04u
M442 U262/net20 n297 VDD VDD pmos W=0.205u L=0.04u
M443 n293 n298 VDD VDD pmos W=0.205u L=0.04u
M444 n293 n221 VDD VDD pmos W=0.205u L=0.04u
M445 n293 n208 VDD VDD pmos W=0.205u L=0.04u
M446 n293 U262/net20 VDD VDD pmos W=0.205u L=0.04u
M447 N104 n299 VSS VSS nmos W=0.155u L=0.04u
M448 N104 n300 VSS VSS nmos W=0.155u L=0.04u
M449 U263/XI1-net8 n300 VDD VDD pmos W=0.205u L=0.04u
M450 N104 n299 U263/XI1-net8 VDD pmos W=0.205u L=0.04u
M451 n300 n272 U264/net14 VSS nmos W=0.155u L=0.04u
M452 U264/net14 n188 VSS VSS nmos W=0.155u L=0.04u
M453 U264/net14 IInDoneHS1 VSS VSS nmos W=0.155u L=0.04u
M454 n300 n224 U264/net14 VSS nmos W=0.155u L=0.04u
M455 n300 n301 U264/net14 VSS nmos W=0.155u L=0.04u
M456 n300 n188 U264/XI16-net11 VDD pmos W=0.205u L=0.04u
M457 U264/XI16-net11 IInDoneHS1 VDD VDD pmos W=0.205u L=0.04u
M458 n300 n224 U264/XI15-net11 VDD pmos W=0.205u L=0.04u
M459 U264/XI15-net11 n301 U264/XI15-net18 VDD pmos W=0.205u L=0.04u
M460 U264/XI15-net18 n272 VDD VDD pmos W=0.205u L=0.04u
M461 n299 n302 U265/net14 VSS nmos W=0.155u L=0.04u
M462 U265/net14 n228 VSS VSS nmos W=0.155u L=0.04u
M463 U265/net14 n305 VSS VSS nmos W=0.155u L=0.04u
M464 n299 n304 U265/net14 VSS nmos W=0.155u L=0.04u
M465 n299 n303 U265/net14 VSS nmos W=0.155u L=0.04u
M466 n299 n228 U265/XI16-net11 VDD pmos W=0.205u L=0.04u
M467 U265/XI16-net11 n305 VDD VDD pmos W=0.205u L=0.04u
M468 n299 n304 U265/XI15-net11 VDD pmos W=0.205u L=0.04u
M469 U265/XI15-net11 n303 U265/XI15-net18 VDD pmos W=0.205u L=0.04u
M470 U265/XI15-net18 n302 VDD VDD pmos W=0.205u L=0.04u
M471 n305 n193 VSS VSS nmos W=0.155u L=0.04u
M472 n305 n199 U266/XI17-net17 VSS nmos W=0.155u L=0.04u
M473 U266/XI17-net17 n226 VSS VSS nmos W=0.155u L=0.04u
M474 n305 n306 U266/XI10-net17 VSS nmos W=0.155u L=0.04u
M475 U266/XI10-net17 n225 VSS VSS nmos W=0.155u L=0.04u
M476 U266/net30 n306 n305 VDD pmos W=0.205u L=0.04u
M477 U266/net30 n225 n305 VDD pmos W=0.205u L=0.04u
M478 VDD n193 U266/net36 VDD pmos W=0.205u L=0.04u
M479 U266/net36 n226 U266/net30 VDD pmos W=0.205u L=0.04u
M480 U266/net36 n199 U266/net30 VDD pmos W=0.205u L=0.04u
M481 n304 Rdy2BmHS1 U267/net27 VSS nmos W=0.155u L=0.04u
M482 U267/net27 n307 VSS VSS nmos W=0.155u L=0.04u
M483 n304 n308 VSS VSS nmos W=0.155u L=0.04u
M484 n304 n307 U267/net13 VDD pmos W=0.205u L=0.04u
M485 U267/net13 n308 VDD VDD pmos W=0.205u L=0.04u
M486 n304 Rdy2BmHS1 U267/net13 VDD pmos W=0.205u L=0.04u
M487 N101 n236 VSS VSS nmos W=0.155u L=0.04u
M488 N101 n238 VSS VSS nmos W=0.155u L=0.04u
M489 N101 n310 VSS VSS nmos W=0.155u L=0.04u
M490 N101 n309 VSS VSS nmos W=0.155u L=0.04u
M491 U268/net49 n238 U268/net52 VDD pmos W=0.41u L=0.04u
M492 U268/net52 n236 VDD VDD pmos W=0.41u L=0.04u
M493 U268/net46 n310 U268/net49 VDD pmos W=0.41u L=0.04u
M494 N101 n309 U268/net46 VDD pmos W=0.41u L=0.04u
M495 n236 U269/net6 VSS VSS nmos W=0.155u L=0.04u
M496 U269/X_u2-net6 n311 VSS VSS nmos W=0.155u L=0.04u
M497 U269/net6 n268 U269/X_u2-net6 VSS nmos W=0.155u L=0.04u
M498 n236 U269/net6 VDD VDD pmos W=0.205u L=0.04u
M499 U269/net6 n311 VDD VDD pmos W=0.205u L=0.04u
M500 U269/net6 n268 VDD VDD pmos W=0.205u L=0.04u
M501 U270/net7 n312 U270/X_u4-net10 VSS nmos W=0.155u L=0.04u
M502 U270/X_u4-net10 n313 U270/X_u4-net13 VSS nmos W=0.155u L=0.04u
M503 U270/X_u4-net13 State_0 VSS VSS nmos W=0.155u L=0.04u
M504 n268 U270/net7 VSS VSS nmos W=0.155u L=0.04u
M505 U270/net7 State_0 VDD VDD pmos W=0.205u L=0.04u
M506 U270/net7 n312 VDD VDD pmos W=0.205u L=0.04u
M507 U270/net7 n313 VDD VDD pmos W=0.205u L=0.04u
M508 n268 U270/net7 VDD VDD pmos W=0.205u L=0.04u
M509 n309 n314 U271/net10 VSS nmos W=0.155u L=0.04u
M510 U271/net10 n316 VSS VSS nmos W=0.155u L=0.04u
M511 n309 n286 U271/net10 VSS nmos W=0.155u L=0.04u
M512 U271/net10 n315 VSS VSS nmos W=0.155u L=0.04u
M513 U271/net30 n316 VDD VDD pmos W=0.205u L=0.04u
M514 n309 n314 U271/net24 VDD pmos W=0.205u L=0.04u
M515 U271/net24 n286 VDD VDD pmos W=0.205u L=0.04u
M516 n309 n315 U271/net30 VDD pmos W=0.205u L=0.04u
M517 n316 n298 U272/net27 VSS nmos W=0.155u L=0.04u
M518 U272/net27 n311 VSS VSS nmos W=0.155u L=0.04u
M519 n316 n253 VSS VSS nmos W=0.155u L=0.04u
M520 n316 n311 U272/net13 VDD pmos W=0.205u L=0.04u
M521 U272/net13 n253 VDD VDD pmos W=0.205u L=0.04u
M522 n316 n298 U272/net13 VDD pmos W=0.205u L=0.04u
M523 n253 n317 VSS VSS nmos W=0.135u L=0.04u
M524 n253 n317 VDD VDD pmos W=0.205u L=0.04u
M525 U274/net20 n303 VSS VSS nmos W=0.155u L=0.04u
M526 n286 n319 U274/p0 VSS nmos W=0.155u L=0.04u
M527 U274/p2 U274/net20 VSS VSS nmos W=0.155u L=0.04u
M528 U274/p1 n311 U274/p2 VSS nmos W=0.155u L=0.04u
M529 U274/p0 n318 U274/p1 VSS nmos W=0.155u L=0.04u
M530 U274/net20 n303 VDD VDD pmos W=0.205u L=0.04u
M531 n286 n311 VDD VDD pmos W=0.205u L=0.04u
M532 n286 n319 VDD VDD pmos W=0.205u L=0.04u
M533 n286 n318 VDD VDD pmos W=0.205u L=0.04u
M534 n286 U274/net20 VDD VDD pmos W=0.205u L=0.04u
M535 n319 State_4 VSS VSS nmos W=0.155u L=0.04u
M536 n319 n190 VSS VSS nmos W=0.155u L=0.04u
M537 U275/XI1-net8 n190 VDD VDD pmos W=0.205u L=0.04u
M538 n319 State_4 U275/XI1-net8 VDD pmos W=0.205u L=0.04u
M539 n303 n285 VSS VSS nmos W=0.155u L=0.04u
M540 n303 n320 VSS VSS nmos W=0.155u L=0.04u
M541 U276/XI1-net8 n320 VDD VDD pmos W=0.205u L=0.04u
M542 n303 n285 U276/XI1-net8 VDD pmos W=0.205u L=0.04u
M543 U277/net11 n306 N100 VDD pmos W=0.205u L=0.04u
M544 U277/net11 State_2 N100 VDD pmos W=0.205u L=0.04u
M545 U277/net11 n252 U277/XI16-net11 VDD pmos W=0.205u L=0.04u
M546 U277/XI16-net11 n321 VDD VDD pmos W=0.205u L=0.04u
M547 N100 n321 VSS VSS nmos W=0.155u L=0.04u
M548 N100 n252 VSS VSS nmos W=0.155u L=0.04u
M549 N100 n306 U277/XI12-net17 VSS nmos W=0.155u L=0.04u
M550 U277/XI12-net17 State_2 VSS VSS nmos W=0.155u L=0.04u
M551 U278/net29 n188 VSS VSS nmos W=0.155u L=0.04u
M552 n321 Prog_0 U278/net29 VSS nmos W=0.155u L=0.04u
M553 n321 N67 U278/net23 VSS nmos W=0.155u L=0.04u
M554 U278/net23 n322 VSS VSS nmos W=0.155u L=0.04u
M555 U278/net20 n322 n321 VDD pmos W=0.205u L=0.04u
M556 U278/net20 N67 n321 VDD pmos W=0.205u L=0.04u
M557 VDD Prog_0 U278/net20 VDD pmos W=0.205u L=0.04u
M558 VDD n188 U278/net20 VDD pmos W=0.205u L=0.04u
M559 N67 U279/net6 VSS VSS nmos W=0.155u L=0.04u
M560 U279/X_u2-net6 n188 VSS VSS nmos W=0.155u L=0.04u
M561 U279/net6 n323 U279/X_u2-net6 VSS nmos W=0.155u L=0.04u
M562 N67 U279/net6 VDD VDD pmos W=0.205u L=0.04u
M563 U279/net6 n188 VDD VDD pmos W=0.205u L=0.04u
M564 U279/net6 n323 VDD VDD pmos W=0.205u L=0.04u
M565 U280/XU1-net6 n267 VSS VSS nmos W=0.155u L=0.04u
M566 n252 n324 U280/XU1-net6 VSS nmos W=0.155u L=0.04u
M567 n252 n267 VDD VDD pmos W=0.155u L=0.04u
M568 n252 n324 VDD VDD pmos W=0.155u L=0.04u
M569 n267 n214 VSS VSS nmos W=0.135u L=0.04u
M570 n267 n214 VDD VDD pmos W=0.205u L=0.04u
M571 U282/net36 n202 U282/net24 VSS nmos W=0.155u L=0.04u
M572 U282/net24 n243 VSS VSS nmos W=0.155u L=0.04u
M573 n324 State_2 U282/net36 VSS nmos W=0.155u L=0.04u
M574 n324 n325 U282/net36 VSS nmos W=0.155u L=0.04u
M575 n324 n325 U282/net35 VDD pmos W=0.205u L=0.04u
M576 U282/net35 State_2 VDD VDD pmos W=0.205u L=0.04u
M577 n324 n243 VDD VDD pmos W=0.205u L=0.04u
M578 n324 n202 VDD VDD pmos W=0.205u L=0.04u
M579 II311 n328 VSS VSS nmos W=0.155u L=0.04u
M580 II311 n247 VSS VSS nmos W=0.155u L=0.04u
M581 II311 n327 VSS VSS nmos W=0.155u L=0.04u
M582 II311 n326 VSS VSS nmos W=0.155u L=0.04u
M583 U283/net49 n247 U283/net52 VDD pmos W=0.41u L=0.04u
M584 U283/net52 n328 VDD VDD pmos W=0.41u L=0.04u
M585 U283/net46 n327 U283/net49 VDD pmos W=0.41u L=0.04u
M586 II311 n326 U283/net46 VDD pmos W=0.41u L=0.04u
M587 n328 n212 U284/net14 VSS nmos W=0.155u L=0.04u
M588 U284/net14 n273 VSS VSS nmos W=0.155u L=0.04u
M589 U284/net14 FullOHS1 VSS VSS nmos W=0.155u L=0.04u
M590 n328 n329 U284/net14 VSS nmos W=0.155u L=0.04u
M591 n328 n282 U284/net14 VSS nmos W=0.155u L=0.04u
M592 n328 n273 U284/XI16-net11 VDD pmos W=0.205u L=0.04u
M593 U284/XI16-net11 FullOHS1 VDD VDD pmos W=0.205u L=0.04u
M594 n328 n329 U284/XI15-net11 VDD pmos W=0.205u L=0.04u
M595 U284/XI15-net11 n282 U284/XI15-net18 VDD pmos W=0.205u L=0.04u
M596 U284/XI15-net18 n212 VDD VDD pmos W=0.205u L=0.04u
M597 U285/XU35-net6 n331 VSS VSS nmos W=0.155u L=0.04u
M598 U285/net5 n330 U285/XU35-net6 VSS nmos W=0.155u L=0.04u
M599 U285/XU36-net6 U285/net5 VSS VSS nmos W=0.155u L=0.04u
M600 n273 n332 U285/XU36-net6 VSS nmos W=0.155u L=0.04u
M601 U285/net5 n331 VDD VDD pmos W=0.205u L=0.04u
M602 U285/net5 n330 VDD VDD pmos W=0.205u L=0.04u
M603 n273 U285/net5 VDD VDD pmos W=0.205u L=0.04u
M604 n273 n332 VDD VDD pmos W=0.205u L=0.04u
M605 n329 n208 VSS VSS nmos W=0.155u L=0.04u
M606 n329 n279 VSS VSS nmos W=0.155u L=0.04u
M607 U286/XI1-net8 n279 VDD VDD pmos W=0.205u L=0.04u
M608 n329 n208 U286/XI1-net8 VDD pmos W=0.205u L=0.04u
M609 n208 n333 VSS VSS nmos W=0.135u L=0.04u
M610 n208 n333 VDD VDD pmos W=0.205u L=0.04u
M611 n282 n279 VSS VSS nmos W=0.155u L=0.04u
M612 n282 U288/net4 VSS VSS nmos W=0.155u L=0.04u
M613 U288/net4 n251 VSS VSS nmos W=0.155u L=0.04u
M614 U288/XU1-net8 U288/net4 VDD VDD pmos W=0.205u L=0.04u
M615 n282 n279 U288/XU1-net8 VDD pmos W=0.205u L=0.04u
M616 U288/net4 n251 VDD VDD pmos W=0.205u L=0.04u
M617 n279 n334 U289/net15 VSS nmos W=0.155u L=0.04u
M618 n279 n313 U289/net15 VSS nmos W=0.155u L=0.04u
M619 U289/net15 N183 VSS VSS nmos W=0.155u L=0.04u
M620 n279 N183 VDD VDD pmos W=0.205u L=0.04u
M621 n279 n334 U289/XI16-net11 VDD pmos W=0.205u L=0.04u
M622 U289/XI16-net11 n313 VDD VDD pmos W=0.205u L=0.04u
M623 n334 Prog_2 VSS VSS nmos W=0.155u L=0.04u
M624 n334 n257 VSS VSS nmos W=0.155u L=0.04u
M625 U290/XI1-net8 n257 VDD VDD pmos W=0.205u L=0.04u
M626 n334 Prog_2 U290/XI1-net8 VDD pmos W=0.205u L=0.04u
M627 U291/XU1-net6 n336 VSS VSS nmos W=0.155u L=0.04u
M628 n247 n335 U291/XU1-net6 VSS nmos W=0.155u L=0.04u
M629 n247 n336 VDD VDD pmos W=0.155u L=0.04u
M630 n247 n335 VDD VDD pmos W=0.155u L=0.04u
M631 VSS n262 U292/net22 VSS nmos W=0.155u L=0.04u
M632 U292/net22 n226 n327 VSS nmos W=0.155u L=0.04u
M633 U292/net22 Rdy1RtHS1 n327 VSS nmos W=0.155u L=0.04u
M634 U292/net22 n337 n327 VSS nmos W=0.155u L=0.04u
M635 U292/net38 n337 VDD VDD pmos W=0.205u L=0.04u
M636 U292/net35 Rdy1RtHS1 U292/net38 VDD pmos W=0.205u L=0.04u
M637 n327 n226 U292/net35 VDD pmos W=0.205u L=0.04u
M638 n327 n262 VDD VDD pmos W=0.205u L=0.04u
M639 U293/p2 n190 VSS VSS nmos W=0.155u L=0.04u
M640 U293/p0 State_1 U293/p1 VSS nmos W=0.155u L=0.04u
M641 U293/p1 State_0 U293/p2 VSS nmos W=0.155u L=0.04u
M642 n262 n209 U293/p0 VSS nmos W=0.155u L=0.04u
M643 n262 State_0 VDD VDD pmos W=0.205u L=0.04u
M644 n262 State_1 VDD VDD pmos W=0.205u L=0.04u
M645 n262 n209 VDD VDD pmos W=0.205u L=0.04u
M646 n262 n190 VDD VDD pmos W=0.205u L=0.04u
M647 U294/net11 n297 n326 VDD pmos W=0.205u L=0.04u
M648 U294/net11 WantBmHS1 n326 VDD pmos W=0.205u L=0.04u
M649 U294/net11 n285 U294/XI16-net11 VDD pmos W=0.205u L=0.04u
M650 U294/XI16-net11 n272 VDD VDD pmos W=0.205u L=0.04u
M651 n326 n272 VSS VSS nmos W=0.155u L=0.04u
M652 n326 n285 VSS VSS nmos W=0.155u L=0.04u
M653 n326 n297 U294/XI12-net17 VSS nmos W=0.155u L=0.04u
M654 U294/XI12-net17 WantBmHS1 VSS VSS nmos W=0.155u L=0.04u
M655 U295/XU1-net6 Rdy2RtHS1 VSS VSS nmos W=0.155u L=0.04u
M656 n272 n291 U295/XU1-net6 VSS nmos W=0.155u L=0.04u
M657 n272 Rdy2RtHS1 VDD VDD pmos W=0.155u L=0.04u
M658 n272 n291 VDD VDD pmos W=0.155u L=0.04u
M659 II303 n283 VSS VSS nmos W=0.155u L=0.04u
M660 II303 n339 VSS VSS nmos W=0.155u L=0.04u
M661 II303 U296/net12 VSS VSS nmos W=0.155u L=0.04u
M662 U296/net12 n338 VSS VSS nmos W=0.155u L=0.04u
M663 U296/XU9-net9 U296/net12 VDD VDD pmos W=0.41u L=0.04u
M664 U296/XU9-net12 n339 U296/XU9-net9 VDD pmos W=0.41u L=0.04u
M665 II303 n283 U296/XU9-net12 VDD pmos W=0.41u L=0.04u
M666 U296/net12 n338 VDD VDD pmos W=0.31u L=0.04u
M667 n339 n257 U297/net10 VSS nmos W=0.155u L=0.04u
M668 U297/net10 n274 VSS VSS nmos W=0.155u L=0.04u
M669 n339 n323 U297/net10 VSS nmos W=0.155u L=0.04u
M670 U297/net10 n317 VSS VSS nmos W=0.155u L=0.04u
M671 U297/net30 n274 VDD VDD pmos W=0.205u L=0.04u
M672 n339 n257 U297/net24 VDD pmos W=0.205u L=0.04u
M673 U297/net24 n323 VDD VDD pmos W=0.205u L=0.04u
M674 n339 n317 U297/net30 VDD pmos W=0.205u L=0.04u
M675 n317 Rdy2BmHS1 U298/XI0-net10 VSS nmos W=0.155u L=0.04u
M676 U298/XI0-net10 n269 U298/XI0-net13 VSS nmos W=0.155u L=0.04u
M677 U298/XI0-net13 n298 VSS VSS nmos W=0.155u L=0.04u
M678 n317 n298 VDD VDD pmos W=0.205u L=0.04u
M679 n317 Rdy2BmHS1 VDD VDD pmos W=0.205u L=0.04u
M680 n317 n269 VDD VDD pmos W=0.205u L=0.04u
M681 n298 n213 VSS VSS nmos W=0.155u L=0.04u
M682 n298 State_0 VSS VSS nmos W=0.155u L=0.04u
M683 n298 U299/net12 VSS VSS nmos W=0.155u L=0.04u
M684 U299/net12 n251 VSS VSS nmos W=0.155u L=0.04u
M685 U299/XU9-net9 U299/net12 VDD VDD pmos W=0.41u L=0.04u
M686 U299/XU9-net12 State_0 U299/XU9-net9 VDD pmos W=0.41u L=0.04u
M687 n298 n213 U299/XU9-net12 VDD pmos W=0.41u L=0.04u
M688 U299/net12 n251 VDD VDD pmos W=0.31u L=0.04u
M689 U300/net13 n231 VSS VSS nmos W=0.155u L=0.04u
M690 U300/net16 U300/net13 VSS VSS nmos W=0.155u L=0.04u
M691 n323 N183 U300/net16 VSS nmos W=0.155u L=0.04u
M692 U300/net13 n231 VDD VDD pmos W=0.205u L=0.04u
M693 VDD U300/net13 n323 VDD pmos W=0.205u L=0.04u
M694 VDD N183 n323 VDD pmos W=0.205u L=0.04u
M695 U301/XU1-net6 n251 VSS VSS nmos W=0.155u L=0.04u
M696 n231 n199 U301/XU1-net6 VSS nmos W=0.155u L=0.04u
M697 n231 n251 VDD VDD pmos W=0.155u L=0.04u
M698 n231 n199 VDD VDD pmos W=0.155u L=0.04u
M699 U302/net7 n250 U302/X_u4-net10 VSS nmos W=0.155u L=0.04u
M700 U302/X_u4-net10 n202 U302/X_u4-net13 VSS nmos W=0.155u L=0.04u
M701 U302/X_u4-net13 State_1 VSS VSS nmos W=0.155u L=0.04u
M702 n199 U302/net7 VSS VSS nmos W=0.155u L=0.04u
M703 U302/net7 State_1 VDD VDD pmos W=0.205u L=0.04u
M704 U302/net7 n250 VDD VDD pmos W=0.205u L=0.04u
M705 U302/net7 n202 VDD VDD pmos W=0.205u L=0.04u
M706 n199 U302/net7 VDD VDD pmos W=0.205u L=0.04u
M707 n257 IInDoneHS1 VSS VSS nmos W=0.135u L=0.04u
M708 n257 IInDoneHS1 VDD VDD pmos W=0.205u L=0.04u
M709 II300 n332 U304/net19 VDD pmos W=0.205u L=0.04u
M710 II300 n341 U304/net19 VDD pmos W=0.205u L=0.04u
M711 II300 n340 U304/net19 VDD pmos W=0.205u L=0.04u
M712 U304/net19 n342 VDD VDD pmos W=0.205u L=0.04u
M713 II300 n342 VSS VSS nmos W=0.155u L=0.04u
M714 U304/XI20-net13 n341 VSS VSS nmos W=0.155u L=0.04u
M715 II300 n332 U304/XI20-net17 VSS nmos W=0.155u L=0.04u
M716 U304/XI20-net17 n340 U304/XI20-net13 VSS nmos W=0.155u L=0.04u
M717 U305/net13 n283 VSS VSS nmos W=0.155u L=0.04u
M718 U305/net16 U305/net13 VSS VSS nmos W=0.155u L=0.04u
M719 n342 n338 U305/net16 VSS nmos W=0.155u L=0.04u
M720 U305/net13 n283 VDD VDD pmos W=0.205u L=0.04u
M721 VDD U305/net13 n342 VDD pmos W=0.205u L=0.04u
M722 VDD n338 n342 VDD pmos W=0.205u L=0.04u
M723 U306/p2 n344 VSS VSS nmos W=0.155u L=0.04u
M724 U306/p0 n209 U306/p1 VSS nmos W=0.155u L=0.04u
M725 U306/p1 n343 U306/p2 VSS nmos W=0.155u L=0.04u
M726 n338 Rdy2RtHS1 U306/p0 VSS nmos W=0.155u L=0.04u
M727 n338 n343 VDD VDD pmos W=0.205u L=0.04u
M728 n338 n209 VDD VDD pmos W=0.205u L=0.04u
M729 n338 Rdy2RtHS1 VDD VDD pmos W=0.205u L=0.04u
M730 n338 n344 VDD VDD pmos W=0.205u L=0.04u
M731 U307/net15 n347 VSS VSS nmos W=0.155u L=0.04u
M732 U307/net15 n346 VSS VSS nmos W=0.155u L=0.04u
M733 n344 n345 U307/net15 VSS nmos W=0.155u L=0.04u
M734 n344 Prog_2 U307/net15 VSS nmos W=0.155u L=0.04u
M735 U307/net15 n285 VSS VSS nmos W=0.155u L=0.04u
M736 n344 n274 U307/net15 VSS nmos W=0.155u L=0.04u
M737 n344 n285 U307/XI1-net11 VDD pmos W=0.205u L=0.04u
M738 U307/XI1-net11 n347 U307/XI1-net18 VDD pmos W=0.205u L=0.04u
M739 U307/XI1-net18 n346 VDD VDD pmos W=0.205u L=0.04u
M740 n344 n345 U307/XI7-net11 VDD pmos W=0.205u L=0.04u
M741 U307/XI7-net11 Prog_2 U307/XI7-net18 VDD pmos W=0.205u L=0.04u
M742 U307/XI7-net18 n274 VDD VDD pmos W=0.205u L=0.04u
M743 U308/XU1-net6 n314 VSS VSS nmos W=0.155u L=0.04u
M744 n346 n224 U308/XU1-net6 VSS nmos W=0.155u L=0.04u
M745 n346 n314 VDD VDD pmos W=0.155u L=0.04u
M746 n346 n224 VDD VDD pmos W=0.155u L=0.04u
M747 n345 n220 VSS VSS nmos W=0.135u L=0.04u
M748 n345 n220 VDD VDD pmos W=0.205u L=0.04u
M749 n220 n224 VSS VSS nmos W=0.155u L=0.04u
M750 n220 Rdy1RtHS1 VSS VSS nmos W=0.155u L=0.04u
M751 U310/XI1-net8 Rdy1RtHS1 VDD VDD pmos W=0.205u L=0.04u
M752 n220 n224 U310/XI1-net8 VDD pmos W=0.205u L=0.04u
M753 n274 n341 VSS VSS nmos W=0.135u L=0.04u
M754 n274 n341 VDD VDD pmos W=0.205u L=0.04u
M755 n283 n307 VSS VSS nmos W=0.155u L=0.04u
M756 n283 U312/net4 VSS VSS nmos W=0.155u L=0.04u
M757 U312/net4 n265 VSS VSS nmos W=0.155u L=0.04u
M758 U312/XU1-net8 U312/net4 VDD VDD pmos W=0.205u L=0.04u
M759 n283 n307 U312/XU1-net8 VDD pmos W=0.205u L=0.04u
M760 U312/net4 n265 VDD VDD pmos W=0.205u L=0.04u
M761 U313/net4 n224 U313/net14 VSS nmos W=0.155u L=0.04u
M762 U313/net6 U313/net10 U313/net14 VSS nmos W=0.17u L=0.04u
M763 U313/net4 Prog_1 VSS VSS nmos W=0.155u L=0.04u
M764 U313/net6 U313/net4 VSS VSS nmos W=0.17u L=0.04u
M765 n307 U313/net14 VSS VSS nmos W=0.155u L=0.04u
M766 U313/net10 n224 VSS VSS nmos W=0.155u L=0.04u
M767 U313/net4 U313/net10 U313/net14 VDD pmos W=0.255u L=0.04u
M768 U313/net6 n224 U313/net14 VDD pmos W=0.28u L=0.04u
M769 U313/net4 Prog_1 VDD VDD pmos W=0.205u L=0.04u
M770 U313/net6 U313/net4 VDD VDD pmos W=0.24u L=0.04u
M771 n307 U313/net14 VDD VDD pmos W=0.205u L=0.04u
M772 U313/net10 n224 VDD VDD pmos W=0.205u L=0.04u
M773 n265 WantRtHS1 VSS VSS nmos W=0.155u L=0.04u
M774 n265 n225 VSS VSS nmos W=0.155u L=0.04u
M775 n265 n302 VSS VSS nmos W=0.155u L=0.04u
M776 n265 n314 VSS VSS nmos W=0.155u L=0.04u
M777 U314/net49 n225 U314/net52 VDD pmos W=0.41u L=0.04u
M778 U314/net52 WantRtHS1 VDD VDD pmos W=0.41u L=0.04u
M779 U314/net46 n302 U314/net49 VDD pmos W=0.41u L=0.04u
M780 n265 n314 U314/net46 VDD pmos W=0.41u L=0.04u
M781 n302 n291 VSS VSS nmos W=0.135u L=0.04u
M782 n302 n291 VDD VDD pmos W=0.205u L=0.04u
M783 n291 n203 VSS VSS nmos W=0.155u L=0.04u
M784 n291 State_4 VSS VSS nmos W=0.155u L=0.04u
M785 n291 n190 VSS VSS nmos W=0.155u L=0.04u
M786 U316/net25 n203 VDD VDD pmos W=0.41u L=0.04u
M787 U316/net28 State_4 U316/net25 VDD pmos W=0.41u L=0.04u
M788 n291 n190 U316/net28 VDD pmos W=0.41u L=0.04u
M789 U317/XU1-net6 n202 VSS VSS nmos W=0.155u L=0.04u
M790 n203 n318 U317/XU1-net6 VSS nmos W=0.155u L=0.04u
M791 n203 n202 VDD VDD pmos W=0.155u L=0.04u
M792 n203 n318 VDD VDD pmos W=0.155u L=0.04u
M793 n341 n221 VSS VSS nmos W=0.155u L=0.04u
M794 n341 FullIIHS1 VSS VSS nmos W=0.155u L=0.04u
M795 U318/XI1-net8 FullIIHS1 VDD VDD pmos W=0.205u L=0.04u
M796 n341 n221 U318/XI1-net8 VDD pmos W=0.205u L=0.04u
M797 n340 n297 U319/net15 VSS nmos W=0.155u L=0.04u
M798 n340 n333 U319/net15 VSS nmos W=0.155u L=0.04u
M799 U319/net15 n330 VSS VSS nmos W=0.155u L=0.04u
M800 n340 n330 VDD VDD pmos W=0.205u L=0.04u
M801 n340 n297 U319/XI16-net11 VDD pmos W=0.205u L=0.04u
M802 U319/XI16-net11 n333 VDD VDD pmos W=0.205u L=0.04u
M803 n297 Rdy2BmHS1 VSS VSS nmos W=0.155u L=0.04u
M804 n297 Rdy1BmHS1 VSS VSS nmos W=0.155u L=0.04u
M805 U320/XI1-net8 Rdy1BmHS1 VDD VDD pmos W=0.205u L=0.04u
M806 n297 Rdy2BmHS1 U320/XI1-net8 VDD pmos W=0.205u L=0.04u
M807 n332 n330 U321/net27 VSS nmos W=0.155u L=0.04u
M808 U321/net27 Prog_0 VSS VSS nmos W=0.155u L=0.04u
M809 n332 n348 VSS VSS nmos W=0.155u L=0.04u
M810 n332 Prog_0 U321/net13 VDD pmos W=0.205u L=0.04u
M811 U321/net13 n348 VDD VDD pmos W=0.205u L=0.04u
M812 n332 n330 U321/net13 VDD pmos W=0.205u L=0.04u
M813 U322/XU1-net6 Prog_0 VSS VSS nmos W=0.155u L=0.04u
M814 n330 n320 U322/XU1-net6 VSS nmos W=0.155u L=0.04u
M815 n330 Prog_0 VDD VDD pmos W=0.155u L=0.04u
M816 n330 n320 VDD VDD pmos W=0.155u L=0.04u
M817 II297 n350 VSS VSS nmos W=0.155u L=0.04u
M818 II297 n214 VSS VSS nmos W=0.155u L=0.04u
M819 II297 n8 VSS VSS nmos W=0.155u L=0.04u
M820 II297 n349 VSS VSS nmos W=0.155u L=0.04u
M821 U323/net49 n214 U323/net52 VDD pmos W=0.41u L=0.04u
M822 U323/net52 n350 VDD VDD pmos W=0.41u L=0.04u
M823 U323/net46 n8 U323/net49 VDD pmos W=0.41u L=0.04u
M824 II297 n349 U323/net46 VDD pmos W=0.41u L=0.04u
M825 n350 State_2 VSS VSS nmos W=0.155u L=0.04u
M826 n350 State_4 VSS VSS nmos W=0.155u L=0.04u
M827 n350 N182 VSS VSS nmos W=0.155u L=0.04u
M828 n350 n351 VSS VSS nmos W=0.155u L=0.04u
M829 U324/net49 State_4 U324/net52 VDD pmos W=0.41u L=0.04u
M830 U324/net52 State_2 VDD VDD pmos W=0.41u L=0.04u
M831 U324/net46 N182 U324/net49 VDD pmos W=0.41u L=0.04u
M832 n350 n351 U324/net46 VDD pmos W=0.41u L=0.04u
M833 U325/XU1-net6 n343 VSS VSS nmos W=0.155u L=0.04u
M834 n351 Prog_2 U325/XU1-net6 VSS nmos W=0.155u L=0.04u
M835 n351 n343 VDD VDD pmos W=0.155u L=0.04u
M836 n351 Prog_2 VDD VDD pmos W=0.155u L=0.04u
M837 n349 n219 U326/net14 VSS nmos W=0.155u L=0.04u
M838 U326/net14 n353 VSS VSS nmos W=0.155u L=0.04u
M839 U326/net14 Rdy2BmHS1 VSS VSS nmos W=0.155u L=0.04u
M840 n349 n352 U326/net14 VSS nmos W=0.155u L=0.04u
M841 n349 Rdy2RtHS1 U326/net14 VSS nmos W=0.155u L=0.04u
M842 n349 n353 U326/XI16-net11 VDD pmos W=0.205u L=0.04u
M843 U326/XI16-net11 Rdy2BmHS1 VDD VDD pmos W=0.205u L=0.04u
M844 n349 n352 U326/XI15-net11 VDD pmos W=0.205u L=0.04u
M845 U326/XI15-net11 Rdy2RtHS1 U326/XI15-net18 VDD pmos W=0.205u L=0.04u
M846 U326/XI15-net18 n219 VDD VDD pmos W=0.205u L=0.04u
M847 U327/net11 n213 VSS VSS nmos W=0.155u L=0.04u
M848 U327/net11 n315 VSS VSS nmos W=0.155u L=0.04u
M849 n353 n318 VSS VSS nmos W=0.155u L=0.04u
M850 n353 U327/net11 VSS VSS nmos W=0.155u L=0.04u
M851 U327/XI1-net8 n315 VDD VDD pmos W=0.205u L=0.04u
M852 U327/net11 n213 U327/XI1-net8 VDD pmos W=0.205u L=0.04u
M853 U327/XU39-net8 U327/net11 VDD VDD pmos W=0.205u L=0.04u
M854 n353 n318 U327/XU39-net8 VDD pmos W=0.205u L=0.04u
M855 n318 U328/net6 VSS VSS nmos W=0.155u L=0.04u
M856 U328/X_u2-net6 Prog_2 VSS VSS nmos W=0.155u L=0.04u
M857 U328/net6 n312 U328/X_u2-net6 VSS nmos W=0.155u L=0.04u
M858 n318 U328/net6 VDD VDD pmos W=0.205u L=0.04u
M859 U328/net6 Prog_2 VDD VDD pmos W=0.205u L=0.04u
M860 U328/net6 n312 VDD VDD pmos W=0.205u L=0.04u
M861 U329/XU1-net6 n224 VSS VSS nmos W=0.155u L=0.04u
M862 n213 n312 U329/XU1-net6 VSS nmos W=0.155u L=0.04u
M863 n213 n224 VDD VDD pmos W=0.155u L=0.04u
M864 n213 n312 VDD VDD pmos W=0.155u L=0.04u
M865 U330/net14 n315 U330/net20 VSS nmos W=0.155u L=0.04u
M866 U330/net14 n224 U330/net20 VSS nmos W=0.155u L=0.04u
M867 U330/net20 n211 VSS VSS nmos W=0.155u L=0.04u
M868 n352 U330/net14 VSS VSS nmos W=0.155u L=0.04u
M869 n352 U330/net14 VDD VDD pmos W=0.205u L=0.04u
M870 U330/net14 n211 VDD VDD pmos W=0.205u L=0.04u
M871 U330/net24 n315 VDD VDD pmos W=0.205u L=0.04u
M872 U330/net14 n224 U330/net24 VDD pmos W=0.205u L=0.04u
M873 n224 Prog_0 VSS VSS nmos W=0.135u L=0.04u
M874 n224 Prog_0 VDD VDD pmos W=0.205u L=0.04u
M875 II295 n214 VSS VSS nmos W=0.155u L=0.04u
M876 II295 n245 VSS VSS nmos W=0.155u L=0.04u
M877 II295 n233 VSS VSS nmos W=0.155u L=0.04u
M878 II295 n354 VSS VSS nmos W=0.155u L=0.04u
M879 U332/net49 n245 U332/net52 VDD pmos W=0.41u L=0.04u
M880 U332/net52 n214 VDD VDD pmos W=0.41u L=0.04u
M881 U332/net46 n233 U332/net49 VDD pmos W=0.41u L=0.04u
M882 II295 n354 U332/net46 VDD pmos W=0.41u L=0.04u
M883 n214 n295 VSS VSS nmos W=0.155u L=0.04u
M884 n214 State_2 VSS VSS nmos W=0.155u L=0.04u
M885 n214 n202 VSS VSS nmos W=0.155u L=0.04u
M886 U333/net25 n295 VDD VDD pmos W=0.41u L=0.04u
M887 U333/net28 State_2 U333/net25 VDD pmos W=0.41u L=0.04u
M888 n214 n202 U333/net28 VDD pmos W=0.41u L=0.04u
M889 n245 n240 VSS VSS nmos W=0.155u L=0.04u
M890 n245 n325 VSS VSS nmos W=0.155u L=0.04u
M891 n245 U334/net12 VSS VSS nmos W=0.155u L=0.04u
M892 U334/net12 N182 VSS VSS nmos W=0.155u L=0.04u
M893 U334/XU9-net9 U334/net12 VDD VDD pmos W=0.41u L=0.04u
M894 U334/XU9-net12 n325 U334/XU9-net9 VDD pmos W=0.41u L=0.04u
M895 n245 n240 U334/XU9-net12 VDD pmos W=0.41u L=0.04u
M896 U334/net12 N182 VDD VDD pmos W=0.31u L=0.04u
M897 n233 n188 VSS VSS nmos W=0.135u L=0.04u
M898 n233 n188 VDD VDD pmos W=0.205u L=0.04u
M899 n188 n312 U336/XI0-net10 VSS nmos W=0.155u L=0.04u
M900 U336/XI0-net10 n202 U336/XI0-net13 VSS nmos W=0.155u L=0.04u
M901 U336/XI0-net13 State_4 VSS VSS nmos W=0.155u L=0.04u
M902 n188 State_4 VDD VDD pmos W=0.205u L=0.04u
M903 n188 n312 VDD VDD pmos W=0.205u L=0.04u
M904 n188 n202 VDD VDD pmos W=0.205u L=0.04u
M905 U337/net7 n250 U337/X_u4-net10 VSS nmos W=0.155u L=0.04u
M906 U337/X_u4-net10 n325 U337/X_u4-net13 VSS nmos W=0.155u L=0.04u
M907 U337/X_u4-net13 N183 VSS VSS nmos W=0.155u L=0.04u
M908 n312 U337/net7 VSS VSS nmos W=0.155u L=0.04u
M909 U337/net7 N183 VDD VDD pmos W=0.205u L=0.04u
M910 U337/net7 n250 VDD VDD pmos W=0.205u L=0.04u
M911 U337/net7 n325 VDD VDD pmos W=0.205u L=0.04u
M912 n312 U337/net7 VDD VDD pmos W=0.205u L=0.04u
M913 U338/net13 n261 VSS VSS nmos W=0.155u L=0.04u
M914 U338/net16 U338/net13 VSS VSS nmos W=0.155u L=0.04u
M915 n354 n335 U338/net16 VSS nmos W=0.155u L=0.04u
M916 U338/net13 n261 VDD VDD pmos W=0.205u L=0.04u
M917 VDD U338/net13 n354 VDD pmos W=0.205u L=0.04u
M918 VDD n335 n354 VDD pmos W=0.205u L=0.04u
M919 n335 n325 U339/XI0-net10 VSS nmos W=0.155u L=0.04u
M920 U339/XI0-net10 N183 U339/XI0-net13 VSS nmos W=0.155u L=0.04u
M921 U339/XI0-net13 n243 VSS VSS nmos W=0.155u L=0.04u
M922 n335 n243 VDD VDD pmos W=0.205u L=0.04u
M923 n335 n325 VDD VDD pmos W=0.205u L=0.04u
M924 n335 N183 VDD VDD pmos W=0.205u L=0.04u
M925 n243 n295 VSS VSS nmos W=0.135u L=0.04u
M926 n243 n295 VDD VDD pmos W=0.205u L=0.04u
M927 n295 n228 U341/XI0-net10 VSS nmos W=0.155u L=0.04u
M928 U341/XI0-net10 n355 U341/XI0-net13 VSS nmos W=0.155u L=0.04u
M929 U341/XI0-net13 N182 VSS VSS nmos W=0.155u L=0.04u
M930 n295 N182 VDD VDD pmos W=0.205u L=0.04u
M931 n295 n228 VDD VDD pmos W=0.205u L=0.04u
M932 n295 n355 VDD VDD pmos W=0.205u L=0.04u
M933 U342/XU1-net6 n322 VSS VSS nmos W=0.155u L=0.04u
M934 n261 n248 U342/XU1-net6 VSS nmos W=0.155u L=0.04u
M935 n261 n322 VDD VDD pmos W=0.155u L=0.04u
M936 n261 n248 VDD VDD pmos W=0.155u L=0.04u
M937 U343/XU1-net6 n251 VSS VSS nmos W=0.155u L=0.04u
M938 n322 n306 U343/XU1-net6 VSS nmos W=0.155u L=0.04u
M939 n322 n251 VDD VDD pmos W=0.155u L=0.04u
M940 n322 n306 VDD VDD pmos W=0.155u L=0.04u
M941 n306 n212 VSS VSS nmos W=0.135u L=0.04u
M942 n306 n212 VDD VDD pmos W=0.205u L=0.04u
M943 U345/XU1-net6 n250 VSS VSS nmos W=0.155u L=0.04u
M944 n212 n234 U345/XU1-net6 VSS nmos W=0.155u L=0.04u
M945 n212 n250 VDD VDD pmos W=0.155u L=0.04u
M946 n212 n234 VDD VDD pmos W=0.155u L=0.04u
M947 n234 n202 VSS VSS nmos W=0.155u L=0.04u
M948 n234 State_1 VSS VSS nmos W=0.155u L=0.04u
M949 U346/XI1-net8 State_1 VDD VDD pmos W=0.205u L=0.04u
M950 n234 n202 U346/XI1-net8 VDD pmos W=0.205u L=0.04u
M951 U347/XU1-net6 n228 VSS VSS nmos W=0.155u L=0.04u
M952 n248 n193 U347/XU1-net6 VSS nmos W=0.155u L=0.04u
M953 n248 n228 VDD VDD pmos W=0.155u L=0.04u
M954 n248 n193 VDD VDD pmos W=0.155u L=0.04u
M955 n193 n241 VSS VSS nmos W=0.135u L=0.04u
M956 n193 n241 VDD VDD pmos W=0.205u L=0.04u
M957 n241 n250 U349/XI0-net10 VSS nmos W=0.155u L=0.04u
M958 U349/XI0-net10 State_2 U349/XI0-net13 VSS nmos W=0.155u L=0.04u
M959 U349/XI0-net13 n249 VSS VSS nmos W=0.155u L=0.04u
M960 n241 n249 VDD VDD pmos W=0.205u L=0.04u
M961 n241 n250 VDD VDD pmos W=0.205u L=0.04u
M962 n241 State_2 VDD VDD pmos W=0.205u L=0.04u
M963 II294 n289 VSS VSS nmos W=0.155u L=0.04u
M964 II294 n310 VSS VSS nmos W=0.155u L=0.04u
M965 II294 n356 VSS VSS nmos W=0.155u L=0.04u
M966 II294 n204 VSS VSS nmos W=0.155u L=0.04u
M967 U350/net49 n310 U350/net52 VDD pmos W=0.41u L=0.04u
M968 U350/net52 n289 VDD VDD pmos W=0.41u L=0.04u
M969 U350/net46 n356 U350/net49 VDD pmos W=0.41u L=0.04u
M970 II294 n204 U350/net46 VDD pmos W=0.41u L=0.04u
M971 n289 U351/net6 VSS VSS nmos W=0.155u L=0.04u
M972 U351/net6 n357 U351/XU30-net23 VSS nmos W=0.155u L=0.04u
M973 U351/XU30-net23 n358 U351/XU30-net26 VSS nmos W=0.155u L=0.04u
M974 U351/XU30-net26 n209 U351/XU30-net29 VSS nmos W=0.155u L=0.04u
M975 U351/XU30-net29 n249 VSS VSS nmos W=0.155u L=0.04u
M976 n289 U351/net6 VDD VDD pmos W=0.205u L=0.04u
M977 U351/net6 n249 VDD VDD pmos W=0.205u L=0.04u
M978 U351/net6 n209 VDD VDD pmos W=0.205u L=0.04u
M979 U351/net6 n358 VDD VDD pmos W=0.205u L=0.04u
M980 U351/net6 n357 VDD VDD pmos W=0.205u L=0.04u
M981 n249 State_0 U352/net27 VSS nmos W=0.155u L=0.04u
M982 U352/net27 State_1 VSS VSS nmos W=0.155u L=0.04u
M983 n249 n343 VSS VSS nmos W=0.155u L=0.04u
M984 n249 State_1 U352/net13 VDD pmos W=0.205u L=0.04u
M985 U352/net13 n343 VDD VDD pmos W=0.205u L=0.04u
M986 n249 State_0 U352/net13 VDD pmos W=0.205u L=0.04u
M987 n209 n200 VSS VSS nmos W=0.135u L=0.04u
M988 n209 n200 VDD VDD pmos W=0.205u L=0.04u
M989 U354/net19 n325 VSS VSS nmos W=0.155u L=0.04u
M990 n357 n325 U354/net40 VSS nmos W=0.155u L=0.04u
M991 n357 U354/net19 U354/net36 VSS nmos W=0.155u L=0.04u
M992 U354/net40 n331 VSS VSS nmos W=0.31u L=0.04u
M993 U354/net36 n359 VSS VSS nmos W=0.155u L=0.04u
M994 U354/net19 n325 VDD VDD pmos W=0.205u L=0.04u
M995 n357 U354/net19 U354/net26 VDD pmos W=0.325u L=0.04u
M996 U354/net26 n331 VDD VDD pmos W=0.41u L=0.04u
M997 n357 n325 U354/net30 VDD pmos W=0.325u L=0.04u
M998 U354/net30 n359 VDD VDD pmos W=0.205u L=0.04u
M999 n331 n311 VSS VSS nmos W=0.135u L=0.04u
M1000 n331 n311 VDD VDD pmos W=0.205u L=0.04u
M1001 U356/net13 n238 VSS VSS nmos W=0.155u L=0.04u
M1002 U356/net16 U356/net13 VSS VSS nmos W=0.155u L=0.04u
M1003 n356 n348 U356/net16 VSS nmos W=0.155u L=0.04u
M1004 U356/net13 n238 VDD VDD pmos W=0.205u L=0.04u
M1005 VDD U356/net13 n356 VDD pmos W=0.205u L=0.04u
M1006 VDD n348 n356 VDD pmos W=0.205u L=0.04u
M1007 n238 n336 VSS VSS nmos W=0.155u L=0.04u
M1008 n238 N182 VSS VSS nmos W=0.155u L=0.04u
M1009 U357/XI1-net8 N182 VDD VDD pmos W=0.205u L=0.04u
M1010 n238 n336 U357/XI1-net8 VDD pmos W=0.205u L=0.04u
M1011 U358/p2 N183 VSS VSS nmos W=0.155u L=0.04u
M1012 U358/p0 n333 U358/p1 VSS nmos W=0.155u L=0.04u
M1013 U358/p1 n201 U358/p2 VSS nmos W=0.155u L=0.04u
M1014 n336 n8 U358/p0 VSS nmos W=0.155u L=0.04u
M1015 n336 n201 VDD VDD pmos W=0.205u L=0.04u
M1016 n336 n333 VDD VDD pmos W=0.205u L=0.04u
M1017 n336 n8 VDD VDD pmos W=0.205u L=0.04u
M1018 n336 N183 VDD VDD pmos W=0.205u L=0.04u
M1019 n333 n225 VSS VSS nmos W=0.155u L=0.04u
M1020 n333 n269 VSS VSS nmos W=0.155u L=0.04u
M1021 U359/XI1-net8 n269 VDD VDD pmos W=0.205u L=0.04u
M1022 n333 n225 U359/XI1-net8 VDD pmos W=0.205u L=0.04u
M1023 n225 Rdy2BmHS1 VSS VSS nmos W=0.135u L=0.04u
M1024 n225 Rdy2BmHS1 VDD VDD pmos W=0.205u L=0.04u
M1025 n8 n296 VSS VSS nmos W=0.155u L=0.04u
M1026 n8 State_5 VSS VSS nmos W=0.155u L=0.04u
M1027 n8 State_4 VSS VSS nmos W=0.155u L=0.04u
M1028 U361/net25 n296 VDD VDD pmos W=0.41u L=0.04u
M1029 U361/net28 State_5 U361/net25 VDD pmos W=0.41u L=0.04u
M1030 n8 State_4 U361/net28 VDD pmos W=0.41u L=0.04u
M1031 n296 n343 VSS VSS nmos W=0.135u L=0.04u
M1032 n296 n343 VDD VDD pmos W=0.205u L=0.04u
M1033 n343 State_1 VSS VSS nmos W=0.155u L=0.04u
M1034 n343 State_0 VSS VSS nmos W=0.155u L=0.04u
M1035 U363/XI1-net8 State_0 VDD VDD pmos W=0.205u L=0.04u
M1036 n343 State_1 U363/XI1-net8 VDD pmos W=0.205u L=0.04u
M1037 n204 n211 VSS VSS nmos W=0.155u L=0.04u
M1038 n204 n189 VSS VSS nmos W=0.155u L=0.04u
M1039 U364/XI1-net8 n189 VDD VDD pmos W=0.205u L=0.04u
M1040 n204 n211 U364/XI1-net8 VDD pmos W=0.205u L=0.04u
M1041 U365/net13 n240 VSS VSS nmos W=0.155u L=0.04u
M1042 U365/net16 U365/net13 VSS VSS nmos W=0.155u L=0.04u
M1043 n189 n239 U365/net16 VSS nmos W=0.155u L=0.04u
M1044 U365/net13 n240 VDD VDD pmos W=0.205u L=0.04u
M1045 VDD U365/net13 n189 VDD pmos W=0.205u L=0.04u
M1046 VDD n239 n189 VDD pmos W=0.205u L=0.04u
M1047 n239 State_1 VSS VSS nmos W=0.155u L=0.04u
M1048 n239 N182 VSS VSS nmos W=0.155u L=0.04u
M1049 n239 U366/net12 VSS VSS nmos W=0.155u L=0.04u
M1050 U366/net12 RtTSHS1 VSS VSS nmos W=0.155u L=0.04u
M1051 U366/XU9-net9 U366/net12 VDD VDD pmos W=0.41u L=0.04u
M1052 U366/XU9-net12 N182 U366/XU9-net9 VDD pmos W=0.41u L=0.04u
M1053 n239 State_1 U366/XU9-net12 VDD pmos W=0.41u L=0.04u
M1054 U366/net12 RtTSHS1 VDD VDD pmos W=0.31u L=0.04u
M1055 II287 n237 VSS VSS nmos W=0.155u L=0.04u
M1056 II287 n361 VSS VSS nmos W=0.155u L=0.04u
M1057 II287 n310 VSS VSS nmos W=0.155u L=0.04u
M1058 II287 n360 VSS VSS nmos W=0.155u L=0.04u
M1059 U367/net49 n361 U367/net52 VDD pmos W=0.41u L=0.04u
M1060 U367/net52 n237 VDD VDD pmos W=0.41u L=0.04u
M1061 U367/net46 n310 U367/net49 VDD pmos W=0.41u L=0.04u
M1062 II287 n360 U367/net46 VDD pmos W=0.41u L=0.04u
M1063 n237 n337 VSS VSS nmos W=0.155u L=0.04u
M1064 n237 n359 VSS VSS nmos W=0.155u L=0.04u
M1065 U368/XI1-net8 n359 VDD VDD pmos W=0.205u L=0.04u
M1066 n237 n337 U368/XI1-net8 VDD pmos W=0.205u L=0.04u
M1067 n359 n320 VSS VSS nmos W=0.135u L=0.04u
M1068 n359 n320 VDD VDD pmos W=0.205u L=0.04u
M1069 n320 n362 VSS VSS nmos W=0.155u L=0.04u
M1070 n320 Rdy2RtHS1 VSS VSS nmos W=0.155u L=0.04u
M1071 U370/XI1-net8 Rdy2RtHS1 VDD VDD pmos W=0.205u L=0.04u
M1072 n320 n362 U370/XI1-net8 VDD pmos W=0.205u L=0.04u
M1073 n337 State_1 U371/XI0-net10 VSS nmos W=0.155u L=0.04u
M1074 U371/XI0-net10 n313 U371/XI0-net13 VSS nmos W=0.155u L=0.04u
M1075 U371/XI0-net13 n198 VSS VSS nmos W=0.155u L=0.04u
M1076 n337 n198 VDD VDD pmos W=0.205u L=0.04u
M1077 n337 State_1 VDD VDD pmos W=0.205u L=0.04u
M1078 n337 n313 VDD VDD pmos W=0.205u L=0.04u
M1079 U372/XU1-net6 n347 VSS VSS nmos W=0.155u L=0.04u
M1080 n313 n228 U372/XU1-net6 VSS nmos W=0.155u L=0.04u
M1081 n313 n347 VDD VDD pmos W=0.155u L=0.04u
M1082 n313 n228 VDD VDD pmos W=0.155u L=0.04u
M1083 n347 n358 VSS VSS nmos W=0.135u L=0.04u
M1084 n347 n358 VDD VDD pmos W=0.205u L=0.04u
M1085 n361 n280 VSS VSS nmos W=0.155u L=0.04u
M1086 n361 n325 VSS VSS nmos W=0.155u L=0.04u
M1087 n361 n240 VSS VSS nmos W=0.155u L=0.04u
M1088 n361 N182 VSS VSS nmos W=0.155u L=0.04u
M1089 U374/net49 n325 U374/net52 VDD pmos W=0.41u L=0.04u
M1090 U374/net52 n280 VDD VDD pmos W=0.41u L=0.04u
M1091 U374/net46 n240 U374/net49 VDD pmos W=0.41u L=0.04u
M1092 n361 N182 U374/net46 VDD pmos W=0.41u L=0.04u
M1093 U375/XU1-net6 n355 VSS VSS nmos W=0.155u L=0.04u
M1094 n240 n277 U375/XU1-net6 VSS nmos W=0.155u L=0.04u
M1095 n240 n355 VDD VDD pmos W=0.155u L=0.04u
M1096 n240 n277 VDD VDD pmos W=0.155u L=0.04u
M1097 n277 N183 VSS VSS nmos W=0.155u L=0.04u
M1098 n277 State_4 VSS VSS nmos W=0.155u L=0.04u
M1099 n277 State_0 VSS VSS nmos W=0.155u L=0.04u
M1100 U376/net25 N183 VDD VDD pmos W=0.41u L=0.04u
M1101 U376/net28 State_4 U376/net25 VDD pmos W=0.41u L=0.04u
M1102 n277 State_0 U376/net28 VDD pmos W=0.41u L=0.04u
M1103 n310 n259 VSS VSS nmos W=0.135u L=0.04u
M1104 n310 n259 VDD VDD pmos W=0.205u L=0.04u
M1105 U378/p2 n362 VSS VSS nmos W=0.155u L=0.04u
M1106 U378/p0 State_1 U378/p1 VSS nmos W=0.155u L=0.04u
M1107 U378/p1 n201 U378/p2 VSS nmos W=0.155u L=0.04u
M1108 n259 n216 U378/p0 VSS nmos W=0.155u L=0.04u
M1109 n259 n201 VDD VDD pmos W=0.205u L=0.04u
M1110 n259 State_1 VDD VDD pmos W=0.205u L=0.04u
M1111 n259 n216 VDD VDD pmos W=0.205u L=0.04u
M1112 n259 n362 VDD VDD pmos W=0.205u L=0.04u
M1113 n216 n200 VSS VSS nmos W=0.155u L=0.04u
M1114 n216 Rdy1BmHS1 VSS VSS nmos W=0.155u L=0.04u
M1115 n216 n202 VSS VSS nmos W=0.155u L=0.04u
M1116 U379/net25 n200 VDD VDD pmos W=0.41u L=0.04u
M1117 U379/net28 Rdy1BmHS1 U379/net25 VDD pmos W=0.41u L=0.04u
M1118 n216 n202 U379/net28 VDD pmos W=0.41u L=0.04u
M1119 n200 N183 U380/XI0-net10 VSS nmos W=0.155u L=0.04u
M1120 U380/XI0-net10 n228 U380/XI0-net13 VSS nmos W=0.155u L=0.04u
M1121 U380/XI0-net13 n250 VSS VSS nmos W=0.155u L=0.04u
M1122 n200 n250 VDD VDD pmos W=0.205u L=0.04u
M1123 n200 N183 VDD VDD pmos W=0.205u L=0.04u
M1124 n200 n228 VDD VDD pmos W=0.205u L=0.04u
M1125 n360 n363 U381/net14 VSS nmos W=0.155u L=0.04u
M1126 U381/net14 n292 VSS VSS nmos W=0.155u L=0.04u
M1127 U381/net14 n315 VSS VSS nmos W=0.155u L=0.04u
M1128 n360 n285 U381/net14 VSS nmos W=0.155u L=0.04u
M1129 n360 n271 U381/net14 VSS nmos W=0.155u L=0.04u
M1130 n360 n292 U381/XI16-net11 VDD pmos W=0.205u L=0.04u
M1131 U381/XI16-net11 n315 VDD VDD pmos W=0.205u L=0.04u
M1132 n360 n285 U381/XI15-net11 VDD pmos W=0.205u L=0.04u
M1133 U381/XI15-net11 n271 U381/XI15-net18 VDD pmos W=0.205u L=0.04u
M1134 U381/XI15-net18 n363 VDD VDD pmos W=0.205u L=0.04u
M1135 U382/p2 n280 VSS VSS nmos W=0.155u L=0.04u
M1136 U382/p0 Prog_0 U382/p1 VSS nmos W=0.155u L=0.04u
M1137 U382/p1 n364 U382/p2 VSS nmos W=0.155u L=0.04u
M1138 n292 n260 U382/p0 VSS nmos W=0.155u L=0.04u
M1139 n292 n364 VDD VDD pmos W=0.205u L=0.04u
M1140 n292 Prog_0 VDD VDD pmos W=0.205u L=0.04u
M1141 n292 n260 VDD VDD pmos W=0.205u L=0.04u
M1142 n292 n280 VDD VDD pmos W=0.205u L=0.04u
M1143 n280 n196 VSS VSS nmos W=0.135u L=0.04u
M1144 n280 n196 VDD VDD pmos W=0.205u L=0.04u
M1145 n196 n226 VSS VSS nmos W=0.155u L=0.04u
M1146 n196 n362 VSS VSS nmos W=0.155u L=0.04u
M1147 U384/XI1-net8 n362 VDD VDD pmos W=0.205u L=0.04u
M1148 n196 n226 U384/XI1-net8 VDD pmos W=0.205u L=0.04u
M1149 U385/XU1-net6 n226 VSS VSS nmos W=0.155u L=0.04u
M1150 n364 n362 U385/XU1-net6 VSS nmos W=0.155u L=0.04u
M1151 n364 n226 VDD VDD pmos W=0.155u L=0.04u
M1152 n364 n362 VDD VDD pmos W=0.155u L=0.04u
M1153 n362 Rdy1RtHS1 VSS VSS nmos W=0.135u L=0.04u
M1154 n362 Rdy1RtHS1 VDD VDD pmos W=0.205u L=0.04u
M1155 n260 n348 VSS VSS nmos W=0.135u L=0.04u
M1156 n260 n348 VDD VDD pmos W=0.205u L=0.04u
M1157 n348 n251 U388/XI0-net10 VSS nmos W=0.155u L=0.04u
M1158 U388/XI0-net10 n325 U388/XI0-net13 VSS nmos W=0.155u L=0.04u
M1159 U388/XI0-net13 n198 VSS VSS nmos W=0.155u L=0.04u
M1160 n348 n198 VDD VDD pmos W=0.205u L=0.04u
M1161 n348 n251 VDD VDD pmos W=0.205u L=0.04u
M1162 n348 n325 VDD VDD pmos W=0.205u L=0.04u
M1163 n325 State_1 VSS VSS nmos W=0.135u L=0.04u
M1164 n325 State_1 VDD VDD pmos W=0.205u L=0.04u
M1165 n251 Prog_2 VSS VSS nmos W=0.155u L=0.04u
M1166 n251 State_4 VSS VSS nmos W=0.155u L=0.04u
M1167 U390/XI1-net8 State_4 VDD VDD pmos W=0.205u L=0.04u
M1168 n251 Prog_2 U390/XI1-net8 VDD pmos W=0.205u L=0.04u
M1169 n315 n221 VSS VSS nmos W=0.155u L=0.04u
M1170 n315 n24 VSS VSS nmos W=0.155u L=0.04u
M1171 U391/XI1-net8 n24 VDD VDD pmos W=0.205u L=0.04u
M1172 n315 n221 U391/XI1-net8 VDD pmos W=0.205u L=0.04u
M1173 n24 FullIIHS1 VSS VSS nmos W=0.135u L=0.04u
M1174 n24 FullIIHS1 VDD VDD pmos W=0.205u L=0.04u
M1175 n221 FullOHS1 VSS VSS nmos W=0.135u L=0.04u
M1176 n221 FullOHS1 VDD VDD pmos W=0.205u L=0.04u
M1177 n285 WantRtHS1 VSS VSS nmos W=0.135u L=0.04u
M1178 n285 WantRtHS1 VDD VDD pmos W=0.205u L=0.04u
M1179 U395/p2 n228 VSS VSS nmos W=0.155u L=0.04u
M1180 U395/p0 n198 U395/p1 VSS nmos W=0.155u L=0.04u
M1181 U395/p1 Rdy1RtHS1 U395/p2 VSS nmos W=0.155u L=0.04u
M1182 n271 n358 U395/p0 VSS nmos W=0.155u L=0.04u
M1183 n271 Rdy1RtHS1 VDD VDD pmos W=0.205u L=0.04u
M1184 n271 n198 VDD VDD pmos W=0.205u L=0.04u
M1185 n271 n358 VDD VDD pmos W=0.205u L=0.04u
M1186 n271 n228 VDD VDD pmos W=0.205u L=0.04u
M1187 n228 State_4 VSS VSS nmos W=0.135u L=0.04u
M1188 n228 State_4 VDD VDD pmos W=0.205u L=0.04u
M1189 n198 n219 VSS VSS nmos W=0.135u L=0.04u
M1190 n198 n219 VDD VDD pmos W=0.205u L=0.04u
M1191 n219 n202 U398/XI0-net10 VSS nmos W=0.155u L=0.04u
M1192 U398/XI0-net10 N183 U398/XI0-net13 VSS nmos W=0.155u L=0.04u
M1193 U398/XI0-net13 n250 VSS VSS nmos W=0.155u L=0.04u
M1194 n219 n250 VDD VDD pmos W=0.205u L=0.04u
M1195 n219 n202 VDD VDD pmos W=0.205u L=0.04u
M1196 n219 N183 VDD VDD pmos W=0.205u L=0.04u
M1197 n250 n355 VSS VSS nmos W=0.155u L=0.04u
M1198 n250 N182 VSS VSS nmos W=0.155u L=0.04u
M1199 U399/XI1-net8 N182 VDD VDD pmos W=0.205u L=0.04u
M1200 n250 n355 U399/XI1-net8 VDD pmos W=0.205u L=0.04u
M1201 n355 State_5 VSS VSS nmos W=0.135u L=0.04u
M1202 n355 State_5 VDD VDD pmos W=0.205u L=0.04u
M1203 N183 State_2 VSS VSS nmos W=0.135u L=0.04u
M1204 N183 State_2 VDD VDD pmos W=0.205u L=0.04u
M1205 n202 State_0 VSS VSS nmos W=0.135u L=0.04u
M1206 n202 State_0 VDD VDD pmos W=0.205u L=0.04u
M1207 n358 n211 VSS VSS nmos W=0.155u L=0.04u
M1208 n358 n190 VSS VSS nmos W=0.155u L=0.04u
M1209 U403/XI1-net8 n190 VDD VDD pmos W=0.205u L=0.04u
M1210 n358 n211 U403/XI1-net8 VDD pmos W=0.205u L=0.04u
M1211 n190 n201 VSS VSS nmos W=0.135u L=0.04u
M1212 n190 n201 VDD VDD pmos W=0.205u L=0.04u
M1213 n201 FullOHS1 VSS VSS nmos W=0.155u L=0.04u
M1214 n201 FullIIHS1 VSS VSS nmos W=0.155u L=0.04u
M1215 U405/XI1-net8 FullIIHS1 VDD VDD pmos W=0.205u L=0.04u
M1216 n201 FullOHS1 U405/XI1-net8 VDD pmos W=0.205u L=0.04u
M1217 n211 Prog_2 VSS VSS nmos W=0.135u L=0.04u
M1218 n211 Prog_2 VDD VDD pmos W=0.205u L=0.04u
M1219 U407/XU1-net6 n226 VSS VSS nmos W=0.155u L=0.04u
M1220 n363 n308 U407/XU1-net6 VSS nmos W=0.155u L=0.04u
M1221 n363 n226 VDD VDD pmos W=0.155u L=0.04u
M1222 n363 n308 VDD VDD pmos W=0.155u L=0.04u
M1223 n226 Rdy2RtHS1 VSS VSS nmos W=0.135u L=0.04u
M1224 n226 Rdy2RtHS1 VDD VDD pmos W=0.205u L=0.04u
M1225 n308 n301 VSS VSS nmos W=0.135u L=0.04u
M1226 n308 n301 VDD VDD pmos W=0.205u L=0.04u
M1227 n301 n314 VSS VSS nmos W=0.155u L=0.04u
M1228 n301 n311 VSS VSS nmos W=0.155u L=0.04u
M1229 U410/XI1-net8 n311 VDD VDD pmos W=0.205u L=0.04u
M1230 n301 n314 U410/XI1-net8 VDD pmos W=0.205u L=0.04u
M1231 n311 n269 VSS VSS nmos W=0.155u L=0.04u
M1232 n311 Rdy2BmHS1 VSS VSS nmos W=0.155u L=0.04u
M1233 U411/XI1-net8 Rdy2BmHS1 VDD VDD pmos W=0.205u L=0.04u
M1234 n311 n269 U411/XI1-net8 VDD pmos W=0.205u L=0.04u
M1235 n269 Rdy1BmHS1 VSS VSS nmos W=0.135u L=0.04u
M1236 n269 Rdy1BmHS1 VDD VDD pmos W=0.205u L=0.04u
M1237 n314 WantBmHS1 VSS VSS nmos W=0.135u L=0.04u
M1238 n314 WantBmHS1 VDD VDD pmos W=0.205u L=0.04u
.ENDS
