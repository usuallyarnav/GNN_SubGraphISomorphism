.SUBCKT s35932 CK CRC_OUT_1_0 CRC_OUT_1_1 CRC_OUT_1_10 CRC_OUT_1_11 CRC_OUT_1_12 CRC_OUT_1_13 CRC_OUT_1_14 CRC_OUT_1_15 CRC_OUT_1_16 CRC_OUT_1_17 CRC_OUT_1_18 CRC_OUT_1_19 CRC_OUT_1_2 CRC_OUT_1_20 CRC_OUT_1_21 CRC_OUT_1_22 CRC_OUT_1_23 CRC_OUT_1_24 CRC_OUT_1_25 CRC_OUT_1_26 CRC_OUT_1_27 CRC_OUT_1_28 CRC_OUT_1_29 CRC_OUT_1_3 CRC_OUT_1_30 CRC_OUT_1_31 CRC_OUT_1_4 CRC_OUT_1_5 CRC_OUT_1_6 CRC_OUT_1_7 CRC_OUT_1_8 CRC_OUT_1_9 CRC_OUT_2_0 CRC_OUT_2_1 CRC_OUT_2_10 CRC_OUT_2_11 CRC_OUT_2_12 CRC_OUT_2_13 CRC_OUT_2_14 CRC_OUT_2_15  CRC_OUT_2_16 CRC_OUT_2_17 CRC_OUT_2_18 CRC_OUT_2_19 CRC_OUT_2_2 CRC_OUT_2_20 CRC_OUT_2_21 CRC_OUT_2_22 CRC_OUT_2_23 CRC_OUT_2_24 CRC_OUT_2_25 CRC_OUT_2_26 CRC_OUT_2_27 CRC_OUT_2_28 CRC_OUT_2_29 CRC_OUT_2_3 CRC_OUT_2_30 CRC_OUT_2_31 CRC_OUT_2_4 CRC_OUT_2_5 CRC_OUT_2_6 CRC_OUT_2_7 CRC_OUT_2_8 CRC_OUT_2_9 CRC_OUT_3_0 CRC_OUT_3_1 CRC_OUT_3_10 CRC_OUT_3_11 CRC_OUT_3_12 CRC_OUT_3_13 CRC_OUT_3_14 CRC_OUT_3_15 CRC_OUT_3_16 CRC_OUT_3_17 CRC_OUT_3_18 CRC_OUT_3_19 CRC_OUT_3_2 CRC_OUT_3_20 CRC_OUT_3_21 CRC_OUT_3_22 CRC_OUT_3_23 CRC_OUT_3_24 CRC_OUT_3_25 CRC_OUT_3_26 CRC_OUT_3_27 CRC_OUT_3_28 CRC_OUT_3_29 CRC_OUT_3_3 CRC_OUT_3_30 CRC_OUT_3_31 CRC_OUT_3_4 CRC_OUT_3_5 CRC_OUT_3_6 CRC_OUT_3_7 CRC_OUT_3_8 CRC_OUT_3_9 CRC_OUT_4_0 CRC_OUT_4_1 CRC_OUT_4_10 CRC_OUT_4_11 CRC_OUT_4_12 CRC_OUT_4_13 CRC_OUT_4_14 CRC_OUT_4_15 CRC_OUT_4_16 CRC_OUT_4_17 CRC_OUT_4_18 CRC_OUT_4_19 CRC_OUT_4_2 CRC_OUT_4_20 CRC_OUT_4_21 CRC_OUT_4_22 CRC_OUT_4_23 CRC_OUT_4_24 CRC_OUT_4_25 CRC_OUT_4_26 CRC_OUT_4_27 CRC_OUT_4_28 CRC_OUT_4_29 CRC_OUT_4_3 CRC_OUT_4_30 CRC_OUT_4_31 CRC_OUT_4_4 CRC_OUT_4_5 CRC_OUT_4_6 CRC_OUT_4_7 CRC_OUT_4_8 CRC_OUT_4_9 CRC_OUT_5_0 CRC_OUT_5_1 CRC_OUT_5_10 CRC_OUT_5_11 CRC_OUT_5_12 CRC_OUT_5_13 CRC_OUT_5_14 CRC_OUT_5_15 CRC_OUT_5_16 CRC_OUT_5_17 CRC_OUT_5_18 CRC_OUT_5_19 CRC_OUT_5_2 CRC_OUT_5_20 CRC_OUT_5_21 CRC_OUT_5_22 CRC_OUT_5_23 CRC_OUT_5_24 CRC_OUT_5_25 CRC_OUT_5_26 CRC_OUT_5_27 CRC_OUT_5_28 CRC_OUT_5_29 CRC_OUT_5_3 CRC_OUT_5_30 CRC_OUT_5_31 CRC_OUT_5_4 CRC_OUT_5_5 CRC_OUT_5_6 CRC_OUT_5_7 CRC_OUT_5_8 CRC_OUT_5_9 CRC_OUT_6_0 CRC_OUT_6_1 CRC_OUT_6_10 CRC_OUT_6_11 CRC_OUT_6_12 CRC_OUT_6_13 CRC_OUT_6_14 CRC_OUT_6_15 CRC_OUT_6_16 CRC_OUT_6_17 CRC_OUT_6_18 CRC_OUT_6_19 CRC_OUT_6_2 CRC_OUT_6_20 CRC_OUT_6_21 CRC_OUT_6_22 CRC_OUT_6_23 CRC_OUT_6_24 CRC_OUT_6_25 CRC_OUT_6_26 CRC_OUT_6_27 CRC_OUT_6_28 CRC_OUT_6_29 CRC_OUT_6_3 CRC_OUT_6_30 CRC_OUT_6_31 CRC_OUT_6_4 CRC_OUT_6_5 CRC_OUT_6_6 CRC_OUT_6_7 CRC_OUT_6_8 CRC_OUT_6_9 CRC_OUT_7_0 CRC_OUT_7_1 CRC_OUT_7_10 CRC_OUT_7_11 CRC_OUT_7_12 CRC_OUT_7_13 CRC_OUT_7_14 CRC_OUT_7_15 CRC_OUT_7_16 CRC_OUT_7_17 CRC_OUT_7_18 CRC_OUT_7_19 CRC_OUT_7_2 CRC_OUT_7_20 CRC_OUT_7_21 CRC_OUT_7_22 CRC_OUT_7_23 CRC_OUT_7_24 CRC_OUT_7_25 CRC_OUT_7_26 CRC_OUT_7_27 CRC_OUT_7_28 CRC_OUT_7_29 CRC_OUT_7_3 CRC_OUT_7_30 CRC_OUT_7_31 CRC_OUT_7_4 CRC_OUT_7_5 CRC_OUT_7_6 CRC_OUT_7_7 CRC_OUT_7_8 CRC_OUT_7_9 CRC_OUT_8_0 CRC_OUT_8_1 CRC_OUT_8_10 CRC_OUT_8_11 CRC_OUT_8_12 CRC_OUT_8_13 CRC_OUT_8_14 CRC_OUT_8_15 CRC_OUT_8_16 CRC_OUT_8_17 CRC_OUT_8_18 CRC_OUT_8_19 CRC_OUT_8_2 CRC_OUT_8_20 CRC_OUT_8_21 CRC_OUT_8_22 CRC_OUT_8_23 CRC_OUT_8_24 CRC_OUT_8_25 CRC_OUT_8_26 CRC_OUT_8_27 CRC_OUT_8_28 CRC_OUT_8_29 CRC_OUT_8_3 CRC_OUT_8_30 CRC_OUT_8_31 CRC_OUT_8_4 CRC_OUT_8_5 CRC_OUT_8_6 CRC_OUT_8_7 CRC_OUT_8_8 CRC_OUT_8_9 CRC_OUT_9_0 CRC_OUT_9_1 CRC_OUT_9_10 CRC_OUT_9_11 CRC_OUT_9_12 CRC_OUT_9_13 CRC_OUT_9_14 CRC_OUT_9_15 CRC_OUT_9_16 CRC_OUT_9_17 CRC_OUT_9_18 CRC_OUT_9_19 CRC_OUT_9_2 CRC_OUT_9_20 CRC_OUT_9_21 CRC_OUT_9_22 CRC_OUT_9_23 CRC_OUT_9_24 CRC_OUT_9_25 CRC_OUT_9_26 CRC_OUT_9_27 CRC_OUT_9_28 CRC_OUT_9_29 CRC_OUT_9_3 CRC_OUT_9_30 CRC_OUT_9_31 CRC_OUT_9_4 CRC_OUT_9_5 CRC_OUT_9_6 CRC_OUT_9_7 CRC_OUT_9_8 CRC_OUT_9_9 DATA_0_0 DATA_0_1 DATA_0_10 DATA_0_11 DATA_0_12 DATA_0_13 DATA_0_14 DATA_0_15 DATA_0_16 DATA_0_17 DATA_0_18 DATA_0_19 DATA_0_2 DATA_0_20 DATA_0_21 DATA_0_22 DATA_0_23 DATA_0_24 DATA_0_25 DATA_0_26 DATA_0_27 DATA_0_28 DATA_0_29 DATA_0_3 DATA_0_30 DATA_0_31 DATA_0_4 DATA_0_5 DATA_0_6 DATA_0_7 DATA_0_8 DATA_0_9 WX1227 WX1220 WX1157 WX1150 WX1143 WX1136 WX1129 WX1122 WX1115 WX1108 WX1101 WX1094 WX1213 WX1087 WX1080 WX1073 WX1066 WX1059 WX1052 WX1045 WX1038 WX1031 WX1024 WX1206 WX1017 WX1010 WX1199 WX1192 WX1185 WX1178 WX1171 WX1164 RESET TM0 TM1 VDD VSS
M1 WX11670 AND2_4031/net6 VSS VSS nmos W=0.31u L=0.04u
M2 AND2_4031/X_u2-net6 RESET VSS VSS nmos W=0.31u L=0.04u
M3 AND2_4031/net6 n1208 AND2_4031/X_u2-net6 VSS nmos W=0.31u L=0.04u
M4 WX11670 AND2_4031/net6 VDD VDD pmos W=0.41u L=0.04u
M5 AND2_4031/net6 RESET VDD VDD pmos W=0.41u L=0.04u
M6 AND2_4031/net6 n1208 VDD VDD pmos W=0.41u L=0.04u
M7 WX11668 AND2_4030/net6 VSS VSS nmos W=0.31u L=0.04u
M8 AND2_4030/X_u2-net6 RESET VSS VSS nmos W=0.31u L=0.04u
M9 AND2_4030/net6 n1209 AND2_4030/X_u2-net6 VSS nmos W=0.31u L=0.04u
M10 WX11668 AND2_4030/net6 VDD VDD pmos W=0.41u L=0.04u
M11 AND2_4030/net6 RESET VDD VDD pmos W=0.41u L=0.04u
M12 AND2_4030/net6 n1209 VDD VDD pmos W=0.41u L=0.04u
M13 WX11666 AND2_4029/net6 VSS VSS nmos W=0.31u L=0.04u
M14 AND2_4029/X_u2-net6 RESET VSS VSS nmos W=0.31u L=0.04u
M15 AND2_4029/net6 n1210 AND2_4029/X_u2-net6 VSS nmos W=0.31u L=0.04u
M16 WX11666 AND2_4029/net6 VDD VDD pmos W=0.41u L=0.04u
M17 AND2_4029/net6 RESET VDD VDD pmos W=0.41u L=0.04u
M18 AND2_4029/net6 n1210 VDD VDD pmos W=0.41u L=0.04u
M19 WX11664 AND2_4028/net6 VSS VSS nmos W=0.31u L=0.04u
M20 AND2_4028/X_u2-net6 RESET VSS VSS nmos W=0.31u L=0.04u
M21 AND2_4028/net6 n1211 AND2_4028/X_u2-net6 VSS nmos W=0.31u L=0.04u
M22 WX11664 AND2_4028/net6 VDD VDD pmos W=0.41u L=0.04u
M23 AND2_4028/net6 RESET VDD VDD pmos W=0.41u L=0.04u
M24 AND2_4028/net6 n1211 VDD VDD pmos W=0.41u L=0.04u
M25 WX11662 AND2_4027/net6 VSS VSS nmos W=0.31u L=0.04u
M26 AND2_4027/X_u2-net6 RESET VSS VSS nmos W=0.31u L=0.04u
M27 AND2_4027/net6 n1212 AND2_4027/X_u2-net6 VSS nmos W=0.31u L=0.04u
M28 WX11662 AND2_4027/net6 VDD VDD pmos W=0.41u L=0.04u
M29 AND2_4027/net6 RESET VDD VDD pmos W=0.41u L=0.04u
M30 AND2_4027/net6 n1212 VDD VDD pmos W=0.41u L=0.04u
M31 WX11660 AND2_4026/net6 VSS VSS nmos W=0.31u L=0.04u
M32 AND2_4026/X_u2-net6 RESET VSS VSS nmos W=0.31u L=0.04u
M33 AND2_4026/net6 n1213 AND2_4026/X_u2-net6 VSS nmos W=0.31u L=0.04u
M34 WX11660 AND2_4026/net6 VDD VDD pmos W=0.41u L=0.04u
M35 AND2_4026/net6 RESET VDD VDD pmos W=0.41u L=0.04u
M36 AND2_4026/net6 n1213 VDD VDD pmos W=0.41u L=0.04u
M37 WX11658 AND2_4025/net6 VSS VSS nmos W=0.31u L=0.04u
M38 AND2_4025/X_u2-net6 RESET VSS VSS nmos W=0.31u L=0.04u
M39 AND2_4025/net6 n1214 AND2_4025/X_u2-net6 VSS nmos W=0.31u L=0.04u
M40 WX11658 AND2_4025/net6 VDD VDD pmos W=0.41u L=0.04u
M41 AND2_4025/net6 RESET VDD VDD pmos W=0.41u L=0.04u
M42 AND2_4025/net6 n1214 VDD VDD pmos W=0.41u L=0.04u
M43 WX11656 AND2_4024/net6 VSS VSS nmos W=0.31u L=0.04u
M44 AND2_4024/X_u2-net6 RESET VSS VSS nmos W=0.31u L=0.04u
M45 AND2_4024/net6 n1215 AND2_4024/X_u2-net6 VSS nmos W=0.31u L=0.04u
M46 WX11656 AND2_4024/net6 VDD VDD pmos W=0.41u L=0.04u
M47 AND2_4024/net6 RESET VDD VDD pmos W=0.41u L=0.04u
M48 AND2_4024/net6 n1215 VDD VDD pmos W=0.41u L=0.04u
M49 WX11654 AND2_4023/net6 VSS VSS nmos W=0.31u L=0.04u
M50 AND2_4023/X_u2-net6 RESET VSS VSS nmos W=0.31u L=0.04u
M51 AND2_4023/net6 n1216 AND2_4023/X_u2-net6 VSS nmos W=0.31u L=0.04u
M52 WX11654 AND2_4023/net6 VDD VDD pmos W=0.41u L=0.04u
M53 AND2_4023/net6 RESET VDD VDD pmos W=0.41u L=0.04u
M54 AND2_4023/net6 n1216 VDD VDD pmos W=0.41u L=0.04u
M55 WX11652 AND2_4022/net6 VSS VSS nmos W=0.31u L=0.04u
M56 AND2_4022/X_u2-net6 RESET VSS VSS nmos W=0.31u L=0.04u
M57 AND2_4022/net6 n1217 AND2_4022/X_u2-net6 VSS nmos W=0.31u L=0.04u
M58 WX11652 AND2_4022/net6 VDD VDD pmos W=0.41u L=0.04u
M59 AND2_4022/net6 RESET VDD VDD pmos W=0.41u L=0.04u
M60 AND2_4022/net6 n1217 VDD VDD pmos W=0.41u L=0.04u
M61 WX11650 AND2_4021/net6 VSS VSS nmos W=0.31u L=0.04u
M62 AND2_4021/X_u2-net6 RESET VSS VSS nmos W=0.31u L=0.04u
M63 AND2_4021/net6 n1218 AND2_4021/X_u2-net6 VSS nmos W=0.31u L=0.04u
M64 WX11650 AND2_4021/net6 VDD VDD pmos W=0.41u L=0.04u
M65 AND2_4021/net6 RESET VDD VDD pmos W=0.41u L=0.04u
M66 AND2_4021/net6 n1218 VDD VDD pmos W=0.41u L=0.04u
M67 WX11648 AND2_4020/net6 VSS VSS nmos W=0.31u L=0.04u
M68 AND2_4020/X_u2-net6 RESET VSS VSS nmos W=0.31u L=0.04u
M69 AND2_4020/net6 n1219 AND2_4020/X_u2-net6 VSS nmos W=0.31u L=0.04u
M70 WX11648 AND2_4020/net6 VDD VDD pmos W=0.41u L=0.04u
M71 AND2_4020/net6 RESET VDD VDD pmos W=0.41u L=0.04u
M72 AND2_4020/net6 n1219 VDD VDD pmos W=0.41u L=0.04u
M73 WX11646 AND2_4019/net6 VSS VSS nmos W=0.31u L=0.04u
M74 AND2_4019/X_u2-net6 RESET VSS VSS nmos W=0.31u L=0.04u
M75 AND2_4019/net6 n1220 AND2_4019/X_u2-net6 VSS nmos W=0.31u L=0.04u
M76 WX11646 AND2_4019/net6 VDD VDD pmos W=0.41u L=0.04u
M77 AND2_4019/net6 RESET VDD VDD pmos W=0.41u L=0.04u
M78 AND2_4019/net6 n1220 VDD VDD pmos W=0.41u L=0.04u
M79 WX11644 AND2_4018/net6 VSS VSS nmos W=0.31u L=0.04u
M80 AND2_4018/X_u2-net6 RESET VSS VSS nmos W=0.31u L=0.04u
M81 AND2_4018/net6 n1221 AND2_4018/X_u2-net6 VSS nmos W=0.31u L=0.04u
M82 WX11644 AND2_4018/net6 VDD VDD pmos W=0.41u L=0.04u
M83 AND2_4018/net6 RESET VDD VDD pmos W=0.41u L=0.04u
M84 AND2_4018/net6 n1221 VDD VDD pmos W=0.41u L=0.04u
M85 WX11642 AND2_4017/net6 VSS VSS nmos W=0.31u L=0.04u
M86 AND2_4017/X_u2-net6 RESET VSS VSS nmos W=0.31u L=0.04u
M87 AND2_4017/net6 n1222 AND2_4017/X_u2-net6 VSS nmos W=0.31u L=0.04u
M88 WX11642 AND2_4017/net6 VDD VDD pmos W=0.41u L=0.04u
M89 AND2_4017/net6 RESET VDD VDD pmos W=0.41u L=0.04u
M90 AND2_4017/net6 n1222 VDD VDD pmos W=0.41u L=0.04u
M91 WX11640 AND2_4016/net6 VSS VSS nmos W=0.31u L=0.04u
M92 AND2_4016/X_u2-net6 RESET VSS VSS nmos W=0.31u L=0.04u
M93 AND2_4016/net6 n1223 AND2_4016/X_u2-net6 VSS nmos W=0.31u L=0.04u
M94 WX11640 AND2_4016/net6 VDD VDD pmos W=0.41u L=0.04u
M95 AND2_4016/net6 RESET VDD VDD pmos W=0.41u L=0.04u
M96 AND2_4016/net6 n1223 VDD VDD pmos W=0.41u L=0.04u
M97 WX11638 AND2_4015/net6 VSS VSS nmos W=0.31u L=0.04u
M98 AND2_4015/X_u2-net6 RESET VSS VSS nmos W=0.31u L=0.04u
M99 AND2_4015/net6 n1224 AND2_4015/X_u2-net6 VSS nmos W=0.31u L=0.04u
M100 WX11638 AND2_4015/net6 VDD VDD pmos W=0.41u L=0.04u
M101 AND2_4015/net6 RESET VDD VDD pmos W=0.41u L=0.04u
M102 AND2_4015/net6 n1224 VDD VDD pmos W=0.41u L=0.04u
M103 WX11636 AND2_4014/net6 VSS VSS nmos W=0.31u L=0.04u
M104 AND2_4014/X_u2-net6 RESET VSS VSS nmos W=0.31u L=0.04u
M105 AND2_4014/net6 n1225 AND2_4014/X_u2-net6 VSS nmos W=0.31u L=0.04u
M106 WX11636 AND2_4014/net6 VDD VDD pmos W=0.41u L=0.04u
M107 AND2_4014/net6 RESET VDD VDD pmos W=0.41u L=0.04u
M108 AND2_4014/net6 n1225 VDD VDD pmos W=0.41u L=0.04u
M109 WX11634 AND2_4013/net6 VSS VSS nmos W=0.31u L=0.04u
M110 AND2_4013/X_u2-net6 RESET VSS VSS nmos W=0.31u L=0.04u
M111 AND2_4013/net6 n1226 AND2_4013/X_u2-net6 VSS nmos W=0.31u L=0.04u
M112 WX11634 AND2_4013/net6 VDD VDD pmos W=0.41u L=0.04u
M113 AND2_4013/net6 RESET VDD VDD pmos W=0.41u L=0.04u
M114 AND2_4013/net6 n1226 VDD VDD pmos W=0.41u L=0.04u
M115 WX11632 AND2_4012/net6 VSS VSS nmos W=0.31u L=0.04u
M116 AND2_4012/X_u2-net6 RESET VSS VSS nmos W=0.31u L=0.04u
M117 AND2_4012/net6 n1227 AND2_4012/X_u2-net6 VSS nmos W=0.31u L=0.04u
M118 WX11632 AND2_4012/net6 VDD VDD pmos W=0.41u L=0.04u
M119 AND2_4012/net6 RESET VDD VDD pmos W=0.41u L=0.04u
M120 AND2_4012/net6 n1227 VDD VDD pmos W=0.41u L=0.04u
M121 WX11630 AND2_4011/net6 VSS VSS nmos W=0.31u L=0.04u
M122 AND2_4011/X_u2-net6 RESET VSS VSS nmos W=0.31u L=0.04u
M123 AND2_4011/net6 n1228 AND2_4011/X_u2-net6 VSS nmos W=0.31u L=0.04u
M124 WX11630 AND2_4011/net6 VDD VDD pmos W=0.41u L=0.04u
M125 AND2_4011/net6 RESET VDD VDD pmos W=0.41u L=0.04u
M126 AND2_4011/net6 n1228 VDD VDD pmos W=0.41u L=0.04u
M127 WX11628 AND2_4010/net6 VSS VSS nmos W=0.31u L=0.04u
M128 AND2_4010/X_u2-net6 RESET VSS VSS nmos W=0.31u L=0.04u
M129 AND2_4010/net6 n1229 AND2_4010/X_u2-net6 VSS nmos W=0.31u L=0.04u
M130 WX11628 AND2_4010/net6 VDD VDD pmos W=0.41u L=0.04u
M131 AND2_4010/net6 RESET VDD VDD pmos W=0.41u L=0.04u
M132 AND2_4010/net6 n1229 VDD VDD pmos W=0.41u L=0.04u
M133 WX11626 AND2_4009/net6 VSS VSS nmos W=0.31u L=0.04u
M134 AND2_4009/X_u2-net6 RESET VSS VSS nmos W=0.31u L=0.04u
M135 AND2_4009/net6 n1230 AND2_4009/X_u2-net6 VSS nmos W=0.31u L=0.04u
M136 WX11626 AND2_4009/net6 VDD VDD pmos W=0.41u L=0.04u
M137 AND2_4009/net6 RESET VDD VDD pmos W=0.41u L=0.04u
M138 AND2_4009/net6 n1230 VDD VDD pmos W=0.41u L=0.04u
M139 WX11624 AND2_4008/net6 VSS VSS nmos W=0.31u L=0.04u
M140 AND2_4008/X_u2-net6 RESET VSS VSS nmos W=0.31u L=0.04u
M141 AND2_4008/net6 n1231 AND2_4008/X_u2-net6 VSS nmos W=0.31u L=0.04u
M142 WX11624 AND2_4008/net6 VDD VDD pmos W=0.41u L=0.04u
M143 AND2_4008/net6 RESET VDD VDD pmos W=0.41u L=0.04u
M144 AND2_4008/net6 n1231 VDD VDD pmos W=0.41u L=0.04u
M145 WX11622 AND2_4007/net6 VSS VSS nmos W=0.31u L=0.04u
M146 AND2_4007/X_u2-net6 RESET VSS VSS nmos W=0.31u L=0.04u
M147 AND2_4007/net6 n1232 AND2_4007/X_u2-net6 VSS nmos W=0.31u L=0.04u
M148 WX11622 AND2_4007/net6 VDD VDD pmos W=0.41u L=0.04u
M149 AND2_4007/net6 RESET VDD VDD pmos W=0.41u L=0.04u
M150 AND2_4007/net6 n1232 VDD VDD pmos W=0.41u L=0.04u
M151 WX11620 AND2_4006/net6 VSS VSS nmos W=0.31u L=0.04u
M152 AND2_4006/X_u2-net6 RESET VSS VSS nmos W=0.31u L=0.04u
M153 AND2_4006/net6 n1233 AND2_4006/X_u2-net6 VSS nmos W=0.31u L=0.04u
M154 WX11620 AND2_4006/net6 VDD VDD pmos W=0.41u L=0.04u
M155 AND2_4006/net6 RESET VDD VDD pmos W=0.41u L=0.04u
M156 AND2_4006/net6 n1233 VDD VDD pmos W=0.41u L=0.04u
M157 WX11618 AND2_4005/net6 VSS VSS nmos W=0.31u L=0.04u
M158 AND2_4005/X_u2-net6 RESET VSS VSS nmos W=0.31u L=0.04u
M159 AND2_4005/net6 n1234 AND2_4005/X_u2-net6 VSS nmos W=0.31u L=0.04u
M160 WX11618 AND2_4005/net6 VDD VDD pmos W=0.41u L=0.04u
M161 AND2_4005/net6 RESET VDD VDD pmos W=0.41u L=0.04u
M162 AND2_4005/net6 n1234 VDD VDD pmos W=0.41u L=0.04u
M163 WX11616 AND2_4004/net6 VSS VSS nmos W=0.31u L=0.04u
M164 AND2_4004/X_u2-net6 RESET VSS VSS nmos W=0.31u L=0.04u
M165 AND2_4004/net6 n1235 AND2_4004/X_u2-net6 VSS nmos W=0.31u L=0.04u
M166 WX11616 AND2_4004/net6 VDD VDD pmos W=0.41u L=0.04u
M167 AND2_4004/net6 RESET VDD VDD pmos W=0.41u L=0.04u
M168 AND2_4004/net6 n1235 VDD VDD pmos W=0.41u L=0.04u
M169 WX11614 AND2_4003/net6 VSS VSS nmos W=0.31u L=0.04u
M170 AND2_4003/X_u2-net6 RESET VSS VSS nmos W=0.31u L=0.04u
M171 AND2_4003/net6 n1236 AND2_4003/X_u2-net6 VSS nmos W=0.31u L=0.04u
M172 WX11614 AND2_4003/net6 VDD VDD pmos W=0.41u L=0.04u
M173 AND2_4003/net6 RESET VDD VDD pmos W=0.41u L=0.04u
M174 AND2_4003/net6 n1236 VDD VDD pmos W=0.41u L=0.04u
M175 WX11612 AND2_4002/net6 VSS VSS nmos W=0.31u L=0.04u
M176 AND2_4002/X_u2-net6 RESET VSS VSS nmos W=0.31u L=0.04u
M177 AND2_4002/net6 n1237 AND2_4002/X_u2-net6 VSS nmos W=0.31u L=0.04u
M178 WX11612 AND2_4002/net6 VDD VDD pmos W=0.41u L=0.04u
M179 AND2_4002/net6 RESET VDD VDD pmos W=0.41u L=0.04u
M180 AND2_4002/net6 n1237 VDD VDD pmos W=0.41u L=0.04u
M181 WX11610 AND2_4001/net6 VSS VSS nmos W=0.31u L=0.04u
M182 AND2_4001/X_u2-net6 RESET VSS VSS nmos W=0.31u L=0.04u
M183 AND2_4001/net6 n1238 AND2_4001/X_u2-net6 VSS nmos W=0.31u L=0.04u
M184 WX11610 AND2_4001/net6 VDD VDD pmos W=0.41u L=0.04u
M185 AND2_4001/net6 RESET VDD VDD pmos W=0.41u L=0.04u
M186 AND2_4001/net6 n1238 VDD VDD pmos W=0.41u L=0.04u
M187 WX11608 AND2_4000/net6 VSS VSS nmos W=0.31u L=0.04u
M188 AND2_4000/X_u2-net6 RESET VSS VSS nmos W=0.31u L=0.04u
M189 AND2_4000/net6 n1239 AND2_4000/X_u2-net6 VSS nmos W=0.31u L=0.04u
M190 WX11608 AND2_4000/net6 VDD VDD pmos W=0.41u L=0.04u
M191 AND2_4000/net6 RESET VDD VDD pmos W=0.41u L=0.04u
M192 AND2_4000/net6 n1239 VDD VDD pmos W=0.41u L=0.04u
M193 WX11242 AND2_3935/net6 VSS VSS nmos W=0.31u L=0.04u
M194 AND2_3935/X_u2-net6 RESET VSS VSS nmos W=0.31u L=0.04u
M195 AND2_3935/net6 WX11179 AND2_3935/X_u2-net6 VSS nmos W=0.31u L=0.04u
M196 WX11242 AND2_3935/net6 VDD VDD pmos W=0.41u L=0.04u
M197 AND2_3935/net6 RESET VDD VDD pmos W=0.41u L=0.04u
M198 AND2_3935/net6 WX11179 VDD VDD pmos W=0.41u L=0.04u
M199 WX11240 AND2_3934/net6 VSS VSS nmos W=0.31u L=0.04u
M200 AND2_3934/X_u2-net6 RESET VSS VSS nmos W=0.31u L=0.04u
M201 AND2_3934/net6 WX11177 AND2_3934/X_u2-net6 VSS nmos W=0.31u L=0.04u
M202 WX11240 AND2_3934/net6 VDD VDD pmos W=0.41u L=0.04u
M203 AND2_3934/net6 RESET VDD VDD pmos W=0.41u L=0.04u
M204 AND2_3934/net6 WX11177 VDD VDD pmos W=0.41u L=0.04u
M205 WX11238 AND2_3933/net6 VSS VSS nmos W=0.31u L=0.04u
M206 AND2_3933/X_u2-net6 RESET VSS VSS nmos W=0.31u L=0.04u
M207 AND2_3933/net6 WX11175 AND2_3933/X_u2-net6 VSS nmos W=0.31u L=0.04u
M208 WX11238 AND2_3933/net6 VDD VDD pmos W=0.41u L=0.04u
M209 AND2_3933/net6 RESET VDD VDD pmos W=0.41u L=0.04u
M210 AND2_3933/net6 WX11175 VDD VDD pmos W=0.41u L=0.04u
M211 WX11236 AND2_3932/net6 VSS VSS nmos W=0.31u L=0.04u
M212 AND2_3932/X_u2-net6 RESET VSS VSS nmos W=0.31u L=0.04u
M213 AND2_3932/net6 WX11173 AND2_3932/X_u2-net6 VSS nmos W=0.31u L=0.04u
M214 WX11236 AND2_3932/net6 VDD VDD pmos W=0.41u L=0.04u
M215 AND2_3932/net6 RESET VDD VDD pmos W=0.41u L=0.04u
M216 AND2_3932/net6 WX11173 VDD VDD pmos W=0.41u L=0.04u
M217 WX11234 AND2_3931/net6 VSS VSS nmos W=0.31u L=0.04u
M218 AND2_3931/X_u2-net6 RESET VSS VSS nmos W=0.31u L=0.04u
M219 AND2_3931/net6 WX11171 AND2_3931/X_u2-net6 VSS nmos W=0.31u L=0.04u
M220 WX11234 AND2_3931/net6 VDD VDD pmos W=0.41u L=0.04u
M221 AND2_3931/net6 RESET VDD VDD pmos W=0.41u L=0.04u
M222 AND2_3931/net6 WX11171 VDD VDD pmos W=0.41u L=0.04u
M223 WX11232 AND2_3930/net6 VSS VSS nmos W=0.31u L=0.04u
M224 AND2_3930/X_u2-net6 RESET VSS VSS nmos W=0.31u L=0.04u
M225 AND2_3930/net6 WX11169 AND2_3930/X_u2-net6 VSS nmos W=0.31u L=0.04u
M226 WX11232 AND2_3930/net6 VDD VDD pmos W=0.41u L=0.04u
M227 AND2_3930/net6 RESET VDD VDD pmos W=0.41u L=0.04u
M228 AND2_3930/net6 WX11169 VDD VDD pmos W=0.41u L=0.04u
M229 WX11230 AND2_3929/net6 VSS VSS nmos W=0.31u L=0.04u
M230 AND2_3929/X_u2-net6 RESET VSS VSS nmos W=0.31u L=0.04u
M231 AND2_3929/net6 WX11167 AND2_3929/X_u2-net6 VSS nmos W=0.31u L=0.04u
M232 WX11230 AND2_3929/net6 VDD VDD pmos W=0.41u L=0.04u
M233 AND2_3929/net6 RESET VDD VDD pmos W=0.41u L=0.04u
M234 AND2_3929/net6 WX11167 VDD VDD pmos W=0.41u L=0.04u
M235 WX11228 AND2_3928/net6 VSS VSS nmos W=0.31u L=0.04u
M236 AND2_3928/X_u2-net6 RESET VSS VSS nmos W=0.31u L=0.04u
M237 AND2_3928/net6 WX11165 AND2_3928/X_u2-net6 VSS nmos W=0.31u L=0.04u
M238 WX11228 AND2_3928/net6 VDD VDD pmos W=0.41u L=0.04u
M239 AND2_3928/net6 RESET VDD VDD pmos W=0.41u L=0.04u
M240 AND2_3928/net6 WX11165 VDD VDD pmos W=0.41u L=0.04u
M241 WX11226 AND2_3927/net6 VSS VSS nmos W=0.31u L=0.04u
M242 AND2_3927/X_u2-net6 RESET VSS VSS nmos W=0.31u L=0.04u
M243 AND2_3927/net6 WX11163 AND2_3927/X_u2-net6 VSS nmos W=0.31u L=0.04u
M244 WX11226 AND2_3927/net6 VDD VDD pmos W=0.41u L=0.04u
M245 AND2_3927/net6 RESET VDD VDD pmos W=0.41u L=0.04u
M246 AND2_3927/net6 WX11163 VDD VDD pmos W=0.41u L=0.04u
M247 WX11224 AND2_3926/net6 VSS VSS nmos W=0.31u L=0.04u
M248 AND2_3926/X_u2-net6 RESET VSS VSS nmos W=0.31u L=0.04u
M249 AND2_3926/net6 WX11161 AND2_3926/X_u2-net6 VSS nmos W=0.31u L=0.04u
M250 WX11224 AND2_3926/net6 VDD VDD pmos W=0.41u L=0.04u
M251 AND2_3926/net6 RESET VDD VDD pmos W=0.41u L=0.04u
M252 AND2_3926/net6 WX11161 VDD VDD pmos W=0.41u L=0.04u
M253 WX11222 AND2_3925/net6 VSS VSS nmos W=0.31u L=0.04u
M254 AND2_3925/X_u2-net6 RESET VSS VSS nmos W=0.31u L=0.04u
M255 AND2_3925/net6 WX11159 AND2_3925/X_u2-net6 VSS nmos W=0.31u L=0.04u
M256 WX11222 AND2_3925/net6 VDD VDD pmos W=0.41u L=0.04u
M257 AND2_3925/net6 RESET VDD VDD pmos W=0.41u L=0.04u
M258 AND2_3925/net6 WX11159 VDD VDD pmos W=0.41u L=0.04u
M259 WX11220 AND2_3924/net6 VSS VSS nmos W=0.31u L=0.04u
M260 AND2_3924/X_u2-net6 RESET VSS VSS nmos W=0.31u L=0.04u
M261 AND2_3924/net6 WX11157 AND2_3924/X_u2-net6 VSS nmos W=0.31u L=0.04u
M262 WX11220 AND2_3924/net6 VDD VDD pmos W=0.41u L=0.04u
M263 AND2_3924/net6 RESET VDD VDD pmos W=0.41u L=0.04u
M264 AND2_3924/net6 WX11157 VDD VDD pmos W=0.41u L=0.04u
M265 WX11218 AND2_3923/net6 VSS VSS nmos W=0.31u L=0.04u
M266 AND2_3923/X_u2-net6 RESET VSS VSS nmos W=0.31u L=0.04u
M267 AND2_3923/net6 WX11155 AND2_3923/X_u2-net6 VSS nmos W=0.31u L=0.04u
M268 WX11218 AND2_3923/net6 VDD VDD pmos W=0.41u L=0.04u
M269 AND2_3923/net6 RESET VDD VDD pmos W=0.41u L=0.04u
M270 AND2_3923/net6 WX11155 VDD VDD pmos W=0.41u L=0.04u
M271 WX11216 AND2_3922/net6 VSS VSS nmos W=0.31u L=0.04u
M272 AND2_3922/X_u2-net6 RESET VSS VSS nmos W=0.31u L=0.04u
M273 AND2_3922/net6 WX11153 AND2_3922/X_u2-net6 VSS nmos W=0.31u L=0.04u
M274 WX11216 AND2_3922/net6 VDD VDD pmos W=0.41u L=0.04u
M275 AND2_3922/net6 RESET VDD VDD pmos W=0.41u L=0.04u
M276 AND2_3922/net6 WX11153 VDD VDD pmos W=0.41u L=0.04u
M277 WX11214 AND2_3921/net6 VSS VSS nmos W=0.31u L=0.04u
M278 AND2_3921/X_u2-net6 RESET VSS VSS nmos W=0.31u L=0.04u
M279 AND2_3921/net6 WX11151 AND2_3921/X_u2-net6 VSS nmos W=0.31u L=0.04u
M280 WX11214 AND2_3921/net6 VDD VDD pmos W=0.41u L=0.04u
M281 AND2_3921/net6 RESET VDD VDD pmos W=0.41u L=0.04u
M282 AND2_3921/net6 WX11151 VDD VDD pmos W=0.41u L=0.04u
M283 WX11212 AND2_3920/net6 VSS VSS nmos W=0.31u L=0.04u
M284 AND2_3920/X_u2-net6 RESET VSS VSS nmos W=0.31u L=0.04u
M285 AND2_3920/net6 WX11149 AND2_3920/X_u2-net6 VSS nmos W=0.31u L=0.04u
M286 WX11212 AND2_3920/net6 VDD VDD pmos W=0.41u L=0.04u
M287 AND2_3920/net6 RESET VDD VDD pmos W=0.41u L=0.04u
M288 AND2_3920/net6 WX11149 VDD VDD pmos W=0.41u L=0.04u
M289 WX11210 AND2_3919/net6 VSS VSS nmos W=0.31u L=0.04u
M290 AND2_3919/X_u2-net6 RESET VSS VSS nmos W=0.31u L=0.04u
M291 AND2_3919/net6 WX11147 AND2_3919/X_u2-net6 VSS nmos W=0.31u L=0.04u
M292 WX11210 AND2_3919/net6 VDD VDD pmos W=0.41u L=0.04u
M293 AND2_3919/net6 RESET VDD VDD pmos W=0.41u L=0.04u
M294 AND2_3919/net6 WX11147 VDD VDD pmos W=0.41u L=0.04u
M295 WX11208 AND2_3918/net6 VSS VSS nmos W=0.31u L=0.04u
M296 AND2_3918/X_u2-net6 RESET VSS VSS nmos W=0.31u L=0.04u
M297 AND2_3918/net6 WX11145 AND2_3918/X_u2-net6 VSS nmos W=0.31u L=0.04u
M298 WX11208 AND2_3918/net6 VDD VDD pmos W=0.41u L=0.04u
M299 AND2_3918/net6 RESET VDD VDD pmos W=0.41u L=0.04u
M300 AND2_3918/net6 WX11145 VDD VDD pmos W=0.41u L=0.04u
M301 WX11206 AND2_3917/net6 VSS VSS nmos W=0.31u L=0.04u
M302 AND2_3917/X_u2-net6 RESET VSS VSS nmos W=0.31u L=0.04u
M303 AND2_3917/net6 WX11143 AND2_3917/X_u2-net6 VSS nmos W=0.31u L=0.04u
M304 WX11206 AND2_3917/net6 VDD VDD pmos W=0.41u L=0.04u
M305 AND2_3917/net6 RESET VDD VDD pmos W=0.41u L=0.04u
M306 AND2_3917/net6 WX11143 VDD VDD pmos W=0.41u L=0.04u
M307 WX11204 AND2_3916/net6 VSS VSS nmos W=0.31u L=0.04u
M308 AND2_3916/X_u2-net6 RESET VSS VSS nmos W=0.31u L=0.04u
M309 AND2_3916/net6 WX11141 AND2_3916/X_u2-net6 VSS nmos W=0.31u L=0.04u
M310 WX11204 AND2_3916/net6 VDD VDD pmos W=0.41u L=0.04u
M311 AND2_3916/net6 RESET VDD VDD pmos W=0.41u L=0.04u
M312 AND2_3916/net6 WX11141 VDD VDD pmos W=0.41u L=0.04u
M313 WX11202 AND2_3915/net6 VSS VSS nmos W=0.31u L=0.04u
M314 AND2_3915/X_u2-net6 RESET VSS VSS nmos W=0.31u L=0.04u
M315 AND2_3915/net6 WX11139 AND2_3915/X_u2-net6 VSS nmos W=0.31u L=0.04u
M316 WX11202 AND2_3915/net6 VDD VDD pmos W=0.41u L=0.04u
M317 AND2_3915/net6 RESET VDD VDD pmos W=0.41u L=0.04u
M318 AND2_3915/net6 WX11139 VDD VDD pmos W=0.41u L=0.04u
M319 WX11200 AND2_3914/net6 VSS VSS nmos W=0.31u L=0.04u
M320 AND2_3914/X_u2-net6 RESET VSS VSS nmos W=0.31u L=0.04u
M321 AND2_3914/net6 WX11137 AND2_3914/X_u2-net6 VSS nmos W=0.31u L=0.04u
M322 WX11200 AND2_3914/net6 VDD VDD pmos W=0.41u L=0.04u
M323 AND2_3914/net6 RESET VDD VDD pmos W=0.41u L=0.04u
M324 AND2_3914/net6 WX11137 VDD VDD pmos W=0.41u L=0.04u
M325 WX11198 AND2_3913/net6 VSS VSS nmos W=0.31u L=0.04u
M326 AND2_3913/X_u2-net6 RESET VSS VSS nmos W=0.31u L=0.04u
M327 AND2_3913/net6 WX11135 AND2_3913/X_u2-net6 VSS nmos W=0.31u L=0.04u
M328 WX11198 AND2_3913/net6 VDD VDD pmos W=0.41u L=0.04u
M329 AND2_3913/net6 RESET VDD VDD pmos W=0.41u L=0.04u
M330 AND2_3913/net6 WX11135 VDD VDD pmos W=0.41u L=0.04u
M331 WX11196 AND2_3912/net6 VSS VSS nmos W=0.31u L=0.04u
M332 AND2_3912/X_u2-net6 RESET VSS VSS nmos W=0.31u L=0.04u
M333 AND2_3912/net6 WX11133 AND2_3912/X_u2-net6 VSS nmos W=0.31u L=0.04u
M334 WX11196 AND2_3912/net6 VDD VDD pmos W=0.41u L=0.04u
M335 AND2_3912/net6 RESET VDD VDD pmos W=0.41u L=0.04u
M336 AND2_3912/net6 WX11133 VDD VDD pmos W=0.41u L=0.04u
M337 WX11194 AND2_3911/net6 VSS VSS nmos W=0.31u L=0.04u
M338 AND2_3911/X_u2-net6 RESET VSS VSS nmos W=0.31u L=0.04u
M339 AND2_3911/net6 WX11131 AND2_3911/X_u2-net6 VSS nmos W=0.31u L=0.04u
M340 WX11194 AND2_3911/net6 VDD VDD pmos W=0.41u L=0.04u
M341 AND2_3911/net6 RESET VDD VDD pmos W=0.41u L=0.04u
M342 AND2_3911/net6 WX11131 VDD VDD pmos W=0.41u L=0.04u
M343 WX11192 AND2_3910/net6 VSS VSS nmos W=0.31u L=0.04u
M344 AND2_3910/X_u2-net6 RESET VSS VSS nmos W=0.31u L=0.04u
M345 AND2_3910/net6 WX11129 AND2_3910/X_u2-net6 VSS nmos W=0.31u L=0.04u
M346 WX11192 AND2_3910/net6 VDD VDD pmos W=0.41u L=0.04u
M347 AND2_3910/net6 RESET VDD VDD pmos W=0.41u L=0.04u
M348 AND2_3910/net6 WX11129 VDD VDD pmos W=0.41u L=0.04u
M349 WX11190 AND2_3909/net6 VSS VSS nmos W=0.31u L=0.04u
M350 AND2_3909/X_u2-net6 RESET VSS VSS nmos W=0.31u L=0.04u
M351 AND2_3909/net6 WX11127 AND2_3909/X_u2-net6 VSS nmos W=0.31u L=0.04u
M352 WX11190 AND2_3909/net6 VDD VDD pmos W=0.41u L=0.04u
M353 AND2_3909/net6 RESET VDD VDD pmos W=0.41u L=0.04u
M354 AND2_3909/net6 WX11127 VDD VDD pmos W=0.41u L=0.04u
M355 WX11188 AND2_3908/net6 VSS VSS nmos W=0.31u L=0.04u
M356 AND2_3908/X_u2-net6 RESET VSS VSS nmos W=0.31u L=0.04u
M357 AND2_3908/net6 WX11125 AND2_3908/X_u2-net6 VSS nmos W=0.31u L=0.04u
M358 WX11188 AND2_3908/net6 VDD VDD pmos W=0.41u L=0.04u
M359 AND2_3908/net6 RESET VDD VDD pmos W=0.41u L=0.04u
M360 AND2_3908/net6 WX11125 VDD VDD pmos W=0.41u L=0.04u
M361 WX11186 AND2_3907/net6 VSS VSS nmos W=0.31u L=0.04u
M362 AND2_3907/X_u2-net6 RESET VSS VSS nmos W=0.31u L=0.04u
M363 AND2_3907/net6 WX11123 AND2_3907/X_u2-net6 VSS nmos W=0.31u L=0.04u
M364 WX11186 AND2_3907/net6 VDD VDD pmos W=0.41u L=0.04u
M365 AND2_3907/net6 RESET VDD VDD pmos W=0.41u L=0.04u
M366 AND2_3907/net6 WX11123 VDD VDD pmos W=0.41u L=0.04u
M367 WX11184 AND2_3906/net6 VSS VSS nmos W=0.31u L=0.04u
M368 AND2_3906/X_u2-net6 RESET VSS VSS nmos W=0.31u L=0.04u
M369 AND2_3906/net6 WX11121 AND2_3906/X_u2-net6 VSS nmos W=0.31u L=0.04u
M370 WX11184 AND2_3906/net6 VDD VDD pmos W=0.41u L=0.04u
M371 AND2_3906/net6 RESET VDD VDD pmos W=0.41u L=0.04u
M372 AND2_3906/net6 WX11121 VDD VDD pmos W=0.41u L=0.04u
M373 WX11182 AND2_3905/net6 VSS VSS nmos W=0.31u L=0.04u
M374 AND2_3905/X_u2-net6 RESET VSS VSS nmos W=0.31u L=0.04u
M375 AND2_3905/net6 WX11119 AND2_3905/X_u2-net6 VSS nmos W=0.31u L=0.04u
M376 WX11182 AND2_3905/net6 VDD VDD pmos W=0.41u L=0.04u
M377 AND2_3905/net6 RESET VDD VDD pmos W=0.41u L=0.04u
M378 AND2_3905/net6 WX11119 VDD VDD pmos W=0.41u L=0.04u
M379 WX11180 AND2_3904/net6 VSS VSS nmos W=0.31u L=0.04u
M380 AND2_3904/X_u2-net6 RESET VSS VSS nmos W=0.31u L=0.04u
M381 AND2_3904/net6 WX11117 AND2_3904/X_u2-net6 VSS nmos W=0.31u L=0.04u
M382 WX11180 AND2_3904/net6 VDD VDD pmos W=0.41u L=0.04u
M383 AND2_3904/net6 RESET VDD VDD pmos W=0.41u L=0.04u
M384 AND2_3904/net6 WX11117 VDD VDD pmos W=0.41u L=0.04u
M385 WX11178 AND2_3903/net6 VSS VSS nmos W=0.31u L=0.04u
M386 AND2_3903/X_u2-net6 RESET VSS VSS nmos W=0.31u L=0.04u
M387 AND2_3903/net6 WX11115 AND2_3903/X_u2-net6 VSS nmos W=0.31u L=0.04u
M388 WX11178 AND2_3903/net6 VDD VDD pmos W=0.41u L=0.04u
M389 AND2_3903/net6 RESET VDD VDD pmos W=0.41u L=0.04u
M390 AND2_3903/net6 WX11115 VDD VDD pmos W=0.41u L=0.04u
M391 WX11176 AND2_3902/net6 VSS VSS nmos W=0.31u L=0.04u
M392 AND2_3902/X_u2-net6 RESET VSS VSS nmos W=0.31u L=0.04u
M393 AND2_3902/net6 WX11113 AND2_3902/X_u2-net6 VSS nmos W=0.31u L=0.04u
M394 WX11176 AND2_3902/net6 VDD VDD pmos W=0.41u L=0.04u
M395 AND2_3902/net6 RESET VDD VDD pmos W=0.41u L=0.04u
M396 AND2_3902/net6 WX11113 VDD VDD pmos W=0.41u L=0.04u
M397 WX11174 AND2_3901/net6 VSS VSS nmos W=0.31u L=0.04u
M398 AND2_3901/X_u2-net6 RESET VSS VSS nmos W=0.31u L=0.04u
M399 AND2_3901/net6 WX11111 AND2_3901/X_u2-net6 VSS nmos W=0.31u L=0.04u
M400 WX11174 AND2_3901/net6 VDD VDD pmos W=0.41u L=0.04u
M401 AND2_3901/net6 RESET VDD VDD pmos W=0.41u L=0.04u
M402 AND2_3901/net6 WX11111 VDD VDD pmos W=0.41u L=0.04u
M403 WX11172 AND2_3900/net6 VSS VSS nmos W=0.31u L=0.04u
M404 AND2_3900/X_u2-net6 RESET VSS VSS nmos W=0.31u L=0.04u
M405 AND2_3900/net6 WX11109 AND2_3900/X_u2-net6 VSS nmos W=0.31u L=0.04u
M406 WX11172 AND2_3900/net6 VDD VDD pmos W=0.41u L=0.04u
M407 AND2_3900/net6 RESET VDD VDD pmos W=0.41u L=0.04u
M408 AND2_3900/net6 WX11109 VDD VDD pmos W=0.41u L=0.04u
M409 WX11170 AND2_3899/net6 VSS VSS nmos W=0.31u L=0.04u
M410 AND2_3899/X_u2-net6 RESET VSS VSS nmos W=0.31u L=0.04u
M411 AND2_3899/net6 WX11107 AND2_3899/X_u2-net6 VSS nmos W=0.31u L=0.04u
M412 WX11170 AND2_3899/net6 VDD VDD pmos W=0.41u L=0.04u
M413 AND2_3899/net6 RESET VDD VDD pmos W=0.41u L=0.04u
M414 AND2_3899/net6 WX11107 VDD VDD pmos W=0.41u L=0.04u
M415 WX11168 AND2_3898/net6 VSS VSS nmos W=0.31u L=0.04u
M416 AND2_3898/X_u2-net6 RESET VSS VSS nmos W=0.31u L=0.04u
M417 AND2_3898/net6 WX11105 AND2_3898/X_u2-net6 VSS nmos W=0.31u L=0.04u
M418 WX11168 AND2_3898/net6 VDD VDD pmos W=0.41u L=0.04u
M419 AND2_3898/net6 RESET VDD VDD pmos W=0.41u L=0.04u
M420 AND2_3898/net6 WX11105 VDD VDD pmos W=0.41u L=0.04u
M421 WX11166 AND2_3897/net6 VSS VSS nmos W=0.31u L=0.04u
M422 AND2_3897/X_u2-net6 RESET VSS VSS nmos W=0.31u L=0.04u
M423 AND2_3897/net6 WX11103 AND2_3897/X_u2-net6 VSS nmos W=0.31u L=0.04u
M424 WX11166 AND2_3897/net6 VDD VDD pmos W=0.41u L=0.04u
M425 AND2_3897/net6 RESET VDD VDD pmos W=0.41u L=0.04u
M426 AND2_3897/net6 WX11103 VDD VDD pmos W=0.41u L=0.04u
M427 WX11164 AND2_3896/net6 VSS VSS nmos W=0.31u L=0.04u
M428 AND2_3896/X_u2-net6 RESET VSS VSS nmos W=0.31u L=0.04u
M429 AND2_3896/net6 WX11101 AND2_3896/X_u2-net6 VSS nmos W=0.31u L=0.04u
M430 WX11164 AND2_3896/net6 VDD VDD pmos W=0.41u L=0.04u
M431 AND2_3896/net6 RESET VDD VDD pmos W=0.41u L=0.04u
M432 AND2_3896/net6 WX11101 VDD VDD pmos W=0.41u L=0.04u
M433 WX11162 AND2_3895/net6 VSS VSS nmos W=0.31u L=0.04u
M434 AND2_3895/X_u2-net6 RESET VSS VSS nmos W=0.31u L=0.04u
M435 AND2_3895/net6 WX11099 AND2_3895/X_u2-net6 VSS nmos W=0.31u L=0.04u
M436 WX11162 AND2_3895/net6 VDD VDD pmos W=0.41u L=0.04u
M437 AND2_3895/net6 RESET VDD VDD pmos W=0.41u L=0.04u
M438 AND2_3895/net6 WX11099 VDD VDD pmos W=0.41u L=0.04u
M439 WX11160 AND2_3894/net6 VSS VSS nmos W=0.31u L=0.04u
M440 AND2_3894/X_u2-net6 RESET VSS VSS nmos W=0.31u L=0.04u
M441 AND2_3894/net6 WX11097 AND2_3894/X_u2-net6 VSS nmos W=0.31u L=0.04u
M442 WX11160 AND2_3894/net6 VDD VDD pmos W=0.41u L=0.04u
M443 AND2_3894/net6 RESET VDD VDD pmos W=0.41u L=0.04u
M444 AND2_3894/net6 WX11097 VDD VDD pmos W=0.41u L=0.04u
M445 WX11158 AND2_3893/net6 VSS VSS nmos W=0.31u L=0.04u
M446 AND2_3893/X_u2-net6 RESET VSS VSS nmos W=0.31u L=0.04u
M447 AND2_3893/net6 WX11095 AND2_3893/X_u2-net6 VSS nmos W=0.31u L=0.04u
M448 WX11158 AND2_3893/net6 VDD VDD pmos W=0.41u L=0.04u
M449 AND2_3893/net6 RESET VDD VDD pmos W=0.41u L=0.04u
M450 AND2_3893/net6 WX11095 VDD VDD pmos W=0.41u L=0.04u
M451 WX11156 AND2_3892/net6 VSS VSS nmos W=0.31u L=0.04u
M452 AND2_3892/X_u2-net6 RESET VSS VSS nmos W=0.31u L=0.04u
M453 AND2_3892/net6 WX11093 AND2_3892/X_u2-net6 VSS nmos W=0.31u L=0.04u
M454 WX11156 AND2_3892/net6 VDD VDD pmos W=0.41u L=0.04u
M455 AND2_3892/net6 RESET VDD VDD pmos W=0.41u L=0.04u
M456 AND2_3892/net6 WX11093 VDD VDD pmos W=0.41u L=0.04u
M457 WX11154 AND2_3891/net6 VSS VSS nmos W=0.31u L=0.04u
M458 AND2_3891/X_u2-net6 RESET VSS VSS nmos W=0.31u L=0.04u
M459 AND2_3891/net6 WX11091 AND2_3891/X_u2-net6 VSS nmos W=0.31u L=0.04u
M460 WX11154 AND2_3891/net6 VDD VDD pmos W=0.41u L=0.04u
M461 AND2_3891/net6 RESET VDD VDD pmos W=0.41u L=0.04u
M462 AND2_3891/net6 WX11091 VDD VDD pmos W=0.41u L=0.04u
M463 WX11152 AND2_3890/net6 VSS VSS nmos W=0.31u L=0.04u
M464 AND2_3890/X_u2-net6 RESET VSS VSS nmos W=0.31u L=0.04u
M465 AND2_3890/net6 WX11089 AND2_3890/X_u2-net6 VSS nmos W=0.31u L=0.04u
M466 WX11152 AND2_3890/net6 VDD VDD pmos W=0.41u L=0.04u
M467 AND2_3890/net6 RESET VDD VDD pmos W=0.41u L=0.04u
M468 AND2_3890/net6 WX11089 VDD VDD pmos W=0.41u L=0.04u
M469 WX11150 AND2_3889/net6 VSS VSS nmos W=0.31u L=0.04u
M470 AND2_3889/X_u2-net6 RESET VSS VSS nmos W=0.31u L=0.04u
M471 AND2_3889/net6 WX11087 AND2_3889/X_u2-net6 VSS nmos W=0.31u L=0.04u
M472 WX11150 AND2_3889/net6 VDD VDD pmos W=0.41u L=0.04u
M473 AND2_3889/net6 RESET VDD VDD pmos W=0.41u L=0.04u
M474 AND2_3889/net6 WX11087 VDD VDD pmos W=0.41u L=0.04u
M475 WX11148 AND2_3888/net6 VSS VSS nmos W=0.31u L=0.04u
M476 AND2_3888/X_u2-net6 RESET VSS VSS nmos W=0.31u L=0.04u
M477 AND2_3888/net6 WX11085 AND2_3888/X_u2-net6 VSS nmos W=0.31u L=0.04u
M478 WX11148 AND2_3888/net6 VDD VDD pmos W=0.41u L=0.04u
M479 AND2_3888/net6 RESET VDD VDD pmos W=0.41u L=0.04u
M480 AND2_3888/net6 WX11085 VDD VDD pmos W=0.41u L=0.04u
M481 WX11146 AND2_3887/net6 VSS VSS nmos W=0.31u L=0.04u
M482 AND2_3887/X_u2-net6 RESET VSS VSS nmos W=0.31u L=0.04u
M483 AND2_3887/net6 WX11083 AND2_3887/X_u2-net6 VSS nmos W=0.31u L=0.04u
M484 WX11146 AND2_3887/net6 VDD VDD pmos W=0.41u L=0.04u
M485 AND2_3887/net6 RESET VDD VDD pmos W=0.41u L=0.04u
M486 AND2_3887/net6 WX11083 VDD VDD pmos W=0.41u L=0.04u
M487 WX11144 AND2_3886/net6 VSS VSS nmos W=0.31u L=0.04u
M488 AND2_3886/X_u2-net6 RESET VSS VSS nmos W=0.31u L=0.04u
M489 AND2_3886/net6 WX11081 AND2_3886/X_u2-net6 VSS nmos W=0.31u L=0.04u
M490 WX11144 AND2_3886/net6 VDD VDD pmos W=0.41u L=0.04u
M491 AND2_3886/net6 RESET VDD VDD pmos W=0.41u L=0.04u
M492 AND2_3886/net6 WX11081 VDD VDD pmos W=0.41u L=0.04u
M493 WX11142 AND2_3885/net6 VSS VSS nmos W=0.31u L=0.04u
M494 AND2_3885/X_u2-net6 RESET VSS VSS nmos W=0.31u L=0.04u
M495 AND2_3885/net6 WX11079 AND2_3885/X_u2-net6 VSS nmos W=0.31u L=0.04u
M496 WX11142 AND2_3885/net6 VDD VDD pmos W=0.41u L=0.04u
M497 AND2_3885/net6 RESET VDD VDD pmos W=0.41u L=0.04u
M498 AND2_3885/net6 WX11079 VDD VDD pmos W=0.41u L=0.04u
M499 WX11140 AND2_3884/net6 VSS VSS nmos W=0.31u L=0.04u
M500 AND2_3884/X_u2-net6 RESET VSS VSS nmos W=0.31u L=0.04u
M501 AND2_3884/net6 WX11077 AND2_3884/X_u2-net6 VSS nmos W=0.31u L=0.04u
M502 WX11140 AND2_3884/net6 VDD VDD pmos W=0.41u L=0.04u
M503 AND2_3884/net6 RESET VDD VDD pmos W=0.41u L=0.04u
M504 AND2_3884/net6 WX11077 VDD VDD pmos W=0.41u L=0.04u
M505 WX11138 AND2_3883/net6 VSS VSS nmos W=0.31u L=0.04u
M506 AND2_3883/X_u2-net6 RESET VSS VSS nmos W=0.31u L=0.04u
M507 AND2_3883/net6 WX11075 AND2_3883/X_u2-net6 VSS nmos W=0.31u L=0.04u
M508 WX11138 AND2_3883/net6 VDD VDD pmos W=0.41u L=0.04u
M509 AND2_3883/net6 RESET VDD VDD pmos W=0.41u L=0.04u
M510 AND2_3883/net6 WX11075 VDD VDD pmos W=0.41u L=0.04u
M511 WX11136 AND2_3882/net6 VSS VSS nmos W=0.31u L=0.04u
M512 AND2_3882/X_u2-net6 RESET VSS VSS nmos W=0.31u L=0.04u
M513 AND2_3882/net6 WX11073 AND2_3882/X_u2-net6 VSS nmos W=0.31u L=0.04u
M514 WX11136 AND2_3882/net6 VDD VDD pmos W=0.41u L=0.04u
M515 AND2_3882/net6 RESET VDD VDD pmos W=0.41u L=0.04u
M516 AND2_3882/net6 WX11073 VDD VDD pmos W=0.41u L=0.04u
M517 WX11134 AND2_3881/net6 VSS VSS nmos W=0.31u L=0.04u
M518 AND2_3881/X_u2-net6 RESET VSS VSS nmos W=0.31u L=0.04u
M519 AND2_3881/net6 WX11071 AND2_3881/X_u2-net6 VSS nmos W=0.31u L=0.04u
M520 WX11134 AND2_3881/net6 VDD VDD pmos W=0.41u L=0.04u
M521 AND2_3881/net6 RESET VDD VDD pmos W=0.41u L=0.04u
M522 AND2_3881/net6 WX11071 VDD VDD pmos W=0.41u L=0.04u
M523 WX11132 AND2_3880/net6 VSS VSS nmos W=0.31u L=0.04u
M524 AND2_3880/X_u2-net6 RESET VSS VSS nmos W=0.31u L=0.04u
M525 AND2_3880/net6 WX11069 AND2_3880/X_u2-net6 VSS nmos W=0.31u L=0.04u
M526 WX11132 AND2_3880/net6 VDD VDD pmos W=0.41u L=0.04u
M527 AND2_3880/net6 RESET VDD VDD pmos W=0.41u L=0.04u
M528 AND2_3880/net6 WX11069 VDD VDD pmos W=0.41u L=0.04u
M529 WX11130 AND2_3879/net6 VSS VSS nmos W=0.31u L=0.04u
M530 AND2_3879/X_u2-net6 RESET VSS VSS nmos W=0.31u L=0.04u
M531 AND2_3879/net6 WX11067 AND2_3879/X_u2-net6 VSS nmos W=0.31u L=0.04u
M532 WX11130 AND2_3879/net6 VDD VDD pmos W=0.41u L=0.04u
M533 AND2_3879/net6 RESET VDD VDD pmos W=0.41u L=0.04u
M534 AND2_3879/net6 WX11067 VDD VDD pmos W=0.41u L=0.04u
M535 WX11128 AND2_3878/net6 VSS VSS nmos W=0.31u L=0.04u
M536 AND2_3878/X_u2-net6 RESET VSS VSS nmos W=0.31u L=0.04u
M537 AND2_3878/net6 WX11065 AND2_3878/X_u2-net6 VSS nmos W=0.31u L=0.04u
M538 WX11128 AND2_3878/net6 VDD VDD pmos W=0.41u L=0.04u
M539 AND2_3878/net6 RESET VDD VDD pmos W=0.41u L=0.04u
M540 AND2_3878/net6 WX11065 VDD VDD pmos W=0.41u L=0.04u
M541 WX11126 AND2_3877/net6 VSS VSS nmos W=0.31u L=0.04u
M542 AND2_3877/X_u2-net6 RESET VSS VSS nmos W=0.31u L=0.04u
M543 AND2_3877/net6 WX11063 AND2_3877/X_u2-net6 VSS nmos W=0.31u L=0.04u
M544 WX11126 AND2_3877/net6 VDD VDD pmos W=0.41u L=0.04u
M545 AND2_3877/net6 RESET VDD VDD pmos W=0.41u L=0.04u
M546 AND2_3877/net6 WX11063 VDD VDD pmos W=0.41u L=0.04u
M547 WX11124 AND2_3876/net6 VSS VSS nmos W=0.31u L=0.04u
M548 AND2_3876/X_u2-net6 RESET VSS VSS nmos W=0.31u L=0.04u
M549 AND2_3876/net6 WX11061 AND2_3876/X_u2-net6 VSS nmos W=0.31u L=0.04u
M550 WX11124 AND2_3876/net6 VDD VDD pmos W=0.41u L=0.04u
M551 AND2_3876/net6 RESET VDD VDD pmos W=0.41u L=0.04u
M552 AND2_3876/net6 WX11061 VDD VDD pmos W=0.41u L=0.04u
M553 WX11122 AND2_3875/net6 VSS VSS nmos W=0.31u L=0.04u
M554 AND2_3875/X_u2-net6 RESET VSS VSS nmos W=0.31u L=0.04u
M555 AND2_3875/net6 WX11059 AND2_3875/X_u2-net6 VSS nmos W=0.31u L=0.04u
M556 WX11122 AND2_3875/net6 VDD VDD pmos W=0.41u L=0.04u
M557 AND2_3875/net6 RESET VDD VDD pmos W=0.41u L=0.04u
M558 AND2_3875/net6 WX11059 VDD VDD pmos W=0.41u L=0.04u
M559 WX11120 AND2_3874/net6 VSS VSS nmos W=0.31u L=0.04u
M560 AND2_3874/X_u2-net6 RESET VSS VSS nmos W=0.31u L=0.04u
M561 AND2_3874/net6 WX11057 AND2_3874/X_u2-net6 VSS nmos W=0.31u L=0.04u
M562 WX11120 AND2_3874/net6 VDD VDD pmos W=0.41u L=0.04u
M563 AND2_3874/net6 RESET VDD VDD pmos W=0.41u L=0.04u
M564 AND2_3874/net6 WX11057 VDD VDD pmos W=0.41u L=0.04u
M565 WX11118 AND2_3873/net6 VSS VSS nmos W=0.31u L=0.04u
M566 AND2_3873/X_u2-net6 RESET VSS VSS nmos W=0.31u L=0.04u
M567 AND2_3873/net6 WX11055 AND2_3873/X_u2-net6 VSS nmos W=0.31u L=0.04u
M568 WX11118 AND2_3873/net6 VDD VDD pmos W=0.41u L=0.04u
M569 AND2_3873/net6 RESET VDD VDD pmos W=0.41u L=0.04u
M570 AND2_3873/net6 WX11055 VDD VDD pmos W=0.41u L=0.04u
M571 WX11116 AND2_3872/net6 VSS VSS nmos W=0.31u L=0.04u
M572 AND2_3872/X_u2-net6 RESET VSS VSS nmos W=0.31u L=0.04u
M573 AND2_3872/net6 WX11053 AND2_3872/X_u2-net6 VSS nmos W=0.31u L=0.04u
M574 WX11116 AND2_3872/net6 VDD VDD pmos W=0.41u L=0.04u
M575 AND2_3872/net6 RESET VDD VDD pmos W=0.41u L=0.04u
M576 AND2_3872/net6 WX11053 VDD VDD pmos W=0.41u L=0.04u
M577 WX11114 AND2_3871/net6 VSS VSS nmos W=0.31u L=0.04u
M578 AND2_3871/X_u2-net6 RESET VSS VSS nmos W=0.31u L=0.04u
M579 AND2_3871/net6 WX11051 AND2_3871/X_u2-net6 VSS nmos W=0.31u L=0.04u
M580 WX11114 AND2_3871/net6 VDD VDD pmos W=0.41u L=0.04u
M581 AND2_3871/net6 RESET VDD VDD pmos W=0.41u L=0.04u
M582 AND2_3871/net6 WX11051 VDD VDD pmos W=0.41u L=0.04u
M583 WX11112 AND2_3870/net6 VSS VSS nmos W=0.31u L=0.04u
M584 AND2_3870/X_u2-net6 RESET VSS VSS nmos W=0.31u L=0.04u
M585 AND2_3870/net6 WX11049 AND2_3870/X_u2-net6 VSS nmos W=0.31u L=0.04u
M586 WX11112 AND2_3870/net6 VDD VDD pmos W=0.41u L=0.04u
M587 AND2_3870/net6 RESET VDD VDD pmos W=0.41u L=0.04u
M588 AND2_3870/net6 WX11049 VDD VDD pmos W=0.41u L=0.04u
M589 WX11110 AND2_3869/net6 VSS VSS nmos W=0.31u L=0.04u
M590 AND2_3869/X_u2-net6 RESET VSS VSS nmos W=0.31u L=0.04u
M591 AND2_3869/net6 WX11047 AND2_3869/X_u2-net6 VSS nmos W=0.31u L=0.04u
M592 WX11110 AND2_3869/net6 VDD VDD pmos W=0.41u L=0.04u
M593 AND2_3869/net6 RESET VDD VDD pmos W=0.41u L=0.04u
M594 AND2_3869/net6 WX11047 VDD VDD pmos W=0.41u L=0.04u
M595 WX11108 AND2_3868/net6 VSS VSS nmos W=0.31u L=0.04u
M596 AND2_3868/X_u2-net6 RESET VSS VSS nmos W=0.31u L=0.04u
M597 AND2_3868/net6 WX11045 AND2_3868/X_u2-net6 VSS nmos W=0.31u L=0.04u
M598 WX11108 AND2_3868/net6 VDD VDD pmos W=0.41u L=0.04u
M599 AND2_3868/net6 RESET VDD VDD pmos W=0.41u L=0.04u
M600 AND2_3868/net6 WX11045 VDD VDD pmos W=0.41u L=0.04u
M601 WX11106 AND2_3867/net6 VSS VSS nmos W=0.31u L=0.04u
M602 AND2_3867/X_u2-net6 RESET VSS VSS nmos W=0.31u L=0.04u
M603 AND2_3867/net6 WX11043 AND2_3867/X_u2-net6 VSS nmos W=0.31u L=0.04u
M604 WX11106 AND2_3867/net6 VDD VDD pmos W=0.41u L=0.04u
M605 AND2_3867/net6 RESET VDD VDD pmos W=0.41u L=0.04u
M606 AND2_3867/net6 WX11043 VDD VDD pmos W=0.41u L=0.04u
M607 WX11104 AND2_3866/net6 VSS VSS nmos W=0.31u L=0.04u
M608 AND2_3866/X_u2-net6 RESET VSS VSS nmos W=0.31u L=0.04u
M609 AND2_3866/net6 WX11041 AND2_3866/X_u2-net6 VSS nmos W=0.31u L=0.04u
M610 WX11104 AND2_3866/net6 VDD VDD pmos W=0.41u L=0.04u
M611 AND2_3866/net6 RESET VDD VDD pmos W=0.41u L=0.04u
M612 AND2_3866/net6 WX11041 VDD VDD pmos W=0.41u L=0.04u
M613 WX11102 AND2_3865/net6 VSS VSS nmos W=0.31u L=0.04u
M614 AND2_3865/X_u2-net6 RESET VSS VSS nmos W=0.31u L=0.04u
M615 AND2_3865/net6 WX11039 AND2_3865/X_u2-net6 VSS nmos W=0.31u L=0.04u
M616 WX11102 AND2_3865/net6 VDD VDD pmos W=0.41u L=0.04u
M617 AND2_3865/net6 RESET VDD VDD pmos W=0.41u L=0.04u
M618 AND2_3865/net6 WX11039 VDD VDD pmos W=0.41u L=0.04u
M619 WX11100 AND2_3864/net6 VSS VSS nmos W=0.31u L=0.04u
M620 AND2_3864/X_u2-net6 RESET VSS VSS nmos W=0.31u L=0.04u
M621 AND2_3864/net6 WX11037 AND2_3864/X_u2-net6 VSS nmos W=0.31u L=0.04u
M622 WX11100 AND2_3864/net6 VDD VDD pmos W=0.41u L=0.04u
M623 AND2_3864/net6 RESET VDD VDD pmos W=0.41u L=0.04u
M624 AND2_3864/net6 WX11037 VDD VDD pmos W=0.41u L=0.04u
M625 WX11098 AND2_3863/net6 VSS VSS nmos W=0.31u L=0.04u
M626 AND2_3863/X_u2-net6 RESET VSS VSS nmos W=0.31u L=0.04u
M627 AND2_3863/net6 WX11035 AND2_3863/X_u2-net6 VSS nmos W=0.31u L=0.04u
M628 WX11098 AND2_3863/net6 VDD VDD pmos W=0.41u L=0.04u
M629 AND2_3863/net6 RESET VDD VDD pmos W=0.41u L=0.04u
M630 AND2_3863/net6 WX11035 VDD VDD pmos W=0.41u L=0.04u
M631 WX11096 AND2_3862/net6 VSS VSS nmos W=0.31u L=0.04u
M632 AND2_3862/X_u2-net6 RESET VSS VSS nmos W=0.31u L=0.04u
M633 AND2_3862/net6 WX11033 AND2_3862/X_u2-net6 VSS nmos W=0.31u L=0.04u
M634 WX11096 AND2_3862/net6 VDD VDD pmos W=0.41u L=0.04u
M635 AND2_3862/net6 RESET VDD VDD pmos W=0.41u L=0.04u
M636 AND2_3862/net6 WX11033 VDD VDD pmos W=0.41u L=0.04u
M637 WX11094 AND2_3861/net6 VSS VSS nmos W=0.31u L=0.04u
M638 AND2_3861/X_u2-net6 RESET VSS VSS nmos W=0.31u L=0.04u
M639 AND2_3861/net6 WX11031 AND2_3861/X_u2-net6 VSS nmos W=0.31u L=0.04u
M640 WX11094 AND2_3861/net6 VDD VDD pmos W=0.41u L=0.04u
M641 AND2_3861/net6 RESET VDD VDD pmos W=0.41u L=0.04u
M642 AND2_3861/net6 WX11031 VDD VDD pmos W=0.41u L=0.04u
M643 WX11092 AND2_3860/net6 VSS VSS nmos W=0.31u L=0.04u
M644 AND2_3860/X_u2-net6 RESET VSS VSS nmos W=0.31u L=0.04u
M645 AND2_3860/net6 WX11029 AND2_3860/X_u2-net6 VSS nmos W=0.31u L=0.04u
M646 WX11092 AND2_3860/net6 VDD VDD pmos W=0.41u L=0.04u
M647 AND2_3860/net6 RESET VDD VDD pmos W=0.41u L=0.04u
M648 AND2_3860/net6 WX11029 VDD VDD pmos W=0.41u L=0.04u
M649 WX11090 AND2_3859/net6 VSS VSS nmos W=0.31u L=0.04u
M650 AND2_3859/X_u2-net6 RESET VSS VSS nmos W=0.31u L=0.04u
M651 AND2_3859/net6 WX11027 AND2_3859/X_u2-net6 VSS nmos W=0.31u L=0.04u
M652 WX11090 AND2_3859/net6 VDD VDD pmos W=0.41u L=0.04u
M653 AND2_3859/net6 RESET VDD VDD pmos W=0.41u L=0.04u
M654 AND2_3859/net6 WX11027 VDD VDD pmos W=0.41u L=0.04u
M655 WX11088 AND2_3858/net6 VSS VSS nmos W=0.31u L=0.04u
M656 AND2_3858/X_u2-net6 RESET VSS VSS nmos W=0.31u L=0.04u
M657 AND2_3858/net6 WX11025 AND2_3858/X_u2-net6 VSS nmos W=0.31u L=0.04u
M658 WX11088 AND2_3858/net6 VDD VDD pmos W=0.41u L=0.04u
M659 AND2_3858/net6 RESET VDD VDD pmos W=0.41u L=0.04u
M660 AND2_3858/net6 WX11025 VDD VDD pmos W=0.41u L=0.04u
M661 WX11086 AND2_3857/net6 VSS VSS nmos W=0.31u L=0.04u
M662 AND2_3857/X_u2-net6 RESET VSS VSS nmos W=0.31u L=0.04u
M663 AND2_3857/net6 WX11023 AND2_3857/X_u2-net6 VSS nmos W=0.31u L=0.04u
M664 WX11086 AND2_3857/net6 VDD VDD pmos W=0.41u L=0.04u
M665 AND2_3857/net6 RESET VDD VDD pmos W=0.41u L=0.04u
M666 AND2_3857/net6 WX11023 VDD VDD pmos W=0.41u L=0.04u
M667 WX11084 AND2_3856/net6 VSS VSS nmos W=0.31u L=0.04u
M668 AND2_3856/X_u2-net6 RESET VSS VSS nmos W=0.31u L=0.04u
M669 AND2_3856/net6 WX11021 AND2_3856/X_u2-net6 VSS nmos W=0.31u L=0.04u
M670 WX11084 AND2_3856/net6 VDD VDD pmos W=0.41u L=0.04u
M671 AND2_3856/net6 RESET VDD VDD pmos W=0.41u L=0.04u
M672 AND2_3856/net6 WX11021 VDD VDD pmos W=0.41u L=0.04u
M673 WX11082 AND2_3855/net6 VSS VSS nmos W=0.31u L=0.04u
M674 AND2_3855/X_u2-net6 RESET VSS VSS nmos W=0.31u L=0.04u
M675 AND2_3855/net6 WX11019 AND2_3855/X_u2-net6 VSS nmos W=0.31u L=0.04u
M676 WX11082 AND2_3855/net6 VDD VDD pmos W=0.41u L=0.04u
M677 AND2_3855/net6 RESET VDD VDD pmos W=0.41u L=0.04u
M678 AND2_3855/net6 WX11019 VDD VDD pmos W=0.41u L=0.04u
M679 WX11080 AND2_3854/net6 VSS VSS nmos W=0.31u L=0.04u
M680 AND2_3854/X_u2-net6 RESET VSS VSS nmos W=0.31u L=0.04u
M681 AND2_3854/net6 WX11017 AND2_3854/X_u2-net6 VSS nmos W=0.31u L=0.04u
M682 WX11080 AND2_3854/net6 VDD VDD pmos W=0.41u L=0.04u
M683 AND2_3854/net6 RESET VDD VDD pmos W=0.41u L=0.04u
M684 AND2_3854/net6 WX11017 VDD VDD pmos W=0.41u L=0.04u
M685 WX11078 AND2_3853/net6 VSS VSS nmos W=0.31u L=0.04u
M686 AND2_3853/X_u2-net6 RESET VSS VSS nmos W=0.31u L=0.04u
M687 AND2_3853/net6 WX11015 AND2_3853/X_u2-net6 VSS nmos W=0.31u L=0.04u
M688 WX11078 AND2_3853/net6 VDD VDD pmos W=0.41u L=0.04u
M689 AND2_3853/net6 RESET VDD VDD pmos W=0.41u L=0.04u
M690 AND2_3853/net6 WX11015 VDD VDD pmos W=0.41u L=0.04u
M691 WX11076 AND2_3852/net6 VSS VSS nmos W=0.31u L=0.04u
M692 AND2_3852/X_u2-net6 RESET VSS VSS nmos W=0.31u L=0.04u
M693 AND2_3852/net6 WX11013 AND2_3852/X_u2-net6 VSS nmos W=0.31u L=0.04u
M694 WX11076 AND2_3852/net6 VDD VDD pmos W=0.41u L=0.04u
M695 AND2_3852/net6 RESET VDD VDD pmos W=0.41u L=0.04u
M696 AND2_3852/net6 WX11013 VDD VDD pmos W=0.41u L=0.04u
M697 WX11074 AND2_3851/net6 VSS VSS nmos W=0.31u L=0.04u
M698 AND2_3851/X_u2-net6 RESET VSS VSS nmos W=0.31u L=0.04u
M699 AND2_3851/net6 WX11011 AND2_3851/X_u2-net6 VSS nmos W=0.31u L=0.04u
M700 WX11074 AND2_3851/net6 VDD VDD pmos W=0.41u L=0.04u
M701 AND2_3851/net6 RESET VDD VDD pmos W=0.41u L=0.04u
M702 AND2_3851/net6 WX11011 VDD VDD pmos W=0.41u L=0.04u
M703 WX11072 AND2_3850/net6 VSS VSS nmos W=0.31u L=0.04u
M704 AND2_3850/X_u2-net6 RESET VSS VSS nmos W=0.31u L=0.04u
M705 AND2_3850/net6 WX11009 AND2_3850/X_u2-net6 VSS nmos W=0.31u L=0.04u
M706 WX11072 AND2_3850/net6 VDD VDD pmos W=0.41u L=0.04u
M707 AND2_3850/net6 RESET VDD VDD pmos W=0.41u L=0.04u
M708 AND2_3850/net6 WX11009 VDD VDD pmos W=0.41u L=0.04u
M709 WX11070 AND2_3849/net6 VSS VSS nmos W=0.31u L=0.04u
M710 AND2_3849/X_u2-net6 RESET VSS VSS nmos W=0.31u L=0.04u
M711 AND2_3849/net6 WX11007 AND2_3849/X_u2-net6 VSS nmos W=0.31u L=0.04u
M712 WX11070 AND2_3849/net6 VDD VDD pmos W=0.41u L=0.04u
M713 AND2_3849/net6 RESET VDD VDD pmos W=0.41u L=0.04u
M714 AND2_3849/net6 WX11007 VDD VDD pmos W=0.41u L=0.04u
M715 WX11068 AND2_3848/net6 VSS VSS nmos W=0.31u L=0.04u
M716 AND2_3848/X_u2-net6 RESET VSS VSS nmos W=0.31u L=0.04u
M717 AND2_3848/net6 WX11005 AND2_3848/X_u2-net6 VSS nmos W=0.31u L=0.04u
M718 WX11068 AND2_3848/net6 VDD VDD pmos W=0.41u L=0.04u
M719 AND2_3848/net6 RESET VDD VDD pmos W=0.41u L=0.04u
M720 AND2_3848/net6 WX11005 VDD VDD pmos W=0.41u L=0.04u
M721 WX11066 AND2_3847/net6 VSS VSS nmos W=0.31u L=0.04u
M722 AND2_3847/X_u2-net6 RESET VSS VSS nmos W=0.31u L=0.04u
M723 AND2_3847/net6 WX11003 AND2_3847/X_u2-net6 VSS nmos W=0.31u L=0.04u
M724 WX11066 AND2_3847/net6 VDD VDD pmos W=0.41u L=0.04u
M725 AND2_3847/net6 RESET VDD VDD pmos W=0.41u L=0.04u
M726 AND2_3847/net6 WX11003 VDD VDD pmos W=0.41u L=0.04u
M727 WX11064 AND2_3846/net6 VSS VSS nmos W=0.31u L=0.04u
M728 AND2_3846/X_u2-net6 RESET VSS VSS nmos W=0.31u L=0.04u
M729 AND2_3846/net6 WX11001 AND2_3846/X_u2-net6 VSS nmos W=0.31u L=0.04u
M730 WX11064 AND2_3846/net6 VDD VDD pmos W=0.41u L=0.04u
M731 AND2_3846/net6 RESET VDD VDD pmos W=0.41u L=0.04u
M732 AND2_3846/net6 WX11001 VDD VDD pmos W=0.41u L=0.04u
M733 WX11062 AND2_3845/net6 VSS VSS nmos W=0.31u L=0.04u
M734 AND2_3845/X_u2-net6 RESET VSS VSS nmos W=0.31u L=0.04u
M735 AND2_3845/net6 WX10999 AND2_3845/X_u2-net6 VSS nmos W=0.31u L=0.04u
M736 WX11062 AND2_3845/net6 VDD VDD pmos W=0.41u L=0.04u
M737 AND2_3845/net6 RESET VDD VDD pmos W=0.41u L=0.04u
M738 AND2_3845/net6 WX10999 VDD VDD pmos W=0.41u L=0.04u
M739 WX11060 AND2_3844/net6 VSS VSS nmos W=0.31u L=0.04u
M740 AND2_3844/X_u2-net6 RESET VSS VSS nmos W=0.31u L=0.04u
M741 AND2_3844/net6 WX10997 AND2_3844/X_u2-net6 VSS nmos W=0.31u L=0.04u
M742 WX11060 AND2_3844/net6 VDD VDD pmos W=0.41u L=0.04u
M743 AND2_3844/net6 RESET VDD VDD pmos W=0.41u L=0.04u
M744 AND2_3844/net6 WX10997 VDD VDD pmos W=0.41u L=0.04u
M745 WX11058 AND2_3843/net6 VSS VSS nmos W=0.31u L=0.04u
M746 AND2_3843/X_u2-net6 RESET VSS VSS nmos W=0.31u L=0.04u
M747 AND2_3843/net6 WX10995 AND2_3843/X_u2-net6 VSS nmos W=0.31u L=0.04u
M748 WX11058 AND2_3843/net6 VDD VDD pmos W=0.41u L=0.04u
M749 AND2_3843/net6 RESET VDD VDD pmos W=0.41u L=0.04u
M750 AND2_3843/net6 WX10995 VDD VDD pmos W=0.41u L=0.04u
M751 WX11056 AND2_3842/net6 VSS VSS nmos W=0.31u L=0.04u
M752 AND2_3842/X_u2-net6 RESET VSS VSS nmos W=0.31u L=0.04u
M753 AND2_3842/net6 WX10993 AND2_3842/X_u2-net6 VSS nmos W=0.31u L=0.04u
M754 WX11056 AND2_3842/net6 VDD VDD pmos W=0.41u L=0.04u
M755 AND2_3842/net6 RESET VDD VDD pmos W=0.41u L=0.04u
M756 AND2_3842/net6 WX10993 VDD VDD pmos W=0.41u L=0.04u
M757 WX11054 AND2_3841/net6 VSS VSS nmos W=0.31u L=0.04u
M758 AND2_3841/X_u2-net6 RESET VSS VSS nmos W=0.31u L=0.04u
M759 AND2_3841/net6 WX10991 AND2_3841/X_u2-net6 VSS nmos W=0.31u L=0.04u
M760 WX11054 AND2_3841/net6 VDD VDD pmos W=0.41u L=0.04u
M761 AND2_3841/net6 RESET VDD VDD pmos W=0.41u L=0.04u
M762 AND2_3841/net6 WX10991 VDD VDD pmos W=0.41u L=0.04u
M763 WX11052 AND2_3840/net6 VSS VSS nmos W=0.31u L=0.04u
M764 AND2_3840/X_u2-net6 RESET VSS VSS nmos W=0.31u L=0.04u
M765 AND2_3840/net6 WX10989 AND2_3840/X_u2-net6 VSS nmos W=0.31u L=0.04u
M766 WX11052 AND2_3840/net6 VDD VDD pmos W=0.41u L=0.04u
M767 AND2_3840/net6 RESET VDD VDD pmos W=0.41u L=0.04u
M768 AND2_3840/net6 WX10989 VDD VDD pmos W=0.41u L=0.04u
M769 WX11050 AND2_3839/net6 VSS VSS nmos W=0.31u L=0.04u
M770 AND2_3839/X_u2-net6 RESET VSS VSS nmos W=0.31u L=0.04u
M771 AND2_3839/net6 WX10816 AND2_3839/X_u2-net6 VSS nmos W=0.31u L=0.04u
M772 WX11050 AND2_3839/net6 VDD VDD pmos W=0.41u L=0.04u
M773 AND2_3839/net6 RESET VDD VDD pmos W=0.41u L=0.04u
M774 AND2_3839/net6 WX10816 VDD VDD pmos W=0.41u L=0.04u
M775 WX11048 AND2_3838/net6 VSS VSS nmos W=0.31u L=0.04u
M776 AND2_3838/X_u2-net6 RESET VSS VSS nmos W=0.31u L=0.04u
M777 AND2_3838/net6 WX10802 AND2_3838/X_u2-net6 VSS nmos W=0.31u L=0.04u
M778 WX11048 AND2_3838/net6 VDD VDD pmos W=0.41u L=0.04u
M779 AND2_3838/net6 RESET VDD VDD pmos W=0.41u L=0.04u
M780 AND2_3838/net6 WX10802 VDD VDD pmos W=0.41u L=0.04u
M781 WX11046 AND2_3837/net6 VSS VSS nmos W=0.31u L=0.04u
M782 AND2_3837/X_u2-net6 RESET VSS VSS nmos W=0.31u L=0.04u
M783 AND2_3837/net6 WX10788 AND2_3837/X_u2-net6 VSS nmos W=0.31u L=0.04u
M784 WX11046 AND2_3837/net6 VDD VDD pmos W=0.41u L=0.04u
M785 AND2_3837/net6 RESET VDD VDD pmos W=0.41u L=0.04u
M786 AND2_3837/net6 WX10788 VDD VDD pmos W=0.41u L=0.04u
M787 WX11044 AND2_3836/net6 VSS VSS nmos W=0.31u L=0.04u
M788 AND2_3836/X_u2-net6 RESET VSS VSS nmos W=0.31u L=0.04u
M789 AND2_3836/net6 WX10774 AND2_3836/X_u2-net6 VSS nmos W=0.31u L=0.04u
M790 WX11044 AND2_3836/net6 VDD VDD pmos W=0.41u L=0.04u
M791 AND2_3836/net6 RESET VDD VDD pmos W=0.41u L=0.04u
M792 AND2_3836/net6 WX10774 VDD VDD pmos W=0.41u L=0.04u
M793 WX11042 AND2_3835/net6 VSS VSS nmos W=0.31u L=0.04u
M794 AND2_3835/X_u2-net6 RESET VSS VSS nmos W=0.31u L=0.04u
M795 AND2_3835/net6 WX10760 AND2_3835/X_u2-net6 VSS nmos W=0.31u L=0.04u
M796 WX11042 AND2_3835/net6 VDD VDD pmos W=0.41u L=0.04u
M797 AND2_3835/net6 RESET VDD VDD pmos W=0.41u L=0.04u
M798 AND2_3835/net6 WX10760 VDD VDD pmos W=0.41u L=0.04u
M799 WX11040 AND2_3834/net6 VSS VSS nmos W=0.31u L=0.04u
M800 AND2_3834/X_u2-net6 RESET VSS VSS nmos W=0.31u L=0.04u
M801 AND2_3834/net6 WX10746 AND2_3834/X_u2-net6 VSS nmos W=0.31u L=0.04u
M802 WX11040 AND2_3834/net6 VDD VDD pmos W=0.41u L=0.04u
M803 AND2_3834/net6 RESET VDD VDD pmos W=0.41u L=0.04u
M804 AND2_3834/net6 WX10746 VDD VDD pmos W=0.41u L=0.04u
M805 WX11038 AND2_3833/net6 VSS VSS nmos W=0.31u L=0.04u
M806 AND2_3833/X_u2-net6 RESET VSS VSS nmos W=0.31u L=0.04u
M807 AND2_3833/net6 WX10732 AND2_3833/X_u2-net6 VSS nmos W=0.31u L=0.04u
M808 WX11038 AND2_3833/net6 VDD VDD pmos W=0.41u L=0.04u
M809 AND2_3833/net6 RESET VDD VDD pmos W=0.41u L=0.04u
M810 AND2_3833/net6 WX10732 VDD VDD pmos W=0.41u L=0.04u
M811 WX11036 AND2_3832/net6 VSS VSS nmos W=0.31u L=0.04u
M812 AND2_3832/X_u2-net6 RESET VSS VSS nmos W=0.31u L=0.04u
M813 AND2_3832/net6 WX10718 AND2_3832/X_u2-net6 VSS nmos W=0.31u L=0.04u
M814 WX11036 AND2_3832/net6 VDD VDD pmos W=0.41u L=0.04u
M815 AND2_3832/net6 RESET VDD VDD pmos W=0.41u L=0.04u
M816 AND2_3832/net6 WX10718 VDD VDD pmos W=0.41u L=0.04u
M817 WX11034 AND2_3831/net6 VSS VSS nmos W=0.31u L=0.04u
M818 AND2_3831/X_u2-net6 RESET VSS VSS nmos W=0.31u L=0.04u
M819 AND2_3831/net6 WX10704 AND2_3831/X_u2-net6 VSS nmos W=0.31u L=0.04u
M820 WX11034 AND2_3831/net6 VDD VDD pmos W=0.41u L=0.04u
M821 AND2_3831/net6 RESET VDD VDD pmos W=0.41u L=0.04u
M822 AND2_3831/net6 WX10704 VDD VDD pmos W=0.41u L=0.04u
M823 WX11032 AND2_3830/net6 VSS VSS nmos W=0.31u L=0.04u
M824 AND2_3830/X_u2-net6 RESET VSS VSS nmos W=0.31u L=0.04u
M825 AND2_3830/net6 WX10690 AND2_3830/X_u2-net6 VSS nmos W=0.31u L=0.04u
M826 WX11032 AND2_3830/net6 VDD VDD pmos W=0.41u L=0.04u
M827 AND2_3830/net6 RESET VDD VDD pmos W=0.41u L=0.04u
M828 AND2_3830/net6 WX10690 VDD VDD pmos W=0.41u L=0.04u
M829 WX11030 AND2_3829/net6 VSS VSS nmos W=0.31u L=0.04u
M830 AND2_3829/X_u2-net6 RESET VSS VSS nmos W=0.31u L=0.04u
M831 AND2_3829/net6 WX10676 AND2_3829/X_u2-net6 VSS nmos W=0.31u L=0.04u
M832 WX11030 AND2_3829/net6 VDD VDD pmos W=0.41u L=0.04u
M833 AND2_3829/net6 RESET VDD VDD pmos W=0.41u L=0.04u
M834 AND2_3829/net6 WX10676 VDD VDD pmos W=0.41u L=0.04u
M835 WX11028 AND2_3828/net6 VSS VSS nmos W=0.31u L=0.04u
M836 AND2_3828/X_u2-net6 RESET VSS VSS nmos W=0.31u L=0.04u
M837 AND2_3828/net6 WX10662 AND2_3828/X_u2-net6 VSS nmos W=0.31u L=0.04u
M838 WX11028 AND2_3828/net6 VDD VDD pmos W=0.41u L=0.04u
M839 AND2_3828/net6 RESET VDD VDD pmos W=0.41u L=0.04u
M840 AND2_3828/net6 WX10662 VDD VDD pmos W=0.41u L=0.04u
M841 WX11026 AND2_3827/net6 VSS VSS nmos W=0.31u L=0.04u
M842 AND2_3827/X_u2-net6 RESET VSS VSS nmos W=0.31u L=0.04u
M843 AND2_3827/net6 WX10648 AND2_3827/X_u2-net6 VSS nmos W=0.31u L=0.04u
M844 WX11026 AND2_3827/net6 VDD VDD pmos W=0.41u L=0.04u
M845 AND2_3827/net6 RESET VDD VDD pmos W=0.41u L=0.04u
M846 AND2_3827/net6 WX10648 VDD VDD pmos W=0.41u L=0.04u
M847 WX11024 AND2_3826/net6 VSS VSS nmos W=0.31u L=0.04u
M848 AND2_3826/X_u2-net6 RESET VSS VSS nmos W=0.31u L=0.04u
M849 AND2_3826/net6 WX10634 AND2_3826/X_u2-net6 VSS nmos W=0.31u L=0.04u
M850 WX11024 AND2_3826/net6 VDD VDD pmos W=0.41u L=0.04u
M851 AND2_3826/net6 RESET VDD VDD pmos W=0.41u L=0.04u
M852 AND2_3826/net6 WX10634 VDD VDD pmos W=0.41u L=0.04u
M853 WX11022 AND2_3825/net6 VSS VSS nmos W=0.31u L=0.04u
M854 AND2_3825/X_u2-net6 RESET VSS VSS nmos W=0.31u L=0.04u
M855 AND2_3825/net6 WX10620 AND2_3825/X_u2-net6 VSS nmos W=0.31u L=0.04u
M856 WX11022 AND2_3825/net6 VDD VDD pmos W=0.41u L=0.04u
M857 AND2_3825/net6 RESET VDD VDD pmos W=0.41u L=0.04u
M858 AND2_3825/net6 WX10620 VDD VDD pmos W=0.41u L=0.04u
M859 WX11020 AND2_3824/net6 VSS VSS nmos W=0.31u L=0.04u
M860 AND2_3824/X_u2-net6 RESET VSS VSS nmos W=0.31u L=0.04u
M861 AND2_3824/net6 WX10606 AND2_3824/X_u2-net6 VSS nmos W=0.31u L=0.04u
M862 WX11020 AND2_3824/net6 VDD VDD pmos W=0.41u L=0.04u
M863 AND2_3824/net6 RESET VDD VDD pmos W=0.41u L=0.04u
M864 AND2_3824/net6 WX10606 VDD VDD pmos W=0.41u L=0.04u
M865 WX11018 AND2_3823/net6 VSS VSS nmos W=0.31u L=0.04u
M866 AND2_3823/X_u2-net6 RESET VSS VSS nmos W=0.31u L=0.04u
M867 AND2_3823/net6 WX10592 AND2_3823/X_u2-net6 VSS nmos W=0.31u L=0.04u
M868 WX11018 AND2_3823/net6 VDD VDD pmos W=0.41u L=0.04u
M869 AND2_3823/net6 RESET VDD VDD pmos W=0.41u L=0.04u
M870 AND2_3823/net6 WX10592 VDD VDD pmos W=0.41u L=0.04u
M871 WX11016 AND2_3822/net6 VSS VSS nmos W=0.31u L=0.04u
M872 AND2_3822/X_u2-net6 RESET VSS VSS nmos W=0.31u L=0.04u
M873 AND2_3822/net6 WX10578 AND2_3822/X_u2-net6 VSS nmos W=0.31u L=0.04u
M874 WX11016 AND2_3822/net6 VDD VDD pmos W=0.41u L=0.04u
M875 AND2_3822/net6 RESET VDD VDD pmos W=0.41u L=0.04u
M876 AND2_3822/net6 WX10578 VDD VDD pmos W=0.41u L=0.04u
M877 WX11014 AND2_3821/net6 VSS VSS nmos W=0.31u L=0.04u
M878 AND2_3821/X_u2-net6 RESET VSS VSS nmos W=0.31u L=0.04u
M879 AND2_3821/net6 WX10564 AND2_3821/X_u2-net6 VSS nmos W=0.31u L=0.04u
M880 WX11014 AND2_3821/net6 VDD VDD pmos W=0.41u L=0.04u
M881 AND2_3821/net6 RESET VDD VDD pmos W=0.41u L=0.04u
M882 AND2_3821/net6 WX10564 VDD VDD pmos W=0.41u L=0.04u
M883 WX11012 AND2_3820/net6 VSS VSS nmos W=0.31u L=0.04u
M884 AND2_3820/X_u2-net6 RESET VSS VSS nmos W=0.31u L=0.04u
M885 AND2_3820/net6 WX10550 AND2_3820/X_u2-net6 VSS nmos W=0.31u L=0.04u
M886 WX11012 AND2_3820/net6 VDD VDD pmos W=0.41u L=0.04u
M887 AND2_3820/net6 RESET VDD VDD pmos W=0.41u L=0.04u
M888 AND2_3820/net6 WX10550 VDD VDD pmos W=0.41u L=0.04u
M889 WX11010 AND2_3819/net6 VSS VSS nmos W=0.31u L=0.04u
M890 AND2_3819/X_u2-net6 RESET VSS VSS nmos W=0.31u L=0.04u
M891 AND2_3819/net6 WX10536 AND2_3819/X_u2-net6 VSS nmos W=0.31u L=0.04u
M892 WX11010 AND2_3819/net6 VDD VDD pmos W=0.41u L=0.04u
M893 AND2_3819/net6 RESET VDD VDD pmos W=0.41u L=0.04u
M894 AND2_3819/net6 WX10536 VDD VDD pmos W=0.41u L=0.04u
M895 WX11008 AND2_3818/net6 VSS VSS nmos W=0.31u L=0.04u
M896 AND2_3818/X_u2-net6 RESET VSS VSS nmos W=0.31u L=0.04u
M897 AND2_3818/net6 WX10522 AND2_3818/X_u2-net6 VSS nmos W=0.31u L=0.04u
M898 WX11008 AND2_3818/net6 VDD VDD pmos W=0.41u L=0.04u
M899 AND2_3818/net6 RESET VDD VDD pmos W=0.41u L=0.04u
M900 AND2_3818/net6 WX10522 VDD VDD pmos W=0.41u L=0.04u
M901 WX11006 AND2_3817/net6 VSS VSS nmos W=0.31u L=0.04u
M902 AND2_3817/X_u2-net6 RESET VSS VSS nmos W=0.31u L=0.04u
M903 AND2_3817/net6 WX10508 AND2_3817/X_u2-net6 VSS nmos W=0.31u L=0.04u
M904 WX11006 AND2_3817/net6 VDD VDD pmos W=0.41u L=0.04u
M905 AND2_3817/net6 RESET VDD VDD pmos W=0.41u L=0.04u
M906 AND2_3817/net6 WX10508 VDD VDD pmos W=0.41u L=0.04u
M907 WX11004 AND2_3816/net6 VSS VSS nmos W=0.31u L=0.04u
M908 AND2_3816/X_u2-net6 RESET VSS VSS nmos W=0.31u L=0.04u
M909 AND2_3816/net6 WX10494 AND2_3816/X_u2-net6 VSS nmos W=0.31u L=0.04u
M910 WX11004 AND2_3816/net6 VDD VDD pmos W=0.41u L=0.04u
M911 AND2_3816/net6 RESET VDD VDD pmos W=0.41u L=0.04u
M912 AND2_3816/net6 WX10494 VDD VDD pmos W=0.41u L=0.04u
M913 WX11002 AND2_3815/net6 VSS VSS nmos W=0.31u L=0.04u
M914 AND2_3815/X_u2-net6 RESET VSS VSS nmos W=0.31u L=0.04u
M915 AND2_3815/net6 WX10480 AND2_3815/X_u2-net6 VSS nmos W=0.31u L=0.04u
M916 WX11002 AND2_3815/net6 VDD VDD pmos W=0.41u L=0.04u
M917 AND2_3815/net6 RESET VDD VDD pmos W=0.41u L=0.04u
M918 AND2_3815/net6 WX10480 VDD VDD pmos W=0.41u L=0.04u
M919 WX11000 AND2_3814/net6 VSS VSS nmos W=0.31u L=0.04u
M920 AND2_3814/X_u2-net6 RESET VSS VSS nmos W=0.31u L=0.04u
M921 AND2_3814/net6 WX10466 AND2_3814/X_u2-net6 VSS nmos W=0.31u L=0.04u
M922 WX11000 AND2_3814/net6 VDD VDD pmos W=0.41u L=0.04u
M923 AND2_3814/net6 RESET VDD VDD pmos W=0.41u L=0.04u
M924 AND2_3814/net6 WX10466 VDD VDD pmos W=0.41u L=0.04u
M925 WX10998 AND2_3813/net6 VSS VSS nmos W=0.31u L=0.04u
M926 AND2_3813/X_u2-net6 RESET VSS VSS nmos W=0.31u L=0.04u
M927 AND2_3813/net6 WX10452 AND2_3813/X_u2-net6 VSS nmos W=0.31u L=0.04u
M928 WX10998 AND2_3813/net6 VDD VDD pmos W=0.41u L=0.04u
M929 AND2_3813/net6 RESET VDD VDD pmos W=0.41u L=0.04u
M930 AND2_3813/net6 WX10452 VDD VDD pmos W=0.41u L=0.04u
M931 WX10996 AND2_3812/net6 VSS VSS nmos W=0.31u L=0.04u
M932 AND2_3812/X_u2-net6 RESET VSS VSS nmos W=0.31u L=0.04u
M933 AND2_3812/net6 WX10438 AND2_3812/X_u2-net6 VSS nmos W=0.31u L=0.04u
M934 WX10996 AND2_3812/net6 VDD VDD pmos W=0.41u L=0.04u
M935 AND2_3812/net6 RESET VDD VDD pmos W=0.41u L=0.04u
M936 AND2_3812/net6 WX10438 VDD VDD pmos W=0.41u L=0.04u
M937 WX10994 AND2_3811/net6 VSS VSS nmos W=0.31u L=0.04u
M938 AND2_3811/X_u2-net6 RESET VSS VSS nmos W=0.31u L=0.04u
M939 AND2_3811/net6 WX10424 AND2_3811/X_u2-net6 VSS nmos W=0.31u L=0.04u
M940 WX10994 AND2_3811/net6 VDD VDD pmos W=0.41u L=0.04u
M941 AND2_3811/net6 RESET VDD VDD pmos W=0.41u L=0.04u
M942 AND2_3811/net6 WX10424 VDD VDD pmos W=0.41u L=0.04u
M943 WX10992 AND2_3810/net6 VSS VSS nmos W=0.31u L=0.04u
M944 AND2_3810/X_u2-net6 RESET VSS VSS nmos W=0.31u L=0.04u
M945 AND2_3810/net6 WX10410 AND2_3810/X_u2-net6 VSS nmos W=0.31u L=0.04u
M946 WX10992 AND2_3810/net6 VDD VDD pmos W=0.41u L=0.04u
M947 AND2_3810/net6 RESET VDD VDD pmos W=0.41u L=0.04u
M948 AND2_3810/net6 WX10410 VDD VDD pmos W=0.41u L=0.04u
M949 WX10990 AND2_3809/net6 VSS VSS nmos W=0.31u L=0.04u
M950 AND2_3809/X_u2-net6 RESET VSS VSS nmos W=0.31u L=0.04u
M951 AND2_3809/net6 WX10396 AND2_3809/X_u2-net6 VSS nmos W=0.31u L=0.04u
M952 WX10990 AND2_3809/net6 VDD VDD pmos W=0.41u L=0.04u
M953 AND2_3809/net6 RESET VDD VDD pmos W=0.41u L=0.04u
M954 AND2_3809/net6 WX10396 VDD VDD pmos W=0.41u L=0.04u
M955 WX10988 AND2_3808/net6 VSS VSS nmos W=0.31u L=0.04u
M956 AND2_3808/X_u2-net6 RESET VSS VSS nmos W=0.31u L=0.04u
M957 AND2_3808/net6 WX10382 AND2_3808/X_u2-net6 VSS nmos W=0.31u L=0.04u
M958 WX10988 AND2_3808/net6 VDD VDD pmos W=0.41u L=0.04u
M959 AND2_3808/net6 RESET VDD VDD pmos W=0.41u L=0.04u
M960 AND2_3808/net6 WX10382 VDD VDD pmos W=0.41u L=0.04u
M961 WX10890 AND2_3807/net6 VSS VSS nmos W=0.31u L=0.04u
M962 AND2_3807/X_u2-net6 RESET VSS VSS nmos W=0.31u L=0.04u
M963 AND2_3807/net6 WX10827 AND2_3807/X_u2-net6 VSS nmos W=0.31u L=0.04u
M964 WX10890 AND2_3807/net6 VDD VDD pmos W=0.41u L=0.04u
M965 AND2_3807/net6 RESET VDD VDD pmos W=0.41u L=0.04u
M966 AND2_3807/net6 WX10827 VDD VDD pmos W=0.41u L=0.04u
M967 WX10888 AND2_3806/net6 VSS VSS nmos W=0.31u L=0.04u
M968 AND2_3806/X_u2-net6 RESET VSS VSS nmos W=0.31u L=0.04u
M969 AND2_3806/net6 WX10891 AND2_3806/X_u2-net6 VSS nmos W=0.31u L=0.04u
M970 WX10888 AND2_3806/net6 VDD VDD pmos W=0.41u L=0.04u
M971 AND2_3806/net6 RESET VDD VDD pmos W=0.41u L=0.04u
M972 AND2_3806/net6 WX10891 VDD VDD pmos W=0.41u L=0.04u
M973 WX10886 AND2_3805/net6 VSS VSS nmos W=0.31u L=0.04u
M974 AND2_3805/X_u2-net6 RESET VSS VSS nmos W=0.31u L=0.04u
M975 AND2_3805/net6 WX10889 AND2_3805/X_u2-net6 VSS nmos W=0.31u L=0.04u
M976 WX10886 AND2_3805/net6 VDD VDD pmos W=0.41u L=0.04u
M977 AND2_3805/net6 RESET VDD VDD pmos W=0.41u L=0.04u
M978 AND2_3805/net6 WX10889 VDD VDD pmos W=0.41u L=0.04u
M979 WX10884 AND2_3804/net6 VSS VSS nmos W=0.31u L=0.04u
M980 AND2_3804/X_u2-net6 RESET VSS VSS nmos W=0.31u L=0.04u
M981 AND2_3804/net6 WX10887 AND2_3804/X_u2-net6 VSS nmos W=0.31u L=0.04u
M982 WX10884 AND2_3804/net6 VDD VDD pmos W=0.41u L=0.04u
M983 AND2_3804/net6 RESET VDD VDD pmos W=0.41u L=0.04u
M984 AND2_3804/net6 WX10887 VDD VDD pmos W=0.41u L=0.04u
M985 WX10882 AND2_3803/net6 VSS VSS nmos W=0.31u L=0.04u
M986 AND2_3803/X_u2-net6 RESET VSS VSS nmos W=0.31u L=0.04u
M987 AND2_3803/net6 WX10885 AND2_3803/X_u2-net6 VSS nmos W=0.31u L=0.04u
M988 WX10882 AND2_3803/net6 VDD VDD pmos W=0.41u L=0.04u
M989 AND2_3803/net6 RESET VDD VDD pmos W=0.41u L=0.04u
M990 AND2_3803/net6 WX10885 VDD VDD pmos W=0.41u L=0.04u
M991 WX10880 AND2_3802/net6 VSS VSS nmos W=0.31u L=0.04u
M992 AND2_3802/X_u2-net6 RESET VSS VSS nmos W=0.31u L=0.04u
M993 AND2_3802/net6 WX10883 AND2_3802/X_u2-net6 VSS nmos W=0.31u L=0.04u
M994 WX10880 AND2_3802/net6 VDD VDD pmos W=0.41u L=0.04u
M995 AND2_3802/net6 RESET VDD VDD pmos W=0.41u L=0.04u
M996 AND2_3802/net6 WX10883 VDD VDD pmos W=0.41u L=0.04u
M997 WX10878 AND2_3801/net6 VSS VSS nmos W=0.31u L=0.04u
M998 AND2_3801/X_u2-net6 RESET VSS VSS nmos W=0.31u L=0.04u
M999 AND2_3801/net6 WX10881 AND2_3801/X_u2-net6 VSS nmos W=0.31u L=0.04u
M1000 WX10878 AND2_3801/net6 VDD VDD pmos W=0.41u L=0.04u
M1001 AND2_3801/net6 RESET VDD VDD pmos W=0.41u L=0.04u
M1002 AND2_3801/net6 WX10881 VDD VDD pmos W=0.41u L=0.04u
M1003 WX10876 AND2_3800/net6 VSS VSS nmos W=0.31u L=0.04u
M1004 AND2_3800/X_u2-net6 RESET VSS VSS nmos W=0.31u L=0.04u
M1005 AND2_3800/net6 WX10879 AND2_3800/X_u2-net6 VSS nmos W=0.31u L=0.04u
M1006 WX10876 AND2_3800/net6 VDD VDD pmos W=0.41u L=0.04u
M1007 AND2_3800/net6 RESET VDD VDD pmos W=0.41u L=0.04u
M1008 AND2_3800/net6 WX10879 VDD VDD pmos W=0.41u L=0.04u
M1009 WX10874 AND2_3799/net6 VSS VSS nmos W=0.31u L=0.04u
M1010 AND2_3799/X_u2-net6 RESET VSS VSS nmos W=0.31u L=0.04u
M1011 AND2_3799/net6 WX10877 AND2_3799/X_u2-net6 VSS nmos W=0.31u L=0.04u
M1012 WX10874 AND2_3799/net6 VDD VDD pmos W=0.41u L=0.04u
M1013 AND2_3799/net6 RESET VDD VDD pmos W=0.41u L=0.04u
M1014 AND2_3799/net6 WX10877 VDD VDD pmos W=0.41u L=0.04u
M1015 WX10872 AND2_3798/net6 VSS VSS nmos W=0.31u L=0.04u
M1016 AND2_3798/X_u2-net6 RESET VSS VSS nmos W=0.31u L=0.04u
M1017 AND2_3798/net6 WX10875 AND2_3798/X_u2-net6 VSS nmos W=0.31u L=0.04u
M1018 WX10872 AND2_3798/net6 VDD VDD pmos W=0.41u L=0.04u
M1019 AND2_3798/net6 RESET VDD VDD pmos W=0.41u L=0.04u
M1020 AND2_3798/net6 WX10875 VDD VDD pmos W=0.41u L=0.04u
M1021 WX10870 AND2_3797/net6 VSS VSS nmos W=0.31u L=0.04u
M1022 AND2_3797/X_u2-net6 RESET VSS VSS nmos W=0.31u L=0.04u
M1023 AND2_3797/net6 WX10873 AND2_3797/X_u2-net6 VSS nmos W=0.31u L=0.04u
M1024 WX10870 AND2_3797/net6 VDD VDD pmos W=0.41u L=0.04u
M1025 AND2_3797/net6 RESET VDD VDD pmos W=0.41u L=0.04u
M1026 AND2_3797/net6 WX10873 VDD VDD pmos W=0.41u L=0.04u
M1027 WX10868 AND2_3796/net6 VSS VSS nmos W=0.31u L=0.04u
M1028 AND2_3796/X_u2-net6 RESET VSS VSS nmos W=0.31u L=0.04u
M1029 AND2_3796/net6 WX10871 AND2_3796/X_u2-net6 VSS nmos W=0.31u L=0.04u
M1030 WX10868 AND2_3796/net6 VDD VDD pmos W=0.41u L=0.04u
M1031 AND2_3796/net6 RESET VDD VDD pmos W=0.41u L=0.04u
M1032 AND2_3796/net6 WX10871 VDD VDD pmos W=0.41u L=0.04u
M1033 WX10866 AND2_3795/net6 VSS VSS nmos W=0.31u L=0.04u
M1034 AND2_3795/X_u2-net6 RESET VSS VSS nmos W=0.31u L=0.04u
M1035 AND2_3795/net6 WX10869 AND2_3795/X_u2-net6 VSS nmos W=0.31u L=0.04u
M1036 WX10866 AND2_3795/net6 VDD VDD pmos W=0.41u L=0.04u
M1037 AND2_3795/net6 RESET VDD VDD pmos W=0.41u L=0.04u
M1038 AND2_3795/net6 WX10869 VDD VDD pmos W=0.41u L=0.04u
M1039 WX10864 AND2_3794/net6 VSS VSS nmos W=0.31u L=0.04u
M1040 AND2_3794/X_u2-net6 RESET VSS VSS nmos W=0.31u L=0.04u
M1041 AND2_3794/net6 WX10867 AND2_3794/X_u2-net6 VSS nmos W=0.31u L=0.04u
M1042 WX10864 AND2_3794/net6 VDD VDD pmos W=0.41u L=0.04u
M1043 AND2_3794/net6 RESET VDD VDD pmos W=0.41u L=0.04u
M1044 AND2_3794/net6 WX10867 VDD VDD pmos W=0.41u L=0.04u
M1045 WX10862 AND2_3793/net6 VSS VSS nmos W=0.31u L=0.04u
M1046 AND2_3793/X_u2-net6 RESET VSS VSS nmos W=0.31u L=0.04u
M1047 AND2_3793/net6 WX10865 AND2_3793/X_u2-net6 VSS nmos W=0.31u L=0.04u
M1048 WX10862 AND2_3793/net6 VDD VDD pmos W=0.41u L=0.04u
M1049 AND2_3793/net6 RESET VDD VDD pmos W=0.41u L=0.04u
M1050 AND2_3793/net6 WX10865 VDD VDD pmos W=0.41u L=0.04u
M1051 WX10860 AND2_3792/net6 VSS VSS nmos W=0.31u L=0.04u
M1052 AND2_3792/X_u2-net6 RESET VSS VSS nmos W=0.31u L=0.04u
M1053 AND2_3792/net6 WX10863 AND2_3792/X_u2-net6 VSS nmos W=0.31u L=0.04u
M1054 WX10860 AND2_3792/net6 VDD VDD pmos W=0.41u L=0.04u
M1055 AND2_3792/net6 RESET VDD VDD pmos W=0.41u L=0.04u
M1056 AND2_3792/net6 WX10863 VDD VDD pmos W=0.41u L=0.04u
M1057 WX10858 AND2_3791/net6 VSS VSS nmos W=0.31u L=0.04u
M1058 AND2_3791/X_u2-net6 RESET VSS VSS nmos W=0.31u L=0.04u
M1059 AND2_3791/net6 WX10861 AND2_3791/X_u2-net6 VSS nmos W=0.31u L=0.04u
M1060 WX10858 AND2_3791/net6 VDD VDD pmos W=0.41u L=0.04u
M1061 AND2_3791/net6 RESET VDD VDD pmos W=0.41u L=0.04u
M1062 AND2_3791/net6 WX10861 VDD VDD pmos W=0.41u L=0.04u
M1063 WX10856 AND2_3790/net6 VSS VSS nmos W=0.31u L=0.04u
M1064 AND2_3790/X_u2-net6 RESET VSS VSS nmos W=0.31u L=0.04u
M1065 AND2_3790/net6 WX10859 AND2_3790/X_u2-net6 VSS nmos W=0.31u L=0.04u
M1066 WX10856 AND2_3790/net6 VDD VDD pmos W=0.41u L=0.04u
M1067 AND2_3790/net6 RESET VDD VDD pmos W=0.41u L=0.04u
M1068 AND2_3790/net6 WX10859 VDD VDD pmos W=0.41u L=0.04u
M1069 WX10854 AND2_3789/net6 VSS VSS nmos W=0.31u L=0.04u
M1070 AND2_3789/X_u2-net6 RESET VSS VSS nmos W=0.31u L=0.04u
M1071 AND2_3789/net6 WX10857 AND2_3789/X_u2-net6 VSS nmos W=0.31u L=0.04u
M1072 WX10854 AND2_3789/net6 VDD VDD pmos W=0.41u L=0.04u
M1073 AND2_3789/net6 RESET VDD VDD pmos W=0.41u L=0.04u
M1074 AND2_3789/net6 WX10857 VDD VDD pmos W=0.41u L=0.04u
M1075 WX10852 AND2_3788/net6 VSS VSS nmos W=0.31u L=0.04u
M1076 AND2_3788/X_u2-net6 RESET VSS VSS nmos W=0.31u L=0.04u
M1077 AND2_3788/net6 WX10855 AND2_3788/X_u2-net6 VSS nmos W=0.31u L=0.04u
M1078 WX10852 AND2_3788/net6 VDD VDD pmos W=0.41u L=0.04u
M1079 AND2_3788/net6 RESET VDD VDD pmos W=0.41u L=0.04u
M1080 AND2_3788/net6 WX10855 VDD VDD pmos W=0.41u L=0.04u
M1081 WX10850 AND2_3787/net6 VSS VSS nmos W=0.31u L=0.04u
M1082 AND2_3787/X_u2-net6 RESET VSS VSS nmos W=0.31u L=0.04u
M1083 AND2_3787/net6 WX10853 AND2_3787/X_u2-net6 VSS nmos W=0.31u L=0.04u
M1084 WX10850 AND2_3787/net6 VDD VDD pmos W=0.41u L=0.04u
M1085 AND2_3787/net6 RESET VDD VDD pmos W=0.41u L=0.04u
M1086 AND2_3787/net6 WX10853 VDD VDD pmos W=0.41u L=0.04u
M1087 WX10848 AND2_3786/net6 VSS VSS nmos W=0.31u L=0.04u
M1088 AND2_3786/X_u2-net6 RESET VSS VSS nmos W=0.31u L=0.04u
M1089 AND2_3786/net6 WX10851 AND2_3786/X_u2-net6 VSS nmos W=0.31u L=0.04u
M1090 WX10848 AND2_3786/net6 VDD VDD pmos W=0.41u L=0.04u
M1091 AND2_3786/net6 RESET VDD VDD pmos W=0.41u L=0.04u
M1092 AND2_3786/net6 WX10851 VDD VDD pmos W=0.41u L=0.04u
M1093 WX10846 AND2_3785/net6 VSS VSS nmos W=0.31u L=0.04u
M1094 AND2_3785/X_u2-net6 RESET VSS VSS nmos W=0.31u L=0.04u
M1095 AND2_3785/net6 WX10849 AND2_3785/X_u2-net6 VSS nmos W=0.31u L=0.04u
M1096 WX10846 AND2_3785/net6 VDD VDD pmos W=0.41u L=0.04u
M1097 AND2_3785/net6 RESET VDD VDD pmos W=0.41u L=0.04u
M1098 AND2_3785/net6 WX10849 VDD VDD pmos W=0.41u L=0.04u
M1099 WX10844 AND2_3784/net6 VSS VSS nmos W=0.31u L=0.04u
M1100 AND2_3784/X_u2-net6 RESET VSS VSS nmos W=0.31u L=0.04u
M1101 AND2_3784/net6 WX10847 AND2_3784/X_u2-net6 VSS nmos W=0.31u L=0.04u
M1102 WX10844 AND2_3784/net6 VDD VDD pmos W=0.41u L=0.04u
M1103 AND2_3784/net6 RESET VDD VDD pmos W=0.41u L=0.04u
M1104 AND2_3784/net6 WX10847 VDD VDD pmos W=0.41u L=0.04u
M1105 WX10842 AND2_3783/net6 VSS VSS nmos W=0.31u L=0.04u
M1106 AND2_3783/X_u2-net6 RESET VSS VSS nmos W=0.31u L=0.04u
M1107 AND2_3783/net6 WX10845 AND2_3783/X_u2-net6 VSS nmos W=0.31u L=0.04u
M1108 WX10842 AND2_3783/net6 VDD VDD pmos W=0.41u L=0.04u
M1109 AND2_3783/net6 RESET VDD VDD pmos W=0.41u L=0.04u
M1110 AND2_3783/net6 WX10845 VDD VDD pmos W=0.41u L=0.04u
M1111 WX10840 AND2_3782/net6 VSS VSS nmos W=0.31u L=0.04u
M1112 AND2_3782/X_u2-net6 RESET VSS VSS nmos W=0.31u L=0.04u
M1113 AND2_3782/net6 WX10843 AND2_3782/X_u2-net6 VSS nmos W=0.31u L=0.04u
M1114 WX10840 AND2_3782/net6 VDD VDD pmos W=0.41u L=0.04u
M1115 AND2_3782/net6 RESET VDD VDD pmos W=0.41u L=0.04u
M1116 AND2_3782/net6 WX10843 VDD VDD pmos W=0.41u L=0.04u
M1117 WX10838 AND2_3781/net6 VSS VSS nmos W=0.31u L=0.04u
M1118 AND2_3781/X_u2-net6 RESET VSS VSS nmos W=0.31u L=0.04u
M1119 AND2_3781/net6 WX10841 AND2_3781/X_u2-net6 VSS nmos W=0.31u L=0.04u
M1120 WX10838 AND2_3781/net6 VDD VDD pmos W=0.41u L=0.04u
M1121 AND2_3781/net6 RESET VDD VDD pmos W=0.41u L=0.04u
M1122 AND2_3781/net6 WX10841 VDD VDD pmos W=0.41u L=0.04u
M1123 WX10836 AND2_3780/net6 VSS VSS nmos W=0.31u L=0.04u
M1124 AND2_3780/X_u2-net6 RESET VSS VSS nmos W=0.31u L=0.04u
M1125 AND2_3780/net6 WX10839 AND2_3780/X_u2-net6 VSS nmos W=0.31u L=0.04u
M1126 WX10836 AND2_3780/net6 VDD VDD pmos W=0.41u L=0.04u
M1127 AND2_3780/net6 RESET VDD VDD pmos W=0.41u L=0.04u
M1128 AND2_3780/net6 WX10839 VDD VDD pmos W=0.41u L=0.04u
M1129 WX10834 AND2_3779/net6 VSS VSS nmos W=0.31u L=0.04u
M1130 AND2_3779/X_u2-net6 RESET VSS VSS nmos W=0.31u L=0.04u
M1131 AND2_3779/net6 WX10837 AND2_3779/X_u2-net6 VSS nmos W=0.31u L=0.04u
M1132 WX10834 AND2_3779/net6 VDD VDD pmos W=0.41u L=0.04u
M1133 AND2_3779/net6 RESET VDD VDD pmos W=0.41u L=0.04u
M1134 AND2_3779/net6 WX10837 VDD VDD pmos W=0.41u L=0.04u
M1135 WX10832 AND2_3778/net6 VSS VSS nmos W=0.31u L=0.04u
M1136 AND2_3778/X_u2-net6 RESET VSS VSS nmos W=0.31u L=0.04u
M1137 AND2_3778/net6 WX10835 AND2_3778/X_u2-net6 VSS nmos W=0.31u L=0.04u
M1138 WX10832 AND2_3778/net6 VDD VDD pmos W=0.41u L=0.04u
M1139 AND2_3778/net6 RESET VDD VDD pmos W=0.41u L=0.04u
M1140 AND2_3778/net6 WX10835 VDD VDD pmos W=0.41u L=0.04u
M1141 WX10830 AND2_3777/net6 VSS VSS nmos W=0.31u L=0.04u
M1142 AND2_3777/X_u2-net6 RESET VSS VSS nmos W=0.31u L=0.04u
M1143 AND2_3777/net6 WX10833 AND2_3777/X_u2-net6 VSS nmos W=0.31u L=0.04u
M1144 WX10830 AND2_3777/net6 VDD VDD pmos W=0.41u L=0.04u
M1145 AND2_3777/net6 RESET VDD VDD pmos W=0.41u L=0.04u
M1146 AND2_3777/net6 WX10833 VDD VDD pmos W=0.41u L=0.04u
M1147 WX10828 AND2_3776/net6 VSS VSS nmos W=0.31u L=0.04u
M1148 AND2_3776/X_u2-net6 RESET VSS VSS nmos W=0.31u L=0.04u
M1149 AND2_3776/net6 WX10831 AND2_3776/X_u2-net6 VSS nmos W=0.31u L=0.04u
M1150 WX10828 AND2_3776/net6 VDD VDD pmos W=0.41u L=0.04u
M1151 AND2_3776/net6 RESET VDD VDD pmos W=0.41u L=0.04u
M1152 AND2_3776/net6 WX10831 VDD VDD pmos W=0.41u L=0.04u
M1153 WX10377 AND2_3583/net6 VSS VSS nmos W=0.31u L=0.04u
M1154 AND2_3583/X_u2-net6 RESET VSS VSS nmos W=0.31u L=0.04u
M1155 AND2_3583/net6 n1176 AND2_3583/X_u2-net6 VSS nmos W=0.31u L=0.04u
M1156 WX10377 AND2_3583/net6 VDD VDD pmos W=0.41u L=0.04u
M1157 AND2_3583/net6 RESET VDD VDD pmos W=0.41u L=0.04u
M1158 AND2_3583/net6 n1176 VDD VDD pmos W=0.41u L=0.04u
M1159 WX10375 AND2_3582/net6 VSS VSS nmos W=0.31u L=0.04u
M1160 AND2_3582/X_u2-net6 RESET VSS VSS nmos W=0.31u L=0.04u
M1161 AND2_3582/net6 n1177 AND2_3582/X_u2-net6 VSS nmos W=0.31u L=0.04u
M1162 WX10375 AND2_3582/net6 VDD VDD pmos W=0.41u L=0.04u
M1163 AND2_3582/net6 RESET VDD VDD pmos W=0.41u L=0.04u
M1164 AND2_3582/net6 n1177 VDD VDD pmos W=0.41u L=0.04u
M1165 WX10373 AND2_3581/net6 VSS VSS nmos W=0.31u L=0.04u
M1166 AND2_3581/X_u2-net6 RESET VSS VSS nmos W=0.31u L=0.04u
M1167 AND2_3581/net6 n1178 AND2_3581/X_u2-net6 VSS nmos W=0.31u L=0.04u
M1168 WX10373 AND2_3581/net6 VDD VDD pmos W=0.41u L=0.04u
M1169 AND2_3581/net6 RESET VDD VDD pmos W=0.41u L=0.04u
M1170 AND2_3581/net6 n1178 VDD VDD pmos W=0.41u L=0.04u
M1171 WX10371 AND2_3580/net6 VSS VSS nmos W=0.31u L=0.04u
M1172 AND2_3580/X_u2-net6 RESET VSS VSS nmos W=0.31u L=0.04u
M1173 AND2_3580/net6 n1179 AND2_3580/X_u2-net6 VSS nmos W=0.31u L=0.04u
M1174 WX10371 AND2_3580/net6 VDD VDD pmos W=0.41u L=0.04u
M1175 AND2_3580/net6 RESET VDD VDD pmos W=0.41u L=0.04u
M1176 AND2_3580/net6 n1179 VDD VDD pmos W=0.41u L=0.04u
M1177 WX10369 AND2_3579/net6 VSS VSS nmos W=0.31u L=0.04u
M1178 AND2_3579/X_u2-net6 RESET VSS VSS nmos W=0.31u L=0.04u
M1179 AND2_3579/net6 n1180 AND2_3579/X_u2-net6 VSS nmos W=0.31u L=0.04u
M1180 WX10369 AND2_3579/net6 VDD VDD pmos W=0.41u L=0.04u
M1181 AND2_3579/net6 RESET VDD VDD pmos W=0.41u L=0.04u
M1182 AND2_3579/net6 n1180 VDD VDD pmos W=0.41u L=0.04u
M1183 WX10367 AND2_3578/net6 VSS VSS nmos W=0.31u L=0.04u
M1184 AND2_3578/X_u2-net6 RESET VSS VSS nmos W=0.31u L=0.04u
M1185 AND2_3578/net6 n1181 AND2_3578/X_u2-net6 VSS nmos W=0.31u L=0.04u
M1186 WX10367 AND2_3578/net6 VDD VDD pmos W=0.41u L=0.04u
M1187 AND2_3578/net6 RESET VDD VDD pmos W=0.41u L=0.04u
M1188 AND2_3578/net6 n1181 VDD VDD pmos W=0.41u L=0.04u
M1189 WX10365 AND2_3577/net6 VSS VSS nmos W=0.31u L=0.04u
M1190 AND2_3577/X_u2-net6 RESET VSS VSS nmos W=0.31u L=0.04u
M1191 AND2_3577/net6 n1182 AND2_3577/X_u2-net6 VSS nmos W=0.31u L=0.04u
M1192 WX10365 AND2_3577/net6 VDD VDD pmos W=0.41u L=0.04u
M1193 AND2_3577/net6 RESET VDD VDD pmos W=0.41u L=0.04u
M1194 AND2_3577/net6 n1182 VDD VDD pmos W=0.41u L=0.04u
M1195 WX10363 AND2_3576/net6 VSS VSS nmos W=0.31u L=0.04u
M1196 AND2_3576/X_u2-net6 RESET VSS VSS nmos W=0.31u L=0.04u
M1197 AND2_3576/net6 n1183 AND2_3576/X_u2-net6 VSS nmos W=0.31u L=0.04u
M1198 WX10363 AND2_3576/net6 VDD VDD pmos W=0.41u L=0.04u
M1199 AND2_3576/net6 RESET VDD VDD pmos W=0.41u L=0.04u
M1200 AND2_3576/net6 n1183 VDD VDD pmos W=0.41u L=0.04u
M1201 WX10361 AND2_3575/net6 VSS VSS nmos W=0.31u L=0.04u
M1202 AND2_3575/X_u2-net6 RESET VSS VSS nmos W=0.31u L=0.04u
M1203 AND2_3575/net6 n1184 AND2_3575/X_u2-net6 VSS nmos W=0.31u L=0.04u
M1204 WX10361 AND2_3575/net6 VDD VDD pmos W=0.41u L=0.04u
M1205 AND2_3575/net6 RESET VDD VDD pmos W=0.41u L=0.04u
M1206 AND2_3575/net6 n1184 VDD VDD pmos W=0.41u L=0.04u
M1207 WX10359 AND2_3574/net6 VSS VSS nmos W=0.31u L=0.04u
M1208 AND2_3574/X_u2-net6 RESET VSS VSS nmos W=0.31u L=0.04u
M1209 AND2_3574/net6 n1185 AND2_3574/X_u2-net6 VSS nmos W=0.31u L=0.04u
M1210 WX10359 AND2_3574/net6 VDD VDD pmos W=0.41u L=0.04u
M1211 AND2_3574/net6 RESET VDD VDD pmos W=0.41u L=0.04u
M1212 AND2_3574/net6 n1185 VDD VDD pmos W=0.41u L=0.04u
M1213 WX10357 AND2_3573/net6 VSS VSS nmos W=0.31u L=0.04u
M1214 AND2_3573/X_u2-net6 RESET VSS VSS nmos W=0.31u L=0.04u
M1215 AND2_3573/net6 n1186 AND2_3573/X_u2-net6 VSS nmos W=0.31u L=0.04u
M1216 WX10357 AND2_3573/net6 VDD VDD pmos W=0.41u L=0.04u
M1217 AND2_3573/net6 RESET VDD VDD pmos W=0.41u L=0.04u
M1218 AND2_3573/net6 n1186 VDD VDD pmos W=0.41u L=0.04u
M1219 WX10355 AND2_3572/net6 VSS VSS nmos W=0.31u L=0.04u
M1220 AND2_3572/X_u2-net6 RESET VSS VSS nmos W=0.31u L=0.04u
M1221 AND2_3572/net6 n1187 AND2_3572/X_u2-net6 VSS nmos W=0.31u L=0.04u
M1222 WX10355 AND2_3572/net6 VDD VDD pmos W=0.41u L=0.04u
M1223 AND2_3572/net6 RESET VDD VDD pmos W=0.41u L=0.04u
M1224 AND2_3572/net6 n1187 VDD VDD pmos W=0.41u L=0.04u
M1225 WX10353 AND2_3571/net6 VSS VSS nmos W=0.31u L=0.04u
M1226 AND2_3571/X_u2-net6 RESET VSS VSS nmos W=0.31u L=0.04u
M1227 AND2_3571/net6 n1188 AND2_3571/X_u2-net6 VSS nmos W=0.31u L=0.04u
M1228 WX10353 AND2_3571/net6 VDD VDD pmos W=0.41u L=0.04u
M1229 AND2_3571/net6 RESET VDD VDD pmos W=0.41u L=0.04u
M1230 AND2_3571/net6 n1188 VDD VDD pmos W=0.41u L=0.04u
M1231 WX10351 AND2_3570/net6 VSS VSS nmos W=0.31u L=0.04u
M1232 AND2_3570/X_u2-net6 RESET VSS VSS nmos W=0.31u L=0.04u
M1233 AND2_3570/net6 n1189 AND2_3570/X_u2-net6 VSS nmos W=0.31u L=0.04u
M1234 WX10351 AND2_3570/net6 VDD VDD pmos W=0.41u L=0.04u
M1235 AND2_3570/net6 RESET VDD VDD pmos W=0.41u L=0.04u
M1236 AND2_3570/net6 n1189 VDD VDD pmos W=0.41u L=0.04u
M1237 WX10349 AND2_3569/net6 VSS VSS nmos W=0.31u L=0.04u
M1238 AND2_3569/X_u2-net6 RESET VSS VSS nmos W=0.31u L=0.04u
M1239 AND2_3569/net6 n1190 AND2_3569/X_u2-net6 VSS nmos W=0.31u L=0.04u
M1240 WX10349 AND2_3569/net6 VDD VDD pmos W=0.41u L=0.04u
M1241 AND2_3569/net6 RESET VDD VDD pmos W=0.41u L=0.04u
M1242 AND2_3569/net6 n1190 VDD VDD pmos W=0.41u L=0.04u
M1243 WX10347 AND2_3568/net6 VSS VSS nmos W=0.31u L=0.04u
M1244 AND2_3568/X_u2-net6 RESET VSS VSS nmos W=0.31u L=0.04u
M1245 AND2_3568/net6 n1191 AND2_3568/X_u2-net6 VSS nmos W=0.31u L=0.04u
M1246 WX10347 AND2_3568/net6 VDD VDD pmos W=0.41u L=0.04u
M1247 AND2_3568/net6 RESET VDD VDD pmos W=0.41u L=0.04u
M1248 AND2_3568/net6 n1191 VDD VDD pmos W=0.41u L=0.04u
M1249 WX10345 AND2_3567/net6 VSS VSS nmos W=0.31u L=0.04u
M1250 AND2_3567/X_u2-net6 RESET VSS VSS nmos W=0.31u L=0.04u
M1251 AND2_3567/net6 n1192 AND2_3567/X_u2-net6 VSS nmos W=0.31u L=0.04u
M1252 WX10345 AND2_3567/net6 VDD VDD pmos W=0.41u L=0.04u
M1253 AND2_3567/net6 RESET VDD VDD pmos W=0.41u L=0.04u
M1254 AND2_3567/net6 n1192 VDD VDD pmos W=0.41u L=0.04u
M1255 WX10343 AND2_3566/net6 VSS VSS nmos W=0.31u L=0.04u
M1256 AND2_3566/X_u2-net6 RESET VSS VSS nmos W=0.31u L=0.04u
M1257 AND2_3566/net6 n1193 AND2_3566/X_u2-net6 VSS nmos W=0.31u L=0.04u
M1258 WX10343 AND2_3566/net6 VDD VDD pmos W=0.41u L=0.04u
M1259 AND2_3566/net6 RESET VDD VDD pmos W=0.41u L=0.04u
M1260 AND2_3566/net6 n1193 VDD VDD pmos W=0.41u L=0.04u
M1261 WX10341 AND2_3565/net6 VSS VSS nmos W=0.31u L=0.04u
M1262 AND2_3565/X_u2-net6 RESET VSS VSS nmos W=0.31u L=0.04u
M1263 AND2_3565/net6 n1194 AND2_3565/X_u2-net6 VSS nmos W=0.31u L=0.04u
M1264 WX10341 AND2_3565/net6 VDD VDD pmos W=0.41u L=0.04u
M1265 AND2_3565/net6 RESET VDD VDD pmos W=0.41u L=0.04u
M1266 AND2_3565/net6 n1194 VDD VDD pmos W=0.41u L=0.04u
M1267 WX10339 AND2_3564/net6 VSS VSS nmos W=0.31u L=0.04u
M1268 AND2_3564/X_u2-net6 RESET VSS VSS nmos W=0.31u L=0.04u
M1269 AND2_3564/net6 n1195 AND2_3564/X_u2-net6 VSS nmos W=0.31u L=0.04u
M1270 WX10339 AND2_3564/net6 VDD VDD pmos W=0.41u L=0.04u
M1271 AND2_3564/net6 RESET VDD VDD pmos W=0.41u L=0.04u
M1272 AND2_3564/net6 n1195 VDD VDD pmos W=0.41u L=0.04u
M1273 WX10337 AND2_3563/net6 VSS VSS nmos W=0.31u L=0.04u
M1274 AND2_3563/X_u2-net6 RESET VSS VSS nmos W=0.31u L=0.04u
M1275 AND2_3563/net6 n1196 AND2_3563/X_u2-net6 VSS nmos W=0.31u L=0.04u
M1276 WX10337 AND2_3563/net6 VDD VDD pmos W=0.41u L=0.04u
M1277 AND2_3563/net6 RESET VDD VDD pmos W=0.41u L=0.04u
M1278 AND2_3563/net6 n1196 VDD VDD pmos W=0.41u L=0.04u
M1279 WX10335 AND2_3562/net6 VSS VSS nmos W=0.31u L=0.04u
M1280 AND2_3562/X_u2-net6 RESET VSS VSS nmos W=0.31u L=0.04u
M1281 AND2_3562/net6 n1197 AND2_3562/X_u2-net6 VSS nmos W=0.31u L=0.04u
M1282 WX10335 AND2_3562/net6 VDD VDD pmos W=0.41u L=0.04u
M1283 AND2_3562/net6 RESET VDD VDD pmos W=0.41u L=0.04u
M1284 AND2_3562/net6 n1197 VDD VDD pmos W=0.41u L=0.04u
M1285 WX10333 AND2_3561/net6 VSS VSS nmos W=0.31u L=0.04u
M1286 AND2_3561/X_u2-net6 RESET VSS VSS nmos W=0.31u L=0.04u
M1287 AND2_3561/net6 n1198 AND2_3561/X_u2-net6 VSS nmos W=0.31u L=0.04u
M1288 WX10333 AND2_3561/net6 VDD VDD pmos W=0.41u L=0.04u
M1289 AND2_3561/net6 RESET VDD VDD pmos W=0.41u L=0.04u
M1290 AND2_3561/net6 n1198 VDD VDD pmos W=0.41u L=0.04u
M1291 WX10331 AND2_3560/net6 VSS VSS nmos W=0.31u L=0.04u
M1292 AND2_3560/X_u2-net6 RESET VSS VSS nmos W=0.31u L=0.04u
M1293 AND2_3560/net6 n1199 AND2_3560/X_u2-net6 VSS nmos W=0.31u L=0.04u
M1294 WX10331 AND2_3560/net6 VDD VDD pmos W=0.41u L=0.04u
M1295 AND2_3560/net6 RESET VDD VDD pmos W=0.41u L=0.04u
M1296 AND2_3560/net6 n1199 VDD VDD pmos W=0.41u L=0.04u
M1297 WX10329 AND2_3559/net6 VSS VSS nmos W=0.31u L=0.04u
M1298 AND2_3559/X_u2-net6 RESET VSS VSS nmos W=0.31u L=0.04u
M1299 AND2_3559/net6 n1200 AND2_3559/X_u2-net6 VSS nmos W=0.31u L=0.04u
M1300 WX10329 AND2_3559/net6 VDD VDD pmos W=0.41u L=0.04u
M1301 AND2_3559/net6 RESET VDD VDD pmos W=0.41u L=0.04u
M1302 AND2_3559/net6 n1200 VDD VDD pmos W=0.41u L=0.04u
M1303 WX10327 AND2_3558/net6 VSS VSS nmos W=0.31u L=0.04u
M1304 AND2_3558/X_u2-net6 RESET VSS VSS nmos W=0.31u L=0.04u
M1305 AND2_3558/net6 n1201 AND2_3558/X_u2-net6 VSS nmos W=0.31u L=0.04u
M1306 WX10327 AND2_3558/net6 VDD VDD pmos W=0.41u L=0.04u
M1307 AND2_3558/net6 RESET VDD VDD pmos W=0.41u L=0.04u
M1308 AND2_3558/net6 n1201 VDD VDD pmos W=0.41u L=0.04u
M1309 WX10325 AND2_3557/net6 VSS VSS nmos W=0.31u L=0.04u
M1310 AND2_3557/X_u2-net6 RESET VSS VSS nmos W=0.31u L=0.04u
M1311 AND2_3557/net6 n1202 AND2_3557/X_u2-net6 VSS nmos W=0.31u L=0.04u
M1312 WX10325 AND2_3557/net6 VDD VDD pmos W=0.41u L=0.04u
M1313 AND2_3557/net6 RESET VDD VDD pmos W=0.41u L=0.04u
M1314 AND2_3557/net6 n1202 VDD VDD pmos W=0.41u L=0.04u
M1315 WX10323 AND2_3556/net6 VSS VSS nmos W=0.31u L=0.04u
M1316 AND2_3556/X_u2-net6 RESET VSS VSS nmos W=0.31u L=0.04u
M1317 AND2_3556/net6 n1203 AND2_3556/X_u2-net6 VSS nmos W=0.31u L=0.04u
M1318 WX10323 AND2_3556/net6 VDD VDD pmos W=0.41u L=0.04u
M1319 AND2_3556/net6 RESET VDD VDD pmos W=0.41u L=0.04u
M1320 AND2_3556/net6 n1203 VDD VDD pmos W=0.41u L=0.04u
M1321 WX10321 AND2_3555/net6 VSS VSS nmos W=0.31u L=0.04u
M1322 AND2_3555/X_u2-net6 RESET VSS VSS nmos W=0.31u L=0.04u
M1323 AND2_3555/net6 n1204 AND2_3555/X_u2-net6 VSS nmos W=0.31u L=0.04u
M1324 WX10321 AND2_3555/net6 VDD VDD pmos W=0.41u L=0.04u
M1325 AND2_3555/net6 RESET VDD VDD pmos W=0.41u L=0.04u
M1326 AND2_3555/net6 n1204 VDD VDD pmos W=0.41u L=0.04u
M1327 WX10319 AND2_3554/net6 VSS VSS nmos W=0.31u L=0.04u
M1328 AND2_3554/X_u2-net6 RESET VSS VSS nmos W=0.31u L=0.04u
M1329 AND2_3554/net6 n1205 AND2_3554/X_u2-net6 VSS nmos W=0.31u L=0.04u
M1330 WX10319 AND2_3554/net6 VDD VDD pmos W=0.41u L=0.04u
M1331 AND2_3554/net6 RESET VDD VDD pmos W=0.41u L=0.04u
M1332 AND2_3554/net6 n1205 VDD VDD pmos W=0.41u L=0.04u
M1333 WX10317 AND2_3553/net6 VSS VSS nmos W=0.31u L=0.04u
M1334 AND2_3553/X_u2-net6 RESET VSS VSS nmos W=0.31u L=0.04u
M1335 AND2_3553/net6 n1206 AND2_3553/X_u2-net6 VSS nmos W=0.31u L=0.04u
M1336 WX10317 AND2_3553/net6 VDD VDD pmos W=0.41u L=0.04u
M1337 AND2_3553/net6 RESET VDD VDD pmos W=0.41u L=0.04u
M1338 AND2_3553/net6 n1206 VDD VDD pmos W=0.41u L=0.04u
M1339 WX10315 AND2_3552/net6 VSS VSS nmos W=0.31u L=0.04u
M1340 AND2_3552/X_u2-net6 RESET VSS VSS nmos W=0.31u L=0.04u
M1341 AND2_3552/net6 n1207 AND2_3552/X_u2-net6 VSS nmos W=0.31u L=0.04u
M1342 WX10315 AND2_3552/net6 VDD VDD pmos W=0.41u L=0.04u
M1343 AND2_3552/net6 RESET VDD VDD pmos W=0.41u L=0.04u
M1344 AND2_3552/net6 n1207 VDD VDD pmos W=0.41u L=0.04u
M1345 WX9949 AND2_3487/net6 VSS VSS nmos W=0.31u L=0.04u
M1346 AND2_3487/X_u2-net6 RESET VSS VSS nmos W=0.31u L=0.04u
M1347 AND2_3487/net6 WX9886 AND2_3487/X_u2-net6 VSS nmos W=0.31u L=0.04u
M1348 WX9949 AND2_3487/net6 VDD VDD pmos W=0.41u L=0.04u
M1349 AND2_3487/net6 RESET VDD VDD pmos W=0.41u L=0.04u
M1350 AND2_3487/net6 WX9886 VDD VDD pmos W=0.41u L=0.04u
M1351 WX9947 AND2_3486/net6 VSS VSS nmos W=0.31u L=0.04u
M1352 AND2_3486/X_u2-net6 RESET VSS VSS nmos W=0.31u L=0.04u
M1353 AND2_3486/net6 WX9884 AND2_3486/X_u2-net6 VSS nmos W=0.31u L=0.04u
M1354 WX9947 AND2_3486/net6 VDD VDD pmos W=0.41u L=0.04u
M1355 AND2_3486/net6 RESET VDD VDD pmos W=0.41u L=0.04u
M1356 AND2_3486/net6 WX9884 VDD VDD pmos W=0.41u L=0.04u
M1357 WX9945 AND2_3485/net6 VSS VSS nmos W=0.31u L=0.04u
M1358 AND2_3485/X_u2-net6 RESET VSS VSS nmos W=0.31u L=0.04u
M1359 AND2_3485/net6 WX9882 AND2_3485/X_u2-net6 VSS nmos W=0.31u L=0.04u
M1360 WX9945 AND2_3485/net6 VDD VDD pmos W=0.41u L=0.04u
M1361 AND2_3485/net6 RESET VDD VDD pmos W=0.41u L=0.04u
M1362 AND2_3485/net6 WX9882 VDD VDD pmos W=0.41u L=0.04u
M1363 WX9943 AND2_3484/net6 VSS VSS nmos W=0.31u L=0.04u
M1364 AND2_3484/X_u2-net6 RESET VSS VSS nmos W=0.31u L=0.04u
M1365 AND2_3484/net6 WX9880 AND2_3484/X_u2-net6 VSS nmos W=0.31u L=0.04u
M1366 WX9943 AND2_3484/net6 VDD VDD pmos W=0.41u L=0.04u
M1367 AND2_3484/net6 RESET VDD VDD pmos W=0.41u L=0.04u
M1368 AND2_3484/net6 WX9880 VDD VDD pmos W=0.41u L=0.04u
M1369 WX9941 AND2_3483/net6 VSS VSS nmos W=0.31u L=0.04u
M1370 AND2_3483/X_u2-net6 RESET VSS VSS nmos W=0.31u L=0.04u
M1371 AND2_3483/net6 WX9878 AND2_3483/X_u2-net6 VSS nmos W=0.31u L=0.04u
M1372 WX9941 AND2_3483/net6 VDD VDD pmos W=0.41u L=0.04u
M1373 AND2_3483/net6 RESET VDD VDD pmos W=0.41u L=0.04u
M1374 AND2_3483/net6 WX9878 VDD VDD pmos W=0.41u L=0.04u
M1375 WX9939 AND2_3482/net6 VSS VSS nmos W=0.31u L=0.04u
M1376 AND2_3482/X_u2-net6 RESET VSS VSS nmos W=0.31u L=0.04u
M1377 AND2_3482/net6 WX9876 AND2_3482/X_u2-net6 VSS nmos W=0.31u L=0.04u
M1378 WX9939 AND2_3482/net6 VDD VDD pmos W=0.41u L=0.04u
M1379 AND2_3482/net6 RESET VDD VDD pmos W=0.41u L=0.04u
M1380 AND2_3482/net6 WX9876 VDD VDD pmos W=0.41u L=0.04u
M1381 WX9937 AND2_3481/net6 VSS VSS nmos W=0.31u L=0.04u
M1382 AND2_3481/X_u2-net6 RESET VSS VSS nmos W=0.31u L=0.04u
M1383 AND2_3481/net6 WX9874 AND2_3481/X_u2-net6 VSS nmos W=0.31u L=0.04u
M1384 WX9937 AND2_3481/net6 VDD VDD pmos W=0.41u L=0.04u
M1385 AND2_3481/net6 RESET VDD VDD pmos W=0.41u L=0.04u
M1386 AND2_3481/net6 WX9874 VDD VDD pmos W=0.41u L=0.04u
M1387 WX9935 AND2_3480/net6 VSS VSS nmos W=0.31u L=0.04u
M1388 AND2_3480/X_u2-net6 RESET VSS VSS nmos W=0.31u L=0.04u
M1389 AND2_3480/net6 WX9872 AND2_3480/X_u2-net6 VSS nmos W=0.31u L=0.04u
M1390 WX9935 AND2_3480/net6 VDD VDD pmos W=0.41u L=0.04u
M1391 AND2_3480/net6 RESET VDD VDD pmos W=0.41u L=0.04u
M1392 AND2_3480/net6 WX9872 VDD VDD pmos W=0.41u L=0.04u
M1393 WX9933 AND2_3479/net6 VSS VSS nmos W=0.31u L=0.04u
M1394 AND2_3479/X_u2-net6 RESET VSS VSS nmos W=0.31u L=0.04u
M1395 AND2_3479/net6 WX9870 AND2_3479/X_u2-net6 VSS nmos W=0.31u L=0.04u
M1396 WX9933 AND2_3479/net6 VDD VDD pmos W=0.41u L=0.04u
M1397 AND2_3479/net6 RESET VDD VDD pmos W=0.41u L=0.04u
M1398 AND2_3479/net6 WX9870 VDD VDD pmos W=0.41u L=0.04u
M1399 WX9931 AND2_3478/net6 VSS VSS nmos W=0.31u L=0.04u
M1400 AND2_3478/X_u2-net6 RESET VSS VSS nmos W=0.31u L=0.04u
M1401 AND2_3478/net6 WX9868 AND2_3478/X_u2-net6 VSS nmos W=0.31u L=0.04u
M1402 WX9931 AND2_3478/net6 VDD VDD pmos W=0.41u L=0.04u
M1403 AND2_3478/net6 RESET VDD VDD pmos W=0.41u L=0.04u
M1404 AND2_3478/net6 WX9868 VDD VDD pmos W=0.41u L=0.04u
M1405 WX9929 AND2_3477/net6 VSS VSS nmos W=0.31u L=0.04u
M1406 AND2_3477/X_u2-net6 RESET VSS VSS nmos W=0.31u L=0.04u
M1407 AND2_3477/net6 WX9866 AND2_3477/X_u2-net6 VSS nmos W=0.31u L=0.04u
M1408 WX9929 AND2_3477/net6 VDD VDD pmos W=0.41u L=0.04u
M1409 AND2_3477/net6 RESET VDD VDD pmos W=0.41u L=0.04u
M1410 AND2_3477/net6 WX9866 VDD VDD pmos W=0.41u L=0.04u
M1411 WX9927 AND2_3476/net6 VSS VSS nmos W=0.31u L=0.04u
M1412 AND2_3476/X_u2-net6 RESET VSS VSS nmos W=0.31u L=0.04u
M1413 AND2_3476/net6 WX9864 AND2_3476/X_u2-net6 VSS nmos W=0.31u L=0.04u
M1414 WX9927 AND2_3476/net6 VDD VDD pmos W=0.41u L=0.04u
M1415 AND2_3476/net6 RESET VDD VDD pmos W=0.41u L=0.04u
M1416 AND2_3476/net6 WX9864 VDD VDD pmos W=0.41u L=0.04u
M1417 WX9925 AND2_3475/net6 VSS VSS nmos W=0.31u L=0.04u
M1418 AND2_3475/X_u2-net6 RESET VSS VSS nmos W=0.31u L=0.04u
M1419 AND2_3475/net6 WX9862 AND2_3475/X_u2-net6 VSS nmos W=0.31u L=0.04u
M1420 WX9925 AND2_3475/net6 VDD VDD pmos W=0.41u L=0.04u
M1421 AND2_3475/net6 RESET VDD VDD pmos W=0.41u L=0.04u
M1422 AND2_3475/net6 WX9862 VDD VDD pmos W=0.41u L=0.04u
M1423 WX9923 AND2_3474/net6 VSS VSS nmos W=0.31u L=0.04u
M1424 AND2_3474/X_u2-net6 RESET VSS VSS nmos W=0.31u L=0.04u
M1425 AND2_3474/net6 WX9860 AND2_3474/X_u2-net6 VSS nmos W=0.31u L=0.04u
M1426 WX9923 AND2_3474/net6 VDD VDD pmos W=0.41u L=0.04u
M1427 AND2_3474/net6 RESET VDD VDD pmos W=0.41u L=0.04u
M1428 AND2_3474/net6 WX9860 VDD VDD pmos W=0.41u L=0.04u
M1429 WX9921 AND2_3473/net6 VSS VSS nmos W=0.31u L=0.04u
M1430 AND2_3473/X_u2-net6 RESET VSS VSS nmos W=0.31u L=0.04u
M1431 AND2_3473/net6 WX9858 AND2_3473/X_u2-net6 VSS nmos W=0.31u L=0.04u
M1432 WX9921 AND2_3473/net6 VDD VDD pmos W=0.41u L=0.04u
M1433 AND2_3473/net6 RESET VDD VDD pmos W=0.41u L=0.04u
M1434 AND2_3473/net6 WX9858 VDD VDD pmos W=0.41u L=0.04u
M1435 WX9919 AND2_3472/net6 VSS VSS nmos W=0.31u L=0.04u
M1436 AND2_3472/X_u2-net6 RESET VSS VSS nmos W=0.31u L=0.04u
M1437 AND2_3472/net6 WX9856 AND2_3472/X_u2-net6 VSS nmos W=0.31u L=0.04u
M1438 WX9919 AND2_3472/net6 VDD VDD pmos W=0.41u L=0.04u
M1439 AND2_3472/net6 RESET VDD VDD pmos W=0.41u L=0.04u
M1440 AND2_3472/net6 WX9856 VDD VDD pmos W=0.41u L=0.04u
M1441 WX9917 AND2_3471/net6 VSS VSS nmos W=0.31u L=0.04u
M1442 AND2_3471/X_u2-net6 RESET VSS VSS nmos W=0.31u L=0.04u
M1443 AND2_3471/net6 WX9854 AND2_3471/X_u2-net6 VSS nmos W=0.31u L=0.04u
M1444 WX9917 AND2_3471/net6 VDD VDD pmos W=0.41u L=0.04u
M1445 AND2_3471/net6 RESET VDD VDD pmos W=0.41u L=0.04u
M1446 AND2_3471/net6 WX9854 VDD VDD pmos W=0.41u L=0.04u
M1447 WX9915 AND2_3470/net6 VSS VSS nmos W=0.31u L=0.04u
M1448 AND2_3470/X_u2-net6 RESET VSS VSS nmos W=0.31u L=0.04u
M1449 AND2_3470/net6 WX9852 AND2_3470/X_u2-net6 VSS nmos W=0.31u L=0.04u
M1450 WX9915 AND2_3470/net6 VDD VDD pmos W=0.41u L=0.04u
M1451 AND2_3470/net6 RESET VDD VDD pmos W=0.41u L=0.04u
M1452 AND2_3470/net6 WX9852 VDD VDD pmos W=0.41u L=0.04u
M1453 WX9913 AND2_3469/net6 VSS VSS nmos W=0.31u L=0.04u
M1454 AND2_3469/X_u2-net6 RESET VSS VSS nmos W=0.31u L=0.04u
M1455 AND2_3469/net6 WX9850 AND2_3469/X_u2-net6 VSS nmos W=0.31u L=0.04u
M1456 WX9913 AND2_3469/net6 VDD VDD pmos W=0.41u L=0.04u
M1457 AND2_3469/net6 RESET VDD VDD pmos W=0.41u L=0.04u
M1458 AND2_3469/net6 WX9850 VDD VDD pmos W=0.41u L=0.04u
M1459 WX9911 AND2_3468/net6 VSS VSS nmos W=0.31u L=0.04u
M1460 AND2_3468/X_u2-net6 RESET VSS VSS nmos W=0.31u L=0.04u
M1461 AND2_3468/net6 WX9848 AND2_3468/X_u2-net6 VSS nmos W=0.31u L=0.04u
M1462 WX9911 AND2_3468/net6 VDD VDD pmos W=0.41u L=0.04u
M1463 AND2_3468/net6 RESET VDD VDD pmos W=0.41u L=0.04u
M1464 AND2_3468/net6 WX9848 VDD VDD pmos W=0.41u L=0.04u
M1465 WX9909 AND2_3467/net6 VSS VSS nmos W=0.31u L=0.04u
M1466 AND2_3467/X_u2-net6 RESET VSS VSS nmos W=0.31u L=0.04u
M1467 AND2_3467/net6 WX9846 AND2_3467/X_u2-net6 VSS nmos W=0.31u L=0.04u
M1468 WX9909 AND2_3467/net6 VDD VDD pmos W=0.41u L=0.04u
M1469 AND2_3467/net6 RESET VDD VDD pmos W=0.41u L=0.04u
M1470 AND2_3467/net6 WX9846 VDD VDD pmos W=0.41u L=0.04u
M1471 WX9907 AND2_3466/net6 VSS VSS nmos W=0.31u L=0.04u
M1472 AND2_3466/X_u2-net6 RESET VSS VSS nmos W=0.31u L=0.04u
M1473 AND2_3466/net6 WX9844 AND2_3466/X_u2-net6 VSS nmos W=0.31u L=0.04u
M1474 WX9907 AND2_3466/net6 VDD VDD pmos W=0.41u L=0.04u
M1475 AND2_3466/net6 RESET VDD VDD pmos W=0.41u L=0.04u
M1476 AND2_3466/net6 WX9844 VDD VDD pmos W=0.41u L=0.04u
M1477 WX9905 AND2_3465/net6 VSS VSS nmos W=0.31u L=0.04u
M1478 AND2_3465/X_u2-net6 RESET VSS VSS nmos W=0.31u L=0.04u
M1479 AND2_3465/net6 WX9842 AND2_3465/X_u2-net6 VSS nmos W=0.31u L=0.04u
M1480 WX9905 AND2_3465/net6 VDD VDD pmos W=0.41u L=0.04u
M1481 AND2_3465/net6 RESET VDD VDD pmos W=0.41u L=0.04u
M1482 AND2_3465/net6 WX9842 VDD VDD pmos W=0.41u L=0.04u
M1483 WX9903 AND2_3464/net6 VSS VSS nmos W=0.31u L=0.04u
M1484 AND2_3464/X_u2-net6 RESET VSS VSS nmos W=0.31u L=0.04u
M1485 AND2_3464/net6 WX9840 AND2_3464/X_u2-net6 VSS nmos W=0.31u L=0.04u
M1486 WX9903 AND2_3464/net6 VDD VDD pmos W=0.41u L=0.04u
M1487 AND2_3464/net6 RESET VDD VDD pmos W=0.41u L=0.04u
M1488 AND2_3464/net6 WX9840 VDD VDD pmos W=0.41u L=0.04u
M1489 WX9901 AND2_3463/net6 VSS VSS nmos W=0.31u L=0.04u
M1490 AND2_3463/X_u2-net6 RESET VSS VSS nmos W=0.31u L=0.04u
M1491 AND2_3463/net6 WX9838 AND2_3463/X_u2-net6 VSS nmos W=0.31u L=0.04u
M1492 WX9901 AND2_3463/net6 VDD VDD pmos W=0.41u L=0.04u
M1493 AND2_3463/net6 RESET VDD VDD pmos W=0.41u L=0.04u
M1494 AND2_3463/net6 WX9838 VDD VDD pmos W=0.41u L=0.04u
M1495 WX9899 AND2_3462/net6 VSS VSS nmos W=0.31u L=0.04u
M1496 AND2_3462/X_u2-net6 RESET VSS VSS nmos W=0.31u L=0.04u
M1497 AND2_3462/net6 WX9836 AND2_3462/X_u2-net6 VSS nmos W=0.31u L=0.04u
M1498 WX9899 AND2_3462/net6 VDD VDD pmos W=0.41u L=0.04u
M1499 AND2_3462/net6 RESET VDD VDD pmos W=0.41u L=0.04u
M1500 AND2_3462/net6 WX9836 VDD VDD pmos W=0.41u L=0.04u
M1501 WX9897 AND2_3461/net6 VSS VSS nmos W=0.31u L=0.04u
M1502 AND2_3461/X_u2-net6 RESET VSS VSS nmos W=0.31u L=0.04u
M1503 AND2_3461/net6 WX9834 AND2_3461/X_u2-net6 VSS nmos W=0.31u L=0.04u
M1504 WX9897 AND2_3461/net6 VDD VDD pmos W=0.41u L=0.04u
M1505 AND2_3461/net6 RESET VDD VDD pmos W=0.41u L=0.04u
M1506 AND2_3461/net6 WX9834 VDD VDD pmos W=0.41u L=0.04u
M1507 WX9895 AND2_3460/net6 VSS VSS nmos W=0.31u L=0.04u
M1508 AND2_3460/X_u2-net6 RESET VSS VSS nmos W=0.31u L=0.04u
M1509 AND2_3460/net6 WX9832 AND2_3460/X_u2-net6 VSS nmos W=0.31u L=0.04u
M1510 WX9895 AND2_3460/net6 VDD VDD pmos W=0.41u L=0.04u
M1511 AND2_3460/net6 RESET VDD VDD pmos W=0.41u L=0.04u
M1512 AND2_3460/net6 WX9832 VDD VDD pmos W=0.41u L=0.04u
M1513 WX9893 AND2_3459/net6 VSS VSS nmos W=0.31u L=0.04u
M1514 AND2_3459/X_u2-net6 RESET VSS VSS nmos W=0.31u L=0.04u
M1515 AND2_3459/net6 WX9830 AND2_3459/X_u2-net6 VSS nmos W=0.31u L=0.04u
M1516 WX9893 AND2_3459/net6 VDD VDD pmos W=0.41u L=0.04u
M1517 AND2_3459/net6 RESET VDD VDD pmos W=0.41u L=0.04u
M1518 AND2_3459/net6 WX9830 VDD VDD pmos W=0.41u L=0.04u
M1519 WX9891 AND2_3458/net6 VSS VSS nmos W=0.31u L=0.04u
M1520 AND2_3458/X_u2-net6 RESET VSS VSS nmos W=0.31u L=0.04u
M1521 AND2_3458/net6 WX9828 AND2_3458/X_u2-net6 VSS nmos W=0.31u L=0.04u
M1522 WX9891 AND2_3458/net6 VDD VDD pmos W=0.41u L=0.04u
M1523 AND2_3458/net6 RESET VDD VDD pmos W=0.41u L=0.04u
M1524 AND2_3458/net6 WX9828 VDD VDD pmos W=0.41u L=0.04u
M1525 WX9889 AND2_3457/net6 VSS VSS nmos W=0.31u L=0.04u
M1526 AND2_3457/X_u2-net6 RESET VSS VSS nmos W=0.31u L=0.04u
M1527 AND2_3457/net6 WX9826 AND2_3457/X_u2-net6 VSS nmos W=0.31u L=0.04u
M1528 WX9889 AND2_3457/net6 VDD VDD pmos W=0.41u L=0.04u
M1529 AND2_3457/net6 RESET VDD VDD pmos W=0.41u L=0.04u
M1530 AND2_3457/net6 WX9826 VDD VDD pmos W=0.41u L=0.04u
M1531 WX9887 AND2_3456/net6 VSS VSS nmos W=0.31u L=0.04u
M1532 AND2_3456/X_u2-net6 RESET VSS VSS nmos W=0.31u L=0.04u
M1533 AND2_3456/net6 WX9824 AND2_3456/X_u2-net6 VSS nmos W=0.31u L=0.04u
M1534 WX9887 AND2_3456/net6 VDD VDD pmos W=0.41u L=0.04u
M1535 AND2_3456/net6 RESET VDD VDD pmos W=0.41u L=0.04u
M1536 AND2_3456/net6 WX9824 VDD VDD pmos W=0.41u L=0.04u
M1537 WX9885 AND2_3455/net6 VSS VSS nmos W=0.31u L=0.04u
M1538 AND2_3455/X_u2-net6 RESET VSS VSS nmos W=0.31u L=0.04u
M1539 AND2_3455/net6 WX9822 AND2_3455/X_u2-net6 VSS nmos W=0.31u L=0.04u
M1540 WX9885 AND2_3455/net6 VDD VDD pmos W=0.41u L=0.04u
M1541 AND2_3455/net6 RESET VDD VDD pmos W=0.41u L=0.04u
M1542 AND2_3455/net6 WX9822 VDD VDD pmos W=0.41u L=0.04u
M1543 WX9883 AND2_3454/net6 VSS VSS nmos W=0.31u L=0.04u
M1544 AND2_3454/X_u2-net6 RESET VSS VSS nmos W=0.31u L=0.04u
M1545 AND2_3454/net6 WX9820 AND2_3454/X_u2-net6 VSS nmos W=0.31u L=0.04u
M1546 WX9883 AND2_3454/net6 VDD VDD pmos W=0.41u L=0.04u
M1547 AND2_3454/net6 RESET VDD VDD pmos W=0.41u L=0.04u
M1548 AND2_3454/net6 WX9820 VDD VDD pmos W=0.41u L=0.04u
M1549 WX9881 AND2_3453/net6 VSS VSS nmos W=0.31u L=0.04u
M1550 AND2_3453/X_u2-net6 RESET VSS VSS nmos W=0.31u L=0.04u
M1551 AND2_3453/net6 WX9818 AND2_3453/X_u2-net6 VSS nmos W=0.31u L=0.04u
M1552 WX9881 AND2_3453/net6 VDD VDD pmos W=0.41u L=0.04u
M1553 AND2_3453/net6 RESET VDD VDD pmos W=0.41u L=0.04u
M1554 AND2_3453/net6 WX9818 VDD VDD pmos W=0.41u L=0.04u
M1555 WX9879 AND2_3452/net6 VSS VSS nmos W=0.31u L=0.04u
M1556 AND2_3452/X_u2-net6 RESET VSS VSS nmos W=0.31u L=0.04u
M1557 AND2_3452/net6 WX9816 AND2_3452/X_u2-net6 VSS nmos W=0.31u L=0.04u
M1558 WX9879 AND2_3452/net6 VDD VDD pmos W=0.41u L=0.04u
M1559 AND2_3452/net6 RESET VDD VDD pmos W=0.41u L=0.04u
M1560 AND2_3452/net6 WX9816 VDD VDD pmos W=0.41u L=0.04u
M1561 WX9877 AND2_3451/net6 VSS VSS nmos W=0.31u L=0.04u
M1562 AND2_3451/X_u2-net6 RESET VSS VSS nmos W=0.31u L=0.04u
M1563 AND2_3451/net6 WX9814 AND2_3451/X_u2-net6 VSS nmos W=0.31u L=0.04u
M1564 WX9877 AND2_3451/net6 VDD VDD pmos W=0.41u L=0.04u
M1565 AND2_3451/net6 RESET VDD VDD pmos W=0.41u L=0.04u
M1566 AND2_3451/net6 WX9814 VDD VDD pmos W=0.41u L=0.04u
M1567 WX9875 AND2_3450/net6 VSS VSS nmos W=0.31u L=0.04u
M1568 AND2_3450/X_u2-net6 RESET VSS VSS nmos W=0.31u L=0.04u
M1569 AND2_3450/net6 WX9812 AND2_3450/X_u2-net6 VSS nmos W=0.31u L=0.04u
M1570 WX9875 AND2_3450/net6 VDD VDD pmos W=0.41u L=0.04u
M1571 AND2_3450/net6 RESET VDD VDD pmos W=0.41u L=0.04u
M1572 AND2_3450/net6 WX9812 VDD VDD pmos W=0.41u L=0.04u
M1573 WX9873 AND2_3449/net6 VSS VSS nmos W=0.31u L=0.04u
M1574 AND2_3449/X_u2-net6 RESET VSS VSS nmos W=0.31u L=0.04u
M1575 AND2_3449/net6 WX9810 AND2_3449/X_u2-net6 VSS nmos W=0.31u L=0.04u
M1576 WX9873 AND2_3449/net6 VDD VDD pmos W=0.41u L=0.04u
M1577 AND2_3449/net6 RESET VDD VDD pmos W=0.41u L=0.04u
M1578 AND2_3449/net6 WX9810 VDD VDD pmos W=0.41u L=0.04u
M1579 WX9871 AND2_3448/net6 VSS VSS nmos W=0.31u L=0.04u
M1580 AND2_3448/X_u2-net6 RESET VSS VSS nmos W=0.31u L=0.04u
M1581 AND2_3448/net6 WX9808 AND2_3448/X_u2-net6 VSS nmos W=0.31u L=0.04u
M1582 WX9871 AND2_3448/net6 VDD VDD pmos W=0.41u L=0.04u
M1583 AND2_3448/net6 RESET VDD VDD pmos W=0.41u L=0.04u
M1584 AND2_3448/net6 WX9808 VDD VDD pmos W=0.41u L=0.04u
M1585 WX9869 AND2_3447/net6 VSS VSS nmos W=0.31u L=0.04u
M1586 AND2_3447/X_u2-net6 RESET VSS VSS nmos W=0.31u L=0.04u
M1587 AND2_3447/net6 WX9806 AND2_3447/X_u2-net6 VSS nmos W=0.31u L=0.04u
M1588 WX9869 AND2_3447/net6 VDD VDD pmos W=0.41u L=0.04u
M1589 AND2_3447/net6 RESET VDD VDD pmos W=0.41u L=0.04u
M1590 AND2_3447/net6 WX9806 VDD VDD pmos W=0.41u L=0.04u
M1591 WX9867 AND2_3446/net6 VSS VSS nmos W=0.31u L=0.04u
M1592 AND2_3446/X_u2-net6 RESET VSS VSS nmos W=0.31u L=0.04u
M1593 AND2_3446/net6 WX9804 AND2_3446/X_u2-net6 VSS nmos W=0.31u L=0.04u
M1594 WX9867 AND2_3446/net6 VDD VDD pmos W=0.41u L=0.04u
M1595 AND2_3446/net6 RESET VDD VDD pmos W=0.41u L=0.04u
M1596 AND2_3446/net6 WX9804 VDD VDD pmos W=0.41u L=0.04u
M1597 WX9865 AND2_3445/net6 VSS VSS nmos W=0.31u L=0.04u
M1598 AND2_3445/X_u2-net6 RESET VSS VSS nmos W=0.31u L=0.04u
M1599 AND2_3445/net6 WX9802 AND2_3445/X_u2-net6 VSS nmos W=0.31u L=0.04u
M1600 WX9865 AND2_3445/net6 VDD VDD pmos W=0.41u L=0.04u
M1601 AND2_3445/net6 RESET VDD VDD pmos W=0.41u L=0.04u
M1602 AND2_3445/net6 WX9802 VDD VDD pmos W=0.41u L=0.04u
M1603 WX9863 AND2_3444/net6 VSS VSS nmos W=0.31u L=0.04u
M1604 AND2_3444/X_u2-net6 RESET VSS VSS nmos W=0.31u L=0.04u
M1605 AND2_3444/net6 WX9800 AND2_3444/X_u2-net6 VSS nmos W=0.31u L=0.04u
M1606 WX9863 AND2_3444/net6 VDD VDD pmos W=0.41u L=0.04u
M1607 AND2_3444/net6 RESET VDD VDD pmos W=0.41u L=0.04u
M1608 AND2_3444/net6 WX9800 VDD VDD pmos W=0.41u L=0.04u
M1609 WX9861 AND2_3443/net6 VSS VSS nmos W=0.31u L=0.04u
M1610 AND2_3443/X_u2-net6 RESET VSS VSS nmos W=0.31u L=0.04u
M1611 AND2_3443/net6 WX9798 AND2_3443/X_u2-net6 VSS nmos W=0.31u L=0.04u
M1612 WX9861 AND2_3443/net6 VDD VDD pmos W=0.41u L=0.04u
M1613 AND2_3443/net6 RESET VDD VDD pmos W=0.41u L=0.04u
M1614 AND2_3443/net6 WX9798 VDD VDD pmos W=0.41u L=0.04u
M1615 WX9859 AND2_3442/net6 VSS VSS nmos W=0.31u L=0.04u
M1616 AND2_3442/X_u2-net6 RESET VSS VSS nmos W=0.31u L=0.04u
M1617 AND2_3442/net6 WX9796 AND2_3442/X_u2-net6 VSS nmos W=0.31u L=0.04u
M1618 WX9859 AND2_3442/net6 VDD VDD pmos W=0.41u L=0.04u
M1619 AND2_3442/net6 RESET VDD VDD pmos W=0.41u L=0.04u
M1620 AND2_3442/net6 WX9796 VDD VDD pmos W=0.41u L=0.04u
M1621 WX9857 AND2_3441/net6 VSS VSS nmos W=0.31u L=0.04u
M1622 AND2_3441/X_u2-net6 RESET VSS VSS nmos W=0.31u L=0.04u
M1623 AND2_3441/net6 WX9794 AND2_3441/X_u2-net6 VSS nmos W=0.31u L=0.04u
M1624 WX9857 AND2_3441/net6 VDD VDD pmos W=0.41u L=0.04u
M1625 AND2_3441/net6 RESET VDD VDD pmos W=0.41u L=0.04u
M1626 AND2_3441/net6 WX9794 VDD VDD pmos W=0.41u L=0.04u
M1627 WX9855 AND2_3440/net6 VSS VSS nmos W=0.31u L=0.04u
M1628 AND2_3440/X_u2-net6 RESET VSS VSS nmos W=0.31u L=0.04u
M1629 AND2_3440/net6 WX9792 AND2_3440/X_u2-net6 VSS nmos W=0.31u L=0.04u
M1630 WX9855 AND2_3440/net6 VDD VDD pmos W=0.41u L=0.04u
M1631 AND2_3440/net6 RESET VDD VDD pmos W=0.41u L=0.04u
M1632 AND2_3440/net6 WX9792 VDD VDD pmos W=0.41u L=0.04u
M1633 WX9853 AND2_3439/net6 VSS VSS nmos W=0.31u L=0.04u
M1634 AND2_3439/X_u2-net6 RESET VSS VSS nmos W=0.31u L=0.04u
M1635 AND2_3439/net6 WX9790 AND2_3439/X_u2-net6 VSS nmos W=0.31u L=0.04u
M1636 WX9853 AND2_3439/net6 VDD VDD pmos W=0.41u L=0.04u
M1637 AND2_3439/net6 RESET VDD VDD pmos W=0.41u L=0.04u
M1638 AND2_3439/net6 WX9790 VDD VDD pmos W=0.41u L=0.04u
M1639 WX9851 AND2_3438/net6 VSS VSS nmos W=0.31u L=0.04u
M1640 AND2_3438/X_u2-net6 RESET VSS VSS nmos W=0.31u L=0.04u
M1641 AND2_3438/net6 WX9788 AND2_3438/X_u2-net6 VSS nmos W=0.31u L=0.04u
M1642 WX9851 AND2_3438/net6 VDD VDD pmos W=0.41u L=0.04u
M1643 AND2_3438/net6 RESET VDD VDD pmos W=0.41u L=0.04u
M1644 AND2_3438/net6 WX9788 VDD VDD pmos W=0.41u L=0.04u
M1645 WX9849 AND2_3437/net6 VSS VSS nmos W=0.31u L=0.04u
M1646 AND2_3437/X_u2-net6 RESET VSS VSS nmos W=0.31u L=0.04u
M1647 AND2_3437/net6 WX9786 AND2_3437/X_u2-net6 VSS nmos W=0.31u L=0.04u
M1648 WX9849 AND2_3437/net6 VDD VDD pmos W=0.41u L=0.04u
M1649 AND2_3437/net6 RESET VDD VDD pmos W=0.41u L=0.04u
M1650 AND2_3437/net6 WX9786 VDD VDD pmos W=0.41u L=0.04u
M1651 WX9847 AND2_3436/net6 VSS VSS nmos W=0.31u L=0.04u
M1652 AND2_3436/X_u2-net6 RESET VSS VSS nmos W=0.31u L=0.04u
M1653 AND2_3436/net6 WX9784 AND2_3436/X_u2-net6 VSS nmos W=0.31u L=0.04u
M1654 WX9847 AND2_3436/net6 VDD VDD pmos W=0.41u L=0.04u
M1655 AND2_3436/net6 RESET VDD VDD pmos W=0.41u L=0.04u
M1656 AND2_3436/net6 WX9784 VDD VDD pmos W=0.41u L=0.04u
M1657 WX9845 AND2_3435/net6 VSS VSS nmos W=0.31u L=0.04u
M1658 AND2_3435/X_u2-net6 RESET VSS VSS nmos W=0.31u L=0.04u
M1659 AND2_3435/net6 WX9782 AND2_3435/X_u2-net6 VSS nmos W=0.31u L=0.04u
M1660 WX9845 AND2_3435/net6 VDD VDD pmos W=0.41u L=0.04u
M1661 AND2_3435/net6 RESET VDD VDD pmos W=0.41u L=0.04u
M1662 AND2_3435/net6 WX9782 VDD VDD pmos W=0.41u L=0.04u
M1663 WX9843 AND2_3434/net6 VSS VSS nmos W=0.31u L=0.04u
M1664 AND2_3434/X_u2-net6 RESET VSS VSS nmos W=0.31u L=0.04u
M1665 AND2_3434/net6 WX9780 AND2_3434/X_u2-net6 VSS nmos W=0.31u L=0.04u
M1666 WX9843 AND2_3434/net6 VDD VDD pmos W=0.41u L=0.04u
M1667 AND2_3434/net6 RESET VDD VDD pmos W=0.41u L=0.04u
M1668 AND2_3434/net6 WX9780 VDD VDD pmos W=0.41u L=0.04u
M1669 WX9841 AND2_3433/net6 VSS VSS nmos W=0.31u L=0.04u
M1670 AND2_3433/X_u2-net6 RESET VSS VSS nmos W=0.31u L=0.04u
M1671 AND2_3433/net6 WX9778 AND2_3433/X_u2-net6 VSS nmos W=0.31u L=0.04u
M1672 WX9841 AND2_3433/net6 VDD VDD pmos W=0.41u L=0.04u
M1673 AND2_3433/net6 RESET VDD VDD pmos W=0.41u L=0.04u
M1674 AND2_3433/net6 WX9778 VDD VDD pmos W=0.41u L=0.04u
M1675 WX9839 AND2_3432/net6 VSS VSS nmos W=0.31u L=0.04u
M1676 AND2_3432/X_u2-net6 RESET VSS VSS nmos W=0.31u L=0.04u
M1677 AND2_3432/net6 WX9776 AND2_3432/X_u2-net6 VSS nmos W=0.31u L=0.04u
M1678 WX9839 AND2_3432/net6 VDD VDD pmos W=0.41u L=0.04u
M1679 AND2_3432/net6 RESET VDD VDD pmos W=0.41u L=0.04u
M1680 AND2_3432/net6 WX9776 VDD VDD pmos W=0.41u L=0.04u
M1681 WX9837 AND2_3431/net6 VSS VSS nmos W=0.31u L=0.04u
M1682 AND2_3431/X_u2-net6 RESET VSS VSS nmos W=0.31u L=0.04u
M1683 AND2_3431/net6 WX9774 AND2_3431/X_u2-net6 VSS nmos W=0.31u L=0.04u
M1684 WX9837 AND2_3431/net6 VDD VDD pmos W=0.41u L=0.04u
M1685 AND2_3431/net6 RESET VDD VDD pmos W=0.41u L=0.04u
M1686 AND2_3431/net6 WX9774 VDD VDD pmos W=0.41u L=0.04u
M1687 WX9835 AND2_3430/net6 VSS VSS nmos W=0.31u L=0.04u
M1688 AND2_3430/X_u2-net6 RESET VSS VSS nmos W=0.31u L=0.04u
M1689 AND2_3430/net6 WX9772 AND2_3430/X_u2-net6 VSS nmos W=0.31u L=0.04u
M1690 WX9835 AND2_3430/net6 VDD VDD pmos W=0.41u L=0.04u
M1691 AND2_3430/net6 RESET VDD VDD pmos W=0.41u L=0.04u
M1692 AND2_3430/net6 WX9772 VDD VDD pmos W=0.41u L=0.04u
M1693 WX9833 AND2_3429/net6 VSS VSS nmos W=0.31u L=0.04u
M1694 AND2_3429/X_u2-net6 RESET VSS VSS nmos W=0.31u L=0.04u
M1695 AND2_3429/net6 WX9770 AND2_3429/X_u2-net6 VSS nmos W=0.31u L=0.04u
M1696 WX9833 AND2_3429/net6 VDD VDD pmos W=0.41u L=0.04u
M1697 AND2_3429/net6 RESET VDD VDD pmos W=0.41u L=0.04u
M1698 AND2_3429/net6 WX9770 VDD VDD pmos W=0.41u L=0.04u
M1699 WX9831 AND2_3428/net6 VSS VSS nmos W=0.31u L=0.04u
M1700 AND2_3428/X_u2-net6 RESET VSS VSS nmos W=0.31u L=0.04u
M1701 AND2_3428/net6 WX9768 AND2_3428/X_u2-net6 VSS nmos W=0.31u L=0.04u
M1702 WX9831 AND2_3428/net6 VDD VDD pmos W=0.41u L=0.04u
M1703 AND2_3428/net6 RESET VDD VDD pmos W=0.41u L=0.04u
M1704 AND2_3428/net6 WX9768 VDD VDD pmos W=0.41u L=0.04u
M1705 WX9829 AND2_3427/net6 VSS VSS nmos W=0.31u L=0.04u
M1706 AND2_3427/X_u2-net6 RESET VSS VSS nmos W=0.31u L=0.04u
M1707 AND2_3427/net6 WX9766 AND2_3427/X_u2-net6 VSS nmos W=0.31u L=0.04u
M1708 WX9829 AND2_3427/net6 VDD VDD pmos W=0.41u L=0.04u
M1709 AND2_3427/net6 RESET VDD VDD pmos W=0.41u L=0.04u
M1710 AND2_3427/net6 WX9766 VDD VDD pmos W=0.41u L=0.04u
M1711 WX9827 AND2_3426/net6 VSS VSS nmos W=0.31u L=0.04u
M1712 AND2_3426/X_u2-net6 RESET VSS VSS nmos W=0.31u L=0.04u
M1713 AND2_3426/net6 WX9764 AND2_3426/X_u2-net6 VSS nmos W=0.31u L=0.04u
M1714 WX9827 AND2_3426/net6 VDD VDD pmos W=0.41u L=0.04u
M1715 AND2_3426/net6 RESET VDD VDD pmos W=0.41u L=0.04u
M1716 AND2_3426/net6 WX9764 VDD VDD pmos W=0.41u L=0.04u
M1717 WX9825 AND2_3425/net6 VSS VSS nmos W=0.31u L=0.04u
M1718 AND2_3425/X_u2-net6 RESET VSS VSS nmos W=0.31u L=0.04u
M1719 AND2_3425/net6 WX9762 AND2_3425/X_u2-net6 VSS nmos W=0.31u L=0.04u
M1720 WX9825 AND2_3425/net6 VDD VDD pmos W=0.41u L=0.04u
M1721 AND2_3425/net6 RESET VDD VDD pmos W=0.41u L=0.04u
M1722 AND2_3425/net6 WX9762 VDD VDD pmos W=0.41u L=0.04u
M1723 WX9823 AND2_3424/net6 VSS VSS nmos W=0.31u L=0.04u
M1724 AND2_3424/X_u2-net6 RESET VSS VSS nmos W=0.31u L=0.04u
M1725 AND2_3424/net6 WX9760 AND2_3424/X_u2-net6 VSS nmos W=0.31u L=0.04u
M1726 WX9823 AND2_3424/net6 VDD VDD pmos W=0.41u L=0.04u
M1727 AND2_3424/net6 RESET VDD VDD pmos W=0.41u L=0.04u
M1728 AND2_3424/net6 WX9760 VDD VDD pmos W=0.41u L=0.04u
M1729 WX9821 AND2_3423/net6 VSS VSS nmos W=0.31u L=0.04u
M1730 AND2_3423/X_u2-net6 RESET VSS VSS nmos W=0.31u L=0.04u
M1731 AND2_3423/net6 WX9758 AND2_3423/X_u2-net6 VSS nmos W=0.31u L=0.04u
M1732 WX9821 AND2_3423/net6 VDD VDD pmos W=0.41u L=0.04u
M1733 AND2_3423/net6 RESET VDD VDD pmos W=0.41u L=0.04u
M1734 AND2_3423/net6 WX9758 VDD VDD pmos W=0.41u L=0.04u
M1735 WX9819 AND2_3422/net6 VSS VSS nmos W=0.31u L=0.04u
M1736 AND2_3422/X_u2-net6 RESET VSS VSS nmos W=0.31u L=0.04u
M1737 AND2_3422/net6 WX9756 AND2_3422/X_u2-net6 VSS nmos W=0.31u L=0.04u
M1738 WX9819 AND2_3422/net6 VDD VDD pmos W=0.41u L=0.04u
M1739 AND2_3422/net6 RESET VDD VDD pmos W=0.41u L=0.04u
M1740 AND2_3422/net6 WX9756 VDD VDD pmos W=0.41u L=0.04u
M1741 WX9817 AND2_3421/net6 VSS VSS nmos W=0.31u L=0.04u
M1742 AND2_3421/X_u2-net6 RESET VSS VSS nmos W=0.31u L=0.04u
M1743 AND2_3421/net6 WX9754 AND2_3421/X_u2-net6 VSS nmos W=0.31u L=0.04u
M1744 WX9817 AND2_3421/net6 VDD VDD pmos W=0.41u L=0.04u
M1745 AND2_3421/net6 RESET VDD VDD pmos W=0.41u L=0.04u
M1746 AND2_3421/net6 WX9754 VDD VDD pmos W=0.41u L=0.04u
M1747 WX9815 AND2_3420/net6 VSS VSS nmos W=0.31u L=0.04u
M1748 AND2_3420/X_u2-net6 RESET VSS VSS nmos W=0.31u L=0.04u
M1749 AND2_3420/net6 WX9752 AND2_3420/X_u2-net6 VSS nmos W=0.31u L=0.04u
M1750 WX9815 AND2_3420/net6 VDD VDD pmos W=0.41u L=0.04u
M1751 AND2_3420/net6 RESET VDD VDD pmos W=0.41u L=0.04u
M1752 AND2_3420/net6 WX9752 VDD VDD pmos W=0.41u L=0.04u
M1753 WX9813 AND2_3419/net6 VSS VSS nmos W=0.31u L=0.04u
M1754 AND2_3419/X_u2-net6 RESET VSS VSS nmos W=0.31u L=0.04u
M1755 AND2_3419/net6 WX9750 AND2_3419/X_u2-net6 VSS nmos W=0.31u L=0.04u
M1756 WX9813 AND2_3419/net6 VDD VDD pmos W=0.41u L=0.04u
M1757 AND2_3419/net6 RESET VDD VDD pmos W=0.41u L=0.04u
M1758 AND2_3419/net6 WX9750 VDD VDD pmos W=0.41u L=0.04u
M1759 WX9811 AND2_3418/net6 VSS VSS nmos W=0.31u L=0.04u
M1760 AND2_3418/X_u2-net6 RESET VSS VSS nmos W=0.31u L=0.04u
M1761 AND2_3418/net6 WX9748 AND2_3418/X_u2-net6 VSS nmos W=0.31u L=0.04u
M1762 WX9811 AND2_3418/net6 VDD VDD pmos W=0.41u L=0.04u
M1763 AND2_3418/net6 RESET VDD VDD pmos W=0.41u L=0.04u
M1764 AND2_3418/net6 WX9748 VDD VDD pmos W=0.41u L=0.04u
M1765 WX9809 AND2_3417/net6 VSS VSS nmos W=0.31u L=0.04u
M1766 AND2_3417/X_u2-net6 RESET VSS VSS nmos W=0.31u L=0.04u
M1767 AND2_3417/net6 WX9746 AND2_3417/X_u2-net6 VSS nmos W=0.31u L=0.04u
M1768 WX9809 AND2_3417/net6 VDD VDD pmos W=0.41u L=0.04u
M1769 AND2_3417/net6 RESET VDD VDD pmos W=0.41u L=0.04u
M1770 AND2_3417/net6 WX9746 VDD VDD pmos W=0.41u L=0.04u
M1771 WX9807 AND2_3416/net6 VSS VSS nmos W=0.31u L=0.04u
M1772 AND2_3416/X_u2-net6 RESET VSS VSS nmos W=0.31u L=0.04u
M1773 AND2_3416/net6 WX9744 AND2_3416/X_u2-net6 VSS nmos W=0.31u L=0.04u
M1774 WX9807 AND2_3416/net6 VDD VDD pmos W=0.41u L=0.04u
M1775 AND2_3416/net6 RESET VDD VDD pmos W=0.41u L=0.04u
M1776 AND2_3416/net6 WX9744 VDD VDD pmos W=0.41u L=0.04u
M1777 WX9805 AND2_3415/net6 VSS VSS nmos W=0.31u L=0.04u
M1778 AND2_3415/X_u2-net6 RESET VSS VSS nmos W=0.31u L=0.04u
M1779 AND2_3415/net6 WX9742 AND2_3415/X_u2-net6 VSS nmos W=0.31u L=0.04u
M1780 WX9805 AND2_3415/net6 VDD VDD pmos W=0.41u L=0.04u
M1781 AND2_3415/net6 RESET VDD VDD pmos W=0.41u L=0.04u
M1782 AND2_3415/net6 WX9742 VDD VDD pmos W=0.41u L=0.04u
M1783 WX9803 AND2_3414/net6 VSS VSS nmos W=0.31u L=0.04u
M1784 AND2_3414/X_u2-net6 RESET VSS VSS nmos W=0.31u L=0.04u
M1785 AND2_3414/net6 WX9740 AND2_3414/X_u2-net6 VSS nmos W=0.31u L=0.04u
M1786 WX9803 AND2_3414/net6 VDD VDD pmos W=0.41u L=0.04u
M1787 AND2_3414/net6 RESET VDD VDD pmos W=0.41u L=0.04u
M1788 AND2_3414/net6 WX9740 VDD VDD pmos W=0.41u L=0.04u
M1789 WX9801 AND2_3413/net6 VSS VSS nmos W=0.31u L=0.04u
M1790 AND2_3413/X_u2-net6 RESET VSS VSS nmos W=0.31u L=0.04u
M1791 AND2_3413/net6 WX9738 AND2_3413/X_u2-net6 VSS nmos W=0.31u L=0.04u
M1792 WX9801 AND2_3413/net6 VDD VDD pmos W=0.41u L=0.04u
M1793 AND2_3413/net6 RESET VDD VDD pmos W=0.41u L=0.04u
M1794 AND2_3413/net6 WX9738 VDD VDD pmos W=0.41u L=0.04u
M1795 WX9799 AND2_3412/net6 VSS VSS nmos W=0.31u L=0.04u
M1796 AND2_3412/X_u2-net6 RESET VSS VSS nmos W=0.31u L=0.04u
M1797 AND2_3412/net6 WX9736 AND2_3412/X_u2-net6 VSS nmos W=0.31u L=0.04u
M1798 WX9799 AND2_3412/net6 VDD VDD pmos W=0.41u L=0.04u
M1799 AND2_3412/net6 RESET VDD VDD pmos W=0.41u L=0.04u
M1800 AND2_3412/net6 WX9736 VDD VDD pmos W=0.41u L=0.04u
M1801 WX9797 AND2_3411/net6 VSS VSS nmos W=0.31u L=0.04u
M1802 AND2_3411/X_u2-net6 RESET VSS VSS nmos W=0.31u L=0.04u
M1803 AND2_3411/net6 WX9734 AND2_3411/X_u2-net6 VSS nmos W=0.31u L=0.04u
M1804 WX9797 AND2_3411/net6 VDD VDD pmos W=0.41u L=0.04u
M1805 AND2_3411/net6 RESET VDD VDD pmos W=0.41u L=0.04u
M1806 AND2_3411/net6 WX9734 VDD VDD pmos W=0.41u L=0.04u
M1807 WX9795 AND2_3410/net6 VSS VSS nmos W=0.31u L=0.04u
M1808 AND2_3410/X_u2-net6 RESET VSS VSS nmos W=0.31u L=0.04u
M1809 AND2_3410/net6 WX9732 AND2_3410/X_u2-net6 VSS nmos W=0.31u L=0.04u
M1810 WX9795 AND2_3410/net6 VDD VDD pmos W=0.41u L=0.04u
M1811 AND2_3410/net6 RESET VDD VDD pmos W=0.41u L=0.04u
M1812 AND2_3410/net6 WX9732 VDD VDD pmos W=0.41u L=0.04u
M1813 WX9793 AND2_3409/net6 VSS VSS nmos W=0.31u L=0.04u
M1814 AND2_3409/X_u2-net6 RESET VSS VSS nmos W=0.31u L=0.04u
M1815 AND2_3409/net6 WX9730 AND2_3409/X_u2-net6 VSS nmos W=0.31u L=0.04u
M1816 WX9793 AND2_3409/net6 VDD VDD pmos W=0.41u L=0.04u
M1817 AND2_3409/net6 RESET VDD VDD pmos W=0.41u L=0.04u
M1818 AND2_3409/net6 WX9730 VDD VDD pmos W=0.41u L=0.04u
M1819 WX9791 AND2_3408/net6 VSS VSS nmos W=0.31u L=0.04u
M1820 AND2_3408/X_u2-net6 RESET VSS VSS nmos W=0.31u L=0.04u
M1821 AND2_3408/net6 WX9728 AND2_3408/X_u2-net6 VSS nmos W=0.31u L=0.04u
M1822 WX9791 AND2_3408/net6 VDD VDD pmos W=0.41u L=0.04u
M1823 AND2_3408/net6 RESET VDD VDD pmos W=0.41u L=0.04u
M1824 AND2_3408/net6 WX9728 VDD VDD pmos W=0.41u L=0.04u
M1825 WX9789 AND2_3407/net6 VSS VSS nmos W=0.31u L=0.04u
M1826 AND2_3407/X_u2-net6 RESET VSS VSS nmos W=0.31u L=0.04u
M1827 AND2_3407/net6 WX9726 AND2_3407/X_u2-net6 VSS nmos W=0.31u L=0.04u
M1828 WX9789 AND2_3407/net6 VDD VDD pmos W=0.41u L=0.04u
M1829 AND2_3407/net6 RESET VDD VDD pmos W=0.41u L=0.04u
M1830 AND2_3407/net6 WX9726 VDD VDD pmos W=0.41u L=0.04u
M1831 WX9787 AND2_3406/net6 VSS VSS nmos W=0.31u L=0.04u
M1832 AND2_3406/X_u2-net6 RESET VSS VSS nmos W=0.31u L=0.04u
M1833 AND2_3406/net6 WX9724 AND2_3406/X_u2-net6 VSS nmos W=0.31u L=0.04u
M1834 WX9787 AND2_3406/net6 VDD VDD pmos W=0.41u L=0.04u
M1835 AND2_3406/net6 RESET VDD VDD pmos W=0.41u L=0.04u
M1836 AND2_3406/net6 WX9724 VDD VDD pmos W=0.41u L=0.04u
M1837 WX9785 AND2_3405/net6 VSS VSS nmos W=0.31u L=0.04u
M1838 AND2_3405/X_u2-net6 RESET VSS VSS nmos W=0.31u L=0.04u
M1839 AND2_3405/net6 WX9722 AND2_3405/X_u2-net6 VSS nmos W=0.31u L=0.04u
M1840 WX9785 AND2_3405/net6 VDD VDD pmos W=0.41u L=0.04u
M1841 AND2_3405/net6 RESET VDD VDD pmos W=0.41u L=0.04u
M1842 AND2_3405/net6 WX9722 VDD VDD pmos W=0.41u L=0.04u
M1843 WX9783 AND2_3404/net6 VSS VSS nmos W=0.31u L=0.04u
M1844 AND2_3404/X_u2-net6 RESET VSS VSS nmos W=0.31u L=0.04u
M1845 AND2_3404/net6 WX9720 AND2_3404/X_u2-net6 VSS nmos W=0.31u L=0.04u
M1846 WX9783 AND2_3404/net6 VDD VDD pmos W=0.41u L=0.04u
M1847 AND2_3404/net6 RESET VDD VDD pmos W=0.41u L=0.04u
M1848 AND2_3404/net6 WX9720 VDD VDD pmos W=0.41u L=0.04u
M1849 WX9781 AND2_3403/net6 VSS VSS nmos W=0.31u L=0.04u
M1850 AND2_3403/X_u2-net6 RESET VSS VSS nmos W=0.31u L=0.04u
M1851 AND2_3403/net6 WX9718 AND2_3403/X_u2-net6 VSS nmos W=0.31u L=0.04u
M1852 WX9781 AND2_3403/net6 VDD VDD pmos W=0.41u L=0.04u
M1853 AND2_3403/net6 RESET VDD VDD pmos W=0.41u L=0.04u
M1854 AND2_3403/net6 WX9718 VDD VDD pmos W=0.41u L=0.04u
M1855 WX9779 AND2_3402/net6 VSS VSS nmos W=0.31u L=0.04u
M1856 AND2_3402/X_u2-net6 RESET VSS VSS nmos W=0.31u L=0.04u
M1857 AND2_3402/net6 WX9716 AND2_3402/X_u2-net6 VSS nmos W=0.31u L=0.04u
M1858 WX9779 AND2_3402/net6 VDD VDD pmos W=0.41u L=0.04u
M1859 AND2_3402/net6 RESET VDD VDD pmos W=0.41u L=0.04u
M1860 AND2_3402/net6 WX9716 VDD VDD pmos W=0.41u L=0.04u
M1861 WX9777 AND2_3401/net6 VSS VSS nmos W=0.31u L=0.04u
M1862 AND2_3401/X_u2-net6 RESET VSS VSS nmos W=0.31u L=0.04u
M1863 AND2_3401/net6 WX9714 AND2_3401/X_u2-net6 VSS nmos W=0.31u L=0.04u
M1864 WX9777 AND2_3401/net6 VDD VDD pmos W=0.41u L=0.04u
M1865 AND2_3401/net6 RESET VDD VDD pmos W=0.41u L=0.04u
M1866 AND2_3401/net6 WX9714 VDD VDD pmos W=0.41u L=0.04u
M1867 WX9775 AND2_3400/net6 VSS VSS nmos W=0.31u L=0.04u
M1868 AND2_3400/X_u2-net6 RESET VSS VSS nmos W=0.31u L=0.04u
M1869 AND2_3400/net6 WX9712 AND2_3400/X_u2-net6 VSS nmos W=0.31u L=0.04u
M1870 WX9775 AND2_3400/net6 VDD VDD pmos W=0.41u L=0.04u
M1871 AND2_3400/net6 RESET VDD VDD pmos W=0.41u L=0.04u
M1872 AND2_3400/net6 WX9712 VDD VDD pmos W=0.41u L=0.04u
M1873 WX9773 AND2_3399/net6 VSS VSS nmos W=0.31u L=0.04u
M1874 AND2_3399/X_u2-net6 RESET VSS VSS nmos W=0.31u L=0.04u
M1875 AND2_3399/net6 WX9710 AND2_3399/X_u2-net6 VSS nmos W=0.31u L=0.04u
M1876 WX9773 AND2_3399/net6 VDD VDD pmos W=0.41u L=0.04u
M1877 AND2_3399/net6 RESET VDD VDD pmos W=0.41u L=0.04u
M1878 AND2_3399/net6 WX9710 VDD VDD pmos W=0.41u L=0.04u
M1879 WX9771 AND2_3398/net6 VSS VSS nmos W=0.31u L=0.04u
M1880 AND2_3398/X_u2-net6 RESET VSS VSS nmos W=0.31u L=0.04u
M1881 AND2_3398/net6 WX9708 AND2_3398/X_u2-net6 VSS nmos W=0.31u L=0.04u
M1882 WX9771 AND2_3398/net6 VDD VDD pmos W=0.41u L=0.04u
M1883 AND2_3398/net6 RESET VDD VDD pmos W=0.41u L=0.04u
M1884 AND2_3398/net6 WX9708 VDD VDD pmos W=0.41u L=0.04u
M1885 WX9769 AND2_3397/net6 VSS VSS nmos W=0.31u L=0.04u
M1886 AND2_3397/X_u2-net6 RESET VSS VSS nmos W=0.31u L=0.04u
M1887 AND2_3397/net6 WX9706 AND2_3397/X_u2-net6 VSS nmos W=0.31u L=0.04u
M1888 WX9769 AND2_3397/net6 VDD VDD pmos W=0.41u L=0.04u
M1889 AND2_3397/net6 RESET VDD VDD pmos W=0.41u L=0.04u
M1890 AND2_3397/net6 WX9706 VDD VDD pmos W=0.41u L=0.04u
M1891 WX9767 AND2_3396/net6 VSS VSS nmos W=0.31u L=0.04u
M1892 AND2_3396/X_u2-net6 RESET VSS VSS nmos W=0.31u L=0.04u
M1893 AND2_3396/net6 WX9704 AND2_3396/X_u2-net6 VSS nmos W=0.31u L=0.04u
M1894 WX9767 AND2_3396/net6 VDD VDD pmos W=0.41u L=0.04u
M1895 AND2_3396/net6 RESET VDD VDD pmos W=0.41u L=0.04u
M1896 AND2_3396/net6 WX9704 VDD VDD pmos W=0.41u L=0.04u
M1897 WX9765 AND2_3395/net6 VSS VSS nmos W=0.31u L=0.04u
M1898 AND2_3395/X_u2-net6 RESET VSS VSS nmos W=0.31u L=0.04u
M1899 AND2_3395/net6 WX9702 AND2_3395/X_u2-net6 VSS nmos W=0.31u L=0.04u
M1900 WX9765 AND2_3395/net6 VDD VDD pmos W=0.41u L=0.04u
M1901 AND2_3395/net6 RESET VDD VDD pmos W=0.41u L=0.04u
M1902 AND2_3395/net6 WX9702 VDD VDD pmos W=0.41u L=0.04u
M1903 WX9763 AND2_3394/net6 VSS VSS nmos W=0.31u L=0.04u
M1904 AND2_3394/X_u2-net6 RESET VSS VSS nmos W=0.31u L=0.04u
M1905 AND2_3394/net6 WX9700 AND2_3394/X_u2-net6 VSS nmos W=0.31u L=0.04u
M1906 WX9763 AND2_3394/net6 VDD VDD pmos W=0.41u L=0.04u
M1907 AND2_3394/net6 RESET VDD VDD pmos W=0.41u L=0.04u
M1908 AND2_3394/net6 WX9700 VDD VDD pmos W=0.41u L=0.04u
M1909 WX9761 AND2_3393/net6 VSS VSS nmos W=0.31u L=0.04u
M1910 AND2_3393/X_u2-net6 RESET VSS VSS nmos W=0.31u L=0.04u
M1911 AND2_3393/net6 WX9698 AND2_3393/X_u2-net6 VSS nmos W=0.31u L=0.04u
M1912 WX9761 AND2_3393/net6 VDD VDD pmos W=0.41u L=0.04u
M1913 AND2_3393/net6 RESET VDD VDD pmos W=0.41u L=0.04u
M1914 AND2_3393/net6 WX9698 VDD VDD pmos W=0.41u L=0.04u
M1915 WX9759 AND2_3392/net6 VSS VSS nmos W=0.31u L=0.04u
M1916 AND2_3392/X_u2-net6 RESET VSS VSS nmos W=0.31u L=0.04u
M1917 AND2_3392/net6 WX9696 AND2_3392/X_u2-net6 VSS nmos W=0.31u L=0.04u
M1918 WX9759 AND2_3392/net6 VDD VDD pmos W=0.41u L=0.04u
M1919 AND2_3392/net6 RESET VDD VDD pmos W=0.41u L=0.04u
M1920 AND2_3392/net6 WX9696 VDD VDD pmos W=0.41u L=0.04u
M1921 WX9757 AND2_3391/net6 VSS VSS nmos W=0.31u L=0.04u
M1922 AND2_3391/X_u2-net6 RESET VSS VSS nmos W=0.31u L=0.04u
M1923 AND2_3391/net6 WX9523 AND2_3391/X_u2-net6 VSS nmos W=0.31u L=0.04u
M1924 WX9757 AND2_3391/net6 VDD VDD pmos W=0.41u L=0.04u
M1925 AND2_3391/net6 RESET VDD VDD pmos W=0.41u L=0.04u
M1926 AND2_3391/net6 WX9523 VDD VDD pmos W=0.41u L=0.04u
M1927 WX9755 AND2_3390/net6 VSS VSS nmos W=0.31u L=0.04u
M1928 AND2_3390/X_u2-net6 RESET VSS VSS nmos W=0.31u L=0.04u
M1929 AND2_3390/net6 WX9509 AND2_3390/X_u2-net6 VSS nmos W=0.31u L=0.04u
M1930 WX9755 AND2_3390/net6 VDD VDD pmos W=0.41u L=0.04u
M1931 AND2_3390/net6 RESET VDD VDD pmos W=0.41u L=0.04u
M1932 AND2_3390/net6 WX9509 VDD VDD pmos W=0.41u L=0.04u
M1933 WX9753 AND2_3389/net6 VSS VSS nmos W=0.31u L=0.04u
M1934 AND2_3389/X_u2-net6 RESET VSS VSS nmos W=0.31u L=0.04u
M1935 AND2_3389/net6 WX9495 AND2_3389/X_u2-net6 VSS nmos W=0.31u L=0.04u
M1936 WX9753 AND2_3389/net6 VDD VDD pmos W=0.41u L=0.04u
M1937 AND2_3389/net6 RESET VDD VDD pmos W=0.41u L=0.04u
M1938 AND2_3389/net6 WX9495 VDD VDD pmos W=0.41u L=0.04u
M1939 WX9751 AND2_3388/net6 VSS VSS nmos W=0.31u L=0.04u
M1940 AND2_3388/X_u2-net6 RESET VSS VSS nmos W=0.31u L=0.04u
M1941 AND2_3388/net6 WX9481 AND2_3388/X_u2-net6 VSS nmos W=0.31u L=0.04u
M1942 WX9751 AND2_3388/net6 VDD VDD pmos W=0.41u L=0.04u
M1943 AND2_3388/net6 RESET VDD VDD pmos W=0.41u L=0.04u
M1944 AND2_3388/net6 WX9481 VDD VDD pmos W=0.41u L=0.04u
M1945 WX9749 AND2_3387/net6 VSS VSS nmos W=0.31u L=0.04u
M1946 AND2_3387/X_u2-net6 RESET VSS VSS nmos W=0.31u L=0.04u
M1947 AND2_3387/net6 WX9467 AND2_3387/X_u2-net6 VSS nmos W=0.31u L=0.04u
M1948 WX9749 AND2_3387/net6 VDD VDD pmos W=0.41u L=0.04u
M1949 AND2_3387/net6 RESET VDD VDD pmos W=0.41u L=0.04u
M1950 AND2_3387/net6 WX9467 VDD VDD pmos W=0.41u L=0.04u
M1951 WX9747 AND2_3386/net6 VSS VSS nmos W=0.31u L=0.04u
M1952 AND2_3386/X_u2-net6 RESET VSS VSS nmos W=0.31u L=0.04u
M1953 AND2_3386/net6 WX9453 AND2_3386/X_u2-net6 VSS nmos W=0.31u L=0.04u
M1954 WX9747 AND2_3386/net6 VDD VDD pmos W=0.41u L=0.04u
M1955 AND2_3386/net6 RESET VDD VDD pmos W=0.41u L=0.04u
M1956 AND2_3386/net6 WX9453 VDD VDD pmos W=0.41u L=0.04u
M1957 WX9745 AND2_3385/net6 VSS VSS nmos W=0.31u L=0.04u
M1958 AND2_3385/X_u2-net6 RESET VSS VSS nmos W=0.31u L=0.04u
M1959 AND2_3385/net6 WX9439 AND2_3385/X_u2-net6 VSS nmos W=0.31u L=0.04u
M1960 WX9745 AND2_3385/net6 VDD VDD pmos W=0.41u L=0.04u
M1961 AND2_3385/net6 RESET VDD VDD pmos W=0.41u L=0.04u
M1962 AND2_3385/net6 WX9439 VDD VDD pmos W=0.41u L=0.04u
M1963 WX9743 AND2_3384/net6 VSS VSS nmos W=0.31u L=0.04u
M1964 AND2_3384/X_u2-net6 RESET VSS VSS nmos W=0.31u L=0.04u
M1965 AND2_3384/net6 WX9425 AND2_3384/X_u2-net6 VSS nmos W=0.31u L=0.04u
M1966 WX9743 AND2_3384/net6 VDD VDD pmos W=0.41u L=0.04u
M1967 AND2_3384/net6 RESET VDD VDD pmos W=0.41u L=0.04u
M1968 AND2_3384/net6 WX9425 VDD VDD pmos W=0.41u L=0.04u
M1969 WX9741 AND2_3383/net6 VSS VSS nmos W=0.31u L=0.04u
M1970 AND2_3383/X_u2-net6 RESET VSS VSS nmos W=0.31u L=0.04u
M1971 AND2_3383/net6 WX9411 AND2_3383/X_u2-net6 VSS nmos W=0.31u L=0.04u
M1972 WX9741 AND2_3383/net6 VDD VDD pmos W=0.41u L=0.04u
M1973 AND2_3383/net6 RESET VDD VDD pmos W=0.41u L=0.04u
M1974 AND2_3383/net6 WX9411 VDD VDD pmos W=0.41u L=0.04u
M1975 WX9739 AND2_3382/net6 VSS VSS nmos W=0.31u L=0.04u
M1976 AND2_3382/X_u2-net6 RESET VSS VSS nmos W=0.31u L=0.04u
M1977 AND2_3382/net6 WX9397 AND2_3382/X_u2-net6 VSS nmos W=0.31u L=0.04u
M1978 WX9739 AND2_3382/net6 VDD VDD pmos W=0.41u L=0.04u
M1979 AND2_3382/net6 RESET VDD VDD pmos W=0.41u L=0.04u
M1980 AND2_3382/net6 WX9397 VDD VDD pmos W=0.41u L=0.04u
M1981 WX9737 AND2_3381/net6 VSS VSS nmos W=0.31u L=0.04u
M1982 AND2_3381/X_u2-net6 RESET VSS VSS nmos W=0.31u L=0.04u
M1983 AND2_3381/net6 WX9383 AND2_3381/X_u2-net6 VSS nmos W=0.31u L=0.04u
M1984 WX9737 AND2_3381/net6 VDD VDD pmos W=0.41u L=0.04u
M1985 AND2_3381/net6 RESET VDD VDD pmos W=0.41u L=0.04u
M1986 AND2_3381/net6 WX9383 VDD VDD pmos W=0.41u L=0.04u
M1987 WX9735 AND2_3380/net6 VSS VSS nmos W=0.31u L=0.04u
M1988 AND2_3380/X_u2-net6 RESET VSS VSS nmos W=0.31u L=0.04u
M1989 AND2_3380/net6 WX9369 AND2_3380/X_u2-net6 VSS nmos W=0.31u L=0.04u
M1990 WX9735 AND2_3380/net6 VDD VDD pmos W=0.41u L=0.04u
M1991 AND2_3380/net6 RESET VDD VDD pmos W=0.41u L=0.04u
M1992 AND2_3380/net6 WX9369 VDD VDD pmos W=0.41u L=0.04u
M1993 WX9733 AND2_3379/net6 VSS VSS nmos W=0.31u L=0.04u
M1994 AND2_3379/X_u2-net6 RESET VSS VSS nmos W=0.31u L=0.04u
M1995 AND2_3379/net6 WX9355 AND2_3379/X_u2-net6 VSS nmos W=0.31u L=0.04u
M1996 WX9733 AND2_3379/net6 VDD VDD pmos W=0.41u L=0.04u
M1997 AND2_3379/net6 RESET VDD VDD pmos W=0.41u L=0.04u
M1998 AND2_3379/net6 WX9355 VDD VDD pmos W=0.41u L=0.04u
M1999 WX9731 AND2_3378/net6 VSS VSS nmos W=0.31u L=0.04u
M2000 AND2_3378/X_u2-net6 RESET VSS VSS nmos W=0.31u L=0.04u
M2001 AND2_3378/net6 WX9341 AND2_3378/X_u2-net6 VSS nmos W=0.31u L=0.04u
M2002 WX9731 AND2_3378/net6 VDD VDD pmos W=0.41u L=0.04u
M2003 AND2_3378/net6 RESET VDD VDD pmos W=0.41u L=0.04u
M2004 AND2_3378/net6 WX9341 VDD VDD pmos W=0.41u L=0.04u
M2005 WX9729 AND2_3377/net6 VSS VSS nmos W=0.31u L=0.04u
M2006 AND2_3377/X_u2-net6 RESET VSS VSS nmos W=0.31u L=0.04u
M2007 AND2_3377/net6 WX9327 AND2_3377/X_u2-net6 VSS nmos W=0.31u L=0.04u
M2008 WX9729 AND2_3377/net6 VDD VDD pmos W=0.41u L=0.04u
M2009 AND2_3377/net6 RESET VDD VDD pmos W=0.41u L=0.04u
M2010 AND2_3377/net6 WX9327 VDD VDD pmos W=0.41u L=0.04u
M2011 WX9727 AND2_3376/net6 VSS VSS nmos W=0.31u L=0.04u
M2012 AND2_3376/X_u2-net6 RESET VSS VSS nmos W=0.31u L=0.04u
M2013 AND2_3376/net6 WX9313 AND2_3376/X_u2-net6 VSS nmos W=0.31u L=0.04u
M2014 WX9727 AND2_3376/net6 VDD VDD pmos W=0.41u L=0.04u
M2015 AND2_3376/net6 RESET VDD VDD pmos W=0.41u L=0.04u
M2016 AND2_3376/net6 WX9313 VDD VDD pmos W=0.41u L=0.04u
M2017 WX9725 AND2_3375/net6 VSS VSS nmos W=0.31u L=0.04u
M2018 AND2_3375/X_u2-net6 RESET VSS VSS nmos W=0.31u L=0.04u
M2019 AND2_3375/net6 WX9299 AND2_3375/X_u2-net6 VSS nmos W=0.31u L=0.04u
M2020 WX9725 AND2_3375/net6 VDD VDD pmos W=0.41u L=0.04u
M2021 AND2_3375/net6 RESET VDD VDD pmos W=0.41u L=0.04u
M2022 AND2_3375/net6 WX9299 VDD VDD pmos W=0.41u L=0.04u
M2023 WX9723 AND2_3374/net6 VSS VSS nmos W=0.31u L=0.04u
M2024 AND2_3374/X_u2-net6 RESET VSS VSS nmos W=0.31u L=0.04u
M2025 AND2_3374/net6 WX9285 AND2_3374/X_u2-net6 VSS nmos W=0.31u L=0.04u
M2026 WX9723 AND2_3374/net6 VDD VDD pmos W=0.41u L=0.04u
M2027 AND2_3374/net6 RESET VDD VDD pmos W=0.41u L=0.04u
M2028 AND2_3374/net6 WX9285 VDD VDD pmos W=0.41u L=0.04u
M2029 WX9721 AND2_3373/net6 VSS VSS nmos W=0.31u L=0.04u
M2030 AND2_3373/X_u2-net6 RESET VSS VSS nmos W=0.31u L=0.04u
M2031 AND2_3373/net6 WX9271 AND2_3373/X_u2-net6 VSS nmos W=0.31u L=0.04u
M2032 WX9721 AND2_3373/net6 VDD VDD pmos W=0.41u L=0.04u
M2033 AND2_3373/net6 RESET VDD VDD pmos W=0.41u L=0.04u
M2034 AND2_3373/net6 WX9271 VDD VDD pmos W=0.41u L=0.04u
M2035 WX9719 AND2_3372/net6 VSS VSS nmos W=0.31u L=0.04u
M2036 AND2_3372/X_u2-net6 RESET VSS VSS nmos W=0.31u L=0.04u
M2037 AND2_3372/net6 WX9257 AND2_3372/X_u2-net6 VSS nmos W=0.31u L=0.04u
M2038 WX9719 AND2_3372/net6 VDD VDD pmos W=0.41u L=0.04u
M2039 AND2_3372/net6 RESET VDD VDD pmos W=0.41u L=0.04u
M2040 AND2_3372/net6 WX9257 VDD VDD pmos W=0.41u L=0.04u
M2041 WX9717 AND2_3371/net6 VSS VSS nmos W=0.31u L=0.04u
M2042 AND2_3371/X_u2-net6 RESET VSS VSS nmos W=0.31u L=0.04u
M2043 AND2_3371/net6 WX9243 AND2_3371/X_u2-net6 VSS nmos W=0.31u L=0.04u
M2044 WX9717 AND2_3371/net6 VDD VDD pmos W=0.41u L=0.04u
M2045 AND2_3371/net6 RESET VDD VDD pmos W=0.41u L=0.04u
M2046 AND2_3371/net6 WX9243 VDD VDD pmos W=0.41u L=0.04u
M2047 WX9715 AND2_3370/net6 VSS VSS nmos W=0.31u L=0.04u
M2048 AND2_3370/X_u2-net6 RESET VSS VSS nmos W=0.31u L=0.04u
M2049 AND2_3370/net6 WX9229 AND2_3370/X_u2-net6 VSS nmos W=0.31u L=0.04u
M2050 WX9715 AND2_3370/net6 VDD VDD pmos W=0.41u L=0.04u
M2051 AND2_3370/net6 RESET VDD VDD pmos W=0.41u L=0.04u
M2052 AND2_3370/net6 WX9229 VDD VDD pmos W=0.41u L=0.04u
M2053 WX9713 AND2_3369/net6 VSS VSS nmos W=0.31u L=0.04u
M2054 AND2_3369/X_u2-net6 RESET VSS VSS nmos W=0.31u L=0.04u
M2055 AND2_3369/net6 WX9215 AND2_3369/X_u2-net6 VSS nmos W=0.31u L=0.04u
M2056 WX9713 AND2_3369/net6 VDD VDD pmos W=0.41u L=0.04u
M2057 AND2_3369/net6 RESET VDD VDD pmos W=0.41u L=0.04u
M2058 AND2_3369/net6 WX9215 VDD VDD pmos W=0.41u L=0.04u
M2059 WX9711 AND2_3368/net6 VSS VSS nmos W=0.31u L=0.04u
M2060 AND2_3368/X_u2-net6 RESET VSS VSS nmos W=0.31u L=0.04u
M2061 AND2_3368/net6 WX9201 AND2_3368/X_u2-net6 VSS nmos W=0.31u L=0.04u
M2062 WX9711 AND2_3368/net6 VDD VDD pmos W=0.41u L=0.04u
M2063 AND2_3368/net6 RESET VDD VDD pmos W=0.41u L=0.04u
M2064 AND2_3368/net6 WX9201 VDD VDD pmos W=0.41u L=0.04u
M2065 WX9709 AND2_3367/net6 VSS VSS nmos W=0.31u L=0.04u
M2066 AND2_3367/X_u2-net6 RESET VSS VSS nmos W=0.31u L=0.04u
M2067 AND2_3367/net6 WX9187 AND2_3367/X_u2-net6 VSS nmos W=0.31u L=0.04u
M2068 WX9709 AND2_3367/net6 VDD VDD pmos W=0.41u L=0.04u
M2069 AND2_3367/net6 RESET VDD VDD pmos W=0.41u L=0.04u
M2070 AND2_3367/net6 WX9187 VDD VDD pmos W=0.41u L=0.04u
M2071 WX9707 AND2_3366/net6 VSS VSS nmos W=0.31u L=0.04u
M2072 AND2_3366/X_u2-net6 RESET VSS VSS nmos W=0.31u L=0.04u
M2073 AND2_3366/net6 WX9173 AND2_3366/X_u2-net6 VSS nmos W=0.31u L=0.04u
M2074 WX9707 AND2_3366/net6 VDD VDD pmos W=0.41u L=0.04u
M2075 AND2_3366/net6 RESET VDD VDD pmos W=0.41u L=0.04u
M2076 AND2_3366/net6 WX9173 VDD VDD pmos W=0.41u L=0.04u
M2077 WX9705 AND2_3365/net6 VSS VSS nmos W=0.31u L=0.04u
M2078 AND2_3365/X_u2-net6 RESET VSS VSS nmos W=0.31u L=0.04u
M2079 AND2_3365/net6 WX9159 AND2_3365/X_u2-net6 VSS nmos W=0.31u L=0.04u
M2080 WX9705 AND2_3365/net6 VDD VDD pmos W=0.41u L=0.04u
M2081 AND2_3365/net6 RESET VDD VDD pmos W=0.41u L=0.04u
M2082 AND2_3365/net6 WX9159 VDD VDD pmos W=0.41u L=0.04u
M2083 WX9703 AND2_3364/net6 VSS VSS nmos W=0.31u L=0.04u
M2084 AND2_3364/X_u2-net6 RESET VSS VSS nmos W=0.31u L=0.04u
M2085 AND2_3364/net6 WX9145 AND2_3364/X_u2-net6 VSS nmos W=0.31u L=0.04u
M2086 WX9703 AND2_3364/net6 VDD VDD pmos W=0.41u L=0.04u
M2087 AND2_3364/net6 RESET VDD VDD pmos W=0.41u L=0.04u
M2088 AND2_3364/net6 WX9145 VDD VDD pmos W=0.41u L=0.04u
M2089 WX9701 AND2_3363/net6 VSS VSS nmos W=0.31u L=0.04u
M2090 AND2_3363/X_u2-net6 RESET VSS VSS nmos W=0.31u L=0.04u
M2091 AND2_3363/net6 WX9131 AND2_3363/X_u2-net6 VSS nmos W=0.31u L=0.04u
M2092 WX9701 AND2_3363/net6 VDD VDD pmos W=0.41u L=0.04u
M2093 AND2_3363/net6 RESET VDD VDD pmos W=0.41u L=0.04u
M2094 AND2_3363/net6 WX9131 VDD VDD pmos W=0.41u L=0.04u
M2095 WX9699 AND2_3362/net6 VSS VSS nmos W=0.31u L=0.04u
M2096 AND2_3362/X_u2-net6 RESET VSS VSS nmos W=0.31u L=0.04u
M2097 AND2_3362/net6 WX9117 AND2_3362/X_u2-net6 VSS nmos W=0.31u L=0.04u
M2098 WX9699 AND2_3362/net6 VDD VDD pmos W=0.41u L=0.04u
M2099 AND2_3362/net6 RESET VDD VDD pmos W=0.41u L=0.04u
M2100 AND2_3362/net6 WX9117 VDD VDD pmos W=0.41u L=0.04u
M2101 WX9697 AND2_3361/net6 VSS VSS nmos W=0.31u L=0.04u
M2102 AND2_3361/X_u2-net6 RESET VSS VSS nmos W=0.31u L=0.04u
M2103 AND2_3361/net6 WX9103 AND2_3361/X_u2-net6 VSS nmos W=0.31u L=0.04u
M2104 WX9697 AND2_3361/net6 VDD VDD pmos W=0.41u L=0.04u
M2105 AND2_3361/net6 RESET VDD VDD pmos W=0.41u L=0.04u
M2106 AND2_3361/net6 WX9103 VDD VDD pmos W=0.41u L=0.04u
M2107 WX9695 AND2_3360/net6 VSS VSS nmos W=0.31u L=0.04u
M2108 AND2_3360/X_u2-net6 RESET VSS VSS nmos W=0.31u L=0.04u
M2109 AND2_3360/net6 WX9089 AND2_3360/X_u2-net6 VSS nmos W=0.31u L=0.04u
M2110 WX9695 AND2_3360/net6 VDD VDD pmos W=0.41u L=0.04u
M2111 AND2_3360/net6 RESET VDD VDD pmos W=0.41u L=0.04u
M2112 AND2_3360/net6 WX9089 VDD VDD pmos W=0.41u L=0.04u
M2113 WX9597 AND2_3359/net6 VSS VSS nmos W=0.31u L=0.04u
M2114 AND2_3359/X_u2-net6 RESET VSS VSS nmos W=0.31u L=0.04u
M2115 AND2_3359/net6 WX9534 AND2_3359/X_u2-net6 VSS nmos W=0.31u L=0.04u
M2116 WX9597 AND2_3359/net6 VDD VDD pmos W=0.41u L=0.04u
M2117 AND2_3359/net6 RESET VDD VDD pmos W=0.41u L=0.04u
M2118 AND2_3359/net6 WX9534 VDD VDD pmos W=0.41u L=0.04u
M2119 WX9595 AND2_3358/net6 VSS VSS nmos W=0.31u L=0.04u
M2120 AND2_3358/X_u2-net6 RESET VSS VSS nmos W=0.31u L=0.04u
M2121 AND2_3358/net6 WX9598 AND2_3358/X_u2-net6 VSS nmos W=0.31u L=0.04u
M2122 WX9595 AND2_3358/net6 VDD VDD pmos W=0.41u L=0.04u
M2123 AND2_3358/net6 RESET VDD VDD pmos W=0.41u L=0.04u
M2124 AND2_3358/net6 WX9598 VDD VDD pmos W=0.41u L=0.04u
M2125 WX9593 AND2_3357/net6 VSS VSS nmos W=0.31u L=0.04u
M2126 AND2_3357/X_u2-net6 RESET VSS VSS nmos W=0.31u L=0.04u
M2127 AND2_3357/net6 WX9596 AND2_3357/X_u2-net6 VSS nmos W=0.31u L=0.04u
M2128 WX9593 AND2_3357/net6 VDD VDD pmos W=0.41u L=0.04u
M2129 AND2_3357/net6 RESET VDD VDD pmos W=0.41u L=0.04u
M2130 AND2_3357/net6 WX9596 VDD VDD pmos W=0.41u L=0.04u
M2131 WX9591 AND2_3356/net6 VSS VSS nmos W=0.31u L=0.04u
M2132 AND2_3356/X_u2-net6 RESET VSS VSS nmos W=0.31u L=0.04u
M2133 AND2_3356/net6 WX9594 AND2_3356/X_u2-net6 VSS nmos W=0.31u L=0.04u
M2134 WX9591 AND2_3356/net6 VDD VDD pmos W=0.41u L=0.04u
M2135 AND2_3356/net6 RESET VDD VDD pmos W=0.41u L=0.04u
M2136 AND2_3356/net6 WX9594 VDD VDD pmos W=0.41u L=0.04u
M2137 WX9589 AND2_3355/net6 VSS VSS nmos W=0.31u L=0.04u
M2138 AND2_3355/X_u2-net6 RESET VSS VSS nmos W=0.31u L=0.04u
M2139 AND2_3355/net6 WX9592 AND2_3355/X_u2-net6 VSS nmos W=0.31u L=0.04u
M2140 WX9589 AND2_3355/net6 VDD VDD pmos W=0.41u L=0.04u
M2141 AND2_3355/net6 RESET VDD VDD pmos W=0.41u L=0.04u
M2142 AND2_3355/net6 WX9592 VDD VDD pmos W=0.41u L=0.04u
M2143 WX9587 AND2_3354/net6 VSS VSS nmos W=0.31u L=0.04u
M2144 AND2_3354/X_u2-net6 RESET VSS VSS nmos W=0.31u L=0.04u
M2145 AND2_3354/net6 WX9590 AND2_3354/X_u2-net6 VSS nmos W=0.31u L=0.04u
M2146 WX9587 AND2_3354/net6 VDD VDD pmos W=0.41u L=0.04u
M2147 AND2_3354/net6 RESET VDD VDD pmos W=0.41u L=0.04u
M2148 AND2_3354/net6 WX9590 VDD VDD pmos W=0.41u L=0.04u
M2149 WX9585 AND2_3353/net6 VSS VSS nmos W=0.31u L=0.04u
M2150 AND2_3353/X_u2-net6 RESET VSS VSS nmos W=0.31u L=0.04u
M2151 AND2_3353/net6 WX9588 AND2_3353/X_u2-net6 VSS nmos W=0.31u L=0.04u
M2152 WX9585 AND2_3353/net6 VDD VDD pmos W=0.41u L=0.04u
M2153 AND2_3353/net6 RESET VDD VDD pmos W=0.41u L=0.04u
M2154 AND2_3353/net6 WX9588 VDD VDD pmos W=0.41u L=0.04u
M2155 WX9583 AND2_3352/net6 VSS VSS nmos W=0.31u L=0.04u
M2156 AND2_3352/X_u2-net6 RESET VSS VSS nmos W=0.31u L=0.04u
M2157 AND2_3352/net6 WX9586 AND2_3352/X_u2-net6 VSS nmos W=0.31u L=0.04u
M2158 WX9583 AND2_3352/net6 VDD VDD pmos W=0.41u L=0.04u
M2159 AND2_3352/net6 RESET VDD VDD pmos W=0.41u L=0.04u
M2160 AND2_3352/net6 WX9586 VDD VDD pmos W=0.41u L=0.04u
M2161 WX9581 AND2_3351/net6 VSS VSS nmos W=0.31u L=0.04u
M2162 AND2_3351/X_u2-net6 RESET VSS VSS nmos W=0.31u L=0.04u
M2163 AND2_3351/net6 WX9584 AND2_3351/X_u2-net6 VSS nmos W=0.31u L=0.04u
M2164 WX9581 AND2_3351/net6 VDD VDD pmos W=0.41u L=0.04u
M2165 AND2_3351/net6 RESET VDD VDD pmos W=0.41u L=0.04u
M2166 AND2_3351/net6 WX9584 VDD VDD pmos W=0.41u L=0.04u
M2167 WX9579 AND2_3350/net6 VSS VSS nmos W=0.31u L=0.04u
M2168 AND2_3350/X_u2-net6 RESET VSS VSS nmos W=0.31u L=0.04u
M2169 AND2_3350/net6 WX9582 AND2_3350/X_u2-net6 VSS nmos W=0.31u L=0.04u
M2170 WX9579 AND2_3350/net6 VDD VDD pmos W=0.41u L=0.04u
M2171 AND2_3350/net6 RESET VDD VDD pmos W=0.41u L=0.04u
M2172 AND2_3350/net6 WX9582 VDD VDD pmos W=0.41u L=0.04u
M2173 WX9577 AND2_3349/net6 VSS VSS nmos W=0.31u L=0.04u
M2174 AND2_3349/X_u2-net6 RESET VSS VSS nmos W=0.31u L=0.04u
M2175 AND2_3349/net6 WX9580 AND2_3349/X_u2-net6 VSS nmos W=0.31u L=0.04u
M2176 WX9577 AND2_3349/net6 VDD VDD pmos W=0.41u L=0.04u
M2177 AND2_3349/net6 RESET VDD VDD pmos W=0.41u L=0.04u
M2178 AND2_3349/net6 WX9580 VDD VDD pmos W=0.41u L=0.04u
M2179 WX9575 AND2_3348/net6 VSS VSS nmos W=0.31u L=0.04u
M2180 AND2_3348/X_u2-net6 RESET VSS VSS nmos W=0.31u L=0.04u
M2181 AND2_3348/net6 WX9578 AND2_3348/X_u2-net6 VSS nmos W=0.31u L=0.04u
M2182 WX9575 AND2_3348/net6 VDD VDD pmos W=0.41u L=0.04u
M2183 AND2_3348/net6 RESET VDD VDD pmos W=0.41u L=0.04u
M2184 AND2_3348/net6 WX9578 VDD VDD pmos W=0.41u L=0.04u
M2185 WX9573 AND2_3347/net6 VSS VSS nmos W=0.31u L=0.04u
M2186 AND2_3347/X_u2-net6 RESET VSS VSS nmos W=0.31u L=0.04u
M2187 AND2_3347/net6 WX9576 AND2_3347/X_u2-net6 VSS nmos W=0.31u L=0.04u
M2188 WX9573 AND2_3347/net6 VDD VDD pmos W=0.41u L=0.04u
M2189 AND2_3347/net6 RESET VDD VDD pmos W=0.41u L=0.04u
M2190 AND2_3347/net6 WX9576 VDD VDD pmos W=0.41u L=0.04u
M2191 WX9571 AND2_3346/net6 VSS VSS nmos W=0.31u L=0.04u
M2192 AND2_3346/X_u2-net6 RESET VSS VSS nmos W=0.31u L=0.04u
M2193 AND2_3346/net6 WX9574 AND2_3346/X_u2-net6 VSS nmos W=0.31u L=0.04u
M2194 WX9571 AND2_3346/net6 VDD VDD pmos W=0.41u L=0.04u
M2195 AND2_3346/net6 RESET VDD VDD pmos W=0.41u L=0.04u
M2196 AND2_3346/net6 WX9574 VDD VDD pmos W=0.41u L=0.04u
M2197 WX9569 AND2_3345/net6 VSS VSS nmos W=0.31u L=0.04u
M2198 AND2_3345/X_u2-net6 RESET VSS VSS nmos W=0.31u L=0.04u
M2199 AND2_3345/net6 WX9572 AND2_3345/X_u2-net6 VSS nmos W=0.31u L=0.04u
M2200 WX9569 AND2_3345/net6 VDD VDD pmos W=0.41u L=0.04u
M2201 AND2_3345/net6 RESET VDD VDD pmos W=0.41u L=0.04u
M2202 AND2_3345/net6 WX9572 VDD VDD pmos W=0.41u L=0.04u
M2203 WX9567 AND2_3344/net6 VSS VSS nmos W=0.31u L=0.04u
M2204 AND2_3344/X_u2-net6 RESET VSS VSS nmos W=0.31u L=0.04u
M2205 AND2_3344/net6 WX9570 AND2_3344/X_u2-net6 VSS nmos W=0.31u L=0.04u
M2206 WX9567 AND2_3344/net6 VDD VDD pmos W=0.41u L=0.04u
M2207 AND2_3344/net6 RESET VDD VDD pmos W=0.41u L=0.04u
M2208 AND2_3344/net6 WX9570 VDD VDD pmos W=0.41u L=0.04u
M2209 WX9565 AND2_3343/net6 VSS VSS nmos W=0.31u L=0.04u
M2210 AND2_3343/X_u2-net6 RESET VSS VSS nmos W=0.31u L=0.04u
M2211 AND2_3343/net6 WX9568 AND2_3343/X_u2-net6 VSS nmos W=0.31u L=0.04u
M2212 WX9565 AND2_3343/net6 VDD VDD pmos W=0.41u L=0.04u
M2213 AND2_3343/net6 RESET VDD VDD pmos W=0.41u L=0.04u
M2214 AND2_3343/net6 WX9568 VDD VDD pmos W=0.41u L=0.04u
M2215 WX9563 AND2_3342/net6 VSS VSS nmos W=0.31u L=0.04u
M2216 AND2_3342/X_u2-net6 RESET VSS VSS nmos W=0.31u L=0.04u
M2217 AND2_3342/net6 WX9566 AND2_3342/X_u2-net6 VSS nmos W=0.31u L=0.04u
M2218 WX9563 AND2_3342/net6 VDD VDD pmos W=0.41u L=0.04u
M2219 AND2_3342/net6 RESET VDD VDD pmos W=0.41u L=0.04u
M2220 AND2_3342/net6 WX9566 VDD VDD pmos W=0.41u L=0.04u
M2221 WX9561 AND2_3341/net6 VSS VSS nmos W=0.31u L=0.04u
M2222 AND2_3341/X_u2-net6 RESET VSS VSS nmos W=0.31u L=0.04u
M2223 AND2_3341/net6 WX9564 AND2_3341/X_u2-net6 VSS nmos W=0.31u L=0.04u
M2224 WX9561 AND2_3341/net6 VDD VDD pmos W=0.41u L=0.04u
M2225 AND2_3341/net6 RESET VDD VDD pmos W=0.41u L=0.04u
M2226 AND2_3341/net6 WX9564 VDD VDD pmos W=0.41u L=0.04u
M2227 WX9559 AND2_3340/net6 VSS VSS nmos W=0.31u L=0.04u
M2228 AND2_3340/X_u2-net6 RESET VSS VSS nmos W=0.31u L=0.04u
M2229 AND2_3340/net6 WX9562 AND2_3340/X_u2-net6 VSS nmos W=0.31u L=0.04u
M2230 WX9559 AND2_3340/net6 VDD VDD pmos W=0.41u L=0.04u
M2231 AND2_3340/net6 RESET VDD VDD pmos W=0.41u L=0.04u
M2232 AND2_3340/net6 WX9562 VDD VDD pmos W=0.41u L=0.04u
M2233 WX9557 AND2_3339/net6 VSS VSS nmos W=0.31u L=0.04u
M2234 AND2_3339/X_u2-net6 RESET VSS VSS nmos W=0.31u L=0.04u
M2235 AND2_3339/net6 WX9560 AND2_3339/X_u2-net6 VSS nmos W=0.31u L=0.04u
M2236 WX9557 AND2_3339/net6 VDD VDD pmos W=0.41u L=0.04u
M2237 AND2_3339/net6 RESET VDD VDD pmos W=0.41u L=0.04u
M2238 AND2_3339/net6 WX9560 VDD VDD pmos W=0.41u L=0.04u
M2239 WX9555 AND2_3338/net6 VSS VSS nmos W=0.31u L=0.04u
M2240 AND2_3338/X_u2-net6 RESET VSS VSS nmos W=0.31u L=0.04u
M2241 AND2_3338/net6 WX9558 AND2_3338/X_u2-net6 VSS nmos W=0.31u L=0.04u
M2242 WX9555 AND2_3338/net6 VDD VDD pmos W=0.41u L=0.04u
M2243 AND2_3338/net6 RESET VDD VDD pmos W=0.41u L=0.04u
M2244 AND2_3338/net6 WX9558 VDD VDD pmos W=0.41u L=0.04u
M2245 WX9553 AND2_3337/net6 VSS VSS nmos W=0.31u L=0.04u
M2246 AND2_3337/X_u2-net6 RESET VSS VSS nmos W=0.31u L=0.04u
M2247 AND2_3337/net6 WX9556 AND2_3337/X_u2-net6 VSS nmos W=0.31u L=0.04u
M2248 WX9553 AND2_3337/net6 VDD VDD pmos W=0.41u L=0.04u
M2249 AND2_3337/net6 RESET VDD VDD pmos W=0.41u L=0.04u
M2250 AND2_3337/net6 WX9556 VDD VDD pmos W=0.41u L=0.04u
M2251 WX9551 AND2_3336/net6 VSS VSS nmos W=0.31u L=0.04u
M2252 AND2_3336/X_u2-net6 RESET VSS VSS nmos W=0.31u L=0.04u
M2253 AND2_3336/net6 WX9554 AND2_3336/X_u2-net6 VSS nmos W=0.31u L=0.04u
M2254 WX9551 AND2_3336/net6 VDD VDD pmos W=0.41u L=0.04u
M2255 AND2_3336/net6 RESET VDD VDD pmos W=0.41u L=0.04u
M2256 AND2_3336/net6 WX9554 VDD VDD pmos W=0.41u L=0.04u
M2257 WX9549 AND2_3335/net6 VSS VSS nmos W=0.31u L=0.04u
M2258 AND2_3335/X_u2-net6 RESET VSS VSS nmos W=0.31u L=0.04u
M2259 AND2_3335/net6 WX9552 AND2_3335/X_u2-net6 VSS nmos W=0.31u L=0.04u
M2260 WX9549 AND2_3335/net6 VDD VDD pmos W=0.41u L=0.04u
M2261 AND2_3335/net6 RESET VDD VDD pmos W=0.41u L=0.04u
M2262 AND2_3335/net6 WX9552 VDD VDD pmos W=0.41u L=0.04u
M2263 WX9547 AND2_3334/net6 VSS VSS nmos W=0.31u L=0.04u
M2264 AND2_3334/X_u2-net6 RESET VSS VSS nmos W=0.31u L=0.04u
M2265 AND2_3334/net6 WX9550 AND2_3334/X_u2-net6 VSS nmos W=0.31u L=0.04u
M2266 WX9547 AND2_3334/net6 VDD VDD pmos W=0.41u L=0.04u
M2267 AND2_3334/net6 RESET VDD VDD pmos W=0.41u L=0.04u
M2268 AND2_3334/net6 WX9550 VDD VDD pmos W=0.41u L=0.04u
M2269 WX9545 AND2_3333/net6 VSS VSS nmos W=0.31u L=0.04u
M2270 AND2_3333/X_u2-net6 RESET VSS VSS nmos W=0.31u L=0.04u
M2271 AND2_3333/net6 WX9548 AND2_3333/X_u2-net6 VSS nmos W=0.31u L=0.04u
M2272 WX9545 AND2_3333/net6 VDD VDD pmos W=0.41u L=0.04u
M2273 AND2_3333/net6 RESET VDD VDD pmos W=0.41u L=0.04u
M2274 AND2_3333/net6 WX9548 VDD VDD pmos W=0.41u L=0.04u
M2275 WX9543 AND2_3332/net6 VSS VSS nmos W=0.31u L=0.04u
M2276 AND2_3332/X_u2-net6 RESET VSS VSS nmos W=0.31u L=0.04u
M2277 AND2_3332/net6 WX9546 AND2_3332/X_u2-net6 VSS nmos W=0.31u L=0.04u
M2278 WX9543 AND2_3332/net6 VDD VDD pmos W=0.41u L=0.04u
M2279 AND2_3332/net6 RESET VDD VDD pmos W=0.41u L=0.04u
M2280 AND2_3332/net6 WX9546 VDD VDD pmos W=0.41u L=0.04u
M2281 WX9541 AND2_3331/net6 VSS VSS nmos W=0.31u L=0.04u
M2282 AND2_3331/X_u2-net6 RESET VSS VSS nmos W=0.31u L=0.04u
M2283 AND2_3331/net6 WX9544 AND2_3331/X_u2-net6 VSS nmos W=0.31u L=0.04u
M2284 WX9541 AND2_3331/net6 VDD VDD pmos W=0.41u L=0.04u
M2285 AND2_3331/net6 RESET VDD VDD pmos W=0.41u L=0.04u
M2286 AND2_3331/net6 WX9544 VDD VDD pmos W=0.41u L=0.04u
M2287 WX9539 AND2_3330/net6 VSS VSS nmos W=0.31u L=0.04u
M2288 AND2_3330/X_u2-net6 RESET VSS VSS nmos W=0.31u L=0.04u
M2289 AND2_3330/net6 WX9542 AND2_3330/X_u2-net6 VSS nmos W=0.31u L=0.04u
M2290 WX9539 AND2_3330/net6 VDD VDD pmos W=0.41u L=0.04u
M2291 AND2_3330/net6 RESET VDD VDD pmos W=0.41u L=0.04u
M2292 AND2_3330/net6 WX9542 VDD VDD pmos W=0.41u L=0.04u
M2293 WX9537 AND2_3329/net6 VSS VSS nmos W=0.31u L=0.04u
M2294 AND2_3329/X_u2-net6 RESET VSS VSS nmos W=0.31u L=0.04u
M2295 AND2_3329/net6 WX9540 AND2_3329/X_u2-net6 VSS nmos W=0.31u L=0.04u
M2296 WX9537 AND2_3329/net6 VDD VDD pmos W=0.41u L=0.04u
M2297 AND2_3329/net6 RESET VDD VDD pmos W=0.41u L=0.04u
M2298 AND2_3329/net6 WX9540 VDD VDD pmos W=0.41u L=0.04u
M2299 WX9535 AND2_3328/net6 VSS VSS nmos W=0.31u L=0.04u
M2300 AND2_3328/X_u2-net6 RESET VSS VSS nmos W=0.31u L=0.04u
M2301 AND2_3328/net6 WX9538 AND2_3328/X_u2-net6 VSS nmos W=0.31u L=0.04u
M2302 WX9535 AND2_3328/net6 VDD VDD pmos W=0.41u L=0.04u
M2303 AND2_3328/net6 RESET VDD VDD pmos W=0.41u L=0.04u
M2304 AND2_3328/net6 WX9538 VDD VDD pmos W=0.41u L=0.04u
M2305 WX9084 AND2_3135/net6 VSS VSS nmos W=0.31u L=0.04u
M2306 AND2_3135/X_u2-net6 RESET VSS VSS nmos W=0.31u L=0.04u
M2307 AND2_3135/net6 n1144 AND2_3135/X_u2-net6 VSS nmos W=0.31u L=0.04u
M2308 WX9084 AND2_3135/net6 VDD VDD pmos W=0.41u L=0.04u
M2309 AND2_3135/net6 RESET VDD VDD pmos W=0.41u L=0.04u
M2310 AND2_3135/net6 n1144 VDD VDD pmos W=0.41u L=0.04u
M2311 WX9082 AND2_3134/net6 VSS VSS nmos W=0.31u L=0.04u
M2312 AND2_3134/X_u2-net6 RESET VSS VSS nmos W=0.31u L=0.04u
M2313 AND2_3134/net6 n1145 AND2_3134/X_u2-net6 VSS nmos W=0.31u L=0.04u
M2314 WX9082 AND2_3134/net6 VDD VDD pmos W=0.41u L=0.04u
M2315 AND2_3134/net6 RESET VDD VDD pmos W=0.41u L=0.04u
M2316 AND2_3134/net6 n1145 VDD VDD pmos W=0.41u L=0.04u
M2317 WX9080 AND2_3133/net6 VSS VSS nmos W=0.31u L=0.04u
M2318 AND2_3133/X_u2-net6 RESET VSS VSS nmos W=0.31u L=0.04u
M2319 AND2_3133/net6 n1146 AND2_3133/X_u2-net6 VSS nmos W=0.31u L=0.04u
M2320 WX9080 AND2_3133/net6 VDD VDD pmos W=0.41u L=0.04u
M2321 AND2_3133/net6 RESET VDD VDD pmos W=0.41u L=0.04u
M2322 AND2_3133/net6 n1146 VDD VDD pmos W=0.41u L=0.04u
M2323 WX9078 AND2_3132/net6 VSS VSS nmos W=0.31u L=0.04u
M2324 AND2_3132/X_u2-net6 RESET VSS VSS nmos W=0.31u L=0.04u
M2325 AND2_3132/net6 n1147 AND2_3132/X_u2-net6 VSS nmos W=0.31u L=0.04u
M2326 WX9078 AND2_3132/net6 VDD VDD pmos W=0.41u L=0.04u
M2327 AND2_3132/net6 RESET VDD VDD pmos W=0.41u L=0.04u
M2328 AND2_3132/net6 n1147 VDD VDD pmos W=0.41u L=0.04u
M2329 WX9076 AND2_3131/net6 VSS VSS nmos W=0.31u L=0.04u
M2330 AND2_3131/X_u2-net6 RESET VSS VSS nmos W=0.31u L=0.04u
M2331 AND2_3131/net6 n1148 AND2_3131/X_u2-net6 VSS nmos W=0.31u L=0.04u
M2332 WX9076 AND2_3131/net6 VDD VDD pmos W=0.41u L=0.04u
M2333 AND2_3131/net6 RESET VDD VDD pmos W=0.41u L=0.04u
M2334 AND2_3131/net6 n1148 VDD VDD pmos W=0.41u L=0.04u
M2335 WX9074 AND2_3130/net6 VSS VSS nmos W=0.31u L=0.04u
M2336 AND2_3130/X_u2-net6 RESET VSS VSS nmos W=0.31u L=0.04u
M2337 AND2_3130/net6 n1149 AND2_3130/X_u2-net6 VSS nmos W=0.31u L=0.04u
M2338 WX9074 AND2_3130/net6 VDD VDD pmos W=0.41u L=0.04u
M2339 AND2_3130/net6 RESET VDD VDD pmos W=0.41u L=0.04u
M2340 AND2_3130/net6 n1149 VDD VDD pmos W=0.41u L=0.04u
M2341 WX9072 AND2_3129/net6 VSS VSS nmos W=0.31u L=0.04u
M2342 AND2_3129/X_u2-net6 RESET VSS VSS nmos W=0.31u L=0.04u
M2343 AND2_3129/net6 n1150 AND2_3129/X_u2-net6 VSS nmos W=0.31u L=0.04u
M2344 WX9072 AND2_3129/net6 VDD VDD pmos W=0.41u L=0.04u
M2345 AND2_3129/net6 RESET VDD VDD pmos W=0.41u L=0.04u
M2346 AND2_3129/net6 n1150 VDD VDD pmos W=0.41u L=0.04u
M2347 WX9070 AND2_3128/net6 VSS VSS nmos W=0.31u L=0.04u
M2348 AND2_3128/X_u2-net6 RESET VSS VSS nmos W=0.31u L=0.04u
M2349 AND2_3128/net6 n1151 AND2_3128/X_u2-net6 VSS nmos W=0.31u L=0.04u
M2350 WX9070 AND2_3128/net6 VDD VDD pmos W=0.41u L=0.04u
M2351 AND2_3128/net6 RESET VDD VDD pmos W=0.41u L=0.04u
M2352 AND2_3128/net6 n1151 VDD VDD pmos W=0.41u L=0.04u
M2353 WX9068 AND2_3127/net6 VSS VSS nmos W=0.31u L=0.04u
M2354 AND2_3127/X_u2-net6 RESET VSS VSS nmos W=0.31u L=0.04u
M2355 AND2_3127/net6 n1152 AND2_3127/X_u2-net6 VSS nmos W=0.31u L=0.04u
M2356 WX9068 AND2_3127/net6 VDD VDD pmos W=0.41u L=0.04u
M2357 AND2_3127/net6 RESET VDD VDD pmos W=0.41u L=0.04u
M2358 AND2_3127/net6 n1152 VDD VDD pmos W=0.41u L=0.04u
M2359 WX9066 AND2_3126/net6 VSS VSS nmos W=0.31u L=0.04u
M2360 AND2_3126/X_u2-net6 RESET VSS VSS nmos W=0.31u L=0.04u
M2361 AND2_3126/net6 n1153 AND2_3126/X_u2-net6 VSS nmos W=0.31u L=0.04u
M2362 WX9066 AND2_3126/net6 VDD VDD pmos W=0.41u L=0.04u
M2363 AND2_3126/net6 RESET VDD VDD pmos W=0.41u L=0.04u
M2364 AND2_3126/net6 n1153 VDD VDD pmos W=0.41u L=0.04u
M2365 WX9064 AND2_3125/net6 VSS VSS nmos W=0.31u L=0.04u
M2366 AND2_3125/X_u2-net6 RESET VSS VSS nmos W=0.31u L=0.04u
M2367 AND2_3125/net6 n1154 AND2_3125/X_u2-net6 VSS nmos W=0.31u L=0.04u
M2368 WX9064 AND2_3125/net6 VDD VDD pmos W=0.41u L=0.04u
M2369 AND2_3125/net6 RESET VDD VDD pmos W=0.41u L=0.04u
M2370 AND2_3125/net6 n1154 VDD VDD pmos W=0.41u L=0.04u
M2371 WX9062 AND2_3124/net6 VSS VSS nmos W=0.31u L=0.04u
M2372 AND2_3124/X_u2-net6 RESET VSS VSS nmos W=0.31u L=0.04u
M2373 AND2_3124/net6 n1155 AND2_3124/X_u2-net6 VSS nmos W=0.31u L=0.04u
M2374 WX9062 AND2_3124/net6 VDD VDD pmos W=0.41u L=0.04u
M2375 AND2_3124/net6 RESET VDD VDD pmos W=0.41u L=0.04u
M2376 AND2_3124/net6 n1155 VDD VDD pmos W=0.41u L=0.04u
M2377 WX9060 AND2_3123/net6 VSS VSS nmos W=0.31u L=0.04u
M2378 AND2_3123/X_u2-net6 RESET VSS VSS nmos W=0.31u L=0.04u
M2379 AND2_3123/net6 n1156 AND2_3123/X_u2-net6 VSS nmos W=0.31u L=0.04u
M2380 WX9060 AND2_3123/net6 VDD VDD pmos W=0.41u L=0.04u
M2381 AND2_3123/net6 RESET VDD VDD pmos W=0.41u L=0.04u
M2382 AND2_3123/net6 n1156 VDD VDD pmos W=0.41u L=0.04u
M2383 WX9058 AND2_3122/net6 VSS VSS nmos W=0.31u L=0.04u
M2384 AND2_3122/X_u2-net6 RESET VSS VSS nmos W=0.31u L=0.04u
M2385 AND2_3122/net6 n1157 AND2_3122/X_u2-net6 VSS nmos W=0.31u L=0.04u
M2386 WX9058 AND2_3122/net6 VDD VDD pmos W=0.41u L=0.04u
M2387 AND2_3122/net6 RESET VDD VDD pmos W=0.41u L=0.04u
M2388 AND2_3122/net6 n1157 VDD VDD pmos W=0.41u L=0.04u
M2389 WX9056 AND2_3121/net6 VSS VSS nmos W=0.31u L=0.04u
M2390 AND2_3121/X_u2-net6 RESET VSS VSS nmos W=0.31u L=0.04u
M2391 AND2_3121/net6 n1158 AND2_3121/X_u2-net6 VSS nmos W=0.31u L=0.04u
M2392 WX9056 AND2_3121/net6 VDD VDD pmos W=0.41u L=0.04u
M2393 AND2_3121/net6 RESET VDD VDD pmos W=0.41u L=0.04u
M2394 AND2_3121/net6 n1158 VDD VDD pmos W=0.41u L=0.04u
M2395 WX9054 AND2_3120/net6 VSS VSS nmos W=0.31u L=0.04u
M2396 AND2_3120/X_u2-net6 RESET VSS VSS nmos W=0.31u L=0.04u
M2397 AND2_3120/net6 n1159 AND2_3120/X_u2-net6 VSS nmos W=0.31u L=0.04u
M2398 WX9054 AND2_3120/net6 VDD VDD pmos W=0.41u L=0.04u
M2399 AND2_3120/net6 RESET VDD VDD pmos W=0.41u L=0.04u
M2400 AND2_3120/net6 n1159 VDD VDD pmos W=0.41u L=0.04u
M2401 WX9052 AND2_3119/net6 VSS VSS nmos W=0.31u L=0.04u
M2402 AND2_3119/X_u2-net6 RESET VSS VSS nmos W=0.31u L=0.04u
M2403 AND2_3119/net6 n1160 AND2_3119/X_u2-net6 VSS nmos W=0.31u L=0.04u
M2404 WX9052 AND2_3119/net6 VDD VDD pmos W=0.41u L=0.04u
M2405 AND2_3119/net6 RESET VDD VDD pmos W=0.41u L=0.04u
M2406 AND2_3119/net6 n1160 VDD VDD pmos W=0.41u L=0.04u
M2407 WX9050 AND2_3118/net6 VSS VSS nmos W=0.31u L=0.04u
M2408 AND2_3118/X_u2-net6 RESET VSS VSS nmos W=0.31u L=0.04u
M2409 AND2_3118/net6 n1161 AND2_3118/X_u2-net6 VSS nmos W=0.31u L=0.04u
M2410 WX9050 AND2_3118/net6 VDD VDD pmos W=0.41u L=0.04u
M2411 AND2_3118/net6 RESET VDD VDD pmos W=0.41u L=0.04u
M2412 AND2_3118/net6 n1161 VDD VDD pmos W=0.41u L=0.04u
M2413 WX9048 AND2_3117/net6 VSS VSS nmos W=0.31u L=0.04u
M2414 AND2_3117/X_u2-net6 RESET VSS VSS nmos W=0.31u L=0.04u
M2415 AND2_3117/net6 n1162 AND2_3117/X_u2-net6 VSS nmos W=0.31u L=0.04u
M2416 WX9048 AND2_3117/net6 VDD VDD pmos W=0.41u L=0.04u
M2417 AND2_3117/net6 RESET VDD VDD pmos W=0.41u L=0.04u
M2418 AND2_3117/net6 n1162 VDD VDD pmos W=0.41u L=0.04u
M2419 WX9046 AND2_3116/net6 VSS VSS nmos W=0.31u L=0.04u
M2420 AND2_3116/X_u2-net6 RESET VSS VSS nmos W=0.31u L=0.04u
M2421 AND2_3116/net6 n1163 AND2_3116/X_u2-net6 VSS nmos W=0.31u L=0.04u
M2422 WX9046 AND2_3116/net6 VDD VDD pmos W=0.41u L=0.04u
M2423 AND2_3116/net6 RESET VDD VDD pmos W=0.41u L=0.04u
M2424 AND2_3116/net6 n1163 VDD VDD pmos W=0.41u L=0.04u
M2425 WX9044 AND2_3115/net6 VSS VSS nmos W=0.31u L=0.04u
M2426 AND2_3115/X_u2-net6 RESET VSS VSS nmos W=0.31u L=0.04u
M2427 AND2_3115/net6 n1164 AND2_3115/X_u2-net6 VSS nmos W=0.31u L=0.04u
M2428 WX9044 AND2_3115/net6 VDD VDD pmos W=0.41u L=0.04u
M2429 AND2_3115/net6 RESET VDD VDD pmos W=0.41u L=0.04u
M2430 AND2_3115/net6 n1164 VDD VDD pmos W=0.41u L=0.04u
M2431 WX9042 AND2_3114/net6 VSS VSS nmos W=0.31u L=0.04u
M2432 AND2_3114/X_u2-net6 RESET VSS VSS nmos W=0.31u L=0.04u
M2433 AND2_3114/net6 n1165 AND2_3114/X_u2-net6 VSS nmos W=0.31u L=0.04u
M2434 WX9042 AND2_3114/net6 VDD VDD pmos W=0.41u L=0.04u
M2435 AND2_3114/net6 RESET VDD VDD pmos W=0.41u L=0.04u
M2436 AND2_3114/net6 n1165 VDD VDD pmos W=0.41u L=0.04u
M2437 WX9040 AND2_3113/net6 VSS VSS nmos W=0.31u L=0.04u
M2438 AND2_3113/X_u2-net6 RESET VSS VSS nmos W=0.31u L=0.04u
M2439 AND2_3113/net6 n1166 AND2_3113/X_u2-net6 VSS nmos W=0.31u L=0.04u
M2440 WX9040 AND2_3113/net6 VDD VDD pmos W=0.41u L=0.04u
M2441 AND2_3113/net6 RESET VDD VDD pmos W=0.41u L=0.04u
M2442 AND2_3113/net6 n1166 VDD VDD pmos W=0.41u L=0.04u
M2443 WX9038 AND2_3112/net6 VSS VSS nmos W=0.31u L=0.04u
M2444 AND2_3112/X_u2-net6 RESET VSS VSS nmos W=0.31u L=0.04u
M2445 AND2_3112/net6 n1167 AND2_3112/X_u2-net6 VSS nmos W=0.31u L=0.04u
M2446 WX9038 AND2_3112/net6 VDD VDD pmos W=0.41u L=0.04u
M2447 AND2_3112/net6 RESET VDD VDD pmos W=0.41u L=0.04u
M2448 AND2_3112/net6 n1167 VDD VDD pmos W=0.41u L=0.04u
M2449 WX9036 AND2_3111/net6 VSS VSS nmos W=0.31u L=0.04u
M2450 AND2_3111/X_u2-net6 RESET VSS VSS nmos W=0.31u L=0.04u
M2451 AND2_3111/net6 n1168 AND2_3111/X_u2-net6 VSS nmos W=0.31u L=0.04u
M2452 WX9036 AND2_3111/net6 VDD VDD pmos W=0.41u L=0.04u
M2453 AND2_3111/net6 RESET VDD VDD pmos W=0.41u L=0.04u
M2454 AND2_3111/net6 n1168 VDD VDD pmos W=0.41u L=0.04u
M2455 WX9034 AND2_3110/net6 VSS VSS nmos W=0.31u L=0.04u
M2456 AND2_3110/X_u2-net6 RESET VSS VSS nmos W=0.31u L=0.04u
M2457 AND2_3110/net6 n1169 AND2_3110/X_u2-net6 VSS nmos W=0.31u L=0.04u
M2458 WX9034 AND2_3110/net6 VDD VDD pmos W=0.41u L=0.04u
M2459 AND2_3110/net6 RESET VDD VDD pmos W=0.41u L=0.04u
M2460 AND2_3110/net6 n1169 VDD VDD pmos W=0.41u L=0.04u
M2461 WX9032 AND2_3109/net6 VSS VSS nmos W=0.31u L=0.04u
M2462 AND2_3109/X_u2-net6 RESET VSS VSS nmos W=0.31u L=0.04u
M2463 AND2_3109/net6 n1170 AND2_3109/X_u2-net6 VSS nmos W=0.31u L=0.04u
M2464 WX9032 AND2_3109/net6 VDD VDD pmos W=0.41u L=0.04u
M2465 AND2_3109/net6 RESET VDD VDD pmos W=0.41u L=0.04u
M2466 AND2_3109/net6 n1170 VDD VDD pmos W=0.41u L=0.04u
M2467 WX9030 AND2_3108/net6 VSS VSS nmos W=0.31u L=0.04u
M2468 AND2_3108/X_u2-net6 RESET VSS VSS nmos W=0.31u L=0.04u
M2469 AND2_3108/net6 n1171 AND2_3108/X_u2-net6 VSS nmos W=0.31u L=0.04u
M2470 WX9030 AND2_3108/net6 VDD VDD pmos W=0.41u L=0.04u
M2471 AND2_3108/net6 RESET VDD VDD pmos W=0.41u L=0.04u
M2472 AND2_3108/net6 n1171 VDD VDD pmos W=0.41u L=0.04u
M2473 WX9028 AND2_3107/net6 VSS VSS nmos W=0.31u L=0.04u
M2474 AND2_3107/X_u2-net6 RESET VSS VSS nmos W=0.31u L=0.04u
M2475 AND2_3107/net6 n1172 AND2_3107/X_u2-net6 VSS nmos W=0.31u L=0.04u
M2476 WX9028 AND2_3107/net6 VDD VDD pmos W=0.41u L=0.04u
M2477 AND2_3107/net6 RESET VDD VDD pmos W=0.41u L=0.04u
M2478 AND2_3107/net6 n1172 VDD VDD pmos W=0.41u L=0.04u
M2479 WX9026 AND2_3106/net6 VSS VSS nmos W=0.31u L=0.04u
M2480 AND2_3106/X_u2-net6 RESET VSS VSS nmos W=0.31u L=0.04u
M2481 AND2_3106/net6 n1173 AND2_3106/X_u2-net6 VSS nmos W=0.31u L=0.04u
M2482 WX9026 AND2_3106/net6 VDD VDD pmos W=0.41u L=0.04u
M2483 AND2_3106/net6 RESET VDD VDD pmos W=0.41u L=0.04u
M2484 AND2_3106/net6 n1173 VDD VDD pmos W=0.41u L=0.04u
M2485 WX9024 AND2_3105/net6 VSS VSS nmos W=0.31u L=0.04u
M2486 AND2_3105/X_u2-net6 RESET VSS VSS nmos W=0.31u L=0.04u
M2487 AND2_3105/net6 n1174 AND2_3105/X_u2-net6 VSS nmos W=0.31u L=0.04u
M2488 WX9024 AND2_3105/net6 VDD VDD pmos W=0.41u L=0.04u
M2489 AND2_3105/net6 RESET VDD VDD pmos W=0.41u L=0.04u
M2490 AND2_3105/net6 n1174 VDD VDD pmos W=0.41u L=0.04u
M2491 WX9022 AND2_3104/net6 VSS VSS nmos W=0.31u L=0.04u
M2492 AND2_3104/X_u2-net6 RESET VSS VSS nmos W=0.31u L=0.04u
M2493 AND2_3104/net6 n1175 AND2_3104/X_u2-net6 VSS nmos W=0.31u L=0.04u
M2494 WX9022 AND2_3104/net6 VDD VDD pmos W=0.41u L=0.04u
M2495 AND2_3104/net6 RESET VDD VDD pmos W=0.41u L=0.04u
M2496 AND2_3104/net6 n1175 VDD VDD pmos W=0.41u L=0.04u
M2497 WX8656 AND2_3039/net6 VSS VSS nmos W=0.31u L=0.04u
M2498 AND2_3039/X_u2-net6 RESET VSS VSS nmos W=0.31u L=0.04u
M2499 AND2_3039/net6 WX8593 AND2_3039/X_u2-net6 VSS nmos W=0.31u L=0.04u
M2500 WX8656 AND2_3039/net6 VDD VDD pmos W=0.41u L=0.04u
M2501 AND2_3039/net6 RESET VDD VDD pmos W=0.41u L=0.04u
M2502 AND2_3039/net6 WX8593 VDD VDD pmos W=0.41u L=0.04u
M2503 WX8654 AND2_3038/net6 VSS VSS nmos W=0.31u L=0.04u
M2504 AND2_3038/X_u2-net6 RESET VSS VSS nmos W=0.31u L=0.04u
M2505 AND2_3038/net6 WX8591 AND2_3038/X_u2-net6 VSS nmos W=0.31u L=0.04u
M2506 WX8654 AND2_3038/net6 VDD VDD pmos W=0.41u L=0.04u
M2507 AND2_3038/net6 RESET VDD VDD pmos W=0.41u L=0.04u
M2508 AND2_3038/net6 WX8591 VDD VDD pmos W=0.41u L=0.04u
M2509 WX8652 AND2_3037/net6 VSS VSS nmos W=0.31u L=0.04u
M2510 AND2_3037/X_u2-net6 RESET VSS VSS nmos W=0.31u L=0.04u
M2511 AND2_3037/net6 WX8589 AND2_3037/X_u2-net6 VSS nmos W=0.31u L=0.04u
M2512 WX8652 AND2_3037/net6 VDD VDD pmos W=0.41u L=0.04u
M2513 AND2_3037/net6 RESET VDD VDD pmos W=0.41u L=0.04u
M2514 AND2_3037/net6 WX8589 VDD VDD pmos W=0.41u L=0.04u
M2515 WX8650 AND2_3036/net6 VSS VSS nmos W=0.31u L=0.04u
M2516 AND2_3036/X_u2-net6 RESET VSS VSS nmos W=0.31u L=0.04u
M2517 AND2_3036/net6 WX8587 AND2_3036/X_u2-net6 VSS nmos W=0.31u L=0.04u
M2518 WX8650 AND2_3036/net6 VDD VDD pmos W=0.41u L=0.04u
M2519 AND2_3036/net6 RESET VDD VDD pmos W=0.41u L=0.04u
M2520 AND2_3036/net6 WX8587 VDD VDD pmos W=0.41u L=0.04u
M2521 WX8648 AND2_3035/net6 VSS VSS nmos W=0.31u L=0.04u
M2522 AND2_3035/X_u2-net6 RESET VSS VSS nmos W=0.31u L=0.04u
M2523 AND2_3035/net6 WX8585 AND2_3035/X_u2-net6 VSS nmos W=0.31u L=0.04u
M2524 WX8648 AND2_3035/net6 VDD VDD pmos W=0.41u L=0.04u
M2525 AND2_3035/net6 RESET VDD VDD pmos W=0.41u L=0.04u
M2526 AND2_3035/net6 WX8585 VDD VDD pmos W=0.41u L=0.04u
M2527 WX8646 AND2_3034/net6 VSS VSS nmos W=0.31u L=0.04u
M2528 AND2_3034/X_u2-net6 RESET VSS VSS nmos W=0.31u L=0.04u
M2529 AND2_3034/net6 WX8583 AND2_3034/X_u2-net6 VSS nmos W=0.31u L=0.04u
M2530 WX8646 AND2_3034/net6 VDD VDD pmos W=0.41u L=0.04u
M2531 AND2_3034/net6 RESET VDD VDD pmos W=0.41u L=0.04u
M2532 AND2_3034/net6 WX8583 VDD VDD pmos W=0.41u L=0.04u
M2533 WX8644 AND2_3033/net6 VSS VSS nmos W=0.31u L=0.04u
M2534 AND2_3033/X_u2-net6 RESET VSS VSS nmos W=0.31u L=0.04u
M2535 AND2_3033/net6 WX8581 AND2_3033/X_u2-net6 VSS nmos W=0.31u L=0.04u
M2536 WX8644 AND2_3033/net6 VDD VDD pmos W=0.41u L=0.04u
M2537 AND2_3033/net6 RESET VDD VDD pmos W=0.41u L=0.04u
M2538 AND2_3033/net6 WX8581 VDD VDD pmos W=0.41u L=0.04u
M2539 WX8642 AND2_3032/net6 VSS VSS nmos W=0.31u L=0.04u
M2540 AND2_3032/X_u2-net6 RESET VSS VSS nmos W=0.31u L=0.04u
M2541 AND2_3032/net6 WX8579 AND2_3032/X_u2-net6 VSS nmos W=0.31u L=0.04u
M2542 WX8642 AND2_3032/net6 VDD VDD pmos W=0.41u L=0.04u
M2543 AND2_3032/net6 RESET VDD VDD pmos W=0.41u L=0.04u
M2544 AND2_3032/net6 WX8579 VDD VDD pmos W=0.41u L=0.04u
M2545 WX8640 AND2_3031/net6 VSS VSS nmos W=0.31u L=0.04u
M2546 AND2_3031/X_u2-net6 RESET VSS VSS nmos W=0.31u L=0.04u
M2547 AND2_3031/net6 WX8577 AND2_3031/X_u2-net6 VSS nmos W=0.31u L=0.04u
M2548 WX8640 AND2_3031/net6 VDD VDD pmos W=0.41u L=0.04u
M2549 AND2_3031/net6 RESET VDD VDD pmos W=0.41u L=0.04u
M2550 AND2_3031/net6 WX8577 VDD VDD pmos W=0.41u L=0.04u
M2551 WX8638 AND2_3030/net6 VSS VSS nmos W=0.31u L=0.04u
M2552 AND2_3030/X_u2-net6 RESET VSS VSS nmos W=0.31u L=0.04u
M2553 AND2_3030/net6 WX8575 AND2_3030/X_u2-net6 VSS nmos W=0.31u L=0.04u
M2554 WX8638 AND2_3030/net6 VDD VDD pmos W=0.41u L=0.04u
M2555 AND2_3030/net6 RESET VDD VDD pmos W=0.41u L=0.04u
M2556 AND2_3030/net6 WX8575 VDD VDD pmos W=0.41u L=0.04u
M2557 WX8636 AND2_3029/net6 VSS VSS nmos W=0.31u L=0.04u
M2558 AND2_3029/X_u2-net6 RESET VSS VSS nmos W=0.31u L=0.04u
M2559 AND2_3029/net6 WX8573 AND2_3029/X_u2-net6 VSS nmos W=0.31u L=0.04u
M2560 WX8636 AND2_3029/net6 VDD VDD pmos W=0.41u L=0.04u
M2561 AND2_3029/net6 RESET VDD VDD pmos W=0.41u L=0.04u
M2562 AND2_3029/net6 WX8573 VDD VDD pmos W=0.41u L=0.04u
M2563 WX8634 AND2_3028/net6 VSS VSS nmos W=0.31u L=0.04u
M2564 AND2_3028/X_u2-net6 RESET VSS VSS nmos W=0.31u L=0.04u
M2565 AND2_3028/net6 WX8571 AND2_3028/X_u2-net6 VSS nmos W=0.31u L=0.04u
M2566 WX8634 AND2_3028/net6 VDD VDD pmos W=0.41u L=0.04u
M2567 AND2_3028/net6 RESET VDD VDD pmos W=0.41u L=0.04u
M2568 AND2_3028/net6 WX8571 VDD VDD pmos W=0.41u L=0.04u
M2569 WX8632 AND2_3027/net6 VSS VSS nmos W=0.31u L=0.04u
M2570 AND2_3027/X_u2-net6 RESET VSS VSS nmos W=0.31u L=0.04u
M2571 AND2_3027/net6 WX8569 AND2_3027/X_u2-net6 VSS nmos W=0.31u L=0.04u
M2572 WX8632 AND2_3027/net6 VDD VDD pmos W=0.41u L=0.04u
M2573 AND2_3027/net6 RESET VDD VDD pmos W=0.41u L=0.04u
M2574 AND2_3027/net6 WX8569 VDD VDD pmos W=0.41u L=0.04u
M2575 WX8630 AND2_3026/net6 VSS VSS nmos W=0.31u L=0.04u
M2576 AND2_3026/X_u2-net6 RESET VSS VSS nmos W=0.31u L=0.04u
M2577 AND2_3026/net6 WX8567 AND2_3026/X_u2-net6 VSS nmos W=0.31u L=0.04u
M2578 WX8630 AND2_3026/net6 VDD VDD pmos W=0.41u L=0.04u
M2579 AND2_3026/net6 RESET VDD VDD pmos W=0.41u L=0.04u
M2580 AND2_3026/net6 WX8567 VDD VDD pmos W=0.41u L=0.04u
M2581 WX8628 AND2_3025/net6 VSS VSS nmos W=0.31u L=0.04u
M2582 AND2_3025/X_u2-net6 RESET VSS VSS nmos W=0.31u L=0.04u
M2583 AND2_3025/net6 WX8565 AND2_3025/X_u2-net6 VSS nmos W=0.31u L=0.04u
M2584 WX8628 AND2_3025/net6 VDD VDD pmos W=0.41u L=0.04u
M2585 AND2_3025/net6 RESET VDD VDD pmos W=0.41u L=0.04u
M2586 AND2_3025/net6 WX8565 VDD VDD pmos W=0.41u L=0.04u
M2587 WX8626 AND2_3024/net6 VSS VSS nmos W=0.31u L=0.04u
M2588 AND2_3024/X_u2-net6 RESET VSS VSS nmos W=0.31u L=0.04u
M2589 AND2_3024/net6 WX8563 AND2_3024/X_u2-net6 VSS nmos W=0.31u L=0.04u
M2590 WX8626 AND2_3024/net6 VDD VDD pmos W=0.41u L=0.04u
M2591 AND2_3024/net6 RESET VDD VDD pmos W=0.41u L=0.04u
M2592 AND2_3024/net6 WX8563 VDD VDD pmos W=0.41u L=0.04u
M2593 WX8624 AND2_3023/net6 VSS VSS nmos W=0.31u L=0.04u
M2594 AND2_3023/X_u2-net6 RESET VSS VSS nmos W=0.31u L=0.04u
M2595 AND2_3023/net6 WX8561 AND2_3023/X_u2-net6 VSS nmos W=0.31u L=0.04u
M2596 WX8624 AND2_3023/net6 VDD VDD pmos W=0.41u L=0.04u
M2597 AND2_3023/net6 RESET VDD VDD pmos W=0.41u L=0.04u
M2598 AND2_3023/net6 WX8561 VDD VDD pmos W=0.41u L=0.04u
M2599 WX8622 AND2_3022/net6 VSS VSS nmos W=0.31u L=0.04u
M2600 AND2_3022/X_u2-net6 RESET VSS VSS nmos W=0.31u L=0.04u
M2601 AND2_3022/net6 WX8559 AND2_3022/X_u2-net6 VSS nmos W=0.31u L=0.04u
M2602 WX8622 AND2_3022/net6 VDD VDD pmos W=0.41u L=0.04u
M2603 AND2_3022/net6 RESET VDD VDD pmos W=0.41u L=0.04u
M2604 AND2_3022/net6 WX8559 VDD VDD pmos W=0.41u L=0.04u
M2605 WX8620 AND2_3021/net6 VSS VSS nmos W=0.31u L=0.04u
M2606 AND2_3021/X_u2-net6 RESET VSS VSS nmos W=0.31u L=0.04u
M2607 AND2_3021/net6 WX8557 AND2_3021/X_u2-net6 VSS nmos W=0.31u L=0.04u
M2608 WX8620 AND2_3021/net6 VDD VDD pmos W=0.41u L=0.04u
M2609 AND2_3021/net6 RESET VDD VDD pmos W=0.41u L=0.04u
M2610 AND2_3021/net6 WX8557 VDD VDD pmos W=0.41u L=0.04u
M2611 WX8618 AND2_3020/net6 VSS VSS nmos W=0.31u L=0.04u
M2612 AND2_3020/X_u2-net6 RESET VSS VSS nmos W=0.31u L=0.04u
M2613 AND2_3020/net6 WX8555 AND2_3020/X_u2-net6 VSS nmos W=0.31u L=0.04u
M2614 WX8618 AND2_3020/net6 VDD VDD pmos W=0.41u L=0.04u
M2615 AND2_3020/net6 RESET VDD VDD pmos W=0.41u L=0.04u
M2616 AND2_3020/net6 WX8555 VDD VDD pmos W=0.41u L=0.04u
M2617 WX8616 AND2_3019/net6 VSS VSS nmos W=0.31u L=0.04u
M2618 AND2_3019/X_u2-net6 RESET VSS VSS nmos W=0.31u L=0.04u
M2619 AND2_3019/net6 WX8553 AND2_3019/X_u2-net6 VSS nmos W=0.31u L=0.04u
M2620 WX8616 AND2_3019/net6 VDD VDD pmos W=0.41u L=0.04u
M2621 AND2_3019/net6 RESET VDD VDD pmos W=0.41u L=0.04u
M2622 AND2_3019/net6 WX8553 VDD VDD pmos W=0.41u L=0.04u
M2623 WX8614 AND2_3018/net6 VSS VSS nmos W=0.31u L=0.04u
M2624 AND2_3018/X_u2-net6 RESET VSS VSS nmos W=0.31u L=0.04u
M2625 AND2_3018/net6 WX8551 AND2_3018/X_u2-net6 VSS nmos W=0.31u L=0.04u
M2626 WX8614 AND2_3018/net6 VDD VDD pmos W=0.41u L=0.04u
M2627 AND2_3018/net6 RESET VDD VDD pmos W=0.41u L=0.04u
M2628 AND2_3018/net6 WX8551 VDD VDD pmos W=0.41u L=0.04u
M2629 WX8612 AND2_3017/net6 VSS VSS nmos W=0.31u L=0.04u
M2630 AND2_3017/X_u2-net6 RESET VSS VSS nmos W=0.31u L=0.04u
M2631 AND2_3017/net6 WX8549 AND2_3017/X_u2-net6 VSS nmos W=0.31u L=0.04u
M2632 WX8612 AND2_3017/net6 VDD VDD pmos W=0.41u L=0.04u
M2633 AND2_3017/net6 RESET VDD VDD pmos W=0.41u L=0.04u
M2634 AND2_3017/net6 WX8549 VDD VDD pmos W=0.41u L=0.04u
M2635 WX8610 AND2_3016/net6 VSS VSS nmos W=0.31u L=0.04u
M2636 AND2_3016/X_u2-net6 RESET VSS VSS nmos W=0.31u L=0.04u
M2637 AND2_3016/net6 WX8547 AND2_3016/X_u2-net6 VSS nmos W=0.31u L=0.04u
M2638 WX8610 AND2_3016/net6 VDD VDD pmos W=0.41u L=0.04u
M2639 AND2_3016/net6 RESET VDD VDD pmos W=0.41u L=0.04u
M2640 AND2_3016/net6 WX8547 VDD VDD pmos W=0.41u L=0.04u
M2641 WX8608 AND2_3015/net6 VSS VSS nmos W=0.31u L=0.04u
M2642 AND2_3015/X_u2-net6 RESET VSS VSS nmos W=0.31u L=0.04u
M2643 AND2_3015/net6 WX8545 AND2_3015/X_u2-net6 VSS nmos W=0.31u L=0.04u
M2644 WX8608 AND2_3015/net6 VDD VDD pmos W=0.41u L=0.04u
M2645 AND2_3015/net6 RESET VDD VDD pmos W=0.41u L=0.04u
M2646 AND2_3015/net6 WX8545 VDD VDD pmos W=0.41u L=0.04u
M2647 WX8606 AND2_3014/net6 VSS VSS nmos W=0.31u L=0.04u
M2648 AND2_3014/X_u2-net6 RESET VSS VSS nmos W=0.31u L=0.04u
M2649 AND2_3014/net6 WX8543 AND2_3014/X_u2-net6 VSS nmos W=0.31u L=0.04u
M2650 WX8606 AND2_3014/net6 VDD VDD pmos W=0.41u L=0.04u
M2651 AND2_3014/net6 RESET VDD VDD pmos W=0.41u L=0.04u
M2652 AND2_3014/net6 WX8543 VDD VDD pmos W=0.41u L=0.04u
M2653 WX8604 AND2_3013/net6 VSS VSS nmos W=0.31u L=0.04u
M2654 AND2_3013/X_u2-net6 RESET VSS VSS nmos W=0.31u L=0.04u
M2655 AND2_3013/net6 WX8541 AND2_3013/X_u2-net6 VSS nmos W=0.31u L=0.04u
M2656 WX8604 AND2_3013/net6 VDD VDD pmos W=0.41u L=0.04u
M2657 AND2_3013/net6 RESET VDD VDD pmos W=0.41u L=0.04u
M2658 AND2_3013/net6 WX8541 VDD VDD pmos W=0.41u L=0.04u
M2659 WX8602 AND2_3012/net6 VSS VSS nmos W=0.31u L=0.04u
M2660 AND2_3012/X_u2-net6 RESET VSS VSS nmos W=0.31u L=0.04u
M2661 AND2_3012/net6 WX8539 AND2_3012/X_u2-net6 VSS nmos W=0.31u L=0.04u
M2662 WX8602 AND2_3012/net6 VDD VDD pmos W=0.41u L=0.04u
M2663 AND2_3012/net6 RESET VDD VDD pmos W=0.41u L=0.04u
M2664 AND2_3012/net6 WX8539 VDD VDD pmos W=0.41u L=0.04u
M2665 WX8600 AND2_3011/net6 VSS VSS nmos W=0.31u L=0.04u
M2666 AND2_3011/X_u2-net6 RESET VSS VSS nmos W=0.31u L=0.04u
M2667 AND2_3011/net6 WX8537 AND2_3011/X_u2-net6 VSS nmos W=0.31u L=0.04u
M2668 WX8600 AND2_3011/net6 VDD VDD pmos W=0.41u L=0.04u
M2669 AND2_3011/net6 RESET VDD VDD pmos W=0.41u L=0.04u
M2670 AND2_3011/net6 WX8537 VDD VDD pmos W=0.41u L=0.04u
M2671 WX8598 AND2_3010/net6 VSS VSS nmos W=0.31u L=0.04u
M2672 AND2_3010/X_u2-net6 RESET VSS VSS nmos W=0.31u L=0.04u
M2673 AND2_3010/net6 WX8535 AND2_3010/X_u2-net6 VSS nmos W=0.31u L=0.04u
M2674 WX8598 AND2_3010/net6 VDD VDD pmos W=0.41u L=0.04u
M2675 AND2_3010/net6 RESET VDD VDD pmos W=0.41u L=0.04u
M2676 AND2_3010/net6 WX8535 VDD VDD pmos W=0.41u L=0.04u
M2677 WX8596 AND2_3009/net6 VSS VSS nmos W=0.31u L=0.04u
M2678 AND2_3009/X_u2-net6 RESET VSS VSS nmos W=0.31u L=0.04u
M2679 AND2_3009/net6 WX8533 AND2_3009/X_u2-net6 VSS nmos W=0.31u L=0.04u
M2680 WX8596 AND2_3009/net6 VDD VDD pmos W=0.41u L=0.04u
M2681 AND2_3009/net6 RESET VDD VDD pmos W=0.41u L=0.04u
M2682 AND2_3009/net6 WX8533 VDD VDD pmos W=0.41u L=0.04u
M2683 WX8594 AND2_3008/net6 VSS VSS nmos W=0.31u L=0.04u
M2684 AND2_3008/X_u2-net6 RESET VSS VSS nmos W=0.31u L=0.04u
M2685 AND2_3008/net6 WX8531 AND2_3008/X_u2-net6 VSS nmos W=0.31u L=0.04u
M2686 WX8594 AND2_3008/net6 VDD VDD pmos W=0.41u L=0.04u
M2687 AND2_3008/net6 RESET VDD VDD pmos W=0.41u L=0.04u
M2688 AND2_3008/net6 WX8531 VDD VDD pmos W=0.41u L=0.04u
M2689 WX8592 AND2_3007/net6 VSS VSS nmos W=0.31u L=0.04u
M2690 AND2_3007/X_u2-net6 RESET VSS VSS nmos W=0.31u L=0.04u
M2691 AND2_3007/net6 WX8529 AND2_3007/X_u2-net6 VSS nmos W=0.31u L=0.04u
M2692 WX8592 AND2_3007/net6 VDD VDD pmos W=0.41u L=0.04u
M2693 AND2_3007/net6 RESET VDD VDD pmos W=0.41u L=0.04u
M2694 AND2_3007/net6 WX8529 VDD VDD pmos W=0.41u L=0.04u
M2695 WX8590 AND2_3006/net6 VSS VSS nmos W=0.31u L=0.04u
M2696 AND2_3006/X_u2-net6 RESET VSS VSS nmos W=0.31u L=0.04u
M2697 AND2_3006/net6 WX8527 AND2_3006/X_u2-net6 VSS nmos W=0.31u L=0.04u
M2698 WX8590 AND2_3006/net6 VDD VDD pmos W=0.41u L=0.04u
M2699 AND2_3006/net6 RESET VDD VDD pmos W=0.41u L=0.04u
M2700 AND2_3006/net6 WX8527 VDD VDD pmos W=0.41u L=0.04u
M2701 WX8588 AND2_3005/net6 VSS VSS nmos W=0.31u L=0.04u
M2702 AND2_3005/X_u2-net6 RESET VSS VSS nmos W=0.31u L=0.04u
M2703 AND2_3005/net6 WX8525 AND2_3005/X_u2-net6 VSS nmos W=0.31u L=0.04u
M2704 WX8588 AND2_3005/net6 VDD VDD pmos W=0.41u L=0.04u
M2705 AND2_3005/net6 RESET VDD VDD pmos W=0.41u L=0.04u
M2706 AND2_3005/net6 WX8525 VDD VDD pmos W=0.41u L=0.04u
M2707 WX8586 AND2_3004/net6 VSS VSS nmos W=0.31u L=0.04u
M2708 AND2_3004/X_u2-net6 RESET VSS VSS nmos W=0.31u L=0.04u
M2709 AND2_3004/net6 WX8523 AND2_3004/X_u2-net6 VSS nmos W=0.31u L=0.04u
M2710 WX8586 AND2_3004/net6 VDD VDD pmos W=0.41u L=0.04u
M2711 AND2_3004/net6 RESET VDD VDD pmos W=0.41u L=0.04u
M2712 AND2_3004/net6 WX8523 VDD VDD pmos W=0.41u L=0.04u
M2713 WX8584 AND2_3003/net6 VSS VSS nmos W=0.31u L=0.04u
M2714 AND2_3003/X_u2-net6 RESET VSS VSS nmos W=0.31u L=0.04u
M2715 AND2_3003/net6 WX8521 AND2_3003/X_u2-net6 VSS nmos W=0.31u L=0.04u
M2716 WX8584 AND2_3003/net6 VDD VDD pmos W=0.41u L=0.04u
M2717 AND2_3003/net6 RESET VDD VDD pmos W=0.41u L=0.04u
M2718 AND2_3003/net6 WX8521 VDD VDD pmos W=0.41u L=0.04u
M2719 WX8582 AND2_3002/net6 VSS VSS nmos W=0.31u L=0.04u
M2720 AND2_3002/X_u2-net6 RESET VSS VSS nmos W=0.31u L=0.04u
M2721 AND2_3002/net6 WX8519 AND2_3002/X_u2-net6 VSS nmos W=0.31u L=0.04u
M2722 WX8582 AND2_3002/net6 VDD VDD pmos W=0.41u L=0.04u
M2723 AND2_3002/net6 RESET VDD VDD pmos W=0.41u L=0.04u
M2724 AND2_3002/net6 WX8519 VDD VDD pmos W=0.41u L=0.04u
M2725 WX8580 AND2_3001/net6 VSS VSS nmos W=0.31u L=0.04u
M2726 AND2_3001/X_u2-net6 RESET VSS VSS nmos W=0.31u L=0.04u
M2727 AND2_3001/net6 WX8517 AND2_3001/X_u2-net6 VSS nmos W=0.31u L=0.04u
M2728 WX8580 AND2_3001/net6 VDD VDD pmos W=0.41u L=0.04u
M2729 AND2_3001/net6 RESET VDD VDD pmos W=0.41u L=0.04u
M2730 AND2_3001/net6 WX8517 VDD VDD pmos W=0.41u L=0.04u
M2731 WX8578 AND2_3000/net6 VSS VSS nmos W=0.31u L=0.04u
M2732 AND2_3000/X_u2-net6 RESET VSS VSS nmos W=0.31u L=0.04u
M2733 AND2_3000/net6 WX8515 AND2_3000/X_u2-net6 VSS nmos W=0.31u L=0.04u
M2734 WX8578 AND2_3000/net6 VDD VDD pmos W=0.41u L=0.04u
M2735 AND2_3000/net6 RESET VDD VDD pmos W=0.41u L=0.04u
M2736 AND2_3000/net6 WX8515 VDD VDD pmos W=0.41u L=0.04u
M2737 WX8576 AND2_2999/net6 VSS VSS nmos W=0.31u L=0.04u
M2738 AND2_2999/X_u2-net6 RESET VSS VSS nmos W=0.31u L=0.04u
M2739 AND2_2999/net6 WX8513 AND2_2999/X_u2-net6 VSS nmos W=0.31u L=0.04u
M2740 WX8576 AND2_2999/net6 VDD VDD pmos W=0.41u L=0.04u
M2741 AND2_2999/net6 RESET VDD VDD pmos W=0.41u L=0.04u
M2742 AND2_2999/net6 WX8513 VDD VDD pmos W=0.41u L=0.04u
M2743 WX8574 AND2_2998/net6 VSS VSS nmos W=0.31u L=0.04u
M2744 AND2_2998/X_u2-net6 RESET VSS VSS nmos W=0.31u L=0.04u
M2745 AND2_2998/net6 WX8511 AND2_2998/X_u2-net6 VSS nmos W=0.31u L=0.04u
M2746 WX8574 AND2_2998/net6 VDD VDD pmos W=0.41u L=0.04u
M2747 AND2_2998/net6 RESET VDD VDD pmos W=0.41u L=0.04u
M2748 AND2_2998/net6 WX8511 VDD VDD pmos W=0.41u L=0.04u
M2749 WX8572 AND2_2997/net6 VSS VSS nmos W=0.31u L=0.04u
M2750 AND2_2997/X_u2-net6 RESET VSS VSS nmos W=0.31u L=0.04u
M2751 AND2_2997/net6 WX8509 AND2_2997/X_u2-net6 VSS nmos W=0.31u L=0.04u
M2752 WX8572 AND2_2997/net6 VDD VDD pmos W=0.41u L=0.04u
M2753 AND2_2997/net6 RESET VDD VDD pmos W=0.41u L=0.04u
M2754 AND2_2997/net6 WX8509 VDD VDD pmos W=0.41u L=0.04u
M2755 WX8570 AND2_2996/net6 VSS VSS nmos W=0.31u L=0.04u
M2756 AND2_2996/X_u2-net6 RESET VSS VSS nmos W=0.31u L=0.04u
M2757 AND2_2996/net6 WX8507 AND2_2996/X_u2-net6 VSS nmos W=0.31u L=0.04u
M2758 WX8570 AND2_2996/net6 VDD VDD pmos W=0.41u L=0.04u
M2759 AND2_2996/net6 RESET VDD VDD pmos W=0.41u L=0.04u
M2760 AND2_2996/net6 WX8507 VDD VDD pmos W=0.41u L=0.04u
M2761 WX8568 AND2_2995/net6 VSS VSS nmos W=0.31u L=0.04u
M2762 AND2_2995/X_u2-net6 RESET VSS VSS nmos W=0.31u L=0.04u
M2763 AND2_2995/net6 WX8505 AND2_2995/X_u2-net6 VSS nmos W=0.31u L=0.04u
M2764 WX8568 AND2_2995/net6 VDD VDD pmos W=0.41u L=0.04u
M2765 AND2_2995/net6 RESET VDD VDD pmos W=0.41u L=0.04u
M2766 AND2_2995/net6 WX8505 VDD VDD pmos W=0.41u L=0.04u
M2767 WX8566 AND2_2994/net6 VSS VSS nmos W=0.31u L=0.04u
M2768 AND2_2994/X_u2-net6 RESET VSS VSS nmos W=0.31u L=0.04u
M2769 AND2_2994/net6 WX8503 AND2_2994/X_u2-net6 VSS nmos W=0.31u L=0.04u
M2770 WX8566 AND2_2994/net6 VDD VDD pmos W=0.41u L=0.04u
M2771 AND2_2994/net6 RESET VDD VDD pmos W=0.41u L=0.04u
M2772 AND2_2994/net6 WX8503 VDD VDD pmos W=0.41u L=0.04u
M2773 WX8564 AND2_2993/net6 VSS VSS nmos W=0.31u L=0.04u
M2774 AND2_2993/X_u2-net6 RESET VSS VSS nmos W=0.31u L=0.04u
M2775 AND2_2993/net6 WX8501 AND2_2993/X_u2-net6 VSS nmos W=0.31u L=0.04u
M2776 WX8564 AND2_2993/net6 VDD VDD pmos W=0.41u L=0.04u
M2777 AND2_2993/net6 RESET VDD VDD pmos W=0.41u L=0.04u
M2778 AND2_2993/net6 WX8501 VDD VDD pmos W=0.41u L=0.04u
M2779 WX8562 AND2_2992/net6 VSS VSS nmos W=0.31u L=0.04u
M2780 AND2_2992/X_u2-net6 RESET VSS VSS nmos W=0.31u L=0.04u
M2781 AND2_2992/net6 WX8499 AND2_2992/X_u2-net6 VSS nmos W=0.31u L=0.04u
M2782 WX8562 AND2_2992/net6 VDD VDD pmos W=0.41u L=0.04u
M2783 AND2_2992/net6 RESET VDD VDD pmos W=0.41u L=0.04u
M2784 AND2_2992/net6 WX8499 VDD VDD pmos W=0.41u L=0.04u
M2785 WX8560 AND2_2991/net6 VSS VSS nmos W=0.31u L=0.04u
M2786 AND2_2991/X_u2-net6 RESET VSS VSS nmos W=0.31u L=0.04u
M2787 AND2_2991/net6 WX8497 AND2_2991/X_u2-net6 VSS nmos W=0.31u L=0.04u
M2788 WX8560 AND2_2991/net6 VDD VDD pmos W=0.41u L=0.04u
M2789 AND2_2991/net6 RESET VDD VDD pmos W=0.41u L=0.04u
M2790 AND2_2991/net6 WX8497 VDD VDD pmos W=0.41u L=0.04u
M2791 WX8558 AND2_2990/net6 VSS VSS nmos W=0.31u L=0.04u
M2792 AND2_2990/X_u2-net6 RESET VSS VSS nmos W=0.31u L=0.04u
M2793 AND2_2990/net6 WX8495 AND2_2990/X_u2-net6 VSS nmos W=0.31u L=0.04u
M2794 WX8558 AND2_2990/net6 VDD VDD pmos W=0.41u L=0.04u
M2795 AND2_2990/net6 RESET VDD VDD pmos W=0.41u L=0.04u
M2796 AND2_2990/net6 WX8495 VDD VDD pmos W=0.41u L=0.04u
M2797 WX8556 AND2_2989/net6 VSS VSS nmos W=0.31u L=0.04u
M2798 AND2_2989/X_u2-net6 RESET VSS VSS nmos W=0.31u L=0.04u
M2799 AND2_2989/net6 WX8493 AND2_2989/X_u2-net6 VSS nmos W=0.31u L=0.04u
M2800 WX8556 AND2_2989/net6 VDD VDD pmos W=0.41u L=0.04u
M2801 AND2_2989/net6 RESET VDD VDD pmos W=0.41u L=0.04u
M2802 AND2_2989/net6 WX8493 VDD VDD pmos W=0.41u L=0.04u
M2803 WX8554 AND2_2988/net6 VSS VSS nmos W=0.31u L=0.04u
M2804 AND2_2988/X_u2-net6 RESET VSS VSS nmos W=0.31u L=0.04u
M2805 AND2_2988/net6 WX8491 AND2_2988/X_u2-net6 VSS nmos W=0.31u L=0.04u
M2806 WX8554 AND2_2988/net6 VDD VDD pmos W=0.41u L=0.04u
M2807 AND2_2988/net6 RESET VDD VDD pmos W=0.41u L=0.04u
M2808 AND2_2988/net6 WX8491 VDD VDD pmos W=0.41u L=0.04u
M2809 WX8552 AND2_2987/net6 VSS VSS nmos W=0.31u L=0.04u
M2810 AND2_2987/X_u2-net6 RESET VSS VSS nmos W=0.31u L=0.04u
M2811 AND2_2987/net6 WX8489 AND2_2987/X_u2-net6 VSS nmos W=0.31u L=0.04u
M2812 WX8552 AND2_2987/net6 VDD VDD pmos W=0.41u L=0.04u
M2813 AND2_2987/net6 RESET VDD VDD pmos W=0.41u L=0.04u
M2814 AND2_2987/net6 WX8489 VDD VDD pmos W=0.41u L=0.04u
M2815 WX8550 AND2_2986/net6 VSS VSS nmos W=0.31u L=0.04u
M2816 AND2_2986/X_u2-net6 RESET VSS VSS nmos W=0.31u L=0.04u
M2817 AND2_2986/net6 WX8487 AND2_2986/X_u2-net6 VSS nmos W=0.31u L=0.04u
M2818 WX8550 AND2_2986/net6 VDD VDD pmos W=0.41u L=0.04u
M2819 AND2_2986/net6 RESET VDD VDD pmos W=0.41u L=0.04u
M2820 AND2_2986/net6 WX8487 VDD VDD pmos W=0.41u L=0.04u
M2821 WX8548 AND2_2985/net6 VSS VSS nmos W=0.31u L=0.04u
M2822 AND2_2985/X_u2-net6 RESET VSS VSS nmos W=0.31u L=0.04u
M2823 AND2_2985/net6 WX8485 AND2_2985/X_u2-net6 VSS nmos W=0.31u L=0.04u
M2824 WX8548 AND2_2985/net6 VDD VDD pmos W=0.41u L=0.04u
M2825 AND2_2985/net6 RESET VDD VDD pmos W=0.41u L=0.04u
M2826 AND2_2985/net6 WX8485 VDD VDD pmos W=0.41u L=0.04u
M2827 WX8546 AND2_2984/net6 VSS VSS nmos W=0.31u L=0.04u
M2828 AND2_2984/X_u2-net6 RESET VSS VSS nmos W=0.31u L=0.04u
M2829 AND2_2984/net6 WX8483 AND2_2984/X_u2-net6 VSS nmos W=0.31u L=0.04u
M2830 WX8546 AND2_2984/net6 VDD VDD pmos W=0.41u L=0.04u
M2831 AND2_2984/net6 RESET VDD VDD pmos W=0.41u L=0.04u
M2832 AND2_2984/net6 WX8483 VDD VDD pmos W=0.41u L=0.04u
M2833 WX8544 AND2_2983/net6 VSS VSS nmos W=0.31u L=0.04u
M2834 AND2_2983/X_u2-net6 RESET VSS VSS nmos W=0.31u L=0.04u
M2835 AND2_2983/net6 WX8481 AND2_2983/X_u2-net6 VSS nmos W=0.31u L=0.04u
M2836 WX8544 AND2_2983/net6 VDD VDD pmos W=0.41u L=0.04u
M2837 AND2_2983/net6 RESET VDD VDD pmos W=0.41u L=0.04u
M2838 AND2_2983/net6 WX8481 VDD VDD pmos W=0.41u L=0.04u
M2839 WX8542 AND2_2982/net6 VSS VSS nmos W=0.31u L=0.04u
M2840 AND2_2982/X_u2-net6 RESET VSS VSS nmos W=0.31u L=0.04u
M2841 AND2_2982/net6 WX8479 AND2_2982/X_u2-net6 VSS nmos W=0.31u L=0.04u
M2842 WX8542 AND2_2982/net6 VDD VDD pmos W=0.41u L=0.04u
M2843 AND2_2982/net6 RESET VDD VDD pmos W=0.41u L=0.04u
M2844 AND2_2982/net6 WX8479 VDD VDD pmos W=0.41u L=0.04u
M2845 WX8540 AND2_2981/net6 VSS VSS nmos W=0.31u L=0.04u
M2846 AND2_2981/X_u2-net6 RESET VSS VSS nmos W=0.31u L=0.04u
M2847 AND2_2981/net6 WX8477 AND2_2981/X_u2-net6 VSS nmos W=0.31u L=0.04u
M2848 WX8540 AND2_2981/net6 VDD VDD pmos W=0.41u L=0.04u
M2849 AND2_2981/net6 RESET VDD VDD pmos W=0.41u L=0.04u
M2850 AND2_2981/net6 WX8477 VDD VDD pmos W=0.41u L=0.04u
M2851 WX8538 AND2_2980/net6 VSS VSS nmos W=0.31u L=0.04u
M2852 AND2_2980/X_u2-net6 RESET VSS VSS nmos W=0.31u L=0.04u
M2853 AND2_2980/net6 WX8475 AND2_2980/X_u2-net6 VSS nmos W=0.31u L=0.04u
M2854 WX8538 AND2_2980/net6 VDD VDD pmos W=0.41u L=0.04u
M2855 AND2_2980/net6 RESET VDD VDD pmos W=0.41u L=0.04u
M2856 AND2_2980/net6 WX8475 VDD VDD pmos W=0.41u L=0.04u
M2857 WX8536 AND2_2979/net6 VSS VSS nmos W=0.31u L=0.04u
M2858 AND2_2979/X_u2-net6 RESET VSS VSS nmos W=0.31u L=0.04u
M2859 AND2_2979/net6 WX8473 AND2_2979/X_u2-net6 VSS nmos W=0.31u L=0.04u
M2860 WX8536 AND2_2979/net6 VDD VDD pmos W=0.41u L=0.04u
M2861 AND2_2979/net6 RESET VDD VDD pmos W=0.41u L=0.04u
M2862 AND2_2979/net6 WX8473 VDD VDD pmos W=0.41u L=0.04u
M2863 WX8534 AND2_2978/net6 VSS VSS nmos W=0.31u L=0.04u
M2864 AND2_2978/X_u2-net6 RESET VSS VSS nmos W=0.31u L=0.04u
M2865 AND2_2978/net6 WX8471 AND2_2978/X_u2-net6 VSS nmos W=0.31u L=0.04u
M2866 WX8534 AND2_2978/net6 VDD VDD pmos W=0.41u L=0.04u
M2867 AND2_2978/net6 RESET VDD VDD pmos W=0.41u L=0.04u
M2868 AND2_2978/net6 WX8471 VDD VDD pmos W=0.41u L=0.04u
M2869 WX8532 AND2_2977/net6 VSS VSS nmos W=0.31u L=0.04u
M2870 AND2_2977/X_u2-net6 RESET VSS VSS nmos W=0.31u L=0.04u
M2871 AND2_2977/net6 WX8469 AND2_2977/X_u2-net6 VSS nmos W=0.31u L=0.04u
M2872 WX8532 AND2_2977/net6 VDD VDD pmos W=0.41u L=0.04u
M2873 AND2_2977/net6 RESET VDD VDD pmos W=0.41u L=0.04u
M2874 AND2_2977/net6 WX8469 VDD VDD pmos W=0.41u L=0.04u
M2875 WX8530 AND2_2976/net6 VSS VSS nmos W=0.31u L=0.04u
M2876 AND2_2976/X_u2-net6 RESET VSS VSS nmos W=0.31u L=0.04u
M2877 AND2_2976/net6 WX8467 AND2_2976/X_u2-net6 VSS nmos W=0.31u L=0.04u
M2878 WX8530 AND2_2976/net6 VDD VDD pmos W=0.41u L=0.04u
M2879 AND2_2976/net6 RESET VDD VDD pmos W=0.41u L=0.04u
M2880 AND2_2976/net6 WX8467 VDD VDD pmos W=0.41u L=0.04u
M2881 WX8528 AND2_2975/net6 VSS VSS nmos W=0.31u L=0.04u
M2882 AND2_2975/X_u2-net6 RESET VSS VSS nmos W=0.31u L=0.04u
M2883 AND2_2975/net6 WX8465 AND2_2975/X_u2-net6 VSS nmos W=0.31u L=0.04u
M2884 WX8528 AND2_2975/net6 VDD VDD pmos W=0.41u L=0.04u
M2885 AND2_2975/net6 RESET VDD VDD pmos W=0.41u L=0.04u
M2886 AND2_2975/net6 WX8465 VDD VDD pmos W=0.41u L=0.04u
M2887 WX8526 AND2_2974/net6 VSS VSS nmos W=0.31u L=0.04u
M2888 AND2_2974/X_u2-net6 RESET VSS VSS nmos W=0.31u L=0.04u
M2889 AND2_2974/net6 WX8463 AND2_2974/X_u2-net6 VSS nmos W=0.31u L=0.04u
M2890 WX8526 AND2_2974/net6 VDD VDD pmos W=0.41u L=0.04u
M2891 AND2_2974/net6 RESET VDD VDD pmos W=0.41u L=0.04u
M2892 AND2_2974/net6 WX8463 VDD VDD pmos W=0.41u L=0.04u
M2893 WX8524 AND2_2973/net6 VSS VSS nmos W=0.31u L=0.04u
M2894 AND2_2973/X_u2-net6 RESET VSS VSS nmos W=0.31u L=0.04u
M2895 AND2_2973/net6 WX8461 AND2_2973/X_u2-net6 VSS nmos W=0.31u L=0.04u
M2896 WX8524 AND2_2973/net6 VDD VDD pmos W=0.41u L=0.04u
M2897 AND2_2973/net6 RESET VDD VDD pmos W=0.41u L=0.04u
M2898 AND2_2973/net6 WX8461 VDD VDD pmos W=0.41u L=0.04u
M2899 WX8522 AND2_2972/net6 VSS VSS nmos W=0.31u L=0.04u
M2900 AND2_2972/X_u2-net6 RESET VSS VSS nmos W=0.31u L=0.04u
M2901 AND2_2972/net6 WX8459 AND2_2972/X_u2-net6 VSS nmos W=0.31u L=0.04u
M2902 WX8522 AND2_2972/net6 VDD VDD pmos W=0.41u L=0.04u
M2903 AND2_2972/net6 RESET VDD VDD pmos W=0.41u L=0.04u
M2904 AND2_2972/net6 WX8459 VDD VDD pmos W=0.41u L=0.04u
M2905 WX8520 AND2_2971/net6 VSS VSS nmos W=0.31u L=0.04u
M2906 AND2_2971/X_u2-net6 RESET VSS VSS nmos W=0.31u L=0.04u
M2907 AND2_2971/net6 WX8457 AND2_2971/X_u2-net6 VSS nmos W=0.31u L=0.04u
M2908 WX8520 AND2_2971/net6 VDD VDD pmos W=0.41u L=0.04u
M2909 AND2_2971/net6 RESET VDD VDD pmos W=0.41u L=0.04u
M2910 AND2_2971/net6 WX8457 VDD VDD pmos W=0.41u L=0.04u
M2911 WX8518 AND2_2970/net6 VSS VSS nmos W=0.31u L=0.04u
M2912 AND2_2970/X_u2-net6 RESET VSS VSS nmos W=0.31u L=0.04u
M2913 AND2_2970/net6 WX8455 AND2_2970/X_u2-net6 VSS nmos W=0.31u L=0.04u
M2914 WX8518 AND2_2970/net6 VDD VDD pmos W=0.41u L=0.04u
M2915 AND2_2970/net6 RESET VDD VDD pmos W=0.41u L=0.04u
M2916 AND2_2970/net6 WX8455 VDD VDD pmos W=0.41u L=0.04u
M2917 WX8516 AND2_2969/net6 VSS VSS nmos W=0.31u L=0.04u
M2918 AND2_2969/X_u2-net6 RESET VSS VSS nmos W=0.31u L=0.04u
M2919 AND2_2969/net6 WX8453 AND2_2969/X_u2-net6 VSS nmos W=0.31u L=0.04u
M2920 WX8516 AND2_2969/net6 VDD VDD pmos W=0.41u L=0.04u
M2921 AND2_2969/net6 RESET VDD VDD pmos W=0.41u L=0.04u
M2922 AND2_2969/net6 WX8453 VDD VDD pmos W=0.41u L=0.04u
M2923 WX8514 AND2_2968/net6 VSS VSS nmos W=0.31u L=0.04u
M2924 AND2_2968/X_u2-net6 RESET VSS VSS nmos W=0.31u L=0.04u
M2925 AND2_2968/net6 WX8451 AND2_2968/X_u2-net6 VSS nmos W=0.31u L=0.04u
M2926 WX8514 AND2_2968/net6 VDD VDD pmos W=0.41u L=0.04u
M2927 AND2_2968/net6 RESET VDD VDD pmos W=0.41u L=0.04u
M2928 AND2_2968/net6 WX8451 VDD VDD pmos W=0.41u L=0.04u
M2929 WX8512 AND2_2967/net6 VSS VSS nmos W=0.31u L=0.04u
M2930 AND2_2967/X_u2-net6 RESET VSS VSS nmos W=0.31u L=0.04u
M2931 AND2_2967/net6 WX8449 AND2_2967/X_u2-net6 VSS nmos W=0.31u L=0.04u
M2932 WX8512 AND2_2967/net6 VDD VDD pmos W=0.41u L=0.04u
M2933 AND2_2967/net6 RESET VDD VDD pmos W=0.41u L=0.04u
M2934 AND2_2967/net6 WX8449 VDD VDD pmos W=0.41u L=0.04u
M2935 WX8510 AND2_2966/net6 VSS VSS nmos W=0.31u L=0.04u
M2936 AND2_2966/X_u2-net6 RESET VSS VSS nmos W=0.31u L=0.04u
M2937 AND2_2966/net6 WX8447 AND2_2966/X_u2-net6 VSS nmos W=0.31u L=0.04u
M2938 WX8510 AND2_2966/net6 VDD VDD pmos W=0.41u L=0.04u
M2939 AND2_2966/net6 RESET VDD VDD pmos W=0.41u L=0.04u
M2940 AND2_2966/net6 WX8447 VDD VDD pmos W=0.41u L=0.04u
M2941 WX8508 AND2_2965/net6 VSS VSS nmos W=0.31u L=0.04u
M2942 AND2_2965/X_u2-net6 RESET VSS VSS nmos W=0.31u L=0.04u
M2943 AND2_2965/net6 WX8445 AND2_2965/X_u2-net6 VSS nmos W=0.31u L=0.04u
M2944 WX8508 AND2_2965/net6 VDD VDD pmos W=0.41u L=0.04u
M2945 AND2_2965/net6 RESET VDD VDD pmos W=0.41u L=0.04u
M2946 AND2_2965/net6 WX8445 VDD VDD pmos W=0.41u L=0.04u
M2947 WX8506 AND2_2964/net6 VSS VSS nmos W=0.31u L=0.04u
M2948 AND2_2964/X_u2-net6 RESET VSS VSS nmos W=0.31u L=0.04u
M2949 AND2_2964/net6 WX8443 AND2_2964/X_u2-net6 VSS nmos W=0.31u L=0.04u
M2950 WX8506 AND2_2964/net6 VDD VDD pmos W=0.41u L=0.04u
M2951 AND2_2964/net6 RESET VDD VDD pmos W=0.41u L=0.04u
M2952 AND2_2964/net6 WX8443 VDD VDD pmos W=0.41u L=0.04u
M2953 WX8504 AND2_2963/net6 VSS VSS nmos W=0.31u L=0.04u
M2954 AND2_2963/X_u2-net6 RESET VSS VSS nmos W=0.31u L=0.04u
M2955 AND2_2963/net6 WX8441 AND2_2963/X_u2-net6 VSS nmos W=0.31u L=0.04u
M2956 WX8504 AND2_2963/net6 VDD VDD pmos W=0.41u L=0.04u
M2957 AND2_2963/net6 RESET VDD VDD pmos W=0.41u L=0.04u
M2958 AND2_2963/net6 WX8441 VDD VDD pmos W=0.41u L=0.04u
M2959 WX8502 AND2_2962/net6 VSS VSS nmos W=0.31u L=0.04u
M2960 AND2_2962/X_u2-net6 RESET VSS VSS nmos W=0.31u L=0.04u
M2961 AND2_2962/net6 WX8439 AND2_2962/X_u2-net6 VSS nmos W=0.31u L=0.04u
M2962 WX8502 AND2_2962/net6 VDD VDD pmos W=0.41u L=0.04u
M2963 AND2_2962/net6 RESET VDD VDD pmos W=0.41u L=0.04u
M2964 AND2_2962/net6 WX8439 VDD VDD pmos W=0.41u L=0.04u
M2965 WX8500 AND2_2961/net6 VSS VSS nmos W=0.31u L=0.04u
M2966 AND2_2961/X_u2-net6 RESET VSS VSS nmos W=0.31u L=0.04u
M2967 AND2_2961/net6 WX8437 AND2_2961/X_u2-net6 VSS nmos W=0.31u L=0.04u
M2968 WX8500 AND2_2961/net6 VDD VDD pmos W=0.41u L=0.04u
M2969 AND2_2961/net6 RESET VDD VDD pmos W=0.41u L=0.04u
M2970 AND2_2961/net6 WX8437 VDD VDD pmos W=0.41u L=0.04u
M2971 WX8498 AND2_2960/net6 VSS VSS nmos W=0.31u L=0.04u
M2972 AND2_2960/X_u2-net6 RESET VSS VSS nmos W=0.31u L=0.04u
M2973 AND2_2960/net6 WX8435 AND2_2960/X_u2-net6 VSS nmos W=0.31u L=0.04u
M2974 WX8498 AND2_2960/net6 VDD VDD pmos W=0.41u L=0.04u
M2975 AND2_2960/net6 RESET VDD VDD pmos W=0.41u L=0.04u
M2976 AND2_2960/net6 WX8435 VDD VDD pmos W=0.41u L=0.04u
M2977 WX8496 AND2_2959/net6 VSS VSS nmos W=0.31u L=0.04u
M2978 AND2_2959/X_u2-net6 RESET VSS VSS nmos W=0.31u L=0.04u
M2979 AND2_2959/net6 WX8433 AND2_2959/X_u2-net6 VSS nmos W=0.31u L=0.04u
M2980 WX8496 AND2_2959/net6 VDD VDD pmos W=0.41u L=0.04u
M2981 AND2_2959/net6 RESET VDD VDD pmos W=0.41u L=0.04u
M2982 AND2_2959/net6 WX8433 VDD VDD pmos W=0.41u L=0.04u
M2983 WX8494 AND2_2958/net6 VSS VSS nmos W=0.31u L=0.04u
M2984 AND2_2958/X_u2-net6 RESET VSS VSS nmos W=0.31u L=0.04u
M2985 AND2_2958/net6 WX8431 AND2_2958/X_u2-net6 VSS nmos W=0.31u L=0.04u
M2986 WX8494 AND2_2958/net6 VDD VDD pmos W=0.41u L=0.04u
M2987 AND2_2958/net6 RESET VDD VDD pmos W=0.41u L=0.04u
M2988 AND2_2958/net6 WX8431 VDD VDD pmos W=0.41u L=0.04u
M2989 WX8492 AND2_2957/net6 VSS VSS nmos W=0.31u L=0.04u
M2990 AND2_2957/X_u2-net6 RESET VSS VSS nmos W=0.31u L=0.04u
M2991 AND2_2957/net6 WX8429 AND2_2957/X_u2-net6 VSS nmos W=0.31u L=0.04u
M2992 WX8492 AND2_2957/net6 VDD VDD pmos W=0.41u L=0.04u
M2993 AND2_2957/net6 RESET VDD VDD pmos W=0.41u L=0.04u
M2994 AND2_2957/net6 WX8429 VDD VDD pmos W=0.41u L=0.04u
M2995 WX8490 AND2_2956/net6 VSS VSS nmos W=0.31u L=0.04u
M2996 AND2_2956/X_u2-net6 RESET VSS VSS nmos W=0.31u L=0.04u
M2997 AND2_2956/net6 WX8427 AND2_2956/X_u2-net6 VSS nmos W=0.31u L=0.04u
M2998 WX8490 AND2_2956/net6 VDD VDD pmos W=0.41u L=0.04u
M2999 AND2_2956/net6 RESET VDD VDD pmos W=0.41u L=0.04u
M3000 AND2_2956/net6 WX8427 VDD VDD pmos W=0.41u L=0.04u
M3001 WX8488 AND2_2955/net6 VSS VSS nmos W=0.31u L=0.04u
M3002 AND2_2955/X_u2-net6 RESET VSS VSS nmos W=0.31u L=0.04u
M3003 AND2_2955/net6 WX8425 AND2_2955/X_u2-net6 VSS nmos W=0.31u L=0.04u
M3004 WX8488 AND2_2955/net6 VDD VDD pmos W=0.41u L=0.04u
M3005 AND2_2955/net6 RESET VDD VDD pmos W=0.41u L=0.04u
M3006 AND2_2955/net6 WX8425 VDD VDD pmos W=0.41u L=0.04u
M3007 WX8486 AND2_2954/net6 VSS VSS nmos W=0.31u L=0.04u
M3008 AND2_2954/X_u2-net6 RESET VSS VSS nmos W=0.31u L=0.04u
M3009 AND2_2954/net6 WX8423 AND2_2954/X_u2-net6 VSS nmos W=0.31u L=0.04u
M3010 WX8486 AND2_2954/net6 VDD VDD pmos W=0.41u L=0.04u
M3011 AND2_2954/net6 RESET VDD VDD pmos W=0.41u L=0.04u
M3012 AND2_2954/net6 WX8423 VDD VDD pmos W=0.41u L=0.04u
M3013 WX8484 AND2_2953/net6 VSS VSS nmos W=0.31u L=0.04u
M3014 AND2_2953/X_u2-net6 RESET VSS VSS nmos W=0.31u L=0.04u
M3015 AND2_2953/net6 WX8421 AND2_2953/X_u2-net6 VSS nmos W=0.31u L=0.04u
M3016 WX8484 AND2_2953/net6 VDD VDD pmos W=0.41u L=0.04u
M3017 AND2_2953/net6 RESET VDD VDD pmos W=0.41u L=0.04u
M3018 AND2_2953/net6 WX8421 VDD VDD pmos W=0.41u L=0.04u
M3019 WX8482 AND2_2952/net6 VSS VSS nmos W=0.31u L=0.04u
M3020 AND2_2952/X_u2-net6 RESET VSS VSS nmos W=0.31u L=0.04u
M3021 AND2_2952/net6 WX8419 AND2_2952/X_u2-net6 VSS nmos W=0.31u L=0.04u
M3022 WX8482 AND2_2952/net6 VDD VDD pmos W=0.41u L=0.04u
M3023 AND2_2952/net6 RESET VDD VDD pmos W=0.41u L=0.04u
M3024 AND2_2952/net6 WX8419 VDD VDD pmos W=0.41u L=0.04u
M3025 WX8480 AND2_2951/net6 VSS VSS nmos W=0.31u L=0.04u
M3026 AND2_2951/X_u2-net6 RESET VSS VSS nmos W=0.31u L=0.04u
M3027 AND2_2951/net6 WX8417 AND2_2951/X_u2-net6 VSS nmos W=0.31u L=0.04u
M3028 WX8480 AND2_2951/net6 VDD VDD pmos W=0.41u L=0.04u
M3029 AND2_2951/net6 RESET VDD VDD pmos W=0.41u L=0.04u
M3030 AND2_2951/net6 WX8417 VDD VDD pmos W=0.41u L=0.04u
M3031 WX8478 AND2_2950/net6 VSS VSS nmos W=0.31u L=0.04u
M3032 AND2_2950/X_u2-net6 RESET VSS VSS nmos W=0.31u L=0.04u
M3033 AND2_2950/net6 WX8415 AND2_2950/X_u2-net6 VSS nmos W=0.31u L=0.04u
M3034 WX8478 AND2_2950/net6 VDD VDD pmos W=0.41u L=0.04u
M3035 AND2_2950/net6 RESET VDD VDD pmos W=0.41u L=0.04u
M3036 AND2_2950/net6 WX8415 VDD VDD pmos W=0.41u L=0.04u
M3037 WX8476 AND2_2949/net6 VSS VSS nmos W=0.31u L=0.04u
M3038 AND2_2949/X_u2-net6 RESET VSS VSS nmos W=0.31u L=0.04u
M3039 AND2_2949/net6 WX8413 AND2_2949/X_u2-net6 VSS nmos W=0.31u L=0.04u
M3040 WX8476 AND2_2949/net6 VDD VDD pmos W=0.41u L=0.04u
M3041 AND2_2949/net6 RESET VDD VDD pmos W=0.41u L=0.04u
M3042 AND2_2949/net6 WX8413 VDD VDD pmos W=0.41u L=0.04u
M3043 WX8474 AND2_2948/net6 VSS VSS nmos W=0.31u L=0.04u
M3044 AND2_2948/X_u2-net6 RESET VSS VSS nmos W=0.31u L=0.04u
M3045 AND2_2948/net6 WX8411 AND2_2948/X_u2-net6 VSS nmos W=0.31u L=0.04u
M3046 WX8474 AND2_2948/net6 VDD VDD pmos W=0.41u L=0.04u
M3047 AND2_2948/net6 RESET VDD VDD pmos W=0.41u L=0.04u
M3048 AND2_2948/net6 WX8411 VDD VDD pmos W=0.41u L=0.04u
M3049 WX8472 AND2_2947/net6 VSS VSS nmos W=0.31u L=0.04u
M3050 AND2_2947/X_u2-net6 RESET VSS VSS nmos W=0.31u L=0.04u
M3051 AND2_2947/net6 WX8409 AND2_2947/X_u2-net6 VSS nmos W=0.31u L=0.04u
M3052 WX8472 AND2_2947/net6 VDD VDD pmos W=0.41u L=0.04u
M3053 AND2_2947/net6 RESET VDD VDD pmos W=0.41u L=0.04u
M3054 AND2_2947/net6 WX8409 VDD VDD pmos W=0.41u L=0.04u
M3055 WX8470 AND2_2946/net6 VSS VSS nmos W=0.31u L=0.04u
M3056 AND2_2946/X_u2-net6 RESET VSS VSS nmos W=0.31u L=0.04u
M3057 AND2_2946/net6 WX8407 AND2_2946/X_u2-net6 VSS nmos W=0.31u L=0.04u
M3058 WX8470 AND2_2946/net6 VDD VDD pmos W=0.41u L=0.04u
M3059 AND2_2946/net6 RESET VDD VDD pmos W=0.41u L=0.04u
M3060 AND2_2946/net6 WX8407 VDD VDD pmos W=0.41u L=0.04u
M3061 WX8468 AND2_2945/net6 VSS VSS nmos W=0.31u L=0.04u
M3062 AND2_2945/X_u2-net6 RESET VSS VSS nmos W=0.31u L=0.04u
M3063 AND2_2945/net6 WX8405 AND2_2945/X_u2-net6 VSS nmos W=0.31u L=0.04u
M3064 WX8468 AND2_2945/net6 VDD VDD pmos W=0.41u L=0.04u
M3065 AND2_2945/net6 RESET VDD VDD pmos W=0.41u L=0.04u
M3066 AND2_2945/net6 WX8405 VDD VDD pmos W=0.41u L=0.04u
M3067 WX8466 AND2_2944/net6 VSS VSS nmos W=0.31u L=0.04u
M3068 AND2_2944/X_u2-net6 RESET VSS VSS nmos W=0.31u L=0.04u
M3069 AND2_2944/net6 WX8403 AND2_2944/X_u2-net6 VSS nmos W=0.31u L=0.04u
M3070 WX8466 AND2_2944/net6 VDD VDD pmos W=0.41u L=0.04u
M3071 AND2_2944/net6 RESET VDD VDD pmos W=0.41u L=0.04u
M3072 AND2_2944/net6 WX8403 VDD VDD pmos W=0.41u L=0.04u
M3073 WX8464 AND2_2943/net6 VSS VSS nmos W=0.31u L=0.04u
M3074 AND2_2943/X_u2-net6 RESET VSS VSS nmos W=0.31u L=0.04u
M3075 AND2_2943/net6 WX8230 AND2_2943/X_u2-net6 VSS nmos W=0.31u L=0.04u
M3076 WX8464 AND2_2943/net6 VDD VDD pmos W=0.41u L=0.04u
M3077 AND2_2943/net6 RESET VDD VDD pmos W=0.41u L=0.04u
M3078 AND2_2943/net6 WX8230 VDD VDD pmos W=0.41u L=0.04u
M3079 WX8462 AND2_2942/net6 VSS VSS nmos W=0.31u L=0.04u
M3080 AND2_2942/X_u2-net6 RESET VSS VSS nmos W=0.31u L=0.04u
M3081 AND2_2942/net6 WX8216 AND2_2942/X_u2-net6 VSS nmos W=0.31u L=0.04u
M3082 WX8462 AND2_2942/net6 VDD VDD pmos W=0.41u L=0.04u
M3083 AND2_2942/net6 RESET VDD VDD pmos W=0.41u L=0.04u
M3084 AND2_2942/net6 WX8216 VDD VDD pmos W=0.41u L=0.04u
M3085 WX8460 AND2_2941/net6 VSS VSS nmos W=0.31u L=0.04u
M3086 AND2_2941/X_u2-net6 RESET VSS VSS nmos W=0.31u L=0.04u
M3087 AND2_2941/net6 WX8202 AND2_2941/X_u2-net6 VSS nmos W=0.31u L=0.04u
M3088 WX8460 AND2_2941/net6 VDD VDD pmos W=0.41u L=0.04u
M3089 AND2_2941/net6 RESET VDD VDD pmos W=0.41u L=0.04u
M3090 AND2_2941/net6 WX8202 VDD VDD pmos W=0.41u L=0.04u
M3091 WX8458 AND2_2940/net6 VSS VSS nmos W=0.31u L=0.04u
M3092 AND2_2940/X_u2-net6 RESET VSS VSS nmos W=0.31u L=0.04u
M3093 AND2_2940/net6 WX8188 AND2_2940/X_u2-net6 VSS nmos W=0.31u L=0.04u
M3094 WX8458 AND2_2940/net6 VDD VDD pmos W=0.41u L=0.04u
M3095 AND2_2940/net6 RESET VDD VDD pmos W=0.41u L=0.04u
M3096 AND2_2940/net6 WX8188 VDD VDD pmos W=0.41u L=0.04u
M3097 WX8456 AND2_2939/net6 VSS VSS nmos W=0.31u L=0.04u
M3098 AND2_2939/X_u2-net6 RESET VSS VSS nmos W=0.31u L=0.04u
M3099 AND2_2939/net6 WX8174 AND2_2939/X_u2-net6 VSS nmos W=0.31u L=0.04u
M3100 WX8456 AND2_2939/net6 VDD VDD pmos W=0.41u L=0.04u
M3101 AND2_2939/net6 RESET VDD VDD pmos W=0.41u L=0.04u
M3102 AND2_2939/net6 WX8174 VDD VDD pmos W=0.41u L=0.04u
M3103 WX8454 AND2_2938/net6 VSS VSS nmos W=0.31u L=0.04u
M3104 AND2_2938/X_u2-net6 RESET VSS VSS nmos W=0.31u L=0.04u
M3105 AND2_2938/net6 WX8160 AND2_2938/X_u2-net6 VSS nmos W=0.31u L=0.04u
M3106 WX8454 AND2_2938/net6 VDD VDD pmos W=0.41u L=0.04u
M3107 AND2_2938/net6 RESET VDD VDD pmos W=0.41u L=0.04u
M3108 AND2_2938/net6 WX8160 VDD VDD pmos W=0.41u L=0.04u
M3109 WX8452 AND2_2937/net6 VSS VSS nmos W=0.31u L=0.04u
M3110 AND2_2937/X_u2-net6 RESET VSS VSS nmos W=0.31u L=0.04u
M3111 AND2_2937/net6 WX8146 AND2_2937/X_u2-net6 VSS nmos W=0.31u L=0.04u
M3112 WX8452 AND2_2937/net6 VDD VDD pmos W=0.41u L=0.04u
M3113 AND2_2937/net6 RESET VDD VDD pmos W=0.41u L=0.04u
M3114 AND2_2937/net6 WX8146 VDD VDD pmos W=0.41u L=0.04u
M3115 WX8450 AND2_2936/net6 VSS VSS nmos W=0.31u L=0.04u
M3116 AND2_2936/X_u2-net6 RESET VSS VSS nmos W=0.31u L=0.04u
M3117 AND2_2936/net6 WX8132 AND2_2936/X_u2-net6 VSS nmos W=0.31u L=0.04u
M3118 WX8450 AND2_2936/net6 VDD VDD pmos W=0.41u L=0.04u
M3119 AND2_2936/net6 RESET VDD VDD pmos W=0.41u L=0.04u
M3120 AND2_2936/net6 WX8132 VDD VDD pmos W=0.41u L=0.04u
M3121 WX8448 AND2_2935/net6 VSS VSS nmos W=0.31u L=0.04u
M3122 AND2_2935/X_u2-net6 RESET VSS VSS nmos W=0.31u L=0.04u
M3123 AND2_2935/net6 WX8118 AND2_2935/X_u2-net6 VSS nmos W=0.31u L=0.04u
M3124 WX8448 AND2_2935/net6 VDD VDD pmos W=0.41u L=0.04u
M3125 AND2_2935/net6 RESET VDD VDD pmos W=0.41u L=0.04u
M3126 AND2_2935/net6 WX8118 VDD VDD pmos W=0.41u L=0.04u
M3127 WX8446 AND2_2934/net6 VSS VSS nmos W=0.31u L=0.04u
M3128 AND2_2934/X_u2-net6 RESET VSS VSS nmos W=0.31u L=0.04u
M3129 AND2_2934/net6 WX8104 AND2_2934/X_u2-net6 VSS nmos W=0.31u L=0.04u
M3130 WX8446 AND2_2934/net6 VDD VDD pmos W=0.41u L=0.04u
M3131 AND2_2934/net6 RESET VDD VDD pmos W=0.41u L=0.04u
M3132 AND2_2934/net6 WX8104 VDD VDD pmos W=0.41u L=0.04u
M3133 WX8444 AND2_2933/net6 VSS VSS nmos W=0.31u L=0.04u
M3134 AND2_2933/X_u2-net6 RESET VSS VSS nmos W=0.31u L=0.04u
M3135 AND2_2933/net6 WX8090 AND2_2933/X_u2-net6 VSS nmos W=0.31u L=0.04u
M3136 WX8444 AND2_2933/net6 VDD VDD pmos W=0.41u L=0.04u
M3137 AND2_2933/net6 RESET VDD VDD pmos W=0.41u L=0.04u
M3138 AND2_2933/net6 WX8090 VDD VDD pmos W=0.41u L=0.04u
M3139 WX8442 AND2_2932/net6 VSS VSS nmos W=0.31u L=0.04u
M3140 AND2_2932/X_u2-net6 RESET VSS VSS nmos W=0.31u L=0.04u
M3141 AND2_2932/net6 WX8076 AND2_2932/X_u2-net6 VSS nmos W=0.31u L=0.04u
M3142 WX8442 AND2_2932/net6 VDD VDD pmos W=0.41u L=0.04u
M3143 AND2_2932/net6 RESET VDD VDD pmos W=0.41u L=0.04u
M3144 AND2_2932/net6 WX8076 VDD VDD pmos W=0.41u L=0.04u
M3145 WX8440 AND2_2931/net6 VSS VSS nmos W=0.31u L=0.04u
M3146 AND2_2931/X_u2-net6 RESET VSS VSS nmos W=0.31u L=0.04u
M3147 AND2_2931/net6 WX8062 AND2_2931/X_u2-net6 VSS nmos W=0.31u L=0.04u
M3148 WX8440 AND2_2931/net6 VDD VDD pmos W=0.41u L=0.04u
M3149 AND2_2931/net6 RESET VDD VDD pmos W=0.41u L=0.04u
M3150 AND2_2931/net6 WX8062 VDD VDD pmos W=0.41u L=0.04u
M3151 WX8438 AND2_2930/net6 VSS VSS nmos W=0.31u L=0.04u
M3152 AND2_2930/X_u2-net6 RESET VSS VSS nmos W=0.31u L=0.04u
M3153 AND2_2930/net6 WX8048 AND2_2930/X_u2-net6 VSS nmos W=0.31u L=0.04u
M3154 WX8438 AND2_2930/net6 VDD VDD pmos W=0.41u L=0.04u
M3155 AND2_2930/net6 RESET VDD VDD pmos W=0.41u L=0.04u
M3156 AND2_2930/net6 WX8048 VDD VDD pmos W=0.41u L=0.04u
M3157 WX8436 AND2_2929/net6 VSS VSS nmos W=0.31u L=0.04u
M3158 AND2_2929/X_u2-net6 RESET VSS VSS nmos W=0.31u L=0.04u
M3159 AND2_2929/net6 WX8034 AND2_2929/X_u2-net6 VSS nmos W=0.31u L=0.04u
M3160 WX8436 AND2_2929/net6 VDD VDD pmos W=0.41u L=0.04u
M3161 AND2_2929/net6 RESET VDD VDD pmos W=0.41u L=0.04u
M3162 AND2_2929/net6 WX8034 VDD VDD pmos W=0.41u L=0.04u
M3163 WX8434 AND2_2928/net6 VSS VSS nmos W=0.31u L=0.04u
M3164 AND2_2928/X_u2-net6 RESET VSS VSS nmos W=0.31u L=0.04u
M3165 AND2_2928/net6 WX8020 AND2_2928/X_u2-net6 VSS nmos W=0.31u L=0.04u
M3166 WX8434 AND2_2928/net6 VDD VDD pmos W=0.41u L=0.04u
M3167 AND2_2928/net6 RESET VDD VDD pmos W=0.41u L=0.04u
M3168 AND2_2928/net6 WX8020 VDD VDD pmos W=0.41u L=0.04u
M3169 WX8432 AND2_2927/net6 VSS VSS nmos W=0.31u L=0.04u
M3170 AND2_2927/X_u2-net6 RESET VSS VSS nmos W=0.31u L=0.04u
M3171 AND2_2927/net6 WX8006 AND2_2927/X_u2-net6 VSS nmos W=0.31u L=0.04u
M3172 WX8432 AND2_2927/net6 VDD VDD pmos W=0.41u L=0.04u
M3173 AND2_2927/net6 RESET VDD VDD pmos W=0.41u L=0.04u
M3174 AND2_2927/net6 WX8006 VDD VDD pmos W=0.41u L=0.04u
M3175 WX8430 AND2_2926/net6 VSS VSS nmos W=0.31u L=0.04u
M3176 AND2_2926/X_u2-net6 RESET VSS VSS nmos W=0.31u L=0.04u
M3177 AND2_2926/net6 WX7992 AND2_2926/X_u2-net6 VSS nmos W=0.31u L=0.04u
M3178 WX8430 AND2_2926/net6 VDD VDD pmos W=0.41u L=0.04u
M3179 AND2_2926/net6 RESET VDD VDD pmos W=0.41u L=0.04u
M3180 AND2_2926/net6 WX7992 VDD VDD pmos W=0.41u L=0.04u
M3181 WX8428 AND2_2925/net6 VSS VSS nmos W=0.31u L=0.04u
M3182 AND2_2925/X_u2-net6 RESET VSS VSS nmos W=0.31u L=0.04u
M3183 AND2_2925/net6 WX7978 AND2_2925/X_u2-net6 VSS nmos W=0.31u L=0.04u
M3184 WX8428 AND2_2925/net6 VDD VDD pmos W=0.41u L=0.04u
M3185 AND2_2925/net6 RESET VDD VDD pmos W=0.41u L=0.04u
M3186 AND2_2925/net6 WX7978 VDD VDD pmos W=0.41u L=0.04u
M3187 WX8426 AND2_2924/net6 VSS VSS nmos W=0.31u L=0.04u
M3188 AND2_2924/X_u2-net6 RESET VSS VSS nmos W=0.31u L=0.04u
M3189 AND2_2924/net6 WX7964 AND2_2924/X_u2-net6 VSS nmos W=0.31u L=0.04u
M3190 WX8426 AND2_2924/net6 VDD VDD pmos W=0.41u L=0.04u
M3191 AND2_2924/net6 RESET VDD VDD pmos W=0.41u L=0.04u
M3192 AND2_2924/net6 WX7964 VDD VDD pmos W=0.41u L=0.04u
M3193 WX8424 AND2_2923/net6 VSS VSS nmos W=0.31u L=0.04u
M3194 AND2_2923/X_u2-net6 RESET VSS VSS nmos W=0.31u L=0.04u
M3195 AND2_2923/net6 WX7950 AND2_2923/X_u2-net6 VSS nmos W=0.31u L=0.04u
M3196 WX8424 AND2_2923/net6 VDD VDD pmos W=0.41u L=0.04u
M3197 AND2_2923/net6 RESET VDD VDD pmos W=0.41u L=0.04u
M3198 AND2_2923/net6 WX7950 VDD VDD pmos W=0.41u L=0.04u
M3199 WX8422 AND2_2922/net6 VSS VSS nmos W=0.31u L=0.04u
M3200 AND2_2922/X_u2-net6 RESET VSS VSS nmos W=0.31u L=0.04u
M3201 AND2_2922/net6 WX7936 AND2_2922/X_u2-net6 VSS nmos W=0.31u L=0.04u
M3202 WX8422 AND2_2922/net6 VDD VDD pmos W=0.41u L=0.04u
M3203 AND2_2922/net6 RESET VDD VDD pmos W=0.41u L=0.04u
M3204 AND2_2922/net6 WX7936 VDD VDD pmos W=0.41u L=0.04u
M3205 WX8420 AND2_2921/net6 VSS VSS nmos W=0.31u L=0.04u
M3206 AND2_2921/X_u2-net6 RESET VSS VSS nmos W=0.31u L=0.04u
M3207 AND2_2921/net6 WX7922 AND2_2921/X_u2-net6 VSS nmos W=0.31u L=0.04u
M3208 WX8420 AND2_2921/net6 VDD VDD pmos W=0.41u L=0.04u
M3209 AND2_2921/net6 RESET VDD VDD pmos W=0.41u L=0.04u
M3210 AND2_2921/net6 WX7922 VDD VDD pmos W=0.41u L=0.04u
M3211 WX8418 AND2_2920/net6 VSS VSS nmos W=0.31u L=0.04u
M3212 AND2_2920/X_u2-net6 RESET VSS VSS nmos W=0.31u L=0.04u
M3213 AND2_2920/net6 WX7908 AND2_2920/X_u2-net6 VSS nmos W=0.31u L=0.04u
M3214 WX8418 AND2_2920/net6 VDD VDD pmos W=0.41u L=0.04u
M3215 AND2_2920/net6 RESET VDD VDD pmos W=0.41u L=0.04u
M3216 AND2_2920/net6 WX7908 VDD VDD pmos W=0.41u L=0.04u
M3217 WX8416 AND2_2919/net6 VSS VSS nmos W=0.31u L=0.04u
M3218 AND2_2919/X_u2-net6 RESET VSS VSS nmos W=0.31u L=0.04u
M3219 AND2_2919/net6 WX7894 AND2_2919/X_u2-net6 VSS nmos W=0.31u L=0.04u
M3220 WX8416 AND2_2919/net6 VDD VDD pmos W=0.41u L=0.04u
M3221 AND2_2919/net6 RESET VDD VDD pmos W=0.41u L=0.04u
M3222 AND2_2919/net6 WX7894 VDD VDD pmos W=0.41u L=0.04u
M3223 WX8414 AND2_2918/net6 VSS VSS nmos W=0.31u L=0.04u
M3224 AND2_2918/X_u2-net6 RESET VSS VSS nmos W=0.31u L=0.04u
M3225 AND2_2918/net6 WX7880 AND2_2918/X_u2-net6 VSS nmos W=0.31u L=0.04u
M3226 WX8414 AND2_2918/net6 VDD VDD pmos W=0.41u L=0.04u
M3227 AND2_2918/net6 RESET VDD VDD pmos W=0.41u L=0.04u
M3228 AND2_2918/net6 WX7880 VDD VDD pmos W=0.41u L=0.04u
M3229 WX8412 AND2_2917/net6 VSS VSS nmos W=0.31u L=0.04u
M3230 AND2_2917/X_u2-net6 RESET VSS VSS nmos W=0.31u L=0.04u
M3231 AND2_2917/net6 WX7866 AND2_2917/X_u2-net6 VSS nmos W=0.31u L=0.04u
M3232 WX8412 AND2_2917/net6 VDD VDD pmos W=0.41u L=0.04u
M3233 AND2_2917/net6 RESET VDD VDD pmos W=0.41u L=0.04u
M3234 AND2_2917/net6 WX7866 VDD VDD pmos W=0.41u L=0.04u
M3235 WX8410 AND2_2916/net6 VSS VSS nmos W=0.31u L=0.04u
M3236 AND2_2916/X_u2-net6 RESET VSS VSS nmos W=0.31u L=0.04u
M3237 AND2_2916/net6 WX7852 AND2_2916/X_u2-net6 VSS nmos W=0.31u L=0.04u
M3238 WX8410 AND2_2916/net6 VDD VDD pmos W=0.41u L=0.04u
M3239 AND2_2916/net6 RESET VDD VDD pmos W=0.41u L=0.04u
M3240 AND2_2916/net6 WX7852 VDD VDD pmos W=0.41u L=0.04u
M3241 WX8408 AND2_2915/net6 VSS VSS nmos W=0.31u L=0.04u
M3242 AND2_2915/X_u2-net6 RESET VSS VSS nmos W=0.31u L=0.04u
M3243 AND2_2915/net6 WX7838 AND2_2915/X_u2-net6 VSS nmos W=0.31u L=0.04u
M3244 WX8408 AND2_2915/net6 VDD VDD pmos W=0.41u L=0.04u
M3245 AND2_2915/net6 RESET VDD VDD pmos W=0.41u L=0.04u
M3246 AND2_2915/net6 WX7838 VDD VDD pmos W=0.41u L=0.04u
M3247 WX8406 AND2_2914/net6 VSS VSS nmos W=0.31u L=0.04u
M3248 AND2_2914/X_u2-net6 RESET VSS VSS nmos W=0.31u L=0.04u
M3249 AND2_2914/net6 WX7824 AND2_2914/X_u2-net6 VSS nmos W=0.31u L=0.04u
M3250 WX8406 AND2_2914/net6 VDD VDD pmos W=0.41u L=0.04u
M3251 AND2_2914/net6 RESET VDD VDD pmos W=0.41u L=0.04u
M3252 AND2_2914/net6 WX7824 VDD VDD pmos W=0.41u L=0.04u
M3253 WX8404 AND2_2913/net6 VSS VSS nmos W=0.31u L=0.04u
M3254 AND2_2913/X_u2-net6 RESET VSS VSS nmos W=0.31u L=0.04u
M3255 AND2_2913/net6 WX7810 AND2_2913/X_u2-net6 VSS nmos W=0.31u L=0.04u
M3256 WX8404 AND2_2913/net6 VDD VDD pmos W=0.41u L=0.04u
M3257 AND2_2913/net6 RESET VDD VDD pmos W=0.41u L=0.04u
M3258 AND2_2913/net6 WX7810 VDD VDD pmos W=0.41u L=0.04u
M3259 WX8402 AND2_2912/net6 VSS VSS nmos W=0.31u L=0.04u
M3260 AND2_2912/X_u2-net6 RESET VSS VSS nmos W=0.31u L=0.04u
M3261 AND2_2912/net6 WX7796 AND2_2912/X_u2-net6 VSS nmos W=0.31u L=0.04u
M3262 WX8402 AND2_2912/net6 VDD VDD pmos W=0.41u L=0.04u
M3263 AND2_2912/net6 RESET VDD VDD pmos W=0.41u L=0.04u
M3264 AND2_2912/net6 WX7796 VDD VDD pmos W=0.41u L=0.04u
M3265 WX8304 AND2_2911/net6 VSS VSS nmos W=0.31u L=0.04u
M3266 AND2_2911/X_u2-net6 RESET VSS VSS nmos W=0.31u L=0.04u
M3267 AND2_2911/net6 WX8241 AND2_2911/X_u2-net6 VSS nmos W=0.31u L=0.04u
M3268 WX8304 AND2_2911/net6 VDD VDD pmos W=0.41u L=0.04u
M3269 AND2_2911/net6 RESET VDD VDD pmos W=0.41u L=0.04u
M3270 AND2_2911/net6 WX8241 VDD VDD pmos W=0.41u L=0.04u
M3271 WX8302 AND2_2910/net6 VSS VSS nmos W=0.31u L=0.04u
M3272 AND2_2910/X_u2-net6 RESET VSS VSS nmos W=0.31u L=0.04u
M3273 AND2_2910/net6 WX8305 AND2_2910/X_u2-net6 VSS nmos W=0.31u L=0.04u
M3274 WX8302 AND2_2910/net6 VDD VDD pmos W=0.41u L=0.04u
M3275 AND2_2910/net6 RESET VDD VDD pmos W=0.41u L=0.04u
M3276 AND2_2910/net6 WX8305 VDD VDD pmos W=0.41u L=0.04u
M3277 WX8300 AND2_2909/net6 VSS VSS nmos W=0.31u L=0.04u
M3278 AND2_2909/X_u2-net6 RESET VSS VSS nmos W=0.31u L=0.04u
M3279 AND2_2909/net6 WX8303 AND2_2909/X_u2-net6 VSS nmos W=0.31u L=0.04u
M3280 WX8300 AND2_2909/net6 VDD VDD pmos W=0.41u L=0.04u
M3281 AND2_2909/net6 RESET VDD VDD pmos W=0.41u L=0.04u
M3282 AND2_2909/net6 WX8303 VDD VDD pmos W=0.41u L=0.04u
M3283 WX8298 AND2_2908/net6 VSS VSS nmos W=0.31u L=0.04u
M3284 AND2_2908/X_u2-net6 RESET VSS VSS nmos W=0.31u L=0.04u
M3285 AND2_2908/net6 WX8301 AND2_2908/X_u2-net6 VSS nmos W=0.31u L=0.04u
M3286 WX8298 AND2_2908/net6 VDD VDD pmos W=0.41u L=0.04u
M3287 AND2_2908/net6 RESET VDD VDD pmos W=0.41u L=0.04u
M3288 AND2_2908/net6 WX8301 VDD VDD pmos W=0.41u L=0.04u
M3289 WX8296 AND2_2907/net6 VSS VSS nmos W=0.31u L=0.04u
M3290 AND2_2907/X_u2-net6 RESET VSS VSS nmos W=0.31u L=0.04u
M3291 AND2_2907/net6 WX8299 AND2_2907/X_u2-net6 VSS nmos W=0.31u L=0.04u
M3292 WX8296 AND2_2907/net6 VDD VDD pmos W=0.41u L=0.04u
M3293 AND2_2907/net6 RESET VDD VDD pmos W=0.41u L=0.04u
M3294 AND2_2907/net6 WX8299 VDD VDD pmos W=0.41u L=0.04u
M3295 WX8294 AND2_2906/net6 VSS VSS nmos W=0.31u L=0.04u
M3296 AND2_2906/X_u2-net6 RESET VSS VSS nmos W=0.31u L=0.04u
M3297 AND2_2906/net6 WX8297 AND2_2906/X_u2-net6 VSS nmos W=0.31u L=0.04u
M3298 WX8294 AND2_2906/net6 VDD VDD pmos W=0.41u L=0.04u
M3299 AND2_2906/net6 RESET VDD VDD pmos W=0.41u L=0.04u
M3300 AND2_2906/net6 WX8297 VDD VDD pmos W=0.41u L=0.04u
M3301 WX8292 AND2_2905/net6 VSS VSS nmos W=0.31u L=0.04u
M3302 AND2_2905/X_u2-net6 RESET VSS VSS nmos W=0.31u L=0.04u
M3303 AND2_2905/net6 WX8295 AND2_2905/X_u2-net6 VSS nmos W=0.31u L=0.04u
M3304 WX8292 AND2_2905/net6 VDD VDD pmos W=0.41u L=0.04u
M3305 AND2_2905/net6 RESET VDD VDD pmos W=0.41u L=0.04u
M3306 AND2_2905/net6 WX8295 VDD VDD pmos W=0.41u L=0.04u
M3307 WX8290 AND2_2904/net6 VSS VSS nmos W=0.31u L=0.04u
M3308 AND2_2904/X_u2-net6 RESET VSS VSS nmos W=0.31u L=0.04u
M3309 AND2_2904/net6 WX8293 AND2_2904/X_u2-net6 VSS nmos W=0.31u L=0.04u
M3310 WX8290 AND2_2904/net6 VDD VDD pmos W=0.41u L=0.04u
M3311 AND2_2904/net6 RESET VDD VDD pmos W=0.41u L=0.04u
M3312 AND2_2904/net6 WX8293 VDD VDD pmos W=0.41u L=0.04u
M3313 WX8288 AND2_2903/net6 VSS VSS nmos W=0.31u L=0.04u
M3314 AND2_2903/X_u2-net6 RESET VSS VSS nmos W=0.31u L=0.04u
M3315 AND2_2903/net6 WX8291 AND2_2903/X_u2-net6 VSS nmos W=0.31u L=0.04u
M3316 WX8288 AND2_2903/net6 VDD VDD pmos W=0.41u L=0.04u
M3317 AND2_2903/net6 RESET VDD VDD pmos W=0.41u L=0.04u
M3318 AND2_2903/net6 WX8291 VDD VDD pmos W=0.41u L=0.04u
M3319 WX8286 AND2_2902/net6 VSS VSS nmos W=0.31u L=0.04u
M3320 AND2_2902/X_u2-net6 RESET VSS VSS nmos W=0.31u L=0.04u
M3321 AND2_2902/net6 WX8289 AND2_2902/X_u2-net6 VSS nmos W=0.31u L=0.04u
M3322 WX8286 AND2_2902/net6 VDD VDD pmos W=0.41u L=0.04u
M3323 AND2_2902/net6 RESET VDD VDD pmos W=0.41u L=0.04u
M3324 AND2_2902/net6 WX8289 VDD VDD pmos W=0.41u L=0.04u
M3325 WX8284 AND2_2901/net6 VSS VSS nmos W=0.31u L=0.04u
M3326 AND2_2901/X_u2-net6 RESET VSS VSS nmos W=0.31u L=0.04u
M3327 AND2_2901/net6 WX8287 AND2_2901/X_u2-net6 VSS nmos W=0.31u L=0.04u
M3328 WX8284 AND2_2901/net6 VDD VDD pmos W=0.41u L=0.04u
M3329 AND2_2901/net6 RESET VDD VDD pmos W=0.41u L=0.04u
M3330 AND2_2901/net6 WX8287 VDD VDD pmos W=0.41u L=0.04u
M3331 WX8282 AND2_2900/net6 VSS VSS nmos W=0.31u L=0.04u
M3332 AND2_2900/X_u2-net6 RESET VSS VSS nmos W=0.31u L=0.04u
M3333 AND2_2900/net6 WX8285 AND2_2900/X_u2-net6 VSS nmos W=0.31u L=0.04u
M3334 WX8282 AND2_2900/net6 VDD VDD pmos W=0.41u L=0.04u
M3335 AND2_2900/net6 RESET VDD VDD pmos W=0.41u L=0.04u
M3336 AND2_2900/net6 WX8285 VDD VDD pmos W=0.41u L=0.04u
M3337 WX8280 AND2_2899/net6 VSS VSS nmos W=0.31u L=0.04u
M3338 AND2_2899/X_u2-net6 RESET VSS VSS nmos W=0.31u L=0.04u
M3339 AND2_2899/net6 WX8283 AND2_2899/X_u2-net6 VSS nmos W=0.31u L=0.04u
M3340 WX8280 AND2_2899/net6 VDD VDD pmos W=0.41u L=0.04u
M3341 AND2_2899/net6 RESET VDD VDD pmos W=0.41u L=0.04u
M3342 AND2_2899/net6 WX8283 VDD VDD pmos W=0.41u L=0.04u
M3343 WX8278 AND2_2898/net6 VSS VSS nmos W=0.31u L=0.04u
M3344 AND2_2898/X_u2-net6 RESET VSS VSS nmos W=0.31u L=0.04u
M3345 AND2_2898/net6 WX8281 AND2_2898/X_u2-net6 VSS nmos W=0.31u L=0.04u
M3346 WX8278 AND2_2898/net6 VDD VDD pmos W=0.41u L=0.04u
M3347 AND2_2898/net6 RESET VDD VDD pmos W=0.41u L=0.04u
M3348 AND2_2898/net6 WX8281 VDD VDD pmos W=0.41u L=0.04u
M3349 WX8276 AND2_2897/net6 VSS VSS nmos W=0.31u L=0.04u
M3350 AND2_2897/X_u2-net6 RESET VSS VSS nmos W=0.31u L=0.04u
M3351 AND2_2897/net6 WX8279 AND2_2897/X_u2-net6 VSS nmos W=0.31u L=0.04u
M3352 WX8276 AND2_2897/net6 VDD VDD pmos W=0.41u L=0.04u
M3353 AND2_2897/net6 RESET VDD VDD pmos W=0.41u L=0.04u
M3354 AND2_2897/net6 WX8279 VDD VDD pmos W=0.41u L=0.04u
M3355 WX8274 AND2_2896/net6 VSS VSS nmos W=0.31u L=0.04u
M3356 AND2_2896/X_u2-net6 RESET VSS VSS nmos W=0.31u L=0.04u
M3357 AND2_2896/net6 WX8277 AND2_2896/X_u2-net6 VSS nmos W=0.31u L=0.04u
M3358 WX8274 AND2_2896/net6 VDD VDD pmos W=0.41u L=0.04u
M3359 AND2_2896/net6 RESET VDD VDD pmos W=0.41u L=0.04u
M3360 AND2_2896/net6 WX8277 VDD VDD pmos W=0.41u L=0.04u
M3361 WX8272 AND2_2895/net6 VSS VSS nmos W=0.31u L=0.04u
M3362 AND2_2895/X_u2-net6 RESET VSS VSS nmos W=0.31u L=0.04u
M3363 AND2_2895/net6 WX8275 AND2_2895/X_u2-net6 VSS nmos W=0.31u L=0.04u
M3364 WX8272 AND2_2895/net6 VDD VDD pmos W=0.41u L=0.04u
M3365 AND2_2895/net6 RESET VDD VDD pmos W=0.41u L=0.04u
M3366 AND2_2895/net6 WX8275 VDD VDD pmos W=0.41u L=0.04u
M3367 WX8270 AND2_2894/net6 VSS VSS nmos W=0.31u L=0.04u
M3368 AND2_2894/X_u2-net6 RESET VSS VSS nmos W=0.31u L=0.04u
M3369 AND2_2894/net6 WX8273 AND2_2894/X_u2-net6 VSS nmos W=0.31u L=0.04u
M3370 WX8270 AND2_2894/net6 VDD VDD pmos W=0.41u L=0.04u
M3371 AND2_2894/net6 RESET VDD VDD pmos W=0.41u L=0.04u
M3372 AND2_2894/net6 WX8273 VDD VDD pmos W=0.41u L=0.04u
M3373 WX8268 AND2_2893/net6 VSS VSS nmos W=0.31u L=0.04u
M3374 AND2_2893/X_u2-net6 RESET VSS VSS nmos W=0.31u L=0.04u
M3375 AND2_2893/net6 WX8271 AND2_2893/X_u2-net6 VSS nmos W=0.31u L=0.04u
M3376 WX8268 AND2_2893/net6 VDD VDD pmos W=0.41u L=0.04u
M3377 AND2_2893/net6 RESET VDD VDD pmos W=0.41u L=0.04u
M3378 AND2_2893/net6 WX8271 VDD VDD pmos W=0.41u L=0.04u
M3379 WX8266 AND2_2892/net6 VSS VSS nmos W=0.31u L=0.04u
M3380 AND2_2892/X_u2-net6 RESET VSS VSS nmos W=0.31u L=0.04u
M3381 AND2_2892/net6 WX8269 AND2_2892/X_u2-net6 VSS nmos W=0.31u L=0.04u
M3382 WX8266 AND2_2892/net6 VDD VDD pmos W=0.41u L=0.04u
M3383 AND2_2892/net6 RESET VDD VDD pmos W=0.41u L=0.04u
M3384 AND2_2892/net6 WX8269 VDD VDD pmos W=0.41u L=0.04u
M3385 WX8264 AND2_2891/net6 VSS VSS nmos W=0.31u L=0.04u
M3386 AND2_2891/X_u2-net6 RESET VSS VSS nmos W=0.31u L=0.04u
M3387 AND2_2891/net6 WX8267 AND2_2891/X_u2-net6 VSS nmos W=0.31u L=0.04u
M3388 WX8264 AND2_2891/net6 VDD VDD pmos W=0.41u L=0.04u
M3389 AND2_2891/net6 RESET VDD VDD pmos W=0.41u L=0.04u
M3390 AND2_2891/net6 WX8267 VDD VDD pmos W=0.41u L=0.04u
M3391 WX8262 AND2_2890/net6 VSS VSS nmos W=0.31u L=0.04u
M3392 AND2_2890/X_u2-net6 RESET VSS VSS nmos W=0.31u L=0.04u
M3393 AND2_2890/net6 WX8265 AND2_2890/X_u2-net6 VSS nmos W=0.31u L=0.04u
M3394 WX8262 AND2_2890/net6 VDD VDD pmos W=0.41u L=0.04u
M3395 AND2_2890/net6 RESET VDD VDD pmos W=0.41u L=0.04u
M3396 AND2_2890/net6 WX8265 VDD VDD pmos W=0.41u L=0.04u
M3397 WX8260 AND2_2889/net6 VSS VSS nmos W=0.31u L=0.04u
M3398 AND2_2889/X_u2-net6 RESET VSS VSS nmos W=0.31u L=0.04u
M3399 AND2_2889/net6 WX8263 AND2_2889/X_u2-net6 VSS nmos W=0.31u L=0.04u
M3400 WX8260 AND2_2889/net6 VDD VDD pmos W=0.41u L=0.04u
M3401 AND2_2889/net6 RESET VDD VDD pmos W=0.41u L=0.04u
M3402 AND2_2889/net6 WX8263 VDD VDD pmos W=0.41u L=0.04u
M3403 WX8258 AND2_2888/net6 VSS VSS nmos W=0.31u L=0.04u
M3404 AND2_2888/X_u2-net6 RESET VSS VSS nmos W=0.31u L=0.04u
M3405 AND2_2888/net6 WX8261 AND2_2888/X_u2-net6 VSS nmos W=0.31u L=0.04u
M3406 WX8258 AND2_2888/net6 VDD VDD pmos W=0.41u L=0.04u
M3407 AND2_2888/net6 RESET VDD VDD pmos W=0.41u L=0.04u
M3408 AND2_2888/net6 WX8261 VDD VDD pmos W=0.41u L=0.04u
M3409 WX8256 AND2_2887/net6 VSS VSS nmos W=0.31u L=0.04u
M3410 AND2_2887/X_u2-net6 RESET VSS VSS nmos W=0.31u L=0.04u
M3411 AND2_2887/net6 WX8259 AND2_2887/X_u2-net6 VSS nmos W=0.31u L=0.04u
M3412 WX8256 AND2_2887/net6 VDD VDD pmos W=0.41u L=0.04u
M3413 AND2_2887/net6 RESET VDD VDD pmos W=0.41u L=0.04u
M3414 AND2_2887/net6 WX8259 VDD VDD pmos W=0.41u L=0.04u
M3415 WX8254 AND2_2886/net6 VSS VSS nmos W=0.31u L=0.04u
M3416 AND2_2886/X_u2-net6 RESET VSS VSS nmos W=0.31u L=0.04u
M3417 AND2_2886/net6 WX8257 AND2_2886/X_u2-net6 VSS nmos W=0.31u L=0.04u
M3418 WX8254 AND2_2886/net6 VDD VDD pmos W=0.41u L=0.04u
M3419 AND2_2886/net6 RESET VDD VDD pmos W=0.41u L=0.04u
M3420 AND2_2886/net6 WX8257 VDD VDD pmos W=0.41u L=0.04u
M3421 WX8252 AND2_2885/net6 VSS VSS nmos W=0.31u L=0.04u
M3422 AND2_2885/X_u2-net6 RESET VSS VSS nmos W=0.31u L=0.04u
M3423 AND2_2885/net6 WX8255 AND2_2885/X_u2-net6 VSS nmos W=0.31u L=0.04u
M3424 WX8252 AND2_2885/net6 VDD VDD pmos W=0.41u L=0.04u
M3425 AND2_2885/net6 RESET VDD VDD pmos W=0.41u L=0.04u
M3426 AND2_2885/net6 WX8255 VDD VDD pmos W=0.41u L=0.04u
M3427 WX8250 AND2_2884/net6 VSS VSS nmos W=0.31u L=0.04u
M3428 AND2_2884/X_u2-net6 RESET VSS VSS nmos W=0.31u L=0.04u
M3429 AND2_2884/net6 WX8253 AND2_2884/X_u2-net6 VSS nmos W=0.31u L=0.04u
M3430 WX8250 AND2_2884/net6 VDD VDD pmos W=0.41u L=0.04u
M3431 AND2_2884/net6 RESET VDD VDD pmos W=0.41u L=0.04u
M3432 AND2_2884/net6 WX8253 VDD VDD pmos W=0.41u L=0.04u
M3433 WX8248 AND2_2883/net6 VSS VSS nmos W=0.31u L=0.04u
M3434 AND2_2883/X_u2-net6 RESET VSS VSS nmos W=0.31u L=0.04u
M3435 AND2_2883/net6 WX8251 AND2_2883/X_u2-net6 VSS nmos W=0.31u L=0.04u
M3436 WX8248 AND2_2883/net6 VDD VDD pmos W=0.41u L=0.04u
M3437 AND2_2883/net6 RESET VDD VDD pmos W=0.41u L=0.04u
M3438 AND2_2883/net6 WX8251 VDD VDD pmos W=0.41u L=0.04u
M3439 WX8246 AND2_2882/net6 VSS VSS nmos W=0.31u L=0.04u
M3440 AND2_2882/X_u2-net6 RESET VSS VSS nmos W=0.31u L=0.04u
M3441 AND2_2882/net6 WX8249 AND2_2882/X_u2-net6 VSS nmos W=0.31u L=0.04u
M3442 WX8246 AND2_2882/net6 VDD VDD pmos W=0.41u L=0.04u
M3443 AND2_2882/net6 RESET VDD VDD pmos W=0.41u L=0.04u
M3444 AND2_2882/net6 WX8249 VDD VDD pmos W=0.41u L=0.04u
M3445 WX8244 AND2_2881/net6 VSS VSS nmos W=0.31u L=0.04u
M3446 AND2_2881/X_u2-net6 RESET VSS VSS nmos W=0.31u L=0.04u
M3447 AND2_2881/net6 WX8247 AND2_2881/X_u2-net6 VSS nmos W=0.31u L=0.04u
M3448 WX8244 AND2_2881/net6 VDD VDD pmos W=0.41u L=0.04u
M3449 AND2_2881/net6 RESET VDD VDD pmos W=0.41u L=0.04u
M3450 AND2_2881/net6 WX8247 VDD VDD pmos W=0.41u L=0.04u
M3451 WX8242 AND2_2880/net6 VSS VSS nmos W=0.31u L=0.04u
M3452 AND2_2880/X_u2-net6 RESET VSS VSS nmos W=0.31u L=0.04u
M3453 AND2_2880/net6 WX8245 AND2_2880/X_u2-net6 VSS nmos W=0.31u L=0.04u
M3454 WX8242 AND2_2880/net6 VDD VDD pmos W=0.41u L=0.04u
M3455 AND2_2880/net6 RESET VDD VDD pmos W=0.41u L=0.04u
M3456 AND2_2880/net6 WX8245 VDD VDD pmos W=0.41u L=0.04u
M3457 WX7791 AND2_2687/net6 VSS VSS nmos W=0.31u L=0.04u
M3458 AND2_2687/X_u2-net6 RESET VSS VSS nmos W=0.31u L=0.04u
M3459 AND2_2687/net6 n1112 AND2_2687/X_u2-net6 VSS nmos W=0.31u L=0.04u
M3460 WX7791 AND2_2687/net6 VDD VDD pmos W=0.41u L=0.04u
M3461 AND2_2687/net6 RESET VDD VDD pmos W=0.41u L=0.04u
M3462 AND2_2687/net6 n1112 VDD VDD pmos W=0.41u L=0.04u
M3463 WX7789 AND2_2686/net6 VSS VSS nmos W=0.31u L=0.04u
M3464 AND2_2686/X_u2-net6 RESET VSS VSS nmos W=0.31u L=0.04u
M3465 AND2_2686/net6 n1113 AND2_2686/X_u2-net6 VSS nmos W=0.31u L=0.04u
M3466 WX7789 AND2_2686/net6 VDD VDD pmos W=0.41u L=0.04u
M3467 AND2_2686/net6 RESET VDD VDD pmos W=0.41u L=0.04u
M3468 AND2_2686/net6 n1113 VDD VDD pmos W=0.41u L=0.04u
M3469 WX7787 AND2_2685/net6 VSS VSS nmos W=0.31u L=0.04u
M3470 AND2_2685/X_u2-net6 RESET VSS VSS nmos W=0.31u L=0.04u
M3471 AND2_2685/net6 n1114 AND2_2685/X_u2-net6 VSS nmos W=0.31u L=0.04u
M3472 WX7787 AND2_2685/net6 VDD VDD pmos W=0.41u L=0.04u
M3473 AND2_2685/net6 RESET VDD VDD pmos W=0.41u L=0.04u
M3474 AND2_2685/net6 n1114 VDD VDD pmos W=0.41u L=0.04u
M3475 WX7785 AND2_2684/net6 VSS VSS nmos W=0.31u L=0.04u
M3476 AND2_2684/X_u2-net6 RESET VSS VSS nmos W=0.31u L=0.04u
M3477 AND2_2684/net6 n1115 AND2_2684/X_u2-net6 VSS nmos W=0.31u L=0.04u
M3478 WX7785 AND2_2684/net6 VDD VDD pmos W=0.41u L=0.04u
M3479 AND2_2684/net6 RESET VDD VDD pmos W=0.41u L=0.04u
M3480 AND2_2684/net6 n1115 VDD VDD pmos W=0.41u L=0.04u
M3481 WX7783 AND2_2683/net6 VSS VSS nmos W=0.31u L=0.04u
M3482 AND2_2683/X_u2-net6 RESET VSS VSS nmos W=0.31u L=0.04u
M3483 AND2_2683/net6 n1116 AND2_2683/X_u2-net6 VSS nmos W=0.31u L=0.04u
M3484 WX7783 AND2_2683/net6 VDD VDD pmos W=0.41u L=0.04u
M3485 AND2_2683/net6 RESET VDD VDD pmos W=0.41u L=0.04u
M3486 AND2_2683/net6 n1116 VDD VDD pmos W=0.41u L=0.04u
M3487 WX7781 AND2_2682/net6 VSS VSS nmos W=0.31u L=0.04u
M3488 AND2_2682/X_u2-net6 RESET VSS VSS nmos W=0.31u L=0.04u
M3489 AND2_2682/net6 n1117 AND2_2682/X_u2-net6 VSS nmos W=0.31u L=0.04u
M3490 WX7781 AND2_2682/net6 VDD VDD pmos W=0.41u L=0.04u
M3491 AND2_2682/net6 RESET VDD VDD pmos W=0.41u L=0.04u
M3492 AND2_2682/net6 n1117 VDD VDD pmos W=0.41u L=0.04u
M3493 WX7779 AND2_2681/net6 VSS VSS nmos W=0.31u L=0.04u
M3494 AND2_2681/X_u2-net6 RESET VSS VSS nmos W=0.31u L=0.04u
M3495 AND2_2681/net6 n1118 AND2_2681/X_u2-net6 VSS nmos W=0.31u L=0.04u
M3496 WX7779 AND2_2681/net6 VDD VDD pmos W=0.41u L=0.04u
M3497 AND2_2681/net6 RESET VDD VDD pmos W=0.41u L=0.04u
M3498 AND2_2681/net6 n1118 VDD VDD pmos W=0.41u L=0.04u
M3499 WX7777 AND2_2680/net6 VSS VSS nmos W=0.31u L=0.04u
M3500 AND2_2680/X_u2-net6 RESET VSS VSS nmos W=0.31u L=0.04u
M3501 AND2_2680/net6 n1119 AND2_2680/X_u2-net6 VSS nmos W=0.31u L=0.04u
M3502 WX7777 AND2_2680/net6 VDD VDD pmos W=0.41u L=0.04u
M3503 AND2_2680/net6 RESET VDD VDD pmos W=0.41u L=0.04u
M3504 AND2_2680/net6 n1119 VDD VDD pmos W=0.41u L=0.04u
M3505 WX7775 AND2_2679/net6 VSS VSS nmos W=0.31u L=0.04u
M3506 AND2_2679/X_u2-net6 RESET VSS VSS nmos W=0.31u L=0.04u
M3507 AND2_2679/net6 n1120 AND2_2679/X_u2-net6 VSS nmos W=0.31u L=0.04u
M3508 WX7775 AND2_2679/net6 VDD VDD pmos W=0.41u L=0.04u
M3509 AND2_2679/net6 RESET VDD VDD pmos W=0.41u L=0.04u
M3510 AND2_2679/net6 n1120 VDD VDD pmos W=0.41u L=0.04u
M3511 WX7773 AND2_2678/net6 VSS VSS nmos W=0.31u L=0.04u
M3512 AND2_2678/X_u2-net6 RESET VSS VSS nmos W=0.31u L=0.04u
M3513 AND2_2678/net6 n1121 AND2_2678/X_u2-net6 VSS nmos W=0.31u L=0.04u
M3514 WX7773 AND2_2678/net6 VDD VDD pmos W=0.41u L=0.04u
M3515 AND2_2678/net6 RESET VDD VDD pmos W=0.41u L=0.04u
M3516 AND2_2678/net6 n1121 VDD VDD pmos W=0.41u L=0.04u
M3517 WX7771 AND2_2677/net6 VSS VSS nmos W=0.31u L=0.04u
M3518 AND2_2677/X_u2-net6 RESET VSS VSS nmos W=0.31u L=0.04u
M3519 AND2_2677/net6 n1122 AND2_2677/X_u2-net6 VSS nmos W=0.31u L=0.04u
M3520 WX7771 AND2_2677/net6 VDD VDD pmos W=0.41u L=0.04u
M3521 AND2_2677/net6 RESET VDD VDD pmos W=0.41u L=0.04u
M3522 AND2_2677/net6 n1122 VDD VDD pmos W=0.41u L=0.04u
M3523 WX7769 AND2_2676/net6 VSS VSS nmos W=0.31u L=0.04u
M3524 AND2_2676/X_u2-net6 RESET VSS VSS nmos W=0.31u L=0.04u
M3525 AND2_2676/net6 n1123 AND2_2676/X_u2-net6 VSS nmos W=0.31u L=0.04u
M3526 WX7769 AND2_2676/net6 VDD VDD pmos W=0.41u L=0.04u
M3527 AND2_2676/net6 RESET VDD VDD pmos W=0.41u L=0.04u
M3528 AND2_2676/net6 n1123 VDD VDD pmos W=0.41u L=0.04u
M3529 WX7767 AND2_2675/net6 VSS VSS nmos W=0.31u L=0.04u
M3530 AND2_2675/X_u2-net6 RESET VSS VSS nmos W=0.31u L=0.04u
M3531 AND2_2675/net6 n1124 AND2_2675/X_u2-net6 VSS nmos W=0.31u L=0.04u
M3532 WX7767 AND2_2675/net6 VDD VDD pmos W=0.41u L=0.04u
M3533 AND2_2675/net6 RESET VDD VDD pmos W=0.41u L=0.04u
M3534 AND2_2675/net6 n1124 VDD VDD pmos W=0.41u L=0.04u
M3535 WX7765 AND2_2674/net6 VSS VSS nmos W=0.31u L=0.04u
M3536 AND2_2674/X_u2-net6 RESET VSS VSS nmos W=0.31u L=0.04u
M3537 AND2_2674/net6 n1125 AND2_2674/X_u2-net6 VSS nmos W=0.31u L=0.04u
M3538 WX7765 AND2_2674/net6 VDD VDD pmos W=0.41u L=0.04u
M3539 AND2_2674/net6 RESET VDD VDD pmos W=0.41u L=0.04u
M3540 AND2_2674/net6 n1125 VDD VDD pmos W=0.41u L=0.04u
M3541 WX7763 AND2_2673/net6 VSS VSS nmos W=0.31u L=0.04u
M3542 AND2_2673/X_u2-net6 RESET VSS VSS nmos W=0.31u L=0.04u
M3543 AND2_2673/net6 n1126 AND2_2673/X_u2-net6 VSS nmos W=0.31u L=0.04u
M3544 WX7763 AND2_2673/net6 VDD VDD pmos W=0.41u L=0.04u
M3545 AND2_2673/net6 RESET VDD VDD pmos W=0.41u L=0.04u
M3546 AND2_2673/net6 n1126 VDD VDD pmos W=0.41u L=0.04u
M3547 WX7761 AND2_2672/net6 VSS VSS nmos W=0.31u L=0.04u
M3548 AND2_2672/X_u2-net6 RESET VSS VSS nmos W=0.31u L=0.04u
M3549 AND2_2672/net6 n1127 AND2_2672/X_u2-net6 VSS nmos W=0.31u L=0.04u
M3550 WX7761 AND2_2672/net6 VDD VDD pmos W=0.41u L=0.04u
M3551 AND2_2672/net6 RESET VDD VDD pmos W=0.41u L=0.04u
M3552 AND2_2672/net6 n1127 VDD VDD pmos W=0.41u L=0.04u
M3553 WX7759 AND2_2671/net6 VSS VSS nmos W=0.31u L=0.04u
M3554 AND2_2671/X_u2-net6 RESET VSS VSS nmos W=0.31u L=0.04u
M3555 AND2_2671/net6 n1128 AND2_2671/X_u2-net6 VSS nmos W=0.31u L=0.04u
M3556 WX7759 AND2_2671/net6 VDD VDD pmos W=0.41u L=0.04u
M3557 AND2_2671/net6 RESET VDD VDD pmos W=0.41u L=0.04u
M3558 AND2_2671/net6 n1128 VDD VDD pmos W=0.41u L=0.04u
M3559 WX7757 AND2_2670/net6 VSS VSS nmos W=0.31u L=0.04u
M3560 AND2_2670/X_u2-net6 RESET VSS VSS nmos W=0.31u L=0.04u
M3561 AND2_2670/net6 n1129 AND2_2670/X_u2-net6 VSS nmos W=0.31u L=0.04u
M3562 WX7757 AND2_2670/net6 VDD VDD pmos W=0.41u L=0.04u
M3563 AND2_2670/net6 RESET VDD VDD pmos W=0.41u L=0.04u
M3564 AND2_2670/net6 n1129 VDD VDD pmos W=0.41u L=0.04u
M3565 WX7755 AND2_2669/net6 VSS VSS nmos W=0.31u L=0.04u
M3566 AND2_2669/X_u2-net6 RESET VSS VSS nmos W=0.31u L=0.04u
M3567 AND2_2669/net6 n1130 AND2_2669/X_u2-net6 VSS nmos W=0.31u L=0.04u
M3568 WX7755 AND2_2669/net6 VDD VDD pmos W=0.41u L=0.04u
M3569 AND2_2669/net6 RESET VDD VDD pmos W=0.41u L=0.04u
M3570 AND2_2669/net6 n1130 VDD VDD pmos W=0.41u L=0.04u
M3571 WX7753 AND2_2668/net6 VSS VSS nmos W=0.31u L=0.04u
M3572 AND2_2668/X_u2-net6 RESET VSS VSS nmos W=0.31u L=0.04u
M3573 AND2_2668/net6 n1131 AND2_2668/X_u2-net6 VSS nmos W=0.31u L=0.04u
M3574 WX7753 AND2_2668/net6 VDD VDD pmos W=0.41u L=0.04u
M3575 AND2_2668/net6 RESET VDD VDD pmos W=0.41u L=0.04u
M3576 AND2_2668/net6 n1131 VDD VDD pmos W=0.41u L=0.04u
M3577 WX7751 AND2_2667/net6 VSS VSS nmos W=0.31u L=0.04u
M3578 AND2_2667/X_u2-net6 RESET VSS VSS nmos W=0.31u L=0.04u
M3579 AND2_2667/net6 n1132 AND2_2667/X_u2-net6 VSS nmos W=0.31u L=0.04u
M3580 WX7751 AND2_2667/net6 VDD VDD pmos W=0.41u L=0.04u
M3581 AND2_2667/net6 RESET VDD VDD pmos W=0.41u L=0.04u
M3582 AND2_2667/net6 n1132 VDD VDD pmos W=0.41u L=0.04u
M3583 WX7749 AND2_2666/net6 VSS VSS nmos W=0.31u L=0.04u
M3584 AND2_2666/X_u2-net6 RESET VSS VSS nmos W=0.31u L=0.04u
M3585 AND2_2666/net6 n1133 AND2_2666/X_u2-net6 VSS nmos W=0.31u L=0.04u
M3586 WX7749 AND2_2666/net6 VDD VDD pmos W=0.41u L=0.04u
M3587 AND2_2666/net6 RESET VDD VDD pmos W=0.41u L=0.04u
M3588 AND2_2666/net6 n1133 VDD VDD pmos W=0.41u L=0.04u
M3589 WX7747 AND2_2665/net6 VSS VSS nmos W=0.31u L=0.04u
M3590 AND2_2665/X_u2-net6 RESET VSS VSS nmos W=0.31u L=0.04u
M3591 AND2_2665/net6 n1134 AND2_2665/X_u2-net6 VSS nmos W=0.31u L=0.04u
M3592 WX7747 AND2_2665/net6 VDD VDD pmos W=0.41u L=0.04u
M3593 AND2_2665/net6 RESET VDD VDD pmos W=0.41u L=0.04u
M3594 AND2_2665/net6 n1134 VDD VDD pmos W=0.41u L=0.04u
M3595 WX7745 AND2_2664/net6 VSS VSS nmos W=0.31u L=0.04u
M3596 AND2_2664/X_u2-net6 RESET VSS VSS nmos W=0.31u L=0.04u
M3597 AND2_2664/net6 n1135 AND2_2664/X_u2-net6 VSS nmos W=0.31u L=0.04u
M3598 WX7745 AND2_2664/net6 VDD VDD pmos W=0.41u L=0.04u
M3599 AND2_2664/net6 RESET VDD VDD pmos W=0.41u L=0.04u
M3600 AND2_2664/net6 n1135 VDD VDD pmos W=0.41u L=0.04u
M3601 WX7743 AND2_2663/net6 VSS VSS nmos W=0.31u L=0.04u
M3602 AND2_2663/X_u2-net6 RESET VSS VSS nmos W=0.31u L=0.04u
M3603 AND2_2663/net6 n1136 AND2_2663/X_u2-net6 VSS nmos W=0.31u L=0.04u
M3604 WX7743 AND2_2663/net6 VDD VDD pmos W=0.41u L=0.04u
M3605 AND2_2663/net6 RESET VDD VDD pmos W=0.41u L=0.04u
M3606 AND2_2663/net6 n1136 VDD VDD pmos W=0.41u L=0.04u
M3607 WX7741 AND2_2662/net6 VSS VSS nmos W=0.31u L=0.04u
M3608 AND2_2662/X_u2-net6 RESET VSS VSS nmos W=0.31u L=0.04u
M3609 AND2_2662/net6 n1137 AND2_2662/X_u2-net6 VSS nmos W=0.31u L=0.04u
M3610 WX7741 AND2_2662/net6 VDD VDD pmos W=0.41u L=0.04u
M3611 AND2_2662/net6 RESET VDD VDD pmos W=0.41u L=0.04u
M3612 AND2_2662/net6 n1137 VDD VDD pmos W=0.41u L=0.04u
M3613 WX7739 AND2_2661/net6 VSS VSS nmos W=0.31u L=0.04u
M3614 AND2_2661/X_u2-net6 RESET VSS VSS nmos W=0.31u L=0.04u
M3615 AND2_2661/net6 n1138 AND2_2661/X_u2-net6 VSS nmos W=0.31u L=0.04u
M3616 WX7739 AND2_2661/net6 VDD VDD pmos W=0.41u L=0.04u
M3617 AND2_2661/net6 RESET VDD VDD pmos W=0.41u L=0.04u
M3618 AND2_2661/net6 n1138 VDD VDD pmos W=0.41u L=0.04u
M3619 WX7737 AND2_2660/net6 VSS VSS nmos W=0.31u L=0.04u
M3620 AND2_2660/X_u2-net6 RESET VSS VSS nmos W=0.31u L=0.04u
M3621 AND2_2660/net6 n1139 AND2_2660/X_u2-net6 VSS nmos W=0.31u L=0.04u
M3622 WX7737 AND2_2660/net6 VDD VDD pmos W=0.41u L=0.04u
M3623 AND2_2660/net6 RESET VDD VDD pmos W=0.41u L=0.04u
M3624 AND2_2660/net6 n1139 VDD VDD pmos W=0.41u L=0.04u
M3625 WX7735 AND2_2659/net6 VSS VSS nmos W=0.31u L=0.04u
M3626 AND2_2659/X_u2-net6 RESET VSS VSS nmos W=0.31u L=0.04u
M3627 AND2_2659/net6 n1140 AND2_2659/X_u2-net6 VSS nmos W=0.31u L=0.04u
M3628 WX7735 AND2_2659/net6 VDD VDD pmos W=0.41u L=0.04u
M3629 AND2_2659/net6 RESET VDD VDD pmos W=0.41u L=0.04u
M3630 AND2_2659/net6 n1140 VDD VDD pmos W=0.41u L=0.04u
M3631 WX7733 AND2_2658/net6 VSS VSS nmos W=0.31u L=0.04u
M3632 AND2_2658/X_u2-net6 RESET VSS VSS nmos W=0.31u L=0.04u
M3633 AND2_2658/net6 n1141 AND2_2658/X_u2-net6 VSS nmos W=0.31u L=0.04u
M3634 WX7733 AND2_2658/net6 VDD VDD pmos W=0.41u L=0.04u
M3635 AND2_2658/net6 RESET VDD VDD pmos W=0.41u L=0.04u
M3636 AND2_2658/net6 n1141 VDD VDD pmos W=0.41u L=0.04u
M3637 WX7731 AND2_2657/net6 VSS VSS nmos W=0.31u L=0.04u
M3638 AND2_2657/X_u2-net6 RESET VSS VSS nmos W=0.31u L=0.04u
M3639 AND2_2657/net6 n1142 AND2_2657/X_u2-net6 VSS nmos W=0.31u L=0.04u
M3640 WX7731 AND2_2657/net6 VDD VDD pmos W=0.41u L=0.04u
M3641 AND2_2657/net6 RESET VDD VDD pmos W=0.41u L=0.04u
M3642 AND2_2657/net6 n1142 VDD VDD pmos W=0.41u L=0.04u
M3643 WX7729 AND2_2656/net6 VSS VSS nmos W=0.31u L=0.04u
M3644 AND2_2656/X_u2-net6 RESET VSS VSS nmos W=0.31u L=0.04u
M3645 AND2_2656/net6 n1143 AND2_2656/X_u2-net6 VSS nmos W=0.31u L=0.04u
M3646 WX7729 AND2_2656/net6 VDD VDD pmos W=0.41u L=0.04u
M3647 AND2_2656/net6 RESET VDD VDD pmos W=0.41u L=0.04u
M3648 AND2_2656/net6 n1143 VDD VDD pmos W=0.41u L=0.04u
M3649 WX7363 AND2_2591/net6 VSS VSS nmos W=0.31u L=0.04u
M3650 AND2_2591/X_u2-net6 RESET VSS VSS nmos W=0.31u L=0.04u
M3651 AND2_2591/net6 WX7300 AND2_2591/X_u2-net6 VSS nmos W=0.31u L=0.04u
M3652 WX7363 AND2_2591/net6 VDD VDD pmos W=0.41u L=0.04u
M3653 AND2_2591/net6 RESET VDD VDD pmos W=0.41u L=0.04u
M3654 AND2_2591/net6 WX7300 VDD VDD pmos W=0.41u L=0.04u
M3655 WX7361 AND2_2590/net6 VSS VSS nmos W=0.31u L=0.04u
M3656 AND2_2590/X_u2-net6 RESET VSS VSS nmos W=0.31u L=0.04u
M3657 AND2_2590/net6 WX7298 AND2_2590/X_u2-net6 VSS nmos W=0.31u L=0.04u
M3658 WX7361 AND2_2590/net6 VDD VDD pmos W=0.41u L=0.04u
M3659 AND2_2590/net6 RESET VDD VDD pmos W=0.41u L=0.04u
M3660 AND2_2590/net6 WX7298 VDD VDD pmos W=0.41u L=0.04u
M3661 WX7359 AND2_2589/net6 VSS VSS nmos W=0.31u L=0.04u
M3662 AND2_2589/X_u2-net6 RESET VSS VSS nmos W=0.31u L=0.04u
M3663 AND2_2589/net6 WX7296 AND2_2589/X_u2-net6 VSS nmos W=0.31u L=0.04u
M3664 WX7359 AND2_2589/net6 VDD VDD pmos W=0.41u L=0.04u
M3665 AND2_2589/net6 RESET VDD VDD pmos W=0.41u L=0.04u
M3666 AND2_2589/net6 WX7296 VDD VDD pmos W=0.41u L=0.04u
M3667 WX7357 AND2_2588/net6 VSS VSS nmos W=0.31u L=0.04u
M3668 AND2_2588/X_u2-net6 RESET VSS VSS nmos W=0.31u L=0.04u
M3669 AND2_2588/net6 WX7294 AND2_2588/X_u2-net6 VSS nmos W=0.31u L=0.04u
M3670 WX7357 AND2_2588/net6 VDD VDD pmos W=0.41u L=0.04u
M3671 AND2_2588/net6 RESET VDD VDD pmos W=0.41u L=0.04u
M3672 AND2_2588/net6 WX7294 VDD VDD pmos W=0.41u L=0.04u
M3673 WX7355 AND2_2587/net6 VSS VSS nmos W=0.31u L=0.04u
M3674 AND2_2587/X_u2-net6 RESET VSS VSS nmos W=0.31u L=0.04u
M3675 AND2_2587/net6 WX7292 AND2_2587/X_u2-net6 VSS nmos W=0.31u L=0.04u
M3676 WX7355 AND2_2587/net6 VDD VDD pmos W=0.41u L=0.04u
M3677 AND2_2587/net6 RESET VDD VDD pmos W=0.41u L=0.04u
M3678 AND2_2587/net6 WX7292 VDD VDD pmos W=0.41u L=0.04u
M3679 WX7353 AND2_2586/net6 VSS VSS nmos W=0.31u L=0.04u
M3680 AND2_2586/X_u2-net6 RESET VSS VSS nmos W=0.31u L=0.04u
M3681 AND2_2586/net6 WX7290 AND2_2586/X_u2-net6 VSS nmos W=0.31u L=0.04u
M3682 WX7353 AND2_2586/net6 VDD VDD pmos W=0.41u L=0.04u
M3683 AND2_2586/net6 RESET VDD VDD pmos W=0.41u L=0.04u
M3684 AND2_2586/net6 WX7290 VDD VDD pmos W=0.41u L=0.04u
M3685 WX7351 AND2_2585/net6 VSS VSS nmos W=0.31u L=0.04u
M3686 AND2_2585/X_u2-net6 RESET VSS VSS nmos W=0.31u L=0.04u
M3687 AND2_2585/net6 WX7288 AND2_2585/X_u2-net6 VSS nmos W=0.31u L=0.04u
M3688 WX7351 AND2_2585/net6 VDD VDD pmos W=0.41u L=0.04u
M3689 AND2_2585/net6 RESET VDD VDD pmos W=0.41u L=0.04u
M3690 AND2_2585/net6 WX7288 VDD VDD pmos W=0.41u L=0.04u
M3691 WX7349 AND2_2584/net6 VSS VSS nmos W=0.31u L=0.04u
M3692 AND2_2584/X_u2-net6 RESET VSS VSS nmos W=0.31u L=0.04u
M3693 AND2_2584/net6 WX7286 AND2_2584/X_u2-net6 VSS nmos W=0.31u L=0.04u
M3694 WX7349 AND2_2584/net6 VDD VDD pmos W=0.41u L=0.04u
M3695 AND2_2584/net6 RESET VDD VDD pmos W=0.41u L=0.04u
M3696 AND2_2584/net6 WX7286 VDD VDD pmos W=0.41u L=0.04u
M3697 WX7347 AND2_2583/net6 VSS VSS nmos W=0.31u L=0.04u
M3698 AND2_2583/X_u2-net6 RESET VSS VSS nmos W=0.31u L=0.04u
M3699 AND2_2583/net6 WX7284 AND2_2583/X_u2-net6 VSS nmos W=0.31u L=0.04u
M3700 WX7347 AND2_2583/net6 VDD VDD pmos W=0.41u L=0.04u
M3701 AND2_2583/net6 RESET VDD VDD pmos W=0.41u L=0.04u
M3702 AND2_2583/net6 WX7284 VDD VDD pmos W=0.41u L=0.04u
M3703 WX7345 AND2_2582/net6 VSS VSS nmos W=0.31u L=0.04u
M3704 AND2_2582/X_u2-net6 RESET VSS VSS nmos W=0.31u L=0.04u
M3705 AND2_2582/net6 WX7282 AND2_2582/X_u2-net6 VSS nmos W=0.31u L=0.04u
M3706 WX7345 AND2_2582/net6 VDD VDD pmos W=0.41u L=0.04u
M3707 AND2_2582/net6 RESET VDD VDD pmos W=0.41u L=0.04u
M3708 AND2_2582/net6 WX7282 VDD VDD pmos W=0.41u L=0.04u
M3709 WX7343 AND2_2581/net6 VSS VSS nmos W=0.31u L=0.04u
M3710 AND2_2581/X_u2-net6 RESET VSS VSS nmos W=0.31u L=0.04u
M3711 AND2_2581/net6 WX7280 AND2_2581/X_u2-net6 VSS nmos W=0.31u L=0.04u
M3712 WX7343 AND2_2581/net6 VDD VDD pmos W=0.41u L=0.04u
M3713 AND2_2581/net6 RESET VDD VDD pmos W=0.41u L=0.04u
M3714 AND2_2581/net6 WX7280 VDD VDD pmos W=0.41u L=0.04u
M3715 WX7341 AND2_2580/net6 VSS VSS nmos W=0.31u L=0.04u
M3716 AND2_2580/X_u2-net6 RESET VSS VSS nmos W=0.31u L=0.04u
M3717 AND2_2580/net6 WX7278 AND2_2580/X_u2-net6 VSS nmos W=0.31u L=0.04u
M3718 WX7341 AND2_2580/net6 VDD VDD pmos W=0.41u L=0.04u
M3719 AND2_2580/net6 RESET VDD VDD pmos W=0.41u L=0.04u
M3720 AND2_2580/net6 WX7278 VDD VDD pmos W=0.41u L=0.04u
M3721 WX7339 AND2_2579/net6 VSS VSS nmos W=0.31u L=0.04u
M3722 AND2_2579/X_u2-net6 RESET VSS VSS nmos W=0.31u L=0.04u
M3723 AND2_2579/net6 WX7276 AND2_2579/X_u2-net6 VSS nmos W=0.31u L=0.04u
M3724 WX7339 AND2_2579/net6 VDD VDD pmos W=0.41u L=0.04u
M3725 AND2_2579/net6 RESET VDD VDD pmos W=0.41u L=0.04u
M3726 AND2_2579/net6 WX7276 VDD VDD pmos W=0.41u L=0.04u
M3727 WX7337 AND2_2578/net6 VSS VSS nmos W=0.31u L=0.04u
M3728 AND2_2578/X_u2-net6 RESET VSS VSS nmos W=0.31u L=0.04u
M3729 AND2_2578/net6 WX7274 AND2_2578/X_u2-net6 VSS nmos W=0.31u L=0.04u
M3730 WX7337 AND2_2578/net6 VDD VDD pmos W=0.41u L=0.04u
M3731 AND2_2578/net6 RESET VDD VDD pmos W=0.41u L=0.04u
M3732 AND2_2578/net6 WX7274 VDD VDD pmos W=0.41u L=0.04u
M3733 WX7335 AND2_2577/net6 VSS VSS nmos W=0.31u L=0.04u
M3734 AND2_2577/X_u2-net6 RESET VSS VSS nmos W=0.31u L=0.04u
M3735 AND2_2577/net6 WX7272 AND2_2577/X_u2-net6 VSS nmos W=0.31u L=0.04u
M3736 WX7335 AND2_2577/net6 VDD VDD pmos W=0.41u L=0.04u
M3737 AND2_2577/net6 RESET VDD VDD pmos W=0.41u L=0.04u
M3738 AND2_2577/net6 WX7272 VDD VDD pmos W=0.41u L=0.04u
M3739 WX7333 AND2_2576/net6 VSS VSS nmos W=0.31u L=0.04u
M3740 AND2_2576/X_u2-net6 RESET VSS VSS nmos W=0.31u L=0.04u
M3741 AND2_2576/net6 WX7270 AND2_2576/X_u2-net6 VSS nmos W=0.31u L=0.04u
M3742 WX7333 AND2_2576/net6 VDD VDD pmos W=0.41u L=0.04u
M3743 AND2_2576/net6 RESET VDD VDD pmos W=0.41u L=0.04u
M3744 AND2_2576/net6 WX7270 VDD VDD pmos W=0.41u L=0.04u
M3745 WX7331 AND2_2575/net6 VSS VSS nmos W=0.31u L=0.04u
M3746 AND2_2575/X_u2-net6 RESET VSS VSS nmos W=0.31u L=0.04u
M3747 AND2_2575/net6 WX7268 AND2_2575/X_u2-net6 VSS nmos W=0.31u L=0.04u
M3748 WX7331 AND2_2575/net6 VDD VDD pmos W=0.41u L=0.04u
M3749 AND2_2575/net6 RESET VDD VDD pmos W=0.41u L=0.04u
M3750 AND2_2575/net6 WX7268 VDD VDD pmos W=0.41u L=0.04u
M3751 WX7329 AND2_2574/net6 VSS VSS nmos W=0.31u L=0.04u
M3752 AND2_2574/X_u2-net6 RESET VSS VSS nmos W=0.31u L=0.04u
M3753 AND2_2574/net6 WX7266 AND2_2574/X_u2-net6 VSS nmos W=0.31u L=0.04u
M3754 WX7329 AND2_2574/net6 VDD VDD pmos W=0.41u L=0.04u
M3755 AND2_2574/net6 RESET VDD VDD pmos W=0.41u L=0.04u
M3756 AND2_2574/net6 WX7266 VDD VDD pmos W=0.41u L=0.04u
M3757 WX7327 AND2_2573/net6 VSS VSS nmos W=0.31u L=0.04u
M3758 AND2_2573/X_u2-net6 RESET VSS VSS nmos W=0.31u L=0.04u
M3759 AND2_2573/net6 WX7264 AND2_2573/X_u2-net6 VSS nmos W=0.31u L=0.04u
M3760 WX7327 AND2_2573/net6 VDD VDD pmos W=0.41u L=0.04u
M3761 AND2_2573/net6 RESET VDD VDD pmos W=0.41u L=0.04u
M3762 AND2_2573/net6 WX7264 VDD VDD pmos W=0.41u L=0.04u
M3763 WX7325 AND2_2572/net6 VSS VSS nmos W=0.31u L=0.04u
M3764 AND2_2572/X_u2-net6 RESET VSS VSS nmos W=0.31u L=0.04u
M3765 AND2_2572/net6 WX7262 AND2_2572/X_u2-net6 VSS nmos W=0.31u L=0.04u
M3766 WX7325 AND2_2572/net6 VDD VDD pmos W=0.41u L=0.04u
M3767 AND2_2572/net6 RESET VDD VDD pmos W=0.41u L=0.04u
M3768 AND2_2572/net6 WX7262 VDD VDD pmos W=0.41u L=0.04u
M3769 WX7323 AND2_2571/net6 VSS VSS nmos W=0.31u L=0.04u
M3770 AND2_2571/X_u2-net6 RESET VSS VSS nmos W=0.31u L=0.04u
M3771 AND2_2571/net6 WX7260 AND2_2571/X_u2-net6 VSS nmos W=0.31u L=0.04u
M3772 WX7323 AND2_2571/net6 VDD VDD pmos W=0.41u L=0.04u
M3773 AND2_2571/net6 RESET VDD VDD pmos W=0.41u L=0.04u
M3774 AND2_2571/net6 WX7260 VDD VDD pmos W=0.41u L=0.04u
M3775 WX7321 AND2_2570/net6 VSS VSS nmos W=0.31u L=0.04u
M3776 AND2_2570/X_u2-net6 RESET VSS VSS nmos W=0.31u L=0.04u
M3777 AND2_2570/net6 WX7258 AND2_2570/X_u2-net6 VSS nmos W=0.31u L=0.04u
M3778 WX7321 AND2_2570/net6 VDD VDD pmos W=0.41u L=0.04u
M3779 AND2_2570/net6 RESET VDD VDD pmos W=0.41u L=0.04u
M3780 AND2_2570/net6 WX7258 VDD VDD pmos W=0.41u L=0.04u
M3781 WX7319 AND2_2569/net6 VSS VSS nmos W=0.31u L=0.04u
M3782 AND2_2569/X_u2-net6 RESET VSS VSS nmos W=0.31u L=0.04u
M3783 AND2_2569/net6 WX7256 AND2_2569/X_u2-net6 VSS nmos W=0.31u L=0.04u
M3784 WX7319 AND2_2569/net6 VDD VDD pmos W=0.41u L=0.04u
M3785 AND2_2569/net6 RESET VDD VDD pmos W=0.41u L=0.04u
M3786 AND2_2569/net6 WX7256 VDD VDD pmos W=0.41u L=0.04u
M3787 WX7317 AND2_2568/net6 VSS VSS nmos W=0.31u L=0.04u
M3788 AND2_2568/X_u2-net6 RESET VSS VSS nmos W=0.31u L=0.04u
M3789 AND2_2568/net6 WX7254 AND2_2568/X_u2-net6 VSS nmos W=0.31u L=0.04u
M3790 WX7317 AND2_2568/net6 VDD VDD pmos W=0.41u L=0.04u
M3791 AND2_2568/net6 RESET VDD VDD pmos W=0.41u L=0.04u
M3792 AND2_2568/net6 WX7254 VDD VDD pmos W=0.41u L=0.04u
M3793 WX7315 AND2_2567/net6 VSS VSS nmos W=0.31u L=0.04u
M3794 AND2_2567/X_u2-net6 RESET VSS VSS nmos W=0.31u L=0.04u
M3795 AND2_2567/net6 WX7252 AND2_2567/X_u2-net6 VSS nmos W=0.31u L=0.04u
M3796 WX7315 AND2_2567/net6 VDD VDD pmos W=0.41u L=0.04u
M3797 AND2_2567/net6 RESET VDD VDD pmos W=0.41u L=0.04u
M3798 AND2_2567/net6 WX7252 VDD VDD pmos W=0.41u L=0.04u
M3799 WX7313 AND2_2566/net6 VSS VSS nmos W=0.31u L=0.04u
M3800 AND2_2566/X_u2-net6 RESET VSS VSS nmos W=0.31u L=0.04u
M3801 AND2_2566/net6 WX7250 AND2_2566/X_u2-net6 VSS nmos W=0.31u L=0.04u
M3802 WX7313 AND2_2566/net6 VDD VDD pmos W=0.41u L=0.04u
M3803 AND2_2566/net6 RESET VDD VDD pmos W=0.41u L=0.04u
M3804 AND2_2566/net6 WX7250 VDD VDD pmos W=0.41u L=0.04u
M3805 WX7311 AND2_2565/net6 VSS VSS nmos W=0.31u L=0.04u
M3806 AND2_2565/X_u2-net6 RESET VSS VSS nmos W=0.31u L=0.04u
M3807 AND2_2565/net6 WX7248 AND2_2565/X_u2-net6 VSS nmos W=0.31u L=0.04u
M3808 WX7311 AND2_2565/net6 VDD VDD pmos W=0.41u L=0.04u
M3809 AND2_2565/net6 RESET VDD VDD pmos W=0.41u L=0.04u
M3810 AND2_2565/net6 WX7248 VDD VDD pmos W=0.41u L=0.04u
M3811 WX7309 AND2_2564/net6 VSS VSS nmos W=0.31u L=0.04u
M3812 AND2_2564/X_u2-net6 RESET VSS VSS nmos W=0.31u L=0.04u
M3813 AND2_2564/net6 WX7246 AND2_2564/X_u2-net6 VSS nmos W=0.31u L=0.04u
M3814 WX7309 AND2_2564/net6 VDD VDD pmos W=0.41u L=0.04u
M3815 AND2_2564/net6 RESET VDD VDD pmos W=0.41u L=0.04u
M3816 AND2_2564/net6 WX7246 VDD VDD pmos W=0.41u L=0.04u
M3817 WX7307 AND2_2563/net6 VSS VSS nmos W=0.31u L=0.04u
M3818 AND2_2563/X_u2-net6 RESET VSS VSS nmos W=0.31u L=0.04u
M3819 AND2_2563/net6 WX7244 AND2_2563/X_u2-net6 VSS nmos W=0.31u L=0.04u
M3820 WX7307 AND2_2563/net6 VDD VDD pmos W=0.41u L=0.04u
M3821 AND2_2563/net6 RESET VDD VDD pmos W=0.41u L=0.04u
M3822 AND2_2563/net6 WX7244 VDD VDD pmos W=0.41u L=0.04u
M3823 WX7305 AND2_2562/net6 VSS VSS nmos W=0.31u L=0.04u
M3824 AND2_2562/X_u2-net6 RESET VSS VSS nmos W=0.31u L=0.04u
M3825 AND2_2562/net6 WX7242 AND2_2562/X_u2-net6 VSS nmos W=0.31u L=0.04u
M3826 WX7305 AND2_2562/net6 VDD VDD pmos W=0.41u L=0.04u
M3827 AND2_2562/net6 RESET VDD VDD pmos W=0.41u L=0.04u
M3828 AND2_2562/net6 WX7242 VDD VDD pmos W=0.41u L=0.04u
M3829 WX7303 AND2_2561/net6 VSS VSS nmos W=0.31u L=0.04u
M3830 AND2_2561/X_u2-net6 RESET VSS VSS nmos W=0.31u L=0.04u
M3831 AND2_2561/net6 WX7240 AND2_2561/X_u2-net6 VSS nmos W=0.31u L=0.04u
M3832 WX7303 AND2_2561/net6 VDD VDD pmos W=0.41u L=0.04u
M3833 AND2_2561/net6 RESET VDD VDD pmos W=0.41u L=0.04u
M3834 AND2_2561/net6 WX7240 VDD VDD pmos W=0.41u L=0.04u
M3835 WX7301 AND2_2560/net6 VSS VSS nmos W=0.31u L=0.04u
M3836 AND2_2560/X_u2-net6 RESET VSS VSS nmos W=0.31u L=0.04u
M3837 AND2_2560/net6 WX7238 AND2_2560/X_u2-net6 VSS nmos W=0.31u L=0.04u
M3838 WX7301 AND2_2560/net6 VDD VDD pmos W=0.41u L=0.04u
M3839 AND2_2560/net6 RESET VDD VDD pmos W=0.41u L=0.04u
M3840 AND2_2560/net6 WX7238 VDD VDD pmos W=0.41u L=0.04u
M3841 WX7299 AND2_2559/net6 VSS VSS nmos W=0.31u L=0.04u
M3842 AND2_2559/X_u2-net6 RESET VSS VSS nmos W=0.31u L=0.04u
M3843 AND2_2559/net6 WX7236 AND2_2559/X_u2-net6 VSS nmos W=0.31u L=0.04u
M3844 WX7299 AND2_2559/net6 VDD VDD pmos W=0.41u L=0.04u
M3845 AND2_2559/net6 RESET VDD VDD pmos W=0.41u L=0.04u
M3846 AND2_2559/net6 WX7236 VDD VDD pmos W=0.41u L=0.04u
M3847 WX7297 AND2_2558/net6 VSS VSS nmos W=0.31u L=0.04u
M3848 AND2_2558/X_u2-net6 RESET VSS VSS nmos W=0.31u L=0.04u
M3849 AND2_2558/net6 WX7234 AND2_2558/X_u2-net6 VSS nmos W=0.31u L=0.04u
M3850 WX7297 AND2_2558/net6 VDD VDD pmos W=0.41u L=0.04u
M3851 AND2_2558/net6 RESET VDD VDD pmos W=0.41u L=0.04u
M3852 AND2_2558/net6 WX7234 VDD VDD pmos W=0.41u L=0.04u
M3853 WX7295 AND2_2557/net6 VSS VSS nmos W=0.31u L=0.04u
M3854 AND2_2557/X_u2-net6 RESET VSS VSS nmos W=0.31u L=0.04u
M3855 AND2_2557/net6 WX7232 AND2_2557/X_u2-net6 VSS nmos W=0.31u L=0.04u
M3856 WX7295 AND2_2557/net6 VDD VDD pmos W=0.41u L=0.04u
M3857 AND2_2557/net6 RESET VDD VDD pmos W=0.41u L=0.04u
M3858 AND2_2557/net6 WX7232 VDD VDD pmos W=0.41u L=0.04u
M3859 WX7293 AND2_2556/net6 VSS VSS nmos W=0.31u L=0.04u
M3860 AND2_2556/X_u2-net6 RESET VSS VSS nmos W=0.31u L=0.04u
M3861 AND2_2556/net6 WX7230 AND2_2556/X_u2-net6 VSS nmos W=0.31u L=0.04u
M3862 WX7293 AND2_2556/net6 VDD VDD pmos W=0.41u L=0.04u
M3863 AND2_2556/net6 RESET VDD VDD pmos W=0.41u L=0.04u
M3864 AND2_2556/net6 WX7230 VDD VDD pmos W=0.41u L=0.04u
M3865 WX7291 AND2_2555/net6 VSS VSS nmos W=0.31u L=0.04u
M3866 AND2_2555/X_u2-net6 RESET VSS VSS nmos W=0.31u L=0.04u
M3867 AND2_2555/net6 WX7228 AND2_2555/X_u2-net6 VSS nmos W=0.31u L=0.04u
M3868 WX7291 AND2_2555/net6 VDD VDD pmos W=0.41u L=0.04u
M3869 AND2_2555/net6 RESET VDD VDD pmos W=0.41u L=0.04u
M3870 AND2_2555/net6 WX7228 VDD VDD pmos W=0.41u L=0.04u
M3871 WX7289 AND2_2554/net6 VSS VSS nmos W=0.31u L=0.04u
M3872 AND2_2554/X_u2-net6 RESET VSS VSS nmos W=0.31u L=0.04u
M3873 AND2_2554/net6 WX7226 AND2_2554/X_u2-net6 VSS nmos W=0.31u L=0.04u
M3874 WX7289 AND2_2554/net6 VDD VDD pmos W=0.41u L=0.04u
M3875 AND2_2554/net6 RESET VDD VDD pmos W=0.41u L=0.04u
M3876 AND2_2554/net6 WX7226 VDD VDD pmos W=0.41u L=0.04u
M3877 WX7287 AND2_2553/net6 VSS VSS nmos W=0.31u L=0.04u
M3878 AND2_2553/X_u2-net6 RESET VSS VSS nmos W=0.31u L=0.04u
M3879 AND2_2553/net6 WX7224 AND2_2553/X_u2-net6 VSS nmos W=0.31u L=0.04u
M3880 WX7287 AND2_2553/net6 VDD VDD pmos W=0.41u L=0.04u
M3881 AND2_2553/net6 RESET VDD VDD pmos W=0.41u L=0.04u
M3882 AND2_2553/net6 WX7224 VDD VDD pmos W=0.41u L=0.04u
M3883 WX7285 AND2_2552/net6 VSS VSS nmos W=0.31u L=0.04u
M3884 AND2_2552/X_u2-net6 RESET VSS VSS nmos W=0.31u L=0.04u
M3885 AND2_2552/net6 WX7222 AND2_2552/X_u2-net6 VSS nmos W=0.31u L=0.04u
M3886 WX7285 AND2_2552/net6 VDD VDD pmos W=0.41u L=0.04u
M3887 AND2_2552/net6 RESET VDD VDD pmos W=0.41u L=0.04u
M3888 AND2_2552/net6 WX7222 VDD VDD pmos W=0.41u L=0.04u
M3889 WX7283 AND2_2551/net6 VSS VSS nmos W=0.31u L=0.04u
M3890 AND2_2551/X_u2-net6 RESET VSS VSS nmos W=0.31u L=0.04u
M3891 AND2_2551/net6 WX7220 AND2_2551/X_u2-net6 VSS nmos W=0.31u L=0.04u
M3892 WX7283 AND2_2551/net6 VDD VDD pmos W=0.41u L=0.04u
M3893 AND2_2551/net6 RESET VDD VDD pmos W=0.41u L=0.04u
M3894 AND2_2551/net6 WX7220 VDD VDD pmos W=0.41u L=0.04u
M3895 WX7281 AND2_2550/net6 VSS VSS nmos W=0.31u L=0.04u
M3896 AND2_2550/X_u2-net6 RESET VSS VSS nmos W=0.31u L=0.04u
M3897 AND2_2550/net6 WX7218 AND2_2550/X_u2-net6 VSS nmos W=0.31u L=0.04u
M3898 WX7281 AND2_2550/net6 VDD VDD pmos W=0.41u L=0.04u
M3899 AND2_2550/net6 RESET VDD VDD pmos W=0.41u L=0.04u
M3900 AND2_2550/net6 WX7218 VDD VDD pmos W=0.41u L=0.04u
M3901 WX7279 AND2_2549/net6 VSS VSS nmos W=0.31u L=0.04u
M3902 AND2_2549/X_u2-net6 RESET VSS VSS nmos W=0.31u L=0.04u
M3903 AND2_2549/net6 WX7216 AND2_2549/X_u2-net6 VSS nmos W=0.31u L=0.04u
M3904 WX7279 AND2_2549/net6 VDD VDD pmos W=0.41u L=0.04u
M3905 AND2_2549/net6 RESET VDD VDD pmos W=0.41u L=0.04u
M3906 AND2_2549/net6 WX7216 VDD VDD pmos W=0.41u L=0.04u
M3907 WX7277 AND2_2548/net6 VSS VSS nmos W=0.31u L=0.04u
M3908 AND2_2548/X_u2-net6 RESET VSS VSS nmos W=0.31u L=0.04u
M3909 AND2_2548/net6 WX7214 AND2_2548/X_u2-net6 VSS nmos W=0.31u L=0.04u
M3910 WX7277 AND2_2548/net6 VDD VDD pmos W=0.41u L=0.04u
M3911 AND2_2548/net6 RESET VDD VDD pmos W=0.41u L=0.04u
M3912 AND2_2548/net6 WX7214 VDD VDD pmos W=0.41u L=0.04u
M3913 WX7275 AND2_2547/net6 VSS VSS nmos W=0.31u L=0.04u
M3914 AND2_2547/X_u2-net6 RESET VSS VSS nmos W=0.31u L=0.04u
M3915 AND2_2547/net6 WX7212 AND2_2547/X_u2-net6 VSS nmos W=0.31u L=0.04u
M3916 WX7275 AND2_2547/net6 VDD VDD pmos W=0.41u L=0.04u
M3917 AND2_2547/net6 RESET VDD VDD pmos W=0.41u L=0.04u
M3918 AND2_2547/net6 WX7212 VDD VDD pmos W=0.41u L=0.04u
M3919 WX7273 AND2_2546/net6 VSS VSS nmos W=0.31u L=0.04u
M3920 AND2_2546/X_u2-net6 RESET VSS VSS nmos W=0.31u L=0.04u
M3921 AND2_2546/net6 WX7210 AND2_2546/X_u2-net6 VSS nmos W=0.31u L=0.04u
M3922 WX7273 AND2_2546/net6 VDD VDD pmos W=0.41u L=0.04u
M3923 AND2_2546/net6 RESET VDD VDD pmos W=0.41u L=0.04u
M3924 AND2_2546/net6 WX7210 VDD VDD pmos W=0.41u L=0.04u
M3925 WX7271 AND2_2545/net6 VSS VSS nmos W=0.31u L=0.04u
M3926 AND2_2545/X_u2-net6 RESET VSS VSS nmos W=0.31u L=0.04u
M3927 AND2_2545/net6 WX7208 AND2_2545/X_u2-net6 VSS nmos W=0.31u L=0.04u
M3928 WX7271 AND2_2545/net6 VDD VDD pmos W=0.41u L=0.04u
M3929 AND2_2545/net6 RESET VDD VDD pmos W=0.41u L=0.04u
M3930 AND2_2545/net6 WX7208 VDD VDD pmos W=0.41u L=0.04u
M3931 WX7269 AND2_2544/net6 VSS VSS nmos W=0.31u L=0.04u
M3932 AND2_2544/X_u2-net6 RESET VSS VSS nmos W=0.31u L=0.04u
M3933 AND2_2544/net6 WX7206 AND2_2544/X_u2-net6 VSS nmos W=0.31u L=0.04u
M3934 WX7269 AND2_2544/net6 VDD VDD pmos W=0.41u L=0.04u
M3935 AND2_2544/net6 RESET VDD VDD pmos W=0.41u L=0.04u
M3936 AND2_2544/net6 WX7206 VDD VDD pmos W=0.41u L=0.04u
M3937 WX7267 AND2_2543/net6 VSS VSS nmos W=0.31u L=0.04u
M3938 AND2_2543/X_u2-net6 RESET VSS VSS nmos W=0.31u L=0.04u
M3939 AND2_2543/net6 WX7204 AND2_2543/X_u2-net6 VSS nmos W=0.31u L=0.04u
M3940 WX7267 AND2_2543/net6 VDD VDD pmos W=0.41u L=0.04u
M3941 AND2_2543/net6 RESET VDD VDD pmos W=0.41u L=0.04u
M3942 AND2_2543/net6 WX7204 VDD VDD pmos W=0.41u L=0.04u
M3943 WX7265 AND2_2542/net6 VSS VSS nmos W=0.31u L=0.04u
M3944 AND2_2542/X_u2-net6 RESET VSS VSS nmos W=0.31u L=0.04u
M3945 AND2_2542/net6 WX7202 AND2_2542/X_u2-net6 VSS nmos W=0.31u L=0.04u
M3946 WX7265 AND2_2542/net6 VDD VDD pmos W=0.41u L=0.04u
M3947 AND2_2542/net6 RESET VDD VDD pmos W=0.41u L=0.04u
M3948 AND2_2542/net6 WX7202 VDD VDD pmos W=0.41u L=0.04u
M3949 WX7263 AND2_2541/net6 VSS VSS nmos W=0.31u L=0.04u
M3950 AND2_2541/X_u2-net6 RESET VSS VSS nmos W=0.31u L=0.04u
M3951 AND2_2541/net6 WX7200 AND2_2541/X_u2-net6 VSS nmos W=0.31u L=0.04u
M3952 WX7263 AND2_2541/net6 VDD VDD pmos W=0.41u L=0.04u
M3953 AND2_2541/net6 RESET VDD VDD pmos W=0.41u L=0.04u
M3954 AND2_2541/net6 WX7200 VDD VDD pmos W=0.41u L=0.04u
M3955 WX7261 AND2_2540/net6 VSS VSS nmos W=0.31u L=0.04u
M3956 AND2_2540/X_u2-net6 RESET VSS VSS nmos W=0.31u L=0.04u
M3957 AND2_2540/net6 WX7198 AND2_2540/X_u2-net6 VSS nmos W=0.31u L=0.04u
M3958 WX7261 AND2_2540/net6 VDD VDD pmos W=0.41u L=0.04u
M3959 AND2_2540/net6 RESET VDD VDD pmos W=0.41u L=0.04u
M3960 AND2_2540/net6 WX7198 VDD VDD pmos W=0.41u L=0.04u
M3961 WX7259 AND2_2539/net6 VSS VSS nmos W=0.31u L=0.04u
M3962 AND2_2539/X_u2-net6 RESET VSS VSS nmos W=0.31u L=0.04u
M3963 AND2_2539/net6 WX7196 AND2_2539/X_u2-net6 VSS nmos W=0.31u L=0.04u
M3964 WX7259 AND2_2539/net6 VDD VDD pmos W=0.41u L=0.04u
M3965 AND2_2539/net6 RESET VDD VDD pmos W=0.41u L=0.04u
M3966 AND2_2539/net6 WX7196 VDD VDD pmos W=0.41u L=0.04u
M3967 WX7257 AND2_2538/net6 VSS VSS nmos W=0.31u L=0.04u
M3968 AND2_2538/X_u2-net6 RESET VSS VSS nmos W=0.31u L=0.04u
M3969 AND2_2538/net6 WX7194 AND2_2538/X_u2-net6 VSS nmos W=0.31u L=0.04u
M3970 WX7257 AND2_2538/net6 VDD VDD pmos W=0.41u L=0.04u
M3971 AND2_2538/net6 RESET VDD VDD pmos W=0.41u L=0.04u
M3972 AND2_2538/net6 WX7194 VDD VDD pmos W=0.41u L=0.04u
M3973 WX7255 AND2_2537/net6 VSS VSS nmos W=0.31u L=0.04u
M3974 AND2_2537/X_u2-net6 RESET VSS VSS nmos W=0.31u L=0.04u
M3975 AND2_2537/net6 WX7192 AND2_2537/X_u2-net6 VSS nmos W=0.31u L=0.04u
M3976 WX7255 AND2_2537/net6 VDD VDD pmos W=0.41u L=0.04u
M3977 AND2_2537/net6 RESET VDD VDD pmos W=0.41u L=0.04u
M3978 AND2_2537/net6 WX7192 VDD VDD pmos W=0.41u L=0.04u
M3979 WX7253 AND2_2536/net6 VSS VSS nmos W=0.31u L=0.04u
M3980 AND2_2536/X_u2-net6 RESET VSS VSS nmos W=0.31u L=0.04u
M3981 AND2_2536/net6 WX7190 AND2_2536/X_u2-net6 VSS nmos W=0.31u L=0.04u
M3982 WX7253 AND2_2536/net6 VDD VDD pmos W=0.41u L=0.04u
M3983 AND2_2536/net6 RESET VDD VDD pmos W=0.41u L=0.04u
M3984 AND2_2536/net6 WX7190 VDD VDD pmos W=0.41u L=0.04u
M3985 WX7251 AND2_2535/net6 VSS VSS nmos W=0.31u L=0.04u
M3986 AND2_2535/X_u2-net6 RESET VSS VSS nmos W=0.31u L=0.04u
M3987 AND2_2535/net6 WX7188 AND2_2535/X_u2-net6 VSS nmos W=0.31u L=0.04u
M3988 WX7251 AND2_2535/net6 VDD VDD pmos W=0.41u L=0.04u
M3989 AND2_2535/net6 RESET VDD VDD pmos W=0.41u L=0.04u
M3990 AND2_2535/net6 WX7188 VDD VDD pmos W=0.41u L=0.04u
M3991 WX7249 AND2_2534/net6 VSS VSS nmos W=0.31u L=0.04u
M3992 AND2_2534/X_u2-net6 RESET VSS VSS nmos W=0.31u L=0.04u
M3993 AND2_2534/net6 WX7186 AND2_2534/X_u2-net6 VSS nmos W=0.31u L=0.04u
M3994 WX7249 AND2_2534/net6 VDD VDD pmos W=0.41u L=0.04u
M3995 AND2_2534/net6 RESET VDD VDD pmos W=0.41u L=0.04u
M3996 AND2_2534/net6 WX7186 VDD VDD pmos W=0.41u L=0.04u
M3997 WX7247 AND2_2533/net6 VSS VSS nmos W=0.31u L=0.04u
M3998 AND2_2533/X_u2-net6 RESET VSS VSS nmos W=0.31u L=0.04u
M3999 AND2_2533/net6 WX7184 AND2_2533/X_u2-net6 VSS nmos W=0.31u L=0.04u
M4000 WX7247 AND2_2533/net6 VDD VDD pmos W=0.41u L=0.04u
M4001 AND2_2533/net6 RESET VDD VDD pmos W=0.41u L=0.04u
M4002 AND2_2533/net6 WX7184 VDD VDD pmos W=0.41u L=0.04u
M4003 WX7245 AND2_2532/net6 VSS VSS nmos W=0.31u L=0.04u
M4004 AND2_2532/X_u2-net6 RESET VSS VSS nmos W=0.31u L=0.04u
M4005 AND2_2532/net6 WX7182 AND2_2532/X_u2-net6 VSS nmos W=0.31u L=0.04u
M4006 WX7245 AND2_2532/net6 VDD VDD pmos W=0.41u L=0.04u
M4007 AND2_2532/net6 RESET VDD VDD pmos W=0.41u L=0.04u
M4008 AND2_2532/net6 WX7182 VDD VDD pmos W=0.41u L=0.04u
M4009 WX7243 AND2_2531/net6 VSS VSS nmos W=0.31u L=0.04u
M4010 AND2_2531/X_u2-net6 RESET VSS VSS nmos W=0.31u L=0.04u
M4011 AND2_2531/net6 WX7180 AND2_2531/X_u2-net6 VSS nmos W=0.31u L=0.04u
M4012 WX7243 AND2_2531/net6 VDD VDD pmos W=0.41u L=0.04u
M4013 AND2_2531/net6 RESET VDD VDD pmos W=0.41u L=0.04u
M4014 AND2_2531/net6 WX7180 VDD VDD pmos W=0.41u L=0.04u
M4015 WX7241 AND2_2530/net6 VSS VSS nmos W=0.31u L=0.04u
M4016 AND2_2530/X_u2-net6 RESET VSS VSS nmos W=0.31u L=0.04u
M4017 AND2_2530/net6 WX7178 AND2_2530/X_u2-net6 VSS nmos W=0.31u L=0.04u
M4018 WX7241 AND2_2530/net6 VDD VDD pmos W=0.41u L=0.04u
M4019 AND2_2530/net6 RESET VDD VDD pmos W=0.41u L=0.04u
M4020 AND2_2530/net6 WX7178 VDD VDD pmos W=0.41u L=0.04u
M4021 WX7239 AND2_2529/net6 VSS VSS nmos W=0.31u L=0.04u
M4022 AND2_2529/X_u2-net6 RESET VSS VSS nmos W=0.31u L=0.04u
M4023 AND2_2529/net6 WX7176 AND2_2529/X_u2-net6 VSS nmos W=0.31u L=0.04u
M4024 WX7239 AND2_2529/net6 VDD VDD pmos W=0.41u L=0.04u
M4025 AND2_2529/net6 RESET VDD VDD pmos W=0.41u L=0.04u
M4026 AND2_2529/net6 WX7176 VDD VDD pmos W=0.41u L=0.04u
M4027 WX7237 AND2_2528/net6 VSS VSS nmos W=0.31u L=0.04u
M4028 AND2_2528/X_u2-net6 RESET VSS VSS nmos W=0.31u L=0.04u
M4029 AND2_2528/net6 WX7174 AND2_2528/X_u2-net6 VSS nmos W=0.31u L=0.04u
M4030 WX7237 AND2_2528/net6 VDD VDD pmos W=0.41u L=0.04u
M4031 AND2_2528/net6 RESET VDD VDD pmos W=0.41u L=0.04u
M4032 AND2_2528/net6 WX7174 VDD VDD pmos W=0.41u L=0.04u
M4033 WX7235 AND2_2527/net6 VSS VSS nmos W=0.31u L=0.04u
M4034 AND2_2527/X_u2-net6 RESET VSS VSS nmos W=0.31u L=0.04u
M4035 AND2_2527/net6 WX7172 AND2_2527/X_u2-net6 VSS nmos W=0.31u L=0.04u
M4036 WX7235 AND2_2527/net6 VDD VDD pmos W=0.41u L=0.04u
M4037 AND2_2527/net6 RESET VDD VDD pmos W=0.41u L=0.04u
M4038 AND2_2527/net6 WX7172 VDD VDD pmos W=0.41u L=0.04u
M4039 WX7233 AND2_2526/net6 VSS VSS nmos W=0.31u L=0.04u
M4040 AND2_2526/X_u2-net6 RESET VSS VSS nmos W=0.31u L=0.04u
M4041 AND2_2526/net6 WX7170 AND2_2526/X_u2-net6 VSS nmos W=0.31u L=0.04u
M4042 WX7233 AND2_2526/net6 VDD VDD pmos W=0.41u L=0.04u
M4043 AND2_2526/net6 RESET VDD VDD pmos W=0.41u L=0.04u
M4044 AND2_2526/net6 WX7170 VDD VDD pmos W=0.41u L=0.04u
M4045 WX7231 AND2_2525/net6 VSS VSS nmos W=0.31u L=0.04u
M4046 AND2_2525/X_u2-net6 RESET VSS VSS nmos W=0.31u L=0.04u
M4047 AND2_2525/net6 WX7168 AND2_2525/X_u2-net6 VSS nmos W=0.31u L=0.04u
M4048 WX7231 AND2_2525/net6 VDD VDD pmos W=0.41u L=0.04u
M4049 AND2_2525/net6 RESET VDD VDD pmos W=0.41u L=0.04u
M4050 AND2_2525/net6 WX7168 VDD VDD pmos W=0.41u L=0.04u
M4051 WX7229 AND2_2524/net6 VSS VSS nmos W=0.31u L=0.04u
M4052 AND2_2524/X_u2-net6 RESET VSS VSS nmos W=0.31u L=0.04u
M4053 AND2_2524/net6 WX7166 AND2_2524/X_u2-net6 VSS nmos W=0.31u L=0.04u
M4054 WX7229 AND2_2524/net6 VDD VDD pmos W=0.41u L=0.04u
M4055 AND2_2524/net6 RESET VDD VDD pmos W=0.41u L=0.04u
M4056 AND2_2524/net6 WX7166 VDD VDD pmos W=0.41u L=0.04u
M4057 WX7227 AND2_2523/net6 VSS VSS nmos W=0.31u L=0.04u
M4058 AND2_2523/X_u2-net6 RESET VSS VSS nmos W=0.31u L=0.04u
M4059 AND2_2523/net6 WX7164 AND2_2523/X_u2-net6 VSS nmos W=0.31u L=0.04u
M4060 WX7227 AND2_2523/net6 VDD VDD pmos W=0.41u L=0.04u
M4061 AND2_2523/net6 RESET VDD VDD pmos W=0.41u L=0.04u
M4062 AND2_2523/net6 WX7164 VDD VDD pmos W=0.41u L=0.04u
M4063 WX7225 AND2_2522/net6 VSS VSS nmos W=0.31u L=0.04u
M4064 AND2_2522/X_u2-net6 RESET VSS VSS nmos W=0.31u L=0.04u
M4065 AND2_2522/net6 WX7162 AND2_2522/X_u2-net6 VSS nmos W=0.31u L=0.04u
M4066 WX7225 AND2_2522/net6 VDD VDD pmos W=0.41u L=0.04u
M4067 AND2_2522/net6 RESET VDD VDD pmos W=0.41u L=0.04u
M4068 AND2_2522/net6 WX7162 VDD VDD pmos W=0.41u L=0.04u
M4069 WX7223 AND2_2521/net6 VSS VSS nmos W=0.31u L=0.04u
M4070 AND2_2521/X_u2-net6 RESET VSS VSS nmos W=0.31u L=0.04u
M4071 AND2_2521/net6 WX7160 AND2_2521/X_u2-net6 VSS nmos W=0.31u L=0.04u
M4072 WX7223 AND2_2521/net6 VDD VDD pmos W=0.41u L=0.04u
M4073 AND2_2521/net6 RESET VDD VDD pmos W=0.41u L=0.04u
M4074 AND2_2521/net6 WX7160 VDD VDD pmos W=0.41u L=0.04u
M4075 WX7221 AND2_2520/net6 VSS VSS nmos W=0.31u L=0.04u
M4076 AND2_2520/X_u2-net6 RESET VSS VSS nmos W=0.31u L=0.04u
M4077 AND2_2520/net6 WX7158 AND2_2520/X_u2-net6 VSS nmos W=0.31u L=0.04u
M4078 WX7221 AND2_2520/net6 VDD VDD pmos W=0.41u L=0.04u
M4079 AND2_2520/net6 RESET VDD VDD pmos W=0.41u L=0.04u
M4080 AND2_2520/net6 WX7158 VDD VDD pmos W=0.41u L=0.04u
M4081 WX7219 AND2_2519/net6 VSS VSS nmos W=0.31u L=0.04u
M4082 AND2_2519/X_u2-net6 RESET VSS VSS nmos W=0.31u L=0.04u
M4083 AND2_2519/net6 WX7156 AND2_2519/X_u2-net6 VSS nmos W=0.31u L=0.04u
M4084 WX7219 AND2_2519/net6 VDD VDD pmos W=0.41u L=0.04u
M4085 AND2_2519/net6 RESET VDD VDD pmos W=0.41u L=0.04u
M4086 AND2_2519/net6 WX7156 VDD VDD pmos W=0.41u L=0.04u
M4087 WX7217 AND2_2518/net6 VSS VSS nmos W=0.31u L=0.04u
M4088 AND2_2518/X_u2-net6 RESET VSS VSS nmos W=0.31u L=0.04u
M4089 AND2_2518/net6 WX7154 AND2_2518/X_u2-net6 VSS nmos W=0.31u L=0.04u
M4090 WX7217 AND2_2518/net6 VDD VDD pmos W=0.41u L=0.04u
M4091 AND2_2518/net6 RESET VDD VDD pmos W=0.41u L=0.04u
M4092 AND2_2518/net6 WX7154 VDD VDD pmos W=0.41u L=0.04u
M4093 WX7215 AND2_2517/net6 VSS VSS nmos W=0.31u L=0.04u
M4094 AND2_2517/X_u2-net6 RESET VSS VSS nmos W=0.31u L=0.04u
M4095 AND2_2517/net6 WX7152 AND2_2517/X_u2-net6 VSS nmos W=0.31u L=0.04u
M4096 WX7215 AND2_2517/net6 VDD VDD pmos W=0.41u L=0.04u
M4097 AND2_2517/net6 RESET VDD VDD pmos W=0.41u L=0.04u
M4098 AND2_2517/net6 WX7152 VDD VDD pmos W=0.41u L=0.04u
M4099 WX7213 AND2_2516/net6 VSS VSS nmos W=0.31u L=0.04u
M4100 AND2_2516/X_u2-net6 RESET VSS VSS nmos W=0.31u L=0.04u
M4101 AND2_2516/net6 WX7150 AND2_2516/X_u2-net6 VSS nmos W=0.31u L=0.04u
M4102 WX7213 AND2_2516/net6 VDD VDD pmos W=0.41u L=0.04u
M4103 AND2_2516/net6 RESET VDD VDD pmos W=0.41u L=0.04u
M4104 AND2_2516/net6 WX7150 VDD VDD pmos W=0.41u L=0.04u
M4105 WX7211 AND2_2515/net6 VSS VSS nmos W=0.31u L=0.04u
M4106 AND2_2515/X_u2-net6 RESET VSS VSS nmos W=0.31u L=0.04u
M4107 AND2_2515/net6 WX7148 AND2_2515/X_u2-net6 VSS nmos W=0.31u L=0.04u
M4108 WX7211 AND2_2515/net6 VDD VDD pmos W=0.41u L=0.04u
M4109 AND2_2515/net6 RESET VDD VDD pmos W=0.41u L=0.04u
M4110 AND2_2515/net6 WX7148 VDD VDD pmos W=0.41u L=0.04u
M4111 WX7209 AND2_2514/net6 VSS VSS nmos W=0.31u L=0.04u
M4112 AND2_2514/X_u2-net6 RESET VSS VSS nmos W=0.31u L=0.04u
M4113 AND2_2514/net6 WX7146 AND2_2514/X_u2-net6 VSS nmos W=0.31u L=0.04u
M4114 WX7209 AND2_2514/net6 VDD VDD pmos W=0.41u L=0.04u
M4115 AND2_2514/net6 RESET VDD VDD pmos W=0.41u L=0.04u
M4116 AND2_2514/net6 WX7146 VDD VDD pmos W=0.41u L=0.04u
M4117 WX7207 AND2_2513/net6 VSS VSS nmos W=0.31u L=0.04u
M4118 AND2_2513/X_u2-net6 RESET VSS VSS nmos W=0.31u L=0.04u
M4119 AND2_2513/net6 WX7144 AND2_2513/X_u2-net6 VSS nmos W=0.31u L=0.04u
M4120 WX7207 AND2_2513/net6 VDD VDD pmos W=0.41u L=0.04u
M4121 AND2_2513/net6 RESET VDD VDD pmos W=0.41u L=0.04u
M4122 AND2_2513/net6 WX7144 VDD VDD pmos W=0.41u L=0.04u
M4123 WX7205 AND2_2512/net6 VSS VSS nmos W=0.31u L=0.04u
M4124 AND2_2512/X_u2-net6 RESET VSS VSS nmos W=0.31u L=0.04u
M4125 AND2_2512/net6 WX7142 AND2_2512/X_u2-net6 VSS nmos W=0.31u L=0.04u
M4126 WX7205 AND2_2512/net6 VDD VDD pmos W=0.41u L=0.04u
M4127 AND2_2512/net6 RESET VDD VDD pmos W=0.41u L=0.04u
M4128 AND2_2512/net6 WX7142 VDD VDD pmos W=0.41u L=0.04u
M4129 WX7203 AND2_2511/net6 VSS VSS nmos W=0.31u L=0.04u
M4130 AND2_2511/X_u2-net6 RESET VSS VSS nmos W=0.31u L=0.04u
M4131 AND2_2511/net6 WX7140 AND2_2511/X_u2-net6 VSS nmos W=0.31u L=0.04u
M4132 WX7203 AND2_2511/net6 VDD VDD pmos W=0.41u L=0.04u
M4133 AND2_2511/net6 RESET VDD VDD pmos W=0.41u L=0.04u
M4134 AND2_2511/net6 WX7140 VDD VDD pmos W=0.41u L=0.04u
M4135 WX7201 AND2_2510/net6 VSS VSS nmos W=0.31u L=0.04u
M4136 AND2_2510/X_u2-net6 RESET VSS VSS nmos W=0.31u L=0.04u
M4137 AND2_2510/net6 WX7138 AND2_2510/X_u2-net6 VSS nmos W=0.31u L=0.04u
M4138 WX7201 AND2_2510/net6 VDD VDD pmos W=0.41u L=0.04u
M4139 AND2_2510/net6 RESET VDD VDD pmos W=0.41u L=0.04u
M4140 AND2_2510/net6 WX7138 VDD VDD pmos W=0.41u L=0.04u
M4141 WX7199 AND2_2509/net6 VSS VSS nmos W=0.31u L=0.04u
M4142 AND2_2509/X_u2-net6 RESET VSS VSS nmos W=0.31u L=0.04u
M4143 AND2_2509/net6 WX7136 AND2_2509/X_u2-net6 VSS nmos W=0.31u L=0.04u
M4144 WX7199 AND2_2509/net6 VDD VDD pmos W=0.41u L=0.04u
M4145 AND2_2509/net6 RESET VDD VDD pmos W=0.41u L=0.04u
M4146 AND2_2509/net6 WX7136 VDD VDD pmos W=0.41u L=0.04u
M4147 WX7197 AND2_2508/net6 VSS VSS nmos W=0.31u L=0.04u
M4148 AND2_2508/X_u2-net6 RESET VSS VSS nmos W=0.31u L=0.04u
M4149 AND2_2508/net6 WX7134 AND2_2508/X_u2-net6 VSS nmos W=0.31u L=0.04u
M4150 WX7197 AND2_2508/net6 VDD VDD pmos W=0.41u L=0.04u
M4151 AND2_2508/net6 RESET VDD VDD pmos W=0.41u L=0.04u
M4152 AND2_2508/net6 WX7134 VDD VDD pmos W=0.41u L=0.04u
M4153 WX7195 AND2_2507/net6 VSS VSS nmos W=0.31u L=0.04u
M4154 AND2_2507/X_u2-net6 RESET VSS VSS nmos W=0.31u L=0.04u
M4155 AND2_2507/net6 WX7132 AND2_2507/X_u2-net6 VSS nmos W=0.31u L=0.04u
M4156 WX7195 AND2_2507/net6 VDD VDD pmos W=0.41u L=0.04u
M4157 AND2_2507/net6 RESET VDD VDD pmos W=0.41u L=0.04u
M4158 AND2_2507/net6 WX7132 VDD VDD pmos W=0.41u L=0.04u
M4159 WX7193 AND2_2506/net6 VSS VSS nmos W=0.31u L=0.04u
M4160 AND2_2506/X_u2-net6 RESET VSS VSS nmos W=0.31u L=0.04u
M4161 AND2_2506/net6 WX7130 AND2_2506/X_u2-net6 VSS nmos W=0.31u L=0.04u
M4162 WX7193 AND2_2506/net6 VDD VDD pmos W=0.41u L=0.04u
M4163 AND2_2506/net6 RESET VDD VDD pmos W=0.41u L=0.04u
M4164 AND2_2506/net6 WX7130 VDD VDD pmos W=0.41u L=0.04u
M4165 WX7191 AND2_2505/net6 VSS VSS nmos W=0.31u L=0.04u
M4166 AND2_2505/X_u2-net6 RESET VSS VSS nmos W=0.31u L=0.04u
M4167 AND2_2505/net6 WX7128 AND2_2505/X_u2-net6 VSS nmos W=0.31u L=0.04u
M4168 WX7191 AND2_2505/net6 VDD VDD pmos W=0.41u L=0.04u
M4169 AND2_2505/net6 RESET VDD VDD pmos W=0.41u L=0.04u
M4170 AND2_2505/net6 WX7128 VDD VDD pmos W=0.41u L=0.04u
M4171 WX7189 AND2_2504/net6 VSS VSS nmos W=0.31u L=0.04u
M4172 AND2_2504/X_u2-net6 RESET VSS VSS nmos W=0.31u L=0.04u
M4173 AND2_2504/net6 WX7126 AND2_2504/X_u2-net6 VSS nmos W=0.31u L=0.04u
M4174 WX7189 AND2_2504/net6 VDD VDD pmos W=0.41u L=0.04u
M4175 AND2_2504/net6 RESET VDD VDD pmos W=0.41u L=0.04u
M4176 AND2_2504/net6 WX7126 VDD VDD pmos W=0.41u L=0.04u
M4177 WX7187 AND2_2503/net6 VSS VSS nmos W=0.31u L=0.04u
M4178 AND2_2503/X_u2-net6 RESET VSS VSS nmos W=0.31u L=0.04u
M4179 AND2_2503/net6 WX7124 AND2_2503/X_u2-net6 VSS nmos W=0.31u L=0.04u
M4180 WX7187 AND2_2503/net6 VDD VDD pmos W=0.41u L=0.04u
M4181 AND2_2503/net6 RESET VDD VDD pmos W=0.41u L=0.04u
M4182 AND2_2503/net6 WX7124 VDD VDD pmos W=0.41u L=0.04u
M4183 WX7185 AND2_2502/net6 VSS VSS nmos W=0.31u L=0.04u
M4184 AND2_2502/X_u2-net6 RESET VSS VSS nmos W=0.31u L=0.04u
M4185 AND2_2502/net6 WX7122 AND2_2502/X_u2-net6 VSS nmos W=0.31u L=0.04u
M4186 WX7185 AND2_2502/net6 VDD VDD pmos W=0.41u L=0.04u
M4187 AND2_2502/net6 RESET VDD VDD pmos W=0.41u L=0.04u
M4188 AND2_2502/net6 WX7122 VDD VDD pmos W=0.41u L=0.04u
M4189 WX7183 AND2_2501/net6 VSS VSS nmos W=0.31u L=0.04u
M4190 AND2_2501/X_u2-net6 RESET VSS VSS nmos W=0.31u L=0.04u
M4191 AND2_2501/net6 WX7120 AND2_2501/X_u2-net6 VSS nmos W=0.31u L=0.04u
M4192 WX7183 AND2_2501/net6 VDD VDD pmos W=0.41u L=0.04u
M4193 AND2_2501/net6 RESET VDD VDD pmos W=0.41u L=0.04u
M4194 AND2_2501/net6 WX7120 VDD VDD pmos W=0.41u L=0.04u
M4195 WX7181 AND2_2500/net6 VSS VSS nmos W=0.31u L=0.04u
M4196 AND2_2500/X_u2-net6 RESET VSS VSS nmos W=0.31u L=0.04u
M4197 AND2_2500/net6 WX7118 AND2_2500/X_u2-net6 VSS nmos W=0.31u L=0.04u
M4198 WX7181 AND2_2500/net6 VDD VDD pmos W=0.41u L=0.04u
M4199 AND2_2500/net6 RESET VDD VDD pmos W=0.41u L=0.04u
M4200 AND2_2500/net6 WX7118 VDD VDD pmos W=0.41u L=0.04u
M4201 WX7179 AND2_2499/net6 VSS VSS nmos W=0.31u L=0.04u
M4202 AND2_2499/X_u2-net6 RESET VSS VSS nmos W=0.31u L=0.04u
M4203 AND2_2499/net6 WX7116 AND2_2499/X_u2-net6 VSS nmos W=0.31u L=0.04u
M4204 WX7179 AND2_2499/net6 VDD VDD pmos W=0.41u L=0.04u
M4205 AND2_2499/net6 RESET VDD VDD pmos W=0.41u L=0.04u
M4206 AND2_2499/net6 WX7116 VDD VDD pmos W=0.41u L=0.04u
M4207 WX7177 AND2_2498/net6 VSS VSS nmos W=0.31u L=0.04u
M4208 AND2_2498/X_u2-net6 RESET VSS VSS nmos W=0.31u L=0.04u
M4209 AND2_2498/net6 WX7114 AND2_2498/X_u2-net6 VSS nmos W=0.31u L=0.04u
M4210 WX7177 AND2_2498/net6 VDD VDD pmos W=0.41u L=0.04u
M4211 AND2_2498/net6 RESET VDD VDD pmos W=0.41u L=0.04u
M4212 AND2_2498/net6 WX7114 VDD VDD pmos W=0.41u L=0.04u
M4213 WX7175 AND2_2497/net6 VSS VSS nmos W=0.31u L=0.04u
M4214 AND2_2497/X_u2-net6 RESET VSS VSS nmos W=0.31u L=0.04u
M4215 AND2_2497/net6 WX7112 AND2_2497/X_u2-net6 VSS nmos W=0.31u L=0.04u
M4216 WX7175 AND2_2497/net6 VDD VDD pmos W=0.41u L=0.04u
M4217 AND2_2497/net6 RESET VDD VDD pmos W=0.41u L=0.04u
M4218 AND2_2497/net6 WX7112 VDD VDD pmos W=0.41u L=0.04u
M4219 WX7173 AND2_2496/net6 VSS VSS nmos W=0.31u L=0.04u
M4220 AND2_2496/X_u2-net6 RESET VSS VSS nmos W=0.31u L=0.04u
M4221 AND2_2496/net6 WX7110 AND2_2496/X_u2-net6 VSS nmos W=0.31u L=0.04u
M4222 WX7173 AND2_2496/net6 VDD VDD pmos W=0.41u L=0.04u
M4223 AND2_2496/net6 RESET VDD VDD pmos W=0.41u L=0.04u
M4224 AND2_2496/net6 WX7110 VDD VDD pmos W=0.41u L=0.04u
M4225 WX7171 AND2_2495/net6 VSS VSS nmos W=0.31u L=0.04u
M4226 AND2_2495/X_u2-net6 RESET VSS VSS nmos W=0.31u L=0.04u
M4227 AND2_2495/net6 WX6937 AND2_2495/X_u2-net6 VSS nmos W=0.31u L=0.04u
M4228 WX7171 AND2_2495/net6 VDD VDD pmos W=0.41u L=0.04u
M4229 AND2_2495/net6 RESET VDD VDD pmos W=0.41u L=0.04u
M4230 AND2_2495/net6 WX6937 VDD VDD pmos W=0.41u L=0.04u
M4231 WX7169 AND2_2494/net6 VSS VSS nmos W=0.31u L=0.04u
M4232 AND2_2494/X_u2-net6 RESET VSS VSS nmos W=0.31u L=0.04u
M4233 AND2_2494/net6 WX6923 AND2_2494/X_u2-net6 VSS nmos W=0.31u L=0.04u
M4234 WX7169 AND2_2494/net6 VDD VDD pmos W=0.41u L=0.04u
M4235 AND2_2494/net6 RESET VDD VDD pmos W=0.41u L=0.04u
M4236 AND2_2494/net6 WX6923 VDD VDD pmos W=0.41u L=0.04u
M4237 WX7167 AND2_2493/net6 VSS VSS nmos W=0.31u L=0.04u
M4238 AND2_2493/X_u2-net6 RESET VSS VSS nmos W=0.31u L=0.04u
M4239 AND2_2493/net6 WX6909 AND2_2493/X_u2-net6 VSS nmos W=0.31u L=0.04u
M4240 WX7167 AND2_2493/net6 VDD VDD pmos W=0.41u L=0.04u
M4241 AND2_2493/net6 RESET VDD VDD pmos W=0.41u L=0.04u
M4242 AND2_2493/net6 WX6909 VDD VDD pmos W=0.41u L=0.04u
M4243 WX7165 AND2_2492/net6 VSS VSS nmos W=0.31u L=0.04u
M4244 AND2_2492/X_u2-net6 RESET VSS VSS nmos W=0.31u L=0.04u
M4245 AND2_2492/net6 WX6895 AND2_2492/X_u2-net6 VSS nmos W=0.31u L=0.04u
M4246 WX7165 AND2_2492/net6 VDD VDD pmos W=0.41u L=0.04u
M4247 AND2_2492/net6 RESET VDD VDD pmos W=0.41u L=0.04u
M4248 AND2_2492/net6 WX6895 VDD VDD pmos W=0.41u L=0.04u
M4249 WX7163 AND2_2491/net6 VSS VSS nmos W=0.31u L=0.04u
M4250 AND2_2491/X_u2-net6 RESET VSS VSS nmos W=0.31u L=0.04u
M4251 AND2_2491/net6 WX6881 AND2_2491/X_u2-net6 VSS nmos W=0.31u L=0.04u
M4252 WX7163 AND2_2491/net6 VDD VDD pmos W=0.41u L=0.04u
M4253 AND2_2491/net6 RESET VDD VDD pmos W=0.41u L=0.04u
M4254 AND2_2491/net6 WX6881 VDD VDD pmos W=0.41u L=0.04u
M4255 WX7161 AND2_2490/net6 VSS VSS nmos W=0.31u L=0.04u
M4256 AND2_2490/X_u2-net6 RESET VSS VSS nmos W=0.31u L=0.04u
M4257 AND2_2490/net6 WX6867 AND2_2490/X_u2-net6 VSS nmos W=0.31u L=0.04u
M4258 WX7161 AND2_2490/net6 VDD VDD pmos W=0.41u L=0.04u
M4259 AND2_2490/net6 RESET VDD VDD pmos W=0.41u L=0.04u
M4260 AND2_2490/net6 WX6867 VDD VDD pmos W=0.41u L=0.04u
M4261 WX7159 AND2_2489/net6 VSS VSS nmos W=0.31u L=0.04u
M4262 AND2_2489/X_u2-net6 RESET VSS VSS nmos W=0.31u L=0.04u
M4263 AND2_2489/net6 WX6853 AND2_2489/X_u2-net6 VSS nmos W=0.31u L=0.04u
M4264 WX7159 AND2_2489/net6 VDD VDD pmos W=0.41u L=0.04u
M4265 AND2_2489/net6 RESET VDD VDD pmos W=0.41u L=0.04u
M4266 AND2_2489/net6 WX6853 VDD VDD pmos W=0.41u L=0.04u
M4267 WX7157 AND2_2488/net6 VSS VSS nmos W=0.31u L=0.04u
M4268 AND2_2488/X_u2-net6 RESET VSS VSS nmos W=0.31u L=0.04u
M4269 AND2_2488/net6 WX6839 AND2_2488/X_u2-net6 VSS nmos W=0.31u L=0.04u
M4270 WX7157 AND2_2488/net6 VDD VDD pmos W=0.41u L=0.04u
M4271 AND2_2488/net6 RESET VDD VDD pmos W=0.41u L=0.04u
M4272 AND2_2488/net6 WX6839 VDD VDD pmos W=0.41u L=0.04u
M4273 WX7155 AND2_2487/net6 VSS VSS nmos W=0.31u L=0.04u
M4274 AND2_2487/X_u2-net6 RESET VSS VSS nmos W=0.31u L=0.04u
M4275 AND2_2487/net6 WX6825 AND2_2487/X_u2-net6 VSS nmos W=0.31u L=0.04u
M4276 WX7155 AND2_2487/net6 VDD VDD pmos W=0.41u L=0.04u
M4277 AND2_2487/net6 RESET VDD VDD pmos W=0.41u L=0.04u
M4278 AND2_2487/net6 WX6825 VDD VDD pmos W=0.41u L=0.04u
M4279 WX7153 AND2_2486/net6 VSS VSS nmos W=0.31u L=0.04u
M4280 AND2_2486/X_u2-net6 RESET VSS VSS nmos W=0.31u L=0.04u
M4281 AND2_2486/net6 WX6811 AND2_2486/X_u2-net6 VSS nmos W=0.31u L=0.04u
M4282 WX7153 AND2_2486/net6 VDD VDD pmos W=0.41u L=0.04u
M4283 AND2_2486/net6 RESET VDD VDD pmos W=0.41u L=0.04u
M4284 AND2_2486/net6 WX6811 VDD VDD pmos W=0.41u L=0.04u
M4285 WX7151 AND2_2485/net6 VSS VSS nmos W=0.31u L=0.04u
M4286 AND2_2485/X_u2-net6 RESET VSS VSS nmos W=0.31u L=0.04u
M4287 AND2_2485/net6 WX6797 AND2_2485/X_u2-net6 VSS nmos W=0.31u L=0.04u
M4288 WX7151 AND2_2485/net6 VDD VDD pmos W=0.41u L=0.04u
M4289 AND2_2485/net6 RESET VDD VDD pmos W=0.41u L=0.04u
M4290 AND2_2485/net6 WX6797 VDD VDD pmos W=0.41u L=0.04u
M4291 WX7149 AND2_2484/net6 VSS VSS nmos W=0.31u L=0.04u
M4292 AND2_2484/X_u2-net6 RESET VSS VSS nmos W=0.31u L=0.04u
M4293 AND2_2484/net6 WX6783 AND2_2484/X_u2-net6 VSS nmos W=0.31u L=0.04u
M4294 WX7149 AND2_2484/net6 VDD VDD pmos W=0.41u L=0.04u
M4295 AND2_2484/net6 RESET VDD VDD pmos W=0.41u L=0.04u
M4296 AND2_2484/net6 WX6783 VDD VDD pmos W=0.41u L=0.04u
M4297 WX7147 AND2_2483/net6 VSS VSS nmos W=0.31u L=0.04u
M4298 AND2_2483/X_u2-net6 RESET VSS VSS nmos W=0.31u L=0.04u
M4299 AND2_2483/net6 WX6769 AND2_2483/X_u2-net6 VSS nmos W=0.31u L=0.04u
M4300 WX7147 AND2_2483/net6 VDD VDD pmos W=0.41u L=0.04u
M4301 AND2_2483/net6 RESET VDD VDD pmos W=0.41u L=0.04u
M4302 AND2_2483/net6 WX6769 VDD VDD pmos W=0.41u L=0.04u
M4303 WX7145 AND2_2482/net6 VSS VSS nmos W=0.31u L=0.04u
M4304 AND2_2482/X_u2-net6 RESET VSS VSS nmos W=0.31u L=0.04u
M4305 AND2_2482/net6 WX6755 AND2_2482/X_u2-net6 VSS nmos W=0.31u L=0.04u
M4306 WX7145 AND2_2482/net6 VDD VDD pmos W=0.41u L=0.04u
M4307 AND2_2482/net6 RESET VDD VDD pmos W=0.41u L=0.04u
M4308 AND2_2482/net6 WX6755 VDD VDD pmos W=0.41u L=0.04u
M4309 WX7143 AND2_2481/net6 VSS VSS nmos W=0.31u L=0.04u
M4310 AND2_2481/X_u2-net6 RESET VSS VSS nmos W=0.31u L=0.04u
M4311 AND2_2481/net6 WX6741 AND2_2481/X_u2-net6 VSS nmos W=0.31u L=0.04u
M4312 WX7143 AND2_2481/net6 VDD VDD pmos W=0.41u L=0.04u
M4313 AND2_2481/net6 RESET VDD VDD pmos W=0.41u L=0.04u
M4314 AND2_2481/net6 WX6741 VDD VDD pmos W=0.41u L=0.04u
M4315 WX7141 AND2_2480/net6 VSS VSS nmos W=0.31u L=0.04u
M4316 AND2_2480/X_u2-net6 RESET VSS VSS nmos W=0.31u L=0.04u
M4317 AND2_2480/net6 WX6727 AND2_2480/X_u2-net6 VSS nmos W=0.31u L=0.04u
M4318 WX7141 AND2_2480/net6 VDD VDD pmos W=0.41u L=0.04u
M4319 AND2_2480/net6 RESET VDD VDD pmos W=0.41u L=0.04u
M4320 AND2_2480/net6 WX6727 VDD VDD pmos W=0.41u L=0.04u
M4321 WX7139 AND2_2479/net6 VSS VSS nmos W=0.31u L=0.04u
M4322 AND2_2479/X_u2-net6 RESET VSS VSS nmos W=0.31u L=0.04u
M4323 AND2_2479/net6 WX6713 AND2_2479/X_u2-net6 VSS nmos W=0.31u L=0.04u
M4324 WX7139 AND2_2479/net6 VDD VDD pmos W=0.41u L=0.04u
M4325 AND2_2479/net6 RESET VDD VDD pmos W=0.41u L=0.04u
M4326 AND2_2479/net6 WX6713 VDD VDD pmos W=0.41u L=0.04u
M4327 WX7137 AND2_2478/net6 VSS VSS nmos W=0.31u L=0.04u
M4328 AND2_2478/X_u2-net6 RESET VSS VSS nmos W=0.31u L=0.04u
M4329 AND2_2478/net6 WX6699 AND2_2478/X_u2-net6 VSS nmos W=0.31u L=0.04u
M4330 WX7137 AND2_2478/net6 VDD VDD pmos W=0.41u L=0.04u
M4331 AND2_2478/net6 RESET VDD VDD pmos W=0.41u L=0.04u
M4332 AND2_2478/net6 WX6699 VDD VDD pmos W=0.41u L=0.04u
M4333 WX7135 AND2_2477/net6 VSS VSS nmos W=0.31u L=0.04u
M4334 AND2_2477/X_u2-net6 RESET VSS VSS nmos W=0.31u L=0.04u
M4335 AND2_2477/net6 WX6685 AND2_2477/X_u2-net6 VSS nmos W=0.31u L=0.04u
M4336 WX7135 AND2_2477/net6 VDD VDD pmos W=0.41u L=0.04u
M4337 AND2_2477/net6 RESET VDD VDD pmos W=0.41u L=0.04u
M4338 AND2_2477/net6 WX6685 VDD VDD pmos W=0.41u L=0.04u
M4339 WX7133 AND2_2476/net6 VSS VSS nmos W=0.31u L=0.04u
M4340 AND2_2476/X_u2-net6 RESET VSS VSS nmos W=0.31u L=0.04u
M4341 AND2_2476/net6 WX6671 AND2_2476/X_u2-net6 VSS nmos W=0.31u L=0.04u
M4342 WX7133 AND2_2476/net6 VDD VDD pmos W=0.41u L=0.04u
M4343 AND2_2476/net6 RESET VDD VDD pmos W=0.41u L=0.04u
M4344 AND2_2476/net6 WX6671 VDD VDD pmos W=0.41u L=0.04u
M4345 WX7131 AND2_2475/net6 VSS VSS nmos W=0.31u L=0.04u
M4346 AND2_2475/X_u2-net6 RESET VSS VSS nmos W=0.31u L=0.04u
M4347 AND2_2475/net6 WX6657 AND2_2475/X_u2-net6 VSS nmos W=0.31u L=0.04u
M4348 WX7131 AND2_2475/net6 VDD VDD pmos W=0.41u L=0.04u
M4349 AND2_2475/net6 RESET VDD VDD pmos W=0.41u L=0.04u
M4350 AND2_2475/net6 WX6657 VDD VDD pmos W=0.41u L=0.04u
M4351 WX7129 AND2_2474/net6 VSS VSS nmos W=0.31u L=0.04u
M4352 AND2_2474/X_u2-net6 RESET VSS VSS nmos W=0.31u L=0.04u
M4353 AND2_2474/net6 WX6643 AND2_2474/X_u2-net6 VSS nmos W=0.31u L=0.04u
M4354 WX7129 AND2_2474/net6 VDD VDD pmos W=0.41u L=0.04u
M4355 AND2_2474/net6 RESET VDD VDD pmos W=0.41u L=0.04u
M4356 AND2_2474/net6 WX6643 VDD VDD pmos W=0.41u L=0.04u
M4357 WX7127 AND2_2473/net6 VSS VSS nmos W=0.31u L=0.04u
M4358 AND2_2473/X_u2-net6 RESET VSS VSS nmos W=0.31u L=0.04u
M4359 AND2_2473/net6 WX6629 AND2_2473/X_u2-net6 VSS nmos W=0.31u L=0.04u
M4360 WX7127 AND2_2473/net6 VDD VDD pmos W=0.41u L=0.04u
M4361 AND2_2473/net6 RESET VDD VDD pmos W=0.41u L=0.04u
M4362 AND2_2473/net6 WX6629 VDD VDD pmos W=0.41u L=0.04u
M4363 WX7125 AND2_2472/net6 VSS VSS nmos W=0.31u L=0.04u
M4364 AND2_2472/X_u2-net6 RESET VSS VSS nmos W=0.31u L=0.04u
M4365 AND2_2472/net6 WX6615 AND2_2472/X_u2-net6 VSS nmos W=0.31u L=0.04u
M4366 WX7125 AND2_2472/net6 VDD VDD pmos W=0.41u L=0.04u
M4367 AND2_2472/net6 RESET VDD VDD pmos W=0.41u L=0.04u
M4368 AND2_2472/net6 WX6615 VDD VDD pmos W=0.41u L=0.04u
M4369 WX7123 AND2_2471/net6 VSS VSS nmos W=0.31u L=0.04u
M4370 AND2_2471/X_u2-net6 RESET VSS VSS nmos W=0.31u L=0.04u
M4371 AND2_2471/net6 WX6601 AND2_2471/X_u2-net6 VSS nmos W=0.31u L=0.04u
M4372 WX7123 AND2_2471/net6 VDD VDD pmos W=0.41u L=0.04u
M4373 AND2_2471/net6 RESET VDD VDD pmos W=0.41u L=0.04u
M4374 AND2_2471/net6 WX6601 VDD VDD pmos W=0.41u L=0.04u
M4375 WX7121 AND2_2470/net6 VSS VSS nmos W=0.31u L=0.04u
M4376 AND2_2470/X_u2-net6 RESET VSS VSS nmos W=0.31u L=0.04u
M4377 AND2_2470/net6 WX6587 AND2_2470/X_u2-net6 VSS nmos W=0.31u L=0.04u
M4378 WX7121 AND2_2470/net6 VDD VDD pmos W=0.41u L=0.04u
M4379 AND2_2470/net6 RESET VDD VDD pmos W=0.41u L=0.04u
M4380 AND2_2470/net6 WX6587 VDD VDD pmos W=0.41u L=0.04u
M4381 WX7119 AND2_2469/net6 VSS VSS nmos W=0.31u L=0.04u
M4382 AND2_2469/X_u2-net6 RESET VSS VSS nmos W=0.31u L=0.04u
M4383 AND2_2469/net6 WX6573 AND2_2469/X_u2-net6 VSS nmos W=0.31u L=0.04u
M4384 WX7119 AND2_2469/net6 VDD VDD pmos W=0.41u L=0.04u
M4385 AND2_2469/net6 RESET VDD VDD pmos W=0.41u L=0.04u
M4386 AND2_2469/net6 WX6573 VDD VDD pmos W=0.41u L=0.04u
M4387 WX7117 AND2_2468/net6 VSS VSS nmos W=0.31u L=0.04u
M4388 AND2_2468/X_u2-net6 RESET VSS VSS nmos W=0.31u L=0.04u
M4389 AND2_2468/net6 WX6559 AND2_2468/X_u2-net6 VSS nmos W=0.31u L=0.04u
M4390 WX7117 AND2_2468/net6 VDD VDD pmos W=0.41u L=0.04u
M4391 AND2_2468/net6 RESET VDD VDD pmos W=0.41u L=0.04u
M4392 AND2_2468/net6 WX6559 VDD VDD pmos W=0.41u L=0.04u
M4393 WX7115 AND2_2467/net6 VSS VSS nmos W=0.31u L=0.04u
M4394 AND2_2467/X_u2-net6 RESET VSS VSS nmos W=0.31u L=0.04u
M4395 AND2_2467/net6 WX6545 AND2_2467/X_u2-net6 VSS nmos W=0.31u L=0.04u
M4396 WX7115 AND2_2467/net6 VDD VDD pmos W=0.41u L=0.04u
M4397 AND2_2467/net6 RESET VDD VDD pmos W=0.41u L=0.04u
M4398 AND2_2467/net6 WX6545 VDD VDD pmos W=0.41u L=0.04u
M4399 WX7113 AND2_2466/net6 VSS VSS nmos W=0.31u L=0.04u
M4400 AND2_2466/X_u2-net6 RESET VSS VSS nmos W=0.31u L=0.04u
M4401 AND2_2466/net6 WX6531 AND2_2466/X_u2-net6 VSS nmos W=0.31u L=0.04u
M4402 WX7113 AND2_2466/net6 VDD VDD pmos W=0.41u L=0.04u
M4403 AND2_2466/net6 RESET VDD VDD pmos W=0.41u L=0.04u
M4404 AND2_2466/net6 WX6531 VDD VDD pmos W=0.41u L=0.04u
M4405 WX7111 AND2_2465/net6 VSS VSS nmos W=0.31u L=0.04u
M4406 AND2_2465/X_u2-net6 RESET VSS VSS nmos W=0.31u L=0.04u
M4407 AND2_2465/net6 WX6517 AND2_2465/X_u2-net6 VSS nmos W=0.31u L=0.04u
M4408 WX7111 AND2_2465/net6 VDD VDD pmos W=0.41u L=0.04u
M4409 AND2_2465/net6 RESET VDD VDD pmos W=0.41u L=0.04u
M4410 AND2_2465/net6 WX6517 VDD VDD pmos W=0.41u L=0.04u
M4411 WX7109 AND2_2464/net6 VSS VSS nmos W=0.31u L=0.04u
M4412 AND2_2464/X_u2-net6 RESET VSS VSS nmos W=0.31u L=0.04u
M4413 AND2_2464/net6 WX6503 AND2_2464/X_u2-net6 VSS nmos W=0.31u L=0.04u
M4414 WX7109 AND2_2464/net6 VDD VDD pmos W=0.41u L=0.04u
M4415 AND2_2464/net6 RESET VDD VDD pmos W=0.41u L=0.04u
M4416 AND2_2464/net6 WX6503 VDD VDD pmos W=0.41u L=0.04u
M4417 WX7011 AND2_2463/net6 VSS VSS nmos W=0.31u L=0.04u
M4418 AND2_2463/X_u2-net6 RESET VSS VSS nmos W=0.31u L=0.04u
M4419 AND2_2463/net6 WX6948 AND2_2463/X_u2-net6 VSS nmos W=0.31u L=0.04u
M4420 WX7011 AND2_2463/net6 VDD VDD pmos W=0.41u L=0.04u
M4421 AND2_2463/net6 RESET VDD VDD pmos W=0.41u L=0.04u
M4422 AND2_2463/net6 WX6948 VDD VDD pmos W=0.41u L=0.04u
M4423 WX7009 AND2_2462/net6 VSS VSS nmos W=0.31u L=0.04u
M4424 AND2_2462/X_u2-net6 RESET VSS VSS nmos W=0.31u L=0.04u
M4425 AND2_2462/net6 WX7012 AND2_2462/X_u2-net6 VSS nmos W=0.31u L=0.04u
M4426 WX7009 AND2_2462/net6 VDD VDD pmos W=0.41u L=0.04u
M4427 AND2_2462/net6 RESET VDD VDD pmos W=0.41u L=0.04u
M4428 AND2_2462/net6 WX7012 VDD VDD pmos W=0.41u L=0.04u
M4429 WX7007 AND2_2461/net6 VSS VSS nmos W=0.31u L=0.04u
M4430 AND2_2461/X_u2-net6 RESET VSS VSS nmos W=0.31u L=0.04u
M4431 AND2_2461/net6 WX7010 AND2_2461/X_u2-net6 VSS nmos W=0.31u L=0.04u
M4432 WX7007 AND2_2461/net6 VDD VDD pmos W=0.41u L=0.04u
M4433 AND2_2461/net6 RESET VDD VDD pmos W=0.41u L=0.04u
M4434 AND2_2461/net6 WX7010 VDD VDD pmos W=0.41u L=0.04u
M4435 WX7005 AND2_2460/net6 VSS VSS nmos W=0.31u L=0.04u
M4436 AND2_2460/X_u2-net6 RESET VSS VSS nmos W=0.31u L=0.04u
M4437 AND2_2460/net6 WX7008 AND2_2460/X_u2-net6 VSS nmos W=0.31u L=0.04u
M4438 WX7005 AND2_2460/net6 VDD VDD pmos W=0.41u L=0.04u
M4439 AND2_2460/net6 RESET VDD VDD pmos W=0.41u L=0.04u
M4440 AND2_2460/net6 WX7008 VDD VDD pmos W=0.41u L=0.04u
M4441 WX7003 AND2_2459/net6 VSS VSS nmos W=0.31u L=0.04u
M4442 AND2_2459/X_u2-net6 RESET VSS VSS nmos W=0.31u L=0.04u
M4443 AND2_2459/net6 WX7006 AND2_2459/X_u2-net6 VSS nmos W=0.31u L=0.04u
M4444 WX7003 AND2_2459/net6 VDD VDD pmos W=0.41u L=0.04u
M4445 AND2_2459/net6 RESET VDD VDD pmos W=0.41u L=0.04u
M4446 AND2_2459/net6 WX7006 VDD VDD pmos W=0.41u L=0.04u
M4447 WX7001 AND2_2458/net6 VSS VSS nmos W=0.31u L=0.04u
M4448 AND2_2458/X_u2-net6 RESET VSS VSS nmos W=0.31u L=0.04u
M4449 AND2_2458/net6 WX7004 AND2_2458/X_u2-net6 VSS nmos W=0.31u L=0.04u
M4450 WX7001 AND2_2458/net6 VDD VDD pmos W=0.41u L=0.04u
M4451 AND2_2458/net6 RESET VDD VDD pmos W=0.41u L=0.04u
M4452 AND2_2458/net6 WX7004 VDD VDD pmos W=0.41u L=0.04u
M4453 WX6999 AND2_2457/net6 VSS VSS nmos W=0.31u L=0.04u
M4454 AND2_2457/X_u2-net6 RESET VSS VSS nmos W=0.31u L=0.04u
M4455 AND2_2457/net6 WX7002 AND2_2457/X_u2-net6 VSS nmos W=0.31u L=0.04u
M4456 WX6999 AND2_2457/net6 VDD VDD pmos W=0.41u L=0.04u
M4457 AND2_2457/net6 RESET VDD VDD pmos W=0.41u L=0.04u
M4458 AND2_2457/net6 WX7002 VDD VDD pmos W=0.41u L=0.04u
M4459 WX6997 AND2_2456/net6 VSS VSS nmos W=0.31u L=0.04u
M4460 AND2_2456/X_u2-net6 RESET VSS VSS nmos W=0.31u L=0.04u
M4461 AND2_2456/net6 WX7000 AND2_2456/X_u2-net6 VSS nmos W=0.31u L=0.04u
M4462 WX6997 AND2_2456/net6 VDD VDD pmos W=0.41u L=0.04u
M4463 AND2_2456/net6 RESET VDD VDD pmos W=0.41u L=0.04u
M4464 AND2_2456/net6 WX7000 VDD VDD pmos W=0.41u L=0.04u
M4465 WX6995 AND2_2455/net6 VSS VSS nmos W=0.31u L=0.04u
M4466 AND2_2455/X_u2-net6 RESET VSS VSS nmos W=0.31u L=0.04u
M4467 AND2_2455/net6 WX6998 AND2_2455/X_u2-net6 VSS nmos W=0.31u L=0.04u
M4468 WX6995 AND2_2455/net6 VDD VDD pmos W=0.41u L=0.04u
M4469 AND2_2455/net6 RESET VDD VDD pmos W=0.41u L=0.04u
M4470 AND2_2455/net6 WX6998 VDD VDD pmos W=0.41u L=0.04u
M4471 WX6993 AND2_2454/net6 VSS VSS nmos W=0.31u L=0.04u
M4472 AND2_2454/X_u2-net6 RESET VSS VSS nmos W=0.31u L=0.04u
M4473 AND2_2454/net6 WX6996 AND2_2454/X_u2-net6 VSS nmos W=0.31u L=0.04u
M4474 WX6993 AND2_2454/net6 VDD VDD pmos W=0.41u L=0.04u
M4475 AND2_2454/net6 RESET VDD VDD pmos W=0.41u L=0.04u
M4476 AND2_2454/net6 WX6996 VDD VDD pmos W=0.41u L=0.04u
M4477 WX6991 AND2_2453/net6 VSS VSS nmos W=0.31u L=0.04u
M4478 AND2_2453/X_u2-net6 RESET VSS VSS nmos W=0.31u L=0.04u
M4479 AND2_2453/net6 WX6994 AND2_2453/X_u2-net6 VSS nmos W=0.31u L=0.04u
M4480 WX6991 AND2_2453/net6 VDD VDD pmos W=0.41u L=0.04u
M4481 AND2_2453/net6 RESET VDD VDD pmos W=0.41u L=0.04u
M4482 AND2_2453/net6 WX6994 VDD VDD pmos W=0.41u L=0.04u
M4483 WX6989 AND2_2452/net6 VSS VSS nmos W=0.31u L=0.04u
M4484 AND2_2452/X_u2-net6 RESET VSS VSS nmos W=0.31u L=0.04u
M4485 AND2_2452/net6 WX6992 AND2_2452/X_u2-net6 VSS nmos W=0.31u L=0.04u
M4486 WX6989 AND2_2452/net6 VDD VDD pmos W=0.41u L=0.04u
M4487 AND2_2452/net6 RESET VDD VDD pmos W=0.41u L=0.04u
M4488 AND2_2452/net6 WX6992 VDD VDD pmos W=0.41u L=0.04u
M4489 WX6987 AND2_2451/net6 VSS VSS nmos W=0.31u L=0.04u
M4490 AND2_2451/X_u2-net6 RESET VSS VSS nmos W=0.31u L=0.04u
M4491 AND2_2451/net6 WX6990 AND2_2451/X_u2-net6 VSS nmos W=0.31u L=0.04u
M4492 WX6987 AND2_2451/net6 VDD VDD pmos W=0.41u L=0.04u
M4493 AND2_2451/net6 RESET VDD VDD pmos W=0.41u L=0.04u
M4494 AND2_2451/net6 WX6990 VDD VDD pmos W=0.41u L=0.04u
M4495 WX6985 AND2_2450/net6 VSS VSS nmos W=0.31u L=0.04u
M4496 AND2_2450/X_u2-net6 RESET VSS VSS nmos W=0.31u L=0.04u
M4497 AND2_2450/net6 WX6988 AND2_2450/X_u2-net6 VSS nmos W=0.31u L=0.04u
M4498 WX6985 AND2_2450/net6 VDD VDD pmos W=0.41u L=0.04u
M4499 AND2_2450/net6 RESET VDD VDD pmos W=0.41u L=0.04u
M4500 AND2_2450/net6 WX6988 VDD VDD pmos W=0.41u L=0.04u
M4501 WX6983 AND2_2449/net6 VSS VSS nmos W=0.31u L=0.04u
M4502 AND2_2449/X_u2-net6 RESET VSS VSS nmos W=0.31u L=0.04u
M4503 AND2_2449/net6 WX6986 AND2_2449/X_u2-net6 VSS nmos W=0.31u L=0.04u
M4504 WX6983 AND2_2449/net6 VDD VDD pmos W=0.41u L=0.04u
M4505 AND2_2449/net6 RESET VDD VDD pmos W=0.41u L=0.04u
M4506 AND2_2449/net6 WX6986 VDD VDD pmos W=0.41u L=0.04u
M4507 WX6981 AND2_2448/net6 VSS VSS nmos W=0.31u L=0.04u
M4508 AND2_2448/X_u2-net6 RESET VSS VSS nmos W=0.31u L=0.04u
M4509 AND2_2448/net6 WX6984 AND2_2448/X_u2-net6 VSS nmos W=0.31u L=0.04u
M4510 WX6981 AND2_2448/net6 VDD VDD pmos W=0.41u L=0.04u
M4511 AND2_2448/net6 RESET VDD VDD pmos W=0.41u L=0.04u
M4512 AND2_2448/net6 WX6984 VDD VDD pmos W=0.41u L=0.04u
M4513 WX6979 AND2_2447/net6 VSS VSS nmos W=0.31u L=0.04u
M4514 AND2_2447/X_u2-net6 RESET VSS VSS nmos W=0.31u L=0.04u
M4515 AND2_2447/net6 WX6982 AND2_2447/X_u2-net6 VSS nmos W=0.31u L=0.04u
M4516 WX6979 AND2_2447/net6 VDD VDD pmos W=0.41u L=0.04u
M4517 AND2_2447/net6 RESET VDD VDD pmos W=0.41u L=0.04u
M4518 AND2_2447/net6 WX6982 VDD VDD pmos W=0.41u L=0.04u
M4519 WX6977 AND2_2446/net6 VSS VSS nmos W=0.31u L=0.04u
M4520 AND2_2446/X_u2-net6 RESET VSS VSS nmos W=0.31u L=0.04u
M4521 AND2_2446/net6 WX6980 AND2_2446/X_u2-net6 VSS nmos W=0.31u L=0.04u
M4522 WX6977 AND2_2446/net6 VDD VDD pmos W=0.41u L=0.04u
M4523 AND2_2446/net6 RESET VDD VDD pmos W=0.41u L=0.04u
M4524 AND2_2446/net6 WX6980 VDD VDD pmos W=0.41u L=0.04u
M4525 WX6975 AND2_2445/net6 VSS VSS nmos W=0.31u L=0.04u
M4526 AND2_2445/X_u2-net6 RESET VSS VSS nmos W=0.31u L=0.04u
M4527 AND2_2445/net6 WX6978 AND2_2445/X_u2-net6 VSS nmos W=0.31u L=0.04u
M4528 WX6975 AND2_2445/net6 VDD VDD pmos W=0.41u L=0.04u
M4529 AND2_2445/net6 RESET VDD VDD pmos W=0.41u L=0.04u
M4530 AND2_2445/net6 WX6978 VDD VDD pmos W=0.41u L=0.04u
M4531 WX6973 AND2_2444/net6 VSS VSS nmos W=0.31u L=0.04u
M4532 AND2_2444/X_u2-net6 RESET VSS VSS nmos W=0.31u L=0.04u
M4533 AND2_2444/net6 WX6976 AND2_2444/X_u2-net6 VSS nmos W=0.31u L=0.04u
M4534 WX6973 AND2_2444/net6 VDD VDD pmos W=0.41u L=0.04u
M4535 AND2_2444/net6 RESET VDD VDD pmos W=0.41u L=0.04u
M4536 AND2_2444/net6 WX6976 VDD VDD pmos W=0.41u L=0.04u
M4537 WX6971 AND2_2443/net6 VSS VSS nmos W=0.31u L=0.04u
M4538 AND2_2443/X_u2-net6 RESET VSS VSS nmos W=0.31u L=0.04u
M4539 AND2_2443/net6 WX6974 AND2_2443/X_u2-net6 VSS nmos W=0.31u L=0.04u
M4540 WX6971 AND2_2443/net6 VDD VDD pmos W=0.41u L=0.04u
M4541 AND2_2443/net6 RESET VDD VDD pmos W=0.41u L=0.04u
M4542 AND2_2443/net6 WX6974 VDD VDD pmos W=0.41u L=0.04u
M4543 WX6969 AND2_2442/net6 VSS VSS nmos W=0.31u L=0.04u
M4544 AND2_2442/X_u2-net6 RESET VSS VSS nmos W=0.31u L=0.04u
M4545 AND2_2442/net6 WX6972 AND2_2442/X_u2-net6 VSS nmos W=0.31u L=0.04u
M4546 WX6969 AND2_2442/net6 VDD VDD pmos W=0.41u L=0.04u
M4547 AND2_2442/net6 RESET VDD VDD pmos W=0.41u L=0.04u
M4548 AND2_2442/net6 WX6972 VDD VDD pmos W=0.41u L=0.04u
M4549 WX6967 AND2_2441/net6 VSS VSS nmos W=0.31u L=0.04u
M4550 AND2_2441/X_u2-net6 RESET VSS VSS nmos W=0.31u L=0.04u
M4551 AND2_2441/net6 WX6970 AND2_2441/X_u2-net6 VSS nmos W=0.31u L=0.04u
M4552 WX6967 AND2_2441/net6 VDD VDD pmos W=0.41u L=0.04u
M4553 AND2_2441/net6 RESET VDD VDD pmos W=0.41u L=0.04u
M4554 AND2_2441/net6 WX6970 VDD VDD pmos W=0.41u L=0.04u
M4555 WX6965 AND2_2440/net6 VSS VSS nmos W=0.31u L=0.04u
M4556 AND2_2440/X_u2-net6 RESET VSS VSS nmos W=0.31u L=0.04u
M4557 AND2_2440/net6 WX6968 AND2_2440/X_u2-net6 VSS nmos W=0.31u L=0.04u
M4558 WX6965 AND2_2440/net6 VDD VDD pmos W=0.41u L=0.04u
M4559 AND2_2440/net6 RESET VDD VDD pmos W=0.41u L=0.04u
M4560 AND2_2440/net6 WX6968 VDD VDD pmos W=0.41u L=0.04u
M4561 WX6963 AND2_2439/net6 VSS VSS nmos W=0.31u L=0.04u
M4562 AND2_2439/X_u2-net6 RESET VSS VSS nmos W=0.31u L=0.04u
M4563 AND2_2439/net6 WX6966 AND2_2439/X_u2-net6 VSS nmos W=0.31u L=0.04u
M4564 WX6963 AND2_2439/net6 VDD VDD pmos W=0.41u L=0.04u
M4565 AND2_2439/net6 RESET VDD VDD pmos W=0.41u L=0.04u
M4566 AND2_2439/net6 WX6966 VDD VDD pmos W=0.41u L=0.04u
M4567 WX6961 AND2_2438/net6 VSS VSS nmos W=0.31u L=0.04u
M4568 AND2_2438/X_u2-net6 RESET VSS VSS nmos W=0.31u L=0.04u
M4569 AND2_2438/net6 WX6964 AND2_2438/X_u2-net6 VSS nmos W=0.31u L=0.04u
M4570 WX6961 AND2_2438/net6 VDD VDD pmos W=0.41u L=0.04u
M4571 AND2_2438/net6 RESET VDD VDD pmos W=0.41u L=0.04u
M4572 AND2_2438/net6 WX6964 VDD VDD pmos W=0.41u L=0.04u
M4573 WX6959 AND2_2437/net6 VSS VSS nmos W=0.31u L=0.04u
M4574 AND2_2437/X_u2-net6 RESET VSS VSS nmos W=0.31u L=0.04u
M4575 AND2_2437/net6 WX6962 AND2_2437/X_u2-net6 VSS nmos W=0.31u L=0.04u
M4576 WX6959 AND2_2437/net6 VDD VDD pmos W=0.41u L=0.04u
M4577 AND2_2437/net6 RESET VDD VDD pmos W=0.41u L=0.04u
M4578 AND2_2437/net6 WX6962 VDD VDD pmos W=0.41u L=0.04u
M4579 WX6957 AND2_2436/net6 VSS VSS nmos W=0.31u L=0.04u
M4580 AND2_2436/X_u2-net6 RESET VSS VSS nmos W=0.31u L=0.04u
M4581 AND2_2436/net6 WX6960 AND2_2436/X_u2-net6 VSS nmos W=0.31u L=0.04u
M4582 WX6957 AND2_2436/net6 VDD VDD pmos W=0.41u L=0.04u
M4583 AND2_2436/net6 RESET VDD VDD pmos W=0.41u L=0.04u
M4584 AND2_2436/net6 WX6960 VDD VDD pmos W=0.41u L=0.04u
M4585 WX6955 AND2_2435/net6 VSS VSS nmos W=0.31u L=0.04u
M4586 AND2_2435/X_u2-net6 RESET VSS VSS nmos W=0.31u L=0.04u
M4587 AND2_2435/net6 WX6958 AND2_2435/X_u2-net6 VSS nmos W=0.31u L=0.04u
M4588 WX6955 AND2_2435/net6 VDD VDD pmos W=0.41u L=0.04u
M4589 AND2_2435/net6 RESET VDD VDD pmos W=0.41u L=0.04u
M4590 AND2_2435/net6 WX6958 VDD VDD pmos W=0.41u L=0.04u
M4591 WX6953 AND2_2434/net6 VSS VSS nmos W=0.31u L=0.04u
M4592 AND2_2434/X_u2-net6 RESET VSS VSS nmos W=0.31u L=0.04u
M4593 AND2_2434/net6 WX6956 AND2_2434/X_u2-net6 VSS nmos W=0.31u L=0.04u
M4594 WX6953 AND2_2434/net6 VDD VDD pmos W=0.41u L=0.04u
M4595 AND2_2434/net6 RESET VDD VDD pmos W=0.41u L=0.04u
M4596 AND2_2434/net6 WX6956 VDD VDD pmos W=0.41u L=0.04u
M4597 WX6951 AND2_2433/net6 VSS VSS nmos W=0.31u L=0.04u
M4598 AND2_2433/X_u2-net6 RESET VSS VSS nmos W=0.31u L=0.04u
M4599 AND2_2433/net6 WX6954 AND2_2433/X_u2-net6 VSS nmos W=0.31u L=0.04u
M4600 WX6951 AND2_2433/net6 VDD VDD pmos W=0.41u L=0.04u
M4601 AND2_2433/net6 RESET VDD VDD pmos W=0.41u L=0.04u
M4602 AND2_2433/net6 WX6954 VDD VDD pmos W=0.41u L=0.04u
M4603 WX6949 AND2_2432/net6 VSS VSS nmos W=0.31u L=0.04u
M4604 AND2_2432/X_u2-net6 RESET VSS VSS nmos W=0.31u L=0.04u
M4605 AND2_2432/net6 WX6952 AND2_2432/X_u2-net6 VSS nmos W=0.31u L=0.04u
M4606 WX6949 AND2_2432/net6 VDD VDD pmos W=0.41u L=0.04u
M4607 AND2_2432/net6 RESET VDD VDD pmos W=0.41u L=0.04u
M4608 AND2_2432/net6 WX6952 VDD VDD pmos W=0.41u L=0.04u
M4609 WX6498 AND2_2239/net6 VSS VSS nmos W=0.31u L=0.04u
M4610 AND2_2239/X_u2-net6 RESET VSS VSS nmos W=0.31u L=0.04u
M4611 AND2_2239/net6 n1080 AND2_2239/X_u2-net6 VSS nmos W=0.31u L=0.04u
M4612 WX6498 AND2_2239/net6 VDD VDD pmos W=0.41u L=0.04u
M4613 AND2_2239/net6 RESET VDD VDD pmos W=0.41u L=0.04u
M4614 AND2_2239/net6 n1080 VDD VDD pmos W=0.41u L=0.04u
M4615 WX6496 AND2_2238/net6 VSS VSS nmos W=0.31u L=0.04u
M4616 AND2_2238/X_u2-net6 RESET VSS VSS nmos W=0.31u L=0.04u
M4617 AND2_2238/net6 n1081 AND2_2238/X_u2-net6 VSS nmos W=0.31u L=0.04u
M4618 WX6496 AND2_2238/net6 VDD VDD pmos W=0.41u L=0.04u
M4619 AND2_2238/net6 RESET VDD VDD pmos W=0.41u L=0.04u
M4620 AND2_2238/net6 n1081 VDD VDD pmos W=0.41u L=0.04u
M4621 WX6494 AND2_2237/net6 VSS VSS nmos W=0.31u L=0.04u
M4622 AND2_2237/X_u2-net6 RESET VSS VSS nmos W=0.31u L=0.04u
M4623 AND2_2237/net6 n1082 AND2_2237/X_u2-net6 VSS nmos W=0.31u L=0.04u
M4624 WX6494 AND2_2237/net6 VDD VDD pmos W=0.41u L=0.04u
M4625 AND2_2237/net6 RESET VDD VDD pmos W=0.41u L=0.04u
M4626 AND2_2237/net6 n1082 VDD VDD pmos W=0.41u L=0.04u
M4627 WX6492 AND2_2236/net6 VSS VSS nmos W=0.31u L=0.04u
M4628 AND2_2236/X_u2-net6 RESET VSS VSS nmos W=0.31u L=0.04u
M4629 AND2_2236/net6 n1083 AND2_2236/X_u2-net6 VSS nmos W=0.31u L=0.04u
M4630 WX6492 AND2_2236/net6 VDD VDD pmos W=0.41u L=0.04u
M4631 AND2_2236/net6 RESET VDD VDD pmos W=0.41u L=0.04u
M4632 AND2_2236/net6 n1083 VDD VDD pmos W=0.41u L=0.04u
M4633 WX6490 AND2_2235/net6 VSS VSS nmos W=0.31u L=0.04u
M4634 AND2_2235/X_u2-net6 RESET VSS VSS nmos W=0.31u L=0.04u
M4635 AND2_2235/net6 n1084 AND2_2235/X_u2-net6 VSS nmos W=0.31u L=0.04u
M4636 WX6490 AND2_2235/net6 VDD VDD pmos W=0.41u L=0.04u
M4637 AND2_2235/net6 RESET VDD VDD pmos W=0.41u L=0.04u
M4638 AND2_2235/net6 n1084 VDD VDD pmos W=0.41u L=0.04u
M4639 WX6488 AND2_2234/net6 VSS VSS nmos W=0.31u L=0.04u
M4640 AND2_2234/X_u2-net6 RESET VSS VSS nmos W=0.31u L=0.04u
M4641 AND2_2234/net6 n1085 AND2_2234/X_u2-net6 VSS nmos W=0.31u L=0.04u
M4642 WX6488 AND2_2234/net6 VDD VDD pmos W=0.41u L=0.04u
M4643 AND2_2234/net6 RESET VDD VDD pmos W=0.41u L=0.04u
M4644 AND2_2234/net6 n1085 VDD VDD pmos W=0.41u L=0.04u
M4645 WX6486 AND2_2233/net6 VSS VSS nmos W=0.31u L=0.04u
M4646 AND2_2233/X_u2-net6 RESET VSS VSS nmos W=0.31u L=0.04u
M4647 AND2_2233/net6 n1086 AND2_2233/X_u2-net6 VSS nmos W=0.31u L=0.04u
M4648 WX6486 AND2_2233/net6 VDD VDD pmos W=0.41u L=0.04u
M4649 AND2_2233/net6 RESET VDD VDD pmos W=0.41u L=0.04u
M4650 AND2_2233/net6 n1086 VDD VDD pmos W=0.41u L=0.04u
M4651 WX6484 AND2_2232/net6 VSS VSS nmos W=0.31u L=0.04u
M4652 AND2_2232/X_u2-net6 RESET VSS VSS nmos W=0.31u L=0.04u
M4653 AND2_2232/net6 n1087 AND2_2232/X_u2-net6 VSS nmos W=0.31u L=0.04u
M4654 WX6484 AND2_2232/net6 VDD VDD pmos W=0.41u L=0.04u
M4655 AND2_2232/net6 RESET VDD VDD pmos W=0.41u L=0.04u
M4656 AND2_2232/net6 n1087 VDD VDD pmos W=0.41u L=0.04u
M4657 WX6482 AND2_2231/net6 VSS VSS nmos W=0.31u L=0.04u
M4658 AND2_2231/X_u2-net6 RESET VSS VSS nmos W=0.31u L=0.04u
M4659 AND2_2231/net6 n1088 AND2_2231/X_u2-net6 VSS nmos W=0.31u L=0.04u
M4660 WX6482 AND2_2231/net6 VDD VDD pmos W=0.41u L=0.04u
M4661 AND2_2231/net6 RESET VDD VDD pmos W=0.41u L=0.04u
M4662 AND2_2231/net6 n1088 VDD VDD pmos W=0.41u L=0.04u
M4663 WX6480 AND2_2230/net6 VSS VSS nmos W=0.31u L=0.04u
M4664 AND2_2230/X_u2-net6 RESET VSS VSS nmos W=0.31u L=0.04u
M4665 AND2_2230/net6 n1089 AND2_2230/X_u2-net6 VSS nmos W=0.31u L=0.04u
M4666 WX6480 AND2_2230/net6 VDD VDD pmos W=0.41u L=0.04u
M4667 AND2_2230/net6 RESET VDD VDD pmos W=0.41u L=0.04u
M4668 AND2_2230/net6 n1089 VDD VDD pmos W=0.41u L=0.04u
M4669 WX6478 AND2_2229/net6 VSS VSS nmos W=0.31u L=0.04u
M4670 AND2_2229/X_u2-net6 RESET VSS VSS nmos W=0.31u L=0.04u
M4671 AND2_2229/net6 n1090 AND2_2229/X_u2-net6 VSS nmos W=0.31u L=0.04u
M4672 WX6478 AND2_2229/net6 VDD VDD pmos W=0.41u L=0.04u
M4673 AND2_2229/net6 RESET VDD VDD pmos W=0.41u L=0.04u
M4674 AND2_2229/net6 n1090 VDD VDD pmos W=0.41u L=0.04u
M4675 WX6476 AND2_2228/net6 VSS VSS nmos W=0.31u L=0.04u
M4676 AND2_2228/X_u2-net6 RESET VSS VSS nmos W=0.31u L=0.04u
M4677 AND2_2228/net6 n1091 AND2_2228/X_u2-net6 VSS nmos W=0.31u L=0.04u
M4678 WX6476 AND2_2228/net6 VDD VDD pmos W=0.41u L=0.04u
M4679 AND2_2228/net6 RESET VDD VDD pmos W=0.41u L=0.04u
M4680 AND2_2228/net6 n1091 VDD VDD pmos W=0.41u L=0.04u
M4681 WX6474 AND2_2227/net6 VSS VSS nmos W=0.31u L=0.04u
M4682 AND2_2227/X_u2-net6 RESET VSS VSS nmos W=0.31u L=0.04u
M4683 AND2_2227/net6 n1092 AND2_2227/X_u2-net6 VSS nmos W=0.31u L=0.04u
M4684 WX6474 AND2_2227/net6 VDD VDD pmos W=0.41u L=0.04u
M4685 AND2_2227/net6 RESET VDD VDD pmos W=0.41u L=0.04u
M4686 AND2_2227/net6 n1092 VDD VDD pmos W=0.41u L=0.04u
M4687 WX6472 AND2_2226/net6 VSS VSS nmos W=0.31u L=0.04u
M4688 AND2_2226/X_u2-net6 RESET VSS VSS nmos W=0.31u L=0.04u
M4689 AND2_2226/net6 n1093 AND2_2226/X_u2-net6 VSS nmos W=0.31u L=0.04u
M4690 WX6472 AND2_2226/net6 VDD VDD pmos W=0.41u L=0.04u
M4691 AND2_2226/net6 RESET VDD VDD pmos W=0.41u L=0.04u
M4692 AND2_2226/net6 n1093 VDD VDD pmos W=0.41u L=0.04u
M4693 WX6470 AND2_2225/net6 VSS VSS nmos W=0.31u L=0.04u
M4694 AND2_2225/X_u2-net6 RESET VSS VSS nmos W=0.31u L=0.04u
M4695 AND2_2225/net6 n1094 AND2_2225/X_u2-net6 VSS nmos W=0.31u L=0.04u
M4696 WX6470 AND2_2225/net6 VDD VDD pmos W=0.41u L=0.04u
M4697 AND2_2225/net6 RESET VDD VDD pmos W=0.41u L=0.04u
M4698 AND2_2225/net6 n1094 VDD VDD pmos W=0.41u L=0.04u
M4699 WX6468 AND2_2224/net6 VSS VSS nmos W=0.31u L=0.04u
M4700 AND2_2224/X_u2-net6 RESET VSS VSS nmos W=0.31u L=0.04u
M4701 AND2_2224/net6 n1095 AND2_2224/X_u2-net6 VSS nmos W=0.31u L=0.04u
M4702 WX6468 AND2_2224/net6 VDD VDD pmos W=0.41u L=0.04u
M4703 AND2_2224/net6 RESET VDD VDD pmos W=0.41u L=0.04u
M4704 AND2_2224/net6 n1095 VDD VDD pmos W=0.41u L=0.04u
M4705 WX6466 AND2_2223/net6 VSS VSS nmos W=0.31u L=0.04u
M4706 AND2_2223/X_u2-net6 RESET VSS VSS nmos W=0.31u L=0.04u
M4707 AND2_2223/net6 n1096 AND2_2223/X_u2-net6 VSS nmos W=0.31u L=0.04u
M4708 WX6466 AND2_2223/net6 VDD VDD pmos W=0.41u L=0.04u
M4709 AND2_2223/net6 RESET VDD VDD pmos W=0.41u L=0.04u
M4710 AND2_2223/net6 n1096 VDD VDD pmos W=0.41u L=0.04u
M4711 WX6464 AND2_2222/net6 VSS VSS nmos W=0.31u L=0.04u
M4712 AND2_2222/X_u2-net6 RESET VSS VSS nmos W=0.31u L=0.04u
M4713 AND2_2222/net6 n1097 AND2_2222/X_u2-net6 VSS nmos W=0.31u L=0.04u
M4714 WX6464 AND2_2222/net6 VDD VDD pmos W=0.41u L=0.04u
M4715 AND2_2222/net6 RESET VDD VDD pmos W=0.41u L=0.04u
M4716 AND2_2222/net6 n1097 VDD VDD pmos W=0.41u L=0.04u
M4717 WX6462 AND2_2221/net6 VSS VSS nmos W=0.31u L=0.04u
M4718 AND2_2221/X_u2-net6 RESET VSS VSS nmos W=0.31u L=0.04u
M4719 AND2_2221/net6 n1098 AND2_2221/X_u2-net6 VSS nmos W=0.31u L=0.04u
M4720 WX6462 AND2_2221/net6 VDD VDD pmos W=0.41u L=0.04u
M4721 AND2_2221/net6 RESET VDD VDD pmos W=0.41u L=0.04u
M4722 AND2_2221/net6 n1098 VDD VDD pmos W=0.41u L=0.04u
M4723 WX6460 AND2_2220/net6 VSS VSS nmos W=0.31u L=0.04u
M4724 AND2_2220/X_u2-net6 RESET VSS VSS nmos W=0.31u L=0.04u
M4725 AND2_2220/net6 n1099 AND2_2220/X_u2-net6 VSS nmos W=0.31u L=0.04u
M4726 WX6460 AND2_2220/net6 VDD VDD pmos W=0.41u L=0.04u
M4727 AND2_2220/net6 RESET VDD VDD pmos W=0.41u L=0.04u
M4728 AND2_2220/net6 n1099 VDD VDD pmos W=0.41u L=0.04u
M4729 WX6458 AND2_2219/net6 VSS VSS nmos W=0.31u L=0.04u
M4730 AND2_2219/X_u2-net6 RESET VSS VSS nmos W=0.31u L=0.04u
M4731 AND2_2219/net6 n1100 AND2_2219/X_u2-net6 VSS nmos W=0.31u L=0.04u
M4732 WX6458 AND2_2219/net6 VDD VDD pmos W=0.41u L=0.04u
M4733 AND2_2219/net6 RESET VDD VDD pmos W=0.41u L=0.04u
M4734 AND2_2219/net6 n1100 VDD VDD pmos W=0.41u L=0.04u
M4735 WX6456 AND2_2218/net6 VSS VSS nmos W=0.31u L=0.04u
M4736 AND2_2218/X_u2-net6 RESET VSS VSS nmos W=0.31u L=0.04u
M4737 AND2_2218/net6 n1101 AND2_2218/X_u2-net6 VSS nmos W=0.31u L=0.04u
M4738 WX6456 AND2_2218/net6 VDD VDD pmos W=0.41u L=0.04u
M4739 AND2_2218/net6 RESET VDD VDD pmos W=0.41u L=0.04u
M4740 AND2_2218/net6 n1101 VDD VDD pmos W=0.41u L=0.04u
M4741 WX6454 AND2_2217/net6 VSS VSS nmos W=0.31u L=0.04u
M4742 AND2_2217/X_u2-net6 RESET VSS VSS nmos W=0.31u L=0.04u
M4743 AND2_2217/net6 n1102 AND2_2217/X_u2-net6 VSS nmos W=0.31u L=0.04u
M4744 WX6454 AND2_2217/net6 VDD VDD pmos W=0.41u L=0.04u
M4745 AND2_2217/net6 RESET VDD VDD pmos W=0.41u L=0.04u
M4746 AND2_2217/net6 n1102 VDD VDD pmos W=0.41u L=0.04u
M4747 WX6452 AND2_2216/net6 VSS VSS nmos W=0.31u L=0.04u
M4748 AND2_2216/X_u2-net6 RESET VSS VSS nmos W=0.31u L=0.04u
M4749 AND2_2216/net6 n1103 AND2_2216/X_u2-net6 VSS nmos W=0.31u L=0.04u
M4750 WX6452 AND2_2216/net6 VDD VDD pmos W=0.41u L=0.04u
M4751 AND2_2216/net6 RESET VDD VDD pmos W=0.41u L=0.04u
M4752 AND2_2216/net6 n1103 VDD VDD pmos W=0.41u L=0.04u
M4753 WX6450 AND2_2215/net6 VSS VSS nmos W=0.31u L=0.04u
M4754 AND2_2215/X_u2-net6 RESET VSS VSS nmos W=0.31u L=0.04u
M4755 AND2_2215/net6 n1104 AND2_2215/X_u2-net6 VSS nmos W=0.31u L=0.04u
M4756 WX6450 AND2_2215/net6 VDD VDD pmos W=0.41u L=0.04u
M4757 AND2_2215/net6 RESET VDD VDD pmos W=0.41u L=0.04u
M4758 AND2_2215/net6 n1104 VDD VDD pmos W=0.41u L=0.04u
M4759 WX6448 AND2_2214/net6 VSS VSS nmos W=0.31u L=0.04u
M4760 AND2_2214/X_u2-net6 RESET VSS VSS nmos W=0.31u L=0.04u
M4761 AND2_2214/net6 n1105 AND2_2214/X_u2-net6 VSS nmos W=0.31u L=0.04u
M4762 WX6448 AND2_2214/net6 VDD VDD pmos W=0.41u L=0.04u
M4763 AND2_2214/net6 RESET VDD VDD pmos W=0.41u L=0.04u
M4764 AND2_2214/net6 n1105 VDD VDD pmos W=0.41u L=0.04u
M4765 WX6446 AND2_2213/net6 VSS VSS nmos W=0.31u L=0.04u
M4766 AND2_2213/X_u2-net6 RESET VSS VSS nmos W=0.31u L=0.04u
M4767 AND2_2213/net6 n1106 AND2_2213/X_u2-net6 VSS nmos W=0.31u L=0.04u
M4768 WX6446 AND2_2213/net6 VDD VDD pmos W=0.41u L=0.04u
M4769 AND2_2213/net6 RESET VDD VDD pmos W=0.41u L=0.04u
M4770 AND2_2213/net6 n1106 VDD VDD pmos W=0.41u L=0.04u
M4771 WX6444 AND2_2212/net6 VSS VSS nmos W=0.31u L=0.04u
M4772 AND2_2212/X_u2-net6 RESET VSS VSS nmos W=0.31u L=0.04u
M4773 AND2_2212/net6 n1107 AND2_2212/X_u2-net6 VSS nmos W=0.31u L=0.04u
M4774 WX6444 AND2_2212/net6 VDD VDD pmos W=0.41u L=0.04u
M4775 AND2_2212/net6 RESET VDD VDD pmos W=0.41u L=0.04u
M4776 AND2_2212/net6 n1107 VDD VDD pmos W=0.41u L=0.04u
M4777 WX6442 AND2_2211/net6 VSS VSS nmos W=0.31u L=0.04u
M4778 AND2_2211/X_u2-net6 RESET VSS VSS nmos W=0.31u L=0.04u
M4779 AND2_2211/net6 n1108 AND2_2211/X_u2-net6 VSS nmos W=0.31u L=0.04u
M4780 WX6442 AND2_2211/net6 VDD VDD pmos W=0.41u L=0.04u
M4781 AND2_2211/net6 RESET VDD VDD pmos W=0.41u L=0.04u
M4782 AND2_2211/net6 n1108 VDD VDD pmos W=0.41u L=0.04u
M4783 WX6440 AND2_2210/net6 VSS VSS nmos W=0.31u L=0.04u
M4784 AND2_2210/X_u2-net6 RESET VSS VSS nmos W=0.31u L=0.04u
M4785 AND2_2210/net6 n1109 AND2_2210/X_u2-net6 VSS nmos W=0.31u L=0.04u
M4786 WX6440 AND2_2210/net6 VDD VDD pmos W=0.41u L=0.04u
M4787 AND2_2210/net6 RESET VDD VDD pmos W=0.41u L=0.04u
M4788 AND2_2210/net6 n1109 VDD VDD pmos W=0.41u L=0.04u
M4789 WX6438 AND2_2209/net6 VSS VSS nmos W=0.31u L=0.04u
M4790 AND2_2209/X_u2-net6 RESET VSS VSS nmos W=0.31u L=0.04u
M4791 AND2_2209/net6 n1110 AND2_2209/X_u2-net6 VSS nmos W=0.31u L=0.04u
M4792 WX6438 AND2_2209/net6 VDD VDD pmos W=0.41u L=0.04u
M4793 AND2_2209/net6 RESET VDD VDD pmos W=0.41u L=0.04u
M4794 AND2_2209/net6 n1110 VDD VDD pmos W=0.41u L=0.04u
M4795 WX6436 AND2_2208/net6 VSS VSS nmos W=0.31u L=0.04u
M4796 AND2_2208/X_u2-net6 RESET VSS VSS nmos W=0.31u L=0.04u
M4797 AND2_2208/net6 n1111 AND2_2208/X_u2-net6 VSS nmos W=0.31u L=0.04u
M4798 WX6436 AND2_2208/net6 VDD VDD pmos W=0.41u L=0.04u
M4799 AND2_2208/net6 RESET VDD VDD pmos W=0.41u L=0.04u
M4800 AND2_2208/net6 n1111 VDD VDD pmos W=0.41u L=0.04u
M4801 WX6070 AND2_2143/net6 VSS VSS nmos W=0.31u L=0.04u
M4802 AND2_2143/X_u2-net6 RESET VSS VSS nmos W=0.31u L=0.04u
M4803 AND2_2143/net6 WX6007 AND2_2143/X_u2-net6 VSS nmos W=0.31u L=0.04u
M4804 WX6070 AND2_2143/net6 VDD VDD pmos W=0.41u L=0.04u
M4805 AND2_2143/net6 RESET VDD VDD pmos W=0.41u L=0.04u
M4806 AND2_2143/net6 WX6007 VDD VDD pmos W=0.41u L=0.04u
M4807 WX6068 AND2_2142/net6 VSS VSS nmos W=0.31u L=0.04u
M4808 AND2_2142/X_u2-net6 RESET VSS VSS nmos W=0.31u L=0.04u
M4809 AND2_2142/net6 WX6005 AND2_2142/X_u2-net6 VSS nmos W=0.31u L=0.04u
M4810 WX6068 AND2_2142/net6 VDD VDD pmos W=0.41u L=0.04u
M4811 AND2_2142/net6 RESET VDD VDD pmos W=0.41u L=0.04u
M4812 AND2_2142/net6 WX6005 VDD VDD pmos W=0.41u L=0.04u
M4813 WX6066 AND2_2141/net6 VSS VSS nmos W=0.31u L=0.04u
M4814 AND2_2141/X_u2-net6 RESET VSS VSS nmos W=0.31u L=0.04u
M4815 AND2_2141/net6 WX6003 AND2_2141/X_u2-net6 VSS nmos W=0.31u L=0.04u
M4816 WX6066 AND2_2141/net6 VDD VDD pmos W=0.41u L=0.04u
M4817 AND2_2141/net6 RESET VDD VDD pmos W=0.41u L=0.04u
M4818 AND2_2141/net6 WX6003 VDD VDD pmos W=0.41u L=0.04u
M4819 WX6064 AND2_2140/net6 VSS VSS nmos W=0.31u L=0.04u
M4820 AND2_2140/X_u2-net6 RESET VSS VSS nmos W=0.31u L=0.04u
M4821 AND2_2140/net6 WX6001 AND2_2140/X_u2-net6 VSS nmos W=0.31u L=0.04u
M4822 WX6064 AND2_2140/net6 VDD VDD pmos W=0.41u L=0.04u
M4823 AND2_2140/net6 RESET VDD VDD pmos W=0.41u L=0.04u
M4824 AND2_2140/net6 WX6001 VDD VDD pmos W=0.41u L=0.04u
M4825 WX6062 AND2_2139/net6 VSS VSS nmos W=0.31u L=0.04u
M4826 AND2_2139/X_u2-net6 RESET VSS VSS nmos W=0.31u L=0.04u
M4827 AND2_2139/net6 WX5999 AND2_2139/X_u2-net6 VSS nmos W=0.31u L=0.04u
M4828 WX6062 AND2_2139/net6 VDD VDD pmos W=0.41u L=0.04u
M4829 AND2_2139/net6 RESET VDD VDD pmos W=0.41u L=0.04u
M4830 AND2_2139/net6 WX5999 VDD VDD pmos W=0.41u L=0.04u
M4831 WX6060 AND2_2138/net6 VSS VSS nmos W=0.31u L=0.04u
M4832 AND2_2138/X_u2-net6 RESET VSS VSS nmos W=0.31u L=0.04u
M4833 AND2_2138/net6 WX5997 AND2_2138/X_u2-net6 VSS nmos W=0.31u L=0.04u
M4834 WX6060 AND2_2138/net6 VDD VDD pmos W=0.41u L=0.04u
M4835 AND2_2138/net6 RESET VDD VDD pmos W=0.41u L=0.04u
M4836 AND2_2138/net6 WX5997 VDD VDD pmos W=0.41u L=0.04u
M4837 WX6058 AND2_2137/net6 VSS VSS nmos W=0.31u L=0.04u
M4838 AND2_2137/X_u2-net6 RESET VSS VSS nmos W=0.31u L=0.04u
M4839 AND2_2137/net6 WX5995 AND2_2137/X_u2-net6 VSS nmos W=0.31u L=0.04u
M4840 WX6058 AND2_2137/net6 VDD VDD pmos W=0.41u L=0.04u
M4841 AND2_2137/net6 RESET VDD VDD pmos W=0.41u L=0.04u
M4842 AND2_2137/net6 WX5995 VDD VDD pmos W=0.41u L=0.04u
M4843 WX6056 AND2_2136/net6 VSS VSS nmos W=0.31u L=0.04u
M4844 AND2_2136/X_u2-net6 RESET VSS VSS nmos W=0.31u L=0.04u
M4845 AND2_2136/net6 WX5993 AND2_2136/X_u2-net6 VSS nmos W=0.31u L=0.04u
M4846 WX6056 AND2_2136/net6 VDD VDD pmos W=0.41u L=0.04u
M4847 AND2_2136/net6 RESET VDD VDD pmos W=0.41u L=0.04u
M4848 AND2_2136/net6 WX5993 VDD VDD pmos W=0.41u L=0.04u
M4849 WX6054 AND2_2135/net6 VSS VSS nmos W=0.31u L=0.04u
M4850 AND2_2135/X_u2-net6 RESET VSS VSS nmos W=0.31u L=0.04u
M4851 AND2_2135/net6 WX5991 AND2_2135/X_u2-net6 VSS nmos W=0.31u L=0.04u
M4852 WX6054 AND2_2135/net6 VDD VDD pmos W=0.41u L=0.04u
M4853 AND2_2135/net6 RESET VDD VDD pmos W=0.41u L=0.04u
M4854 AND2_2135/net6 WX5991 VDD VDD pmos W=0.41u L=0.04u
M4855 WX6052 AND2_2134/net6 VSS VSS nmos W=0.31u L=0.04u
M4856 AND2_2134/X_u2-net6 RESET VSS VSS nmos W=0.31u L=0.04u
M4857 AND2_2134/net6 WX5989 AND2_2134/X_u2-net6 VSS nmos W=0.31u L=0.04u
M4858 WX6052 AND2_2134/net6 VDD VDD pmos W=0.41u L=0.04u
M4859 AND2_2134/net6 RESET VDD VDD pmos W=0.41u L=0.04u
M4860 AND2_2134/net6 WX5989 VDD VDD pmos W=0.41u L=0.04u
M4861 WX6050 AND2_2133/net6 VSS VSS nmos W=0.31u L=0.04u
M4862 AND2_2133/X_u2-net6 RESET VSS VSS nmos W=0.31u L=0.04u
M4863 AND2_2133/net6 WX5987 AND2_2133/X_u2-net6 VSS nmos W=0.31u L=0.04u
M4864 WX6050 AND2_2133/net6 VDD VDD pmos W=0.41u L=0.04u
M4865 AND2_2133/net6 RESET VDD VDD pmos W=0.41u L=0.04u
M4866 AND2_2133/net6 WX5987 VDD VDD pmos W=0.41u L=0.04u
M4867 WX6048 AND2_2132/net6 VSS VSS nmos W=0.31u L=0.04u
M4868 AND2_2132/X_u2-net6 RESET VSS VSS nmos W=0.31u L=0.04u
M4869 AND2_2132/net6 WX5985 AND2_2132/X_u2-net6 VSS nmos W=0.31u L=0.04u
M4870 WX6048 AND2_2132/net6 VDD VDD pmos W=0.41u L=0.04u
M4871 AND2_2132/net6 RESET VDD VDD pmos W=0.41u L=0.04u
M4872 AND2_2132/net6 WX5985 VDD VDD pmos W=0.41u L=0.04u
M4873 WX6046 AND2_2131/net6 VSS VSS nmos W=0.31u L=0.04u
M4874 AND2_2131/X_u2-net6 RESET VSS VSS nmos W=0.31u L=0.04u
M4875 AND2_2131/net6 WX5983 AND2_2131/X_u2-net6 VSS nmos W=0.31u L=0.04u
M4876 WX6046 AND2_2131/net6 VDD VDD pmos W=0.41u L=0.04u
M4877 AND2_2131/net6 RESET VDD VDD pmos W=0.41u L=0.04u
M4878 AND2_2131/net6 WX5983 VDD VDD pmos W=0.41u L=0.04u
M4879 WX6044 AND2_2130/net6 VSS VSS nmos W=0.31u L=0.04u
M4880 AND2_2130/X_u2-net6 RESET VSS VSS nmos W=0.31u L=0.04u
M4881 AND2_2130/net6 WX5981 AND2_2130/X_u2-net6 VSS nmos W=0.31u L=0.04u
M4882 WX6044 AND2_2130/net6 VDD VDD pmos W=0.41u L=0.04u
M4883 AND2_2130/net6 RESET VDD VDD pmos W=0.41u L=0.04u
M4884 AND2_2130/net6 WX5981 VDD VDD pmos W=0.41u L=0.04u
M4885 WX6042 AND2_2129/net6 VSS VSS nmos W=0.31u L=0.04u
M4886 AND2_2129/X_u2-net6 RESET VSS VSS nmos W=0.31u L=0.04u
M4887 AND2_2129/net6 WX5979 AND2_2129/X_u2-net6 VSS nmos W=0.31u L=0.04u
M4888 WX6042 AND2_2129/net6 VDD VDD pmos W=0.41u L=0.04u
M4889 AND2_2129/net6 RESET VDD VDD pmos W=0.41u L=0.04u
M4890 AND2_2129/net6 WX5979 VDD VDD pmos W=0.41u L=0.04u
M4891 WX6040 AND2_2128/net6 VSS VSS nmos W=0.31u L=0.04u
M4892 AND2_2128/X_u2-net6 RESET VSS VSS nmos W=0.31u L=0.04u
M4893 AND2_2128/net6 WX5977 AND2_2128/X_u2-net6 VSS nmos W=0.31u L=0.04u
M4894 WX6040 AND2_2128/net6 VDD VDD pmos W=0.41u L=0.04u
M4895 AND2_2128/net6 RESET VDD VDD pmos W=0.41u L=0.04u
M4896 AND2_2128/net6 WX5977 VDD VDD pmos W=0.41u L=0.04u
M4897 WX6038 AND2_2127/net6 VSS VSS nmos W=0.31u L=0.04u
M4898 AND2_2127/X_u2-net6 RESET VSS VSS nmos W=0.31u L=0.04u
M4899 AND2_2127/net6 WX5975 AND2_2127/X_u2-net6 VSS nmos W=0.31u L=0.04u
M4900 WX6038 AND2_2127/net6 VDD VDD pmos W=0.41u L=0.04u
M4901 AND2_2127/net6 RESET VDD VDD pmos W=0.41u L=0.04u
M4902 AND2_2127/net6 WX5975 VDD VDD pmos W=0.41u L=0.04u
M4903 WX6036 AND2_2126/net6 VSS VSS nmos W=0.31u L=0.04u
M4904 AND2_2126/X_u2-net6 RESET VSS VSS nmos W=0.31u L=0.04u
M4905 AND2_2126/net6 WX5973 AND2_2126/X_u2-net6 VSS nmos W=0.31u L=0.04u
M4906 WX6036 AND2_2126/net6 VDD VDD pmos W=0.41u L=0.04u
M4907 AND2_2126/net6 RESET VDD VDD pmos W=0.41u L=0.04u
M4908 AND2_2126/net6 WX5973 VDD VDD pmos W=0.41u L=0.04u
M4909 WX6034 AND2_2125/net6 VSS VSS nmos W=0.31u L=0.04u
M4910 AND2_2125/X_u2-net6 RESET VSS VSS nmos W=0.31u L=0.04u
M4911 AND2_2125/net6 WX5971 AND2_2125/X_u2-net6 VSS nmos W=0.31u L=0.04u
M4912 WX6034 AND2_2125/net6 VDD VDD pmos W=0.41u L=0.04u
M4913 AND2_2125/net6 RESET VDD VDD pmos W=0.41u L=0.04u
M4914 AND2_2125/net6 WX5971 VDD VDD pmos W=0.41u L=0.04u
M4915 WX6032 AND2_2124/net6 VSS VSS nmos W=0.31u L=0.04u
M4916 AND2_2124/X_u2-net6 RESET VSS VSS nmos W=0.31u L=0.04u
M4917 AND2_2124/net6 WX5969 AND2_2124/X_u2-net6 VSS nmos W=0.31u L=0.04u
M4918 WX6032 AND2_2124/net6 VDD VDD pmos W=0.41u L=0.04u
M4919 AND2_2124/net6 RESET VDD VDD pmos W=0.41u L=0.04u
M4920 AND2_2124/net6 WX5969 VDD VDD pmos W=0.41u L=0.04u
M4921 WX6030 AND2_2123/net6 VSS VSS nmos W=0.31u L=0.04u
M4922 AND2_2123/X_u2-net6 RESET VSS VSS nmos W=0.31u L=0.04u
M4923 AND2_2123/net6 WX5967 AND2_2123/X_u2-net6 VSS nmos W=0.31u L=0.04u
M4924 WX6030 AND2_2123/net6 VDD VDD pmos W=0.41u L=0.04u
M4925 AND2_2123/net6 RESET VDD VDD pmos W=0.41u L=0.04u
M4926 AND2_2123/net6 WX5967 VDD VDD pmos W=0.41u L=0.04u
M4927 WX6028 AND2_2122/net6 VSS VSS nmos W=0.31u L=0.04u
M4928 AND2_2122/X_u2-net6 RESET VSS VSS nmos W=0.31u L=0.04u
M4929 AND2_2122/net6 WX5965 AND2_2122/X_u2-net6 VSS nmos W=0.31u L=0.04u
M4930 WX6028 AND2_2122/net6 VDD VDD pmos W=0.41u L=0.04u
M4931 AND2_2122/net6 RESET VDD VDD pmos W=0.41u L=0.04u
M4932 AND2_2122/net6 WX5965 VDD VDD pmos W=0.41u L=0.04u
M4933 WX6026 AND2_2121/net6 VSS VSS nmos W=0.31u L=0.04u
M4934 AND2_2121/X_u2-net6 RESET VSS VSS nmos W=0.31u L=0.04u
M4935 AND2_2121/net6 WX5963 AND2_2121/X_u2-net6 VSS nmos W=0.31u L=0.04u
M4936 WX6026 AND2_2121/net6 VDD VDD pmos W=0.41u L=0.04u
M4937 AND2_2121/net6 RESET VDD VDD pmos W=0.41u L=0.04u
M4938 AND2_2121/net6 WX5963 VDD VDD pmos W=0.41u L=0.04u
M4939 WX6024 AND2_2120/net6 VSS VSS nmos W=0.31u L=0.04u
M4940 AND2_2120/X_u2-net6 RESET VSS VSS nmos W=0.31u L=0.04u
M4941 AND2_2120/net6 WX5961 AND2_2120/X_u2-net6 VSS nmos W=0.31u L=0.04u
M4942 WX6024 AND2_2120/net6 VDD VDD pmos W=0.41u L=0.04u
M4943 AND2_2120/net6 RESET VDD VDD pmos W=0.41u L=0.04u
M4944 AND2_2120/net6 WX5961 VDD VDD pmos W=0.41u L=0.04u
M4945 WX6022 AND2_2119/net6 VSS VSS nmos W=0.31u L=0.04u
M4946 AND2_2119/X_u2-net6 RESET VSS VSS nmos W=0.31u L=0.04u
M4947 AND2_2119/net6 WX5959 AND2_2119/X_u2-net6 VSS nmos W=0.31u L=0.04u
M4948 WX6022 AND2_2119/net6 VDD VDD pmos W=0.41u L=0.04u
M4949 AND2_2119/net6 RESET VDD VDD pmos W=0.41u L=0.04u
M4950 AND2_2119/net6 WX5959 VDD VDD pmos W=0.41u L=0.04u
M4951 WX6020 AND2_2118/net6 VSS VSS nmos W=0.31u L=0.04u
M4952 AND2_2118/X_u2-net6 RESET VSS VSS nmos W=0.31u L=0.04u
M4953 AND2_2118/net6 WX5957 AND2_2118/X_u2-net6 VSS nmos W=0.31u L=0.04u
M4954 WX6020 AND2_2118/net6 VDD VDD pmos W=0.41u L=0.04u
M4955 AND2_2118/net6 RESET VDD VDD pmos W=0.41u L=0.04u
M4956 AND2_2118/net6 WX5957 VDD VDD pmos W=0.41u L=0.04u
M4957 WX6018 AND2_2117/net6 VSS VSS nmos W=0.31u L=0.04u
M4958 AND2_2117/X_u2-net6 RESET VSS VSS nmos W=0.31u L=0.04u
M4959 AND2_2117/net6 WX5955 AND2_2117/X_u2-net6 VSS nmos W=0.31u L=0.04u
M4960 WX6018 AND2_2117/net6 VDD VDD pmos W=0.41u L=0.04u
M4961 AND2_2117/net6 RESET VDD VDD pmos W=0.41u L=0.04u
M4962 AND2_2117/net6 WX5955 VDD VDD pmos W=0.41u L=0.04u
M4963 WX6016 AND2_2116/net6 VSS VSS nmos W=0.31u L=0.04u
M4964 AND2_2116/X_u2-net6 RESET VSS VSS nmos W=0.31u L=0.04u
M4965 AND2_2116/net6 WX5953 AND2_2116/X_u2-net6 VSS nmos W=0.31u L=0.04u
M4966 WX6016 AND2_2116/net6 VDD VDD pmos W=0.41u L=0.04u
M4967 AND2_2116/net6 RESET VDD VDD pmos W=0.41u L=0.04u
M4968 AND2_2116/net6 WX5953 VDD VDD pmos W=0.41u L=0.04u
M4969 WX6014 AND2_2115/net6 VSS VSS nmos W=0.31u L=0.04u
M4970 AND2_2115/X_u2-net6 RESET VSS VSS nmos W=0.31u L=0.04u
M4971 AND2_2115/net6 WX5951 AND2_2115/X_u2-net6 VSS nmos W=0.31u L=0.04u
M4972 WX6014 AND2_2115/net6 VDD VDD pmos W=0.41u L=0.04u
M4973 AND2_2115/net6 RESET VDD VDD pmos W=0.41u L=0.04u
M4974 AND2_2115/net6 WX5951 VDD VDD pmos W=0.41u L=0.04u
M4975 WX6012 AND2_2114/net6 VSS VSS nmos W=0.31u L=0.04u
M4976 AND2_2114/X_u2-net6 RESET VSS VSS nmos W=0.31u L=0.04u
M4977 AND2_2114/net6 WX5949 AND2_2114/X_u2-net6 VSS nmos W=0.31u L=0.04u
M4978 WX6012 AND2_2114/net6 VDD VDD pmos W=0.41u L=0.04u
M4979 AND2_2114/net6 RESET VDD VDD pmos W=0.41u L=0.04u
M4980 AND2_2114/net6 WX5949 VDD VDD pmos W=0.41u L=0.04u
M4981 WX6010 AND2_2113/net6 VSS VSS nmos W=0.31u L=0.04u
M4982 AND2_2113/X_u2-net6 RESET VSS VSS nmos W=0.31u L=0.04u
M4983 AND2_2113/net6 WX5947 AND2_2113/X_u2-net6 VSS nmos W=0.31u L=0.04u
M4984 WX6010 AND2_2113/net6 VDD VDD pmos W=0.41u L=0.04u
M4985 AND2_2113/net6 RESET VDD VDD pmos W=0.41u L=0.04u
M4986 AND2_2113/net6 WX5947 VDD VDD pmos W=0.41u L=0.04u
M4987 WX6008 AND2_2112/net6 VSS VSS nmos W=0.31u L=0.04u
M4988 AND2_2112/X_u2-net6 RESET VSS VSS nmos W=0.31u L=0.04u
M4989 AND2_2112/net6 WX5945 AND2_2112/X_u2-net6 VSS nmos W=0.31u L=0.04u
M4990 WX6008 AND2_2112/net6 VDD VDD pmos W=0.41u L=0.04u
M4991 AND2_2112/net6 RESET VDD VDD pmos W=0.41u L=0.04u
M4992 AND2_2112/net6 WX5945 VDD VDD pmos W=0.41u L=0.04u
M4993 WX6006 AND2_2111/net6 VSS VSS nmos W=0.31u L=0.04u
M4994 AND2_2111/X_u2-net6 RESET VSS VSS nmos W=0.31u L=0.04u
M4995 AND2_2111/net6 WX5943 AND2_2111/X_u2-net6 VSS nmos W=0.31u L=0.04u
M4996 WX6006 AND2_2111/net6 VDD VDD pmos W=0.41u L=0.04u
M4997 AND2_2111/net6 RESET VDD VDD pmos W=0.41u L=0.04u
M4998 AND2_2111/net6 WX5943 VDD VDD pmos W=0.41u L=0.04u
M4999 WX6004 AND2_2110/net6 VSS VSS nmos W=0.31u L=0.04u
M5000 AND2_2110/X_u2-net6 RESET VSS VSS nmos W=0.31u L=0.04u
M5001 AND2_2110/net6 WX5941 AND2_2110/X_u2-net6 VSS nmos W=0.31u L=0.04u
M5002 WX6004 AND2_2110/net6 VDD VDD pmos W=0.41u L=0.04u
M5003 AND2_2110/net6 RESET VDD VDD pmos W=0.41u L=0.04u
M5004 AND2_2110/net6 WX5941 VDD VDD pmos W=0.41u L=0.04u
M5005 WX6002 AND2_2109/net6 VSS VSS nmos W=0.31u L=0.04u
M5006 AND2_2109/X_u2-net6 RESET VSS VSS nmos W=0.31u L=0.04u
M5007 AND2_2109/net6 WX5939 AND2_2109/X_u2-net6 VSS nmos W=0.31u L=0.04u
M5008 WX6002 AND2_2109/net6 VDD VDD pmos W=0.41u L=0.04u
M5009 AND2_2109/net6 RESET VDD VDD pmos W=0.41u L=0.04u
M5010 AND2_2109/net6 WX5939 VDD VDD pmos W=0.41u L=0.04u
M5011 WX6000 AND2_2108/net6 VSS VSS nmos W=0.31u L=0.04u
M5012 AND2_2108/X_u2-net6 RESET VSS VSS nmos W=0.31u L=0.04u
M5013 AND2_2108/net6 WX5937 AND2_2108/X_u2-net6 VSS nmos W=0.31u L=0.04u
M5014 WX6000 AND2_2108/net6 VDD VDD pmos W=0.41u L=0.04u
M5015 AND2_2108/net6 RESET VDD VDD pmos W=0.41u L=0.04u
M5016 AND2_2108/net6 WX5937 VDD VDD pmos W=0.41u L=0.04u
M5017 WX5998 AND2_2107/net6 VSS VSS nmos W=0.31u L=0.04u
M5018 AND2_2107/X_u2-net6 RESET VSS VSS nmos W=0.31u L=0.04u
M5019 AND2_2107/net6 WX5935 AND2_2107/X_u2-net6 VSS nmos W=0.31u L=0.04u
M5020 WX5998 AND2_2107/net6 VDD VDD pmos W=0.41u L=0.04u
M5021 AND2_2107/net6 RESET VDD VDD pmos W=0.41u L=0.04u
M5022 AND2_2107/net6 WX5935 VDD VDD pmos W=0.41u L=0.04u
M5023 WX5996 AND2_2106/net6 VSS VSS nmos W=0.31u L=0.04u
M5024 AND2_2106/X_u2-net6 RESET VSS VSS nmos W=0.31u L=0.04u
M5025 AND2_2106/net6 WX5933 AND2_2106/X_u2-net6 VSS nmos W=0.31u L=0.04u
M5026 WX5996 AND2_2106/net6 VDD VDD pmos W=0.41u L=0.04u
M5027 AND2_2106/net6 RESET VDD VDD pmos W=0.41u L=0.04u
M5028 AND2_2106/net6 WX5933 VDD VDD pmos W=0.41u L=0.04u
M5029 WX5994 AND2_2105/net6 VSS VSS nmos W=0.31u L=0.04u
M5030 AND2_2105/X_u2-net6 RESET VSS VSS nmos W=0.31u L=0.04u
M5031 AND2_2105/net6 WX5931 AND2_2105/X_u2-net6 VSS nmos W=0.31u L=0.04u
M5032 WX5994 AND2_2105/net6 VDD VDD pmos W=0.41u L=0.04u
M5033 AND2_2105/net6 RESET VDD VDD pmos W=0.41u L=0.04u
M5034 AND2_2105/net6 WX5931 VDD VDD pmos W=0.41u L=0.04u
M5035 WX5992 AND2_2104/net6 VSS VSS nmos W=0.31u L=0.04u
M5036 AND2_2104/X_u2-net6 RESET VSS VSS nmos W=0.31u L=0.04u
M5037 AND2_2104/net6 WX5929 AND2_2104/X_u2-net6 VSS nmos W=0.31u L=0.04u
M5038 WX5992 AND2_2104/net6 VDD VDD pmos W=0.41u L=0.04u
M5039 AND2_2104/net6 RESET VDD VDD pmos W=0.41u L=0.04u
M5040 AND2_2104/net6 WX5929 VDD VDD pmos W=0.41u L=0.04u
M5041 WX5990 AND2_2103/net6 VSS VSS nmos W=0.31u L=0.04u
M5042 AND2_2103/X_u2-net6 RESET VSS VSS nmos W=0.31u L=0.04u
M5043 AND2_2103/net6 WX5927 AND2_2103/X_u2-net6 VSS nmos W=0.31u L=0.04u
M5044 WX5990 AND2_2103/net6 VDD VDD pmos W=0.41u L=0.04u
M5045 AND2_2103/net6 RESET VDD VDD pmos W=0.41u L=0.04u
M5046 AND2_2103/net6 WX5927 VDD VDD pmos W=0.41u L=0.04u
M5047 WX5988 AND2_2102/net6 VSS VSS nmos W=0.31u L=0.04u
M5048 AND2_2102/X_u2-net6 RESET VSS VSS nmos W=0.31u L=0.04u
M5049 AND2_2102/net6 WX5925 AND2_2102/X_u2-net6 VSS nmos W=0.31u L=0.04u
M5050 WX5988 AND2_2102/net6 VDD VDD pmos W=0.41u L=0.04u
M5051 AND2_2102/net6 RESET VDD VDD pmos W=0.41u L=0.04u
M5052 AND2_2102/net6 WX5925 VDD VDD pmos W=0.41u L=0.04u
M5053 WX5986 AND2_2101/net6 VSS VSS nmos W=0.31u L=0.04u
M5054 AND2_2101/X_u2-net6 RESET VSS VSS nmos W=0.31u L=0.04u
M5055 AND2_2101/net6 WX5923 AND2_2101/X_u2-net6 VSS nmos W=0.31u L=0.04u
M5056 WX5986 AND2_2101/net6 VDD VDD pmos W=0.41u L=0.04u
M5057 AND2_2101/net6 RESET VDD VDD pmos W=0.41u L=0.04u
M5058 AND2_2101/net6 WX5923 VDD VDD pmos W=0.41u L=0.04u
M5059 WX5984 AND2_2100/net6 VSS VSS nmos W=0.31u L=0.04u
M5060 AND2_2100/X_u2-net6 RESET VSS VSS nmos W=0.31u L=0.04u
M5061 AND2_2100/net6 WX5921 AND2_2100/X_u2-net6 VSS nmos W=0.31u L=0.04u
M5062 WX5984 AND2_2100/net6 VDD VDD pmos W=0.41u L=0.04u
M5063 AND2_2100/net6 RESET VDD VDD pmos W=0.41u L=0.04u
M5064 AND2_2100/net6 WX5921 VDD VDD pmos W=0.41u L=0.04u
M5065 WX5982 AND2_2099/net6 VSS VSS nmos W=0.31u L=0.04u
M5066 AND2_2099/X_u2-net6 RESET VSS VSS nmos W=0.31u L=0.04u
M5067 AND2_2099/net6 WX5919 AND2_2099/X_u2-net6 VSS nmos W=0.31u L=0.04u
M5068 WX5982 AND2_2099/net6 VDD VDD pmos W=0.41u L=0.04u
M5069 AND2_2099/net6 RESET VDD VDD pmos W=0.41u L=0.04u
M5070 AND2_2099/net6 WX5919 VDD VDD pmos W=0.41u L=0.04u
M5071 WX5980 AND2_2098/net6 VSS VSS nmos W=0.31u L=0.04u
M5072 AND2_2098/X_u2-net6 RESET VSS VSS nmos W=0.31u L=0.04u
M5073 AND2_2098/net6 WX5917 AND2_2098/X_u2-net6 VSS nmos W=0.31u L=0.04u
M5074 WX5980 AND2_2098/net6 VDD VDD pmos W=0.41u L=0.04u
M5075 AND2_2098/net6 RESET VDD VDD pmos W=0.41u L=0.04u
M5076 AND2_2098/net6 WX5917 VDD VDD pmos W=0.41u L=0.04u
M5077 WX5978 AND2_2097/net6 VSS VSS nmos W=0.31u L=0.04u
M5078 AND2_2097/X_u2-net6 RESET VSS VSS nmos W=0.31u L=0.04u
M5079 AND2_2097/net6 WX5915 AND2_2097/X_u2-net6 VSS nmos W=0.31u L=0.04u
M5080 WX5978 AND2_2097/net6 VDD VDD pmos W=0.41u L=0.04u
M5081 AND2_2097/net6 RESET VDD VDD pmos W=0.41u L=0.04u
M5082 AND2_2097/net6 WX5915 VDD VDD pmos W=0.41u L=0.04u
M5083 WX5976 AND2_2096/net6 VSS VSS nmos W=0.31u L=0.04u
M5084 AND2_2096/X_u2-net6 RESET VSS VSS nmos W=0.31u L=0.04u
M5085 AND2_2096/net6 WX5913 AND2_2096/X_u2-net6 VSS nmos W=0.31u L=0.04u
M5086 WX5976 AND2_2096/net6 VDD VDD pmos W=0.41u L=0.04u
M5087 AND2_2096/net6 RESET VDD VDD pmos W=0.41u L=0.04u
M5088 AND2_2096/net6 WX5913 VDD VDD pmos W=0.41u L=0.04u
M5089 WX5974 AND2_2095/net6 VSS VSS nmos W=0.31u L=0.04u
M5090 AND2_2095/X_u2-net6 RESET VSS VSS nmos W=0.31u L=0.04u
M5091 AND2_2095/net6 WX5911 AND2_2095/X_u2-net6 VSS nmos W=0.31u L=0.04u
M5092 WX5974 AND2_2095/net6 VDD VDD pmos W=0.41u L=0.04u
M5093 AND2_2095/net6 RESET VDD VDD pmos W=0.41u L=0.04u
M5094 AND2_2095/net6 WX5911 VDD VDD pmos W=0.41u L=0.04u
M5095 WX5972 AND2_2094/net6 VSS VSS nmos W=0.31u L=0.04u
M5096 AND2_2094/X_u2-net6 RESET VSS VSS nmos W=0.31u L=0.04u
M5097 AND2_2094/net6 WX5909 AND2_2094/X_u2-net6 VSS nmos W=0.31u L=0.04u
M5098 WX5972 AND2_2094/net6 VDD VDD pmos W=0.41u L=0.04u
M5099 AND2_2094/net6 RESET VDD VDD pmos W=0.41u L=0.04u
M5100 AND2_2094/net6 WX5909 VDD VDD pmos W=0.41u L=0.04u
M5101 WX5970 AND2_2093/net6 VSS VSS nmos W=0.31u L=0.04u
M5102 AND2_2093/X_u2-net6 RESET VSS VSS nmos W=0.31u L=0.04u
M5103 AND2_2093/net6 WX5907 AND2_2093/X_u2-net6 VSS nmos W=0.31u L=0.04u
M5104 WX5970 AND2_2093/net6 VDD VDD pmos W=0.41u L=0.04u
M5105 AND2_2093/net6 RESET VDD VDD pmos W=0.41u L=0.04u
M5106 AND2_2093/net6 WX5907 VDD VDD pmos W=0.41u L=0.04u
M5107 WX5968 AND2_2092/net6 VSS VSS nmos W=0.31u L=0.04u
M5108 AND2_2092/X_u2-net6 RESET VSS VSS nmos W=0.31u L=0.04u
M5109 AND2_2092/net6 WX5905 AND2_2092/X_u2-net6 VSS nmos W=0.31u L=0.04u
M5110 WX5968 AND2_2092/net6 VDD VDD pmos W=0.41u L=0.04u
M5111 AND2_2092/net6 RESET VDD VDD pmos W=0.41u L=0.04u
M5112 AND2_2092/net6 WX5905 VDD VDD pmos W=0.41u L=0.04u
M5113 WX5966 AND2_2091/net6 VSS VSS nmos W=0.31u L=0.04u
M5114 AND2_2091/X_u2-net6 RESET VSS VSS nmos W=0.31u L=0.04u
M5115 AND2_2091/net6 WX5903 AND2_2091/X_u2-net6 VSS nmos W=0.31u L=0.04u
M5116 WX5966 AND2_2091/net6 VDD VDD pmos W=0.41u L=0.04u
M5117 AND2_2091/net6 RESET VDD VDD pmos W=0.41u L=0.04u
M5118 AND2_2091/net6 WX5903 VDD VDD pmos W=0.41u L=0.04u
M5119 WX5964 AND2_2090/net6 VSS VSS nmos W=0.31u L=0.04u
M5120 AND2_2090/X_u2-net6 RESET VSS VSS nmos W=0.31u L=0.04u
M5121 AND2_2090/net6 WX5901 AND2_2090/X_u2-net6 VSS nmos W=0.31u L=0.04u
M5122 WX5964 AND2_2090/net6 VDD VDD pmos W=0.41u L=0.04u
M5123 AND2_2090/net6 RESET VDD VDD pmos W=0.41u L=0.04u
M5124 AND2_2090/net6 WX5901 VDD VDD pmos W=0.41u L=0.04u
M5125 WX5962 AND2_2089/net6 VSS VSS nmos W=0.31u L=0.04u
M5126 AND2_2089/X_u2-net6 RESET VSS VSS nmos W=0.31u L=0.04u
M5127 AND2_2089/net6 WX5899 AND2_2089/X_u2-net6 VSS nmos W=0.31u L=0.04u
M5128 WX5962 AND2_2089/net6 VDD VDD pmos W=0.41u L=0.04u
M5129 AND2_2089/net6 RESET VDD VDD pmos W=0.41u L=0.04u
M5130 AND2_2089/net6 WX5899 VDD VDD pmos W=0.41u L=0.04u
M5131 WX5960 AND2_2088/net6 VSS VSS nmos W=0.31u L=0.04u
M5132 AND2_2088/X_u2-net6 RESET VSS VSS nmos W=0.31u L=0.04u
M5133 AND2_2088/net6 WX5897 AND2_2088/X_u2-net6 VSS nmos W=0.31u L=0.04u
M5134 WX5960 AND2_2088/net6 VDD VDD pmos W=0.41u L=0.04u
M5135 AND2_2088/net6 RESET VDD VDD pmos W=0.41u L=0.04u
M5136 AND2_2088/net6 WX5897 VDD VDD pmos W=0.41u L=0.04u
M5137 WX5958 AND2_2087/net6 VSS VSS nmos W=0.31u L=0.04u
M5138 AND2_2087/X_u2-net6 RESET VSS VSS nmos W=0.31u L=0.04u
M5139 AND2_2087/net6 WX5895 AND2_2087/X_u2-net6 VSS nmos W=0.31u L=0.04u
M5140 WX5958 AND2_2087/net6 VDD VDD pmos W=0.41u L=0.04u
M5141 AND2_2087/net6 RESET VDD VDD pmos W=0.41u L=0.04u
M5142 AND2_2087/net6 WX5895 VDD VDD pmos W=0.41u L=0.04u
M5143 WX5956 AND2_2086/net6 VSS VSS nmos W=0.31u L=0.04u
M5144 AND2_2086/X_u2-net6 RESET VSS VSS nmos W=0.31u L=0.04u
M5145 AND2_2086/net6 WX5893 AND2_2086/X_u2-net6 VSS nmos W=0.31u L=0.04u
M5146 WX5956 AND2_2086/net6 VDD VDD pmos W=0.41u L=0.04u
M5147 AND2_2086/net6 RESET VDD VDD pmos W=0.41u L=0.04u
M5148 AND2_2086/net6 WX5893 VDD VDD pmos W=0.41u L=0.04u
M5149 WX5954 AND2_2085/net6 VSS VSS nmos W=0.31u L=0.04u
M5150 AND2_2085/X_u2-net6 RESET VSS VSS nmos W=0.31u L=0.04u
M5151 AND2_2085/net6 WX5891 AND2_2085/X_u2-net6 VSS nmos W=0.31u L=0.04u
M5152 WX5954 AND2_2085/net6 VDD VDD pmos W=0.41u L=0.04u
M5153 AND2_2085/net6 RESET VDD VDD pmos W=0.41u L=0.04u
M5154 AND2_2085/net6 WX5891 VDD VDD pmos W=0.41u L=0.04u
M5155 WX5952 AND2_2084/net6 VSS VSS nmos W=0.31u L=0.04u
M5156 AND2_2084/X_u2-net6 RESET VSS VSS nmos W=0.31u L=0.04u
M5157 AND2_2084/net6 WX5889 AND2_2084/X_u2-net6 VSS nmos W=0.31u L=0.04u
M5158 WX5952 AND2_2084/net6 VDD VDD pmos W=0.41u L=0.04u
M5159 AND2_2084/net6 RESET VDD VDD pmos W=0.41u L=0.04u
M5160 AND2_2084/net6 WX5889 VDD VDD pmos W=0.41u L=0.04u
M5161 WX5950 AND2_2083/net6 VSS VSS nmos W=0.31u L=0.04u
M5162 AND2_2083/X_u2-net6 RESET VSS VSS nmos W=0.31u L=0.04u
M5163 AND2_2083/net6 WX5887 AND2_2083/X_u2-net6 VSS nmos W=0.31u L=0.04u
M5164 WX5950 AND2_2083/net6 VDD VDD pmos W=0.41u L=0.04u
M5165 AND2_2083/net6 RESET VDD VDD pmos W=0.41u L=0.04u
M5166 AND2_2083/net6 WX5887 VDD VDD pmos W=0.41u L=0.04u
M5167 WX5948 AND2_2082/net6 VSS VSS nmos W=0.31u L=0.04u
M5168 AND2_2082/X_u2-net6 RESET VSS VSS nmos W=0.31u L=0.04u
M5169 AND2_2082/net6 WX5885 AND2_2082/X_u2-net6 VSS nmos W=0.31u L=0.04u
M5170 WX5948 AND2_2082/net6 VDD VDD pmos W=0.41u L=0.04u
M5171 AND2_2082/net6 RESET VDD VDD pmos W=0.41u L=0.04u
M5172 AND2_2082/net6 WX5885 VDD VDD pmos W=0.41u L=0.04u
M5173 WX5946 AND2_2081/net6 VSS VSS nmos W=0.31u L=0.04u
M5174 AND2_2081/X_u2-net6 RESET VSS VSS nmos W=0.31u L=0.04u
M5175 AND2_2081/net6 WX5883 AND2_2081/X_u2-net6 VSS nmos W=0.31u L=0.04u
M5176 WX5946 AND2_2081/net6 VDD VDD pmos W=0.41u L=0.04u
M5177 AND2_2081/net6 RESET VDD VDD pmos W=0.41u L=0.04u
M5178 AND2_2081/net6 WX5883 VDD VDD pmos W=0.41u L=0.04u
M5179 WX5944 AND2_2080/net6 VSS VSS nmos W=0.31u L=0.04u
M5180 AND2_2080/X_u2-net6 RESET VSS VSS nmos W=0.31u L=0.04u
M5181 AND2_2080/net6 WX5881 AND2_2080/X_u2-net6 VSS nmos W=0.31u L=0.04u
M5182 WX5944 AND2_2080/net6 VDD VDD pmos W=0.41u L=0.04u
M5183 AND2_2080/net6 RESET VDD VDD pmos W=0.41u L=0.04u
M5184 AND2_2080/net6 WX5881 VDD VDD pmos W=0.41u L=0.04u
M5185 WX5942 AND2_2079/net6 VSS VSS nmos W=0.31u L=0.04u
M5186 AND2_2079/X_u2-net6 RESET VSS VSS nmos W=0.31u L=0.04u
M5187 AND2_2079/net6 WX5879 AND2_2079/X_u2-net6 VSS nmos W=0.31u L=0.04u
M5188 WX5942 AND2_2079/net6 VDD VDD pmos W=0.41u L=0.04u
M5189 AND2_2079/net6 RESET VDD VDD pmos W=0.41u L=0.04u
M5190 AND2_2079/net6 WX5879 VDD VDD pmos W=0.41u L=0.04u
M5191 WX5940 AND2_2078/net6 VSS VSS nmos W=0.31u L=0.04u
M5192 AND2_2078/X_u2-net6 RESET VSS VSS nmos W=0.31u L=0.04u
M5193 AND2_2078/net6 WX5877 AND2_2078/X_u2-net6 VSS nmos W=0.31u L=0.04u
M5194 WX5940 AND2_2078/net6 VDD VDD pmos W=0.41u L=0.04u
M5195 AND2_2078/net6 RESET VDD VDD pmos W=0.41u L=0.04u
M5196 AND2_2078/net6 WX5877 VDD VDD pmos W=0.41u L=0.04u
M5197 WX5938 AND2_2077/net6 VSS VSS nmos W=0.31u L=0.04u
M5198 AND2_2077/X_u2-net6 RESET VSS VSS nmos W=0.31u L=0.04u
M5199 AND2_2077/net6 WX5875 AND2_2077/X_u2-net6 VSS nmos W=0.31u L=0.04u
M5200 WX5938 AND2_2077/net6 VDD VDD pmos W=0.41u L=0.04u
M5201 AND2_2077/net6 RESET VDD VDD pmos W=0.41u L=0.04u
M5202 AND2_2077/net6 WX5875 VDD VDD pmos W=0.41u L=0.04u
M5203 WX5936 AND2_2076/net6 VSS VSS nmos W=0.31u L=0.04u
M5204 AND2_2076/X_u2-net6 RESET VSS VSS nmos W=0.31u L=0.04u
M5205 AND2_2076/net6 WX5873 AND2_2076/X_u2-net6 VSS nmos W=0.31u L=0.04u
M5206 WX5936 AND2_2076/net6 VDD VDD pmos W=0.41u L=0.04u
M5207 AND2_2076/net6 RESET VDD VDD pmos W=0.41u L=0.04u
M5208 AND2_2076/net6 WX5873 VDD VDD pmos W=0.41u L=0.04u
M5209 WX5934 AND2_2075/net6 VSS VSS nmos W=0.31u L=0.04u
M5210 AND2_2075/X_u2-net6 RESET VSS VSS nmos W=0.31u L=0.04u
M5211 AND2_2075/net6 WX5871 AND2_2075/X_u2-net6 VSS nmos W=0.31u L=0.04u
M5212 WX5934 AND2_2075/net6 VDD VDD pmos W=0.41u L=0.04u
M5213 AND2_2075/net6 RESET VDD VDD pmos W=0.41u L=0.04u
M5214 AND2_2075/net6 WX5871 VDD VDD pmos W=0.41u L=0.04u
M5215 WX5932 AND2_2074/net6 VSS VSS nmos W=0.31u L=0.04u
M5216 AND2_2074/X_u2-net6 RESET VSS VSS nmos W=0.31u L=0.04u
M5217 AND2_2074/net6 WX5869 AND2_2074/X_u2-net6 VSS nmos W=0.31u L=0.04u
M5218 WX5932 AND2_2074/net6 VDD VDD pmos W=0.41u L=0.04u
M5219 AND2_2074/net6 RESET VDD VDD pmos W=0.41u L=0.04u
M5220 AND2_2074/net6 WX5869 VDD VDD pmos W=0.41u L=0.04u
M5221 WX5930 AND2_2073/net6 VSS VSS nmos W=0.31u L=0.04u
M5222 AND2_2073/X_u2-net6 RESET VSS VSS nmos W=0.31u L=0.04u
M5223 AND2_2073/net6 WX5867 AND2_2073/X_u2-net6 VSS nmos W=0.31u L=0.04u
M5224 WX5930 AND2_2073/net6 VDD VDD pmos W=0.41u L=0.04u
M5225 AND2_2073/net6 RESET VDD VDD pmos W=0.41u L=0.04u
M5226 AND2_2073/net6 WX5867 VDD VDD pmos W=0.41u L=0.04u
M5227 WX5928 AND2_2072/net6 VSS VSS nmos W=0.31u L=0.04u
M5228 AND2_2072/X_u2-net6 RESET VSS VSS nmos W=0.31u L=0.04u
M5229 AND2_2072/net6 WX5865 AND2_2072/X_u2-net6 VSS nmos W=0.31u L=0.04u
M5230 WX5928 AND2_2072/net6 VDD VDD pmos W=0.41u L=0.04u
M5231 AND2_2072/net6 RESET VDD VDD pmos W=0.41u L=0.04u
M5232 AND2_2072/net6 WX5865 VDD VDD pmos W=0.41u L=0.04u
M5233 WX5926 AND2_2071/net6 VSS VSS nmos W=0.31u L=0.04u
M5234 AND2_2071/X_u2-net6 RESET VSS VSS nmos W=0.31u L=0.04u
M5235 AND2_2071/net6 WX5863 AND2_2071/X_u2-net6 VSS nmos W=0.31u L=0.04u
M5236 WX5926 AND2_2071/net6 VDD VDD pmos W=0.41u L=0.04u
M5237 AND2_2071/net6 RESET VDD VDD pmos W=0.41u L=0.04u
M5238 AND2_2071/net6 WX5863 VDD VDD pmos W=0.41u L=0.04u
M5239 WX5924 AND2_2070/net6 VSS VSS nmos W=0.31u L=0.04u
M5240 AND2_2070/X_u2-net6 RESET VSS VSS nmos W=0.31u L=0.04u
M5241 AND2_2070/net6 WX5861 AND2_2070/X_u2-net6 VSS nmos W=0.31u L=0.04u
M5242 WX5924 AND2_2070/net6 VDD VDD pmos W=0.41u L=0.04u
M5243 AND2_2070/net6 RESET VDD VDD pmos W=0.41u L=0.04u
M5244 AND2_2070/net6 WX5861 VDD VDD pmos W=0.41u L=0.04u
M5245 WX5922 AND2_2069/net6 VSS VSS nmos W=0.31u L=0.04u
M5246 AND2_2069/X_u2-net6 RESET VSS VSS nmos W=0.31u L=0.04u
M5247 AND2_2069/net6 WX5859 AND2_2069/X_u2-net6 VSS nmos W=0.31u L=0.04u
M5248 WX5922 AND2_2069/net6 VDD VDD pmos W=0.41u L=0.04u
M5249 AND2_2069/net6 RESET VDD VDD pmos W=0.41u L=0.04u
M5250 AND2_2069/net6 WX5859 VDD VDD pmos W=0.41u L=0.04u
M5251 WX5920 AND2_2068/net6 VSS VSS nmos W=0.31u L=0.04u
M5252 AND2_2068/X_u2-net6 RESET VSS VSS nmos W=0.31u L=0.04u
M5253 AND2_2068/net6 WX5857 AND2_2068/X_u2-net6 VSS nmos W=0.31u L=0.04u
M5254 WX5920 AND2_2068/net6 VDD VDD pmos W=0.41u L=0.04u
M5255 AND2_2068/net6 RESET VDD VDD pmos W=0.41u L=0.04u
M5256 AND2_2068/net6 WX5857 VDD VDD pmos W=0.41u L=0.04u
M5257 WX5918 AND2_2067/net6 VSS VSS nmos W=0.31u L=0.04u
M5258 AND2_2067/X_u2-net6 RESET VSS VSS nmos W=0.31u L=0.04u
M5259 AND2_2067/net6 WX5855 AND2_2067/X_u2-net6 VSS nmos W=0.31u L=0.04u
M5260 WX5918 AND2_2067/net6 VDD VDD pmos W=0.41u L=0.04u
M5261 AND2_2067/net6 RESET VDD VDD pmos W=0.41u L=0.04u
M5262 AND2_2067/net6 WX5855 VDD VDD pmos W=0.41u L=0.04u
M5263 WX5916 AND2_2066/net6 VSS VSS nmos W=0.31u L=0.04u
M5264 AND2_2066/X_u2-net6 RESET VSS VSS nmos W=0.31u L=0.04u
M5265 AND2_2066/net6 WX5853 AND2_2066/X_u2-net6 VSS nmos W=0.31u L=0.04u
M5266 WX5916 AND2_2066/net6 VDD VDD pmos W=0.41u L=0.04u
M5267 AND2_2066/net6 RESET VDD VDD pmos W=0.41u L=0.04u
M5268 AND2_2066/net6 WX5853 VDD VDD pmos W=0.41u L=0.04u
M5269 WX5914 AND2_2065/net6 VSS VSS nmos W=0.31u L=0.04u
M5270 AND2_2065/X_u2-net6 RESET VSS VSS nmos W=0.31u L=0.04u
M5271 AND2_2065/net6 WX5851 AND2_2065/X_u2-net6 VSS nmos W=0.31u L=0.04u
M5272 WX5914 AND2_2065/net6 VDD VDD pmos W=0.41u L=0.04u
M5273 AND2_2065/net6 RESET VDD VDD pmos W=0.41u L=0.04u
M5274 AND2_2065/net6 WX5851 VDD VDD pmos W=0.41u L=0.04u
M5275 WX5912 AND2_2064/net6 VSS VSS nmos W=0.31u L=0.04u
M5276 AND2_2064/X_u2-net6 RESET VSS VSS nmos W=0.31u L=0.04u
M5277 AND2_2064/net6 WX5849 AND2_2064/X_u2-net6 VSS nmos W=0.31u L=0.04u
M5278 WX5912 AND2_2064/net6 VDD VDD pmos W=0.41u L=0.04u
M5279 AND2_2064/net6 RESET VDD VDD pmos W=0.41u L=0.04u
M5280 AND2_2064/net6 WX5849 VDD VDD pmos W=0.41u L=0.04u
M5281 WX5910 AND2_2063/net6 VSS VSS nmos W=0.31u L=0.04u
M5282 AND2_2063/X_u2-net6 RESET VSS VSS nmos W=0.31u L=0.04u
M5283 AND2_2063/net6 WX5847 AND2_2063/X_u2-net6 VSS nmos W=0.31u L=0.04u
M5284 WX5910 AND2_2063/net6 VDD VDD pmos W=0.41u L=0.04u
M5285 AND2_2063/net6 RESET VDD VDD pmos W=0.41u L=0.04u
M5286 AND2_2063/net6 WX5847 VDD VDD pmos W=0.41u L=0.04u
M5287 WX5908 AND2_2062/net6 VSS VSS nmos W=0.31u L=0.04u
M5288 AND2_2062/X_u2-net6 RESET VSS VSS nmos W=0.31u L=0.04u
M5289 AND2_2062/net6 WX5845 AND2_2062/X_u2-net6 VSS nmos W=0.31u L=0.04u
M5290 WX5908 AND2_2062/net6 VDD VDD pmos W=0.41u L=0.04u
M5291 AND2_2062/net6 RESET VDD VDD pmos W=0.41u L=0.04u
M5292 AND2_2062/net6 WX5845 VDD VDD pmos W=0.41u L=0.04u
M5293 WX5906 AND2_2061/net6 VSS VSS nmos W=0.31u L=0.04u
M5294 AND2_2061/X_u2-net6 RESET VSS VSS nmos W=0.31u L=0.04u
M5295 AND2_2061/net6 WX5843 AND2_2061/X_u2-net6 VSS nmos W=0.31u L=0.04u
M5296 WX5906 AND2_2061/net6 VDD VDD pmos W=0.41u L=0.04u
M5297 AND2_2061/net6 RESET VDD VDD pmos W=0.41u L=0.04u
M5298 AND2_2061/net6 WX5843 VDD VDD pmos W=0.41u L=0.04u
M5299 WX5904 AND2_2060/net6 VSS VSS nmos W=0.31u L=0.04u
M5300 AND2_2060/X_u2-net6 RESET VSS VSS nmos W=0.31u L=0.04u
M5301 AND2_2060/net6 WX5841 AND2_2060/X_u2-net6 VSS nmos W=0.31u L=0.04u
M5302 WX5904 AND2_2060/net6 VDD VDD pmos W=0.41u L=0.04u
M5303 AND2_2060/net6 RESET VDD VDD pmos W=0.41u L=0.04u
M5304 AND2_2060/net6 WX5841 VDD VDD pmos W=0.41u L=0.04u
M5305 WX5902 AND2_2059/net6 VSS VSS nmos W=0.31u L=0.04u
M5306 AND2_2059/X_u2-net6 RESET VSS VSS nmos W=0.31u L=0.04u
M5307 AND2_2059/net6 WX5839 AND2_2059/X_u2-net6 VSS nmos W=0.31u L=0.04u
M5308 WX5902 AND2_2059/net6 VDD VDD pmos W=0.41u L=0.04u
M5309 AND2_2059/net6 RESET VDD VDD pmos W=0.41u L=0.04u
M5310 AND2_2059/net6 WX5839 VDD VDD pmos W=0.41u L=0.04u
M5311 WX5900 AND2_2058/net6 VSS VSS nmos W=0.31u L=0.04u
M5312 AND2_2058/X_u2-net6 RESET VSS VSS nmos W=0.31u L=0.04u
M5313 AND2_2058/net6 WX5837 AND2_2058/X_u2-net6 VSS nmos W=0.31u L=0.04u
M5314 WX5900 AND2_2058/net6 VDD VDD pmos W=0.41u L=0.04u
M5315 AND2_2058/net6 RESET VDD VDD pmos W=0.41u L=0.04u
M5316 AND2_2058/net6 WX5837 VDD VDD pmos W=0.41u L=0.04u
M5317 WX5898 AND2_2057/net6 VSS VSS nmos W=0.31u L=0.04u
M5318 AND2_2057/X_u2-net6 RESET VSS VSS nmos W=0.31u L=0.04u
M5319 AND2_2057/net6 WX5835 AND2_2057/X_u2-net6 VSS nmos W=0.31u L=0.04u
M5320 WX5898 AND2_2057/net6 VDD VDD pmos W=0.41u L=0.04u
M5321 AND2_2057/net6 RESET VDD VDD pmos W=0.41u L=0.04u
M5322 AND2_2057/net6 WX5835 VDD VDD pmos W=0.41u L=0.04u
M5323 WX5896 AND2_2056/net6 VSS VSS nmos W=0.31u L=0.04u
M5324 AND2_2056/X_u2-net6 RESET VSS VSS nmos W=0.31u L=0.04u
M5325 AND2_2056/net6 WX5833 AND2_2056/X_u2-net6 VSS nmos W=0.31u L=0.04u
M5326 WX5896 AND2_2056/net6 VDD VDD pmos W=0.41u L=0.04u
M5327 AND2_2056/net6 RESET VDD VDD pmos W=0.41u L=0.04u
M5328 AND2_2056/net6 WX5833 VDD VDD pmos W=0.41u L=0.04u
M5329 WX5894 AND2_2055/net6 VSS VSS nmos W=0.31u L=0.04u
M5330 AND2_2055/X_u2-net6 RESET VSS VSS nmos W=0.31u L=0.04u
M5331 AND2_2055/net6 WX5831 AND2_2055/X_u2-net6 VSS nmos W=0.31u L=0.04u
M5332 WX5894 AND2_2055/net6 VDD VDD pmos W=0.41u L=0.04u
M5333 AND2_2055/net6 RESET VDD VDD pmos W=0.41u L=0.04u
M5334 AND2_2055/net6 WX5831 VDD VDD pmos W=0.41u L=0.04u
M5335 WX5892 AND2_2054/net6 VSS VSS nmos W=0.31u L=0.04u
M5336 AND2_2054/X_u2-net6 RESET VSS VSS nmos W=0.31u L=0.04u
M5337 AND2_2054/net6 WX5829 AND2_2054/X_u2-net6 VSS nmos W=0.31u L=0.04u
M5338 WX5892 AND2_2054/net6 VDD VDD pmos W=0.41u L=0.04u
M5339 AND2_2054/net6 RESET VDD VDD pmos W=0.41u L=0.04u
M5340 AND2_2054/net6 WX5829 VDD VDD pmos W=0.41u L=0.04u
M5341 WX5890 AND2_2053/net6 VSS VSS nmos W=0.31u L=0.04u
M5342 AND2_2053/X_u2-net6 RESET VSS VSS nmos W=0.31u L=0.04u
M5343 AND2_2053/net6 WX5827 AND2_2053/X_u2-net6 VSS nmos W=0.31u L=0.04u
M5344 WX5890 AND2_2053/net6 VDD VDD pmos W=0.41u L=0.04u
M5345 AND2_2053/net6 RESET VDD VDD pmos W=0.41u L=0.04u
M5346 AND2_2053/net6 WX5827 VDD VDD pmos W=0.41u L=0.04u
M5347 WX5888 AND2_2052/net6 VSS VSS nmos W=0.31u L=0.04u
M5348 AND2_2052/X_u2-net6 RESET VSS VSS nmos W=0.31u L=0.04u
M5349 AND2_2052/net6 WX5825 AND2_2052/X_u2-net6 VSS nmos W=0.31u L=0.04u
M5350 WX5888 AND2_2052/net6 VDD VDD pmos W=0.41u L=0.04u
M5351 AND2_2052/net6 RESET VDD VDD pmos W=0.41u L=0.04u
M5352 AND2_2052/net6 WX5825 VDD VDD pmos W=0.41u L=0.04u
M5353 WX5886 AND2_2051/net6 VSS VSS nmos W=0.31u L=0.04u
M5354 AND2_2051/X_u2-net6 RESET VSS VSS nmos W=0.31u L=0.04u
M5355 AND2_2051/net6 WX5823 AND2_2051/X_u2-net6 VSS nmos W=0.31u L=0.04u
M5356 WX5886 AND2_2051/net6 VDD VDD pmos W=0.41u L=0.04u
M5357 AND2_2051/net6 RESET VDD VDD pmos W=0.41u L=0.04u
M5358 AND2_2051/net6 WX5823 VDD VDD pmos W=0.41u L=0.04u
M5359 WX5884 AND2_2050/net6 VSS VSS nmos W=0.31u L=0.04u
M5360 AND2_2050/X_u2-net6 RESET VSS VSS nmos W=0.31u L=0.04u
M5361 AND2_2050/net6 WX5821 AND2_2050/X_u2-net6 VSS nmos W=0.31u L=0.04u
M5362 WX5884 AND2_2050/net6 VDD VDD pmos W=0.41u L=0.04u
M5363 AND2_2050/net6 RESET VDD VDD pmos W=0.41u L=0.04u
M5364 AND2_2050/net6 WX5821 VDD VDD pmos W=0.41u L=0.04u
M5365 WX5882 AND2_2049/net6 VSS VSS nmos W=0.31u L=0.04u
M5366 AND2_2049/X_u2-net6 RESET VSS VSS nmos W=0.31u L=0.04u
M5367 AND2_2049/net6 WX5819 AND2_2049/X_u2-net6 VSS nmos W=0.31u L=0.04u
M5368 WX5882 AND2_2049/net6 VDD VDD pmos W=0.41u L=0.04u
M5369 AND2_2049/net6 RESET VDD VDD pmos W=0.41u L=0.04u
M5370 AND2_2049/net6 WX5819 VDD VDD pmos W=0.41u L=0.04u
M5371 WX5880 AND2_2048/net6 VSS VSS nmos W=0.31u L=0.04u
M5372 AND2_2048/X_u2-net6 RESET VSS VSS nmos W=0.31u L=0.04u
M5373 AND2_2048/net6 WX5817 AND2_2048/X_u2-net6 VSS nmos W=0.31u L=0.04u
M5374 WX5880 AND2_2048/net6 VDD VDD pmos W=0.41u L=0.04u
M5375 AND2_2048/net6 RESET VDD VDD pmos W=0.41u L=0.04u
M5376 AND2_2048/net6 WX5817 VDD VDD pmos W=0.41u L=0.04u
M5377 WX5878 AND2_2047/net6 VSS VSS nmos W=0.31u L=0.04u
M5378 AND2_2047/X_u2-net6 RESET VSS VSS nmos W=0.31u L=0.04u
M5379 AND2_2047/net6 WX5644 AND2_2047/X_u2-net6 VSS nmos W=0.31u L=0.04u
M5380 WX5878 AND2_2047/net6 VDD VDD pmos W=0.41u L=0.04u
M5381 AND2_2047/net6 RESET VDD VDD pmos W=0.41u L=0.04u
M5382 AND2_2047/net6 WX5644 VDD VDD pmos W=0.41u L=0.04u
M5383 WX5876 AND2_2046/net6 VSS VSS nmos W=0.31u L=0.04u
M5384 AND2_2046/X_u2-net6 RESET VSS VSS nmos W=0.31u L=0.04u
M5385 AND2_2046/net6 WX5630 AND2_2046/X_u2-net6 VSS nmos W=0.31u L=0.04u
M5386 WX5876 AND2_2046/net6 VDD VDD pmos W=0.41u L=0.04u
M5387 AND2_2046/net6 RESET VDD VDD pmos W=0.41u L=0.04u
M5388 AND2_2046/net6 WX5630 VDD VDD pmos W=0.41u L=0.04u
M5389 WX5874 AND2_2045/net6 VSS VSS nmos W=0.31u L=0.04u
M5390 AND2_2045/X_u2-net6 RESET VSS VSS nmos W=0.31u L=0.04u
M5391 AND2_2045/net6 WX5616 AND2_2045/X_u2-net6 VSS nmos W=0.31u L=0.04u
M5392 WX5874 AND2_2045/net6 VDD VDD pmos W=0.41u L=0.04u
M5393 AND2_2045/net6 RESET VDD VDD pmos W=0.41u L=0.04u
M5394 AND2_2045/net6 WX5616 VDD VDD pmos W=0.41u L=0.04u
M5395 WX5872 AND2_2044/net6 VSS VSS nmos W=0.31u L=0.04u
M5396 AND2_2044/X_u2-net6 RESET VSS VSS nmos W=0.31u L=0.04u
M5397 AND2_2044/net6 WX5602 AND2_2044/X_u2-net6 VSS nmos W=0.31u L=0.04u
M5398 WX5872 AND2_2044/net6 VDD VDD pmos W=0.41u L=0.04u
M5399 AND2_2044/net6 RESET VDD VDD pmos W=0.41u L=0.04u
M5400 AND2_2044/net6 WX5602 VDD VDD pmos W=0.41u L=0.04u
M5401 WX5870 AND2_2043/net6 VSS VSS nmos W=0.31u L=0.04u
M5402 AND2_2043/X_u2-net6 RESET VSS VSS nmos W=0.31u L=0.04u
M5403 AND2_2043/net6 WX5588 AND2_2043/X_u2-net6 VSS nmos W=0.31u L=0.04u
M5404 WX5870 AND2_2043/net6 VDD VDD pmos W=0.41u L=0.04u
M5405 AND2_2043/net6 RESET VDD VDD pmos W=0.41u L=0.04u
M5406 AND2_2043/net6 WX5588 VDD VDD pmos W=0.41u L=0.04u
M5407 WX5868 AND2_2042/net6 VSS VSS nmos W=0.31u L=0.04u
M5408 AND2_2042/X_u2-net6 RESET VSS VSS nmos W=0.31u L=0.04u
M5409 AND2_2042/net6 WX5574 AND2_2042/X_u2-net6 VSS nmos W=0.31u L=0.04u
M5410 WX5868 AND2_2042/net6 VDD VDD pmos W=0.41u L=0.04u
M5411 AND2_2042/net6 RESET VDD VDD pmos W=0.41u L=0.04u
M5412 AND2_2042/net6 WX5574 VDD VDD pmos W=0.41u L=0.04u
M5413 WX5866 AND2_2041/net6 VSS VSS nmos W=0.31u L=0.04u
M5414 AND2_2041/X_u2-net6 RESET VSS VSS nmos W=0.31u L=0.04u
M5415 AND2_2041/net6 WX5560 AND2_2041/X_u2-net6 VSS nmos W=0.31u L=0.04u
M5416 WX5866 AND2_2041/net6 VDD VDD pmos W=0.41u L=0.04u
M5417 AND2_2041/net6 RESET VDD VDD pmos W=0.41u L=0.04u
M5418 AND2_2041/net6 WX5560 VDD VDD pmos W=0.41u L=0.04u
M5419 WX5864 AND2_2040/net6 VSS VSS nmos W=0.31u L=0.04u
M5420 AND2_2040/X_u2-net6 RESET VSS VSS nmos W=0.31u L=0.04u
M5421 AND2_2040/net6 WX5546 AND2_2040/X_u2-net6 VSS nmos W=0.31u L=0.04u
M5422 WX5864 AND2_2040/net6 VDD VDD pmos W=0.41u L=0.04u
M5423 AND2_2040/net6 RESET VDD VDD pmos W=0.41u L=0.04u
M5424 AND2_2040/net6 WX5546 VDD VDD pmos W=0.41u L=0.04u
M5425 WX5862 AND2_2039/net6 VSS VSS nmos W=0.31u L=0.04u
M5426 AND2_2039/X_u2-net6 RESET VSS VSS nmos W=0.31u L=0.04u
M5427 AND2_2039/net6 WX5532 AND2_2039/X_u2-net6 VSS nmos W=0.31u L=0.04u
M5428 WX5862 AND2_2039/net6 VDD VDD pmos W=0.41u L=0.04u
M5429 AND2_2039/net6 RESET VDD VDD pmos W=0.41u L=0.04u
M5430 AND2_2039/net6 WX5532 VDD VDD pmos W=0.41u L=0.04u
M5431 WX5860 AND2_2038/net6 VSS VSS nmos W=0.31u L=0.04u
M5432 AND2_2038/X_u2-net6 RESET VSS VSS nmos W=0.31u L=0.04u
M5433 AND2_2038/net6 WX5518 AND2_2038/X_u2-net6 VSS nmos W=0.31u L=0.04u
M5434 WX5860 AND2_2038/net6 VDD VDD pmos W=0.41u L=0.04u
M5435 AND2_2038/net6 RESET VDD VDD pmos W=0.41u L=0.04u
M5436 AND2_2038/net6 WX5518 VDD VDD pmos W=0.41u L=0.04u
M5437 WX5858 AND2_2037/net6 VSS VSS nmos W=0.31u L=0.04u
M5438 AND2_2037/X_u2-net6 RESET VSS VSS nmos W=0.31u L=0.04u
M5439 AND2_2037/net6 WX5504 AND2_2037/X_u2-net6 VSS nmos W=0.31u L=0.04u
M5440 WX5858 AND2_2037/net6 VDD VDD pmos W=0.41u L=0.04u
M5441 AND2_2037/net6 RESET VDD VDD pmos W=0.41u L=0.04u
M5442 AND2_2037/net6 WX5504 VDD VDD pmos W=0.41u L=0.04u
M5443 WX5856 AND2_2036/net6 VSS VSS nmos W=0.31u L=0.04u
M5444 AND2_2036/X_u2-net6 RESET VSS VSS nmos W=0.31u L=0.04u
M5445 AND2_2036/net6 WX5490 AND2_2036/X_u2-net6 VSS nmos W=0.31u L=0.04u
M5446 WX5856 AND2_2036/net6 VDD VDD pmos W=0.41u L=0.04u
M5447 AND2_2036/net6 RESET VDD VDD pmos W=0.41u L=0.04u
M5448 AND2_2036/net6 WX5490 VDD VDD pmos W=0.41u L=0.04u
M5449 WX5854 AND2_2035/net6 VSS VSS nmos W=0.31u L=0.04u
M5450 AND2_2035/X_u2-net6 RESET VSS VSS nmos W=0.31u L=0.04u
M5451 AND2_2035/net6 WX5476 AND2_2035/X_u2-net6 VSS nmos W=0.31u L=0.04u
M5452 WX5854 AND2_2035/net6 VDD VDD pmos W=0.41u L=0.04u
M5453 AND2_2035/net6 RESET VDD VDD pmos W=0.41u L=0.04u
M5454 AND2_2035/net6 WX5476 VDD VDD pmos W=0.41u L=0.04u
M5455 WX5852 AND2_2034/net6 VSS VSS nmos W=0.31u L=0.04u
M5456 AND2_2034/X_u2-net6 RESET VSS VSS nmos W=0.31u L=0.04u
M5457 AND2_2034/net6 WX5462 AND2_2034/X_u2-net6 VSS nmos W=0.31u L=0.04u
M5458 WX5852 AND2_2034/net6 VDD VDD pmos W=0.41u L=0.04u
M5459 AND2_2034/net6 RESET VDD VDD pmos W=0.41u L=0.04u
M5460 AND2_2034/net6 WX5462 VDD VDD pmos W=0.41u L=0.04u
M5461 WX5850 AND2_2033/net6 VSS VSS nmos W=0.31u L=0.04u
M5462 AND2_2033/X_u2-net6 RESET VSS VSS nmos W=0.31u L=0.04u
M5463 AND2_2033/net6 WX5448 AND2_2033/X_u2-net6 VSS nmos W=0.31u L=0.04u
M5464 WX5850 AND2_2033/net6 VDD VDD pmos W=0.41u L=0.04u
M5465 AND2_2033/net6 RESET VDD VDD pmos W=0.41u L=0.04u
M5466 AND2_2033/net6 WX5448 VDD VDD pmos W=0.41u L=0.04u
M5467 WX5848 AND2_2032/net6 VSS VSS nmos W=0.31u L=0.04u
M5468 AND2_2032/X_u2-net6 RESET VSS VSS nmos W=0.31u L=0.04u
M5469 AND2_2032/net6 WX5434 AND2_2032/X_u2-net6 VSS nmos W=0.31u L=0.04u
M5470 WX5848 AND2_2032/net6 VDD VDD pmos W=0.41u L=0.04u
M5471 AND2_2032/net6 RESET VDD VDD pmos W=0.41u L=0.04u
M5472 AND2_2032/net6 WX5434 VDD VDD pmos W=0.41u L=0.04u
M5473 WX5846 AND2_2031/net6 VSS VSS nmos W=0.31u L=0.04u
M5474 AND2_2031/X_u2-net6 RESET VSS VSS nmos W=0.31u L=0.04u
M5475 AND2_2031/net6 WX5420 AND2_2031/X_u2-net6 VSS nmos W=0.31u L=0.04u
M5476 WX5846 AND2_2031/net6 VDD VDD pmos W=0.41u L=0.04u
M5477 AND2_2031/net6 RESET VDD VDD pmos W=0.41u L=0.04u
M5478 AND2_2031/net6 WX5420 VDD VDD pmos W=0.41u L=0.04u
M5479 WX5844 AND2_2030/net6 VSS VSS nmos W=0.31u L=0.04u
M5480 AND2_2030/X_u2-net6 RESET VSS VSS nmos W=0.31u L=0.04u
M5481 AND2_2030/net6 WX5406 AND2_2030/X_u2-net6 VSS nmos W=0.31u L=0.04u
M5482 WX5844 AND2_2030/net6 VDD VDD pmos W=0.41u L=0.04u
M5483 AND2_2030/net6 RESET VDD VDD pmos W=0.41u L=0.04u
M5484 AND2_2030/net6 WX5406 VDD VDD pmos W=0.41u L=0.04u
M5485 WX5842 AND2_2029/net6 VSS VSS nmos W=0.31u L=0.04u
M5486 AND2_2029/X_u2-net6 RESET VSS VSS nmos W=0.31u L=0.04u
M5487 AND2_2029/net6 WX5392 AND2_2029/X_u2-net6 VSS nmos W=0.31u L=0.04u
M5488 WX5842 AND2_2029/net6 VDD VDD pmos W=0.41u L=0.04u
M5489 AND2_2029/net6 RESET VDD VDD pmos W=0.41u L=0.04u
M5490 AND2_2029/net6 WX5392 VDD VDD pmos W=0.41u L=0.04u
M5491 WX5840 AND2_2028/net6 VSS VSS nmos W=0.31u L=0.04u
M5492 AND2_2028/X_u2-net6 RESET VSS VSS nmos W=0.31u L=0.04u
M5493 AND2_2028/net6 WX5378 AND2_2028/X_u2-net6 VSS nmos W=0.31u L=0.04u
M5494 WX5840 AND2_2028/net6 VDD VDD pmos W=0.41u L=0.04u
M5495 AND2_2028/net6 RESET VDD VDD pmos W=0.41u L=0.04u
M5496 AND2_2028/net6 WX5378 VDD VDD pmos W=0.41u L=0.04u
M5497 WX5838 AND2_2027/net6 VSS VSS nmos W=0.31u L=0.04u
M5498 AND2_2027/X_u2-net6 RESET VSS VSS nmos W=0.31u L=0.04u
M5499 AND2_2027/net6 WX5364 AND2_2027/X_u2-net6 VSS nmos W=0.31u L=0.04u
M5500 WX5838 AND2_2027/net6 VDD VDD pmos W=0.41u L=0.04u
M5501 AND2_2027/net6 RESET VDD VDD pmos W=0.41u L=0.04u
M5502 AND2_2027/net6 WX5364 VDD VDD pmos W=0.41u L=0.04u
M5503 WX5836 AND2_2026/net6 VSS VSS nmos W=0.31u L=0.04u
M5504 AND2_2026/X_u2-net6 RESET VSS VSS nmos W=0.31u L=0.04u
M5505 AND2_2026/net6 WX5350 AND2_2026/X_u2-net6 VSS nmos W=0.31u L=0.04u
M5506 WX5836 AND2_2026/net6 VDD VDD pmos W=0.41u L=0.04u
M5507 AND2_2026/net6 RESET VDD VDD pmos W=0.41u L=0.04u
M5508 AND2_2026/net6 WX5350 VDD VDD pmos W=0.41u L=0.04u
M5509 WX5834 AND2_2025/net6 VSS VSS nmos W=0.31u L=0.04u
M5510 AND2_2025/X_u2-net6 RESET VSS VSS nmos W=0.31u L=0.04u
M5511 AND2_2025/net6 WX5336 AND2_2025/X_u2-net6 VSS nmos W=0.31u L=0.04u
M5512 WX5834 AND2_2025/net6 VDD VDD pmos W=0.41u L=0.04u
M5513 AND2_2025/net6 RESET VDD VDD pmos W=0.41u L=0.04u
M5514 AND2_2025/net6 WX5336 VDD VDD pmos W=0.41u L=0.04u
M5515 WX5832 AND2_2024/net6 VSS VSS nmos W=0.31u L=0.04u
M5516 AND2_2024/X_u2-net6 RESET VSS VSS nmos W=0.31u L=0.04u
M5517 AND2_2024/net6 WX5322 AND2_2024/X_u2-net6 VSS nmos W=0.31u L=0.04u
M5518 WX5832 AND2_2024/net6 VDD VDD pmos W=0.41u L=0.04u
M5519 AND2_2024/net6 RESET VDD VDD pmos W=0.41u L=0.04u
M5520 AND2_2024/net6 WX5322 VDD VDD pmos W=0.41u L=0.04u
M5521 WX5830 AND2_2023/net6 VSS VSS nmos W=0.31u L=0.04u
M5522 AND2_2023/X_u2-net6 RESET VSS VSS nmos W=0.31u L=0.04u
M5523 AND2_2023/net6 WX5308 AND2_2023/X_u2-net6 VSS nmos W=0.31u L=0.04u
M5524 WX5830 AND2_2023/net6 VDD VDD pmos W=0.41u L=0.04u
M5525 AND2_2023/net6 RESET VDD VDD pmos W=0.41u L=0.04u
M5526 AND2_2023/net6 WX5308 VDD VDD pmos W=0.41u L=0.04u
M5527 WX5828 AND2_2022/net6 VSS VSS nmos W=0.31u L=0.04u
M5528 AND2_2022/X_u2-net6 RESET VSS VSS nmos W=0.31u L=0.04u
M5529 AND2_2022/net6 WX5294 AND2_2022/X_u2-net6 VSS nmos W=0.31u L=0.04u
M5530 WX5828 AND2_2022/net6 VDD VDD pmos W=0.41u L=0.04u
M5531 AND2_2022/net6 RESET VDD VDD pmos W=0.41u L=0.04u
M5532 AND2_2022/net6 WX5294 VDD VDD pmos W=0.41u L=0.04u
M5533 WX5826 AND2_2021/net6 VSS VSS nmos W=0.31u L=0.04u
M5534 AND2_2021/X_u2-net6 RESET VSS VSS nmos W=0.31u L=0.04u
M5535 AND2_2021/net6 WX5280 AND2_2021/X_u2-net6 VSS nmos W=0.31u L=0.04u
M5536 WX5826 AND2_2021/net6 VDD VDD pmos W=0.41u L=0.04u
M5537 AND2_2021/net6 RESET VDD VDD pmos W=0.41u L=0.04u
M5538 AND2_2021/net6 WX5280 VDD VDD pmos W=0.41u L=0.04u
M5539 WX5824 AND2_2020/net6 VSS VSS nmos W=0.31u L=0.04u
M5540 AND2_2020/X_u2-net6 RESET VSS VSS nmos W=0.31u L=0.04u
M5541 AND2_2020/net6 WX5266 AND2_2020/X_u2-net6 VSS nmos W=0.31u L=0.04u
M5542 WX5824 AND2_2020/net6 VDD VDD pmos W=0.41u L=0.04u
M5543 AND2_2020/net6 RESET VDD VDD pmos W=0.41u L=0.04u
M5544 AND2_2020/net6 WX5266 VDD VDD pmos W=0.41u L=0.04u
M5545 WX5822 AND2_2019/net6 VSS VSS nmos W=0.31u L=0.04u
M5546 AND2_2019/X_u2-net6 RESET VSS VSS nmos W=0.31u L=0.04u
M5547 AND2_2019/net6 WX5252 AND2_2019/X_u2-net6 VSS nmos W=0.31u L=0.04u
M5548 WX5822 AND2_2019/net6 VDD VDD pmos W=0.41u L=0.04u
M5549 AND2_2019/net6 RESET VDD VDD pmos W=0.41u L=0.04u
M5550 AND2_2019/net6 WX5252 VDD VDD pmos W=0.41u L=0.04u
M5551 WX5820 AND2_2018/net6 VSS VSS nmos W=0.31u L=0.04u
M5552 AND2_2018/X_u2-net6 RESET VSS VSS nmos W=0.31u L=0.04u
M5553 AND2_2018/net6 WX5238 AND2_2018/X_u2-net6 VSS nmos W=0.31u L=0.04u
M5554 WX5820 AND2_2018/net6 VDD VDD pmos W=0.41u L=0.04u
M5555 AND2_2018/net6 RESET VDD VDD pmos W=0.41u L=0.04u
M5556 AND2_2018/net6 WX5238 VDD VDD pmos W=0.41u L=0.04u
M5557 WX5818 AND2_2017/net6 VSS VSS nmos W=0.31u L=0.04u
M5558 AND2_2017/X_u2-net6 RESET VSS VSS nmos W=0.31u L=0.04u
M5559 AND2_2017/net6 WX5224 AND2_2017/X_u2-net6 VSS nmos W=0.31u L=0.04u
M5560 WX5818 AND2_2017/net6 VDD VDD pmos W=0.41u L=0.04u
M5561 AND2_2017/net6 RESET VDD VDD pmos W=0.41u L=0.04u
M5562 AND2_2017/net6 WX5224 VDD VDD pmos W=0.41u L=0.04u
M5563 WX5816 AND2_2016/net6 VSS VSS nmos W=0.31u L=0.04u
M5564 AND2_2016/X_u2-net6 RESET VSS VSS nmos W=0.31u L=0.04u
M5565 AND2_2016/net6 WX5210 AND2_2016/X_u2-net6 VSS nmos W=0.31u L=0.04u
M5566 WX5816 AND2_2016/net6 VDD VDD pmos W=0.41u L=0.04u
M5567 AND2_2016/net6 RESET VDD VDD pmos W=0.41u L=0.04u
M5568 AND2_2016/net6 WX5210 VDD VDD pmos W=0.41u L=0.04u
M5569 WX5718 AND2_2015/net6 VSS VSS nmos W=0.31u L=0.04u
M5570 AND2_2015/X_u2-net6 RESET VSS VSS nmos W=0.31u L=0.04u
M5571 AND2_2015/net6 WX5655 AND2_2015/X_u2-net6 VSS nmos W=0.31u L=0.04u
M5572 WX5718 AND2_2015/net6 VDD VDD pmos W=0.41u L=0.04u
M5573 AND2_2015/net6 RESET VDD VDD pmos W=0.41u L=0.04u
M5574 AND2_2015/net6 WX5655 VDD VDD pmos W=0.41u L=0.04u
M5575 WX5716 AND2_2014/net6 VSS VSS nmos W=0.31u L=0.04u
M5576 AND2_2014/X_u2-net6 RESET VSS VSS nmos W=0.31u L=0.04u
M5577 AND2_2014/net6 WX5719 AND2_2014/X_u2-net6 VSS nmos W=0.31u L=0.04u
M5578 WX5716 AND2_2014/net6 VDD VDD pmos W=0.41u L=0.04u
M5579 AND2_2014/net6 RESET VDD VDD pmos W=0.41u L=0.04u
M5580 AND2_2014/net6 WX5719 VDD VDD pmos W=0.41u L=0.04u
M5581 WX5714 AND2_2013/net6 VSS VSS nmos W=0.31u L=0.04u
M5582 AND2_2013/X_u2-net6 RESET VSS VSS nmos W=0.31u L=0.04u
M5583 AND2_2013/net6 WX5717 AND2_2013/X_u2-net6 VSS nmos W=0.31u L=0.04u
M5584 WX5714 AND2_2013/net6 VDD VDD pmos W=0.41u L=0.04u
M5585 AND2_2013/net6 RESET VDD VDD pmos W=0.41u L=0.04u
M5586 AND2_2013/net6 WX5717 VDD VDD pmos W=0.41u L=0.04u
M5587 WX5712 AND2_2012/net6 VSS VSS nmos W=0.31u L=0.04u
M5588 AND2_2012/X_u2-net6 RESET VSS VSS nmos W=0.31u L=0.04u
M5589 AND2_2012/net6 WX5715 AND2_2012/X_u2-net6 VSS nmos W=0.31u L=0.04u
M5590 WX5712 AND2_2012/net6 VDD VDD pmos W=0.41u L=0.04u
M5591 AND2_2012/net6 RESET VDD VDD pmos W=0.41u L=0.04u
M5592 AND2_2012/net6 WX5715 VDD VDD pmos W=0.41u L=0.04u
M5593 WX5710 AND2_2011/net6 VSS VSS nmos W=0.31u L=0.04u
M5594 AND2_2011/X_u2-net6 RESET VSS VSS nmos W=0.31u L=0.04u
M5595 AND2_2011/net6 WX5713 AND2_2011/X_u2-net6 VSS nmos W=0.31u L=0.04u
M5596 WX5710 AND2_2011/net6 VDD VDD pmos W=0.41u L=0.04u
M5597 AND2_2011/net6 RESET VDD VDD pmos W=0.41u L=0.04u
M5598 AND2_2011/net6 WX5713 VDD VDD pmos W=0.41u L=0.04u
M5599 WX5708 AND2_2010/net6 VSS VSS nmos W=0.31u L=0.04u
M5600 AND2_2010/X_u2-net6 RESET VSS VSS nmos W=0.31u L=0.04u
M5601 AND2_2010/net6 WX5711 AND2_2010/X_u2-net6 VSS nmos W=0.31u L=0.04u
M5602 WX5708 AND2_2010/net6 VDD VDD pmos W=0.41u L=0.04u
M5603 AND2_2010/net6 RESET VDD VDD pmos W=0.41u L=0.04u
M5604 AND2_2010/net6 WX5711 VDD VDD pmos W=0.41u L=0.04u
M5605 WX5706 AND2_2009/net6 VSS VSS nmos W=0.31u L=0.04u
M5606 AND2_2009/X_u2-net6 RESET VSS VSS nmos W=0.31u L=0.04u
M5607 AND2_2009/net6 WX5709 AND2_2009/X_u2-net6 VSS nmos W=0.31u L=0.04u
M5608 WX5706 AND2_2009/net6 VDD VDD pmos W=0.41u L=0.04u
M5609 AND2_2009/net6 RESET VDD VDD pmos W=0.41u L=0.04u
M5610 AND2_2009/net6 WX5709 VDD VDD pmos W=0.41u L=0.04u
M5611 WX5704 AND2_2008/net6 VSS VSS nmos W=0.31u L=0.04u
M5612 AND2_2008/X_u2-net6 RESET VSS VSS nmos W=0.31u L=0.04u
M5613 AND2_2008/net6 WX5707 AND2_2008/X_u2-net6 VSS nmos W=0.31u L=0.04u
M5614 WX5704 AND2_2008/net6 VDD VDD pmos W=0.41u L=0.04u
M5615 AND2_2008/net6 RESET VDD VDD pmos W=0.41u L=0.04u
M5616 AND2_2008/net6 WX5707 VDD VDD pmos W=0.41u L=0.04u
M5617 WX5702 AND2_2007/net6 VSS VSS nmos W=0.31u L=0.04u
M5618 AND2_2007/X_u2-net6 RESET VSS VSS nmos W=0.31u L=0.04u
M5619 AND2_2007/net6 WX5705 AND2_2007/X_u2-net6 VSS nmos W=0.31u L=0.04u
M5620 WX5702 AND2_2007/net6 VDD VDD pmos W=0.41u L=0.04u
M5621 AND2_2007/net6 RESET VDD VDD pmos W=0.41u L=0.04u
M5622 AND2_2007/net6 WX5705 VDD VDD pmos W=0.41u L=0.04u
M5623 WX5700 AND2_2006/net6 VSS VSS nmos W=0.31u L=0.04u
M5624 AND2_2006/X_u2-net6 RESET VSS VSS nmos W=0.31u L=0.04u
M5625 AND2_2006/net6 WX5703 AND2_2006/X_u2-net6 VSS nmos W=0.31u L=0.04u
M5626 WX5700 AND2_2006/net6 VDD VDD pmos W=0.41u L=0.04u
M5627 AND2_2006/net6 RESET VDD VDD pmos W=0.41u L=0.04u
M5628 AND2_2006/net6 WX5703 VDD VDD pmos W=0.41u L=0.04u
M5629 WX5698 AND2_2005/net6 VSS VSS nmos W=0.31u L=0.04u
M5630 AND2_2005/X_u2-net6 RESET VSS VSS nmos W=0.31u L=0.04u
M5631 AND2_2005/net6 WX5701 AND2_2005/X_u2-net6 VSS nmos W=0.31u L=0.04u
M5632 WX5698 AND2_2005/net6 VDD VDD pmos W=0.41u L=0.04u
M5633 AND2_2005/net6 RESET VDD VDD pmos W=0.41u L=0.04u
M5634 AND2_2005/net6 WX5701 VDD VDD pmos W=0.41u L=0.04u
M5635 WX5696 AND2_2004/net6 VSS VSS nmos W=0.31u L=0.04u
M5636 AND2_2004/X_u2-net6 RESET VSS VSS nmos W=0.31u L=0.04u
M5637 AND2_2004/net6 WX5699 AND2_2004/X_u2-net6 VSS nmos W=0.31u L=0.04u
M5638 WX5696 AND2_2004/net6 VDD VDD pmos W=0.41u L=0.04u
M5639 AND2_2004/net6 RESET VDD VDD pmos W=0.41u L=0.04u
M5640 AND2_2004/net6 WX5699 VDD VDD pmos W=0.41u L=0.04u
M5641 WX5694 AND2_2003/net6 VSS VSS nmos W=0.31u L=0.04u
M5642 AND2_2003/X_u2-net6 RESET VSS VSS nmos W=0.31u L=0.04u
M5643 AND2_2003/net6 WX5697 AND2_2003/X_u2-net6 VSS nmos W=0.31u L=0.04u
M5644 WX5694 AND2_2003/net6 VDD VDD pmos W=0.41u L=0.04u
M5645 AND2_2003/net6 RESET VDD VDD pmos W=0.41u L=0.04u
M5646 AND2_2003/net6 WX5697 VDD VDD pmos W=0.41u L=0.04u
M5647 WX5692 AND2_2002/net6 VSS VSS nmos W=0.31u L=0.04u
M5648 AND2_2002/X_u2-net6 RESET VSS VSS nmos W=0.31u L=0.04u
M5649 AND2_2002/net6 WX5695 AND2_2002/X_u2-net6 VSS nmos W=0.31u L=0.04u
M5650 WX5692 AND2_2002/net6 VDD VDD pmos W=0.41u L=0.04u
M5651 AND2_2002/net6 RESET VDD VDD pmos W=0.41u L=0.04u
M5652 AND2_2002/net6 WX5695 VDD VDD pmos W=0.41u L=0.04u
M5653 WX5690 AND2_2001/net6 VSS VSS nmos W=0.31u L=0.04u
M5654 AND2_2001/X_u2-net6 RESET VSS VSS nmos W=0.31u L=0.04u
M5655 AND2_2001/net6 WX5693 AND2_2001/X_u2-net6 VSS nmos W=0.31u L=0.04u
M5656 WX5690 AND2_2001/net6 VDD VDD pmos W=0.41u L=0.04u
M5657 AND2_2001/net6 RESET VDD VDD pmos W=0.41u L=0.04u
M5658 AND2_2001/net6 WX5693 VDD VDD pmos W=0.41u L=0.04u
M5659 WX5688 AND2_2000/net6 VSS VSS nmos W=0.31u L=0.04u
M5660 AND2_2000/X_u2-net6 RESET VSS VSS nmos W=0.31u L=0.04u
M5661 AND2_2000/net6 WX5691 AND2_2000/X_u2-net6 VSS nmos W=0.31u L=0.04u
M5662 WX5688 AND2_2000/net6 VDD VDD pmos W=0.41u L=0.04u
M5663 AND2_2000/net6 RESET VDD VDD pmos W=0.41u L=0.04u
M5664 AND2_2000/net6 WX5691 VDD VDD pmos W=0.41u L=0.04u
M5665 WX5686 AND2_1999/net6 VSS VSS nmos W=0.31u L=0.04u
M5666 AND2_1999/X_u2-net6 RESET VSS VSS nmos W=0.31u L=0.04u
M5667 AND2_1999/net6 WX5689 AND2_1999/X_u2-net6 VSS nmos W=0.31u L=0.04u
M5668 WX5686 AND2_1999/net6 VDD VDD pmos W=0.41u L=0.04u
M5669 AND2_1999/net6 RESET VDD VDD pmos W=0.41u L=0.04u
M5670 AND2_1999/net6 WX5689 VDD VDD pmos W=0.41u L=0.04u
M5671 WX5684 AND2_1998/net6 VSS VSS nmos W=0.31u L=0.04u
M5672 AND2_1998/X_u2-net6 RESET VSS VSS nmos W=0.31u L=0.04u
M5673 AND2_1998/net6 WX5687 AND2_1998/X_u2-net6 VSS nmos W=0.31u L=0.04u
M5674 WX5684 AND2_1998/net6 VDD VDD pmos W=0.41u L=0.04u
M5675 AND2_1998/net6 RESET VDD VDD pmos W=0.41u L=0.04u
M5676 AND2_1998/net6 WX5687 VDD VDD pmos W=0.41u L=0.04u
M5677 WX5682 AND2_1997/net6 VSS VSS nmos W=0.31u L=0.04u
M5678 AND2_1997/X_u2-net6 RESET VSS VSS nmos W=0.31u L=0.04u
M5679 AND2_1997/net6 WX5685 AND2_1997/X_u2-net6 VSS nmos W=0.31u L=0.04u
M5680 WX5682 AND2_1997/net6 VDD VDD pmos W=0.41u L=0.04u
M5681 AND2_1997/net6 RESET VDD VDD pmos W=0.41u L=0.04u
M5682 AND2_1997/net6 WX5685 VDD VDD pmos W=0.41u L=0.04u
M5683 WX5680 AND2_1996/net6 VSS VSS nmos W=0.31u L=0.04u
M5684 AND2_1996/X_u2-net6 RESET VSS VSS nmos W=0.31u L=0.04u
M5685 AND2_1996/net6 WX5683 AND2_1996/X_u2-net6 VSS nmos W=0.31u L=0.04u
M5686 WX5680 AND2_1996/net6 VDD VDD pmos W=0.41u L=0.04u
M5687 AND2_1996/net6 RESET VDD VDD pmos W=0.41u L=0.04u
M5688 AND2_1996/net6 WX5683 VDD VDD pmos W=0.41u L=0.04u
M5689 WX5678 AND2_1995/net6 VSS VSS nmos W=0.31u L=0.04u
M5690 AND2_1995/X_u2-net6 RESET VSS VSS nmos W=0.31u L=0.04u
M5691 AND2_1995/net6 WX5681 AND2_1995/X_u2-net6 VSS nmos W=0.31u L=0.04u
M5692 WX5678 AND2_1995/net6 VDD VDD pmos W=0.41u L=0.04u
M5693 AND2_1995/net6 RESET VDD VDD pmos W=0.41u L=0.04u
M5694 AND2_1995/net6 WX5681 VDD VDD pmos W=0.41u L=0.04u
M5695 WX5676 AND2_1994/net6 VSS VSS nmos W=0.31u L=0.04u
M5696 AND2_1994/X_u2-net6 RESET VSS VSS nmos W=0.31u L=0.04u
M5697 AND2_1994/net6 WX5679 AND2_1994/X_u2-net6 VSS nmos W=0.31u L=0.04u
M5698 WX5676 AND2_1994/net6 VDD VDD pmos W=0.41u L=0.04u
M5699 AND2_1994/net6 RESET VDD VDD pmos W=0.41u L=0.04u
M5700 AND2_1994/net6 WX5679 VDD VDD pmos W=0.41u L=0.04u
M5701 WX5674 AND2_1993/net6 VSS VSS nmos W=0.31u L=0.04u
M5702 AND2_1993/X_u2-net6 RESET VSS VSS nmos W=0.31u L=0.04u
M5703 AND2_1993/net6 WX5677 AND2_1993/X_u2-net6 VSS nmos W=0.31u L=0.04u
M5704 WX5674 AND2_1993/net6 VDD VDD pmos W=0.41u L=0.04u
M5705 AND2_1993/net6 RESET VDD VDD pmos W=0.41u L=0.04u
M5706 AND2_1993/net6 WX5677 VDD VDD pmos W=0.41u L=0.04u
M5707 WX5672 AND2_1992/net6 VSS VSS nmos W=0.31u L=0.04u
M5708 AND2_1992/X_u2-net6 RESET VSS VSS nmos W=0.31u L=0.04u
M5709 AND2_1992/net6 WX5675 AND2_1992/X_u2-net6 VSS nmos W=0.31u L=0.04u
M5710 WX5672 AND2_1992/net6 VDD VDD pmos W=0.41u L=0.04u
M5711 AND2_1992/net6 RESET VDD VDD pmos W=0.41u L=0.04u
M5712 AND2_1992/net6 WX5675 VDD VDD pmos W=0.41u L=0.04u
M5713 WX5670 AND2_1991/net6 VSS VSS nmos W=0.31u L=0.04u
M5714 AND2_1991/X_u2-net6 RESET VSS VSS nmos W=0.31u L=0.04u
M5715 AND2_1991/net6 WX5673 AND2_1991/X_u2-net6 VSS nmos W=0.31u L=0.04u
M5716 WX5670 AND2_1991/net6 VDD VDD pmos W=0.41u L=0.04u
M5717 AND2_1991/net6 RESET VDD VDD pmos W=0.41u L=0.04u
M5718 AND2_1991/net6 WX5673 VDD VDD pmos W=0.41u L=0.04u
M5719 WX5668 AND2_1990/net6 VSS VSS nmos W=0.31u L=0.04u
M5720 AND2_1990/X_u2-net6 RESET VSS VSS nmos W=0.31u L=0.04u
M5721 AND2_1990/net6 WX5671 AND2_1990/X_u2-net6 VSS nmos W=0.31u L=0.04u
M5722 WX5668 AND2_1990/net6 VDD VDD pmos W=0.41u L=0.04u
M5723 AND2_1990/net6 RESET VDD VDD pmos W=0.41u L=0.04u
M5724 AND2_1990/net6 WX5671 VDD VDD pmos W=0.41u L=0.04u
M5725 WX5666 AND2_1989/net6 VSS VSS nmos W=0.31u L=0.04u
M5726 AND2_1989/X_u2-net6 RESET VSS VSS nmos W=0.31u L=0.04u
M5727 AND2_1989/net6 WX5669 AND2_1989/X_u2-net6 VSS nmos W=0.31u L=0.04u
M5728 WX5666 AND2_1989/net6 VDD VDD pmos W=0.41u L=0.04u
M5729 AND2_1989/net6 RESET VDD VDD pmos W=0.41u L=0.04u
M5730 AND2_1989/net6 WX5669 VDD VDD pmos W=0.41u L=0.04u
M5731 WX5664 AND2_1988/net6 VSS VSS nmos W=0.31u L=0.04u
M5732 AND2_1988/X_u2-net6 RESET VSS VSS nmos W=0.31u L=0.04u
M5733 AND2_1988/net6 WX5667 AND2_1988/X_u2-net6 VSS nmos W=0.31u L=0.04u
M5734 WX5664 AND2_1988/net6 VDD VDD pmos W=0.41u L=0.04u
M5735 AND2_1988/net6 RESET VDD VDD pmos W=0.41u L=0.04u
M5736 AND2_1988/net6 WX5667 VDD VDD pmos W=0.41u L=0.04u
M5737 WX5662 AND2_1987/net6 VSS VSS nmos W=0.31u L=0.04u
M5738 AND2_1987/X_u2-net6 RESET VSS VSS nmos W=0.31u L=0.04u
M5739 AND2_1987/net6 WX5665 AND2_1987/X_u2-net6 VSS nmos W=0.31u L=0.04u
M5740 WX5662 AND2_1987/net6 VDD VDD pmos W=0.41u L=0.04u
M5741 AND2_1987/net6 RESET VDD VDD pmos W=0.41u L=0.04u
M5742 AND2_1987/net6 WX5665 VDD VDD pmos W=0.41u L=0.04u
M5743 WX5660 AND2_1986/net6 VSS VSS nmos W=0.31u L=0.04u
M5744 AND2_1986/X_u2-net6 RESET VSS VSS nmos W=0.31u L=0.04u
M5745 AND2_1986/net6 WX5663 AND2_1986/X_u2-net6 VSS nmos W=0.31u L=0.04u
M5746 WX5660 AND2_1986/net6 VDD VDD pmos W=0.41u L=0.04u
M5747 AND2_1986/net6 RESET VDD VDD pmos W=0.41u L=0.04u
M5748 AND2_1986/net6 WX5663 VDD VDD pmos W=0.41u L=0.04u
M5749 WX5658 AND2_1985/net6 VSS VSS nmos W=0.31u L=0.04u
M5750 AND2_1985/X_u2-net6 RESET VSS VSS nmos W=0.31u L=0.04u
M5751 AND2_1985/net6 WX5661 AND2_1985/X_u2-net6 VSS nmos W=0.31u L=0.04u
M5752 WX5658 AND2_1985/net6 VDD VDD pmos W=0.41u L=0.04u
M5753 AND2_1985/net6 RESET VDD VDD pmos W=0.41u L=0.04u
M5754 AND2_1985/net6 WX5661 VDD VDD pmos W=0.41u L=0.04u
M5755 WX5656 AND2_1984/net6 VSS VSS nmos W=0.31u L=0.04u
M5756 AND2_1984/X_u2-net6 RESET VSS VSS nmos W=0.31u L=0.04u
M5757 AND2_1984/net6 WX5659 AND2_1984/X_u2-net6 VSS nmos W=0.31u L=0.04u
M5758 WX5656 AND2_1984/net6 VDD VDD pmos W=0.41u L=0.04u
M5759 AND2_1984/net6 RESET VDD VDD pmos W=0.41u L=0.04u
M5760 AND2_1984/net6 WX5659 VDD VDD pmos W=0.41u L=0.04u
M5761 WX5205 AND2_1791/net6 VSS VSS nmos W=0.31u L=0.04u
M5762 AND2_1791/X_u2-net6 RESET VSS VSS nmos W=0.31u L=0.04u
M5763 AND2_1791/net6 n1048 AND2_1791/X_u2-net6 VSS nmos W=0.31u L=0.04u
M5764 WX5205 AND2_1791/net6 VDD VDD pmos W=0.41u L=0.04u
M5765 AND2_1791/net6 RESET VDD VDD pmos W=0.41u L=0.04u
M5766 AND2_1791/net6 n1048 VDD VDD pmos W=0.41u L=0.04u
M5767 WX5203 AND2_1790/net6 VSS VSS nmos W=0.31u L=0.04u
M5768 AND2_1790/X_u2-net6 RESET VSS VSS nmos W=0.31u L=0.04u
M5769 AND2_1790/net6 n1049 AND2_1790/X_u2-net6 VSS nmos W=0.31u L=0.04u
M5770 WX5203 AND2_1790/net6 VDD VDD pmos W=0.41u L=0.04u
M5771 AND2_1790/net6 RESET VDD VDD pmos W=0.41u L=0.04u
M5772 AND2_1790/net6 n1049 VDD VDD pmos W=0.41u L=0.04u
M5773 WX5201 AND2_1789/net6 VSS VSS nmos W=0.31u L=0.04u
M5774 AND2_1789/X_u2-net6 RESET VSS VSS nmos W=0.31u L=0.04u
M5775 AND2_1789/net6 n1050 AND2_1789/X_u2-net6 VSS nmos W=0.31u L=0.04u
M5776 WX5201 AND2_1789/net6 VDD VDD pmos W=0.41u L=0.04u
M5777 AND2_1789/net6 RESET VDD VDD pmos W=0.41u L=0.04u
M5778 AND2_1789/net6 n1050 VDD VDD pmos W=0.41u L=0.04u
M5779 WX5199 AND2_1788/net6 VSS VSS nmos W=0.31u L=0.04u
M5780 AND2_1788/X_u2-net6 RESET VSS VSS nmos W=0.31u L=0.04u
M5781 AND2_1788/net6 n1051 AND2_1788/X_u2-net6 VSS nmos W=0.31u L=0.04u
M5782 WX5199 AND2_1788/net6 VDD VDD pmos W=0.41u L=0.04u
M5783 AND2_1788/net6 RESET VDD VDD pmos W=0.41u L=0.04u
M5784 AND2_1788/net6 n1051 VDD VDD pmos W=0.41u L=0.04u
M5785 WX5197 AND2_1787/net6 VSS VSS nmos W=0.31u L=0.04u
M5786 AND2_1787/X_u2-net6 RESET VSS VSS nmos W=0.31u L=0.04u
M5787 AND2_1787/net6 n1052 AND2_1787/X_u2-net6 VSS nmos W=0.31u L=0.04u
M5788 WX5197 AND2_1787/net6 VDD VDD pmos W=0.41u L=0.04u
M5789 AND2_1787/net6 RESET VDD VDD pmos W=0.41u L=0.04u
M5790 AND2_1787/net6 n1052 VDD VDD pmos W=0.41u L=0.04u
M5791 WX5195 AND2_1786/net6 VSS VSS nmos W=0.31u L=0.04u
M5792 AND2_1786/X_u2-net6 RESET VSS VSS nmos W=0.31u L=0.04u
M5793 AND2_1786/net6 n1053 AND2_1786/X_u2-net6 VSS nmos W=0.31u L=0.04u
M5794 WX5195 AND2_1786/net6 VDD VDD pmos W=0.41u L=0.04u
M5795 AND2_1786/net6 RESET VDD VDD pmos W=0.41u L=0.04u
M5796 AND2_1786/net6 n1053 VDD VDD pmos W=0.41u L=0.04u
M5797 WX5193 AND2_1785/net6 VSS VSS nmos W=0.31u L=0.04u
M5798 AND2_1785/X_u2-net6 RESET VSS VSS nmos W=0.31u L=0.04u
M5799 AND2_1785/net6 n1054 AND2_1785/X_u2-net6 VSS nmos W=0.31u L=0.04u
M5800 WX5193 AND2_1785/net6 VDD VDD pmos W=0.41u L=0.04u
M5801 AND2_1785/net6 RESET VDD VDD pmos W=0.41u L=0.04u
M5802 AND2_1785/net6 n1054 VDD VDD pmos W=0.41u L=0.04u
M5803 WX5191 AND2_1784/net6 VSS VSS nmos W=0.31u L=0.04u
M5804 AND2_1784/X_u2-net6 RESET VSS VSS nmos W=0.31u L=0.04u
M5805 AND2_1784/net6 n1055 AND2_1784/X_u2-net6 VSS nmos W=0.31u L=0.04u
M5806 WX5191 AND2_1784/net6 VDD VDD pmos W=0.41u L=0.04u
M5807 AND2_1784/net6 RESET VDD VDD pmos W=0.41u L=0.04u
M5808 AND2_1784/net6 n1055 VDD VDD pmos W=0.41u L=0.04u
M5809 WX5189 AND2_1783/net6 VSS VSS nmos W=0.31u L=0.04u
M5810 AND2_1783/X_u2-net6 RESET VSS VSS nmos W=0.31u L=0.04u
M5811 AND2_1783/net6 n1056 AND2_1783/X_u2-net6 VSS nmos W=0.31u L=0.04u
M5812 WX5189 AND2_1783/net6 VDD VDD pmos W=0.41u L=0.04u
M5813 AND2_1783/net6 RESET VDD VDD pmos W=0.41u L=0.04u
M5814 AND2_1783/net6 n1056 VDD VDD pmos W=0.41u L=0.04u
M5815 WX5187 AND2_1782/net6 VSS VSS nmos W=0.31u L=0.04u
M5816 AND2_1782/X_u2-net6 RESET VSS VSS nmos W=0.31u L=0.04u
M5817 AND2_1782/net6 n1057 AND2_1782/X_u2-net6 VSS nmos W=0.31u L=0.04u
M5818 WX5187 AND2_1782/net6 VDD VDD pmos W=0.41u L=0.04u
M5819 AND2_1782/net6 RESET VDD VDD pmos W=0.41u L=0.04u
M5820 AND2_1782/net6 n1057 VDD VDD pmos W=0.41u L=0.04u
M5821 WX5185 AND2_1781/net6 VSS VSS nmos W=0.31u L=0.04u
M5822 AND2_1781/X_u2-net6 RESET VSS VSS nmos W=0.31u L=0.04u
M5823 AND2_1781/net6 n1058 AND2_1781/X_u2-net6 VSS nmos W=0.31u L=0.04u
M5824 WX5185 AND2_1781/net6 VDD VDD pmos W=0.41u L=0.04u
M5825 AND2_1781/net6 RESET VDD VDD pmos W=0.41u L=0.04u
M5826 AND2_1781/net6 n1058 VDD VDD pmos W=0.41u L=0.04u
M5827 WX5183 AND2_1780/net6 VSS VSS nmos W=0.31u L=0.04u
M5828 AND2_1780/X_u2-net6 RESET VSS VSS nmos W=0.31u L=0.04u
M5829 AND2_1780/net6 n1059 AND2_1780/X_u2-net6 VSS nmos W=0.31u L=0.04u
M5830 WX5183 AND2_1780/net6 VDD VDD pmos W=0.41u L=0.04u
M5831 AND2_1780/net6 RESET VDD VDD pmos W=0.41u L=0.04u
M5832 AND2_1780/net6 n1059 VDD VDD pmos W=0.41u L=0.04u
M5833 WX5181 AND2_1779/net6 VSS VSS nmos W=0.31u L=0.04u
M5834 AND2_1779/X_u2-net6 RESET VSS VSS nmos W=0.31u L=0.04u
M5835 AND2_1779/net6 n1060 AND2_1779/X_u2-net6 VSS nmos W=0.31u L=0.04u
M5836 WX5181 AND2_1779/net6 VDD VDD pmos W=0.41u L=0.04u
M5837 AND2_1779/net6 RESET VDD VDD pmos W=0.41u L=0.04u
M5838 AND2_1779/net6 n1060 VDD VDD pmos W=0.41u L=0.04u
M5839 WX5179 AND2_1778/net6 VSS VSS nmos W=0.31u L=0.04u
M5840 AND2_1778/X_u2-net6 RESET VSS VSS nmos W=0.31u L=0.04u
M5841 AND2_1778/net6 n1061 AND2_1778/X_u2-net6 VSS nmos W=0.31u L=0.04u
M5842 WX5179 AND2_1778/net6 VDD VDD pmos W=0.41u L=0.04u
M5843 AND2_1778/net6 RESET VDD VDD pmos W=0.41u L=0.04u
M5844 AND2_1778/net6 n1061 VDD VDD pmos W=0.41u L=0.04u
M5845 WX5177 AND2_1777/net6 VSS VSS nmos W=0.31u L=0.04u
M5846 AND2_1777/X_u2-net6 RESET VSS VSS nmos W=0.31u L=0.04u
M5847 AND2_1777/net6 n1062 AND2_1777/X_u2-net6 VSS nmos W=0.31u L=0.04u
M5848 WX5177 AND2_1777/net6 VDD VDD pmos W=0.41u L=0.04u
M5849 AND2_1777/net6 RESET VDD VDD pmos W=0.41u L=0.04u
M5850 AND2_1777/net6 n1062 VDD VDD pmos W=0.41u L=0.04u
M5851 WX5175 AND2_1776/net6 VSS VSS nmos W=0.31u L=0.04u
M5852 AND2_1776/X_u2-net6 RESET VSS VSS nmos W=0.31u L=0.04u
M5853 AND2_1776/net6 n1063 AND2_1776/X_u2-net6 VSS nmos W=0.31u L=0.04u
M5854 WX5175 AND2_1776/net6 VDD VDD pmos W=0.41u L=0.04u
M5855 AND2_1776/net6 RESET VDD VDD pmos W=0.41u L=0.04u
M5856 AND2_1776/net6 n1063 VDD VDD pmos W=0.41u L=0.04u
M5857 WX5173 AND2_1775/net6 VSS VSS nmos W=0.31u L=0.04u
M5858 AND2_1775/X_u2-net6 RESET VSS VSS nmos W=0.31u L=0.04u
M5859 AND2_1775/net6 n1064 AND2_1775/X_u2-net6 VSS nmos W=0.31u L=0.04u
M5860 WX5173 AND2_1775/net6 VDD VDD pmos W=0.41u L=0.04u
M5861 AND2_1775/net6 RESET VDD VDD pmos W=0.41u L=0.04u
M5862 AND2_1775/net6 n1064 VDD VDD pmos W=0.41u L=0.04u
M5863 WX5171 AND2_1774/net6 VSS VSS nmos W=0.31u L=0.04u
M5864 AND2_1774/X_u2-net6 RESET VSS VSS nmos W=0.31u L=0.04u
M5865 AND2_1774/net6 n1065 AND2_1774/X_u2-net6 VSS nmos W=0.31u L=0.04u
M5866 WX5171 AND2_1774/net6 VDD VDD pmos W=0.41u L=0.04u
M5867 AND2_1774/net6 RESET VDD VDD pmos W=0.41u L=0.04u
M5868 AND2_1774/net6 n1065 VDD VDD pmos W=0.41u L=0.04u
M5869 WX5169 AND2_1773/net6 VSS VSS nmos W=0.31u L=0.04u
M5870 AND2_1773/X_u2-net6 RESET VSS VSS nmos W=0.31u L=0.04u
M5871 AND2_1773/net6 n1066 AND2_1773/X_u2-net6 VSS nmos W=0.31u L=0.04u
M5872 WX5169 AND2_1773/net6 VDD VDD pmos W=0.41u L=0.04u
M5873 AND2_1773/net6 RESET VDD VDD pmos W=0.41u L=0.04u
M5874 AND2_1773/net6 n1066 VDD VDD pmos W=0.41u L=0.04u
M5875 WX5167 AND2_1772/net6 VSS VSS nmos W=0.31u L=0.04u
M5876 AND2_1772/X_u2-net6 RESET VSS VSS nmos W=0.31u L=0.04u
M5877 AND2_1772/net6 n1067 AND2_1772/X_u2-net6 VSS nmos W=0.31u L=0.04u
M5878 WX5167 AND2_1772/net6 VDD VDD pmos W=0.41u L=0.04u
M5879 AND2_1772/net6 RESET VDD VDD pmos W=0.41u L=0.04u
M5880 AND2_1772/net6 n1067 VDD VDD pmos W=0.41u L=0.04u
M5881 WX5165 AND2_1771/net6 VSS VSS nmos W=0.31u L=0.04u
M5882 AND2_1771/X_u2-net6 RESET VSS VSS nmos W=0.31u L=0.04u
M5883 AND2_1771/net6 n1068 AND2_1771/X_u2-net6 VSS nmos W=0.31u L=0.04u
M5884 WX5165 AND2_1771/net6 VDD VDD pmos W=0.41u L=0.04u
M5885 AND2_1771/net6 RESET VDD VDD pmos W=0.41u L=0.04u
M5886 AND2_1771/net6 n1068 VDD VDD pmos W=0.41u L=0.04u
M5887 WX5163 AND2_1770/net6 VSS VSS nmos W=0.31u L=0.04u
M5888 AND2_1770/X_u2-net6 RESET VSS VSS nmos W=0.31u L=0.04u
M5889 AND2_1770/net6 n1069 AND2_1770/X_u2-net6 VSS nmos W=0.31u L=0.04u
M5890 WX5163 AND2_1770/net6 VDD VDD pmos W=0.41u L=0.04u
M5891 AND2_1770/net6 RESET VDD VDD pmos W=0.41u L=0.04u
M5892 AND2_1770/net6 n1069 VDD VDD pmos W=0.41u L=0.04u
M5893 WX5161 AND2_1769/net6 VSS VSS nmos W=0.31u L=0.04u
M5894 AND2_1769/X_u2-net6 RESET VSS VSS nmos W=0.31u L=0.04u
M5895 AND2_1769/net6 n1070 AND2_1769/X_u2-net6 VSS nmos W=0.31u L=0.04u
M5896 WX5161 AND2_1769/net6 VDD VDD pmos W=0.41u L=0.04u
M5897 AND2_1769/net6 RESET VDD VDD pmos W=0.41u L=0.04u
M5898 AND2_1769/net6 n1070 VDD VDD pmos W=0.41u L=0.04u
M5899 WX5159 AND2_1768/net6 VSS VSS nmos W=0.31u L=0.04u
M5900 AND2_1768/X_u2-net6 RESET VSS VSS nmos W=0.31u L=0.04u
M5901 AND2_1768/net6 n1071 AND2_1768/X_u2-net6 VSS nmos W=0.31u L=0.04u
M5902 WX5159 AND2_1768/net6 VDD VDD pmos W=0.41u L=0.04u
M5903 AND2_1768/net6 RESET VDD VDD pmos W=0.41u L=0.04u
M5904 AND2_1768/net6 n1071 VDD VDD pmos W=0.41u L=0.04u
M5905 WX5157 AND2_1767/net6 VSS VSS nmos W=0.31u L=0.04u
M5906 AND2_1767/X_u2-net6 RESET VSS VSS nmos W=0.31u L=0.04u
M5907 AND2_1767/net6 n1072 AND2_1767/X_u2-net6 VSS nmos W=0.31u L=0.04u
M5908 WX5157 AND2_1767/net6 VDD VDD pmos W=0.41u L=0.04u
M5909 AND2_1767/net6 RESET VDD VDD pmos W=0.41u L=0.04u
M5910 AND2_1767/net6 n1072 VDD VDD pmos W=0.41u L=0.04u
M5911 WX5155 AND2_1766/net6 VSS VSS nmos W=0.31u L=0.04u
M5912 AND2_1766/X_u2-net6 RESET VSS VSS nmos W=0.31u L=0.04u
M5913 AND2_1766/net6 n1073 AND2_1766/X_u2-net6 VSS nmos W=0.31u L=0.04u
M5914 WX5155 AND2_1766/net6 VDD VDD pmos W=0.41u L=0.04u
M5915 AND2_1766/net6 RESET VDD VDD pmos W=0.41u L=0.04u
M5916 AND2_1766/net6 n1073 VDD VDD pmos W=0.41u L=0.04u
M5917 WX5153 AND2_1765/net6 VSS VSS nmos W=0.31u L=0.04u
M5918 AND2_1765/X_u2-net6 RESET VSS VSS nmos W=0.31u L=0.04u
M5919 AND2_1765/net6 n1074 AND2_1765/X_u2-net6 VSS nmos W=0.31u L=0.04u
M5920 WX5153 AND2_1765/net6 VDD VDD pmos W=0.41u L=0.04u
M5921 AND2_1765/net6 RESET VDD VDD pmos W=0.41u L=0.04u
M5922 AND2_1765/net6 n1074 VDD VDD pmos W=0.41u L=0.04u
M5923 WX5151 AND2_1764/net6 VSS VSS nmos W=0.31u L=0.04u
M5924 AND2_1764/X_u2-net6 RESET VSS VSS nmos W=0.31u L=0.04u
M5925 AND2_1764/net6 n1075 AND2_1764/X_u2-net6 VSS nmos W=0.31u L=0.04u
M5926 WX5151 AND2_1764/net6 VDD VDD pmos W=0.41u L=0.04u
M5927 AND2_1764/net6 RESET VDD VDD pmos W=0.41u L=0.04u
M5928 AND2_1764/net6 n1075 VDD VDD pmos W=0.41u L=0.04u
M5929 WX5149 AND2_1763/net6 VSS VSS nmos W=0.31u L=0.04u
M5930 AND2_1763/X_u2-net6 RESET VSS VSS nmos W=0.31u L=0.04u
M5931 AND2_1763/net6 n1076 AND2_1763/X_u2-net6 VSS nmos W=0.31u L=0.04u
M5932 WX5149 AND2_1763/net6 VDD VDD pmos W=0.41u L=0.04u
M5933 AND2_1763/net6 RESET VDD VDD pmos W=0.41u L=0.04u
M5934 AND2_1763/net6 n1076 VDD VDD pmos W=0.41u L=0.04u
M5935 WX5147 AND2_1762/net6 VSS VSS nmos W=0.31u L=0.04u
M5936 AND2_1762/X_u2-net6 RESET VSS VSS nmos W=0.31u L=0.04u
M5937 AND2_1762/net6 n1077 AND2_1762/X_u2-net6 VSS nmos W=0.31u L=0.04u
M5938 WX5147 AND2_1762/net6 VDD VDD pmos W=0.41u L=0.04u
M5939 AND2_1762/net6 RESET VDD VDD pmos W=0.41u L=0.04u
M5940 AND2_1762/net6 n1077 VDD VDD pmos W=0.41u L=0.04u
M5941 WX5145 AND2_1761/net6 VSS VSS nmos W=0.31u L=0.04u
M5942 AND2_1761/X_u2-net6 RESET VSS VSS nmos W=0.31u L=0.04u
M5943 AND2_1761/net6 n1078 AND2_1761/X_u2-net6 VSS nmos W=0.31u L=0.04u
M5944 WX5145 AND2_1761/net6 VDD VDD pmos W=0.41u L=0.04u
M5945 AND2_1761/net6 RESET VDD VDD pmos W=0.41u L=0.04u
M5946 AND2_1761/net6 n1078 VDD VDD pmos W=0.41u L=0.04u
M5947 WX5143 AND2_1760/net6 VSS VSS nmos W=0.31u L=0.04u
M5948 AND2_1760/X_u2-net6 RESET VSS VSS nmos W=0.31u L=0.04u
M5949 AND2_1760/net6 n1079 AND2_1760/X_u2-net6 VSS nmos W=0.31u L=0.04u
M5950 WX5143 AND2_1760/net6 VDD VDD pmos W=0.41u L=0.04u
M5951 AND2_1760/net6 RESET VDD VDD pmos W=0.41u L=0.04u
M5952 AND2_1760/net6 n1079 VDD VDD pmos W=0.41u L=0.04u
M5953 WX4777 AND2_1695/net6 VSS VSS nmos W=0.31u L=0.04u
M5954 AND2_1695/X_u2-net6 RESET VSS VSS nmos W=0.31u L=0.04u
M5955 AND2_1695/net6 WX4714 AND2_1695/X_u2-net6 VSS nmos W=0.31u L=0.04u
M5956 WX4777 AND2_1695/net6 VDD VDD pmos W=0.41u L=0.04u
M5957 AND2_1695/net6 RESET VDD VDD pmos W=0.41u L=0.04u
M5958 AND2_1695/net6 WX4714 VDD VDD pmos W=0.41u L=0.04u
M5959 WX4775 AND2_1694/net6 VSS VSS nmos W=0.31u L=0.04u
M5960 AND2_1694/X_u2-net6 RESET VSS VSS nmos W=0.31u L=0.04u
M5961 AND2_1694/net6 WX4712 AND2_1694/X_u2-net6 VSS nmos W=0.31u L=0.04u
M5962 WX4775 AND2_1694/net6 VDD VDD pmos W=0.41u L=0.04u
M5963 AND2_1694/net6 RESET VDD VDD pmos W=0.41u L=0.04u
M5964 AND2_1694/net6 WX4712 VDD VDD pmos W=0.41u L=0.04u
M5965 WX4773 AND2_1693/net6 VSS VSS nmos W=0.31u L=0.04u
M5966 AND2_1693/X_u2-net6 RESET VSS VSS nmos W=0.31u L=0.04u
M5967 AND2_1693/net6 WX4710 AND2_1693/X_u2-net6 VSS nmos W=0.31u L=0.04u
M5968 WX4773 AND2_1693/net6 VDD VDD pmos W=0.41u L=0.04u
M5969 AND2_1693/net6 RESET VDD VDD pmos W=0.41u L=0.04u
M5970 AND2_1693/net6 WX4710 VDD VDD pmos W=0.41u L=0.04u
M5971 WX4771 AND2_1692/net6 VSS VSS nmos W=0.31u L=0.04u
M5972 AND2_1692/X_u2-net6 RESET VSS VSS nmos W=0.31u L=0.04u
M5973 AND2_1692/net6 WX4708 AND2_1692/X_u2-net6 VSS nmos W=0.31u L=0.04u
M5974 WX4771 AND2_1692/net6 VDD VDD pmos W=0.41u L=0.04u
M5975 AND2_1692/net6 RESET VDD VDD pmos W=0.41u L=0.04u
M5976 AND2_1692/net6 WX4708 VDD VDD pmos W=0.41u L=0.04u
M5977 WX4769 AND2_1691/net6 VSS VSS nmos W=0.31u L=0.04u
M5978 AND2_1691/X_u2-net6 RESET VSS VSS nmos W=0.31u L=0.04u
M5979 AND2_1691/net6 WX4706 AND2_1691/X_u2-net6 VSS nmos W=0.31u L=0.04u
M5980 WX4769 AND2_1691/net6 VDD VDD pmos W=0.41u L=0.04u
M5981 AND2_1691/net6 RESET VDD VDD pmos W=0.41u L=0.04u
M5982 AND2_1691/net6 WX4706 VDD VDD pmos W=0.41u L=0.04u
M5983 WX4767 AND2_1690/net6 VSS VSS nmos W=0.31u L=0.04u
M5984 AND2_1690/X_u2-net6 RESET VSS VSS nmos W=0.31u L=0.04u
M5985 AND2_1690/net6 WX4704 AND2_1690/X_u2-net6 VSS nmos W=0.31u L=0.04u
M5986 WX4767 AND2_1690/net6 VDD VDD pmos W=0.41u L=0.04u
M5987 AND2_1690/net6 RESET VDD VDD pmos W=0.41u L=0.04u
M5988 AND2_1690/net6 WX4704 VDD VDD pmos W=0.41u L=0.04u
M5989 WX4765 AND2_1689/net6 VSS VSS nmos W=0.31u L=0.04u
M5990 AND2_1689/X_u2-net6 RESET VSS VSS nmos W=0.31u L=0.04u
M5991 AND2_1689/net6 WX4702 AND2_1689/X_u2-net6 VSS nmos W=0.31u L=0.04u
M5992 WX4765 AND2_1689/net6 VDD VDD pmos W=0.41u L=0.04u
M5993 AND2_1689/net6 RESET VDD VDD pmos W=0.41u L=0.04u
M5994 AND2_1689/net6 WX4702 VDD VDD pmos W=0.41u L=0.04u
M5995 WX4763 AND2_1688/net6 VSS VSS nmos W=0.31u L=0.04u
M5996 AND2_1688/X_u2-net6 RESET VSS VSS nmos W=0.31u L=0.04u
M5997 AND2_1688/net6 WX4700 AND2_1688/X_u2-net6 VSS nmos W=0.31u L=0.04u
M5998 WX4763 AND2_1688/net6 VDD VDD pmos W=0.41u L=0.04u
M5999 AND2_1688/net6 RESET VDD VDD pmos W=0.41u L=0.04u
M6000 AND2_1688/net6 WX4700 VDD VDD pmos W=0.41u L=0.04u
M6001 WX4761 AND2_1687/net6 VSS VSS nmos W=0.31u L=0.04u
M6002 AND2_1687/X_u2-net6 RESET VSS VSS nmos W=0.31u L=0.04u
M6003 AND2_1687/net6 WX4698 AND2_1687/X_u2-net6 VSS nmos W=0.31u L=0.04u
M6004 WX4761 AND2_1687/net6 VDD VDD pmos W=0.41u L=0.04u
M6005 AND2_1687/net6 RESET VDD VDD pmos W=0.41u L=0.04u
M6006 AND2_1687/net6 WX4698 VDD VDD pmos W=0.41u L=0.04u
M6007 WX4759 AND2_1686/net6 VSS VSS nmos W=0.31u L=0.04u
M6008 AND2_1686/X_u2-net6 RESET VSS VSS nmos W=0.31u L=0.04u
M6009 AND2_1686/net6 WX4696 AND2_1686/X_u2-net6 VSS nmos W=0.31u L=0.04u
M6010 WX4759 AND2_1686/net6 VDD VDD pmos W=0.41u L=0.04u
M6011 AND2_1686/net6 RESET VDD VDD pmos W=0.41u L=0.04u
M6012 AND2_1686/net6 WX4696 VDD VDD pmos W=0.41u L=0.04u
M6013 WX4757 AND2_1685/net6 VSS VSS nmos W=0.31u L=0.04u
M6014 AND2_1685/X_u2-net6 RESET VSS VSS nmos W=0.31u L=0.04u
M6015 AND2_1685/net6 WX4694 AND2_1685/X_u2-net6 VSS nmos W=0.31u L=0.04u
M6016 WX4757 AND2_1685/net6 VDD VDD pmos W=0.41u L=0.04u
M6017 AND2_1685/net6 RESET VDD VDD pmos W=0.41u L=0.04u
M6018 AND2_1685/net6 WX4694 VDD VDD pmos W=0.41u L=0.04u
M6019 WX4755 AND2_1684/net6 VSS VSS nmos W=0.31u L=0.04u
M6020 AND2_1684/X_u2-net6 RESET VSS VSS nmos W=0.31u L=0.04u
M6021 AND2_1684/net6 WX4692 AND2_1684/X_u2-net6 VSS nmos W=0.31u L=0.04u
M6022 WX4755 AND2_1684/net6 VDD VDD pmos W=0.41u L=0.04u
M6023 AND2_1684/net6 RESET VDD VDD pmos W=0.41u L=0.04u
M6024 AND2_1684/net6 WX4692 VDD VDD pmos W=0.41u L=0.04u
M6025 WX4753 AND2_1683/net6 VSS VSS nmos W=0.31u L=0.04u
M6026 AND2_1683/X_u2-net6 RESET VSS VSS nmos W=0.31u L=0.04u
M6027 AND2_1683/net6 WX4690 AND2_1683/X_u2-net6 VSS nmos W=0.31u L=0.04u
M6028 WX4753 AND2_1683/net6 VDD VDD pmos W=0.41u L=0.04u
M6029 AND2_1683/net6 RESET VDD VDD pmos W=0.41u L=0.04u
M6030 AND2_1683/net6 WX4690 VDD VDD pmos W=0.41u L=0.04u
M6031 WX4751 AND2_1682/net6 VSS VSS nmos W=0.31u L=0.04u
M6032 AND2_1682/X_u2-net6 RESET VSS VSS nmos W=0.31u L=0.04u
M6033 AND2_1682/net6 WX4688 AND2_1682/X_u2-net6 VSS nmos W=0.31u L=0.04u
M6034 WX4751 AND2_1682/net6 VDD VDD pmos W=0.41u L=0.04u
M6035 AND2_1682/net6 RESET VDD VDD pmos W=0.41u L=0.04u
M6036 AND2_1682/net6 WX4688 VDD VDD pmos W=0.41u L=0.04u
M6037 WX4749 AND2_1681/net6 VSS VSS nmos W=0.31u L=0.04u
M6038 AND2_1681/X_u2-net6 RESET VSS VSS nmos W=0.31u L=0.04u
M6039 AND2_1681/net6 WX4686 AND2_1681/X_u2-net6 VSS nmos W=0.31u L=0.04u
M6040 WX4749 AND2_1681/net6 VDD VDD pmos W=0.41u L=0.04u
M6041 AND2_1681/net6 RESET VDD VDD pmos W=0.41u L=0.04u
M6042 AND2_1681/net6 WX4686 VDD VDD pmos W=0.41u L=0.04u
M6043 WX4747 AND2_1680/net6 VSS VSS nmos W=0.31u L=0.04u
M6044 AND2_1680/X_u2-net6 RESET VSS VSS nmos W=0.31u L=0.04u
M6045 AND2_1680/net6 WX4684 AND2_1680/X_u2-net6 VSS nmos W=0.31u L=0.04u
M6046 WX4747 AND2_1680/net6 VDD VDD pmos W=0.41u L=0.04u
M6047 AND2_1680/net6 RESET VDD VDD pmos W=0.41u L=0.04u
M6048 AND2_1680/net6 WX4684 VDD VDD pmos W=0.41u L=0.04u
M6049 WX4745 AND2_1679/net6 VSS VSS nmos W=0.31u L=0.04u
M6050 AND2_1679/X_u2-net6 RESET VSS VSS nmos W=0.31u L=0.04u
M6051 AND2_1679/net6 WX4682 AND2_1679/X_u2-net6 VSS nmos W=0.31u L=0.04u
M6052 WX4745 AND2_1679/net6 VDD VDD pmos W=0.41u L=0.04u
M6053 AND2_1679/net6 RESET VDD VDD pmos W=0.41u L=0.04u
M6054 AND2_1679/net6 WX4682 VDD VDD pmos W=0.41u L=0.04u
M6055 WX4743 AND2_1678/net6 VSS VSS nmos W=0.31u L=0.04u
M6056 AND2_1678/X_u2-net6 RESET VSS VSS nmos W=0.31u L=0.04u
M6057 AND2_1678/net6 WX4680 AND2_1678/X_u2-net6 VSS nmos W=0.31u L=0.04u
M6058 WX4743 AND2_1678/net6 VDD VDD pmos W=0.41u L=0.04u
M6059 AND2_1678/net6 RESET VDD VDD pmos W=0.41u L=0.04u
M6060 AND2_1678/net6 WX4680 VDD VDD pmos W=0.41u L=0.04u
M6061 WX4741 AND2_1677/net6 VSS VSS nmos W=0.31u L=0.04u
M6062 AND2_1677/X_u2-net6 RESET VSS VSS nmos W=0.31u L=0.04u
M6063 AND2_1677/net6 WX4678 AND2_1677/X_u2-net6 VSS nmos W=0.31u L=0.04u
M6064 WX4741 AND2_1677/net6 VDD VDD pmos W=0.41u L=0.04u
M6065 AND2_1677/net6 RESET VDD VDD pmos W=0.41u L=0.04u
M6066 AND2_1677/net6 WX4678 VDD VDD pmos W=0.41u L=0.04u
M6067 WX4739 AND2_1676/net6 VSS VSS nmos W=0.31u L=0.04u
M6068 AND2_1676/X_u2-net6 RESET VSS VSS nmos W=0.31u L=0.04u
M6069 AND2_1676/net6 WX4676 AND2_1676/X_u2-net6 VSS nmos W=0.31u L=0.04u
M6070 WX4739 AND2_1676/net6 VDD VDD pmos W=0.41u L=0.04u
M6071 AND2_1676/net6 RESET VDD VDD pmos W=0.41u L=0.04u
M6072 AND2_1676/net6 WX4676 VDD VDD pmos W=0.41u L=0.04u
M6073 WX4737 AND2_1675/net6 VSS VSS nmos W=0.31u L=0.04u
M6074 AND2_1675/X_u2-net6 RESET VSS VSS nmos W=0.31u L=0.04u
M6075 AND2_1675/net6 WX4674 AND2_1675/X_u2-net6 VSS nmos W=0.31u L=0.04u
M6076 WX4737 AND2_1675/net6 VDD VDD pmos W=0.41u L=0.04u
M6077 AND2_1675/net6 RESET VDD VDD pmos W=0.41u L=0.04u
M6078 AND2_1675/net6 WX4674 VDD VDD pmos W=0.41u L=0.04u
M6079 WX4735 AND2_1674/net6 VSS VSS nmos W=0.31u L=0.04u
M6080 AND2_1674/X_u2-net6 RESET VSS VSS nmos W=0.31u L=0.04u
M6081 AND2_1674/net6 WX4672 AND2_1674/X_u2-net6 VSS nmos W=0.31u L=0.04u
M6082 WX4735 AND2_1674/net6 VDD VDD pmos W=0.41u L=0.04u
M6083 AND2_1674/net6 RESET VDD VDD pmos W=0.41u L=0.04u
M6084 AND2_1674/net6 WX4672 VDD VDD pmos W=0.41u L=0.04u
M6085 WX4733 AND2_1673/net6 VSS VSS nmos W=0.31u L=0.04u
M6086 AND2_1673/X_u2-net6 RESET VSS VSS nmos W=0.31u L=0.04u
M6087 AND2_1673/net6 WX4670 AND2_1673/X_u2-net6 VSS nmos W=0.31u L=0.04u
M6088 WX4733 AND2_1673/net6 VDD VDD pmos W=0.41u L=0.04u
M6089 AND2_1673/net6 RESET VDD VDD pmos W=0.41u L=0.04u
M6090 AND2_1673/net6 WX4670 VDD VDD pmos W=0.41u L=0.04u
M6091 WX4731 AND2_1672/net6 VSS VSS nmos W=0.31u L=0.04u
M6092 AND2_1672/X_u2-net6 RESET VSS VSS nmos W=0.31u L=0.04u
M6093 AND2_1672/net6 WX4668 AND2_1672/X_u2-net6 VSS nmos W=0.31u L=0.04u
M6094 WX4731 AND2_1672/net6 VDD VDD pmos W=0.41u L=0.04u
M6095 AND2_1672/net6 RESET VDD VDD pmos W=0.41u L=0.04u
M6096 AND2_1672/net6 WX4668 VDD VDD pmos W=0.41u L=0.04u
M6097 WX4729 AND2_1671/net6 VSS VSS nmos W=0.31u L=0.04u
M6098 AND2_1671/X_u2-net6 RESET VSS VSS nmos W=0.31u L=0.04u
M6099 AND2_1671/net6 WX4666 AND2_1671/X_u2-net6 VSS nmos W=0.31u L=0.04u
M6100 WX4729 AND2_1671/net6 VDD VDD pmos W=0.41u L=0.04u
M6101 AND2_1671/net6 RESET VDD VDD pmos W=0.41u L=0.04u
M6102 AND2_1671/net6 WX4666 VDD VDD pmos W=0.41u L=0.04u
M6103 WX4727 AND2_1670/net6 VSS VSS nmos W=0.31u L=0.04u
M6104 AND2_1670/X_u2-net6 RESET VSS VSS nmos W=0.31u L=0.04u
M6105 AND2_1670/net6 WX4664 AND2_1670/X_u2-net6 VSS nmos W=0.31u L=0.04u
M6106 WX4727 AND2_1670/net6 VDD VDD pmos W=0.41u L=0.04u
M6107 AND2_1670/net6 RESET VDD VDD pmos W=0.41u L=0.04u
M6108 AND2_1670/net6 WX4664 VDD VDD pmos W=0.41u L=0.04u
M6109 WX4725 AND2_1669/net6 VSS VSS nmos W=0.31u L=0.04u
M6110 AND2_1669/X_u2-net6 RESET VSS VSS nmos W=0.31u L=0.04u
M6111 AND2_1669/net6 WX4662 AND2_1669/X_u2-net6 VSS nmos W=0.31u L=0.04u
M6112 WX4725 AND2_1669/net6 VDD VDD pmos W=0.41u L=0.04u
M6113 AND2_1669/net6 RESET VDD VDD pmos W=0.41u L=0.04u
M6114 AND2_1669/net6 WX4662 VDD VDD pmos W=0.41u L=0.04u
M6115 WX4723 AND2_1668/net6 VSS VSS nmos W=0.31u L=0.04u
M6116 AND2_1668/X_u2-net6 RESET VSS VSS nmos W=0.31u L=0.04u
M6117 AND2_1668/net6 WX4660 AND2_1668/X_u2-net6 VSS nmos W=0.31u L=0.04u
M6118 WX4723 AND2_1668/net6 VDD VDD pmos W=0.41u L=0.04u
M6119 AND2_1668/net6 RESET VDD VDD pmos W=0.41u L=0.04u
M6120 AND2_1668/net6 WX4660 VDD VDD pmos W=0.41u L=0.04u
M6121 WX4721 AND2_1667/net6 VSS VSS nmos W=0.31u L=0.04u
M6122 AND2_1667/X_u2-net6 RESET VSS VSS nmos W=0.31u L=0.04u
M6123 AND2_1667/net6 WX4658 AND2_1667/X_u2-net6 VSS nmos W=0.31u L=0.04u
M6124 WX4721 AND2_1667/net6 VDD VDD pmos W=0.41u L=0.04u
M6125 AND2_1667/net6 RESET VDD VDD pmos W=0.41u L=0.04u
M6126 AND2_1667/net6 WX4658 VDD VDD pmos W=0.41u L=0.04u
M6127 WX4719 AND2_1666/net6 VSS VSS nmos W=0.31u L=0.04u
M6128 AND2_1666/X_u2-net6 RESET VSS VSS nmos W=0.31u L=0.04u
M6129 AND2_1666/net6 WX4656 AND2_1666/X_u2-net6 VSS nmos W=0.31u L=0.04u
M6130 WX4719 AND2_1666/net6 VDD VDD pmos W=0.41u L=0.04u
M6131 AND2_1666/net6 RESET VDD VDD pmos W=0.41u L=0.04u
M6132 AND2_1666/net6 WX4656 VDD VDD pmos W=0.41u L=0.04u
M6133 WX4717 AND2_1665/net6 VSS VSS nmos W=0.31u L=0.04u
M6134 AND2_1665/X_u2-net6 RESET VSS VSS nmos W=0.31u L=0.04u
M6135 AND2_1665/net6 WX4654 AND2_1665/X_u2-net6 VSS nmos W=0.31u L=0.04u
M6136 WX4717 AND2_1665/net6 VDD VDD pmos W=0.41u L=0.04u
M6137 AND2_1665/net6 RESET VDD VDD pmos W=0.41u L=0.04u
M6138 AND2_1665/net6 WX4654 VDD VDD pmos W=0.41u L=0.04u
M6139 WX4715 AND2_1664/net6 VSS VSS nmos W=0.31u L=0.04u
M6140 AND2_1664/X_u2-net6 RESET VSS VSS nmos W=0.31u L=0.04u
M6141 AND2_1664/net6 WX4652 AND2_1664/X_u2-net6 VSS nmos W=0.31u L=0.04u
M6142 WX4715 AND2_1664/net6 VDD VDD pmos W=0.41u L=0.04u
M6143 AND2_1664/net6 RESET VDD VDD pmos W=0.41u L=0.04u
M6144 AND2_1664/net6 WX4652 VDD VDD pmos W=0.41u L=0.04u
M6145 WX4713 AND2_1663/net6 VSS VSS nmos W=0.31u L=0.04u
M6146 AND2_1663/X_u2-net6 RESET VSS VSS nmos W=0.31u L=0.04u
M6147 AND2_1663/net6 WX4650 AND2_1663/X_u2-net6 VSS nmos W=0.31u L=0.04u
M6148 WX4713 AND2_1663/net6 VDD VDD pmos W=0.41u L=0.04u
M6149 AND2_1663/net6 RESET VDD VDD pmos W=0.41u L=0.04u
M6150 AND2_1663/net6 WX4650 VDD VDD pmos W=0.41u L=0.04u
M6151 WX4711 AND2_1662/net6 VSS VSS nmos W=0.31u L=0.04u
M6152 AND2_1662/X_u2-net6 RESET VSS VSS nmos W=0.31u L=0.04u
M6153 AND2_1662/net6 WX4648 AND2_1662/X_u2-net6 VSS nmos W=0.31u L=0.04u
M6154 WX4711 AND2_1662/net6 VDD VDD pmos W=0.41u L=0.04u
M6155 AND2_1662/net6 RESET VDD VDD pmos W=0.41u L=0.04u
M6156 AND2_1662/net6 WX4648 VDD VDD pmos W=0.41u L=0.04u
M6157 WX4709 AND2_1661/net6 VSS VSS nmos W=0.31u L=0.04u
M6158 AND2_1661/X_u2-net6 RESET VSS VSS nmos W=0.31u L=0.04u
M6159 AND2_1661/net6 WX4646 AND2_1661/X_u2-net6 VSS nmos W=0.31u L=0.04u
M6160 WX4709 AND2_1661/net6 VDD VDD pmos W=0.41u L=0.04u
M6161 AND2_1661/net6 RESET VDD VDD pmos W=0.41u L=0.04u
M6162 AND2_1661/net6 WX4646 VDD VDD pmos W=0.41u L=0.04u
M6163 WX4707 AND2_1660/net6 VSS VSS nmos W=0.31u L=0.04u
M6164 AND2_1660/X_u2-net6 RESET VSS VSS nmos W=0.31u L=0.04u
M6165 AND2_1660/net6 WX4644 AND2_1660/X_u2-net6 VSS nmos W=0.31u L=0.04u
M6166 WX4707 AND2_1660/net6 VDD VDD pmos W=0.41u L=0.04u
M6167 AND2_1660/net6 RESET VDD VDD pmos W=0.41u L=0.04u
M6168 AND2_1660/net6 WX4644 VDD VDD pmos W=0.41u L=0.04u
M6169 WX4705 AND2_1659/net6 VSS VSS nmos W=0.31u L=0.04u
M6170 AND2_1659/X_u2-net6 RESET VSS VSS nmos W=0.31u L=0.04u
M6171 AND2_1659/net6 WX4642 AND2_1659/X_u2-net6 VSS nmos W=0.31u L=0.04u
M6172 WX4705 AND2_1659/net6 VDD VDD pmos W=0.41u L=0.04u
M6173 AND2_1659/net6 RESET VDD VDD pmos W=0.41u L=0.04u
M6174 AND2_1659/net6 WX4642 VDD VDD pmos W=0.41u L=0.04u
M6175 WX4703 AND2_1658/net6 VSS VSS nmos W=0.31u L=0.04u
M6176 AND2_1658/X_u2-net6 RESET VSS VSS nmos W=0.31u L=0.04u
M6177 AND2_1658/net6 WX4640 AND2_1658/X_u2-net6 VSS nmos W=0.31u L=0.04u
M6178 WX4703 AND2_1658/net6 VDD VDD pmos W=0.41u L=0.04u
M6179 AND2_1658/net6 RESET VDD VDD pmos W=0.41u L=0.04u
M6180 AND2_1658/net6 WX4640 VDD VDD pmos W=0.41u L=0.04u
M6181 WX4701 AND2_1657/net6 VSS VSS nmos W=0.31u L=0.04u
M6182 AND2_1657/X_u2-net6 RESET VSS VSS nmos W=0.31u L=0.04u
M6183 AND2_1657/net6 WX4638 AND2_1657/X_u2-net6 VSS nmos W=0.31u L=0.04u
M6184 WX4701 AND2_1657/net6 VDD VDD pmos W=0.41u L=0.04u
M6185 AND2_1657/net6 RESET VDD VDD pmos W=0.41u L=0.04u
M6186 AND2_1657/net6 WX4638 VDD VDD pmos W=0.41u L=0.04u
M6187 WX4699 AND2_1656/net6 VSS VSS nmos W=0.31u L=0.04u
M6188 AND2_1656/X_u2-net6 RESET VSS VSS nmos W=0.31u L=0.04u
M6189 AND2_1656/net6 WX4636 AND2_1656/X_u2-net6 VSS nmos W=0.31u L=0.04u
M6190 WX4699 AND2_1656/net6 VDD VDD pmos W=0.41u L=0.04u
M6191 AND2_1656/net6 RESET VDD VDD pmos W=0.41u L=0.04u
M6192 AND2_1656/net6 WX4636 VDD VDD pmos W=0.41u L=0.04u
M6193 WX4697 AND2_1655/net6 VSS VSS nmos W=0.31u L=0.04u
M6194 AND2_1655/X_u2-net6 RESET VSS VSS nmos W=0.31u L=0.04u
M6195 AND2_1655/net6 WX4634 AND2_1655/X_u2-net6 VSS nmos W=0.31u L=0.04u
M6196 WX4697 AND2_1655/net6 VDD VDD pmos W=0.41u L=0.04u
M6197 AND2_1655/net6 RESET VDD VDD pmos W=0.41u L=0.04u
M6198 AND2_1655/net6 WX4634 VDD VDD pmos W=0.41u L=0.04u
M6199 WX4695 AND2_1654/net6 VSS VSS nmos W=0.31u L=0.04u
M6200 AND2_1654/X_u2-net6 RESET VSS VSS nmos W=0.31u L=0.04u
M6201 AND2_1654/net6 WX4632 AND2_1654/X_u2-net6 VSS nmos W=0.31u L=0.04u
M6202 WX4695 AND2_1654/net6 VDD VDD pmos W=0.41u L=0.04u
M6203 AND2_1654/net6 RESET VDD VDD pmos W=0.41u L=0.04u
M6204 AND2_1654/net6 WX4632 VDD VDD pmos W=0.41u L=0.04u
M6205 WX4693 AND2_1653/net6 VSS VSS nmos W=0.31u L=0.04u
M6206 AND2_1653/X_u2-net6 RESET VSS VSS nmos W=0.31u L=0.04u
M6207 AND2_1653/net6 WX4630 AND2_1653/X_u2-net6 VSS nmos W=0.31u L=0.04u
M6208 WX4693 AND2_1653/net6 VDD VDD pmos W=0.41u L=0.04u
M6209 AND2_1653/net6 RESET VDD VDD pmos W=0.41u L=0.04u
M6210 AND2_1653/net6 WX4630 VDD VDD pmos W=0.41u L=0.04u
M6211 WX4691 AND2_1652/net6 VSS VSS nmos W=0.31u L=0.04u
M6212 AND2_1652/X_u2-net6 RESET VSS VSS nmos W=0.31u L=0.04u
M6213 AND2_1652/net6 WX4628 AND2_1652/X_u2-net6 VSS nmos W=0.31u L=0.04u
M6214 WX4691 AND2_1652/net6 VDD VDD pmos W=0.41u L=0.04u
M6215 AND2_1652/net6 RESET VDD VDD pmos W=0.41u L=0.04u
M6216 AND2_1652/net6 WX4628 VDD VDD pmos W=0.41u L=0.04u
M6217 WX4689 AND2_1651/net6 VSS VSS nmos W=0.31u L=0.04u
M6218 AND2_1651/X_u2-net6 RESET VSS VSS nmos W=0.31u L=0.04u
M6219 AND2_1651/net6 WX4626 AND2_1651/X_u2-net6 VSS nmos W=0.31u L=0.04u
M6220 WX4689 AND2_1651/net6 VDD VDD pmos W=0.41u L=0.04u
M6221 AND2_1651/net6 RESET VDD VDD pmos W=0.41u L=0.04u
M6222 AND2_1651/net6 WX4626 VDD VDD pmos W=0.41u L=0.04u
M6223 WX4687 AND2_1650/net6 VSS VSS nmos W=0.31u L=0.04u
M6224 AND2_1650/X_u2-net6 RESET VSS VSS nmos W=0.31u L=0.04u
M6225 AND2_1650/net6 WX4624 AND2_1650/X_u2-net6 VSS nmos W=0.31u L=0.04u
M6226 WX4687 AND2_1650/net6 VDD VDD pmos W=0.41u L=0.04u
M6227 AND2_1650/net6 RESET VDD VDD pmos W=0.41u L=0.04u
M6228 AND2_1650/net6 WX4624 VDD VDD pmos W=0.41u L=0.04u
M6229 WX4685 AND2_1649/net6 VSS VSS nmos W=0.31u L=0.04u
M6230 AND2_1649/X_u2-net6 RESET VSS VSS nmos W=0.31u L=0.04u
M6231 AND2_1649/net6 WX4622 AND2_1649/X_u2-net6 VSS nmos W=0.31u L=0.04u
M6232 WX4685 AND2_1649/net6 VDD VDD pmos W=0.41u L=0.04u
M6233 AND2_1649/net6 RESET VDD VDD pmos W=0.41u L=0.04u
M6234 AND2_1649/net6 WX4622 VDD VDD pmos W=0.41u L=0.04u
M6235 WX4683 AND2_1648/net6 VSS VSS nmos W=0.31u L=0.04u
M6236 AND2_1648/X_u2-net6 RESET VSS VSS nmos W=0.31u L=0.04u
M6237 AND2_1648/net6 WX4620 AND2_1648/X_u2-net6 VSS nmos W=0.31u L=0.04u
M6238 WX4683 AND2_1648/net6 VDD VDD pmos W=0.41u L=0.04u
M6239 AND2_1648/net6 RESET VDD VDD pmos W=0.41u L=0.04u
M6240 AND2_1648/net6 WX4620 VDD VDD pmos W=0.41u L=0.04u
M6241 WX4681 AND2_1647/net6 VSS VSS nmos W=0.31u L=0.04u
M6242 AND2_1647/X_u2-net6 RESET VSS VSS nmos W=0.31u L=0.04u
M6243 AND2_1647/net6 WX4618 AND2_1647/X_u2-net6 VSS nmos W=0.31u L=0.04u
M6244 WX4681 AND2_1647/net6 VDD VDD pmos W=0.41u L=0.04u
M6245 AND2_1647/net6 RESET VDD VDD pmos W=0.41u L=0.04u
M6246 AND2_1647/net6 WX4618 VDD VDD pmos W=0.41u L=0.04u
M6247 WX4679 AND2_1646/net6 VSS VSS nmos W=0.31u L=0.04u
M6248 AND2_1646/X_u2-net6 RESET VSS VSS nmos W=0.31u L=0.04u
M6249 AND2_1646/net6 WX4616 AND2_1646/X_u2-net6 VSS nmos W=0.31u L=0.04u
M6250 WX4679 AND2_1646/net6 VDD VDD pmos W=0.41u L=0.04u
M6251 AND2_1646/net6 RESET VDD VDD pmos W=0.41u L=0.04u
M6252 AND2_1646/net6 WX4616 VDD VDD pmos W=0.41u L=0.04u
M6253 WX4677 AND2_1645/net6 VSS VSS nmos W=0.31u L=0.04u
M6254 AND2_1645/X_u2-net6 RESET VSS VSS nmos W=0.31u L=0.04u
M6255 AND2_1645/net6 WX4614 AND2_1645/X_u2-net6 VSS nmos W=0.31u L=0.04u
M6256 WX4677 AND2_1645/net6 VDD VDD pmos W=0.41u L=0.04u
M6257 AND2_1645/net6 RESET VDD VDD pmos W=0.41u L=0.04u
M6258 AND2_1645/net6 WX4614 VDD VDD pmos W=0.41u L=0.04u
M6259 WX4675 AND2_1644/net6 VSS VSS nmos W=0.31u L=0.04u
M6260 AND2_1644/X_u2-net6 RESET VSS VSS nmos W=0.31u L=0.04u
M6261 AND2_1644/net6 WX4612 AND2_1644/X_u2-net6 VSS nmos W=0.31u L=0.04u
M6262 WX4675 AND2_1644/net6 VDD VDD pmos W=0.41u L=0.04u
M6263 AND2_1644/net6 RESET VDD VDD pmos W=0.41u L=0.04u
M6264 AND2_1644/net6 WX4612 VDD VDD pmos W=0.41u L=0.04u
M6265 WX4673 AND2_1643/net6 VSS VSS nmos W=0.31u L=0.04u
M6266 AND2_1643/X_u2-net6 RESET VSS VSS nmos W=0.31u L=0.04u
M6267 AND2_1643/net6 WX4610 AND2_1643/X_u2-net6 VSS nmos W=0.31u L=0.04u
M6268 WX4673 AND2_1643/net6 VDD VDD pmos W=0.41u L=0.04u
M6269 AND2_1643/net6 RESET VDD VDD pmos W=0.41u L=0.04u
M6270 AND2_1643/net6 WX4610 VDD VDD pmos W=0.41u L=0.04u
M6271 WX4671 AND2_1642/net6 VSS VSS nmos W=0.31u L=0.04u
M6272 AND2_1642/X_u2-net6 RESET VSS VSS nmos W=0.31u L=0.04u
M6273 AND2_1642/net6 WX4608 AND2_1642/X_u2-net6 VSS nmos W=0.31u L=0.04u
M6274 WX4671 AND2_1642/net6 VDD VDD pmos W=0.41u L=0.04u
M6275 AND2_1642/net6 RESET VDD VDD pmos W=0.41u L=0.04u
M6276 AND2_1642/net6 WX4608 VDD VDD pmos W=0.41u L=0.04u
M6277 WX4669 AND2_1641/net6 VSS VSS nmos W=0.31u L=0.04u
M6278 AND2_1641/X_u2-net6 RESET VSS VSS nmos W=0.31u L=0.04u
M6279 AND2_1641/net6 WX4606 AND2_1641/X_u2-net6 VSS nmos W=0.31u L=0.04u
M6280 WX4669 AND2_1641/net6 VDD VDD pmos W=0.41u L=0.04u
M6281 AND2_1641/net6 RESET VDD VDD pmos W=0.41u L=0.04u
M6282 AND2_1641/net6 WX4606 VDD VDD pmos W=0.41u L=0.04u
M6283 WX4667 AND2_1640/net6 VSS VSS nmos W=0.31u L=0.04u
M6284 AND2_1640/X_u2-net6 RESET VSS VSS nmos W=0.31u L=0.04u
M6285 AND2_1640/net6 WX4604 AND2_1640/X_u2-net6 VSS nmos W=0.31u L=0.04u
M6286 WX4667 AND2_1640/net6 VDD VDD pmos W=0.41u L=0.04u
M6287 AND2_1640/net6 RESET VDD VDD pmos W=0.41u L=0.04u
M6288 AND2_1640/net6 WX4604 VDD VDD pmos W=0.41u L=0.04u
M6289 WX4665 AND2_1639/net6 VSS VSS nmos W=0.31u L=0.04u
M6290 AND2_1639/X_u2-net6 RESET VSS VSS nmos W=0.31u L=0.04u
M6291 AND2_1639/net6 WX4602 AND2_1639/X_u2-net6 VSS nmos W=0.31u L=0.04u
M6292 WX4665 AND2_1639/net6 VDD VDD pmos W=0.41u L=0.04u
M6293 AND2_1639/net6 RESET VDD VDD pmos W=0.41u L=0.04u
M6294 AND2_1639/net6 WX4602 VDD VDD pmos W=0.41u L=0.04u
M6295 WX4663 AND2_1638/net6 VSS VSS nmos W=0.31u L=0.04u
M6296 AND2_1638/X_u2-net6 RESET VSS VSS nmos W=0.31u L=0.04u
M6297 AND2_1638/net6 WX4600 AND2_1638/X_u2-net6 VSS nmos W=0.31u L=0.04u
M6298 WX4663 AND2_1638/net6 VDD VDD pmos W=0.41u L=0.04u
M6299 AND2_1638/net6 RESET VDD VDD pmos W=0.41u L=0.04u
M6300 AND2_1638/net6 WX4600 VDD VDD pmos W=0.41u L=0.04u
M6301 WX4661 AND2_1637/net6 VSS VSS nmos W=0.31u L=0.04u
M6302 AND2_1637/X_u2-net6 RESET VSS VSS nmos W=0.31u L=0.04u
M6303 AND2_1637/net6 WX4598 AND2_1637/X_u2-net6 VSS nmos W=0.31u L=0.04u
M6304 WX4661 AND2_1637/net6 VDD VDD pmos W=0.41u L=0.04u
M6305 AND2_1637/net6 RESET VDD VDD pmos W=0.41u L=0.04u
M6306 AND2_1637/net6 WX4598 VDD VDD pmos W=0.41u L=0.04u
M6307 WX4659 AND2_1636/net6 VSS VSS nmos W=0.31u L=0.04u
M6308 AND2_1636/X_u2-net6 RESET VSS VSS nmos W=0.31u L=0.04u
M6309 AND2_1636/net6 WX4596 AND2_1636/X_u2-net6 VSS nmos W=0.31u L=0.04u
M6310 WX4659 AND2_1636/net6 VDD VDD pmos W=0.41u L=0.04u
M6311 AND2_1636/net6 RESET VDD VDD pmos W=0.41u L=0.04u
M6312 AND2_1636/net6 WX4596 VDD VDD pmos W=0.41u L=0.04u
M6313 WX4657 AND2_1635/net6 VSS VSS nmos W=0.31u L=0.04u
M6314 AND2_1635/X_u2-net6 RESET VSS VSS nmos W=0.31u L=0.04u
M6315 AND2_1635/net6 WX4594 AND2_1635/X_u2-net6 VSS nmos W=0.31u L=0.04u
M6316 WX4657 AND2_1635/net6 VDD VDD pmos W=0.41u L=0.04u
M6317 AND2_1635/net6 RESET VDD VDD pmos W=0.41u L=0.04u
M6318 AND2_1635/net6 WX4594 VDD VDD pmos W=0.41u L=0.04u
M6319 WX4655 AND2_1634/net6 VSS VSS nmos W=0.31u L=0.04u
M6320 AND2_1634/X_u2-net6 RESET VSS VSS nmos W=0.31u L=0.04u
M6321 AND2_1634/net6 WX4592 AND2_1634/X_u2-net6 VSS nmos W=0.31u L=0.04u
M6322 WX4655 AND2_1634/net6 VDD VDD pmos W=0.41u L=0.04u
M6323 AND2_1634/net6 RESET VDD VDD pmos W=0.41u L=0.04u
M6324 AND2_1634/net6 WX4592 VDD VDD pmos W=0.41u L=0.04u
M6325 WX4653 AND2_1633/net6 VSS VSS nmos W=0.31u L=0.04u
M6326 AND2_1633/X_u2-net6 RESET VSS VSS nmos W=0.31u L=0.04u
M6327 AND2_1633/net6 WX4590 AND2_1633/X_u2-net6 VSS nmos W=0.31u L=0.04u
M6328 WX4653 AND2_1633/net6 VDD VDD pmos W=0.41u L=0.04u
M6329 AND2_1633/net6 RESET VDD VDD pmos W=0.41u L=0.04u
M6330 AND2_1633/net6 WX4590 VDD VDD pmos W=0.41u L=0.04u
M6331 WX4651 AND2_1632/net6 VSS VSS nmos W=0.31u L=0.04u
M6332 AND2_1632/X_u2-net6 RESET VSS VSS nmos W=0.31u L=0.04u
M6333 AND2_1632/net6 WX4588 AND2_1632/X_u2-net6 VSS nmos W=0.31u L=0.04u
M6334 WX4651 AND2_1632/net6 VDD VDD pmos W=0.41u L=0.04u
M6335 AND2_1632/net6 RESET VDD VDD pmos W=0.41u L=0.04u
M6336 AND2_1632/net6 WX4588 VDD VDD pmos W=0.41u L=0.04u
M6337 WX4649 AND2_1631/net6 VSS VSS nmos W=0.31u L=0.04u
M6338 AND2_1631/X_u2-net6 RESET VSS VSS nmos W=0.31u L=0.04u
M6339 AND2_1631/net6 WX4586 AND2_1631/X_u2-net6 VSS nmos W=0.31u L=0.04u
M6340 WX4649 AND2_1631/net6 VDD VDD pmos W=0.41u L=0.04u
M6341 AND2_1631/net6 RESET VDD VDD pmos W=0.41u L=0.04u
M6342 AND2_1631/net6 WX4586 VDD VDD pmos W=0.41u L=0.04u
M6343 WX4647 AND2_1630/net6 VSS VSS nmos W=0.31u L=0.04u
M6344 AND2_1630/X_u2-net6 RESET VSS VSS nmos W=0.31u L=0.04u
M6345 AND2_1630/net6 WX4584 AND2_1630/X_u2-net6 VSS nmos W=0.31u L=0.04u
M6346 WX4647 AND2_1630/net6 VDD VDD pmos W=0.41u L=0.04u
M6347 AND2_1630/net6 RESET VDD VDD pmos W=0.41u L=0.04u
M6348 AND2_1630/net6 WX4584 VDD VDD pmos W=0.41u L=0.04u
M6349 WX4645 AND2_1629/net6 VSS VSS nmos W=0.31u L=0.04u
M6350 AND2_1629/X_u2-net6 RESET VSS VSS nmos W=0.31u L=0.04u
M6351 AND2_1629/net6 WX4582 AND2_1629/X_u2-net6 VSS nmos W=0.31u L=0.04u
M6352 WX4645 AND2_1629/net6 VDD VDD pmos W=0.41u L=0.04u
M6353 AND2_1629/net6 RESET VDD VDD pmos W=0.41u L=0.04u
M6354 AND2_1629/net6 WX4582 VDD VDD pmos W=0.41u L=0.04u
M6355 WX4643 AND2_1628/net6 VSS VSS nmos W=0.31u L=0.04u
M6356 AND2_1628/X_u2-net6 RESET VSS VSS nmos W=0.31u L=0.04u
M6357 AND2_1628/net6 WX4580 AND2_1628/X_u2-net6 VSS nmos W=0.31u L=0.04u
M6358 WX4643 AND2_1628/net6 VDD VDD pmos W=0.41u L=0.04u
M6359 AND2_1628/net6 RESET VDD VDD pmos W=0.41u L=0.04u
M6360 AND2_1628/net6 WX4580 VDD VDD pmos W=0.41u L=0.04u
M6361 WX4641 AND2_1627/net6 VSS VSS nmos W=0.31u L=0.04u
M6362 AND2_1627/X_u2-net6 RESET VSS VSS nmos W=0.31u L=0.04u
M6363 AND2_1627/net6 WX4578 AND2_1627/X_u2-net6 VSS nmos W=0.31u L=0.04u
M6364 WX4641 AND2_1627/net6 VDD VDD pmos W=0.41u L=0.04u
M6365 AND2_1627/net6 RESET VDD VDD pmos W=0.41u L=0.04u
M6366 AND2_1627/net6 WX4578 VDD VDD pmos W=0.41u L=0.04u
M6367 WX4639 AND2_1626/net6 VSS VSS nmos W=0.31u L=0.04u
M6368 AND2_1626/X_u2-net6 RESET VSS VSS nmos W=0.31u L=0.04u
M6369 AND2_1626/net6 WX4576 AND2_1626/X_u2-net6 VSS nmos W=0.31u L=0.04u
M6370 WX4639 AND2_1626/net6 VDD VDD pmos W=0.41u L=0.04u
M6371 AND2_1626/net6 RESET VDD VDD pmos W=0.41u L=0.04u
M6372 AND2_1626/net6 WX4576 VDD VDD pmos W=0.41u L=0.04u
M6373 WX4637 AND2_1625/net6 VSS VSS nmos W=0.31u L=0.04u
M6374 AND2_1625/X_u2-net6 RESET VSS VSS nmos W=0.31u L=0.04u
M6375 AND2_1625/net6 WX4574 AND2_1625/X_u2-net6 VSS nmos W=0.31u L=0.04u
M6376 WX4637 AND2_1625/net6 VDD VDD pmos W=0.41u L=0.04u
M6377 AND2_1625/net6 RESET VDD VDD pmos W=0.41u L=0.04u
M6378 AND2_1625/net6 WX4574 VDD VDD pmos W=0.41u L=0.04u
M6379 WX4635 AND2_1624/net6 VSS VSS nmos W=0.31u L=0.04u
M6380 AND2_1624/X_u2-net6 RESET VSS VSS nmos W=0.31u L=0.04u
M6381 AND2_1624/net6 WX4572 AND2_1624/X_u2-net6 VSS nmos W=0.31u L=0.04u
M6382 WX4635 AND2_1624/net6 VDD VDD pmos W=0.41u L=0.04u
M6383 AND2_1624/net6 RESET VDD VDD pmos W=0.41u L=0.04u
M6384 AND2_1624/net6 WX4572 VDD VDD pmos W=0.41u L=0.04u
M6385 WX4633 AND2_1623/net6 VSS VSS nmos W=0.31u L=0.04u
M6386 AND2_1623/X_u2-net6 RESET VSS VSS nmos W=0.31u L=0.04u
M6387 AND2_1623/net6 WX4570 AND2_1623/X_u2-net6 VSS nmos W=0.31u L=0.04u
M6388 WX4633 AND2_1623/net6 VDD VDD pmos W=0.41u L=0.04u
M6389 AND2_1623/net6 RESET VDD VDD pmos W=0.41u L=0.04u
M6390 AND2_1623/net6 WX4570 VDD VDD pmos W=0.41u L=0.04u
M6391 WX4631 AND2_1622/net6 VSS VSS nmos W=0.31u L=0.04u
M6392 AND2_1622/X_u2-net6 RESET VSS VSS nmos W=0.31u L=0.04u
M6393 AND2_1622/net6 WX4568 AND2_1622/X_u2-net6 VSS nmos W=0.31u L=0.04u
M6394 WX4631 AND2_1622/net6 VDD VDD pmos W=0.41u L=0.04u
M6395 AND2_1622/net6 RESET VDD VDD pmos W=0.41u L=0.04u
M6396 AND2_1622/net6 WX4568 VDD VDD pmos W=0.41u L=0.04u
M6397 WX4629 AND2_1621/net6 VSS VSS nmos W=0.31u L=0.04u
M6398 AND2_1621/X_u2-net6 RESET VSS VSS nmos W=0.31u L=0.04u
M6399 AND2_1621/net6 WX4566 AND2_1621/X_u2-net6 VSS nmos W=0.31u L=0.04u
M6400 WX4629 AND2_1621/net6 VDD VDD pmos W=0.41u L=0.04u
M6401 AND2_1621/net6 RESET VDD VDD pmos W=0.41u L=0.04u
M6402 AND2_1621/net6 WX4566 VDD VDD pmos W=0.41u L=0.04u
M6403 WX4627 AND2_1620/net6 VSS VSS nmos W=0.31u L=0.04u
M6404 AND2_1620/X_u2-net6 RESET VSS VSS nmos W=0.31u L=0.04u
M6405 AND2_1620/net6 WX4564 AND2_1620/X_u2-net6 VSS nmos W=0.31u L=0.04u
M6406 WX4627 AND2_1620/net6 VDD VDD pmos W=0.41u L=0.04u
M6407 AND2_1620/net6 RESET VDD VDD pmos W=0.41u L=0.04u
M6408 AND2_1620/net6 WX4564 VDD VDD pmos W=0.41u L=0.04u
M6409 WX4625 AND2_1619/net6 VSS VSS nmos W=0.31u L=0.04u
M6410 AND2_1619/X_u2-net6 RESET VSS VSS nmos W=0.31u L=0.04u
M6411 AND2_1619/net6 WX4562 AND2_1619/X_u2-net6 VSS nmos W=0.31u L=0.04u
M6412 WX4625 AND2_1619/net6 VDD VDD pmos W=0.41u L=0.04u
M6413 AND2_1619/net6 RESET VDD VDD pmos W=0.41u L=0.04u
M6414 AND2_1619/net6 WX4562 VDD VDD pmos W=0.41u L=0.04u
M6415 WX4623 AND2_1618/net6 VSS VSS nmos W=0.31u L=0.04u
M6416 AND2_1618/X_u2-net6 RESET VSS VSS nmos W=0.31u L=0.04u
M6417 AND2_1618/net6 WX4560 AND2_1618/X_u2-net6 VSS nmos W=0.31u L=0.04u
M6418 WX4623 AND2_1618/net6 VDD VDD pmos W=0.41u L=0.04u
M6419 AND2_1618/net6 RESET VDD VDD pmos W=0.41u L=0.04u
M6420 AND2_1618/net6 WX4560 VDD VDD pmos W=0.41u L=0.04u
M6421 WX4621 AND2_1617/net6 VSS VSS nmos W=0.31u L=0.04u
M6422 AND2_1617/X_u2-net6 RESET VSS VSS nmos W=0.31u L=0.04u
M6423 AND2_1617/net6 WX4558 AND2_1617/X_u2-net6 VSS nmos W=0.31u L=0.04u
M6424 WX4621 AND2_1617/net6 VDD VDD pmos W=0.41u L=0.04u
M6425 AND2_1617/net6 RESET VDD VDD pmos W=0.41u L=0.04u
M6426 AND2_1617/net6 WX4558 VDD VDD pmos W=0.41u L=0.04u
M6427 WX4619 AND2_1616/net6 VSS VSS nmos W=0.31u L=0.04u
M6428 AND2_1616/X_u2-net6 RESET VSS VSS nmos W=0.31u L=0.04u
M6429 AND2_1616/net6 WX4556 AND2_1616/X_u2-net6 VSS nmos W=0.31u L=0.04u
M6430 WX4619 AND2_1616/net6 VDD VDD pmos W=0.41u L=0.04u
M6431 AND2_1616/net6 RESET VDD VDD pmos W=0.41u L=0.04u
M6432 AND2_1616/net6 WX4556 VDD VDD pmos W=0.41u L=0.04u
M6433 WX4617 AND2_1615/net6 VSS VSS nmos W=0.31u L=0.04u
M6434 AND2_1615/X_u2-net6 RESET VSS VSS nmos W=0.31u L=0.04u
M6435 AND2_1615/net6 WX4554 AND2_1615/X_u2-net6 VSS nmos W=0.31u L=0.04u
M6436 WX4617 AND2_1615/net6 VDD VDD pmos W=0.41u L=0.04u
M6437 AND2_1615/net6 RESET VDD VDD pmos W=0.41u L=0.04u
M6438 AND2_1615/net6 WX4554 VDD VDD pmos W=0.41u L=0.04u
M6439 WX4615 AND2_1614/net6 VSS VSS nmos W=0.31u L=0.04u
M6440 AND2_1614/X_u2-net6 RESET VSS VSS nmos W=0.31u L=0.04u
M6441 AND2_1614/net6 WX4552 AND2_1614/X_u2-net6 VSS nmos W=0.31u L=0.04u
M6442 WX4615 AND2_1614/net6 VDD VDD pmos W=0.41u L=0.04u
M6443 AND2_1614/net6 RESET VDD VDD pmos W=0.41u L=0.04u
M6444 AND2_1614/net6 WX4552 VDD VDD pmos W=0.41u L=0.04u
M6445 WX4613 AND2_1613/net6 VSS VSS nmos W=0.31u L=0.04u
M6446 AND2_1613/X_u2-net6 RESET VSS VSS nmos W=0.31u L=0.04u
M6447 AND2_1613/net6 WX4550 AND2_1613/X_u2-net6 VSS nmos W=0.31u L=0.04u
M6448 WX4613 AND2_1613/net6 VDD VDD pmos W=0.41u L=0.04u
M6449 AND2_1613/net6 RESET VDD VDD pmos W=0.41u L=0.04u
M6450 AND2_1613/net6 WX4550 VDD VDD pmos W=0.41u L=0.04u
M6451 WX4611 AND2_1612/net6 VSS VSS nmos W=0.31u L=0.04u
M6452 AND2_1612/X_u2-net6 RESET VSS VSS nmos W=0.31u L=0.04u
M6453 AND2_1612/net6 WX4548 AND2_1612/X_u2-net6 VSS nmos W=0.31u L=0.04u
M6454 WX4611 AND2_1612/net6 VDD VDD pmos W=0.41u L=0.04u
M6455 AND2_1612/net6 RESET VDD VDD pmos W=0.41u L=0.04u
M6456 AND2_1612/net6 WX4548 VDD VDD pmos W=0.41u L=0.04u
M6457 WX4609 AND2_1611/net6 VSS VSS nmos W=0.31u L=0.04u
M6458 AND2_1611/X_u2-net6 RESET VSS VSS nmos W=0.31u L=0.04u
M6459 AND2_1611/net6 WX4546 AND2_1611/X_u2-net6 VSS nmos W=0.31u L=0.04u
M6460 WX4609 AND2_1611/net6 VDD VDD pmos W=0.41u L=0.04u
M6461 AND2_1611/net6 RESET VDD VDD pmos W=0.41u L=0.04u
M6462 AND2_1611/net6 WX4546 VDD VDD pmos W=0.41u L=0.04u
M6463 WX4607 AND2_1610/net6 VSS VSS nmos W=0.31u L=0.04u
M6464 AND2_1610/X_u2-net6 RESET VSS VSS nmos W=0.31u L=0.04u
M6465 AND2_1610/net6 WX4544 AND2_1610/X_u2-net6 VSS nmos W=0.31u L=0.04u
M6466 WX4607 AND2_1610/net6 VDD VDD pmos W=0.41u L=0.04u
M6467 AND2_1610/net6 RESET VDD VDD pmos W=0.41u L=0.04u
M6468 AND2_1610/net6 WX4544 VDD VDD pmos W=0.41u L=0.04u
M6469 WX4605 AND2_1609/net6 VSS VSS nmos W=0.31u L=0.04u
M6470 AND2_1609/X_u2-net6 RESET VSS VSS nmos W=0.31u L=0.04u
M6471 AND2_1609/net6 WX4542 AND2_1609/X_u2-net6 VSS nmos W=0.31u L=0.04u
M6472 WX4605 AND2_1609/net6 VDD VDD pmos W=0.41u L=0.04u
M6473 AND2_1609/net6 RESET VDD VDD pmos W=0.41u L=0.04u
M6474 AND2_1609/net6 WX4542 VDD VDD pmos W=0.41u L=0.04u
M6475 WX4603 AND2_1608/net6 VSS VSS nmos W=0.31u L=0.04u
M6476 AND2_1608/X_u2-net6 RESET VSS VSS nmos W=0.31u L=0.04u
M6477 AND2_1608/net6 WX4540 AND2_1608/X_u2-net6 VSS nmos W=0.31u L=0.04u
M6478 WX4603 AND2_1608/net6 VDD VDD pmos W=0.41u L=0.04u
M6479 AND2_1608/net6 RESET VDD VDD pmos W=0.41u L=0.04u
M6480 AND2_1608/net6 WX4540 VDD VDD pmos W=0.41u L=0.04u
M6481 WX4601 AND2_1607/net6 VSS VSS nmos W=0.31u L=0.04u
M6482 AND2_1607/X_u2-net6 RESET VSS VSS nmos W=0.31u L=0.04u
M6483 AND2_1607/net6 WX4538 AND2_1607/X_u2-net6 VSS nmos W=0.31u L=0.04u
M6484 WX4601 AND2_1607/net6 VDD VDD pmos W=0.41u L=0.04u
M6485 AND2_1607/net6 RESET VDD VDD pmos W=0.41u L=0.04u
M6486 AND2_1607/net6 WX4538 VDD VDD pmos W=0.41u L=0.04u
M6487 WX4599 AND2_1606/net6 VSS VSS nmos W=0.31u L=0.04u
M6488 AND2_1606/X_u2-net6 RESET VSS VSS nmos W=0.31u L=0.04u
M6489 AND2_1606/net6 WX4536 AND2_1606/X_u2-net6 VSS nmos W=0.31u L=0.04u
M6490 WX4599 AND2_1606/net6 VDD VDD pmos W=0.41u L=0.04u
M6491 AND2_1606/net6 RESET VDD VDD pmos W=0.41u L=0.04u
M6492 AND2_1606/net6 WX4536 VDD VDD pmos W=0.41u L=0.04u
M6493 WX4597 AND2_1605/net6 VSS VSS nmos W=0.31u L=0.04u
M6494 AND2_1605/X_u2-net6 RESET VSS VSS nmos W=0.31u L=0.04u
M6495 AND2_1605/net6 WX4534 AND2_1605/X_u2-net6 VSS nmos W=0.31u L=0.04u
M6496 WX4597 AND2_1605/net6 VDD VDD pmos W=0.41u L=0.04u
M6497 AND2_1605/net6 RESET VDD VDD pmos W=0.41u L=0.04u
M6498 AND2_1605/net6 WX4534 VDD VDD pmos W=0.41u L=0.04u
M6499 WX4595 AND2_1604/net6 VSS VSS nmos W=0.31u L=0.04u
M6500 AND2_1604/X_u2-net6 RESET VSS VSS nmos W=0.31u L=0.04u
M6501 AND2_1604/net6 WX4532 AND2_1604/X_u2-net6 VSS nmos W=0.31u L=0.04u
M6502 WX4595 AND2_1604/net6 VDD VDD pmos W=0.41u L=0.04u
M6503 AND2_1604/net6 RESET VDD VDD pmos W=0.41u L=0.04u
M6504 AND2_1604/net6 WX4532 VDD VDD pmos W=0.41u L=0.04u
M6505 WX4593 AND2_1603/net6 VSS VSS nmos W=0.31u L=0.04u
M6506 AND2_1603/X_u2-net6 RESET VSS VSS nmos W=0.31u L=0.04u
M6507 AND2_1603/net6 WX4530 AND2_1603/X_u2-net6 VSS nmos W=0.31u L=0.04u
M6508 WX4593 AND2_1603/net6 VDD VDD pmos W=0.41u L=0.04u
M6509 AND2_1603/net6 RESET VDD VDD pmos W=0.41u L=0.04u
M6510 AND2_1603/net6 WX4530 VDD VDD pmos W=0.41u L=0.04u
M6511 WX4591 AND2_1602/net6 VSS VSS nmos W=0.31u L=0.04u
M6512 AND2_1602/X_u2-net6 RESET VSS VSS nmos W=0.31u L=0.04u
M6513 AND2_1602/net6 WX4528 AND2_1602/X_u2-net6 VSS nmos W=0.31u L=0.04u
M6514 WX4591 AND2_1602/net6 VDD VDD pmos W=0.41u L=0.04u
M6515 AND2_1602/net6 RESET VDD VDD pmos W=0.41u L=0.04u
M6516 AND2_1602/net6 WX4528 VDD VDD pmos W=0.41u L=0.04u
M6517 WX4589 AND2_1601/net6 VSS VSS nmos W=0.31u L=0.04u
M6518 AND2_1601/X_u2-net6 RESET VSS VSS nmos W=0.31u L=0.04u
M6519 AND2_1601/net6 WX4526 AND2_1601/X_u2-net6 VSS nmos W=0.31u L=0.04u
M6520 WX4589 AND2_1601/net6 VDD VDD pmos W=0.41u L=0.04u
M6521 AND2_1601/net6 RESET VDD VDD pmos W=0.41u L=0.04u
M6522 AND2_1601/net6 WX4526 VDD VDD pmos W=0.41u L=0.04u
M6523 WX4587 AND2_1600/net6 VSS VSS nmos W=0.31u L=0.04u
M6524 AND2_1600/X_u2-net6 RESET VSS VSS nmos W=0.31u L=0.04u
M6525 AND2_1600/net6 WX4524 AND2_1600/X_u2-net6 VSS nmos W=0.31u L=0.04u
M6526 WX4587 AND2_1600/net6 VDD VDD pmos W=0.41u L=0.04u
M6527 AND2_1600/net6 RESET VDD VDD pmos W=0.41u L=0.04u
M6528 AND2_1600/net6 WX4524 VDD VDD pmos W=0.41u L=0.04u
M6529 WX4585 AND2_1599/net6 VSS VSS nmos W=0.31u L=0.04u
M6530 AND2_1599/X_u2-net6 RESET VSS VSS nmos W=0.31u L=0.04u
M6531 AND2_1599/net6 WX4351 AND2_1599/X_u2-net6 VSS nmos W=0.31u L=0.04u
M6532 WX4585 AND2_1599/net6 VDD VDD pmos W=0.41u L=0.04u
M6533 AND2_1599/net6 RESET VDD VDD pmos W=0.41u L=0.04u
M6534 AND2_1599/net6 WX4351 VDD VDD pmos W=0.41u L=0.04u
M6535 WX4583 AND2_1598/net6 VSS VSS nmos W=0.31u L=0.04u
M6536 AND2_1598/X_u2-net6 RESET VSS VSS nmos W=0.31u L=0.04u
M6537 AND2_1598/net6 WX4337 AND2_1598/X_u2-net6 VSS nmos W=0.31u L=0.04u
M6538 WX4583 AND2_1598/net6 VDD VDD pmos W=0.41u L=0.04u
M6539 AND2_1598/net6 RESET VDD VDD pmos W=0.41u L=0.04u
M6540 AND2_1598/net6 WX4337 VDD VDD pmos W=0.41u L=0.04u
M6541 WX4581 AND2_1597/net6 VSS VSS nmos W=0.31u L=0.04u
M6542 AND2_1597/X_u2-net6 RESET VSS VSS nmos W=0.31u L=0.04u
M6543 AND2_1597/net6 WX4323 AND2_1597/X_u2-net6 VSS nmos W=0.31u L=0.04u
M6544 WX4581 AND2_1597/net6 VDD VDD pmos W=0.41u L=0.04u
M6545 AND2_1597/net6 RESET VDD VDD pmos W=0.41u L=0.04u
M6546 AND2_1597/net6 WX4323 VDD VDD pmos W=0.41u L=0.04u
M6547 WX4579 AND2_1596/net6 VSS VSS nmos W=0.31u L=0.04u
M6548 AND2_1596/X_u2-net6 RESET VSS VSS nmos W=0.31u L=0.04u
M6549 AND2_1596/net6 WX4309 AND2_1596/X_u2-net6 VSS nmos W=0.31u L=0.04u
M6550 WX4579 AND2_1596/net6 VDD VDD pmos W=0.41u L=0.04u
M6551 AND2_1596/net6 RESET VDD VDD pmos W=0.41u L=0.04u
M6552 AND2_1596/net6 WX4309 VDD VDD pmos W=0.41u L=0.04u
M6553 WX4577 AND2_1595/net6 VSS VSS nmos W=0.31u L=0.04u
M6554 AND2_1595/X_u2-net6 RESET VSS VSS nmos W=0.31u L=0.04u
M6555 AND2_1595/net6 WX4295 AND2_1595/X_u2-net6 VSS nmos W=0.31u L=0.04u
M6556 WX4577 AND2_1595/net6 VDD VDD pmos W=0.41u L=0.04u
M6557 AND2_1595/net6 RESET VDD VDD pmos W=0.41u L=0.04u
M6558 AND2_1595/net6 WX4295 VDD VDD pmos W=0.41u L=0.04u
M6559 WX4575 AND2_1594/net6 VSS VSS nmos W=0.31u L=0.04u
M6560 AND2_1594/X_u2-net6 RESET VSS VSS nmos W=0.31u L=0.04u
M6561 AND2_1594/net6 WX4281 AND2_1594/X_u2-net6 VSS nmos W=0.31u L=0.04u
M6562 WX4575 AND2_1594/net6 VDD VDD pmos W=0.41u L=0.04u
M6563 AND2_1594/net6 RESET VDD VDD pmos W=0.41u L=0.04u
M6564 AND2_1594/net6 WX4281 VDD VDD pmos W=0.41u L=0.04u
M6565 WX4573 AND2_1593/net6 VSS VSS nmos W=0.31u L=0.04u
M6566 AND2_1593/X_u2-net6 RESET VSS VSS nmos W=0.31u L=0.04u
M6567 AND2_1593/net6 WX4267 AND2_1593/X_u2-net6 VSS nmos W=0.31u L=0.04u
M6568 WX4573 AND2_1593/net6 VDD VDD pmos W=0.41u L=0.04u
M6569 AND2_1593/net6 RESET VDD VDD pmos W=0.41u L=0.04u
M6570 AND2_1593/net6 WX4267 VDD VDD pmos W=0.41u L=0.04u
M6571 WX4571 AND2_1592/net6 VSS VSS nmos W=0.31u L=0.04u
M6572 AND2_1592/X_u2-net6 RESET VSS VSS nmos W=0.31u L=0.04u
M6573 AND2_1592/net6 WX4253 AND2_1592/X_u2-net6 VSS nmos W=0.31u L=0.04u
M6574 WX4571 AND2_1592/net6 VDD VDD pmos W=0.41u L=0.04u
M6575 AND2_1592/net6 RESET VDD VDD pmos W=0.41u L=0.04u
M6576 AND2_1592/net6 WX4253 VDD VDD pmos W=0.41u L=0.04u
M6577 WX4569 AND2_1591/net6 VSS VSS nmos W=0.31u L=0.04u
M6578 AND2_1591/X_u2-net6 RESET VSS VSS nmos W=0.31u L=0.04u
M6579 AND2_1591/net6 WX4239 AND2_1591/X_u2-net6 VSS nmos W=0.31u L=0.04u
M6580 WX4569 AND2_1591/net6 VDD VDD pmos W=0.41u L=0.04u
M6581 AND2_1591/net6 RESET VDD VDD pmos W=0.41u L=0.04u
M6582 AND2_1591/net6 WX4239 VDD VDD pmos W=0.41u L=0.04u
M6583 WX4567 AND2_1590/net6 VSS VSS nmos W=0.31u L=0.04u
M6584 AND2_1590/X_u2-net6 RESET VSS VSS nmos W=0.31u L=0.04u
M6585 AND2_1590/net6 WX4225 AND2_1590/X_u2-net6 VSS nmos W=0.31u L=0.04u
M6586 WX4567 AND2_1590/net6 VDD VDD pmos W=0.41u L=0.04u
M6587 AND2_1590/net6 RESET VDD VDD pmos W=0.41u L=0.04u
M6588 AND2_1590/net6 WX4225 VDD VDD pmos W=0.41u L=0.04u
M6589 WX4565 AND2_1589/net6 VSS VSS nmos W=0.31u L=0.04u
M6590 AND2_1589/X_u2-net6 RESET VSS VSS nmos W=0.31u L=0.04u
M6591 AND2_1589/net6 WX4211 AND2_1589/X_u2-net6 VSS nmos W=0.31u L=0.04u
M6592 WX4565 AND2_1589/net6 VDD VDD pmos W=0.41u L=0.04u
M6593 AND2_1589/net6 RESET VDD VDD pmos W=0.41u L=0.04u
M6594 AND2_1589/net6 WX4211 VDD VDD pmos W=0.41u L=0.04u
M6595 WX4563 AND2_1588/net6 VSS VSS nmos W=0.31u L=0.04u
M6596 AND2_1588/X_u2-net6 RESET VSS VSS nmos W=0.31u L=0.04u
M6597 AND2_1588/net6 WX4197 AND2_1588/X_u2-net6 VSS nmos W=0.31u L=0.04u
M6598 WX4563 AND2_1588/net6 VDD VDD pmos W=0.41u L=0.04u
M6599 AND2_1588/net6 RESET VDD VDD pmos W=0.41u L=0.04u
M6600 AND2_1588/net6 WX4197 VDD VDD pmos W=0.41u L=0.04u
M6601 WX4561 AND2_1587/net6 VSS VSS nmos W=0.31u L=0.04u
M6602 AND2_1587/X_u2-net6 RESET VSS VSS nmos W=0.31u L=0.04u
M6603 AND2_1587/net6 WX4183 AND2_1587/X_u2-net6 VSS nmos W=0.31u L=0.04u
M6604 WX4561 AND2_1587/net6 VDD VDD pmos W=0.41u L=0.04u
M6605 AND2_1587/net6 RESET VDD VDD pmos W=0.41u L=0.04u
M6606 AND2_1587/net6 WX4183 VDD VDD pmos W=0.41u L=0.04u
M6607 WX4559 AND2_1586/net6 VSS VSS nmos W=0.31u L=0.04u
M6608 AND2_1586/X_u2-net6 RESET VSS VSS nmos W=0.31u L=0.04u
M6609 AND2_1586/net6 WX4169 AND2_1586/X_u2-net6 VSS nmos W=0.31u L=0.04u
M6610 WX4559 AND2_1586/net6 VDD VDD pmos W=0.41u L=0.04u
M6611 AND2_1586/net6 RESET VDD VDD pmos W=0.41u L=0.04u
M6612 AND2_1586/net6 WX4169 VDD VDD pmos W=0.41u L=0.04u
M6613 WX4557 AND2_1585/net6 VSS VSS nmos W=0.31u L=0.04u
M6614 AND2_1585/X_u2-net6 RESET VSS VSS nmos W=0.31u L=0.04u
M6615 AND2_1585/net6 WX4155 AND2_1585/X_u2-net6 VSS nmos W=0.31u L=0.04u
M6616 WX4557 AND2_1585/net6 VDD VDD pmos W=0.41u L=0.04u
M6617 AND2_1585/net6 RESET VDD VDD pmos W=0.41u L=0.04u
M6618 AND2_1585/net6 WX4155 VDD VDD pmos W=0.41u L=0.04u
M6619 WX4555 AND2_1584/net6 VSS VSS nmos W=0.31u L=0.04u
M6620 AND2_1584/X_u2-net6 RESET VSS VSS nmos W=0.31u L=0.04u
M6621 AND2_1584/net6 WX4141 AND2_1584/X_u2-net6 VSS nmos W=0.31u L=0.04u
M6622 WX4555 AND2_1584/net6 VDD VDD pmos W=0.41u L=0.04u
M6623 AND2_1584/net6 RESET VDD VDD pmos W=0.41u L=0.04u
M6624 AND2_1584/net6 WX4141 VDD VDD pmos W=0.41u L=0.04u
M6625 WX4553 AND2_1583/net6 VSS VSS nmos W=0.31u L=0.04u
M6626 AND2_1583/X_u2-net6 RESET VSS VSS nmos W=0.31u L=0.04u
M6627 AND2_1583/net6 WX4127 AND2_1583/X_u2-net6 VSS nmos W=0.31u L=0.04u
M6628 WX4553 AND2_1583/net6 VDD VDD pmos W=0.41u L=0.04u
M6629 AND2_1583/net6 RESET VDD VDD pmos W=0.41u L=0.04u
M6630 AND2_1583/net6 WX4127 VDD VDD pmos W=0.41u L=0.04u
M6631 WX4551 AND2_1582/net6 VSS VSS nmos W=0.31u L=0.04u
M6632 AND2_1582/X_u2-net6 RESET VSS VSS nmos W=0.31u L=0.04u
M6633 AND2_1582/net6 WX4113 AND2_1582/X_u2-net6 VSS nmos W=0.31u L=0.04u
M6634 WX4551 AND2_1582/net6 VDD VDD pmos W=0.41u L=0.04u
M6635 AND2_1582/net6 RESET VDD VDD pmos W=0.41u L=0.04u
M6636 AND2_1582/net6 WX4113 VDD VDD pmos W=0.41u L=0.04u
M6637 WX4549 AND2_1581/net6 VSS VSS nmos W=0.31u L=0.04u
M6638 AND2_1581/X_u2-net6 RESET VSS VSS nmos W=0.31u L=0.04u
M6639 AND2_1581/net6 WX4099 AND2_1581/X_u2-net6 VSS nmos W=0.31u L=0.04u
M6640 WX4549 AND2_1581/net6 VDD VDD pmos W=0.41u L=0.04u
M6641 AND2_1581/net6 RESET VDD VDD pmos W=0.41u L=0.04u
M6642 AND2_1581/net6 WX4099 VDD VDD pmos W=0.41u L=0.04u
M6643 WX4547 AND2_1580/net6 VSS VSS nmos W=0.31u L=0.04u
M6644 AND2_1580/X_u2-net6 RESET VSS VSS nmos W=0.31u L=0.04u
M6645 AND2_1580/net6 WX4085 AND2_1580/X_u2-net6 VSS nmos W=0.31u L=0.04u
M6646 WX4547 AND2_1580/net6 VDD VDD pmos W=0.41u L=0.04u
M6647 AND2_1580/net6 RESET VDD VDD pmos W=0.41u L=0.04u
M6648 AND2_1580/net6 WX4085 VDD VDD pmos W=0.41u L=0.04u
M6649 WX4545 AND2_1579/net6 VSS VSS nmos W=0.31u L=0.04u
M6650 AND2_1579/X_u2-net6 RESET VSS VSS nmos W=0.31u L=0.04u
M6651 AND2_1579/net6 WX4071 AND2_1579/X_u2-net6 VSS nmos W=0.31u L=0.04u
M6652 WX4545 AND2_1579/net6 VDD VDD pmos W=0.41u L=0.04u
M6653 AND2_1579/net6 RESET VDD VDD pmos W=0.41u L=0.04u
M6654 AND2_1579/net6 WX4071 VDD VDD pmos W=0.41u L=0.04u
M6655 WX4543 AND2_1578/net6 VSS VSS nmos W=0.31u L=0.04u
M6656 AND2_1578/X_u2-net6 RESET VSS VSS nmos W=0.31u L=0.04u
M6657 AND2_1578/net6 WX4057 AND2_1578/X_u2-net6 VSS nmos W=0.31u L=0.04u
M6658 WX4543 AND2_1578/net6 VDD VDD pmos W=0.41u L=0.04u
M6659 AND2_1578/net6 RESET VDD VDD pmos W=0.41u L=0.04u
M6660 AND2_1578/net6 WX4057 VDD VDD pmos W=0.41u L=0.04u
M6661 WX4541 AND2_1577/net6 VSS VSS nmos W=0.31u L=0.04u
M6662 AND2_1577/X_u2-net6 RESET VSS VSS nmos W=0.31u L=0.04u
M6663 AND2_1577/net6 WX4043 AND2_1577/X_u2-net6 VSS nmos W=0.31u L=0.04u
M6664 WX4541 AND2_1577/net6 VDD VDD pmos W=0.41u L=0.04u
M6665 AND2_1577/net6 RESET VDD VDD pmos W=0.41u L=0.04u
M6666 AND2_1577/net6 WX4043 VDD VDD pmos W=0.41u L=0.04u
M6667 WX4539 AND2_1576/net6 VSS VSS nmos W=0.31u L=0.04u
M6668 AND2_1576/X_u2-net6 RESET VSS VSS nmos W=0.31u L=0.04u
M6669 AND2_1576/net6 WX4029 AND2_1576/X_u2-net6 VSS nmos W=0.31u L=0.04u
M6670 WX4539 AND2_1576/net6 VDD VDD pmos W=0.41u L=0.04u
M6671 AND2_1576/net6 RESET VDD VDD pmos W=0.41u L=0.04u
M6672 AND2_1576/net6 WX4029 VDD VDD pmos W=0.41u L=0.04u
M6673 WX4537 AND2_1575/net6 VSS VSS nmos W=0.31u L=0.04u
M6674 AND2_1575/X_u2-net6 RESET VSS VSS nmos W=0.31u L=0.04u
M6675 AND2_1575/net6 WX4015 AND2_1575/X_u2-net6 VSS nmos W=0.31u L=0.04u
M6676 WX4537 AND2_1575/net6 VDD VDD pmos W=0.41u L=0.04u
M6677 AND2_1575/net6 RESET VDD VDD pmos W=0.41u L=0.04u
M6678 AND2_1575/net6 WX4015 VDD VDD pmos W=0.41u L=0.04u
M6679 WX4535 AND2_1574/net6 VSS VSS nmos W=0.31u L=0.04u
M6680 AND2_1574/X_u2-net6 RESET VSS VSS nmos W=0.31u L=0.04u
M6681 AND2_1574/net6 WX4001 AND2_1574/X_u2-net6 VSS nmos W=0.31u L=0.04u
M6682 WX4535 AND2_1574/net6 VDD VDD pmos W=0.41u L=0.04u
M6683 AND2_1574/net6 RESET VDD VDD pmos W=0.41u L=0.04u
M6684 AND2_1574/net6 WX4001 VDD VDD pmos W=0.41u L=0.04u
M6685 WX4533 AND2_1573/net6 VSS VSS nmos W=0.31u L=0.04u
M6686 AND2_1573/X_u2-net6 RESET VSS VSS nmos W=0.31u L=0.04u
M6687 AND2_1573/net6 WX3987 AND2_1573/X_u2-net6 VSS nmos W=0.31u L=0.04u
M6688 WX4533 AND2_1573/net6 VDD VDD pmos W=0.41u L=0.04u
M6689 AND2_1573/net6 RESET VDD VDD pmos W=0.41u L=0.04u
M6690 AND2_1573/net6 WX3987 VDD VDD pmos W=0.41u L=0.04u
M6691 WX4531 AND2_1572/net6 VSS VSS nmos W=0.31u L=0.04u
M6692 AND2_1572/X_u2-net6 RESET VSS VSS nmos W=0.31u L=0.04u
M6693 AND2_1572/net6 WX3973 AND2_1572/X_u2-net6 VSS nmos W=0.31u L=0.04u
M6694 WX4531 AND2_1572/net6 VDD VDD pmos W=0.41u L=0.04u
M6695 AND2_1572/net6 RESET VDD VDD pmos W=0.41u L=0.04u
M6696 AND2_1572/net6 WX3973 VDD VDD pmos W=0.41u L=0.04u
M6697 WX4529 AND2_1571/net6 VSS VSS nmos W=0.31u L=0.04u
M6698 AND2_1571/X_u2-net6 RESET VSS VSS nmos W=0.31u L=0.04u
M6699 AND2_1571/net6 WX3959 AND2_1571/X_u2-net6 VSS nmos W=0.31u L=0.04u
M6700 WX4529 AND2_1571/net6 VDD VDD pmos W=0.41u L=0.04u
M6701 AND2_1571/net6 RESET VDD VDD pmos W=0.41u L=0.04u
M6702 AND2_1571/net6 WX3959 VDD VDD pmos W=0.41u L=0.04u
M6703 WX4527 AND2_1570/net6 VSS VSS nmos W=0.31u L=0.04u
M6704 AND2_1570/X_u2-net6 RESET VSS VSS nmos W=0.31u L=0.04u
M6705 AND2_1570/net6 WX3945 AND2_1570/X_u2-net6 VSS nmos W=0.31u L=0.04u
M6706 WX4527 AND2_1570/net6 VDD VDD pmos W=0.41u L=0.04u
M6707 AND2_1570/net6 RESET VDD VDD pmos W=0.41u L=0.04u
M6708 AND2_1570/net6 WX3945 VDD VDD pmos W=0.41u L=0.04u
M6709 WX4525 AND2_1569/net6 VSS VSS nmos W=0.31u L=0.04u
M6710 AND2_1569/X_u2-net6 RESET VSS VSS nmos W=0.31u L=0.04u
M6711 AND2_1569/net6 WX3931 AND2_1569/X_u2-net6 VSS nmos W=0.31u L=0.04u
M6712 WX4525 AND2_1569/net6 VDD VDD pmos W=0.41u L=0.04u
M6713 AND2_1569/net6 RESET VDD VDD pmos W=0.41u L=0.04u
M6714 AND2_1569/net6 WX3931 VDD VDD pmos W=0.41u L=0.04u
M6715 WX4523 AND2_1568/net6 VSS VSS nmos W=0.31u L=0.04u
M6716 AND2_1568/X_u2-net6 RESET VSS VSS nmos W=0.31u L=0.04u
M6717 AND2_1568/net6 WX3917 AND2_1568/X_u2-net6 VSS nmos W=0.31u L=0.04u
M6718 WX4523 AND2_1568/net6 VDD VDD pmos W=0.41u L=0.04u
M6719 AND2_1568/net6 RESET VDD VDD pmos W=0.41u L=0.04u
M6720 AND2_1568/net6 WX3917 VDD VDD pmos W=0.41u L=0.04u
M6721 WX4425 AND2_1567/net6 VSS VSS nmos W=0.31u L=0.04u
M6722 AND2_1567/X_u2-net6 RESET VSS VSS nmos W=0.31u L=0.04u
M6723 AND2_1567/net6 WX4362 AND2_1567/X_u2-net6 VSS nmos W=0.31u L=0.04u
M6724 WX4425 AND2_1567/net6 VDD VDD pmos W=0.41u L=0.04u
M6725 AND2_1567/net6 RESET VDD VDD pmos W=0.41u L=0.04u
M6726 AND2_1567/net6 WX4362 VDD VDD pmos W=0.41u L=0.04u
M6727 WX4423 AND2_1566/net6 VSS VSS nmos W=0.31u L=0.04u
M6728 AND2_1566/X_u2-net6 RESET VSS VSS nmos W=0.31u L=0.04u
M6729 AND2_1566/net6 WX4426 AND2_1566/X_u2-net6 VSS nmos W=0.31u L=0.04u
M6730 WX4423 AND2_1566/net6 VDD VDD pmos W=0.41u L=0.04u
M6731 AND2_1566/net6 RESET VDD VDD pmos W=0.41u L=0.04u
M6732 AND2_1566/net6 WX4426 VDD VDD pmos W=0.41u L=0.04u
M6733 WX4421 AND2_1565/net6 VSS VSS nmos W=0.31u L=0.04u
M6734 AND2_1565/X_u2-net6 RESET VSS VSS nmos W=0.31u L=0.04u
M6735 AND2_1565/net6 WX4424 AND2_1565/X_u2-net6 VSS nmos W=0.31u L=0.04u
M6736 WX4421 AND2_1565/net6 VDD VDD pmos W=0.41u L=0.04u
M6737 AND2_1565/net6 RESET VDD VDD pmos W=0.41u L=0.04u
M6738 AND2_1565/net6 WX4424 VDD VDD pmos W=0.41u L=0.04u
M6739 WX4419 AND2_1564/net6 VSS VSS nmos W=0.31u L=0.04u
M6740 AND2_1564/X_u2-net6 RESET VSS VSS nmos W=0.31u L=0.04u
M6741 AND2_1564/net6 WX4422 AND2_1564/X_u2-net6 VSS nmos W=0.31u L=0.04u
M6742 WX4419 AND2_1564/net6 VDD VDD pmos W=0.41u L=0.04u
M6743 AND2_1564/net6 RESET VDD VDD pmos W=0.41u L=0.04u
M6744 AND2_1564/net6 WX4422 VDD VDD pmos W=0.41u L=0.04u
M6745 WX4417 AND2_1563/net6 VSS VSS nmos W=0.31u L=0.04u
M6746 AND2_1563/X_u2-net6 RESET VSS VSS nmos W=0.31u L=0.04u
M6747 AND2_1563/net6 WX4420 AND2_1563/X_u2-net6 VSS nmos W=0.31u L=0.04u
M6748 WX4417 AND2_1563/net6 VDD VDD pmos W=0.41u L=0.04u
M6749 AND2_1563/net6 RESET VDD VDD pmos W=0.41u L=0.04u
M6750 AND2_1563/net6 WX4420 VDD VDD pmos W=0.41u L=0.04u
M6751 WX4415 AND2_1562/net6 VSS VSS nmos W=0.31u L=0.04u
M6752 AND2_1562/X_u2-net6 RESET VSS VSS nmos W=0.31u L=0.04u
M6753 AND2_1562/net6 WX4418 AND2_1562/X_u2-net6 VSS nmos W=0.31u L=0.04u
M6754 WX4415 AND2_1562/net6 VDD VDD pmos W=0.41u L=0.04u
M6755 AND2_1562/net6 RESET VDD VDD pmos W=0.41u L=0.04u
M6756 AND2_1562/net6 WX4418 VDD VDD pmos W=0.41u L=0.04u
M6757 WX4413 AND2_1561/net6 VSS VSS nmos W=0.31u L=0.04u
M6758 AND2_1561/X_u2-net6 RESET VSS VSS nmos W=0.31u L=0.04u
M6759 AND2_1561/net6 WX4416 AND2_1561/X_u2-net6 VSS nmos W=0.31u L=0.04u
M6760 WX4413 AND2_1561/net6 VDD VDD pmos W=0.41u L=0.04u
M6761 AND2_1561/net6 RESET VDD VDD pmos W=0.41u L=0.04u
M6762 AND2_1561/net6 WX4416 VDD VDD pmos W=0.41u L=0.04u
M6763 WX4411 AND2_1560/net6 VSS VSS nmos W=0.31u L=0.04u
M6764 AND2_1560/X_u2-net6 RESET VSS VSS nmos W=0.31u L=0.04u
M6765 AND2_1560/net6 WX4414 AND2_1560/X_u2-net6 VSS nmos W=0.31u L=0.04u
M6766 WX4411 AND2_1560/net6 VDD VDD pmos W=0.41u L=0.04u
M6767 AND2_1560/net6 RESET VDD VDD pmos W=0.41u L=0.04u
M6768 AND2_1560/net6 WX4414 VDD VDD pmos W=0.41u L=0.04u
M6769 WX4409 AND2_1559/net6 VSS VSS nmos W=0.31u L=0.04u
M6770 AND2_1559/X_u2-net6 RESET VSS VSS nmos W=0.31u L=0.04u
M6771 AND2_1559/net6 WX4412 AND2_1559/X_u2-net6 VSS nmos W=0.31u L=0.04u
M6772 WX4409 AND2_1559/net6 VDD VDD pmos W=0.41u L=0.04u
M6773 AND2_1559/net6 RESET VDD VDD pmos W=0.41u L=0.04u
M6774 AND2_1559/net6 WX4412 VDD VDD pmos W=0.41u L=0.04u
M6775 WX4407 AND2_1558/net6 VSS VSS nmos W=0.31u L=0.04u
M6776 AND2_1558/X_u2-net6 RESET VSS VSS nmos W=0.31u L=0.04u
M6777 AND2_1558/net6 WX4410 AND2_1558/X_u2-net6 VSS nmos W=0.31u L=0.04u
M6778 WX4407 AND2_1558/net6 VDD VDD pmos W=0.41u L=0.04u
M6779 AND2_1558/net6 RESET VDD VDD pmos W=0.41u L=0.04u
M6780 AND2_1558/net6 WX4410 VDD VDD pmos W=0.41u L=0.04u
M6781 WX4405 AND2_1557/net6 VSS VSS nmos W=0.31u L=0.04u
M6782 AND2_1557/X_u2-net6 RESET VSS VSS nmos W=0.31u L=0.04u
M6783 AND2_1557/net6 WX4408 AND2_1557/X_u2-net6 VSS nmos W=0.31u L=0.04u
M6784 WX4405 AND2_1557/net6 VDD VDD pmos W=0.41u L=0.04u
M6785 AND2_1557/net6 RESET VDD VDD pmos W=0.41u L=0.04u
M6786 AND2_1557/net6 WX4408 VDD VDD pmos W=0.41u L=0.04u
M6787 WX4403 AND2_1556/net6 VSS VSS nmos W=0.31u L=0.04u
M6788 AND2_1556/X_u2-net6 RESET VSS VSS nmos W=0.31u L=0.04u
M6789 AND2_1556/net6 WX4406 AND2_1556/X_u2-net6 VSS nmos W=0.31u L=0.04u
M6790 WX4403 AND2_1556/net6 VDD VDD pmos W=0.41u L=0.04u
M6791 AND2_1556/net6 RESET VDD VDD pmos W=0.41u L=0.04u
M6792 AND2_1556/net6 WX4406 VDD VDD pmos W=0.41u L=0.04u
M6793 WX4401 AND2_1555/net6 VSS VSS nmos W=0.31u L=0.04u
M6794 AND2_1555/X_u2-net6 RESET VSS VSS nmos W=0.31u L=0.04u
M6795 AND2_1555/net6 WX4404 AND2_1555/X_u2-net6 VSS nmos W=0.31u L=0.04u
M6796 WX4401 AND2_1555/net6 VDD VDD pmos W=0.41u L=0.04u
M6797 AND2_1555/net6 RESET VDD VDD pmos W=0.41u L=0.04u
M6798 AND2_1555/net6 WX4404 VDD VDD pmos W=0.41u L=0.04u
M6799 WX4399 AND2_1554/net6 VSS VSS nmos W=0.31u L=0.04u
M6800 AND2_1554/X_u2-net6 RESET VSS VSS nmos W=0.31u L=0.04u
M6801 AND2_1554/net6 WX4402 AND2_1554/X_u2-net6 VSS nmos W=0.31u L=0.04u
M6802 WX4399 AND2_1554/net6 VDD VDD pmos W=0.41u L=0.04u
M6803 AND2_1554/net6 RESET VDD VDD pmos W=0.41u L=0.04u
M6804 AND2_1554/net6 WX4402 VDD VDD pmos W=0.41u L=0.04u
M6805 WX4397 AND2_1553/net6 VSS VSS nmos W=0.31u L=0.04u
M6806 AND2_1553/X_u2-net6 RESET VSS VSS nmos W=0.31u L=0.04u
M6807 AND2_1553/net6 WX4400 AND2_1553/X_u2-net6 VSS nmos W=0.31u L=0.04u
M6808 WX4397 AND2_1553/net6 VDD VDD pmos W=0.41u L=0.04u
M6809 AND2_1553/net6 RESET VDD VDD pmos W=0.41u L=0.04u
M6810 AND2_1553/net6 WX4400 VDD VDD pmos W=0.41u L=0.04u
M6811 WX4395 AND2_1552/net6 VSS VSS nmos W=0.31u L=0.04u
M6812 AND2_1552/X_u2-net6 RESET VSS VSS nmos W=0.31u L=0.04u
M6813 AND2_1552/net6 WX4398 AND2_1552/X_u2-net6 VSS nmos W=0.31u L=0.04u
M6814 WX4395 AND2_1552/net6 VDD VDD pmos W=0.41u L=0.04u
M6815 AND2_1552/net6 RESET VDD VDD pmos W=0.41u L=0.04u
M6816 AND2_1552/net6 WX4398 VDD VDD pmos W=0.41u L=0.04u
M6817 WX4393 AND2_1551/net6 VSS VSS nmos W=0.31u L=0.04u
M6818 AND2_1551/X_u2-net6 RESET VSS VSS nmos W=0.31u L=0.04u
M6819 AND2_1551/net6 WX4396 AND2_1551/X_u2-net6 VSS nmos W=0.31u L=0.04u
M6820 WX4393 AND2_1551/net6 VDD VDD pmos W=0.41u L=0.04u
M6821 AND2_1551/net6 RESET VDD VDD pmos W=0.41u L=0.04u
M6822 AND2_1551/net6 WX4396 VDD VDD pmos W=0.41u L=0.04u
M6823 WX4391 AND2_1550/net6 VSS VSS nmos W=0.31u L=0.04u
M6824 AND2_1550/X_u2-net6 RESET VSS VSS nmos W=0.31u L=0.04u
M6825 AND2_1550/net6 WX4394 AND2_1550/X_u2-net6 VSS nmos W=0.31u L=0.04u
M6826 WX4391 AND2_1550/net6 VDD VDD pmos W=0.41u L=0.04u
M6827 AND2_1550/net6 RESET VDD VDD pmos W=0.41u L=0.04u
M6828 AND2_1550/net6 WX4394 VDD VDD pmos W=0.41u L=0.04u
M6829 WX4389 AND2_1549/net6 VSS VSS nmos W=0.31u L=0.04u
M6830 AND2_1549/X_u2-net6 RESET VSS VSS nmos W=0.31u L=0.04u
M6831 AND2_1549/net6 WX4392 AND2_1549/X_u2-net6 VSS nmos W=0.31u L=0.04u
M6832 WX4389 AND2_1549/net6 VDD VDD pmos W=0.41u L=0.04u
M6833 AND2_1549/net6 RESET VDD VDD pmos W=0.41u L=0.04u
M6834 AND2_1549/net6 WX4392 VDD VDD pmos W=0.41u L=0.04u
M6835 WX4387 AND2_1548/net6 VSS VSS nmos W=0.31u L=0.04u
M6836 AND2_1548/X_u2-net6 RESET VSS VSS nmos W=0.31u L=0.04u
M6837 AND2_1548/net6 WX4390 AND2_1548/X_u2-net6 VSS nmos W=0.31u L=0.04u
M6838 WX4387 AND2_1548/net6 VDD VDD pmos W=0.41u L=0.04u
M6839 AND2_1548/net6 RESET VDD VDD pmos W=0.41u L=0.04u
M6840 AND2_1548/net6 WX4390 VDD VDD pmos W=0.41u L=0.04u
M6841 WX4385 AND2_1547/net6 VSS VSS nmos W=0.31u L=0.04u
M6842 AND2_1547/X_u2-net6 RESET VSS VSS nmos W=0.31u L=0.04u
M6843 AND2_1547/net6 WX4388 AND2_1547/X_u2-net6 VSS nmos W=0.31u L=0.04u
M6844 WX4385 AND2_1547/net6 VDD VDD pmos W=0.41u L=0.04u
M6845 AND2_1547/net6 RESET VDD VDD pmos W=0.41u L=0.04u
M6846 AND2_1547/net6 WX4388 VDD VDD pmos W=0.41u L=0.04u
M6847 WX4383 AND2_1546/net6 VSS VSS nmos W=0.31u L=0.04u
M6848 AND2_1546/X_u2-net6 RESET VSS VSS nmos W=0.31u L=0.04u
M6849 AND2_1546/net6 WX4386 AND2_1546/X_u2-net6 VSS nmos W=0.31u L=0.04u
M6850 WX4383 AND2_1546/net6 VDD VDD pmos W=0.41u L=0.04u
M6851 AND2_1546/net6 RESET VDD VDD pmos W=0.41u L=0.04u
M6852 AND2_1546/net6 WX4386 VDD VDD pmos W=0.41u L=0.04u
M6853 WX4381 AND2_1545/net6 VSS VSS nmos W=0.31u L=0.04u
M6854 AND2_1545/X_u2-net6 RESET VSS VSS nmos W=0.31u L=0.04u
M6855 AND2_1545/net6 WX4384 AND2_1545/X_u2-net6 VSS nmos W=0.31u L=0.04u
M6856 WX4381 AND2_1545/net6 VDD VDD pmos W=0.41u L=0.04u
M6857 AND2_1545/net6 RESET VDD VDD pmos W=0.41u L=0.04u
M6858 AND2_1545/net6 WX4384 VDD VDD pmos W=0.41u L=0.04u
M6859 WX4379 AND2_1544/net6 VSS VSS nmos W=0.31u L=0.04u
M6860 AND2_1544/X_u2-net6 RESET VSS VSS nmos W=0.31u L=0.04u
M6861 AND2_1544/net6 WX4382 AND2_1544/X_u2-net6 VSS nmos W=0.31u L=0.04u
M6862 WX4379 AND2_1544/net6 VDD VDD pmos W=0.41u L=0.04u
M6863 AND2_1544/net6 RESET VDD VDD pmos W=0.41u L=0.04u
M6864 AND2_1544/net6 WX4382 VDD VDD pmos W=0.41u L=0.04u
M6865 WX4377 AND2_1543/net6 VSS VSS nmos W=0.31u L=0.04u
M6866 AND2_1543/X_u2-net6 RESET VSS VSS nmos W=0.31u L=0.04u
M6867 AND2_1543/net6 WX4380 AND2_1543/X_u2-net6 VSS nmos W=0.31u L=0.04u
M6868 WX4377 AND2_1543/net6 VDD VDD pmos W=0.41u L=0.04u
M6869 AND2_1543/net6 RESET VDD VDD pmos W=0.41u L=0.04u
M6870 AND2_1543/net6 WX4380 VDD VDD pmos W=0.41u L=0.04u
M6871 WX4375 AND2_1542/net6 VSS VSS nmos W=0.31u L=0.04u
M6872 AND2_1542/X_u2-net6 RESET VSS VSS nmos W=0.31u L=0.04u
M6873 AND2_1542/net6 WX4378 AND2_1542/X_u2-net6 VSS nmos W=0.31u L=0.04u
M6874 WX4375 AND2_1542/net6 VDD VDD pmos W=0.41u L=0.04u
M6875 AND2_1542/net6 RESET VDD VDD pmos W=0.41u L=0.04u
M6876 AND2_1542/net6 WX4378 VDD VDD pmos W=0.41u L=0.04u
M6877 WX4373 AND2_1541/net6 VSS VSS nmos W=0.31u L=0.04u
M6878 AND2_1541/X_u2-net6 RESET VSS VSS nmos W=0.31u L=0.04u
M6879 AND2_1541/net6 WX4376 AND2_1541/X_u2-net6 VSS nmos W=0.31u L=0.04u
M6880 WX4373 AND2_1541/net6 VDD VDD pmos W=0.41u L=0.04u
M6881 AND2_1541/net6 RESET VDD VDD pmos W=0.41u L=0.04u
M6882 AND2_1541/net6 WX4376 VDD VDD pmos W=0.41u L=0.04u
M6883 WX4371 AND2_1540/net6 VSS VSS nmos W=0.31u L=0.04u
M6884 AND2_1540/X_u2-net6 RESET VSS VSS nmos W=0.31u L=0.04u
M6885 AND2_1540/net6 WX4374 AND2_1540/X_u2-net6 VSS nmos W=0.31u L=0.04u
M6886 WX4371 AND2_1540/net6 VDD VDD pmos W=0.41u L=0.04u
M6887 AND2_1540/net6 RESET VDD VDD pmos W=0.41u L=0.04u
M6888 AND2_1540/net6 WX4374 VDD VDD pmos W=0.41u L=0.04u
M6889 WX4369 AND2_1539/net6 VSS VSS nmos W=0.31u L=0.04u
M6890 AND2_1539/X_u2-net6 RESET VSS VSS nmos W=0.31u L=0.04u
M6891 AND2_1539/net6 WX4372 AND2_1539/X_u2-net6 VSS nmos W=0.31u L=0.04u
M6892 WX4369 AND2_1539/net6 VDD VDD pmos W=0.41u L=0.04u
M6893 AND2_1539/net6 RESET VDD VDD pmos W=0.41u L=0.04u
M6894 AND2_1539/net6 WX4372 VDD VDD pmos W=0.41u L=0.04u
M6895 WX4367 AND2_1538/net6 VSS VSS nmos W=0.31u L=0.04u
M6896 AND2_1538/X_u2-net6 RESET VSS VSS nmos W=0.31u L=0.04u
M6897 AND2_1538/net6 WX4370 AND2_1538/X_u2-net6 VSS nmos W=0.31u L=0.04u
M6898 WX4367 AND2_1538/net6 VDD VDD pmos W=0.41u L=0.04u
M6899 AND2_1538/net6 RESET VDD VDD pmos W=0.41u L=0.04u
M6900 AND2_1538/net6 WX4370 VDD VDD pmos W=0.41u L=0.04u
M6901 WX4365 AND2_1537/net6 VSS VSS nmos W=0.31u L=0.04u
M6902 AND2_1537/X_u2-net6 RESET VSS VSS nmos W=0.31u L=0.04u
M6903 AND2_1537/net6 WX4368 AND2_1537/X_u2-net6 VSS nmos W=0.31u L=0.04u
M6904 WX4365 AND2_1537/net6 VDD VDD pmos W=0.41u L=0.04u
M6905 AND2_1537/net6 RESET VDD VDD pmos W=0.41u L=0.04u
M6906 AND2_1537/net6 WX4368 VDD VDD pmos W=0.41u L=0.04u
M6907 WX4363 AND2_1536/net6 VSS VSS nmos W=0.31u L=0.04u
M6908 AND2_1536/X_u2-net6 RESET VSS VSS nmos W=0.31u L=0.04u
M6909 AND2_1536/net6 WX4366 AND2_1536/X_u2-net6 VSS nmos W=0.31u L=0.04u
M6910 WX4363 AND2_1536/net6 VDD VDD pmos W=0.41u L=0.04u
M6911 AND2_1536/net6 RESET VDD VDD pmos W=0.41u L=0.04u
M6912 AND2_1536/net6 WX4366 VDD VDD pmos W=0.41u L=0.04u
M6913 WX3912 AND2_1343/net6 VSS VSS nmos W=0.31u L=0.04u
M6914 AND2_1343/X_u2-net6 RESET VSS VSS nmos W=0.31u L=0.04u
M6915 AND2_1343/net6 n1016 AND2_1343/X_u2-net6 VSS nmos W=0.31u L=0.04u
M6916 WX3912 AND2_1343/net6 VDD VDD pmos W=0.41u L=0.04u
M6917 AND2_1343/net6 RESET VDD VDD pmos W=0.41u L=0.04u
M6918 AND2_1343/net6 n1016 VDD VDD pmos W=0.41u L=0.04u
M6919 WX3910 AND2_1342/net6 VSS VSS nmos W=0.31u L=0.04u
M6920 AND2_1342/X_u2-net6 RESET VSS VSS nmos W=0.31u L=0.04u
M6921 AND2_1342/net6 n1017 AND2_1342/X_u2-net6 VSS nmos W=0.31u L=0.04u
M6922 WX3910 AND2_1342/net6 VDD VDD pmos W=0.41u L=0.04u
M6923 AND2_1342/net6 RESET VDD VDD pmos W=0.41u L=0.04u
M6924 AND2_1342/net6 n1017 VDD VDD pmos W=0.41u L=0.04u
M6925 WX3908 AND2_1341/net6 VSS VSS nmos W=0.31u L=0.04u
M6926 AND2_1341/X_u2-net6 RESET VSS VSS nmos W=0.31u L=0.04u
M6927 AND2_1341/net6 n1018 AND2_1341/X_u2-net6 VSS nmos W=0.31u L=0.04u
M6928 WX3908 AND2_1341/net6 VDD VDD pmos W=0.41u L=0.04u
M6929 AND2_1341/net6 RESET VDD VDD pmos W=0.41u L=0.04u
M6930 AND2_1341/net6 n1018 VDD VDD pmos W=0.41u L=0.04u
M6931 WX3906 AND2_1340/net6 VSS VSS nmos W=0.31u L=0.04u
M6932 AND2_1340/X_u2-net6 RESET VSS VSS nmos W=0.31u L=0.04u
M6933 AND2_1340/net6 n1019 AND2_1340/X_u2-net6 VSS nmos W=0.31u L=0.04u
M6934 WX3906 AND2_1340/net6 VDD VDD pmos W=0.41u L=0.04u
M6935 AND2_1340/net6 RESET VDD VDD pmos W=0.41u L=0.04u
M6936 AND2_1340/net6 n1019 VDD VDD pmos W=0.41u L=0.04u
M6937 WX3904 AND2_1339/net6 VSS VSS nmos W=0.31u L=0.04u
M6938 AND2_1339/X_u2-net6 RESET VSS VSS nmos W=0.31u L=0.04u
M6939 AND2_1339/net6 n1020 AND2_1339/X_u2-net6 VSS nmos W=0.31u L=0.04u
M6940 WX3904 AND2_1339/net6 VDD VDD pmos W=0.41u L=0.04u
M6941 AND2_1339/net6 RESET VDD VDD pmos W=0.41u L=0.04u
M6942 AND2_1339/net6 n1020 VDD VDD pmos W=0.41u L=0.04u
M6943 WX3902 AND2_1338/net6 VSS VSS nmos W=0.31u L=0.04u
M6944 AND2_1338/X_u2-net6 RESET VSS VSS nmos W=0.31u L=0.04u
M6945 AND2_1338/net6 n1021 AND2_1338/X_u2-net6 VSS nmos W=0.31u L=0.04u
M6946 WX3902 AND2_1338/net6 VDD VDD pmos W=0.41u L=0.04u
M6947 AND2_1338/net6 RESET VDD VDD pmos W=0.41u L=0.04u
M6948 AND2_1338/net6 n1021 VDD VDD pmos W=0.41u L=0.04u
M6949 WX3900 AND2_1337/net6 VSS VSS nmos W=0.31u L=0.04u
M6950 AND2_1337/X_u2-net6 RESET VSS VSS nmos W=0.31u L=0.04u
M6951 AND2_1337/net6 n1022 AND2_1337/X_u2-net6 VSS nmos W=0.31u L=0.04u
M6952 WX3900 AND2_1337/net6 VDD VDD pmos W=0.41u L=0.04u
M6953 AND2_1337/net6 RESET VDD VDD pmos W=0.41u L=0.04u
M6954 AND2_1337/net6 n1022 VDD VDD pmos W=0.41u L=0.04u
M6955 WX3898 AND2_1336/net6 VSS VSS nmos W=0.31u L=0.04u
M6956 AND2_1336/X_u2-net6 RESET VSS VSS nmos W=0.31u L=0.04u
M6957 AND2_1336/net6 n1023 AND2_1336/X_u2-net6 VSS nmos W=0.31u L=0.04u
M6958 WX3898 AND2_1336/net6 VDD VDD pmos W=0.41u L=0.04u
M6959 AND2_1336/net6 RESET VDD VDD pmos W=0.41u L=0.04u
M6960 AND2_1336/net6 n1023 VDD VDD pmos W=0.41u L=0.04u
M6961 WX3896 AND2_1335/net6 VSS VSS nmos W=0.31u L=0.04u
M6962 AND2_1335/X_u2-net6 RESET VSS VSS nmos W=0.31u L=0.04u
M6963 AND2_1335/net6 n1024 AND2_1335/X_u2-net6 VSS nmos W=0.31u L=0.04u
M6964 WX3896 AND2_1335/net6 VDD VDD pmos W=0.41u L=0.04u
M6965 AND2_1335/net6 RESET VDD VDD pmos W=0.41u L=0.04u
M6966 AND2_1335/net6 n1024 VDD VDD pmos W=0.41u L=0.04u
M6967 WX3894 AND2_1334/net6 VSS VSS nmos W=0.31u L=0.04u
M6968 AND2_1334/X_u2-net6 RESET VSS VSS nmos W=0.31u L=0.04u
M6969 AND2_1334/net6 n1025 AND2_1334/X_u2-net6 VSS nmos W=0.31u L=0.04u
M6970 WX3894 AND2_1334/net6 VDD VDD pmos W=0.41u L=0.04u
M6971 AND2_1334/net6 RESET VDD VDD pmos W=0.41u L=0.04u
M6972 AND2_1334/net6 n1025 VDD VDD pmos W=0.41u L=0.04u
M6973 WX3892 AND2_1333/net6 VSS VSS nmos W=0.31u L=0.04u
M6974 AND2_1333/X_u2-net6 RESET VSS VSS nmos W=0.31u L=0.04u
M6975 AND2_1333/net6 n1026 AND2_1333/X_u2-net6 VSS nmos W=0.31u L=0.04u
M6976 WX3892 AND2_1333/net6 VDD VDD pmos W=0.41u L=0.04u
M6977 AND2_1333/net6 RESET VDD VDD pmos W=0.41u L=0.04u
M6978 AND2_1333/net6 n1026 VDD VDD pmos W=0.41u L=0.04u
M6979 WX3890 AND2_1332/net6 VSS VSS nmos W=0.31u L=0.04u
M6980 AND2_1332/X_u2-net6 RESET VSS VSS nmos W=0.31u L=0.04u
M6981 AND2_1332/net6 n1027 AND2_1332/X_u2-net6 VSS nmos W=0.31u L=0.04u
M6982 WX3890 AND2_1332/net6 VDD VDD pmos W=0.41u L=0.04u
M6983 AND2_1332/net6 RESET VDD VDD pmos W=0.41u L=0.04u
M6984 AND2_1332/net6 n1027 VDD VDD pmos W=0.41u L=0.04u
M6985 WX3888 AND2_1331/net6 VSS VSS nmos W=0.31u L=0.04u
M6986 AND2_1331/X_u2-net6 RESET VSS VSS nmos W=0.31u L=0.04u
M6987 AND2_1331/net6 n1028 AND2_1331/X_u2-net6 VSS nmos W=0.31u L=0.04u
M6988 WX3888 AND2_1331/net6 VDD VDD pmos W=0.41u L=0.04u
M6989 AND2_1331/net6 RESET VDD VDD pmos W=0.41u L=0.04u
M6990 AND2_1331/net6 n1028 VDD VDD pmos W=0.41u L=0.04u
M6991 WX3886 AND2_1330/net6 VSS VSS nmos W=0.31u L=0.04u
M6992 AND2_1330/X_u2-net6 RESET VSS VSS nmos W=0.31u L=0.04u
M6993 AND2_1330/net6 n1029 AND2_1330/X_u2-net6 VSS nmos W=0.31u L=0.04u
M6994 WX3886 AND2_1330/net6 VDD VDD pmos W=0.41u L=0.04u
M6995 AND2_1330/net6 RESET VDD VDD pmos W=0.41u L=0.04u
M6996 AND2_1330/net6 n1029 VDD VDD pmos W=0.41u L=0.04u
M6997 WX3884 AND2_1329/net6 VSS VSS nmos W=0.31u L=0.04u
M6998 AND2_1329/X_u2-net6 RESET VSS VSS nmos W=0.31u L=0.04u
M6999 AND2_1329/net6 n1030 AND2_1329/X_u2-net6 VSS nmos W=0.31u L=0.04u
M7000 WX3884 AND2_1329/net6 VDD VDD pmos W=0.41u L=0.04u
M7001 AND2_1329/net6 RESET VDD VDD pmos W=0.41u L=0.04u
M7002 AND2_1329/net6 n1030 VDD VDD pmos W=0.41u L=0.04u
M7003 WX3882 AND2_1328/net6 VSS VSS nmos W=0.31u L=0.04u
M7004 AND2_1328/X_u2-net6 RESET VSS VSS nmos W=0.31u L=0.04u
M7005 AND2_1328/net6 n1031 AND2_1328/X_u2-net6 VSS nmos W=0.31u L=0.04u
M7006 WX3882 AND2_1328/net6 VDD VDD pmos W=0.41u L=0.04u
M7007 AND2_1328/net6 RESET VDD VDD pmos W=0.41u L=0.04u
M7008 AND2_1328/net6 n1031 VDD VDD pmos W=0.41u L=0.04u
M7009 WX3880 AND2_1327/net6 VSS VSS nmos W=0.31u L=0.04u
M7010 AND2_1327/X_u2-net6 RESET VSS VSS nmos W=0.31u L=0.04u
M7011 AND2_1327/net6 n1032 AND2_1327/X_u2-net6 VSS nmos W=0.31u L=0.04u
M7012 WX3880 AND2_1327/net6 VDD VDD pmos W=0.41u L=0.04u
M7013 AND2_1327/net6 RESET VDD VDD pmos W=0.41u L=0.04u
M7014 AND2_1327/net6 n1032 VDD VDD pmos W=0.41u L=0.04u
M7015 WX3878 AND2_1326/net6 VSS VSS nmos W=0.31u L=0.04u
M7016 AND2_1326/X_u2-net6 RESET VSS VSS nmos W=0.31u L=0.04u
M7017 AND2_1326/net6 n1033 AND2_1326/X_u2-net6 VSS nmos W=0.31u L=0.04u
M7018 WX3878 AND2_1326/net6 VDD VDD pmos W=0.41u L=0.04u
M7019 AND2_1326/net6 RESET VDD VDD pmos W=0.41u L=0.04u
M7020 AND2_1326/net6 n1033 VDD VDD pmos W=0.41u L=0.04u
M7021 WX3876 AND2_1325/net6 VSS VSS nmos W=0.31u L=0.04u
M7022 AND2_1325/X_u2-net6 RESET VSS VSS nmos W=0.31u L=0.04u
M7023 AND2_1325/net6 n1034 AND2_1325/X_u2-net6 VSS nmos W=0.31u L=0.04u
M7024 WX3876 AND2_1325/net6 VDD VDD pmos W=0.41u L=0.04u
M7025 AND2_1325/net6 RESET VDD VDD pmos W=0.41u L=0.04u
M7026 AND2_1325/net6 n1034 VDD VDD pmos W=0.41u L=0.04u
M7027 WX3874 AND2_1324/net6 VSS VSS nmos W=0.31u L=0.04u
M7028 AND2_1324/X_u2-net6 RESET VSS VSS nmos W=0.31u L=0.04u
M7029 AND2_1324/net6 n1035 AND2_1324/X_u2-net6 VSS nmos W=0.31u L=0.04u
M7030 WX3874 AND2_1324/net6 VDD VDD pmos W=0.41u L=0.04u
M7031 AND2_1324/net6 RESET VDD VDD pmos W=0.41u L=0.04u
M7032 AND2_1324/net6 n1035 VDD VDD pmos W=0.41u L=0.04u
M7033 WX3872 AND2_1323/net6 VSS VSS nmos W=0.31u L=0.04u
M7034 AND2_1323/X_u2-net6 RESET VSS VSS nmos W=0.31u L=0.04u
M7035 AND2_1323/net6 n1036 AND2_1323/X_u2-net6 VSS nmos W=0.31u L=0.04u
M7036 WX3872 AND2_1323/net6 VDD VDD pmos W=0.41u L=0.04u
M7037 AND2_1323/net6 RESET VDD VDD pmos W=0.41u L=0.04u
M7038 AND2_1323/net6 n1036 VDD VDD pmos W=0.41u L=0.04u
M7039 WX3870 AND2_1322/net6 VSS VSS nmos W=0.31u L=0.04u
M7040 AND2_1322/X_u2-net6 RESET VSS VSS nmos W=0.31u L=0.04u
M7041 AND2_1322/net6 n1037 AND2_1322/X_u2-net6 VSS nmos W=0.31u L=0.04u
M7042 WX3870 AND2_1322/net6 VDD VDD pmos W=0.41u L=0.04u
M7043 AND2_1322/net6 RESET VDD VDD pmos W=0.41u L=0.04u
M7044 AND2_1322/net6 n1037 VDD VDD pmos W=0.41u L=0.04u
M7045 WX3868 AND2_1321/net6 VSS VSS nmos W=0.31u L=0.04u
M7046 AND2_1321/X_u2-net6 RESET VSS VSS nmos W=0.31u L=0.04u
M7047 AND2_1321/net6 n1038 AND2_1321/X_u2-net6 VSS nmos W=0.31u L=0.04u
M7048 WX3868 AND2_1321/net6 VDD VDD pmos W=0.41u L=0.04u
M7049 AND2_1321/net6 RESET VDD VDD pmos W=0.41u L=0.04u
M7050 AND2_1321/net6 n1038 VDD VDD pmos W=0.41u L=0.04u
M7051 WX3866 AND2_1320/net6 VSS VSS nmos W=0.31u L=0.04u
M7052 AND2_1320/X_u2-net6 RESET VSS VSS nmos W=0.31u L=0.04u
M7053 AND2_1320/net6 n1039 AND2_1320/X_u2-net6 VSS nmos W=0.31u L=0.04u
M7054 WX3866 AND2_1320/net6 VDD VDD pmos W=0.41u L=0.04u
M7055 AND2_1320/net6 RESET VDD VDD pmos W=0.41u L=0.04u
M7056 AND2_1320/net6 n1039 VDD VDD pmos W=0.41u L=0.04u
M7057 WX3864 AND2_1319/net6 VSS VSS nmos W=0.31u L=0.04u
M7058 AND2_1319/X_u2-net6 RESET VSS VSS nmos W=0.31u L=0.04u
M7059 AND2_1319/net6 n1040 AND2_1319/X_u2-net6 VSS nmos W=0.31u L=0.04u
M7060 WX3864 AND2_1319/net6 VDD VDD pmos W=0.41u L=0.04u
M7061 AND2_1319/net6 RESET VDD VDD pmos W=0.41u L=0.04u
M7062 AND2_1319/net6 n1040 VDD VDD pmos W=0.41u L=0.04u
M7063 WX3862 AND2_1318/net6 VSS VSS nmos W=0.31u L=0.04u
M7064 AND2_1318/X_u2-net6 RESET VSS VSS nmos W=0.31u L=0.04u
M7065 AND2_1318/net6 n1041 AND2_1318/X_u2-net6 VSS nmos W=0.31u L=0.04u
M7066 WX3862 AND2_1318/net6 VDD VDD pmos W=0.41u L=0.04u
M7067 AND2_1318/net6 RESET VDD VDD pmos W=0.41u L=0.04u
M7068 AND2_1318/net6 n1041 VDD VDD pmos W=0.41u L=0.04u
M7069 WX3860 AND2_1317/net6 VSS VSS nmos W=0.31u L=0.04u
M7070 AND2_1317/X_u2-net6 RESET VSS VSS nmos W=0.31u L=0.04u
M7071 AND2_1317/net6 n1042 AND2_1317/X_u2-net6 VSS nmos W=0.31u L=0.04u
M7072 WX3860 AND2_1317/net6 VDD VDD pmos W=0.41u L=0.04u
M7073 AND2_1317/net6 RESET VDD VDD pmos W=0.41u L=0.04u
M7074 AND2_1317/net6 n1042 VDD VDD pmos W=0.41u L=0.04u
M7075 WX3858 AND2_1316/net6 VSS VSS nmos W=0.31u L=0.04u
M7076 AND2_1316/X_u2-net6 RESET VSS VSS nmos W=0.31u L=0.04u
M7077 AND2_1316/net6 n1043 AND2_1316/X_u2-net6 VSS nmos W=0.31u L=0.04u
M7078 WX3858 AND2_1316/net6 VDD VDD pmos W=0.41u L=0.04u
M7079 AND2_1316/net6 RESET VDD VDD pmos W=0.41u L=0.04u
M7080 AND2_1316/net6 n1043 VDD VDD pmos W=0.41u L=0.04u
M7081 WX3856 AND2_1315/net6 VSS VSS nmos W=0.31u L=0.04u
M7082 AND2_1315/X_u2-net6 RESET VSS VSS nmos W=0.31u L=0.04u
M7083 AND2_1315/net6 n1044 AND2_1315/X_u2-net6 VSS nmos W=0.31u L=0.04u
M7084 WX3856 AND2_1315/net6 VDD VDD pmos W=0.41u L=0.04u
M7085 AND2_1315/net6 RESET VDD VDD pmos W=0.41u L=0.04u
M7086 AND2_1315/net6 n1044 VDD VDD pmos W=0.41u L=0.04u
M7087 WX3854 AND2_1314/net6 VSS VSS nmos W=0.31u L=0.04u
M7088 AND2_1314/X_u2-net6 RESET VSS VSS nmos W=0.31u L=0.04u
M7089 AND2_1314/net6 n1045 AND2_1314/X_u2-net6 VSS nmos W=0.31u L=0.04u
M7090 WX3854 AND2_1314/net6 VDD VDD pmos W=0.41u L=0.04u
M7091 AND2_1314/net6 RESET VDD VDD pmos W=0.41u L=0.04u
M7092 AND2_1314/net6 n1045 VDD VDD pmos W=0.41u L=0.04u
M7093 WX3852 AND2_1313/net6 VSS VSS nmos W=0.31u L=0.04u
M7094 AND2_1313/X_u2-net6 RESET VSS VSS nmos W=0.31u L=0.04u
M7095 AND2_1313/net6 n1046 AND2_1313/X_u2-net6 VSS nmos W=0.31u L=0.04u
M7096 WX3852 AND2_1313/net6 VDD VDD pmos W=0.41u L=0.04u
M7097 AND2_1313/net6 RESET VDD VDD pmos W=0.41u L=0.04u
M7098 AND2_1313/net6 n1046 VDD VDD pmos W=0.41u L=0.04u
M7099 WX3850 AND2_1312/net6 VSS VSS nmos W=0.31u L=0.04u
M7100 AND2_1312/X_u2-net6 RESET VSS VSS nmos W=0.31u L=0.04u
M7101 AND2_1312/net6 n1047 AND2_1312/X_u2-net6 VSS nmos W=0.31u L=0.04u
M7102 WX3850 AND2_1312/net6 VDD VDD pmos W=0.41u L=0.04u
M7103 AND2_1312/net6 RESET VDD VDD pmos W=0.41u L=0.04u
M7104 AND2_1312/net6 n1047 VDD VDD pmos W=0.41u L=0.04u
M7105 WX3484 AND2_1247/net6 VSS VSS nmos W=0.31u L=0.04u
M7106 AND2_1247/X_u2-net6 RESET VSS VSS nmos W=0.31u L=0.04u
M7107 AND2_1247/net6 WX3421 AND2_1247/X_u2-net6 VSS nmos W=0.31u L=0.04u
M7108 WX3484 AND2_1247/net6 VDD VDD pmos W=0.41u L=0.04u
M7109 AND2_1247/net6 RESET VDD VDD pmos W=0.41u L=0.04u
M7110 AND2_1247/net6 WX3421 VDD VDD pmos W=0.41u L=0.04u
M7111 WX3482 AND2_1246/net6 VSS VSS nmos W=0.31u L=0.04u
M7112 AND2_1246/X_u2-net6 RESET VSS VSS nmos W=0.31u L=0.04u
M7113 AND2_1246/net6 WX3419 AND2_1246/X_u2-net6 VSS nmos W=0.31u L=0.04u
M7114 WX3482 AND2_1246/net6 VDD VDD pmos W=0.41u L=0.04u
M7115 AND2_1246/net6 RESET VDD VDD pmos W=0.41u L=0.04u
M7116 AND2_1246/net6 WX3419 VDD VDD pmos W=0.41u L=0.04u
M7117 WX3480 AND2_1245/net6 VSS VSS nmos W=0.31u L=0.04u
M7118 AND2_1245/X_u2-net6 RESET VSS VSS nmos W=0.31u L=0.04u
M7119 AND2_1245/net6 WX3417 AND2_1245/X_u2-net6 VSS nmos W=0.31u L=0.04u
M7120 WX3480 AND2_1245/net6 VDD VDD pmos W=0.41u L=0.04u
M7121 AND2_1245/net6 RESET VDD VDD pmos W=0.41u L=0.04u
M7122 AND2_1245/net6 WX3417 VDD VDD pmos W=0.41u L=0.04u
M7123 WX3478 AND2_1244/net6 VSS VSS nmos W=0.31u L=0.04u
M7124 AND2_1244/X_u2-net6 RESET VSS VSS nmos W=0.31u L=0.04u
M7125 AND2_1244/net6 WX3415 AND2_1244/X_u2-net6 VSS nmos W=0.31u L=0.04u
M7126 WX3478 AND2_1244/net6 VDD VDD pmos W=0.41u L=0.04u
M7127 AND2_1244/net6 RESET VDD VDD pmos W=0.41u L=0.04u
M7128 AND2_1244/net6 WX3415 VDD VDD pmos W=0.41u L=0.04u
M7129 WX3476 AND2_1243/net6 VSS VSS nmos W=0.31u L=0.04u
M7130 AND2_1243/X_u2-net6 RESET VSS VSS nmos W=0.31u L=0.04u
M7131 AND2_1243/net6 WX3413 AND2_1243/X_u2-net6 VSS nmos W=0.31u L=0.04u
M7132 WX3476 AND2_1243/net6 VDD VDD pmos W=0.41u L=0.04u
M7133 AND2_1243/net6 RESET VDD VDD pmos W=0.41u L=0.04u
M7134 AND2_1243/net6 WX3413 VDD VDD pmos W=0.41u L=0.04u
M7135 WX3474 AND2_1242/net6 VSS VSS nmos W=0.31u L=0.04u
M7136 AND2_1242/X_u2-net6 RESET VSS VSS nmos W=0.31u L=0.04u
M7137 AND2_1242/net6 WX3411 AND2_1242/X_u2-net6 VSS nmos W=0.31u L=0.04u
M7138 WX3474 AND2_1242/net6 VDD VDD pmos W=0.41u L=0.04u
M7139 AND2_1242/net6 RESET VDD VDD pmos W=0.41u L=0.04u
M7140 AND2_1242/net6 WX3411 VDD VDD pmos W=0.41u L=0.04u
M7141 WX3472 AND2_1241/net6 VSS VSS nmos W=0.31u L=0.04u
M7142 AND2_1241/X_u2-net6 RESET VSS VSS nmos W=0.31u L=0.04u
M7143 AND2_1241/net6 WX3409 AND2_1241/X_u2-net6 VSS nmos W=0.31u L=0.04u
M7144 WX3472 AND2_1241/net6 VDD VDD pmos W=0.41u L=0.04u
M7145 AND2_1241/net6 RESET VDD VDD pmos W=0.41u L=0.04u
M7146 AND2_1241/net6 WX3409 VDD VDD pmos W=0.41u L=0.04u
M7147 WX3470 AND2_1240/net6 VSS VSS nmos W=0.31u L=0.04u
M7148 AND2_1240/X_u2-net6 RESET VSS VSS nmos W=0.31u L=0.04u
M7149 AND2_1240/net6 WX3407 AND2_1240/X_u2-net6 VSS nmos W=0.31u L=0.04u
M7150 WX3470 AND2_1240/net6 VDD VDD pmos W=0.41u L=0.04u
M7151 AND2_1240/net6 RESET VDD VDD pmos W=0.41u L=0.04u
M7152 AND2_1240/net6 WX3407 VDD VDD pmos W=0.41u L=0.04u
M7153 WX3468 AND2_1239/net6 VSS VSS nmos W=0.31u L=0.04u
M7154 AND2_1239/X_u2-net6 RESET VSS VSS nmos W=0.31u L=0.04u
M7155 AND2_1239/net6 WX3405 AND2_1239/X_u2-net6 VSS nmos W=0.31u L=0.04u
M7156 WX3468 AND2_1239/net6 VDD VDD pmos W=0.41u L=0.04u
M7157 AND2_1239/net6 RESET VDD VDD pmos W=0.41u L=0.04u
M7158 AND2_1239/net6 WX3405 VDD VDD pmos W=0.41u L=0.04u
M7159 WX3466 AND2_1238/net6 VSS VSS nmos W=0.31u L=0.04u
M7160 AND2_1238/X_u2-net6 RESET VSS VSS nmos W=0.31u L=0.04u
M7161 AND2_1238/net6 WX3403 AND2_1238/X_u2-net6 VSS nmos W=0.31u L=0.04u
M7162 WX3466 AND2_1238/net6 VDD VDD pmos W=0.41u L=0.04u
M7163 AND2_1238/net6 RESET VDD VDD pmos W=0.41u L=0.04u
M7164 AND2_1238/net6 WX3403 VDD VDD pmos W=0.41u L=0.04u
M7165 WX3464 AND2_1237/net6 VSS VSS nmos W=0.31u L=0.04u
M7166 AND2_1237/X_u2-net6 RESET VSS VSS nmos W=0.31u L=0.04u
M7167 AND2_1237/net6 WX3401 AND2_1237/X_u2-net6 VSS nmos W=0.31u L=0.04u
M7168 WX3464 AND2_1237/net6 VDD VDD pmos W=0.41u L=0.04u
M7169 AND2_1237/net6 RESET VDD VDD pmos W=0.41u L=0.04u
M7170 AND2_1237/net6 WX3401 VDD VDD pmos W=0.41u L=0.04u
M7171 WX3462 AND2_1236/net6 VSS VSS nmos W=0.31u L=0.04u
M7172 AND2_1236/X_u2-net6 RESET VSS VSS nmos W=0.31u L=0.04u
M7173 AND2_1236/net6 WX3399 AND2_1236/X_u2-net6 VSS nmos W=0.31u L=0.04u
M7174 WX3462 AND2_1236/net6 VDD VDD pmos W=0.41u L=0.04u
M7175 AND2_1236/net6 RESET VDD VDD pmos W=0.41u L=0.04u
M7176 AND2_1236/net6 WX3399 VDD VDD pmos W=0.41u L=0.04u
M7177 WX3460 AND2_1235/net6 VSS VSS nmos W=0.31u L=0.04u
M7178 AND2_1235/X_u2-net6 RESET VSS VSS nmos W=0.31u L=0.04u
M7179 AND2_1235/net6 WX3397 AND2_1235/X_u2-net6 VSS nmos W=0.31u L=0.04u
M7180 WX3460 AND2_1235/net6 VDD VDD pmos W=0.41u L=0.04u
M7181 AND2_1235/net6 RESET VDD VDD pmos W=0.41u L=0.04u
M7182 AND2_1235/net6 WX3397 VDD VDD pmos W=0.41u L=0.04u
M7183 WX3458 AND2_1234/net6 VSS VSS nmos W=0.31u L=0.04u
M7184 AND2_1234/X_u2-net6 RESET VSS VSS nmos W=0.31u L=0.04u
M7185 AND2_1234/net6 WX3395 AND2_1234/X_u2-net6 VSS nmos W=0.31u L=0.04u
M7186 WX3458 AND2_1234/net6 VDD VDD pmos W=0.41u L=0.04u
M7187 AND2_1234/net6 RESET VDD VDD pmos W=0.41u L=0.04u
M7188 AND2_1234/net6 WX3395 VDD VDD pmos W=0.41u L=0.04u
M7189 WX3456 AND2_1233/net6 VSS VSS nmos W=0.31u L=0.04u
M7190 AND2_1233/X_u2-net6 RESET VSS VSS nmos W=0.31u L=0.04u
M7191 AND2_1233/net6 WX3393 AND2_1233/X_u2-net6 VSS nmos W=0.31u L=0.04u
M7192 WX3456 AND2_1233/net6 VDD VDD pmos W=0.41u L=0.04u
M7193 AND2_1233/net6 RESET VDD VDD pmos W=0.41u L=0.04u
M7194 AND2_1233/net6 WX3393 VDD VDD pmos W=0.41u L=0.04u
M7195 WX3454 AND2_1232/net6 VSS VSS nmos W=0.31u L=0.04u
M7196 AND2_1232/X_u2-net6 RESET VSS VSS nmos W=0.31u L=0.04u
M7197 AND2_1232/net6 WX3391 AND2_1232/X_u2-net6 VSS nmos W=0.31u L=0.04u
M7198 WX3454 AND2_1232/net6 VDD VDD pmos W=0.41u L=0.04u
M7199 AND2_1232/net6 RESET VDD VDD pmos W=0.41u L=0.04u
M7200 AND2_1232/net6 WX3391 VDD VDD pmos W=0.41u L=0.04u
M7201 WX3452 AND2_1231/net6 VSS VSS nmos W=0.31u L=0.04u
M7202 AND2_1231/X_u2-net6 RESET VSS VSS nmos W=0.31u L=0.04u
M7203 AND2_1231/net6 WX3389 AND2_1231/X_u2-net6 VSS nmos W=0.31u L=0.04u
M7204 WX3452 AND2_1231/net6 VDD VDD pmos W=0.41u L=0.04u
M7205 AND2_1231/net6 RESET VDD VDD pmos W=0.41u L=0.04u
M7206 AND2_1231/net6 WX3389 VDD VDD pmos W=0.41u L=0.04u
M7207 WX3450 AND2_1230/net6 VSS VSS nmos W=0.31u L=0.04u
M7208 AND2_1230/X_u2-net6 RESET VSS VSS nmos W=0.31u L=0.04u
M7209 AND2_1230/net6 WX3387 AND2_1230/X_u2-net6 VSS nmos W=0.31u L=0.04u
M7210 WX3450 AND2_1230/net6 VDD VDD pmos W=0.41u L=0.04u
M7211 AND2_1230/net6 RESET VDD VDD pmos W=0.41u L=0.04u
M7212 AND2_1230/net6 WX3387 VDD VDD pmos W=0.41u L=0.04u
M7213 WX3448 AND2_1229/net6 VSS VSS nmos W=0.31u L=0.04u
M7214 AND2_1229/X_u2-net6 RESET VSS VSS nmos W=0.31u L=0.04u
M7215 AND2_1229/net6 WX3385 AND2_1229/X_u2-net6 VSS nmos W=0.31u L=0.04u
M7216 WX3448 AND2_1229/net6 VDD VDD pmos W=0.41u L=0.04u
M7217 AND2_1229/net6 RESET VDD VDD pmos W=0.41u L=0.04u
M7218 AND2_1229/net6 WX3385 VDD VDD pmos W=0.41u L=0.04u
M7219 WX3446 AND2_1228/net6 VSS VSS nmos W=0.31u L=0.04u
M7220 AND2_1228/X_u2-net6 RESET VSS VSS nmos W=0.31u L=0.04u
M7221 AND2_1228/net6 WX3383 AND2_1228/X_u2-net6 VSS nmos W=0.31u L=0.04u
M7222 WX3446 AND2_1228/net6 VDD VDD pmos W=0.41u L=0.04u
M7223 AND2_1228/net6 RESET VDD VDD pmos W=0.41u L=0.04u
M7224 AND2_1228/net6 WX3383 VDD VDD pmos W=0.41u L=0.04u
M7225 WX3444 AND2_1227/net6 VSS VSS nmos W=0.31u L=0.04u
M7226 AND2_1227/X_u2-net6 RESET VSS VSS nmos W=0.31u L=0.04u
M7227 AND2_1227/net6 WX3381 AND2_1227/X_u2-net6 VSS nmos W=0.31u L=0.04u
M7228 WX3444 AND2_1227/net6 VDD VDD pmos W=0.41u L=0.04u
M7229 AND2_1227/net6 RESET VDD VDD pmos W=0.41u L=0.04u
M7230 AND2_1227/net6 WX3381 VDD VDD pmos W=0.41u L=0.04u
M7231 WX3442 AND2_1226/net6 VSS VSS nmos W=0.31u L=0.04u
M7232 AND2_1226/X_u2-net6 RESET VSS VSS nmos W=0.31u L=0.04u
M7233 AND2_1226/net6 WX3379 AND2_1226/X_u2-net6 VSS nmos W=0.31u L=0.04u
M7234 WX3442 AND2_1226/net6 VDD VDD pmos W=0.41u L=0.04u
M7235 AND2_1226/net6 RESET VDD VDD pmos W=0.41u L=0.04u
M7236 AND2_1226/net6 WX3379 VDD VDD pmos W=0.41u L=0.04u
M7237 WX3440 AND2_1225/net6 VSS VSS nmos W=0.31u L=0.04u
M7238 AND2_1225/X_u2-net6 RESET VSS VSS nmos W=0.31u L=0.04u
M7239 AND2_1225/net6 WX3377 AND2_1225/X_u2-net6 VSS nmos W=0.31u L=0.04u
M7240 WX3440 AND2_1225/net6 VDD VDD pmos W=0.41u L=0.04u
M7241 AND2_1225/net6 RESET VDD VDD pmos W=0.41u L=0.04u
M7242 AND2_1225/net6 WX3377 VDD VDD pmos W=0.41u L=0.04u
M7243 WX3438 AND2_1224/net6 VSS VSS nmos W=0.31u L=0.04u
M7244 AND2_1224/X_u2-net6 RESET VSS VSS nmos W=0.31u L=0.04u
M7245 AND2_1224/net6 WX3375 AND2_1224/X_u2-net6 VSS nmos W=0.31u L=0.04u
M7246 WX3438 AND2_1224/net6 VDD VDD pmos W=0.41u L=0.04u
M7247 AND2_1224/net6 RESET VDD VDD pmos W=0.41u L=0.04u
M7248 AND2_1224/net6 WX3375 VDD VDD pmos W=0.41u L=0.04u
M7249 WX3436 AND2_1223/net6 VSS VSS nmos W=0.31u L=0.04u
M7250 AND2_1223/X_u2-net6 RESET VSS VSS nmos W=0.31u L=0.04u
M7251 AND2_1223/net6 WX3373 AND2_1223/X_u2-net6 VSS nmos W=0.31u L=0.04u
M7252 WX3436 AND2_1223/net6 VDD VDD pmos W=0.41u L=0.04u
M7253 AND2_1223/net6 RESET VDD VDD pmos W=0.41u L=0.04u
M7254 AND2_1223/net6 WX3373 VDD VDD pmos W=0.41u L=0.04u
M7255 WX3434 AND2_1222/net6 VSS VSS nmos W=0.31u L=0.04u
M7256 AND2_1222/X_u2-net6 RESET VSS VSS nmos W=0.31u L=0.04u
M7257 AND2_1222/net6 WX3371 AND2_1222/X_u2-net6 VSS nmos W=0.31u L=0.04u
M7258 WX3434 AND2_1222/net6 VDD VDD pmos W=0.41u L=0.04u
M7259 AND2_1222/net6 RESET VDD VDD pmos W=0.41u L=0.04u
M7260 AND2_1222/net6 WX3371 VDD VDD pmos W=0.41u L=0.04u
M7261 WX3432 AND2_1221/net6 VSS VSS nmos W=0.31u L=0.04u
M7262 AND2_1221/X_u2-net6 RESET VSS VSS nmos W=0.31u L=0.04u
M7263 AND2_1221/net6 WX3369 AND2_1221/X_u2-net6 VSS nmos W=0.31u L=0.04u
M7264 WX3432 AND2_1221/net6 VDD VDD pmos W=0.41u L=0.04u
M7265 AND2_1221/net6 RESET VDD VDD pmos W=0.41u L=0.04u
M7266 AND2_1221/net6 WX3369 VDD VDD pmos W=0.41u L=0.04u
M7267 WX3430 AND2_1220/net6 VSS VSS nmos W=0.31u L=0.04u
M7268 AND2_1220/X_u2-net6 RESET VSS VSS nmos W=0.31u L=0.04u
M7269 AND2_1220/net6 WX3367 AND2_1220/X_u2-net6 VSS nmos W=0.31u L=0.04u
M7270 WX3430 AND2_1220/net6 VDD VDD pmos W=0.41u L=0.04u
M7271 AND2_1220/net6 RESET VDD VDD pmos W=0.41u L=0.04u
M7272 AND2_1220/net6 WX3367 VDD VDD pmos W=0.41u L=0.04u
M7273 WX3428 AND2_1219/net6 VSS VSS nmos W=0.31u L=0.04u
M7274 AND2_1219/X_u2-net6 RESET VSS VSS nmos W=0.31u L=0.04u
M7275 AND2_1219/net6 WX3365 AND2_1219/X_u2-net6 VSS nmos W=0.31u L=0.04u
M7276 WX3428 AND2_1219/net6 VDD VDD pmos W=0.41u L=0.04u
M7277 AND2_1219/net6 RESET VDD VDD pmos W=0.41u L=0.04u
M7278 AND2_1219/net6 WX3365 VDD VDD pmos W=0.41u L=0.04u
M7279 WX3426 AND2_1218/net6 VSS VSS nmos W=0.31u L=0.04u
M7280 AND2_1218/X_u2-net6 RESET VSS VSS nmos W=0.31u L=0.04u
M7281 AND2_1218/net6 WX3363 AND2_1218/X_u2-net6 VSS nmos W=0.31u L=0.04u
M7282 WX3426 AND2_1218/net6 VDD VDD pmos W=0.41u L=0.04u
M7283 AND2_1218/net6 RESET VDD VDD pmos W=0.41u L=0.04u
M7284 AND2_1218/net6 WX3363 VDD VDD pmos W=0.41u L=0.04u
M7285 WX3424 AND2_1217/net6 VSS VSS nmos W=0.31u L=0.04u
M7286 AND2_1217/X_u2-net6 RESET VSS VSS nmos W=0.31u L=0.04u
M7287 AND2_1217/net6 WX3361 AND2_1217/X_u2-net6 VSS nmos W=0.31u L=0.04u
M7288 WX3424 AND2_1217/net6 VDD VDD pmos W=0.41u L=0.04u
M7289 AND2_1217/net6 RESET VDD VDD pmos W=0.41u L=0.04u
M7290 AND2_1217/net6 WX3361 VDD VDD pmos W=0.41u L=0.04u
M7291 WX3422 AND2_1216/net6 VSS VSS nmos W=0.31u L=0.04u
M7292 AND2_1216/X_u2-net6 RESET VSS VSS nmos W=0.31u L=0.04u
M7293 AND2_1216/net6 WX3359 AND2_1216/X_u2-net6 VSS nmos W=0.31u L=0.04u
M7294 WX3422 AND2_1216/net6 VDD VDD pmos W=0.41u L=0.04u
M7295 AND2_1216/net6 RESET VDD VDD pmos W=0.41u L=0.04u
M7296 AND2_1216/net6 WX3359 VDD VDD pmos W=0.41u L=0.04u
M7297 WX3420 AND2_1215/net6 VSS VSS nmos W=0.31u L=0.04u
M7298 AND2_1215/X_u2-net6 RESET VSS VSS nmos W=0.31u L=0.04u
M7299 AND2_1215/net6 WX3357 AND2_1215/X_u2-net6 VSS nmos W=0.31u L=0.04u
M7300 WX3420 AND2_1215/net6 VDD VDD pmos W=0.41u L=0.04u
M7301 AND2_1215/net6 RESET VDD VDD pmos W=0.41u L=0.04u
M7302 AND2_1215/net6 WX3357 VDD VDD pmos W=0.41u L=0.04u
M7303 WX3418 AND2_1214/net6 VSS VSS nmos W=0.31u L=0.04u
M7304 AND2_1214/X_u2-net6 RESET VSS VSS nmos W=0.31u L=0.04u
M7305 AND2_1214/net6 WX3355 AND2_1214/X_u2-net6 VSS nmos W=0.31u L=0.04u
M7306 WX3418 AND2_1214/net6 VDD VDD pmos W=0.41u L=0.04u
M7307 AND2_1214/net6 RESET VDD VDD pmos W=0.41u L=0.04u
M7308 AND2_1214/net6 WX3355 VDD VDD pmos W=0.41u L=0.04u
M7309 WX3416 AND2_1213/net6 VSS VSS nmos W=0.31u L=0.04u
M7310 AND2_1213/X_u2-net6 RESET VSS VSS nmos W=0.31u L=0.04u
M7311 AND2_1213/net6 WX3353 AND2_1213/X_u2-net6 VSS nmos W=0.31u L=0.04u
M7312 WX3416 AND2_1213/net6 VDD VDD pmos W=0.41u L=0.04u
M7313 AND2_1213/net6 RESET VDD VDD pmos W=0.41u L=0.04u
M7314 AND2_1213/net6 WX3353 VDD VDD pmos W=0.41u L=0.04u
M7315 WX3414 AND2_1212/net6 VSS VSS nmos W=0.31u L=0.04u
M7316 AND2_1212/X_u2-net6 RESET VSS VSS nmos W=0.31u L=0.04u
M7317 AND2_1212/net6 WX3351 AND2_1212/X_u2-net6 VSS nmos W=0.31u L=0.04u
M7318 WX3414 AND2_1212/net6 VDD VDD pmos W=0.41u L=0.04u
M7319 AND2_1212/net6 RESET VDD VDD pmos W=0.41u L=0.04u
M7320 AND2_1212/net6 WX3351 VDD VDD pmos W=0.41u L=0.04u
M7321 WX3412 AND2_1211/net6 VSS VSS nmos W=0.31u L=0.04u
M7322 AND2_1211/X_u2-net6 RESET VSS VSS nmos W=0.31u L=0.04u
M7323 AND2_1211/net6 WX3349 AND2_1211/X_u2-net6 VSS nmos W=0.31u L=0.04u
M7324 WX3412 AND2_1211/net6 VDD VDD pmos W=0.41u L=0.04u
M7325 AND2_1211/net6 RESET VDD VDD pmos W=0.41u L=0.04u
M7326 AND2_1211/net6 WX3349 VDD VDD pmos W=0.41u L=0.04u
M7327 WX3410 AND2_1210/net6 VSS VSS nmos W=0.31u L=0.04u
M7328 AND2_1210/X_u2-net6 RESET VSS VSS nmos W=0.31u L=0.04u
M7329 AND2_1210/net6 WX3347 AND2_1210/X_u2-net6 VSS nmos W=0.31u L=0.04u
M7330 WX3410 AND2_1210/net6 VDD VDD pmos W=0.41u L=0.04u
M7331 AND2_1210/net6 RESET VDD VDD pmos W=0.41u L=0.04u
M7332 AND2_1210/net6 WX3347 VDD VDD pmos W=0.41u L=0.04u
M7333 WX3408 AND2_1209/net6 VSS VSS nmos W=0.31u L=0.04u
M7334 AND2_1209/X_u2-net6 RESET VSS VSS nmos W=0.31u L=0.04u
M7335 AND2_1209/net6 WX3345 AND2_1209/X_u2-net6 VSS nmos W=0.31u L=0.04u
M7336 WX3408 AND2_1209/net6 VDD VDD pmos W=0.41u L=0.04u
M7337 AND2_1209/net6 RESET VDD VDD pmos W=0.41u L=0.04u
M7338 AND2_1209/net6 WX3345 VDD VDD pmos W=0.41u L=0.04u
M7339 WX3406 AND2_1208/net6 VSS VSS nmos W=0.31u L=0.04u
M7340 AND2_1208/X_u2-net6 RESET VSS VSS nmos W=0.31u L=0.04u
M7341 AND2_1208/net6 WX3343 AND2_1208/X_u2-net6 VSS nmos W=0.31u L=0.04u
M7342 WX3406 AND2_1208/net6 VDD VDD pmos W=0.41u L=0.04u
M7343 AND2_1208/net6 RESET VDD VDD pmos W=0.41u L=0.04u
M7344 AND2_1208/net6 WX3343 VDD VDD pmos W=0.41u L=0.04u
M7345 WX3404 AND2_1207/net6 VSS VSS nmos W=0.31u L=0.04u
M7346 AND2_1207/X_u2-net6 RESET VSS VSS nmos W=0.31u L=0.04u
M7347 AND2_1207/net6 WX3341 AND2_1207/X_u2-net6 VSS nmos W=0.31u L=0.04u
M7348 WX3404 AND2_1207/net6 VDD VDD pmos W=0.41u L=0.04u
M7349 AND2_1207/net6 RESET VDD VDD pmos W=0.41u L=0.04u
M7350 AND2_1207/net6 WX3341 VDD VDD pmos W=0.41u L=0.04u
M7351 WX3402 AND2_1206/net6 VSS VSS nmos W=0.31u L=0.04u
M7352 AND2_1206/X_u2-net6 RESET VSS VSS nmos W=0.31u L=0.04u
M7353 AND2_1206/net6 WX3339 AND2_1206/X_u2-net6 VSS nmos W=0.31u L=0.04u
M7354 WX3402 AND2_1206/net6 VDD VDD pmos W=0.41u L=0.04u
M7355 AND2_1206/net6 RESET VDD VDD pmos W=0.41u L=0.04u
M7356 AND2_1206/net6 WX3339 VDD VDD pmos W=0.41u L=0.04u
M7357 WX3400 AND2_1205/net6 VSS VSS nmos W=0.31u L=0.04u
M7358 AND2_1205/X_u2-net6 RESET VSS VSS nmos W=0.31u L=0.04u
M7359 AND2_1205/net6 WX3337 AND2_1205/X_u2-net6 VSS nmos W=0.31u L=0.04u
M7360 WX3400 AND2_1205/net6 VDD VDD pmos W=0.41u L=0.04u
M7361 AND2_1205/net6 RESET VDD VDD pmos W=0.41u L=0.04u
M7362 AND2_1205/net6 WX3337 VDD VDD pmos W=0.41u L=0.04u
M7363 WX3398 AND2_1204/net6 VSS VSS nmos W=0.31u L=0.04u
M7364 AND2_1204/X_u2-net6 RESET VSS VSS nmos W=0.31u L=0.04u
M7365 AND2_1204/net6 WX3335 AND2_1204/X_u2-net6 VSS nmos W=0.31u L=0.04u
M7366 WX3398 AND2_1204/net6 VDD VDD pmos W=0.41u L=0.04u
M7367 AND2_1204/net6 RESET VDD VDD pmos W=0.41u L=0.04u
M7368 AND2_1204/net6 WX3335 VDD VDD pmos W=0.41u L=0.04u
M7369 WX3396 AND2_1203/net6 VSS VSS nmos W=0.31u L=0.04u
M7370 AND2_1203/X_u2-net6 RESET VSS VSS nmos W=0.31u L=0.04u
M7371 AND2_1203/net6 WX3333 AND2_1203/X_u2-net6 VSS nmos W=0.31u L=0.04u
M7372 WX3396 AND2_1203/net6 VDD VDD pmos W=0.41u L=0.04u
M7373 AND2_1203/net6 RESET VDD VDD pmos W=0.41u L=0.04u
M7374 AND2_1203/net6 WX3333 VDD VDD pmos W=0.41u L=0.04u
M7375 WX3394 AND2_1202/net6 VSS VSS nmos W=0.31u L=0.04u
M7376 AND2_1202/X_u2-net6 RESET VSS VSS nmos W=0.31u L=0.04u
M7377 AND2_1202/net6 WX3331 AND2_1202/X_u2-net6 VSS nmos W=0.31u L=0.04u
M7378 WX3394 AND2_1202/net6 VDD VDD pmos W=0.41u L=0.04u
M7379 AND2_1202/net6 RESET VDD VDD pmos W=0.41u L=0.04u
M7380 AND2_1202/net6 WX3331 VDD VDD pmos W=0.41u L=0.04u
M7381 WX3392 AND2_1201/net6 VSS VSS nmos W=0.31u L=0.04u
M7382 AND2_1201/X_u2-net6 RESET VSS VSS nmos W=0.31u L=0.04u
M7383 AND2_1201/net6 WX3329 AND2_1201/X_u2-net6 VSS nmos W=0.31u L=0.04u
M7384 WX3392 AND2_1201/net6 VDD VDD pmos W=0.41u L=0.04u
M7385 AND2_1201/net6 RESET VDD VDD pmos W=0.41u L=0.04u
M7386 AND2_1201/net6 WX3329 VDD VDD pmos W=0.41u L=0.04u
M7387 WX3390 AND2_1200/net6 VSS VSS nmos W=0.31u L=0.04u
M7388 AND2_1200/X_u2-net6 RESET VSS VSS nmos W=0.31u L=0.04u
M7389 AND2_1200/net6 WX3327 AND2_1200/X_u2-net6 VSS nmos W=0.31u L=0.04u
M7390 WX3390 AND2_1200/net6 VDD VDD pmos W=0.41u L=0.04u
M7391 AND2_1200/net6 RESET VDD VDD pmos W=0.41u L=0.04u
M7392 AND2_1200/net6 WX3327 VDD VDD pmos W=0.41u L=0.04u
M7393 WX3388 AND2_1199/net6 VSS VSS nmos W=0.31u L=0.04u
M7394 AND2_1199/X_u2-net6 RESET VSS VSS nmos W=0.31u L=0.04u
M7395 AND2_1199/net6 WX3325 AND2_1199/X_u2-net6 VSS nmos W=0.31u L=0.04u
M7396 WX3388 AND2_1199/net6 VDD VDD pmos W=0.41u L=0.04u
M7397 AND2_1199/net6 RESET VDD VDD pmos W=0.41u L=0.04u
M7398 AND2_1199/net6 WX3325 VDD VDD pmos W=0.41u L=0.04u
M7399 WX3386 AND2_1198/net6 VSS VSS nmos W=0.31u L=0.04u
M7400 AND2_1198/X_u2-net6 RESET VSS VSS nmos W=0.31u L=0.04u
M7401 AND2_1198/net6 WX3323 AND2_1198/X_u2-net6 VSS nmos W=0.31u L=0.04u
M7402 WX3386 AND2_1198/net6 VDD VDD pmos W=0.41u L=0.04u
M7403 AND2_1198/net6 RESET VDD VDD pmos W=0.41u L=0.04u
M7404 AND2_1198/net6 WX3323 VDD VDD pmos W=0.41u L=0.04u
M7405 WX3384 AND2_1197/net6 VSS VSS nmos W=0.31u L=0.04u
M7406 AND2_1197/X_u2-net6 RESET VSS VSS nmos W=0.31u L=0.04u
M7407 AND2_1197/net6 WX3321 AND2_1197/X_u2-net6 VSS nmos W=0.31u L=0.04u
M7408 WX3384 AND2_1197/net6 VDD VDD pmos W=0.41u L=0.04u
M7409 AND2_1197/net6 RESET VDD VDD pmos W=0.41u L=0.04u
M7410 AND2_1197/net6 WX3321 VDD VDD pmos W=0.41u L=0.04u
M7411 WX3382 AND2_1196/net6 VSS VSS nmos W=0.31u L=0.04u
M7412 AND2_1196/X_u2-net6 RESET VSS VSS nmos W=0.31u L=0.04u
M7413 AND2_1196/net6 WX3319 AND2_1196/X_u2-net6 VSS nmos W=0.31u L=0.04u
M7414 WX3382 AND2_1196/net6 VDD VDD pmos W=0.41u L=0.04u
M7415 AND2_1196/net6 RESET VDD VDD pmos W=0.41u L=0.04u
M7416 AND2_1196/net6 WX3319 VDD VDD pmos W=0.41u L=0.04u
M7417 WX3380 AND2_1195/net6 VSS VSS nmos W=0.31u L=0.04u
M7418 AND2_1195/X_u2-net6 RESET VSS VSS nmos W=0.31u L=0.04u
M7419 AND2_1195/net6 WX3317 AND2_1195/X_u2-net6 VSS nmos W=0.31u L=0.04u
M7420 WX3380 AND2_1195/net6 VDD VDD pmos W=0.41u L=0.04u
M7421 AND2_1195/net6 RESET VDD VDD pmos W=0.41u L=0.04u
M7422 AND2_1195/net6 WX3317 VDD VDD pmos W=0.41u L=0.04u
M7423 WX3378 AND2_1194/net6 VSS VSS nmos W=0.31u L=0.04u
M7424 AND2_1194/X_u2-net6 RESET VSS VSS nmos W=0.31u L=0.04u
M7425 AND2_1194/net6 WX3315 AND2_1194/X_u2-net6 VSS nmos W=0.31u L=0.04u
M7426 WX3378 AND2_1194/net6 VDD VDD pmos W=0.41u L=0.04u
M7427 AND2_1194/net6 RESET VDD VDD pmos W=0.41u L=0.04u
M7428 AND2_1194/net6 WX3315 VDD VDD pmos W=0.41u L=0.04u
M7429 WX3376 AND2_1193/net6 VSS VSS nmos W=0.31u L=0.04u
M7430 AND2_1193/X_u2-net6 RESET VSS VSS nmos W=0.31u L=0.04u
M7431 AND2_1193/net6 WX3313 AND2_1193/X_u2-net6 VSS nmos W=0.31u L=0.04u
M7432 WX3376 AND2_1193/net6 VDD VDD pmos W=0.41u L=0.04u
M7433 AND2_1193/net6 RESET VDD VDD pmos W=0.41u L=0.04u
M7434 AND2_1193/net6 WX3313 VDD VDD pmos W=0.41u L=0.04u
M7435 WX3374 AND2_1192/net6 VSS VSS nmos W=0.31u L=0.04u
M7436 AND2_1192/X_u2-net6 RESET VSS VSS nmos W=0.31u L=0.04u
M7437 AND2_1192/net6 WX3311 AND2_1192/X_u2-net6 VSS nmos W=0.31u L=0.04u
M7438 WX3374 AND2_1192/net6 VDD VDD pmos W=0.41u L=0.04u
M7439 AND2_1192/net6 RESET VDD VDD pmos W=0.41u L=0.04u
M7440 AND2_1192/net6 WX3311 VDD VDD pmos W=0.41u L=0.04u
M7441 WX3372 AND2_1191/net6 VSS VSS nmos W=0.31u L=0.04u
M7442 AND2_1191/X_u2-net6 RESET VSS VSS nmos W=0.31u L=0.04u
M7443 AND2_1191/net6 WX3309 AND2_1191/X_u2-net6 VSS nmos W=0.31u L=0.04u
M7444 WX3372 AND2_1191/net6 VDD VDD pmos W=0.41u L=0.04u
M7445 AND2_1191/net6 RESET VDD VDD pmos W=0.41u L=0.04u
M7446 AND2_1191/net6 WX3309 VDD VDD pmos W=0.41u L=0.04u
M7447 WX3370 AND2_1190/net6 VSS VSS nmos W=0.31u L=0.04u
M7448 AND2_1190/X_u2-net6 RESET VSS VSS nmos W=0.31u L=0.04u
M7449 AND2_1190/net6 WX3307 AND2_1190/X_u2-net6 VSS nmos W=0.31u L=0.04u
M7450 WX3370 AND2_1190/net6 VDD VDD pmos W=0.41u L=0.04u
M7451 AND2_1190/net6 RESET VDD VDD pmos W=0.41u L=0.04u
M7452 AND2_1190/net6 WX3307 VDD VDD pmos W=0.41u L=0.04u
M7453 WX3368 AND2_1189/net6 VSS VSS nmos W=0.31u L=0.04u
M7454 AND2_1189/X_u2-net6 RESET VSS VSS nmos W=0.31u L=0.04u
M7455 AND2_1189/net6 WX3305 AND2_1189/X_u2-net6 VSS nmos W=0.31u L=0.04u
M7456 WX3368 AND2_1189/net6 VDD VDD pmos W=0.41u L=0.04u
M7457 AND2_1189/net6 RESET VDD VDD pmos W=0.41u L=0.04u
M7458 AND2_1189/net6 WX3305 VDD VDD pmos W=0.41u L=0.04u
M7459 WX3366 AND2_1188/net6 VSS VSS nmos W=0.31u L=0.04u
M7460 AND2_1188/X_u2-net6 RESET VSS VSS nmos W=0.31u L=0.04u
M7461 AND2_1188/net6 WX3303 AND2_1188/X_u2-net6 VSS nmos W=0.31u L=0.04u
M7462 WX3366 AND2_1188/net6 VDD VDD pmos W=0.41u L=0.04u
M7463 AND2_1188/net6 RESET VDD VDD pmos W=0.41u L=0.04u
M7464 AND2_1188/net6 WX3303 VDD VDD pmos W=0.41u L=0.04u
M7465 WX3364 AND2_1187/net6 VSS VSS nmos W=0.31u L=0.04u
M7466 AND2_1187/X_u2-net6 RESET VSS VSS nmos W=0.31u L=0.04u
M7467 AND2_1187/net6 WX3301 AND2_1187/X_u2-net6 VSS nmos W=0.31u L=0.04u
M7468 WX3364 AND2_1187/net6 VDD VDD pmos W=0.41u L=0.04u
M7469 AND2_1187/net6 RESET VDD VDD pmos W=0.41u L=0.04u
M7470 AND2_1187/net6 WX3301 VDD VDD pmos W=0.41u L=0.04u
M7471 WX3362 AND2_1186/net6 VSS VSS nmos W=0.31u L=0.04u
M7472 AND2_1186/X_u2-net6 RESET VSS VSS nmos W=0.31u L=0.04u
M7473 AND2_1186/net6 WX3299 AND2_1186/X_u2-net6 VSS nmos W=0.31u L=0.04u
M7474 WX3362 AND2_1186/net6 VDD VDD pmos W=0.41u L=0.04u
M7475 AND2_1186/net6 RESET VDD VDD pmos W=0.41u L=0.04u
M7476 AND2_1186/net6 WX3299 VDD VDD pmos W=0.41u L=0.04u
M7477 WX3360 AND2_1185/net6 VSS VSS nmos W=0.31u L=0.04u
M7478 AND2_1185/X_u2-net6 RESET VSS VSS nmos W=0.31u L=0.04u
M7479 AND2_1185/net6 WX3297 AND2_1185/X_u2-net6 VSS nmos W=0.31u L=0.04u
M7480 WX3360 AND2_1185/net6 VDD VDD pmos W=0.41u L=0.04u
M7481 AND2_1185/net6 RESET VDD VDD pmos W=0.41u L=0.04u
M7482 AND2_1185/net6 WX3297 VDD VDD pmos W=0.41u L=0.04u
M7483 WX3358 AND2_1184/net6 VSS VSS nmos W=0.31u L=0.04u
M7484 AND2_1184/X_u2-net6 RESET VSS VSS nmos W=0.31u L=0.04u
M7485 AND2_1184/net6 WX3295 AND2_1184/X_u2-net6 VSS nmos W=0.31u L=0.04u
M7486 WX3358 AND2_1184/net6 VDD VDD pmos W=0.41u L=0.04u
M7487 AND2_1184/net6 RESET VDD VDD pmos W=0.41u L=0.04u
M7488 AND2_1184/net6 WX3295 VDD VDD pmos W=0.41u L=0.04u
M7489 WX3356 AND2_1183/net6 VSS VSS nmos W=0.31u L=0.04u
M7490 AND2_1183/X_u2-net6 RESET VSS VSS nmos W=0.31u L=0.04u
M7491 AND2_1183/net6 WX3293 AND2_1183/X_u2-net6 VSS nmos W=0.31u L=0.04u
M7492 WX3356 AND2_1183/net6 VDD VDD pmos W=0.41u L=0.04u
M7493 AND2_1183/net6 RESET VDD VDD pmos W=0.41u L=0.04u
M7494 AND2_1183/net6 WX3293 VDD VDD pmos W=0.41u L=0.04u
M7495 WX3354 AND2_1182/net6 VSS VSS nmos W=0.31u L=0.04u
M7496 AND2_1182/X_u2-net6 RESET VSS VSS nmos W=0.31u L=0.04u
M7497 AND2_1182/net6 WX3291 AND2_1182/X_u2-net6 VSS nmos W=0.31u L=0.04u
M7498 WX3354 AND2_1182/net6 VDD VDD pmos W=0.41u L=0.04u
M7499 AND2_1182/net6 RESET VDD VDD pmos W=0.41u L=0.04u
M7500 AND2_1182/net6 WX3291 VDD VDD pmos W=0.41u L=0.04u
M7501 WX3352 AND2_1181/net6 VSS VSS nmos W=0.31u L=0.04u
M7502 AND2_1181/X_u2-net6 RESET VSS VSS nmos W=0.31u L=0.04u
M7503 AND2_1181/net6 WX3289 AND2_1181/X_u2-net6 VSS nmos W=0.31u L=0.04u
M7504 WX3352 AND2_1181/net6 VDD VDD pmos W=0.41u L=0.04u
M7505 AND2_1181/net6 RESET VDD VDD pmos W=0.41u L=0.04u
M7506 AND2_1181/net6 WX3289 VDD VDD pmos W=0.41u L=0.04u
M7507 WX3350 AND2_1180/net6 VSS VSS nmos W=0.31u L=0.04u
M7508 AND2_1180/X_u2-net6 RESET VSS VSS nmos W=0.31u L=0.04u
M7509 AND2_1180/net6 WX3287 AND2_1180/X_u2-net6 VSS nmos W=0.31u L=0.04u
M7510 WX3350 AND2_1180/net6 VDD VDD pmos W=0.41u L=0.04u
M7511 AND2_1180/net6 RESET VDD VDD pmos W=0.41u L=0.04u
M7512 AND2_1180/net6 WX3287 VDD VDD pmos W=0.41u L=0.04u
M7513 WX3348 AND2_1179/net6 VSS VSS nmos W=0.31u L=0.04u
M7514 AND2_1179/X_u2-net6 RESET VSS VSS nmos W=0.31u L=0.04u
M7515 AND2_1179/net6 WX3285 AND2_1179/X_u2-net6 VSS nmos W=0.31u L=0.04u
M7516 WX3348 AND2_1179/net6 VDD VDD pmos W=0.41u L=0.04u
M7517 AND2_1179/net6 RESET VDD VDD pmos W=0.41u L=0.04u
M7518 AND2_1179/net6 WX3285 VDD VDD pmos W=0.41u L=0.04u
M7519 WX3346 AND2_1178/net6 VSS VSS nmos W=0.31u L=0.04u
M7520 AND2_1178/X_u2-net6 RESET VSS VSS nmos W=0.31u L=0.04u
M7521 AND2_1178/net6 WX3283 AND2_1178/X_u2-net6 VSS nmos W=0.31u L=0.04u
M7522 WX3346 AND2_1178/net6 VDD VDD pmos W=0.41u L=0.04u
M7523 AND2_1178/net6 RESET VDD VDD pmos W=0.41u L=0.04u
M7524 AND2_1178/net6 WX3283 VDD VDD pmos W=0.41u L=0.04u
M7525 WX3344 AND2_1177/net6 VSS VSS nmos W=0.31u L=0.04u
M7526 AND2_1177/X_u2-net6 RESET VSS VSS nmos W=0.31u L=0.04u
M7527 AND2_1177/net6 WX3281 AND2_1177/X_u2-net6 VSS nmos W=0.31u L=0.04u
M7528 WX3344 AND2_1177/net6 VDD VDD pmos W=0.41u L=0.04u
M7529 AND2_1177/net6 RESET VDD VDD pmos W=0.41u L=0.04u
M7530 AND2_1177/net6 WX3281 VDD VDD pmos W=0.41u L=0.04u
M7531 WX3342 AND2_1176/net6 VSS VSS nmos W=0.31u L=0.04u
M7532 AND2_1176/X_u2-net6 RESET VSS VSS nmos W=0.31u L=0.04u
M7533 AND2_1176/net6 WX3279 AND2_1176/X_u2-net6 VSS nmos W=0.31u L=0.04u
M7534 WX3342 AND2_1176/net6 VDD VDD pmos W=0.41u L=0.04u
M7535 AND2_1176/net6 RESET VDD VDD pmos W=0.41u L=0.04u
M7536 AND2_1176/net6 WX3279 VDD VDD pmos W=0.41u L=0.04u
M7537 WX3340 AND2_1175/net6 VSS VSS nmos W=0.31u L=0.04u
M7538 AND2_1175/X_u2-net6 RESET VSS VSS nmos W=0.31u L=0.04u
M7539 AND2_1175/net6 WX3277 AND2_1175/X_u2-net6 VSS nmos W=0.31u L=0.04u
M7540 WX3340 AND2_1175/net6 VDD VDD pmos W=0.41u L=0.04u
M7541 AND2_1175/net6 RESET VDD VDD pmos W=0.41u L=0.04u
M7542 AND2_1175/net6 WX3277 VDD VDD pmos W=0.41u L=0.04u
M7543 WX3338 AND2_1174/net6 VSS VSS nmos W=0.31u L=0.04u
M7544 AND2_1174/X_u2-net6 RESET VSS VSS nmos W=0.31u L=0.04u
M7545 AND2_1174/net6 WX3275 AND2_1174/X_u2-net6 VSS nmos W=0.31u L=0.04u
M7546 WX3338 AND2_1174/net6 VDD VDD pmos W=0.41u L=0.04u
M7547 AND2_1174/net6 RESET VDD VDD pmos W=0.41u L=0.04u
M7548 AND2_1174/net6 WX3275 VDD VDD pmos W=0.41u L=0.04u
M7549 WX3336 AND2_1173/net6 VSS VSS nmos W=0.31u L=0.04u
M7550 AND2_1173/X_u2-net6 RESET VSS VSS nmos W=0.31u L=0.04u
M7551 AND2_1173/net6 WX3273 AND2_1173/X_u2-net6 VSS nmos W=0.31u L=0.04u
M7552 WX3336 AND2_1173/net6 VDD VDD pmos W=0.41u L=0.04u
M7553 AND2_1173/net6 RESET VDD VDD pmos W=0.41u L=0.04u
M7554 AND2_1173/net6 WX3273 VDD VDD pmos W=0.41u L=0.04u
M7555 WX3334 AND2_1172/net6 VSS VSS nmos W=0.31u L=0.04u
M7556 AND2_1172/X_u2-net6 RESET VSS VSS nmos W=0.31u L=0.04u
M7557 AND2_1172/net6 WX3271 AND2_1172/X_u2-net6 VSS nmos W=0.31u L=0.04u
M7558 WX3334 AND2_1172/net6 VDD VDD pmos W=0.41u L=0.04u
M7559 AND2_1172/net6 RESET VDD VDD pmos W=0.41u L=0.04u
M7560 AND2_1172/net6 WX3271 VDD VDD pmos W=0.41u L=0.04u
M7561 WX3332 AND2_1171/net6 VSS VSS nmos W=0.31u L=0.04u
M7562 AND2_1171/X_u2-net6 RESET VSS VSS nmos W=0.31u L=0.04u
M7563 AND2_1171/net6 WX3269 AND2_1171/X_u2-net6 VSS nmos W=0.31u L=0.04u
M7564 WX3332 AND2_1171/net6 VDD VDD pmos W=0.41u L=0.04u
M7565 AND2_1171/net6 RESET VDD VDD pmos W=0.41u L=0.04u
M7566 AND2_1171/net6 WX3269 VDD VDD pmos W=0.41u L=0.04u
M7567 WX3330 AND2_1170/net6 VSS VSS nmos W=0.31u L=0.04u
M7568 AND2_1170/X_u2-net6 RESET VSS VSS nmos W=0.31u L=0.04u
M7569 AND2_1170/net6 WX3267 AND2_1170/X_u2-net6 VSS nmos W=0.31u L=0.04u
M7570 WX3330 AND2_1170/net6 VDD VDD pmos W=0.41u L=0.04u
M7571 AND2_1170/net6 RESET VDD VDD pmos W=0.41u L=0.04u
M7572 AND2_1170/net6 WX3267 VDD VDD pmos W=0.41u L=0.04u
M7573 WX3328 AND2_1169/net6 VSS VSS nmos W=0.31u L=0.04u
M7574 AND2_1169/X_u2-net6 RESET VSS VSS nmos W=0.31u L=0.04u
M7575 AND2_1169/net6 WX3265 AND2_1169/X_u2-net6 VSS nmos W=0.31u L=0.04u
M7576 WX3328 AND2_1169/net6 VDD VDD pmos W=0.41u L=0.04u
M7577 AND2_1169/net6 RESET VDD VDD pmos W=0.41u L=0.04u
M7578 AND2_1169/net6 WX3265 VDD VDD pmos W=0.41u L=0.04u
M7579 WX3326 AND2_1168/net6 VSS VSS nmos W=0.31u L=0.04u
M7580 AND2_1168/X_u2-net6 RESET VSS VSS nmos W=0.31u L=0.04u
M7581 AND2_1168/net6 WX3263 AND2_1168/X_u2-net6 VSS nmos W=0.31u L=0.04u
M7582 WX3326 AND2_1168/net6 VDD VDD pmos W=0.41u L=0.04u
M7583 AND2_1168/net6 RESET VDD VDD pmos W=0.41u L=0.04u
M7584 AND2_1168/net6 WX3263 VDD VDD pmos W=0.41u L=0.04u
M7585 WX3324 AND2_1167/net6 VSS VSS nmos W=0.31u L=0.04u
M7586 AND2_1167/X_u2-net6 RESET VSS VSS nmos W=0.31u L=0.04u
M7587 AND2_1167/net6 WX3261 AND2_1167/X_u2-net6 VSS nmos W=0.31u L=0.04u
M7588 WX3324 AND2_1167/net6 VDD VDD pmos W=0.41u L=0.04u
M7589 AND2_1167/net6 RESET VDD VDD pmos W=0.41u L=0.04u
M7590 AND2_1167/net6 WX3261 VDD VDD pmos W=0.41u L=0.04u
M7591 WX3322 AND2_1166/net6 VSS VSS nmos W=0.31u L=0.04u
M7592 AND2_1166/X_u2-net6 RESET VSS VSS nmos W=0.31u L=0.04u
M7593 AND2_1166/net6 WX3259 AND2_1166/X_u2-net6 VSS nmos W=0.31u L=0.04u
M7594 WX3322 AND2_1166/net6 VDD VDD pmos W=0.41u L=0.04u
M7595 AND2_1166/net6 RESET VDD VDD pmos W=0.41u L=0.04u
M7596 AND2_1166/net6 WX3259 VDD VDD pmos W=0.41u L=0.04u
M7597 WX3320 AND2_1165/net6 VSS VSS nmos W=0.31u L=0.04u
M7598 AND2_1165/X_u2-net6 RESET VSS VSS nmos W=0.31u L=0.04u
M7599 AND2_1165/net6 WX3257 AND2_1165/X_u2-net6 VSS nmos W=0.31u L=0.04u
M7600 WX3320 AND2_1165/net6 VDD VDD pmos W=0.41u L=0.04u
M7601 AND2_1165/net6 RESET VDD VDD pmos W=0.41u L=0.04u
M7602 AND2_1165/net6 WX3257 VDD VDD pmos W=0.41u L=0.04u
M7603 WX3318 AND2_1164/net6 VSS VSS nmos W=0.31u L=0.04u
M7604 AND2_1164/X_u2-net6 RESET VSS VSS nmos W=0.31u L=0.04u
M7605 AND2_1164/net6 WX3255 AND2_1164/X_u2-net6 VSS nmos W=0.31u L=0.04u
M7606 WX3318 AND2_1164/net6 VDD VDD pmos W=0.41u L=0.04u
M7607 AND2_1164/net6 RESET VDD VDD pmos W=0.41u L=0.04u
M7608 AND2_1164/net6 WX3255 VDD VDD pmos W=0.41u L=0.04u
M7609 WX3316 AND2_1163/net6 VSS VSS nmos W=0.31u L=0.04u
M7610 AND2_1163/X_u2-net6 RESET VSS VSS nmos W=0.31u L=0.04u
M7611 AND2_1163/net6 WX3253 AND2_1163/X_u2-net6 VSS nmos W=0.31u L=0.04u
M7612 WX3316 AND2_1163/net6 VDD VDD pmos W=0.41u L=0.04u
M7613 AND2_1163/net6 RESET VDD VDD pmos W=0.41u L=0.04u
M7614 AND2_1163/net6 WX3253 VDD VDD pmos W=0.41u L=0.04u
M7615 WX3314 AND2_1162/net6 VSS VSS nmos W=0.31u L=0.04u
M7616 AND2_1162/X_u2-net6 RESET VSS VSS nmos W=0.31u L=0.04u
M7617 AND2_1162/net6 WX3251 AND2_1162/X_u2-net6 VSS nmos W=0.31u L=0.04u
M7618 WX3314 AND2_1162/net6 VDD VDD pmos W=0.41u L=0.04u
M7619 AND2_1162/net6 RESET VDD VDD pmos W=0.41u L=0.04u
M7620 AND2_1162/net6 WX3251 VDD VDD pmos W=0.41u L=0.04u
M7621 WX3312 AND2_1161/net6 VSS VSS nmos W=0.31u L=0.04u
M7622 AND2_1161/X_u2-net6 RESET VSS VSS nmos W=0.31u L=0.04u
M7623 AND2_1161/net6 WX3249 AND2_1161/X_u2-net6 VSS nmos W=0.31u L=0.04u
M7624 WX3312 AND2_1161/net6 VDD VDD pmos W=0.41u L=0.04u
M7625 AND2_1161/net6 RESET VDD VDD pmos W=0.41u L=0.04u
M7626 AND2_1161/net6 WX3249 VDD VDD pmos W=0.41u L=0.04u
M7627 WX3310 AND2_1160/net6 VSS VSS nmos W=0.31u L=0.04u
M7628 AND2_1160/X_u2-net6 RESET VSS VSS nmos W=0.31u L=0.04u
M7629 AND2_1160/net6 WX3247 AND2_1160/X_u2-net6 VSS nmos W=0.31u L=0.04u
M7630 WX3310 AND2_1160/net6 VDD VDD pmos W=0.41u L=0.04u
M7631 AND2_1160/net6 RESET VDD VDD pmos W=0.41u L=0.04u
M7632 AND2_1160/net6 WX3247 VDD VDD pmos W=0.41u L=0.04u
M7633 WX3308 AND2_1159/net6 VSS VSS nmos W=0.31u L=0.04u
M7634 AND2_1159/X_u2-net6 RESET VSS VSS nmos W=0.31u L=0.04u
M7635 AND2_1159/net6 WX3245 AND2_1159/X_u2-net6 VSS nmos W=0.31u L=0.04u
M7636 WX3308 AND2_1159/net6 VDD VDD pmos W=0.41u L=0.04u
M7637 AND2_1159/net6 RESET VDD VDD pmos W=0.41u L=0.04u
M7638 AND2_1159/net6 WX3245 VDD VDD pmos W=0.41u L=0.04u
M7639 WX3306 AND2_1158/net6 VSS VSS nmos W=0.31u L=0.04u
M7640 AND2_1158/X_u2-net6 RESET VSS VSS nmos W=0.31u L=0.04u
M7641 AND2_1158/net6 WX3243 AND2_1158/X_u2-net6 VSS nmos W=0.31u L=0.04u
M7642 WX3306 AND2_1158/net6 VDD VDD pmos W=0.41u L=0.04u
M7643 AND2_1158/net6 RESET VDD VDD pmos W=0.41u L=0.04u
M7644 AND2_1158/net6 WX3243 VDD VDD pmos W=0.41u L=0.04u
M7645 WX3304 AND2_1157/net6 VSS VSS nmos W=0.31u L=0.04u
M7646 AND2_1157/X_u2-net6 RESET VSS VSS nmos W=0.31u L=0.04u
M7647 AND2_1157/net6 WX3241 AND2_1157/X_u2-net6 VSS nmos W=0.31u L=0.04u
M7648 WX3304 AND2_1157/net6 VDD VDD pmos W=0.41u L=0.04u
M7649 AND2_1157/net6 RESET VDD VDD pmos W=0.41u L=0.04u
M7650 AND2_1157/net6 WX3241 VDD VDD pmos W=0.41u L=0.04u
M7651 WX3302 AND2_1156/net6 VSS VSS nmos W=0.31u L=0.04u
M7652 AND2_1156/X_u2-net6 RESET VSS VSS nmos W=0.31u L=0.04u
M7653 AND2_1156/net6 WX3239 AND2_1156/X_u2-net6 VSS nmos W=0.31u L=0.04u
M7654 WX3302 AND2_1156/net6 VDD VDD pmos W=0.41u L=0.04u
M7655 AND2_1156/net6 RESET VDD VDD pmos W=0.41u L=0.04u
M7656 AND2_1156/net6 WX3239 VDD VDD pmos W=0.41u L=0.04u
M7657 WX3300 AND2_1155/net6 VSS VSS nmos W=0.31u L=0.04u
M7658 AND2_1155/X_u2-net6 RESET VSS VSS nmos W=0.31u L=0.04u
M7659 AND2_1155/net6 WX3237 AND2_1155/X_u2-net6 VSS nmos W=0.31u L=0.04u
M7660 WX3300 AND2_1155/net6 VDD VDD pmos W=0.41u L=0.04u
M7661 AND2_1155/net6 RESET VDD VDD pmos W=0.41u L=0.04u
M7662 AND2_1155/net6 WX3237 VDD VDD pmos W=0.41u L=0.04u
M7663 WX3298 AND2_1154/net6 VSS VSS nmos W=0.31u L=0.04u
M7664 AND2_1154/X_u2-net6 RESET VSS VSS nmos W=0.31u L=0.04u
M7665 AND2_1154/net6 WX3235 AND2_1154/X_u2-net6 VSS nmos W=0.31u L=0.04u
M7666 WX3298 AND2_1154/net6 VDD VDD pmos W=0.41u L=0.04u
M7667 AND2_1154/net6 RESET VDD VDD pmos W=0.41u L=0.04u
M7668 AND2_1154/net6 WX3235 VDD VDD pmos W=0.41u L=0.04u
M7669 WX3296 AND2_1153/net6 VSS VSS nmos W=0.31u L=0.04u
M7670 AND2_1153/X_u2-net6 RESET VSS VSS nmos W=0.31u L=0.04u
M7671 AND2_1153/net6 WX3233 AND2_1153/X_u2-net6 VSS nmos W=0.31u L=0.04u
M7672 WX3296 AND2_1153/net6 VDD VDD pmos W=0.41u L=0.04u
M7673 AND2_1153/net6 RESET VDD VDD pmos W=0.41u L=0.04u
M7674 AND2_1153/net6 WX3233 VDD VDD pmos W=0.41u L=0.04u
M7675 WX3294 AND2_1152/net6 VSS VSS nmos W=0.31u L=0.04u
M7676 AND2_1152/X_u2-net6 RESET VSS VSS nmos W=0.31u L=0.04u
M7677 AND2_1152/net6 WX3231 AND2_1152/X_u2-net6 VSS nmos W=0.31u L=0.04u
M7678 WX3294 AND2_1152/net6 VDD VDD pmos W=0.41u L=0.04u
M7679 AND2_1152/net6 RESET VDD VDD pmos W=0.41u L=0.04u
M7680 AND2_1152/net6 WX3231 VDD VDD pmos W=0.41u L=0.04u
M7681 WX3292 AND2_1151/net6 VSS VSS nmos W=0.31u L=0.04u
M7682 AND2_1151/X_u2-net6 RESET VSS VSS nmos W=0.31u L=0.04u
M7683 AND2_1151/net6 WX3058 AND2_1151/X_u2-net6 VSS nmos W=0.31u L=0.04u
M7684 WX3292 AND2_1151/net6 VDD VDD pmos W=0.41u L=0.04u
M7685 AND2_1151/net6 RESET VDD VDD pmos W=0.41u L=0.04u
M7686 AND2_1151/net6 WX3058 VDD VDD pmos W=0.41u L=0.04u
M7687 WX3290 AND2_1150/net6 VSS VSS nmos W=0.31u L=0.04u
M7688 AND2_1150/X_u2-net6 RESET VSS VSS nmos W=0.31u L=0.04u
M7689 AND2_1150/net6 WX3044 AND2_1150/X_u2-net6 VSS nmos W=0.31u L=0.04u
M7690 WX3290 AND2_1150/net6 VDD VDD pmos W=0.41u L=0.04u
M7691 AND2_1150/net6 RESET VDD VDD pmos W=0.41u L=0.04u
M7692 AND2_1150/net6 WX3044 VDD VDD pmos W=0.41u L=0.04u
M7693 WX3288 AND2_1149/net6 VSS VSS nmos W=0.31u L=0.04u
M7694 AND2_1149/X_u2-net6 RESET VSS VSS nmos W=0.31u L=0.04u
M7695 AND2_1149/net6 WX3030 AND2_1149/X_u2-net6 VSS nmos W=0.31u L=0.04u
M7696 WX3288 AND2_1149/net6 VDD VDD pmos W=0.41u L=0.04u
M7697 AND2_1149/net6 RESET VDD VDD pmos W=0.41u L=0.04u
M7698 AND2_1149/net6 WX3030 VDD VDD pmos W=0.41u L=0.04u
M7699 WX3286 AND2_1148/net6 VSS VSS nmos W=0.31u L=0.04u
M7700 AND2_1148/X_u2-net6 RESET VSS VSS nmos W=0.31u L=0.04u
M7701 AND2_1148/net6 WX3016 AND2_1148/X_u2-net6 VSS nmos W=0.31u L=0.04u
M7702 WX3286 AND2_1148/net6 VDD VDD pmos W=0.41u L=0.04u
M7703 AND2_1148/net6 RESET VDD VDD pmos W=0.41u L=0.04u
M7704 AND2_1148/net6 WX3016 VDD VDD pmos W=0.41u L=0.04u
M7705 WX3284 AND2_1147/net6 VSS VSS nmos W=0.31u L=0.04u
M7706 AND2_1147/X_u2-net6 RESET VSS VSS nmos W=0.31u L=0.04u
M7707 AND2_1147/net6 WX3002 AND2_1147/X_u2-net6 VSS nmos W=0.31u L=0.04u
M7708 WX3284 AND2_1147/net6 VDD VDD pmos W=0.41u L=0.04u
M7709 AND2_1147/net6 RESET VDD VDD pmos W=0.41u L=0.04u
M7710 AND2_1147/net6 WX3002 VDD VDD pmos W=0.41u L=0.04u
M7711 WX3282 AND2_1146/net6 VSS VSS nmos W=0.31u L=0.04u
M7712 AND2_1146/X_u2-net6 RESET VSS VSS nmos W=0.31u L=0.04u
M7713 AND2_1146/net6 WX2988 AND2_1146/X_u2-net6 VSS nmos W=0.31u L=0.04u
M7714 WX3282 AND2_1146/net6 VDD VDD pmos W=0.41u L=0.04u
M7715 AND2_1146/net6 RESET VDD VDD pmos W=0.41u L=0.04u
M7716 AND2_1146/net6 WX2988 VDD VDD pmos W=0.41u L=0.04u
M7717 WX3280 AND2_1145/net6 VSS VSS nmos W=0.31u L=0.04u
M7718 AND2_1145/X_u2-net6 RESET VSS VSS nmos W=0.31u L=0.04u
M7719 AND2_1145/net6 WX2974 AND2_1145/X_u2-net6 VSS nmos W=0.31u L=0.04u
M7720 WX3280 AND2_1145/net6 VDD VDD pmos W=0.41u L=0.04u
M7721 AND2_1145/net6 RESET VDD VDD pmos W=0.41u L=0.04u
M7722 AND2_1145/net6 WX2974 VDD VDD pmos W=0.41u L=0.04u
M7723 WX3278 AND2_1144/net6 VSS VSS nmos W=0.31u L=0.04u
M7724 AND2_1144/X_u2-net6 RESET VSS VSS nmos W=0.31u L=0.04u
M7725 AND2_1144/net6 WX2960 AND2_1144/X_u2-net6 VSS nmos W=0.31u L=0.04u
M7726 WX3278 AND2_1144/net6 VDD VDD pmos W=0.41u L=0.04u
M7727 AND2_1144/net6 RESET VDD VDD pmos W=0.41u L=0.04u
M7728 AND2_1144/net6 WX2960 VDD VDD pmos W=0.41u L=0.04u
M7729 WX3276 AND2_1143/net6 VSS VSS nmos W=0.31u L=0.04u
M7730 AND2_1143/X_u2-net6 RESET VSS VSS nmos W=0.31u L=0.04u
M7731 AND2_1143/net6 WX2946 AND2_1143/X_u2-net6 VSS nmos W=0.31u L=0.04u
M7732 WX3276 AND2_1143/net6 VDD VDD pmos W=0.41u L=0.04u
M7733 AND2_1143/net6 RESET VDD VDD pmos W=0.41u L=0.04u
M7734 AND2_1143/net6 WX2946 VDD VDD pmos W=0.41u L=0.04u
M7735 WX3274 AND2_1142/net6 VSS VSS nmos W=0.31u L=0.04u
M7736 AND2_1142/X_u2-net6 RESET VSS VSS nmos W=0.31u L=0.04u
M7737 AND2_1142/net6 WX2932 AND2_1142/X_u2-net6 VSS nmos W=0.31u L=0.04u
M7738 WX3274 AND2_1142/net6 VDD VDD pmos W=0.41u L=0.04u
M7739 AND2_1142/net6 RESET VDD VDD pmos W=0.41u L=0.04u
M7740 AND2_1142/net6 WX2932 VDD VDD pmos W=0.41u L=0.04u
M7741 WX3272 AND2_1141/net6 VSS VSS nmos W=0.31u L=0.04u
M7742 AND2_1141/X_u2-net6 RESET VSS VSS nmos W=0.31u L=0.04u
M7743 AND2_1141/net6 WX2918 AND2_1141/X_u2-net6 VSS nmos W=0.31u L=0.04u
M7744 WX3272 AND2_1141/net6 VDD VDD pmos W=0.41u L=0.04u
M7745 AND2_1141/net6 RESET VDD VDD pmos W=0.41u L=0.04u
M7746 AND2_1141/net6 WX2918 VDD VDD pmos W=0.41u L=0.04u
M7747 WX3270 AND2_1140/net6 VSS VSS nmos W=0.31u L=0.04u
M7748 AND2_1140/X_u2-net6 RESET VSS VSS nmos W=0.31u L=0.04u
M7749 AND2_1140/net6 WX2904 AND2_1140/X_u2-net6 VSS nmos W=0.31u L=0.04u
M7750 WX3270 AND2_1140/net6 VDD VDD pmos W=0.41u L=0.04u
M7751 AND2_1140/net6 RESET VDD VDD pmos W=0.41u L=0.04u
M7752 AND2_1140/net6 WX2904 VDD VDD pmos W=0.41u L=0.04u
M7753 WX3268 AND2_1139/net6 VSS VSS nmos W=0.31u L=0.04u
M7754 AND2_1139/X_u2-net6 RESET VSS VSS nmos W=0.31u L=0.04u
M7755 AND2_1139/net6 WX2890 AND2_1139/X_u2-net6 VSS nmos W=0.31u L=0.04u
M7756 WX3268 AND2_1139/net6 VDD VDD pmos W=0.41u L=0.04u
M7757 AND2_1139/net6 RESET VDD VDD pmos W=0.41u L=0.04u
M7758 AND2_1139/net6 WX2890 VDD VDD pmos W=0.41u L=0.04u
M7759 WX3266 AND2_1138/net6 VSS VSS nmos W=0.31u L=0.04u
M7760 AND2_1138/X_u2-net6 RESET VSS VSS nmos W=0.31u L=0.04u
M7761 AND2_1138/net6 WX2876 AND2_1138/X_u2-net6 VSS nmos W=0.31u L=0.04u
M7762 WX3266 AND2_1138/net6 VDD VDD pmos W=0.41u L=0.04u
M7763 AND2_1138/net6 RESET VDD VDD pmos W=0.41u L=0.04u
M7764 AND2_1138/net6 WX2876 VDD VDD pmos W=0.41u L=0.04u
M7765 WX3264 AND2_1137/net6 VSS VSS nmos W=0.31u L=0.04u
M7766 AND2_1137/X_u2-net6 RESET VSS VSS nmos W=0.31u L=0.04u
M7767 AND2_1137/net6 WX2862 AND2_1137/X_u2-net6 VSS nmos W=0.31u L=0.04u
M7768 WX3264 AND2_1137/net6 VDD VDD pmos W=0.41u L=0.04u
M7769 AND2_1137/net6 RESET VDD VDD pmos W=0.41u L=0.04u
M7770 AND2_1137/net6 WX2862 VDD VDD pmos W=0.41u L=0.04u
M7771 WX3262 AND2_1136/net6 VSS VSS nmos W=0.31u L=0.04u
M7772 AND2_1136/X_u2-net6 RESET VSS VSS nmos W=0.31u L=0.04u
M7773 AND2_1136/net6 WX2848 AND2_1136/X_u2-net6 VSS nmos W=0.31u L=0.04u
M7774 WX3262 AND2_1136/net6 VDD VDD pmos W=0.41u L=0.04u
M7775 AND2_1136/net6 RESET VDD VDD pmos W=0.41u L=0.04u
M7776 AND2_1136/net6 WX2848 VDD VDD pmos W=0.41u L=0.04u
M7777 WX3260 AND2_1135/net6 VSS VSS nmos W=0.31u L=0.04u
M7778 AND2_1135/X_u2-net6 RESET VSS VSS nmos W=0.31u L=0.04u
M7779 AND2_1135/net6 WX2834 AND2_1135/X_u2-net6 VSS nmos W=0.31u L=0.04u
M7780 WX3260 AND2_1135/net6 VDD VDD pmos W=0.41u L=0.04u
M7781 AND2_1135/net6 RESET VDD VDD pmos W=0.41u L=0.04u
M7782 AND2_1135/net6 WX2834 VDD VDD pmos W=0.41u L=0.04u
M7783 WX3258 AND2_1134/net6 VSS VSS nmos W=0.31u L=0.04u
M7784 AND2_1134/X_u2-net6 RESET VSS VSS nmos W=0.31u L=0.04u
M7785 AND2_1134/net6 WX2820 AND2_1134/X_u2-net6 VSS nmos W=0.31u L=0.04u
M7786 WX3258 AND2_1134/net6 VDD VDD pmos W=0.41u L=0.04u
M7787 AND2_1134/net6 RESET VDD VDD pmos W=0.41u L=0.04u
M7788 AND2_1134/net6 WX2820 VDD VDD pmos W=0.41u L=0.04u
M7789 WX3256 AND2_1133/net6 VSS VSS nmos W=0.31u L=0.04u
M7790 AND2_1133/X_u2-net6 RESET VSS VSS nmos W=0.31u L=0.04u
M7791 AND2_1133/net6 WX2806 AND2_1133/X_u2-net6 VSS nmos W=0.31u L=0.04u
M7792 WX3256 AND2_1133/net6 VDD VDD pmos W=0.41u L=0.04u
M7793 AND2_1133/net6 RESET VDD VDD pmos W=0.41u L=0.04u
M7794 AND2_1133/net6 WX2806 VDD VDD pmos W=0.41u L=0.04u
M7795 WX3254 AND2_1132/net6 VSS VSS nmos W=0.31u L=0.04u
M7796 AND2_1132/X_u2-net6 RESET VSS VSS nmos W=0.31u L=0.04u
M7797 AND2_1132/net6 WX2792 AND2_1132/X_u2-net6 VSS nmos W=0.31u L=0.04u
M7798 WX3254 AND2_1132/net6 VDD VDD pmos W=0.41u L=0.04u
M7799 AND2_1132/net6 RESET VDD VDD pmos W=0.41u L=0.04u
M7800 AND2_1132/net6 WX2792 VDD VDD pmos W=0.41u L=0.04u
M7801 WX3252 AND2_1131/net6 VSS VSS nmos W=0.31u L=0.04u
M7802 AND2_1131/X_u2-net6 RESET VSS VSS nmos W=0.31u L=0.04u
M7803 AND2_1131/net6 WX2778 AND2_1131/X_u2-net6 VSS nmos W=0.31u L=0.04u
M7804 WX3252 AND2_1131/net6 VDD VDD pmos W=0.41u L=0.04u
M7805 AND2_1131/net6 RESET VDD VDD pmos W=0.41u L=0.04u
M7806 AND2_1131/net6 WX2778 VDD VDD pmos W=0.41u L=0.04u
M7807 WX3250 AND2_1130/net6 VSS VSS nmos W=0.31u L=0.04u
M7808 AND2_1130/X_u2-net6 RESET VSS VSS nmos W=0.31u L=0.04u
M7809 AND2_1130/net6 WX2764 AND2_1130/X_u2-net6 VSS nmos W=0.31u L=0.04u
M7810 WX3250 AND2_1130/net6 VDD VDD pmos W=0.41u L=0.04u
M7811 AND2_1130/net6 RESET VDD VDD pmos W=0.41u L=0.04u
M7812 AND2_1130/net6 WX2764 VDD VDD pmos W=0.41u L=0.04u
M7813 WX3248 AND2_1129/net6 VSS VSS nmos W=0.31u L=0.04u
M7814 AND2_1129/X_u2-net6 RESET VSS VSS nmos W=0.31u L=0.04u
M7815 AND2_1129/net6 WX2750 AND2_1129/X_u2-net6 VSS nmos W=0.31u L=0.04u
M7816 WX3248 AND2_1129/net6 VDD VDD pmos W=0.41u L=0.04u
M7817 AND2_1129/net6 RESET VDD VDD pmos W=0.41u L=0.04u
M7818 AND2_1129/net6 WX2750 VDD VDD pmos W=0.41u L=0.04u
M7819 WX3246 AND2_1128/net6 VSS VSS nmos W=0.31u L=0.04u
M7820 AND2_1128/X_u2-net6 RESET VSS VSS nmos W=0.31u L=0.04u
M7821 AND2_1128/net6 WX2736 AND2_1128/X_u2-net6 VSS nmos W=0.31u L=0.04u
M7822 WX3246 AND2_1128/net6 VDD VDD pmos W=0.41u L=0.04u
M7823 AND2_1128/net6 RESET VDD VDD pmos W=0.41u L=0.04u
M7824 AND2_1128/net6 WX2736 VDD VDD pmos W=0.41u L=0.04u
M7825 WX3244 AND2_1127/net6 VSS VSS nmos W=0.31u L=0.04u
M7826 AND2_1127/X_u2-net6 RESET VSS VSS nmos W=0.31u L=0.04u
M7827 AND2_1127/net6 WX2722 AND2_1127/X_u2-net6 VSS nmos W=0.31u L=0.04u
M7828 WX3244 AND2_1127/net6 VDD VDD pmos W=0.41u L=0.04u
M7829 AND2_1127/net6 RESET VDD VDD pmos W=0.41u L=0.04u
M7830 AND2_1127/net6 WX2722 VDD VDD pmos W=0.41u L=0.04u
M7831 WX3242 AND2_1126/net6 VSS VSS nmos W=0.31u L=0.04u
M7832 AND2_1126/X_u2-net6 RESET VSS VSS nmos W=0.31u L=0.04u
M7833 AND2_1126/net6 WX2708 AND2_1126/X_u2-net6 VSS nmos W=0.31u L=0.04u
M7834 WX3242 AND2_1126/net6 VDD VDD pmos W=0.41u L=0.04u
M7835 AND2_1126/net6 RESET VDD VDD pmos W=0.41u L=0.04u
M7836 AND2_1126/net6 WX2708 VDD VDD pmos W=0.41u L=0.04u
M7837 WX3240 AND2_1125/net6 VSS VSS nmos W=0.31u L=0.04u
M7838 AND2_1125/X_u2-net6 RESET VSS VSS nmos W=0.31u L=0.04u
M7839 AND2_1125/net6 WX2694 AND2_1125/X_u2-net6 VSS nmos W=0.31u L=0.04u
M7840 WX3240 AND2_1125/net6 VDD VDD pmos W=0.41u L=0.04u
M7841 AND2_1125/net6 RESET VDD VDD pmos W=0.41u L=0.04u
M7842 AND2_1125/net6 WX2694 VDD VDD pmos W=0.41u L=0.04u
M7843 WX3238 AND2_1124/net6 VSS VSS nmos W=0.31u L=0.04u
M7844 AND2_1124/X_u2-net6 RESET VSS VSS nmos W=0.31u L=0.04u
M7845 AND2_1124/net6 WX2680 AND2_1124/X_u2-net6 VSS nmos W=0.31u L=0.04u
M7846 WX3238 AND2_1124/net6 VDD VDD pmos W=0.41u L=0.04u
M7847 AND2_1124/net6 RESET VDD VDD pmos W=0.41u L=0.04u
M7848 AND2_1124/net6 WX2680 VDD VDD pmos W=0.41u L=0.04u
M7849 WX3236 AND2_1123/net6 VSS VSS nmos W=0.31u L=0.04u
M7850 AND2_1123/X_u2-net6 RESET VSS VSS nmos W=0.31u L=0.04u
M7851 AND2_1123/net6 WX2666 AND2_1123/X_u2-net6 VSS nmos W=0.31u L=0.04u
M7852 WX3236 AND2_1123/net6 VDD VDD pmos W=0.41u L=0.04u
M7853 AND2_1123/net6 RESET VDD VDD pmos W=0.41u L=0.04u
M7854 AND2_1123/net6 WX2666 VDD VDD pmos W=0.41u L=0.04u
M7855 WX3234 AND2_1122/net6 VSS VSS nmos W=0.31u L=0.04u
M7856 AND2_1122/X_u2-net6 RESET VSS VSS nmos W=0.31u L=0.04u
M7857 AND2_1122/net6 WX2652 AND2_1122/X_u2-net6 VSS nmos W=0.31u L=0.04u
M7858 WX3234 AND2_1122/net6 VDD VDD pmos W=0.41u L=0.04u
M7859 AND2_1122/net6 RESET VDD VDD pmos W=0.41u L=0.04u
M7860 AND2_1122/net6 WX2652 VDD VDD pmos W=0.41u L=0.04u
M7861 WX3232 AND2_1121/net6 VSS VSS nmos W=0.31u L=0.04u
M7862 AND2_1121/X_u2-net6 RESET VSS VSS nmos W=0.31u L=0.04u
M7863 AND2_1121/net6 WX2638 AND2_1121/X_u2-net6 VSS nmos W=0.31u L=0.04u
M7864 WX3232 AND2_1121/net6 VDD VDD pmos W=0.41u L=0.04u
M7865 AND2_1121/net6 RESET VDD VDD pmos W=0.41u L=0.04u
M7866 AND2_1121/net6 WX2638 VDD VDD pmos W=0.41u L=0.04u
M7867 WX3230 AND2_1120/net6 VSS VSS nmos W=0.31u L=0.04u
M7868 AND2_1120/X_u2-net6 RESET VSS VSS nmos W=0.31u L=0.04u
M7869 AND2_1120/net6 WX2624 AND2_1120/X_u2-net6 VSS nmos W=0.31u L=0.04u
M7870 WX3230 AND2_1120/net6 VDD VDD pmos W=0.41u L=0.04u
M7871 AND2_1120/net6 RESET VDD VDD pmos W=0.41u L=0.04u
M7872 AND2_1120/net6 WX2624 VDD VDD pmos W=0.41u L=0.04u
M7873 WX3132 AND2_1119/net6 VSS VSS nmos W=0.31u L=0.04u
M7874 AND2_1119/X_u2-net6 RESET VSS VSS nmos W=0.31u L=0.04u
M7875 AND2_1119/net6 WX3069 AND2_1119/X_u2-net6 VSS nmos W=0.31u L=0.04u
M7876 WX3132 AND2_1119/net6 VDD VDD pmos W=0.41u L=0.04u
M7877 AND2_1119/net6 RESET VDD VDD pmos W=0.41u L=0.04u
M7878 AND2_1119/net6 WX3069 VDD VDD pmos W=0.41u L=0.04u
M7879 WX3130 AND2_1118/net6 VSS VSS nmos W=0.31u L=0.04u
M7880 AND2_1118/X_u2-net6 RESET VSS VSS nmos W=0.31u L=0.04u
M7881 AND2_1118/net6 WX3133 AND2_1118/X_u2-net6 VSS nmos W=0.31u L=0.04u
M7882 WX3130 AND2_1118/net6 VDD VDD pmos W=0.41u L=0.04u
M7883 AND2_1118/net6 RESET VDD VDD pmos W=0.41u L=0.04u
M7884 AND2_1118/net6 WX3133 VDD VDD pmos W=0.41u L=0.04u
M7885 WX3128 AND2_1117/net6 VSS VSS nmos W=0.31u L=0.04u
M7886 AND2_1117/X_u2-net6 RESET VSS VSS nmos W=0.31u L=0.04u
M7887 AND2_1117/net6 WX3131 AND2_1117/X_u2-net6 VSS nmos W=0.31u L=0.04u
M7888 WX3128 AND2_1117/net6 VDD VDD pmos W=0.41u L=0.04u
M7889 AND2_1117/net6 RESET VDD VDD pmos W=0.41u L=0.04u
M7890 AND2_1117/net6 WX3131 VDD VDD pmos W=0.41u L=0.04u
M7891 WX3126 AND2_1116/net6 VSS VSS nmos W=0.31u L=0.04u
M7892 AND2_1116/X_u2-net6 RESET VSS VSS nmos W=0.31u L=0.04u
M7893 AND2_1116/net6 WX3129 AND2_1116/X_u2-net6 VSS nmos W=0.31u L=0.04u
M7894 WX3126 AND2_1116/net6 VDD VDD pmos W=0.41u L=0.04u
M7895 AND2_1116/net6 RESET VDD VDD pmos W=0.41u L=0.04u
M7896 AND2_1116/net6 WX3129 VDD VDD pmos W=0.41u L=0.04u
M7897 WX3124 AND2_1115/net6 VSS VSS nmos W=0.31u L=0.04u
M7898 AND2_1115/X_u2-net6 RESET VSS VSS nmos W=0.31u L=0.04u
M7899 AND2_1115/net6 WX3127 AND2_1115/X_u2-net6 VSS nmos W=0.31u L=0.04u
M7900 WX3124 AND2_1115/net6 VDD VDD pmos W=0.41u L=0.04u
M7901 AND2_1115/net6 RESET VDD VDD pmos W=0.41u L=0.04u
M7902 AND2_1115/net6 WX3127 VDD VDD pmos W=0.41u L=0.04u
M7903 WX3122 AND2_1114/net6 VSS VSS nmos W=0.31u L=0.04u
M7904 AND2_1114/X_u2-net6 RESET VSS VSS nmos W=0.31u L=0.04u
M7905 AND2_1114/net6 WX3125 AND2_1114/X_u2-net6 VSS nmos W=0.31u L=0.04u
M7906 WX3122 AND2_1114/net6 VDD VDD pmos W=0.41u L=0.04u
M7907 AND2_1114/net6 RESET VDD VDD pmos W=0.41u L=0.04u
M7908 AND2_1114/net6 WX3125 VDD VDD pmos W=0.41u L=0.04u
M7909 WX3120 AND2_1113/net6 VSS VSS nmos W=0.31u L=0.04u
M7910 AND2_1113/X_u2-net6 RESET VSS VSS nmos W=0.31u L=0.04u
M7911 AND2_1113/net6 WX3123 AND2_1113/X_u2-net6 VSS nmos W=0.31u L=0.04u
M7912 WX3120 AND2_1113/net6 VDD VDD pmos W=0.41u L=0.04u
M7913 AND2_1113/net6 RESET VDD VDD pmos W=0.41u L=0.04u
M7914 AND2_1113/net6 WX3123 VDD VDD pmos W=0.41u L=0.04u
M7915 WX3118 AND2_1112/net6 VSS VSS nmos W=0.31u L=0.04u
M7916 AND2_1112/X_u2-net6 RESET VSS VSS nmos W=0.31u L=0.04u
M7917 AND2_1112/net6 WX3121 AND2_1112/X_u2-net6 VSS nmos W=0.31u L=0.04u
M7918 WX3118 AND2_1112/net6 VDD VDD pmos W=0.41u L=0.04u
M7919 AND2_1112/net6 RESET VDD VDD pmos W=0.41u L=0.04u
M7920 AND2_1112/net6 WX3121 VDD VDD pmos W=0.41u L=0.04u
M7921 WX3116 AND2_1111/net6 VSS VSS nmos W=0.31u L=0.04u
M7922 AND2_1111/X_u2-net6 RESET VSS VSS nmos W=0.31u L=0.04u
M7923 AND2_1111/net6 WX3119 AND2_1111/X_u2-net6 VSS nmos W=0.31u L=0.04u
M7924 WX3116 AND2_1111/net6 VDD VDD pmos W=0.41u L=0.04u
M7925 AND2_1111/net6 RESET VDD VDD pmos W=0.41u L=0.04u
M7926 AND2_1111/net6 WX3119 VDD VDD pmos W=0.41u L=0.04u
M7927 WX3114 AND2_1110/net6 VSS VSS nmos W=0.31u L=0.04u
M7928 AND2_1110/X_u2-net6 RESET VSS VSS nmos W=0.31u L=0.04u
M7929 AND2_1110/net6 WX3117 AND2_1110/X_u2-net6 VSS nmos W=0.31u L=0.04u
M7930 WX3114 AND2_1110/net6 VDD VDD pmos W=0.41u L=0.04u
M7931 AND2_1110/net6 RESET VDD VDD pmos W=0.41u L=0.04u
M7932 AND2_1110/net6 WX3117 VDD VDD pmos W=0.41u L=0.04u
M7933 WX3112 AND2_1109/net6 VSS VSS nmos W=0.31u L=0.04u
M7934 AND2_1109/X_u2-net6 RESET VSS VSS nmos W=0.31u L=0.04u
M7935 AND2_1109/net6 WX3115 AND2_1109/X_u2-net6 VSS nmos W=0.31u L=0.04u
M7936 WX3112 AND2_1109/net6 VDD VDD pmos W=0.41u L=0.04u
M7937 AND2_1109/net6 RESET VDD VDD pmos W=0.41u L=0.04u
M7938 AND2_1109/net6 WX3115 VDD VDD pmos W=0.41u L=0.04u
M7939 WX3110 AND2_1108/net6 VSS VSS nmos W=0.31u L=0.04u
M7940 AND2_1108/X_u2-net6 RESET VSS VSS nmos W=0.31u L=0.04u
M7941 AND2_1108/net6 WX3113 AND2_1108/X_u2-net6 VSS nmos W=0.31u L=0.04u
M7942 WX3110 AND2_1108/net6 VDD VDD pmos W=0.41u L=0.04u
M7943 AND2_1108/net6 RESET VDD VDD pmos W=0.41u L=0.04u
M7944 AND2_1108/net6 WX3113 VDD VDD pmos W=0.41u L=0.04u
M7945 WX3108 AND2_1107/net6 VSS VSS nmos W=0.31u L=0.04u
M7946 AND2_1107/X_u2-net6 RESET VSS VSS nmos W=0.31u L=0.04u
M7947 AND2_1107/net6 WX3111 AND2_1107/X_u2-net6 VSS nmos W=0.31u L=0.04u
M7948 WX3108 AND2_1107/net6 VDD VDD pmos W=0.41u L=0.04u
M7949 AND2_1107/net6 RESET VDD VDD pmos W=0.41u L=0.04u
M7950 AND2_1107/net6 WX3111 VDD VDD pmos W=0.41u L=0.04u
M7951 WX3106 AND2_1106/net6 VSS VSS nmos W=0.31u L=0.04u
M7952 AND2_1106/X_u2-net6 RESET VSS VSS nmos W=0.31u L=0.04u
M7953 AND2_1106/net6 WX3109 AND2_1106/X_u2-net6 VSS nmos W=0.31u L=0.04u
M7954 WX3106 AND2_1106/net6 VDD VDD pmos W=0.41u L=0.04u
M7955 AND2_1106/net6 RESET VDD VDD pmos W=0.41u L=0.04u
M7956 AND2_1106/net6 WX3109 VDD VDD pmos W=0.41u L=0.04u
M7957 WX3104 AND2_1105/net6 VSS VSS nmos W=0.31u L=0.04u
M7958 AND2_1105/X_u2-net6 RESET VSS VSS nmos W=0.31u L=0.04u
M7959 AND2_1105/net6 WX3107 AND2_1105/X_u2-net6 VSS nmos W=0.31u L=0.04u
M7960 WX3104 AND2_1105/net6 VDD VDD pmos W=0.41u L=0.04u
M7961 AND2_1105/net6 RESET VDD VDD pmos W=0.41u L=0.04u
M7962 AND2_1105/net6 WX3107 VDD VDD pmos W=0.41u L=0.04u
M7963 WX3102 AND2_1104/net6 VSS VSS nmos W=0.31u L=0.04u
M7964 AND2_1104/X_u2-net6 RESET VSS VSS nmos W=0.31u L=0.04u
M7965 AND2_1104/net6 WX3105 AND2_1104/X_u2-net6 VSS nmos W=0.31u L=0.04u
M7966 WX3102 AND2_1104/net6 VDD VDD pmos W=0.41u L=0.04u
M7967 AND2_1104/net6 RESET VDD VDD pmos W=0.41u L=0.04u
M7968 AND2_1104/net6 WX3105 VDD VDD pmos W=0.41u L=0.04u
M7969 WX3100 AND2_1103/net6 VSS VSS nmos W=0.31u L=0.04u
M7970 AND2_1103/X_u2-net6 RESET VSS VSS nmos W=0.31u L=0.04u
M7971 AND2_1103/net6 WX3103 AND2_1103/X_u2-net6 VSS nmos W=0.31u L=0.04u
M7972 WX3100 AND2_1103/net6 VDD VDD pmos W=0.41u L=0.04u
M7973 AND2_1103/net6 RESET VDD VDD pmos W=0.41u L=0.04u
M7974 AND2_1103/net6 WX3103 VDD VDD pmos W=0.41u L=0.04u
M7975 WX3098 AND2_1102/net6 VSS VSS nmos W=0.31u L=0.04u
M7976 AND2_1102/X_u2-net6 RESET VSS VSS nmos W=0.31u L=0.04u
M7977 AND2_1102/net6 WX3101 AND2_1102/X_u2-net6 VSS nmos W=0.31u L=0.04u
M7978 WX3098 AND2_1102/net6 VDD VDD pmos W=0.41u L=0.04u
M7979 AND2_1102/net6 RESET VDD VDD pmos W=0.41u L=0.04u
M7980 AND2_1102/net6 WX3101 VDD VDD pmos W=0.41u L=0.04u
M7981 WX3096 AND2_1101/net6 VSS VSS nmos W=0.31u L=0.04u
M7982 AND2_1101/X_u2-net6 RESET VSS VSS nmos W=0.31u L=0.04u
M7983 AND2_1101/net6 WX3099 AND2_1101/X_u2-net6 VSS nmos W=0.31u L=0.04u
M7984 WX3096 AND2_1101/net6 VDD VDD pmos W=0.41u L=0.04u
M7985 AND2_1101/net6 RESET VDD VDD pmos W=0.41u L=0.04u
M7986 AND2_1101/net6 WX3099 VDD VDD pmos W=0.41u L=0.04u
M7987 WX3094 AND2_1100/net6 VSS VSS nmos W=0.31u L=0.04u
M7988 AND2_1100/X_u2-net6 RESET VSS VSS nmos W=0.31u L=0.04u
M7989 AND2_1100/net6 WX3097 AND2_1100/X_u2-net6 VSS nmos W=0.31u L=0.04u
M7990 WX3094 AND2_1100/net6 VDD VDD pmos W=0.41u L=0.04u
M7991 AND2_1100/net6 RESET VDD VDD pmos W=0.41u L=0.04u
M7992 AND2_1100/net6 WX3097 VDD VDD pmos W=0.41u L=0.04u
M7993 WX3092 AND2_1099/net6 VSS VSS nmos W=0.31u L=0.04u
M7994 AND2_1099/X_u2-net6 RESET VSS VSS nmos W=0.31u L=0.04u
M7995 AND2_1099/net6 WX3095 AND2_1099/X_u2-net6 VSS nmos W=0.31u L=0.04u
M7996 WX3092 AND2_1099/net6 VDD VDD pmos W=0.41u L=0.04u
M7997 AND2_1099/net6 RESET VDD VDD pmos W=0.41u L=0.04u
M7998 AND2_1099/net6 WX3095 VDD VDD pmos W=0.41u L=0.04u
M7999 WX3090 AND2_1098/net6 VSS VSS nmos W=0.31u L=0.04u
M8000 AND2_1098/X_u2-net6 RESET VSS VSS nmos W=0.31u L=0.04u
M8001 AND2_1098/net6 WX3093 AND2_1098/X_u2-net6 VSS nmos W=0.31u L=0.04u
M8002 WX3090 AND2_1098/net6 VDD VDD pmos W=0.41u L=0.04u
M8003 AND2_1098/net6 RESET VDD VDD pmos W=0.41u L=0.04u
M8004 AND2_1098/net6 WX3093 VDD VDD pmos W=0.41u L=0.04u
M8005 WX3088 AND2_1097/net6 VSS VSS nmos W=0.31u L=0.04u
M8006 AND2_1097/X_u2-net6 RESET VSS VSS nmos W=0.31u L=0.04u
M8007 AND2_1097/net6 WX3091 AND2_1097/X_u2-net6 VSS nmos W=0.31u L=0.04u
M8008 WX3088 AND2_1097/net6 VDD VDD pmos W=0.41u L=0.04u
M8009 AND2_1097/net6 RESET VDD VDD pmos W=0.41u L=0.04u
M8010 AND2_1097/net6 WX3091 VDD VDD pmos W=0.41u L=0.04u
M8011 WX3086 AND2_1096/net6 VSS VSS nmos W=0.31u L=0.04u
M8012 AND2_1096/X_u2-net6 RESET VSS VSS nmos W=0.31u L=0.04u
M8013 AND2_1096/net6 WX3089 AND2_1096/X_u2-net6 VSS nmos W=0.31u L=0.04u
M8014 WX3086 AND2_1096/net6 VDD VDD pmos W=0.41u L=0.04u
M8015 AND2_1096/net6 RESET VDD VDD pmos W=0.41u L=0.04u
M8016 AND2_1096/net6 WX3089 VDD VDD pmos W=0.41u L=0.04u
M8017 WX3084 AND2_1095/net6 VSS VSS nmos W=0.31u L=0.04u
M8018 AND2_1095/X_u2-net6 RESET VSS VSS nmos W=0.31u L=0.04u
M8019 AND2_1095/net6 WX3087 AND2_1095/X_u2-net6 VSS nmos W=0.31u L=0.04u
M8020 WX3084 AND2_1095/net6 VDD VDD pmos W=0.41u L=0.04u
M8021 AND2_1095/net6 RESET VDD VDD pmos W=0.41u L=0.04u
M8022 AND2_1095/net6 WX3087 VDD VDD pmos W=0.41u L=0.04u
M8023 WX3082 AND2_1094/net6 VSS VSS nmos W=0.31u L=0.04u
M8024 AND2_1094/X_u2-net6 RESET VSS VSS nmos W=0.31u L=0.04u
M8025 AND2_1094/net6 WX3085 AND2_1094/X_u2-net6 VSS nmos W=0.31u L=0.04u
M8026 WX3082 AND2_1094/net6 VDD VDD pmos W=0.41u L=0.04u
M8027 AND2_1094/net6 RESET VDD VDD pmos W=0.41u L=0.04u
M8028 AND2_1094/net6 WX3085 VDD VDD pmos W=0.41u L=0.04u
M8029 WX3080 AND2_1093/net6 VSS VSS nmos W=0.31u L=0.04u
M8030 AND2_1093/X_u2-net6 RESET VSS VSS nmos W=0.31u L=0.04u
M8031 AND2_1093/net6 WX3083 AND2_1093/X_u2-net6 VSS nmos W=0.31u L=0.04u
M8032 WX3080 AND2_1093/net6 VDD VDD pmos W=0.41u L=0.04u
M8033 AND2_1093/net6 RESET VDD VDD pmos W=0.41u L=0.04u
M8034 AND2_1093/net6 WX3083 VDD VDD pmos W=0.41u L=0.04u
M8035 WX3078 AND2_1092/net6 VSS VSS nmos W=0.31u L=0.04u
M8036 AND2_1092/X_u2-net6 RESET VSS VSS nmos W=0.31u L=0.04u
M8037 AND2_1092/net6 WX3081 AND2_1092/X_u2-net6 VSS nmos W=0.31u L=0.04u
M8038 WX3078 AND2_1092/net6 VDD VDD pmos W=0.41u L=0.04u
M8039 AND2_1092/net6 RESET VDD VDD pmos W=0.41u L=0.04u
M8040 AND2_1092/net6 WX3081 VDD VDD pmos W=0.41u L=0.04u
M8041 WX3076 AND2_1091/net6 VSS VSS nmos W=0.31u L=0.04u
M8042 AND2_1091/X_u2-net6 RESET VSS VSS nmos W=0.31u L=0.04u
M8043 AND2_1091/net6 WX3079 AND2_1091/X_u2-net6 VSS nmos W=0.31u L=0.04u
M8044 WX3076 AND2_1091/net6 VDD VDD pmos W=0.41u L=0.04u
M8045 AND2_1091/net6 RESET VDD VDD pmos W=0.41u L=0.04u
M8046 AND2_1091/net6 WX3079 VDD VDD pmos W=0.41u L=0.04u
M8047 WX3074 AND2_1090/net6 VSS VSS nmos W=0.31u L=0.04u
M8048 AND2_1090/X_u2-net6 RESET VSS VSS nmos W=0.31u L=0.04u
M8049 AND2_1090/net6 WX3077 AND2_1090/X_u2-net6 VSS nmos W=0.31u L=0.04u
M8050 WX3074 AND2_1090/net6 VDD VDD pmos W=0.41u L=0.04u
M8051 AND2_1090/net6 RESET VDD VDD pmos W=0.41u L=0.04u
M8052 AND2_1090/net6 WX3077 VDD VDD pmos W=0.41u L=0.04u
M8053 WX3072 AND2_1089/net6 VSS VSS nmos W=0.31u L=0.04u
M8054 AND2_1089/X_u2-net6 RESET VSS VSS nmos W=0.31u L=0.04u
M8055 AND2_1089/net6 WX3075 AND2_1089/X_u2-net6 VSS nmos W=0.31u L=0.04u
M8056 WX3072 AND2_1089/net6 VDD VDD pmos W=0.41u L=0.04u
M8057 AND2_1089/net6 RESET VDD VDD pmos W=0.41u L=0.04u
M8058 AND2_1089/net6 WX3075 VDD VDD pmos W=0.41u L=0.04u
M8059 WX3070 AND2_1088/net6 VSS VSS nmos W=0.31u L=0.04u
M8060 AND2_1088/X_u2-net6 RESET VSS VSS nmos W=0.31u L=0.04u
M8061 AND2_1088/net6 WX3073 AND2_1088/X_u2-net6 VSS nmos W=0.31u L=0.04u
M8062 WX3070 AND2_1088/net6 VDD VDD pmos W=0.41u L=0.04u
M8063 AND2_1088/net6 RESET VDD VDD pmos W=0.41u L=0.04u
M8064 AND2_1088/net6 WX3073 VDD VDD pmos W=0.41u L=0.04u
M8065 WX2619 AND2_895/net6 VSS VSS nmos W=0.31u L=0.04u
M8066 AND2_895/X_u2-net6 RESET VSS VSS nmos W=0.31u L=0.04u
M8067 AND2_895/net6 n984 AND2_895/X_u2-net6 VSS nmos W=0.31u L=0.04u
M8068 WX2619 AND2_895/net6 VDD VDD pmos W=0.41u L=0.04u
M8069 AND2_895/net6 RESET VDD VDD pmos W=0.41u L=0.04u
M8070 AND2_895/net6 n984 VDD VDD pmos W=0.41u L=0.04u
M8071 WX2617 AND2_894/net6 VSS VSS nmos W=0.31u L=0.04u
M8072 AND2_894/X_u2-net6 RESET VSS VSS nmos W=0.31u L=0.04u
M8073 AND2_894/net6 n985 AND2_894/X_u2-net6 VSS nmos W=0.31u L=0.04u
M8074 WX2617 AND2_894/net6 VDD VDD pmos W=0.41u L=0.04u
M8075 AND2_894/net6 RESET VDD VDD pmos W=0.41u L=0.04u
M8076 AND2_894/net6 n985 VDD VDD pmos W=0.41u L=0.04u
M8077 WX2615 AND2_893/net6 VSS VSS nmos W=0.31u L=0.04u
M8078 AND2_893/X_u2-net6 RESET VSS VSS nmos W=0.31u L=0.04u
M8079 AND2_893/net6 n986 AND2_893/X_u2-net6 VSS nmos W=0.31u L=0.04u
M8080 WX2615 AND2_893/net6 VDD VDD pmos W=0.41u L=0.04u
M8081 AND2_893/net6 RESET VDD VDD pmos W=0.41u L=0.04u
M8082 AND2_893/net6 n986 VDD VDD pmos W=0.41u L=0.04u
M8083 WX2613 AND2_892/net6 VSS VSS nmos W=0.31u L=0.04u
M8084 AND2_892/X_u2-net6 RESET VSS VSS nmos W=0.31u L=0.04u
M8085 AND2_892/net6 n987 AND2_892/X_u2-net6 VSS nmos W=0.31u L=0.04u
M8086 WX2613 AND2_892/net6 VDD VDD pmos W=0.41u L=0.04u
M8087 AND2_892/net6 RESET VDD VDD pmos W=0.41u L=0.04u
M8088 AND2_892/net6 n987 VDD VDD pmos W=0.41u L=0.04u
M8089 WX2611 AND2_891/net6 VSS VSS nmos W=0.31u L=0.04u
M8090 AND2_891/X_u2-net6 RESET VSS VSS nmos W=0.31u L=0.04u
M8091 AND2_891/net6 n988 AND2_891/X_u2-net6 VSS nmos W=0.31u L=0.04u
M8092 WX2611 AND2_891/net6 VDD VDD pmos W=0.41u L=0.04u
M8093 AND2_891/net6 RESET VDD VDD pmos W=0.41u L=0.04u
M8094 AND2_891/net6 n988 VDD VDD pmos W=0.41u L=0.04u
M8095 WX2609 AND2_890/net6 VSS VSS nmos W=0.31u L=0.04u
M8096 AND2_890/X_u2-net6 RESET VSS VSS nmos W=0.31u L=0.04u
M8097 AND2_890/net6 n989 AND2_890/X_u2-net6 VSS nmos W=0.31u L=0.04u
M8098 WX2609 AND2_890/net6 VDD VDD pmos W=0.41u L=0.04u
M8099 AND2_890/net6 RESET VDD VDD pmos W=0.41u L=0.04u
M8100 AND2_890/net6 n989 VDD VDD pmos W=0.41u L=0.04u
M8101 WX2607 AND2_889/net6 VSS VSS nmos W=0.31u L=0.04u
M8102 AND2_889/X_u2-net6 RESET VSS VSS nmos W=0.31u L=0.04u
M8103 AND2_889/net6 n990 AND2_889/X_u2-net6 VSS nmos W=0.31u L=0.04u
M8104 WX2607 AND2_889/net6 VDD VDD pmos W=0.41u L=0.04u
M8105 AND2_889/net6 RESET VDD VDD pmos W=0.41u L=0.04u
M8106 AND2_889/net6 n990 VDD VDD pmos W=0.41u L=0.04u
M8107 WX2605 AND2_888/net6 VSS VSS nmos W=0.31u L=0.04u
M8108 AND2_888/X_u2-net6 RESET VSS VSS nmos W=0.31u L=0.04u
M8109 AND2_888/net6 n991 AND2_888/X_u2-net6 VSS nmos W=0.31u L=0.04u
M8110 WX2605 AND2_888/net6 VDD VDD pmos W=0.41u L=0.04u
M8111 AND2_888/net6 RESET VDD VDD pmos W=0.41u L=0.04u
M8112 AND2_888/net6 n991 VDD VDD pmos W=0.41u L=0.04u
M8113 WX2603 AND2_887/net6 VSS VSS nmos W=0.31u L=0.04u
M8114 AND2_887/X_u2-net6 RESET VSS VSS nmos W=0.31u L=0.04u
M8115 AND2_887/net6 n992 AND2_887/X_u2-net6 VSS nmos W=0.31u L=0.04u
M8116 WX2603 AND2_887/net6 VDD VDD pmos W=0.41u L=0.04u
M8117 AND2_887/net6 RESET VDD VDD pmos W=0.41u L=0.04u
M8118 AND2_887/net6 n992 VDD VDD pmos W=0.41u L=0.04u
M8119 WX2601 AND2_886/net6 VSS VSS nmos W=0.31u L=0.04u
M8120 AND2_886/X_u2-net6 RESET VSS VSS nmos W=0.31u L=0.04u
M8121 AND2_886/net6 n993 AND2_886/X_u2-net6 VSS nmos W=0.31u L=0.04u
M8122 WX2601 AND2_886/net6 VDD VDD pmos W=0.41u L=0.04u
M8123 AND2_886/net6 RESET VDD VDD pmos W=0.41u L=0.04u
M8124 AND2_886/net6 n993 VDD VDD pmos W=0.41u L=0.04u
M8125 WX2599 AND2_885/net6 VSS VSS nmos W=0.31u L=0.04u
M8126 AND2_885/X_u2-net6 RESET VSS VSS nmos W=0.31u L=0.04u
M8127 AND2_885/net6 n994 AND2_885/X_u2-net6 VSS nmos W=0.31u L=0.04u
M8128 WX2599 AND2_885/net6 VDD VDD pmos W=0.41u L=0.04u
M8129 AND2_885/net6 RESET VDD VDD pmos W=0.41u L=0.04u
M8130 AND2_885/net6 n994 VDD VDD pmos W=0.41u L=0.04u
M8131 WX2597 AND2_884/net6 VSS VSS nmos W=0.31u L=0.04u
M8132 AND2_884/X_u2-net6 RESET VSS VSS nmos W=0.31u L=0.04u
M8133 AND2_884/net6 n995 AND2_884/X_u2-net6 VSS nmos W=0.31u L=0.04u
M8134 WX2597 AND2_884/net6 VDD VDD pmos W=0.41u L=0.04u
M8135 AND2_884/net6 RESET VDD VDD pmos W=0.41u L=0.04u
M8136 AND2_884/net6 n995 VDD VDD pmos W=0.41u L=0.04u
M8137 WX2595 AND2_883/net6 VSS VSS nmos W=0.31u L=0.04u
M8138 AND2_883/X_u2-net6 RESET VSS VSS nmos W=0.31u L=0.04u
M8139 AND2_883/net6 n996 AND2_883/X_u2-net6 VSS nmos W=0.31u L=0.04u
M8140 WX2595 AND2_883/net6 VDD VDD pmos W=0.41u L=0.04u
M8141 AND2_883/net6 RESET VDD VDD pmos W=0.41u L=0.04u
M8142 AND2_883/net6 n996 VDD VDD pmos W=0.41u L=0.04u
M8143 WX2593 AND2_882/net6 VSS VSS nmos W=0.31u L=0.04u
M8144 AND2_882/X_u2-net6 RESET VSS VSS nmos W=0.31u L=0.04u
M8145 AND2_882/net6 n997 AND2_882/X_u2-net6 VSS nmos W=0.31u L=0.04u
M8146 WX2593 AND2_882/net6 VDD VDD pmos W=0.41u L=0.04u
M8147 AND2_882/net6 RESET VDD VDD pmos W=0.41u L=0.04u
M8148 AND2_882/net6 n997 VDD VDD pmos W=0.41u L=0.04u
M8149 WX2591 AND2_881/net6 VSS VSS nmos W=0.31u L=0.04u
M8150 AND2_881/X_u2-net6 RESET VSS VSS nmos W=0.31u L=0.04u
M8151 AND2_881/net6 n998 AND2_881/X_u2-net6 VSS nmos W=0.31u L=0.04u
M8152 WX2591 AND2_881/net6 VDD VDD pmos W=0.41u L=0.04u
M8153 AND2_881/net6 RESET VDD VDD pmos W=0.41u L=0.04u
M8154 AND2_881/net6 n998 VDD VDD pmos W=0.41u L=0.04u
M8155 WX2589 AND2_880/net6 VSS VSS nmos W=0.31u L=0.04u
M8156 AND2_880/X_u2-net6 RESET VSS VSS nmos W=0.31u L=0.04u
M8157 AND2_880/net6 n999 AND2_880/X_u2-net6 VSS nmos W=0.31u L=0.04u
M8158 WX2589 AND2_880/net6 VDD VDD pmos W=0.41u L=0.04u
M8159 AND2_880/net6 RESET VDD VDD pmos W=0.41u L=0.04u
M8160 AND2_880/net6 n999 VDD VDD pmos W=0.41u L=0.04u
M8161 WX2587 AND2_879/net6 VSS VSS nmos W=0.31u L=0.04u
M8162 AND2_879/X_u2-net6 RESET VSS VSS nmos W=0.31u L=0.04u
M8163 AND2_879/net6 n1000 AND2_879/X_u2-net6 VSS nmos W=0.31u L=0.04u
M8164 WX2587 AND2_879/net6 VDD VDD pmos W=0.41u L=0.04u
M8165 AND2_879/net6 RESET VDD VDD pmos W=0.41u L=0.04u
M8166 AND2_879/net6 n1000 VDD VDD pmos W=0.41u L=0.04u
M8167 WX2585 AND2_878/net6 VSS VSS nmos W=0.31u L=0.04u
M8168 AND2_878/X_u2-net6 RESET VSS VSS nmos W=0.31u L=0.04u
M8169 AND2_878/net6 n1001 AND2_878/X_u2-net6 VSS nmos W=0.31u L=0.04u
M8170 WX2585 AND2_878/net6 VDD VDD pmos W=0.41u L=0.04u
M8171 AND2_878/net6 RESET VDD VDD pmos W=0.41u L=0.04u
M8172 AND2_878/net6 n1001 VDD VDD pmos W=0.41u L=0.04u
M8173 WX2583 AND2_877/net6 VSS VSS nmos W=0.31u L=0.04u
M8174 AND2_877/X_u2-net6 RESET VSS VSS nmos W=0.31u L=0.04u
M8175 AND2_877/net6 n1002 AND2_877/X_u2-net6 VSS nmos W=0.31u L=0.04u
M8176 WX2583 AND2_877/net6 VDD VDD pmos W=0.41u L=0.04u
M8177 AND2_877/net6 RESET VDD VDD pmos W=0.41u L=0.04u
M8178 AND2_877/net6 n1002 VDD VDD pmos W=0.41u L=0.04u
M8179 WX2581 AND2_876/net6 VSS VSS nmos W=0.31u L=0.04u
M8180 AND2_876/X_u2-net6 RESET VSS VSS nmos W=0.31u L=0.04u
M8181 AND2_876/net6 n1003 AND2_876/X_u2-net6 VSS nmos W=0.31u L=0.04u
M8182 WX2581 AND2_876/net6 VDD VDD pmos W=0.41u L=0.04u
M8183 AND2_876/net6 RESET VDD VDD pmos W=0.41u L=0.04u
M8184 AND2_876/net6 n1003 VDD VDD pmos W=0.41u L=0.04u
M8185 WX2579 AND2_875/net6 VSS VSS nmos W=0.31u L=0.04u
M8186 AND2_875/X_u2-net6 RESET VSS VSS nmos W=0.31u L=0.04u
M8187 AND2_875/net6 n1004 AND2_875/X_u2-net6 VSS nmos W=0.31u L=0.04u
M8188 WX2579 AND2_875/net6 VDD VDD pmos W=0.41u L=0.04u
M8189 AND2_875/net6 RESET VDD VDD pmos W=0.41u L=0.04u
M8190 AND2_875/net6 n1004 VDD VDD pmos W=0.41u L=0.04u
M8191 WX2577 AND2_874/net6 VSS VSS nmos W=0.31u L=0.04u
M8192 AND2_874/X_u2-net6 RESET VSS VSS nmos W=0.31u L=0.04u
M8193 AND2_874/net6 n1005 AND2_874/X_u2-net6 VSS nmos W=0.31u L=0.04u
M8194 WX2577 AND2_874/net6 VDD VDD pmos W=0.41u L=0.04u
M8195 AND2_874/net6 RESET VDD VDD pmos W=0.41u L=0.04u
M8196 AND2_874/net6 n1005 VDD VDD pmos W=0.41u L=0.04u
M8197 WX2575 AND2_873/net6 VSS VSS nmos W=0.31u L=0.04u
M8198 AND2_873/X_u2-net6 RESET VSS VSS nmos W=0.31u L=0.04u
M8199 AND2_873/net6 n1006 AND2_873/X_u2-net6 VSS nmos W=0.31u L=0.04u
M8200 WX2575 AND2_873/net6 VDD VDD pmos W=0.41u L=0.04u
M8201 AND2_873/net6 RESET VDD VDD pmos W=0.41u L=0.04u
M8202 AND2_873/net6 n1006 VDD VDD pmos W=0.41u L=0.04u
M8203 WX2573 AND2_872/net6 VSS VSS nmos W=0.31u L=0.04u
M8204 AND2_872/X_u2-net6 RESET VSS VSS nmos W=0.31u L=0.04u
M8205 AND2_872/net6 n1007 AND2_872/X_u2-net6 VSS nmos W=0.31u L=0.04u
M8206 WX2573 AND2_872/net6 VDD VDD pmos W=0.41u L=0.04u
M8207 AND2_872/net6 RESET VDD VDD pmos W=0.41u L=0.04u
M8208 AND2_872/net6 n1007 VDD VDD pmos W=0.41u L=0.04u
M8209 WX2571 AND2_871/net6 VSS VSS nmos W=0.31u L=0.04u
M8210 AND2_871/X_u2-net6 RESET VSS VSS nmos W=0.31u L=0.04u
M8211 AND2_871/net6 n1008 AND2_871/X_u2-net6 VSS nmos W=0.31u L=0.04u
M8212 WX2571 AND2_871/net6 VDD VDD pmos W=0.41u L=0.04u
M8213 AND2_871/net6 RESET VDD VDD pmos W=0.41u L=0.04u
M8214 AND2_871/net6 n1008 VDD VDD pmos W=0.41u L=0.04u
M8215 WX2569 AND2_870/net6 VSS VSS nmos W=0.31u L=0.04u
M8216 AND2_870/X_u2-net6 RESET VSS VSS nmos W=0.31u L=0.04u
M8217 AND2_870/net6 n1009 AND2_870/X_u2-net6 VSS nmos W=0.31u L=0.04u
M8218 WX2569 AND2_870/net6 VDD VDD pmos W=0.41u L=0.04u
M8219 AND2_870/net6 RESET VDD VDD pmos W=0.41u L=0.04u
M8220 AND2_870/net6 n1009 VDD VDD pmos W=0.41u L=0.04u
M8221 WX2567 AND2_869/net6 VSS VSS nmos W=0.31u L=0.04u
M8222 AND2_869/X_u2-net6 RESET VSS VSS nmos W=0.31u L=0.04u
M8223 AND2_869/net6 n1010 AND2_869/X_u2-net6 VSS nmos W=0.31u L=0.04u
M8224 WX2567 AND2_869/net6 VDD VDD pmos W=0.41u L=0.04u
M8225 AND2_869/net6 RESET VDD VDD pmos W=0.41u L=0.04u
M8226 AND2_869/net6 n1010 VDD VDD pmos W=0.41u L=0.04u
M8227 WX2565 AND2_868/net6 VSS VSS nmos W=0.31u L=0.04u
M8228 AND2_868/X_u2-net6 RESET VSS VSS nmos W=0.31u L=0.04u
M8229 AND2_868/net6 n1011 AND2_868/X_u2-net6 VSS nmos W=0.31u L=0.04u
M8230 WX2565 AND2_868/net6 VDD VDD pmos W=0.41u L=0.04u
M8231 AND2_868/net6 RESET VDD VDD pmos W=0.41u L=0.04u
M8232 AND2_868/net6 n1011 VDD VDD pmos W=0.41u L=0.04u
M8233 WX2563 AND2_867/net6 VSS VSS nmos W=0.31u L=0.04u
M8234 AND2_867/X_u2-net6 RESET VSS VSS nmos W=0.31u L=0.04u
M8235 AND2_867/net6 n1012 AND2_867/X_u2-net6 VSS nmos W=0.31u L=0.04u
M8236 WX2563 AND2_867/net6 VDD VDD pmos W=0.41u L=0.04u
M8237 AND2_867/net6 RESET VDD VDD pmos W=0.41u L=0.04u
M8238 AND2_867/net6 n1012 VDD VDD pmos W=0.41u L=0.04u
M8239 WX2561 AND2_866/net6 VSS VSS nmos W=0.31u L=0.04u
M8240 AND2_866/X_u2-net6 RESET VSS VSS nmos W=0.31u L=0.04u
M8241 AND2_866/net6 n1013 AND2_866/X_u2-net6 VSS nmos W=0.31u L=0.04u
M8242 WX2561 AND2_866/net6 VDD VDD pmos W=0.41u L=0.04u
M8243 AND2_866/net6 RESET VDD VDD pmos W=0.41u L=0.04u
M8244 AND2_866/net6 n1013 VDD VDD pmos W=0.41u L=0.04u
M8245 WX2559 AND2_865/net6 VSS VSS nmos W=0.31u L=0.04u
M8246 AND2_865/X_u2-net6 RESET VSS VSS nmos W=0.31u L=0.04u
M8247 AND2_865/net6 n1014 AND2_865/X_u2-net6 VSS nmos W=0.31u L=0.04u
M8248 WX2559 AND2_865/net6 VDD VDD pmos W=0.41u L=0.04u
M8249 AND2_865/net6 RESET VDD VDD pmos W=0.41u L=0.04u
M8250 AND2_865/net6 n1014 VDD VDD pmos W=0.41u L=0.04u
M8251 WX2557 AND2_864/net6 VSS VSS nmos W=0.31u L=0.04u
M8252 AND2_864/X_u2-net6 RESET VSS VSS nmos W=0.31u L=0.04u
M8253 AND2_864/net6 n1015 AND2_864/X_u2-net6 VSS nmos W=0.31u L=0.04u
M8254 WX2557 AND2_864/net6 VDD VDD pmos W=0.41u L=0.04u
M8255 AND2_864/net6 RESET VDD VDD pmos W=0.41u L=0.04u
M8256 AND2_864/net6 n1015 VDD VDD pmos W=0.41u L=0.04u
M8257 WX2191 AND2_799/net6 VSS VSS nmos W=0.31u L=0.04u
M8258 AND2_799/X_u2-net6 RESET VSS VSS nmos W=0.31u L=0.04u
M8259 AND2_799/net6 WX2128 AND2_799/X_u2-net6 VSS nmos W=0.31u L=0.04u
M8260 WX2191 AND2_799/net6 VDD VDD pmos W=0.41u L=0.04u
M8261 AND2_799/net6 RESET VDD VDD pmos W=0.41u L=0.04u
M8262 AND2_799/net6 WX2128 VDD VDD pmos W=0.41u L=0.04u
M8263 WX2189 AND2_798/net6 VSS VSS nmos W=0.31u L=0.04u
M8264 AND2_798/X_u2-net6 RESET VSS VSS nmos W=0.31u L=0.04u
M8265 AND2_798/net6 WX2126 AND2_798/X_u2-net6 VSS nmos W=0.31u L=0.04u
M8266 WX2189 AND2_798/net6 VDD VDD pmos W=0.41u L=0.04u
M8267 AND2_798/net6 RESET VDD VDD pmos W=0.41u L=0.04u
M8268 AND2_798/net6 WX2126 VDD VDD pmos W=0.41u L=0.04u
M8269 WX2187 AND2_797/net6 VSS VSS nmos W=0.31u L=0.04u
M8270 AND2_797/X_u2-net6 RESET VSS VSS nmos W=0.31u L=0.04u
M8271 AND2_797/net6 WX2124 AND2_797/X_u2-net6 VSS nmos W=0.31u L=0.04u
M8272 WX2187 AND2_797/net6 VDD VDD pmos W=0.41u L=0.04u
M8273 AND2_797/net6 RESET VDD VDD pmos W=0.41u L=0.04u
M8274 AND2_797/net6 WX2124 VDD VDD pmos W=0.41u L=0.04u
M8275 WX2185 AND2_796/net6 VSS VSS nmos W=0.31u L=0.04u
M8276 AND2_796/X_u2-net6 RESET VSS VSS nmos W=0.31u L=0.04u
M8277 AND2_796/net6 WX2122 AND2_796/X_u2-net6 VSS nmos W=0.31u L=0.04u
M8278 WX2185 AND2_796/net6 VDD VDD pmos W=0.41u L=0.04u
M8279 AND2_796/net6 RESET VDD VDD pmos W=0.41u L=0.04u
M8280 AND2_796/net6 WX2122 VDD VDD pmos W=0.41u L=0.04u
M8281 WX2183 AND2_795/net6 VSS VSS nmos W=0.31u L=0.04u
M8282 AND2_795/X_u2-net6 RESET VSS VSS nmos W=0.31u L=0.04u
M8283 AND2_795/net6 WX2120 AND2_795/X_u2-net6 VSS nmos W=0.31u L=0.04u
M8284 WX2183 AND2_795/net6 VDD VDD pmos W=0.41u L=0.04u
M8285 AND2_795/net6 RESET VDD VDD pmos W=0.41u L=0.04u
M8286 AND2_795/net6 WX2120 VDD VDD pmos W=0.41u L=0.04u
M8287 WX2181 AND2_794/net6 VSS VSS nmos W=0.31u L=0.04u
M8288 AND2_794/X_u2-net6 RESET VSS VSS nmos W=0.31u L=0.04u
M8289 AND2_794/net6 WX2118 AND2_794/X_u2-net6 VSS nmos W=0.31u L=0.04u
M8290 WX2181 AND2_794/net6 VDD VDD pmos W=0.41u L=0.04u
M8291 AND2_794/net6 RESET VDD VDD pmos W=0.41u L=0.04u
M8292 AND2_794/net6 WX2118 VDD VDD pmos W=0.41u L=0.04u
M8293 WX2179 AND2_793/net6 VSS VSS nmos W=0.31u L=0.04u
M8294 AND2_793/X_u2-net6 RESET VSS VSS nmos W=0.31u L=0.04u
M8295 AND2_793/net6 WX2116 AND2_793/X_u2-net6 VSS nmos W=0.31u L=0.04u
M8296 WX2179 AND2_793/net6 VDD VDD pmos W=0.41u L=0.04u
M8297 AND2_793/net6 RESET VDD VDD pmos W=0.41u L=0.04u
M8298 AND2_793/net6 WX2116 VDD VDD pmos W=0.41u L=0.04u
M8299 WX2177 AND2_792/net6 VSS VSS nmos W=0.31u L=0.04u
M8300 AND2_792/X_u2-net6 RESET VSS VSS nmos W=0.31u L=0.04u
M8301 AND2_792/net6 WX2114 AND2_792/X_u2-net6 VSS nmos W=0.31u L=0.04u
M8302 WX2177 AND2_792/net6 VDD VDD pmos W=0.41u L=0.04u
M8303 AND2_792/net6 RESET VDD VDD pmos W=0.41u L=0.04u
M8304 AND2_792/net6 WX2114 VDD VDD pmos W=0.41u L=0.04u
M8305 WX2175 AND2_791/net6 VSS VSS nmos W=0.31u L=0.04u
M8306 AND2_791/X_u2-net6 RESET VSS VSS nmos W=0.31u L=0.04u
M8307 AND2_791/net6 WX2112 AND2_791/X_u2-net6 VSS nmos W=0.31u L=0.04u
M8308 WX2175 AND2_791/net6 VDD VDD pmos W=0.41u L=0.04u
M8309 AND2_791/net6 RESET VDD VDD pmos W=0.41u L=0.04u
M8310 AND2_791/net6 WX2112 VDD VDD pmos W=0.41u L=0.04u
M8311 WX2173 AND2_790/net6 VSS VSS nmos W=0.31u L=0.04u
M8312 AND2_790/X_u2-net6 RESET VSS VSS nmos W=0.31u L=0.04u
M8313 AND2_790/net6 WX2110 AND2_790/X_u2-net6 VSS nmos W=0.31u L=0.04u
M8314 WX2173 AND2_790/net6 VDD VDD pmos W=0.41u L=0.04u
M8315 AND2_790/net6 RESET VDD VDD pmos W=0.41u L=0.04u
M8316 AND2_790/net6 WX2110 VDD VDD pmos W=0.41u L=0.04u
M8317 WX2171 AND2_789/net6 VSS VSS nmos W=0.31u L=0.04u
M8318 AND2_789/X_u2-net6 RESET VSS VSS nmos W=0.31u L=0.04u
M8319 AND2_789/net6 WX2108 AND2_789/X_u2-net6 VSS nmos W=0.31u L=0.04u
M8320 WX2171 AND2_789/net6 VDD VDD pmos W=0.41u L=0.04u
M8321 AND2_789/net6 RESET VDD VDD pmos W=0.41u L=0.04u
M8322 AND2_789/net6 WX2108 VDD VDD pmos W=0.41u L=0.04u
M8323 WX2169 AND2_788/net6 VSS VSS nmos W=0.31u L=0.04u
M8324 AND2_788/X_u2-net6 RESET VSS VSS nmos W=0.31u L=0.04u
M8325 AND2_788/net6 WX2106 AND2_788/X_u2-net6 VSS nmos W=0.31u L=0.04u
M8326 WX2169 AND2_788/net6 VDD VDD pmos W=0.41u L=0.04u
M8327 AND2_788/net6 RESET VDD VDD pmos W=0.41u L=0.04u
M8328 AND2_788/net6 WX2106 VDD VDD pmos W=0.41u L=0.04u
M8329 WX2167 AND2_787/net6 VSS VSS nmos W=0.31u L=0.04u
M8330 AND2_787/X_u2-net6 RESET VSS VSS nmos W=0.31u L=0.04u
M8331 AND2_787/net6 WX2104 AND2_787/X_u2-net6 VSS nmos W=0.31u L=0.04u
M8332 WX2167 AND2_787/net6 VDD VDD pmos W=0.41u L=0.04u
M8333 AND2_787/net6 RESET VDD VDD pmos W=0.41u L=0.04u
M8334 AND2_787/net6 WX2104 VDD VDD pmos W=0.41u L=0.04u
M8335 WX2165 AND2_786/net6 VSS VSS nmos W=0.31u L=0.04u
M8336 AND2_786/X_u2-net6 RESET VSS VSS nmos W=0.31u L=0.04u
M8337 AND2_786/net6 WX2102 AND2_786/X_u2-net6 VSS nmos W=0.31u L=0.04u
M8338 WX2165 AND2_786/net6 VDD VDD pmos W=0.41u L=0.04u
M8339 AND2_786/net6 RESET VDD VDD pmos W=0.41u L=0.04u
M8340 AND2_786/net6 WX2102 VDD VDD pmos W=0.41u L=0.04u
M8341 WX2163 AND2_785/net6 VSS VSS nmos W=0.31u L=0.04u
M8342 AND2_785/X_u2-net6 RESET VSS VSS nmos W=0.31u L=0.04u
M8343 AND2_785/net6 WX2100 AND2_785/X_u2-net6 VSS nmos W=0.31u L=0.04u
M8344 WX2163 AND2_785/net6 VDD VDD pmos W=0.41u L=0.04u
M8345 AND2_785/net6 RESET VDD VDD pmos W=0.41u L=0.04u
M8346 AND2_785/net6 WX2100 VDD VDD pmos W=0.41u L=0.04u
M8347 WX2161 AND2_784/net6 VSS VSS nmos W=0.31u L=0.04u
M8348 AND2_784/X_u2-net6 RESET VSS VSS nmos W=0.31u L=0.04u
M8349 AND2_784/net6 WX2098 AND2_784/X_u2-net6 VSS nmos W=0.31u L=0.04u
M8350 WX2161 AND2_784/net6 VDD VDD pmos W=0.41u L=0.04u
M8351 AND2_784/net6 RESET VDD VDD pmos W=0.41u L=0.04u
M8352 AND2_784/net6 WX2098 VDD VDD pmos W=0.41u L=0.04u
M8353 WX2159 AND2_783/net6 VSS VSS nmos W=0.31u L=0.04u
M8354 AND2_783/X_u2-net6 RESET VSS VSS nmos W=0.31u L=0.04u
M8355 AND2_783/net6 WX2096 AND2_783/X_u2-net6 VSS nmos W=0.31u L=0.04u
M8356 WX2159 AND2_783/net6 VDD VDD pmos W=0.41u L=0.04u
M8357 AND2_783/net6 RESET VDD VDD pmos W=0.41u L=0.04u
M8358 AND2_783/net6 WX2096 VDD VDD pmos W=0.41u L=0.04u
M8359 WX2157 AND2_782/net6 VSS VSS nmos W=0.31u L=0.04u
M8360 AND2_782/X_u2-net6 RESET VSS VSS nmos W=0.31u L=0.04u
M8361 AND2_782/net6 WX2094 AND2_782/X_u2-net6 VSS nmos W=0.31u L=0.04u
M8362 WX2157 AND2_782/net6 VDD VDD pmos W=0.41u L=0.04u
M8363 AND2_782/net6 RESET VDD VDD pmos W=0.41u L=0.04u
M8364 AND2_782/net6 WX2094 VDD VDD pmos W=0.41u L=0.04u
M8365 WX2155 AND2_781/net6 VSS VSS nmos W=0.31u L=0.04u
M8366 AND2_781/X_u2-net6 RESET VSS VSS nmos W=0.31u L=0.04u
M8367 AND2_781/net6 WX2092 AND2_781/X_u2-net6 VSS nmos W=0.31u L=0.04u
M8368 WX2155 AND2_781/net6 VDD VDD pmos W=0.41u L=0.04u
M8369 AND2_781/net6 RESET VDD VDD pmos W=0.41u L=0.04u
M8370 AND2_781/net6 WX2092 VDD VDD pmos W=0.41u L=0.04u
M8371 WX2153 AND2_780/net6 VSS VSS nmos W=0.31u L=0.04u
M8372 AND2_780/X_u2-net6 RESET VSS VSS nmos W=0.31u L=0.04u
M8373 AND2_780/net6 WX2090 AND2_780/X_u2-net6 VSS nmos W=0.31u L=0.04u
M8374 WX2153 AND2_780/net6 VDD VDD pmos W=0.41u L=0.04u
M8375 AND2_780/net6 RESET VDD VDD pmos W=0.41u L=0.04u
M8376 AND2_780/net6 WX2090 VDD VDD pmos W=0.41u L=0.04u
M8377 WX2151 AND2_779/net6 VSS VSS nmos W=0.31u L=0.04u
M8378 AND2_779/X_u2-net6 RESET VSS VSS nmos W=0.31u L=0.04u
M8379 AND2_779/net6 WX2088 AND2_779/X_u2-net6 VSS nmos W=0.31u L=0.04u
M8380 WX2151 AND2_779/net6 VDD VDD pmos W=0.41u L=0.04u
M8381 AND2_779/net6 RESET VDD VDD pmos W=0.41u L=0.04u
M8382 AND2_779/net6 WX2088 VDD VDD pmos W=0.41u L=0.04u
M8383 WX2149 AND2_778/net6 VSS VSS nmos W=0.31u L=0.04u
M8384 AND2_778/X_u2-net6 RESET VSS VSS nmos W=0.31u L=0.04u
M8385 AND2_778/net6 WX2086 AND2_778/X_u2-net6 VSS nmos W=0.31u L=0.04u
M8386 WX2149 AND2_778/net6 VDD VDD pmos W=0.41u L=0.04u
M8387 AND2_778/net6 RESET VDD VDD pmos W=0.41u L=0.04u
M8388 AND2_778/net6 WX2086 VDD VDD pmos W=0.41u L=0.04u
M8389 WX2147 AND2_777/net6 VSS VSS nmos W=0.31u L=0.04u
M8390 AND2_777/X_u2-net6 RESET VSS VSS nmos W=0.31u L=0.04u
M8391 AND2_777/net6 WX2084 AND2_777/X_u2-net6 VSS nmos W=0.31u L=0.04u
M8392 WX2147 AND2_777/net6 VDD VDD pmos W=0.41u L=0.04u
M8393 AND2_777/net6 RESET VDD VDD pmos W=0.41u L=0.04u
M8394 AND2_777/net6 WX2084 VDD VDD pmos W=0.41u L=0.04u
M8395 WX2145 AND2_776/net6 VSS VSS nmos W=0.31u L=0.04u
M8396 AND2_776/X_u2-net6 RESET VSS VSS nmos W=0.31u L=0.04u
M8397 AND2_776/net6 WX2082 AND2_776/X_u2-net6 VSS nmos W=0.31u L=0.04u
M8398 WX2145 AND2_776/net6 VDD VDD pmos W=0.41u L=0.04u
M8399 AND2_776/net6 RESET VDD VDD pmos W=0.41u L=0.04u
M8400 AND2_776/net6 WX2082 VDD VDD pmos W=0.41u L=0.04u
M8401 WX2143 AND2_775/net6 VSS VSS nmos W=0.31u L=0.04u
M8402 AND2_775/X_u2-net6 RESET VSS VSS nmos W=0.31u L=0.04u
M8403 AND2_775/net6 WX2080 AND2_775/X_u2-net6 VSS nmos W=0.31u L=0.04u
M8404 WX2143 AND2_775/net6 VDD VDD pmos W=0.41u L=0.04u
M8405 AND2_775/net6 RESET VDD VDD pmos W=0.41u L=0.04u
M8406 AND2_775/net6 WX2080 VDD VDD pmos W=0.41u L=0.04u
M8407 WX2141 AND2_774/net6 VSS VSS nmos W=0.31u L=0.04u
M8408 AND2_774/X_u2-net6 RESET VSS VSS nmos W=0.31u L=0.04u
M8409 AND2_774/net6 WX2078 AND2_774/X_u2-net6 VSS nmos W=0.31u L=0.04u
M8410 WX2141 AND2_774/net6 VDD VDD pmos W=0.41u L=0.04u
M8411 AND2_774/net6 RESET VDD VDD pmos W=0.41u L=0.04u
M8412 AND2_774/net6 WX2078 VDD VDD pmos W=0.41u L=0.04u
M8413 WX2139 AND2_773/net6 VSS VSS nmos W=0.31u L=0.04u
M8414 AND2_773/X_u2-net6 RESET VSS VSS nmos W=0.31u L=0.04u
M8415 AND2_773/net6 WX2076 AND2_773/X_u2-net6 VSS nmos W=0.31u L=0.04u
M8416 WX2139 AND2_773/net6 VDD VDD pmos W=0.41u L=0.04u
M8417 AND2_773/net6 RESET VDD VDD pmos W=0.41u L=0.04u
M8418 AND2_773/net6 WX2076 VDD VDD pmos W=0.41u L=0.04u
M8419 WX2137 AND2_772/net6 VSS VSS nmos W=0.31u L=0.04u
M8420 AND2_772/X_u2-net6 RESET VSS VSS nmos W=0.31u L=0.04u
M8421 AND2_772/net6 WX2074 AND2_772/X_u2-net6 VSS nmos W=0.31u L=0.04u
M8422 WX2137 AND2_772/net6 VDD VDD pmos W=0.41u L=0.04u
M8423 AND2_772/net6 RESET VDD VDD pmos W=0.41u L=0.04u
M8424 AND2_772/net6 WX2074 VDD VDD pmos W=0.41u L=0.04u
M8425 WX2135 AND2_771/net6 VSS VSS nmos W=0.31u L=0.04u
M8426 AND2_771/X_u2-net6 RESET VSS VSS nmos W=0.31u L=0.04u
M8427 AND2_771/net6 WX2072 AND2_771/X_u2-net6 VSS nmos W=0.31u L=0.04u
M8428 WX2135 AND2_771/net6 VDD VDD pmos W=0.41u L=0.04u
M8429 AND2_771/net6 RESET VDD VDD pmos W=0.41u L=0.04u
M8430 AND2_771/net6 WX2072 VDD VDD pmos W=0.41u L=0.04u
M8431 WX2133 AND2_770/net6 VSS VSS nmos W=0.31u L=0.04u
M8432 AND2_770/X_u2-net6 RESET VSS VSS nmos W=0.31u L=0.04u
M8433 AND2_770/net6 WX2070 AND2_770/X_u2-net6 VSS nmos W=0.31u L=0.04u
M8434 WX2133 AND2_770/net6 VDD VDD pmos W=0.41u L=0.04u
M8435 AND2_770/net6 RESET VDD VDD pmos W=0.41u L=0.04u
M8436 AND2_770/net6 WX2070 VDD VDD pmos W=0.41u L=0.04u
M8437 WX2131 AND2_769/net6 VSS VSS nmos W=0.31u L=0.04u
M8438 AND2_769/X_u2-net6 RESET VSS VSS nmos W=0.31u L=0.04u
M8439 AND2_769/net6 WX2068 AND2_769/X_u2-net6 VSS nmos W=0.31u L=0.04u
M8440 WX2131 AND2_769/net6 VDD VDD pmos W=0.41u L=0.04u
M8441 AND2_769/net6 RESET VDD VDD pmos W=0.41u L=0.04u
M8442 AND2_769/net6 WX2068 VDD VDD pmos W=0.41u L=0.04u
M8443 WX2129 AND2_768/net6 VSS VSS nmos W=0.31u L=0.04u
M8444 AND2_768/X_u2-net6 RESET VSS VSS nmos W=0.31u L=0.04u
M8445 AND2_768/net6 WX2066 AND2_768/X_u2-net6 VSS nmos W=0.31u L=0.04u
M8446 WX2129 AND2_768/net6 VDD VDD pmos W=0.41u L=0.04u
M8447 AND2_768/net6 RESET VDD VDD pmos W=0.41u L=0.04u
M8448 AND2_768/net6 WX2066 VDD VDD pmos W=0.41u L=0.04u
M8449 WX2127 AND2_767/net6 VSS VSS nmos W=0.31u L=0.04u
M8450 AND2_767/X_u2-net6 RESET VSS VSS nmos W=0.31u L=0.04u
M8451 AND2_767/net6 WX2064 AND2_767/X_u2-net6 VSS nmos W=0.31u L=0.04u
M8452 WX2127 AND2_767/net6 VDD VDD pmos W=0.41u L=0.04u
M8453 AND2_767/net6 RESET VDD VDD pmos W=0.41u L=0.04u
M8454 AND2_767/net6 WX2064 VDD VDD pmos W=0.41u L=0.04u
M8455 WX2125 AND2_766/net6 VSS VSS nmos W=0.31u L=0.04u
M8456 AND2_766/X_u2-net6 RESET VSS VSS nmos W=0.31u L=0.04u
M8457 AND2_766/net6 WX2062 AND2_766/X_u2-net6 VSS nmos W=0.31u L=0.04u
M8458 WX2125 AND2_766/net6 VDD VDD pmos W=0.41u L=0.04u
M8459 AND2_766/net6 RESET VDD VDD pmos W=0.41u L=0.04u
M8460 AND2_766/net6 WX2062 VDD VDD pmos W=0.41u L=0.04u
M8461 WX2123 AND2_765/net6 VSS VSS nmos W=0.31u L=0.04u
M8462 AND2_765/X_u2-net6 RESET VSS VSS nmos W=0.31u L=0.04u
M8463 AND2_765/net6 WX2060 AND2_765/X_u2-net6 VSS nmos W=0.31u L=0.04u
M8464 WX2123 AND2_765/net6 VDD VDD pmos W=0.41u L=0.04u
M8465 AND2_765/net6 RESET VDD VDD pmos W=0.41u L=0.04u
M8466 AND2_765/net6 WX2060 VDD VDD pmos W=0.41u L=0.04u
M8467 WX2121 AND2_764/net6 VSS VSS nmos W=0.31u L=0.04u
M8468 AND2_764/X_u2-net6 RESET VSS VSS nmos W=0.31u L=0.04u
M8469 AND2_764/net6 WX2058 AND2_764/X_u2-net6 VSS nmos W=0.31u L=0.04u
M8470 WX2121 AND2_764/net6 VDD VDD pmos W=0.41u L=0.04u
M8471 AND2_764/net6 RESET VDD VDD pmos W=0.41u L=0.04u
M8472 AND2_764/net6 WX2058 VDD VDD pmos W=0.41u L=0.04u
M8473 WX2119 AND2_763/net6 VSS VSS nmos W=0.31u L=0.04u
M8474 AND2_763/X_u2-net6 RESET VSS VSS nmos W=0.31u L=0.04u
M8475 AND2_763/net6 WX2056 AND2_763/X_u2-net6 VSS nmos W=0.31u L=0.04u
M8476 WX2119 AND2_763/net6 VDD VDD pmos W=0.41u L=0.04u
M8477 AND2_763/net6 RESET VDD VDD pmos W=0.41u L=0.04u
M8478 AND2_763/net6 WX2056 VDD VDD pmos W=0.41u L=0.04u
M8479 WX2117 AND2_762/net6 VSS VSS nmos W=0.31u L=0.04u
M8480 AND2_762/X_u2-net6 RESET VSS VSS nmos W=0.31u L=0.04u
M8481 AND2_762/net6 WX2054 AND2_762/X_u2-net6 VSS nmos W=0.31u L=0.04u
M8482 WX2117 AND2_762/net6 VDD VDD pmos W=0.41u L=0.04u
M8483 AND2_762/net6 RESET VDD VDD pmos W=0.41u L=0.04u
M8484 AND2_762/net6 WX2054 VDD VDD pmos W=0.41u L=0.04u
M8485 WX2115 AND2_761/net6 VSS VSS nmos W=0.31u L=0.04u
M8486 AND2_761/X_u2-net6 RESET VSS VSS nmos W=0.31u L=0.04u
M8487 AND2_761/net6 WX2052 AND2_761/X_u2-net6 VSS nmos W=0.31u L=0.04u
M8488 WX2115 AND2_761/net6 VDD VDD pmos W=0.41u L=0.04u
M8489 AND2_761/net6 RESET VDD VDD pmos W=0.41u L=0.04u
M8490 AND2_761/net6 WX2052 VDD VDD pmos W=0.41u L=0.04u
M8491 WX2113 AND2_760/net6 VSS VSS nmos W=0.31u L=0.04u
M8492 AND2_760/X_u2-net6 RESET VSS VSS nmos W=0.31u L=0.04u
M8493 AND2_760/net6 WX2050 AND2_760/X_u2-net6 VSS nmos W=0.31u L=0.04u
M8494 WX2113 AND2_760/net6 VDD VDD pmos W=0.41u L=0.04u
M8495 AND2_760/net6 RESET VDD VDD pmos W=0.41u L=0.04u
M8496 AND2_760/net6 WX2050 VDD VDD pmos W=0.41u L=0.04u
M8497 WX2111 AND2_759/net6 VSS VSS nmos W=0.31u L=0.04u
M8498 AND2_759/X_u2-net6 RESET VSS VSS nmos W=0.31u L=0.04u
M8499 AND2_759/net6 WX2048 AND2_759/X_u2-net6 VSS nmos W=0.31u L=0.04u
M8500 WX2111 AND2_759/net6 VDD VDD pmos W=0.41u L=0.04u
M8501 AND2_759/net6 RESET VDD VDD pmos W=0.41u L=0.04u
M8502 AND2_759/net6 WX2048 VDD VDD pmos W=0.41u L=0.04u
M8503 WX2109 AND2_758/net6 VSS VSS nmos W=0.31u L=0.04u
M8504 AND2_758/X_u2-net6 RESET VSS VSS nmos W=0.31u L=0.04u
M8505 AND2_758/net6 WX2046 AND2_758/X_u2-net6 VSS nmos W=0.31u L=0.04u
M8506 WX2109 AND2_758/net6 VDD VDD pmos W=0.41u L=0.04u
M8507 AND2_758/net6 RESET VDD VDD pmos W=0.41u L=0.04u
M8508 AND2_758/net6 WX2046 VDD VDD pmos W=0.41u L=0.04u
M8509 WX2107 AND2_757/net6 VSS VSS nmos W=0.31u L=0.04u
M8510 AND2_757/X_u2-net6 RESET VSS VSS nmos W=0.31u L=0.04u
M8511 AND2_757/net6 WX2044 AND2_757/X_u2-net6 VSS nmos W=0.31u L=0.04u
M8512 WX2107 AND2_757/net6 VDD VDD pmos W=0.41u L=0.04u
M8513 AND2_757/net6 RESET VDD VDD pmos W=0.41u L=0.04u
M8514 AND2_757/net6 WX2044 VDD VDD pmos W=0.41u L=0.04u
M8515 WX2105 AND2_756/net6 VSS VSS nmos W=0.31u L=0.04u
M8516 AND2_756/X_u2-net6 RESET VSS VSS nmos W=0.31u L=0.04u
M8517 AND2_756/net6 WX2042 AND2_756/X_u2-net6 VSS nmos W=0.31u L=0.04u
M8518 WX2105 AND2_756/net6 VDD VDD pmos W=0.41u L=0.04u
M8519 AND2_756/net6 RESET VDD VDD pmos W=0.41u L=0.04u
M8520 AND2_756/net6 WX2042 VDD VDD pmos W=0.41u L=0.04u
M8521 WX2103 AND2_755/net6 VSS VSS nmos W=0.31u L=0.04u
M8522 AND2_755/X_u2-net6 RESET VSS VSS nmos W=0.31u L=0.04u
M8523 AND2_755/net6 WX2040 AND2_755/X_u2-net6 VSS nmos W=0.31u L=0.04u
M8524 WX2103 AND2_755/net6 VDD VDD pmos W=0.41u L=0.04u
M8525 AND2_755/net6 RESET VDD VDD pmos W=0.41u L=0.04u
M8526 AND2_755/net6 WX2040 VDD VDD pmos W=0.41u L=0.04u
M8527 WX2101 AND2_754/net6 VSS VSS nmos W=0.31u L=0.04u
M8528 AND2_754/X_u2-net6 RESET VSS VSS nmos W=0.31u L=0.04u
M8529 AND2_754/net6 WX2038 AND2_754/X_u2-net6 VSS nmos W=0.31u L=0.04u
M8530 WX2101 AND2_754/net6 VDD VDD pmos W=0.41u L=0.04u
M8531 AND2_754/net6 RESET VDD VDD pmos W=0.41u L=0.04u
M8532 AND2_754/net6 WX2038 VDD VDD pmos W=0.41u L=0.04u
M8533 WX2099 AND2_753/net6 VSS VSS nmos W=0.31u L=0.04u
M8534 AND2_753/X_u2-net6 RESET VSS VSS nmos W=0.31u L=0.04u
M8535 AND2_753/net6 WX2036 AND2_753/X_u2-net6 VSS nmos W=0.31u L=0.04u
M8536 WX2099 AND2_753/net6 VDD VDD pmos W=0.41u L=0.04u
M8537 AND2_753/net6 RESET VDD VDD pmos W=0.41u L=0.04u
M8538 AND2_753/net6 WX2036 VDD VDD pmos W=0.41u L=0.04u
M8539 WX2097 AND2_752/net6 VSS VSS nmos W=0.31u L=0.04u
M8540 AND2_752/X_u2-net6 RESET VSS VSS nmos W=0.31u L=0.04u
M8541 AND2_752/net6 WX2034 AND2_752/X_u2-net6 VSS nmos W=0.31u L=0.04u
M8542 WX2097 AND2_752/net6 VDD VDD pmos W=0.41u L=0.04u
M8543 AND2_752/net6 RESET VDD VDD pmos W=0.41u L=0.04u
M8544 AND2_752/net6 WX2034 VDD VDD pmos W=0.41u L=0.04u
M8545 WX2095 AND2_751/net6 VSS VSS nmos W=0.31u L=0.04u
M8546 AND2_751/X_u2-net6 RESET VSS VSS nmos W=0.31u L=0.04u
M8547 AND2_751/net6 WX2032 AND2_751/X_u2-net6 VSS nmos W=0.31u L=0.04u
M8548 WX2095 AND2_751/net6 VDD VDD pmos W=0.41u L=0.04u
M8549 AND2_751/net6 RESET VDD VDD pmos W=0.41u L=0.04u
M8550 AND2_751/net6 WX2032 VDD VDD pmos W=0.41u L=0.04u
M8551 WX2093 AND2_750/net6 VSS VSS nmos W=0.31u L=0.04u
M8552 AND2_750/X_u2-net6 RESET VSS VSS nmos W=0.31u L=0.04u
M8553 AND2_750/net6 WX2030 AND2_750/X_u2-net6 VSS nmos W=0.31u L=0.04u
M8554 WX2093 AND2_750/net6 VDD VDD pmos W=0.41u L=0.04u
M8555 AND2_750/net6 RESET VDD VDD pmos W=0.41u L=0.04u
M8556 AND2_750/net6 WX2030 VDD VDD pmos W=0.41u L=0.04u
M8557 WX2091 AND2_749/net6 VSS VSS nmos W=0.31u L=0.04u
M8558 AND2_749/X_u2-net6 RESET VSS VSS nmos W=0.31u L=0.04u
M8559 AND2_749/net6 WX2028 AND2_749/X_u2-net6 VSS nmos W=0.31u L=0.04u
M8560 WX2091 AND2_749/net6 VDD VDD pmos W=0.41u L=0.04u
M8561 AND2_749/net6 RESET VDD VDD pmos W=0.41u L=0.04u
M8562 AND2_749/net6 WX2028 VDD VDD pmos W=0.41u L=0.04u
M8563 WX2089 AND2_748/net6 VSS VSS nmos W=0.31u L=0.04u
M8564 AND2_748/X_u2-net6 RESET VSS VSS nmos W=0.31u L=0.04u
M8565 AND2_748/net6 WX2026 AND2_748/X_u2-net6 VSS nmos W=0.31u L=0.04u
M8566 WX2089 AND2_748/net6 VDD VDD pmos W=0.41u L=0.04u
M8567 AND2_748/net6 RESET VDD VDD pmos W=0.41u L=0.04u
M8568 AND2_748/net6 WX2026 VDD VDD pmos W=0.41u L=0.04u
M8569 WX2087 AND2_747/net6 VSS VSS nmos W=0.31u L=0.04u
M8570 AND2_747/X_u2-net6 RESET VSS VSS nmos W=0.31u L=0.04u
M8571 AND2_747/net6 WX2024 AND2_747/X_u2-net6 VSS nmos W=0.31u L=0.04u
M8572 WX2087 AND2_747/net6 VDD VDD pmos W=0.41u L=0.04u
M8573 AND2_747/net6 RESET VDD VDD pmos W=0.41u L=0.04u
M8574 AND2_747/net6 WX2024 VDD VDD pmos W=0.41u L=0.04u
M8575 WX2085 AND2_746/net6 VSS VSS nmos W=0.31u L=0.04u
M8576 AND2_746/X_u2-net6 RESET VSS VSS nmos W=0.31u L=0.04u
M8577 AND2_746/net6 WX2022 AND2_746/X_u2-net6 VSS nmos W=0.31u L=0.04u
M8578 WX2085 AND2_746/net6 VDD VDD pmos W=0.41u L=0.04u
M8579 AND2_746/net6 RESET VDD VDD pmos W=0.41u L=0.04u
M8580 AND2_746/net6 WX2022 VDD VDD pmos W=0.41u L=0.04u
M8581 WX2083 AND2_745/net6 VSS VSS nmos W=0.31u L=0.04u
M8582 AND2_745/X_u2-net6 RESET VSS VSS nmos W=0.31u L=0.04u
M8583 AND2_745/net6 WX2020 AND2_745/X_u2-net6 VSS nmos W=0.31u L=0.04u
M8584 WX2083 AND2_745/net6 VDD VDD pmos W=0.41u L=0.04u
M8585 AND2_745/net6 RESET VDD VDD pmos W=0.41u L=0.04u
M8586 AND2_745/net6 WX2020 VDD VDD pmos W=0.41u L=0.04u
M8587 WX2081 AND2_744/net6 VSS VSS nmos W=0.31u L=0.04u
M8588 AND2_744/X_u2-net6 RESET VSS VSS nmos W=0.31u L=0.04u
M8589 AND2_744/net6 WX2018 AND2_744/X_u2-net6 VSS nmos W=0.31u L=0.04u
M8590 WX2081 AND2_744/net6 VDD VDD pmos W=0.41u L=0.04u
M8591 AND2_744/net6 RESET VDD VDD pmos W=0.41u L=0.04u
M8592 AND2_744/net6 WX2018 VDD VDD pmos W=0.41u L=0.04u
M8593 WX2079 AND2_743/net6 VSS VSS nmos W=0.31u L=0.04u
M8594 AND2_743/X_u2-net6 RESET VSS VSS nmos W=0.31u L=0.04u
M8595 AND2_743/net6 WX2016 AND2_743/X_u2-net6 VSS nmos W=0.31u L=0.04u
M8596 WX2079 AND2_743/net6 VDD VDD pmos W=0.41u L=0.04u
M8597 AND2_743/net6 RESET VDD VDD pmos W=0.41u L=0.04u
M8598 AND2_743/net6 WX2016 VDD VDD pmos W=0.41u L=0.04u
M8599 WX2077 AND2_742/net6 VSS VSS nmos W=0.31u L=0.04u
M8600 AND2_742/X_u2-net6 RESET VSS VSS nmos W=0.31u L=0.04u
M8601 AND2_742/net6 WX2014 AND2_742/X_u2-net6 VSS nmos W=0.31u L=0.04u
M8602 WX2077 AND2_742/net6 VDD VDD pmos W=0.41u L=0.04u
M8603 AND2_742/net6 RESET VDD VDD pmos W=0.41u L=0.04u
M8604 AND2_742/net6 WX2014 VDD VDD pmos W=0.41u L=0.04u
M8605 WX2075 AND2_741/net6 VSS VSS nmos W=0.31u L=0.04u
M8606 AND2_741/X_u2-net6 RESET VSS VSS nmos W=0.31u L=0.04u
M8607 AND2_741/net6 WX2012 AND2_741/X_u2-net6 VSS nmos W=0.31u L=0.04u
M8608 WX2075 AND2_741/net6 VDD VDD pmos W=0.41u L=0.04u
M8609 AND2_741/net6 RESET VDD VDD pmos W=0.41u L=0.04u
M8610 AND2_741/net6 WX2012 VDD VDD pmos W=0.41u L=0.04u
M8611 WX2073 AND2_740/net6 VSS VSS nmos W=0.31u L=0.04u
M8612 AND2_740/X_u2-net6 RESET VSS VSS nmos W=0.31u L=0.04u
M8613 AND2_740/net6 WX2010 AND2_740/X_u2-net6 VSS nmos W=0.31u L=0.04u
M8614 WX2073 AND2_740/net6 VDD VDD pmos W=0.41u L=0.04u
M8615 AND2_740/net6 RESET VDD VDD pmos W=0.41u L=0.04u
M8616 AND2_740/net6 WX2010 VDD VDD pmos W=0.41u L=0.04u
M8617 WX2071 AND2_739/net6 VSS VSS nmos W=0.31u L=0.04u
M8618 AND2_739/X_u2-net6 RESET VSS VSS nmos W=0.31u L=0.04u
M8619 AND2_739/net6 WX2008 AND2_739/X_u2-net6 VSS nmos W=0.31u L=0.04u
M8620 WX2071 AND2_739/net6 VDD VDD pmos W=0.41u L=0.04u
M8621 AND2_739/net6 RESET VDD VDD pmos W=0.41u L=0.04u
M8622 AND2_739/net6 WX2008 VDD VDD pmos W=0.41u L=0.04u
M8623 WX2069 AND2_738/net6 VSS VSS nmos W=0.31u L=0.04u
M8624 AND2_738/X_u2-net6 RESET VSS VSS nmos W=0.31u L=0.04u
M8625 AND2_738/net6 WX2006 AND2_738/X_u2-net6 VSS nmos W=0.31u L=0.04u
M8626 WX2069 AND2_738/net6 VDD VDD pmos W=0.41u L=0.04u
M8627 AND2_738/net6 RESET VDD VDD pmos W=0.41u L=0.04u
M8628 AND2_738/net6 WX2006 VDD VDD pmos W=0.41u L=0.04u
M8629 WX2067 AND2_737/net6 VSS VSS nmos W=0.31u L=0.04u
M8630 AND2_737/X_u2-net6 RESET VSS VSS nmos W=0.31u L=0.04u
M8631 AND2_737/net6 WX2004 AND2_737/X_u2-net6 VSS nmos W=0.31u L=0.04u
M8632 WX2067 AND2_737/net6 VDD VDD pmos W=0.41u L=0.04u
M8633 AND2_737/net6 RESET VDD VDD pmos W=0.41u L=0.04u
M8634 AND2_737/net6 WX2004 VDD VDD pmos W=0.41u L=0.04u
M8635 WX2065 AND2_736/net6 VSS VSS nmos W=0.31u L=0.04u
M8636 AND2_736/X_u2-net6 RESET VSS VSS nmos W=0.31u L=0.04u
M8637 AND2_736/net6 WX2002 AND2_736/X_u2-net6 VSS nmos W=0.31u L=0.04u
M8638 WX2065 AND2_736/net6 VDD VDD pmos W=0.41u L=0.04u
M8639 AND2_736/net6 RESET VDD VDD pmos W=0.41u L=0.04u
M8640 AND2_736/net6 WX2002 VDD VDD pmos W=0.41u L=0.04u
M8641 WX2063 AND2_735/net6 VSS VSS nmos W=0.31u L=0.04u
M8642 AND2_735/X_u2-net6 RESET VSS VSS nmos W=0.31u L=0.04u
M8643 AND2_735/net6 WX2000 AND2_735/X_u2-net6 VSS nmos W=0.31u L=0.04u
M8644 WX2063 AND2_735/net6 VDD VDD pmos W=0.41u L=0.04u
M8645 AND2_735/net6 RESET VDD VDD pmos W=0.41u L=0.04u
M8646 AND2_735/net6 WX2000 VDD VDD pmos W=0.41u L=0.04u
M8647 WX2061 AND2_734/net6 VSS VSS nmos W=0.31u L=0.04u
M8648 AND2_734/X_u2-net6 RESET VSS VSS nmos W=0.31u L=0.04u
M8649 AND2_734/net6 WX1998 AND2_734/X_u2-net6 VSS nmos W=0.31u L=0.04u
M8650 WX2061 AND2_734/net6 VDD VDD pmos W=0.41u L=0.04u
M8651 AND2_734/net6 RESET VDD VDD pmos W=0.41u L=0.04u
M8652 AND2_734/net6 WX1998 VDD VDD pmos W=0.41u L=0.04u
M8653 WX2059 AND2_733/net6 VSS VSS nmos W=0.31u L=0.04u
M8654 AND2_733/X_u2-net6 RESET VSS VSS nmos W=0.31u L=0.04u
M8655 AND2_733/net6 WX1996 AND2_733/X_u2-net6 VSS nmos W=0.31u L=0.04u
M8656 WX2059 AND2_733/net6 VDD VDD pmos W=0.41u L=0.04u
M8657 AND2_733/net6 RESET VDD VDD pmos W=0.41u L=0.04u
M8658 AND2_733/net6 WX1996 VDD VDD pmos W=0.41u L=0.04u
M8659 WX2057 AND2_732/net6 VSS VSS nmos W=0.31u L=0.04u
M8660 AND2_732/X_u2-net6 RESET VSS VSS nmos W=0.31u L=0.04u
M8661 AND2_732/net6 WX1994 AND2_732/X_u2-net6 VSS nmos W=0.31u L=0.04u
M8662 WX2057 AND2_732/net6 VDD VDD pmos W=0.41u L=0.04u
M8663 AND2_732/net6 RESET VDD VDD pmos W=0.41u L=0.04u
M8664 AND2_732/net6 WX1994 VDD VDD pmos W=0.41u L=0.04u
M8665 WX2055 AND2_731/net6 VSS VSS nmos W=0.31u L=0.04u
M8666 AND2_731/X_u2-net6 RESET VSS VSS nmos W=0.31u L=0.04u
M8667 AND2_731/net6 WX1992 AND2_731/X_u2-net6 VSS nmos W=0.31u L=0.04u
M8668 WX2055 AND2_731/net6 VDD VDD pmos W=0.41u L=0.04u
M8669 AND2_731/net6 RESET VDD VDD pmos W=0.41u L=0.04u
M8670 AND2_731/net6 WX1992 VDD VDD pmos W=0.41u L=0.04u
M8671 WX2053 AND2_730/net6 VSS VSS nmos W=0.31u L=0.04u
M8672 AND2_730/X_u2-net6 RESET VSS VSS nmos W=0.31u L=0.04u
M8673 AND2_730/net6 WX1990 AND2_730/X_u2-net6 VSS nmos W=0.31u L=0.04u
M8674 WX2053 AND2_730/net6 VDD VDD pmos W=0.41u L=0.04u
M8675 AND2_730/net6 RESET VDD VDD pmos W=0.41u L=0.04u
M8676 AND2_730/net6 WX1990 VDD VDD pmos W=0.41u L=0.04u
M8677 WX2051 AND2_729/net6 VSS VSS nmos W=0.31u L=0.04u
M8678 AND2_729/X_u2-net6 RESET VSS VSS nmos W=0.31u L=0.04u
M8679 AND2_729/net6 WX1988 AND2_729/X_u2-net6 VSS nmos W=0.31u L=0.04u
M8680 WX2051 AND2_729/net6 VDD VDD pmos W=0.41u L=0.04u
M8681 AND2_729/net6 RESET VDD VDD pmos W=0.41u L=0.04u
M8682 AND2_729/net6 WX1988 VDD VDD pmos W=0.41u L=0.04u
M8683 WX2049 AND2_728/net6 VSS VSS nmos W=0.31u L=0.04u
M8684 AND2_728/X_u2-net6 RESET VSS VSS nmos W=0.31u L=0.04u
M8685 AND2_728/net6 WX1986 AND2_728/X_u2-net6 VSS nmos W=0.31u L=0.04u
M8686 WX2049 AND2_728/net6 VDD VDD pmos W=0.41u L=0.04u
M8687 AND2_728/net6 RESET VDD VDD pmos W=0.41u L=0.04u
M8688 AND2_728/net6 WX1986 VDD VDD pmos W=0.41u L=0.04u
M8689 WX2047 AND2_727/net6 VSS VSS nmos W=0.31u L=0.04u
M8690 AND2_727/X_u2-net6 RESET VSS VSS nmos W=0.31u L=0.04u
M8691 AND2_727/net6 WX1984 AND2_727/X_u2-net6 VSS nmos W=0.31u L=0.04u
M8692 WX2047 AND2_727/net6 VDD VDD pmos W=0.41u L=0.04u
M8693 AND2_727/net6 RESET VDD VDD pmos W=0.41u L=0.04u
M8694 AND2_727/net6 WX1984 VDD VDD pmos W=0.41u L=0.04u
M8695 WX2045 AND2_726/net6 VSS VSS nmos W=0.31u L=0.04u
M8696 AND2_726/X_u2-net6 RESET VSS VSS nmos W=0.31u L=0.04u
M8697 AND2_726/net6 WX1982 AND2_726/X_u2-net6 VSS nmos W=0.31u L=0.04u
M8698 WX2045 AND2_726/net6 VDD VDD pmos W=0.41u L=0.04u
M8699 AND2_726/net6 RESET VDD VDD pmos W=0.41u L=0.04u
M8700 AND2_726/net6 WX1982 VDD VDD pmos W=0.41u L=0.04u
M8701 WX2043 AND2_725/net6 VSS VSS nmos W=0.31u L=0.04u
M8702 AND2_725/X_u2-net6 RESET VSS VSS nmos W=0.31u L=0.04u
M8703 AND2_725/net6 WX1980 AND2_725/X_u2-net6 VSS nmos W=0.31u L=0.04u
M8704 WX2043 AND2_725/net6 VDD VDD pmos W=0.41u L=0.04u
M8705 AND2_725/net6 RESET VDD VDD pmos W=0.41u L=0.04u
M8706 AND2_725/net6 WX1980 VDD VDD pmos W=0.41u L=0.04u
M8707 WX2041 AND2_724/net6 VSS VSS nmos W=0.31u L=0.04u
M8708 AND2_724/X_u2-net6 RESET VSS VSS nmos W=0.31u L=0.04u
M8709 AND2_724/net6 WX1978 AND2_724/X_u2-net6 VSS nmos W=0.31u L=0.04u
M8710 WX2041 AND2_724/net6 VDD VDD pmos W=0.41u L=0.04u
M8711 AND2_724/net6 RESET VDD VDD pmos W=0.41u L=0.04u
M8712 AND2_724/net6 WX1978 VDD VDD pmos W=0.41u L=0.04u
M8713 WX2039 AND2_723/net6 VSS VSS nmos W=0.31u L=0.04u
M8714 AND2_723/X_u2-net6 RESET VSS VSS nmos W=0.31u L=0.04u
M8715 AND2_723/net6 WX1976 AND2_723/X_u2-net6 VSS nmos W=0.31u L=0.04u
M8716 WX2039 AND2_723/net6 VDD VDD pmos W=0.41u L=0.04u
M8717 AND2_723/net6 RESET VDD VDD pmos W=0.41u L=0.04u
M8718 AND2_723/net6 WX1976 VDD VDD pmos W=0.41u L=0.04u
M8719 WX2037 AND2_722/net6 VSS VSS nmos W=0.31u L=0.04u
M8720 AND2_722/X_u2-net6 RESET VSS VSS nmos W=0.31u L=0.04u
M8721 AND2_722/net6 WX1974 AND2_722/X_u2-net6 VSS nmos W=0.31u L=0.04u
M8722 WX2037 AND2_722/net6 VDD VDD pmos W=0.41u L=0.04u
M8723 AND2_722/net6 RESET VDD VDD pmos W=0.41u L=0.04u
M8724 AND2_722/net6 WX1974 VDD VDD pmos W=0.41u L=0.04u
M8725 WX2035 AND2_721/net6 VSS VSS nmos W=0.31u L=0.04u
M8726 AND2_721/X_u2-net6 RESET VSS VSS nmos W=0.31u L=0.04u
M8727 AND2_721/net6 WX1972 AND2_721/X_u2-net6 VSS nmos W=0.31u L=0.04u
M8728 WX2035 AND2_721/net6 VDD VDD pmos W=0.41u L=0.04u
M8729 AND2_721/net6 RESET VDD VDD pmos W=0.41u L=0.04u
M8730 AND2_721/net6 WX1972 VDD VDD pmos W=0.41u L=0.04u
M8731 WX2033 AND2_720/net6 VSS VSS nmos W=0.31u L=0.04u
M8732 AND2_720/X_u2-net6 RESET VSS VSS nmos W=0.31u L=0.04u
M8733 AND2_720/net6 WX1970 AND2_720/X_u2-net6 VSS nmos W=0.31u L=0.04u
M8734 WX2033 AND2_720/net6 VDD VDD pmos W=0.41u L=0.04u
M8735 AND2_720/net6 RESET VDD VDD pmos W=0.41u L=0.04u
M8736 AND2_720/net6 WX1970 VDD VDD pmos W=0.41u L=0.04u
M8737 WX2031 AND2_719/net6 VSS VSS nmos W=0.31u L=0.04u
M8738 AND2_719/X_u2-net6 RESET VSS VSS nmos W=0.31u L=0.04u
M8739 AND2_719/net6 WX1968 AND2_719/X_u2-net6 VSS nmos W=0.31u L=0.04u
M8740 WX2031 AND2_719/net6 VDD VDD pmos W=0.41u L=0.04u
M8741 AND2_719/net6 RESET VDD VDD pmos W=0.41u L=0.04u
M8742 AND2_719/net6 WX1968 VDD VDD pmos W=0.41u L=0.04u
M8743 WX2029 AND2_718/net6 VSS VSS nmos W=0.31u L=0.04u
M8744 AND2_718/X_u2-net6 RESET VSS VSS nmos W=0.31u L=0.04u
M8745 AND2_718/net6 WX1966 AND2_718/X_u2-net6 VSS nmos W=0.31u L=0.04u
M8746 WX2029 AND2_718/net6 VDD VDD pmos W=0.41u L=0.04u
M8747 AND2_718/net6 RESET VDD VDD pmos W=0.41u L=0.04u
M8748 AND2_718/net6 WX1966 VDD VDD pmos W=0.41u L=0.04u
M8749 WX2027 AND2_717/net6 VSS VSS nmos W=0.31u L=0.04u
M8750 AND2_717/X_u2-net6 RESET VSS VSS nmos W=0.31u L=0.04u
M8751 AND2_717/net6 WX1964 AND2_717/X_u2-net6 VSS nmos W=0.31u L=0.04u
M8752 WX2027 AND2_717/net6 VDD VDD pmos W=0.41u L=0.04u
M8753 AND2_717/net6 RESET VDD VDD pmos W=0.41u L=0.04u
M8754 AND2_717/net6 WX1964 VDD VDD pmos W=0.41u L=0.04u
M8755 WX2025 AND2_716/net6 VSS VSS nmos W=0.31u L=0.04u
M8756 AND2_716/X_u2-net6 RESET VSS VSS nmos W=0.31u L=0.04u
M8757 AND2_716/net6 WX1962 AND2_716/X_u2-net6 VSS nmos W=0.31u L=0.04u
M8758 WX2025 AND2_716/net6 VDD VDD pmos W=0.41u L=0.04u
M8759 AND2_716/net6 RESET VDD VDD pmos W=0.41u L=0.04u
M8760 AND2_716/net6 WX1962 VDD VDD pmos W=0.41u L=0.04u
M8761 WX2023 AND2_715/net6 VSS VSS nmos W=0.31u L=0.04u
M8762 AND2_715/X_u2-net6 RESET VSS VSS nmos W=0.31u L=0.04u
M8763 AND2_715/net6 WX1960 AND2_715/X_u2-net6 VSS nmos W=0.31u L=0.04u
M8764 WX2023 AND2_715/net6 VDD VDD pmos W=0.41u L=0.04u
M8765 AND2_715/net6 RESET VDD VDD pmos W=0.41u L=0.04u
M8766 AND2_715/net6 WX1960 VDD VDD pmos W=0.41u L=0.04u
M8767 WX2021 AND2_714/net6 VSS VSS nmos W=0.31u L=0.04u
M8768 AND2_714/X_u2-net6 RESET VSS VSS nmos W=0.31u L=0.04u
M8769 AND2_714/net6 WX1958 AND2_714/X_u2-net6 VSS nmos W=0.31u L=0.04u
M8770 WX2021 AND2_714/net6 VDD VDD pmos W=0.41u L=0.04u
M8771 AND2_714/net6 RESET VDD VDD pmos W=0.41u L=0.04u
M8772 AND2_714/net6 WX1958 VDD VDD pmos W=0.41u L=0.04u
M8773 WX2019 AND2_713/net6 VSS VSS nmos W=0.31u L=0.04u
M8774 AND2_713/X_u2-net6 RESET VSS VSS nmos W=0.31u L=0.04u
M8775 AND2_713/net6 WX1956 AND2_713/X_u2-net6 VSS nmos W=0.31u L=0.04u
M8776 WX2019 AND2_713/net6 VDD VDD pmos W=0.41u L=0.04u
M8777 AND2_713/net6 RESET VDD VDD pmos W=0.41u L=0.04u
M8778 AND2_713/net6 WX1956 VDD VDD pmos W=0.41u L=0.04u
M8779 WX2017 AND2_712/net6 VSS VSS nmos W=0.31u L=0.04u
M8780 AND2_712/X_u2-net6 RESET VSS VSS nmos W=0.31u L=0.04u
M8781 AND2_712/net6 WX1954 AND2_712/X_u2-net6 VSS nmos W=0.31u L=0.04u
M8782 WX2017 AND2_712/net6 VDD VDD pmos W=0.41u L=0.04u
M8783 AND2_712/net6 RESET VDD VDD pmos W=0.41u L=0.04u
M8784 AND2_712/net6 WX1954 VDD VDD pmos W=0.41u L=0.04u
M8785 WX2015 AND2_711/net6 VSS VSS nmos W=0.31u L=0.04u
M8786 AND2_711/X_u2-net6 RESET VSS VSS nmos W=0.31u L=0.04u
M8787 AND2_711/net6 WX1952 AND2_711/X_u2-net6 VSS nmos W=0.31u L=0.04u
M8788 WX2015 AND2_711/net6 VDD VDD pmos W=0.41u L=0.04u
M8789 AND2_711/net6 RESET VDD VDD pmos W=0.41u L=0.04u
M8790 AND2_711/net6 WX1952 VDD VDD pmos W=0.41u L=0.04u
M8791 WX2013 AND2_710/net6 VSS VSS nmos W=0.31u L=0.04u
M8792 AND2_710/X_u2-net6 RESET VSS VSS nmos W=0.31u L=0.04u
M8793 AND2_710/net6 WX1950 AND2_710/X_u2-net6 VSS nmos W=0.31u L=0.04u
M8794 WX2013 AND2_710/net6 VDD VDD pmos W=0.41u L=0.04u
M8795 AND2_710/net6 RESET VDD VDD pmos W=0.41u L=0.04u
M8796 AND2_710/net6 WX1950 VDD VDD pmos W=0.41u L=0.04u
M8797 WX2011 AND2_709/net6 VSS VSS nmos W=0.31u L=0.04u
M8798 AND2_709/X_u2-net6 RESET VSS VSS nmos W=0.31u L=0.04u
M8799 AND2_709/net6 WX1948 AND2_709/X_u2-net6 VSS nmos W=0.31u L=0.04u
M8800 WX2011 AND2_709/net6 VDD VDD pmos W=0.41u L=0.04u
M8801 AND2_709/net6 RESET VDD VDD pmos W=0.41u L=0.04u
M8802 AND2_709/net6 WX1948 VDD VDD pmos W=0.41u L=0.04u
M8803 WX2009 AND2_708/net6 VSS VSS nmos W=0.31u L=0.04u
M8804 AND2_708/X_u2-net6 RESET VSS VSS nmos W=0.31u L=0.04u
M8805 AND2_708/net6 WX1946 AND2_708/X_u2-net6 VSS nmos W=0.31u L=0.04u
M8806 WX2009 AND2_708/net6 VDD VDD pmos W=0.41u L=0.04u
M8807 AND2_708/net6 RESET VDD VDD pmos W=0.41u L=0.04u
M8808 AND2_708/net6 WX1946 VDD VDD pmos W=0.41u L=0.04u
M8809 WX2007 AND2_707/net6 VSS VSS nmos W=0.31u L=0.04u
M8810 AND2_707/X_u2-net6 RESET VSS VSS nmos W=0.31u L=0.04u
M8811 AND2_707/net6 WX1944 AND2_707/X_u2-net6 VSS nmos W=0.31u L=0.04u
M8812 WX2007 AND2_707/net6 VDD VDD pmos W=0.41u L=0.04u
M8813 AND2_707/net6 RESET VDD VDD pmos W=0.41u L=0.04u
M8814 AND2_707/net6 WX1944 VDD VDD pmos W=0.41u L=0.04u
M8815 WX2005 AND2_706/net6 VSS VSS nmos W=0.31u L=0.04u
M8816 AND2_706/X_u2-net6 RESET VSS VSS nmos W=0.31u L=0.04u
M8817 AND2_706/net6 WX1942 AND2_706/X_u2-net6 VSS nmos W=0.31u L=0.04u
M8818 WX2005 AND2_706/net6 VDD VDD pmos W=0.41u L=0.04u
M8819 AND2_706/net6 RESET VDD VDD pmos W=0.41u L=0.04u
M8820 AND2_706/net6 WX1942 VDD VDD pmos W=0.41u L=0.04u
M8821 WX2003 AND2_705/net6 VSS VSS nmos W=0.31u L=0.04u
M8822 AND2_705/X_u2-net6 RESET VSS VSS nmos W=0.31u L=0.04u
M8823 AND2_705/net6 WX1940 AND2_705/X_u2-net6 VSS nmos W=0.31u L=0.04u
M8824 WX2003 AND2_705/net6 VDD VDD pmos W=0.41u L=0.04u
M8825 AND2_705/net6 RESET VDD VDD pmos W=0.41u L=0.04u
M8826 AND2_705/net6 WX1940 VDD VDD pmos W=0.41u L=0.04u
M8827 WX2001 AND2_704/net6 VSS VSS nmos W=0.31u L=0.04u
M8828 AND2_704/X_u2-net6 RESET VSS VSS nmos W=0.31u L=0.04u
M8829 AND2_704/net6 WX1938 AND2_704/X_u2-net6 VSS nmos W=0.31u L=0.04u
M8830 WX2001 AND2_704/net6 VDD VDD pmos W=0.41u L=0.04u
M8831 AND2_704/net6 RESET VDD VDD pmos W=0.41u L=0.04u
M8832 AND2_704/net6 WX1938 VDD VDD pmos W=0.41u L=0.04u
M8833 WX1999 AND2_703/net6 VSS VSS nmos W=0.31u L=0.04u
M8834 AND2_703/X_u2-net6 RESET VSS VSS nmos W=0.31u L=0.04u
M8835 AND2_703/net6 WX1765 AND2_703/X_u2-net6 VSS nmos W=0.31u L=0.04u
M8836 WX1999 AND2_703/net6 VDD VDD pmos W=0.41u L=0.04u
M8837 AND2_703/net6 RESET VDD VDD pmos W=0.41u L=0.04u
M8838 AND2_703/net6 WX1765 VDD VDD pmos W=0.41u L=0.04u
M8839 WX1997 AND2_702/net6 VSS VSS nmos W=0.31u L=0.04u
M8840 AND2_702/X_u2-net6 RESET VSS VSS nmos W=0.31u L=0.04u
M8841 AND2_702/net6 WX1751 AND2_702/X_u2-net6 VSS nmos W=0.31u L=0.04u
M8842 WX1997 AND2_702/net6 VDD VDD pmos W=0.41u L=0.04u
M8843 AND2_702/net6 RESET VDD VDD pmos W=0.41u L=0.04u
M8844 AND2_702/net6 WX1751 VDD VDD pmos W=0.41u L=0.04u
M8845 WX1995 AND2_701/net6 VSS VSS nmos W=0.31u L=0.04u
M8846 AND2_701/X_u2-net6 RESET VSS VSS nmos W=0.31u L=0.04u
M8847 AND2_701/net6 WX1737 AND2_701/X_u2-net6 VSS nmos W=0.31u L=0.04u
M8848 WX1995 AND2_701/net6 VDD VDD pmos W=0.41u L=0.04u
M8849 AND2_701/net6 RESET VDD VDD pmos W=0.41u L=0.04u
M8850 AND2_701/net6 WX1737 VDD VDD pmos W=0.41u L=0.04u
M8851 WX1993 AND2_700/net6 VSS VSS nmos W=0.31u L=0.04u
M8852 AND2_700/X_u2-net6 RESET VSS VSS nmos W=0.31u L=0.04u
M8853 AND2_700/net6 WX1723 AND2_700/X_u2-net6 VSS nmos W=0.31u L=0.04u
M8854 WX1993 AND2_700/net6 VDD VDD pmos W=0.41u L=0.04u
M8855 AND2_700/net6 RESET VDD VDD pmos W=0.41u L=0.04u
M8856 AND2_700/net6 WX1723 VDD VDD pmos W=0.41u L=0.04u
M8857 WX1991 AND2_699/net6 VSS VSS nmos W=0.31u L=0.04u
M8858 AND2_699/X_u2-net6 RESET VSS VSS nmos W=0.31u L=0.04u
M8859 AND2_699/net6 WX1709 AND2_699/X_u2-net6 VSS nmos W=0.31u L=0.04u
M8860 WX1991 AND2_699/net6 VDD VDD pmos W=0.41u L=0.04u
M8861 AND2_699/net6 RESET VDD VDD pmos W=0.41u L=0.04u
M8862 AND2_699/net6 WX1709 VDD VDD pmos W=0.41u L=0.04u
M8863 WX1989 AND2_698/net6 VSS VSS nmos W=0.31u L=0.04u
M8864 AND2_698/X_u2-net6 RESET VSS VSS nmos W=0.31u L=0.04u
M8865 AND2_698/net6 WX1695 AND2_698/X_u2-net6 VSS nmos W=0.31u L=0.04u
M8866 WX1989 AND2_698/net6 VDD VDD pmos W=0.41u L=0.04u
M8867 AND2_698/net6 RESET VDD VDD pmos W=0.41u L=0.04u
M8868 AND2_698/net6 WX1695 VDD VDD pmos W=0.41u L=0.04u
M8869 WX1987 AND2_697/net6 VSS VSS nmos W=0.31u L=0.04u
M8870 AND2_697/X_u2-net6 RESET VSS VSS nmos W=0.31u L=0.04u
M8871 AND2_697/net6 WX1681 AND2_697/X_u2-net6 VSS nmos W=0.31u L=0.04u
M8872 WX1987 AND2_697/net6 VDD VDD pmos W=0.41u L=0.04u
M8873 AND2_697/net6 RESET VDD VDD pmos W=0.41u L=0.04u
M8874 AND2_697/net6 WX1681 VDD VDD pmos W=0.41u L=0.04u
M8875 WX1985 AND2_696/net6 VSS VSS nmos W=0.31u L=0.04u
M8876 AND2_696/X_u2-net6 RESET VSS VSS nmos W=0.31u L=0.04u
M8877 AND2_696/net6 WX1667 AND2_696/X_u2-net6 VSS nmos W=0.31u L=0.04u
M8878 WX1985 AND2_696/net6 VDD VDD pmos W=0.41u L=0.04u
M8879 AND2_696/net6 RESET VDD VDD pmos W=0.41u L=0.04u
M8880 AND2_696/net6 WX1667 VDD VDD pmos W=0.41u L=0.04u
M8881 WX1983 AND2_695/net6 VSS VSS nmos W=0.31u L=0.04u
M8882 AND2_695/X_u2-net6 RESET VSS VSS nmos W=0.31u L=0.04u
M8883 AND2_695/net6 WX1653 AND2_695/X_u2-net6 VSS nmos W=0.31u L=0.04u
M8884 WX1983 AND2_695/net6 VDD VDD pmos W=0.41u L=0.04u
M8885 AND2_695/net6 RESET VDD VDD pmos W=0.41u L=0.04u
M8886 AND2_695/net6 WX1653 VDD VDD pmos W=0.41u L=0.04u
M8887 WX1981 AND2_694/net6 VSS VSS nmos W=0.31u L=0.04u
M8888 AND2_694/X_u2-net6 RESET VSS VSS nmos W=0.31u L=0.04u
M8889 AND2_694/net6 WX1639 AND2_694/X_u2-net6 VSS nmos W=0.31u L=0.04u
M8890 WX1981 AND2_694/net6 VDD VDD pmos W=0.41u L=0.04u
M8891 AND2_694/net6 RESET VDD VDD pmos W=0.41u L=0.04u
M8892 AND2_694/net6 WX1639 VDD VDD pmos W=0.41u L=0.04u
M8893 WX1979 AND2_693/net6 VSS VSS nmos W=0.31u L=0.04u
M8894 AND2_693/X_u2-net6 RESET VSS VSS nmos W=0.31u L=0.04u
M8895 AND2_693/net6 WX1625 AND2_693/X_u2-net6 VSS nmos W=0.31u L=0.04u
M8896 WX1979 AND2_693/net6 VDD VDD pmos W=0.41u L=0.04u
M8897 AND2_693/net6 RESET VDD VDD pmos W=0.41u L=0.04u
M8898 AND2_693/net6 WX1625 VDD VDD pmos W=0.41u L=0.04u
M8899 WX1977 AND2_692/net6 VSS VSS nmos W=0.31u L=0.04u
M8900 AND2_692/X_u2-net6 RESET VSS VSS nmos W=0.31u L=0.04u
M8901 AND2_692/net6 WX1611 AND2_692/X_u2-net6 VSS nmos W=0.31u L=0.04u
M8902 WX1977 AND2_692/net6 VDD VDD pmos W=0.41u L=0.04u
M8903 AND2_692/net6 RESET VDD VDD pmos W=0.41u L=0.04u
M8904 AND2_692/net6 WX1611 VDD VDD pmos W=0.41u L=0.04u
M8905 WX1975 AND2_691/net6 VSS VSS nmos W=0.31u L=0.04u
M8906 AND2_691/X_u2-net6 RESET VSS VSS nmos W=0.31u L=0.04u
M8907 AND2_691/net6 WX1597 AND2_691/X_u2-net6 VSS nmos W=0.31u L=0.04u
M8908 WX1975 AND2_691/net6 VDD VDD pmos W=0.41u L=0.04u
M8909 AND2_691/net6 RESET VDD VDD pmos W=0.41u L=0.04u
M8910 AND2_691/net6 WX1597 VDD VDD pmos W=0.41u L=0.04u
M8911 WX1973 AND2_690/net6 VSS VSS nmos W=0.31u L=0.04u
M8912 AND2_690/X_u2-net6 RESET VSS VSS nmos W=0.31u L=0.04u
M8913 AND2_690/net6 WX1583 AND2_690/X_u2-net6 VSS nmos W=0.31u L=0.04u
M8914 WX1973 AND2_690/net6 VDD VDD pmos W=0.41u L=0.04u
M8915 AND2_690/net6 RESET VDD VDD pmos W=0.41u L=0.04u
M8916 AND2_690/net6 WX1583 VDD VDD pmos W=0.41u L=0.04u
M8917 WX1971 AND2_689/net6 VSS VSS nmos W=0.31u L=0.04u
M8918 AND2_689/X_u2-net6 RESET VSS VSS nmos W=0.31u L=0.04u
M8919 AND2_689/net6 WX1569 AND2_689/X_u2-net6 VSS nmos W=0.31u L=0.04u
M8920 WX1971 AND2_689/net6 VDD VDD pmos W=0.41u L=0.04u
M8921 AND2_689/net6 RESET VDD VDD pmos W=0.41u L=0.04u
M8922 AND2_689/net6 WX1569 VDD VDD pmos W=0.41u L=0.04u
M8923 WX1969 AND2_688/net6 VSS VSS nmos W=0.31u L=0.04u
M8924 AND2_688/X_u2-net6 RESET VSS VSS nmos W=0.31u L=0.04u
M8925 AND2_688/net6 WX1555 AND2_688/X_u2-net6 VSS nmos W=0.31u L=0.04u
M8926 WX1969 AND2_688/net6 VDD VDD pmos W=0.41u L=0.04u
M8927 AND2_688/net6 RESET VDD VDD pmos W=0.41u L=0.04u
M8928 AND2_688/net6 WX1555 VDD VDD pmos W=0.41u L=0.04u
M8929 WX1967 AND2_687/net6 VSS VSS nmos W=0.31u L=0.04u
M8930 AND2_687/X_u2-net6 RESET VSS VSS nmos W=0.31u L=0.04u
M8931 AND2_687/net6 WX1541 AND2_687/X_u2-net6 VSS nmos W=0.31u L=0.04u
M8932 WX1967 AND2_687/net6 VDD VDD pmos W=0.41u L=0.04u
M8933 AND2_687/net6 RESET VDD VDD pmos W=0.41u L=0.04u
M8934 AND2_687/net6 WX1541 VDD VDD pmos W=0.41u L=0.04u
M8935 WX1965 AND2_686/net6 VSS VSS nmos W=0.31u L=0.04u
M8936 AND2_686/X_u2-net6 RESET VSS VSS nmos W=0.31u L=0.04u
M8937 AND2_686/net6 WX1527 AND2_686/X_u2-net6 VSS nmos W=0.31u L=0.04u
M8938 WX1965 AND2_686/net6 VDD VDD pmos W=0.41u L=0.04u
M8939 AND2_686/net6 RESET VDD VDD pmos W=0.41u L=0.04u
M8940 AND2_686/net6 WX1527 VDD VDD pmos W=0.41u L=0.04u
M8941 WX1963 AND2_685/net6 VSS VSS nmos W=0.31u L=0.04u
M8942 AND2_685/X_u2-net6 RESET VSS VSS nmos W=0.31u L=0.04u
M8943 AND2_685/net6 WX1513 AND2_685/X_u2-net6 VSS nmos W=0.31u L=0.04u
M8944 WX1963 AND2_685/net6 VDD VDD pmos W=0.41u L=0.04u
M8945 AND2_685/net6 RESET VDD VDD pmos W=0.41u L=0.04u
M8946 AND2_685/net6 WX1513 VDD VDD pmos W=0.41u L=0.04u
M8947 WX1961 AND2_684/net6 VSS VSS nmos W=0.31u L=0.04u
M8948 AND2_684/X_u2-net6 RESET VSS VSS nmos W=0.31u L=0.04u
M8949 AND2_684/net6 WX1499 AND2_684/X_u2-net6 VSS nmos W=0.31u L=0.04u
M8950 WX1961 AND2_684/net6 VDD VDD pmos W=0.41u L=0.04u
M8951 AND2_684/net6 RESET VDD VDD pmos W=0.41u L=0.04u
M8952 AND2_684/net6 WX1499 VDD VDD pmos W=0.41u L=0.04u
M8953 WX1959 AND2_683/net6 VSS VSS nmos W=0.31u L=0.04u
M8954 AND2_683/X_u2-net6 RESET VSS VSS nmos W=0.31u L=0.04u
M8955 AND2_683/net6 WX1485 AND2_683/X_u2-net6 VSS nmos W=0.31u L=0.04u
M8956 WX1959 AND2_683/net6 VDD VDD pmos W=0.41u L=0.04u
M8957 AND2_683/net6 RESET VDD VDD pmos W=0.41u L=0.04u
M8958 AND2_683/net6 WX1485 VDD VDD pmos W=0.41u L=0.04u
M8959 WX1957 AND2_682/net6 VSS VSS nmos W=0.31u L=0.04u
M8960 AND2_682/X_u2-net6 RESET VSS VSS nmos W=0.31u L=0.04u
M8961 AND2_682/net6 WX1471 AND2_682/X_u2-net6 VSS nmos W=0.31u L=0.04u
M8962 WX1957 AND2_682/net6 VDD VDD pmos W=0.41u L=0.04u
M8963 AND2_682/net6 RESET VDD VDD pmos W=0.41u L=0.04u
M8964 AND2_682/net6 WX1471 VDD VDD pmos W=0.41u L=0.04u
M8965 WX1955 AND2_681/net6 VSS VSS nmos W=0.31u L=0.04u
M8966 AND2_681/X_u2-net6 RESET VSS VSS nmos W=0.31u L=0.04u
M8967 AND2_681/net6 WX1457 AND2_681/X_u2-net6 VSS nmos W=0.31u L=0.04u
M8968 WX1955 AND2_681/net6 VDD VDD pmos W=0.41u L=0.04u
M8969 AND2_681/net6 RESET VDD VDD pmos W=0.41u L=0.04u
M8970 AND2_681/net6 WX1457 VDD VDD pmos W=0.41u L=0.04u
M8971 WX1953 AND2_680/net6 VSS VSS nmos W=0.31u L=0.04u
M8972 AND2_680/X_u2-net6 RESET VSS VSS nmos W=0.31u L=0.04u
M8973 AND2_680/net6 WX1443 AND2_680/X_u2-net6 VSS nmos W=0.31u L=0.04u
M8974 WX1953 AND2_680/net6 VDD VDD pmos W=0.41u L=0.04u
M8975 AND2_680/net6 RESET VDD VDD pmos W=0.41u L=0.04u
M8976 AND2_680/net6 WX1443 VDD VDD pmos W=0.41u L=0.04u
M8977 WX1951 AND2_679/net6 VSS VSS nmos W=0.31u L=0.04u
M8978 AND2_679/X_u2-net6 RESET VSS VSS nmos W=0.31u L=0.04u
M8979 AND2_679/net6 WX1429 AND2_679/X_u2-net6 VSS nmos W=0.31u L=0.04u
M8980 WX1951 AND2_679/net6 VDD VDD pmos W=0.41u L=0.04u
M8981 AND2_679/net6 RESET VDD VDD pmos W=0.41u L=0.04u
M8982 AND2_679/net6 WX1429 VDD VDD pmos W=0.41u L=0.04u
M8983 WX1949 AND2_678/net6 VSS VSS nmos W=0.31u L=0.04u
M8984 AND2_678/X_u2-net6 RESET VSS VSS nmos W=0.31u L=0.04u
M8985 AND2_678/net6 WX1415 AND2_678/X_u2-net6 VSS nmos W=0.31u L=0.04u
M8986 WX1949 AND2_678/net6 VDD VDD pmos W=0.41u L=0.04u
M8987 AND2_678/net6 RESET VDD VDD pmos W=0.41u L=0.04u
M8988 AND2_678/net6 WX1415 VDD VDD pmos W=0.41u L=0.04u
M8989 WX1947 AND2_677/net6 VSS VSS nmos W=0.31u L=0.04u
M8990 AND2_677/X_u2-net6 RESET VSS VSS nmos W=0.31u L=0.04u
M8991 AND2_677/net6 WX1401 AND2_677/X_u2-net6 VSS nmos W=0.31u L=0.04u
M8992 WX1947 AND2_677/net6 VDD VDD pmos W=0.41u L=0.04u
M8993 AND2_677/net6 RESET VDD VDD pmos W=0.41u L=0.04u
M8994 AND2_677/net6 WX1401 VDD VDD pmos W=0.41u L=0.04u
M8995 WX1945 AND2_676/net6 VSS VSS nmos W=0.31u L=0.04u
M8996 AND2_676/X_u2-net6 RESET VSS VSS nmos W=0.31u L=0.04u
M8997 AND2_676/net6 WX1387 AND2_676/X_u2-net6 VSS nmos W=0.31u L=0.04u
M8998 WX1945 AND2_676/net6 VDD VDD pmos W=0.41u L=0.04u
M8999 AND2_676/net6 RESET VDD VDD pmos W=0.41u L=0.04u
M9000 AND2_676/net6 WX1387 VDD VDD pmos W=0.41u L=0.04u
M9001 WX1943 AND2_675/net6 VSS VSS nmos W=0.31u L=0.04u
M9002 AND2_675/X_u2-net6 RESET VSS VSS nmos W=0.31u L=0.04u
M9003 AND2_675/net6 WX1373 AND2_675/X_u2-net6 VSS nmos W=0.31u L=0.04u
M9004 WX1943 AND2_675/net6 VDD VDD pmos W=0.41u L=0.04u
M9005 AND2_675/net6 RESET VDD VDD pmos W=0.41u L=0.04u
M9006 AND2_675/net6 WX1373 VDD VDD pmos W=0.41u L=0.04u
M9007 WX1941 AND2_674/net6 VSS VSS nmos W=0.31u L=0.04u
M9008 AND2_674/X_u2-net6 RESET VSS VSS nmos W=0.31u L=0.04u
M9009 AND2_674/net6 WX1359 AND2_674/X_u2-net6 VSS nmos W=0.31u L=0.04u
M9010 WX1941 AND2_674/net6 VDD VDD pmos W=0.41u L=0.04u
M9011 AND2_674/net6 RESET VDD VDD pmos W=0.41u L=0.04u
M9012 AND2_674/net6 WX1359 VDD VDD pmos W=0.41u L=0.04u
M9013 WX1939 AND2_673/net6 VSS VSS nmos W=0.31u L=0.04u
M9014 AND2_673/X_u2-net6 RESET VSS VSS nmos W=0.31u L=0.04u
M9015 AND2_673/net6 WX1345 AND2_673/X_u2-net6 VSS nmos W=0.31u L=0.04u
M9016 WX1939 AND2_673/net6 VDD VDD pmos W=0.41u L=0.04u
M9017 AND2_673/net6 RESET VDD VDD pmos W=0.41u L=0.04u
M9018 AND2_673/net6 WX1345 VDD VDD pmos W=0.41u L=0.04u
M9019 WX1937 AND2_672/net6 VSS VSS nmos W=0.31u L=0.04u
M9020 AND2_672/X_u2-net6 RESET VSS VSS nmos W=0.31u L=0.04u
M9021 AND2_672/net6 WX1331 AND2_672/X_u2-net6 VSS nmos W=0.31u L=0.04u
M9022 WX1937 AND2_672/net6 VDD VDD pmos W=0.41u L=0.04u
M9023 AND2_672/net6 RESET VDD VDD pmos W=0.41u L=0.04u
M9024 AND2_672/net6 WX1331 VDD VDD pmos W=0.41u L=0.04u
M9025 WX1839 AND2_671/net6 VSS VSS nmos W=0.31u L=0.04u
M9026 AND2_671/X_u2-net6 RESET VSS VSS nmos W=0.31u L=0.04u
M9027 AND2_671/net6 WX1776 AND2_671/X_u2-net6 VSS nmos W=0.31u L=0.04u
M9028 WX1839 AND2_671/net6 VDD VDD pmos W=0.41u L=0.04u
M9029 AND2_671/net6 RESET VDD VDD pmos W=0.41u L=0.04u
M9030 AND2_671/net6 WX1776 VDD VDD pmos W=0.41u L=0.04u
M9031 WX1837 AND2_670/net6 VSS VSS nmos W=0.31u L=0.04u
M9032 AND2_670/X_u2-net6 RESET VSS VSS nmos W=0.31u L=0.04u
M9033 AND2_670/net6 WX1840 AND2_670/X_u2-net6 VSS nmos W=0.31u L=0.04u
M9034 WX1837 AND2_670/net6 VDD VDD pmos W=0.41u L=0.04u
M9035 AND2_670/net6 RESET VDD VDD pmos W=0.41u L=0.04u
M9036 AND2_670/net6 WX1840 VDD VDD pmos W=0.41u L=0.04u
M9037 WX1835 AND2_669/net6 VSS VSS nmos W=0.31u L=0.04u
M9038 AND2_669/X_u2-net6 RESET VSS VSS nmos W=0.31u L=0.04u
M9039 AND2_669/net6 WX1838 AND2_669/X_u2-net6 VSS nmos W=0.31u L=0.04u
M9040 WX1835 AND2_669/net6 VDD VDD pmos W=0.41u L=0.04u
M9041 AND2_669/net6 RESET VDD VDD pmos W=0.41u L=0.04u
M9042 AND2_669/net6 WX1838 VDD VDD pmos W=0.41u L=0.04u
M9043 WX1833 AND2_668/net6 VSS VSS nmos W=0.31u L=0.04u
M9044 AND2_668/X_u2-net6 RESET VSS VSS nmos W=0.31u L=0.04u
M9045 AND2_668/net6 WX1836 AND2_668/X_u2-net6 VSS nmos W=0.31u L=0.04u
M9046 WX1833 AND2_668/net6 VDD VDD pmos W=0.41u L=0.04u
M9047 AND2_668/net6 RESET VDD VDD pmos W=0.41u L=0.04u
M9048 AND2_668/net6 WX1836 VDD VDD pmos W=0.41u L=0.04u
M9049 WX1831 AND2_667/net6 VSS VSS nmos W=0.31u L=0.04u
M9050 AND2_667/X_u2-net6 RESET VSS VSS nmos W=0.31u L=0.04u
M9051 AND2_667/net6 WX1834 AND2_667/X_u2-net6 VSS nmos W=0.31u L=0.04u
M9052 WX1831 AND2_667/net6 VDD VDD pmos W=0.41u L=0.04u
M9053 AND2_667/net6 RESET VDD VDD pmos W=0.41u L=0.04u
M9054 AND2_667/net6 WX1834 VDD VDD pmos W=0.41u L=0.04u
M9055 WX1829 AND2_666/net6 VSS VSS nmos W=0.31u L=0.04u
M9056 AND2_666/X_u2-net6 RESET VSS VSS nmos W=0.31u L=0.04u
M9057 AND2_666/net6 WX1832 AND2_666/X_u2-net6 VSS nmos W=0.31u L=0.04u
M9058 WX1829 AND2_666/net6 VDD VDD pmos W=0.41u L=0.04u
M9059 AND2_666/net6 RESET VDD VDD pmos W=0.41u L=0.04u
M9060 AND2_666/net6 WX1832 VDD VDD pmos W=0.41u L=0.04u
M9061 WX1827 AND2_665/net6 VSS VSS nmos W=0.31u L=0.04u
M9062 AND2_665/X_u2-net6 RESET VSS VSS nmos W=0.31u L=0.04u
M9063 AND2_665/net6 WX1830 AND2_665/X_u2-net6 VSS nmos W=0.31u L=0.04u
M9064 WX1827 AND2_665/net6 VDD VDD pmos W=0.41u L=0.04u
M9065 AND2_665/net6 RESET VDD VDD pmos W=0.41u L=0.04u
M9066 AND2_665/net6 WX1830 VDD VDD pmos W=0.41u L=0.04u
M9067 WX1825 AND2_664/net6 VSS VSS nmos W=0.31u L=0.04u
M9068 AND2_664/X_u2-net6 RESET VSS VSS nmos W=0.31u L=0.04u
M9069 AND2_664/net6 WX1828 AND2_664/X_u2-net6 VSS nmos W=0.31u L=0.04u
M9070 WX1825 AND2_664/net6 VDD VDD pmos W=0.41u L=0.04u
M9071 AND2_664/net6 RESET VDD VDD pmos W=0.41u L=0.04u
M9072 AND2_664/net6 WX1828 VDD VDD pmos W=0.41u L=0.04u
M9073 WX1823 AND2_663/net6 VSS VSS nmos W=0.31u L=0.04u
M9074 AND2_663/X_u2-net6 RESET VSS VSS nmos W=0.31u L=0.04u
M9075 AND2_663/net6 WX1826 AND2_663/X_u2-net6 VSS nmos W=0.31u L=0.04u
M9076 WX1823 AND2_663/net6 VDD VDD pmos W=0.41u L=0.04u
M9077 AND2_663/net6 RESET VDD VDD pmos W=0.41u L=0.04u
M9078 AND2_663/net6 WX1826 VDD VDD pmos W=0.41u L=0.04u
M9079 WX1821 AND2_662/net6 VSS VSS nmos W=0.31u L=0.04u
M9080 AND2_662/X_u2-net6 RESET VSS VSS nmos W=0.31u L=0.04u
M9081 AND2_662/net6 WX1824 AND2_662/X_u2-net6 VSS nmos W=0.31u L=0.04u
M9082 WX1821 AND2_662/net6 VDD VDD pmos W=0.41u L=0.04u
M9083 AND2_662/net6 RESET VDD VDD pmos W=0.41u L=0.04u
M9084 AND2_662/net6 WX1824 VDD VDD pmos W=0.41u L=0.04u
M9085 WX1819 AND2_661/net6 VSS VSS nmos W=0.31u L=0.04u
M9086 AND2_661/X_u2-net6 RESET VSS VSS nmos W=0.31u L=0.04u
M9087 AND2_661/net6 WX1822 AND2_661/X_u2-net6 VSS nmos W=0.31u L=0.04u
M9088 WX1819 AND2_661/net6 VDD VDD pmos W=0.41u L=0.04u
M9089 AND2_661/net6 RESET VDD VDD pmos W=0.41u L=0.04u
M9090 AND2_661/net6 WX1822 VDD VDD pmos W=0.41u L=0.04u
M9091 WX1817 AND2_660/net6 VSS VSS nmos W=0.31u L=0.04u
M9092 AND2_660/X_u2-net6 RESET VSS VSS nmos W=0.31u L=0.04u
M9093 AND2_660/net6 WX1820 AND2_660/X_u2-net6 VSS nmos W=0.31u L=0.04u
M9094 WX1817 AND2_660/net6 VDD VDD pmos W=0.41u L=0.04u
M9095 AND2_660/net6 RESET VDD VDD pmos W=0.41u L=0.04u
M9096 AND2_660/net6 WX1820 VDD VDD pmos W=0.41u L=0.04u
M9097 WX1815 AND2_659/net6 VSS VSS nmos W=0.31u L=0.04u
M9098 AND2_659/X_u2-net6 RESET VSS VSS nmos W=0.31u L=0.04u
M9099 AND2_659/net6 WX1818 AND2_659/X_u2-net6 VSS nmos W=0.31u L=0.04u
M9100 WX1815 AND2_659/net6 VDD VDD pmos W=0.41u L=0.04u
M9101 AND2_659/net6 RESET VDD VDD pmos W=0.41u L=0.04u
M9102 AND2_659/net6 WX1818 VDD VDD pmos W=0.41u L=0.04u
M9103 WX1813 AND2_658/net6 VSS VSS nmos W=0.31u L=0.04u
M9104 AND2_658/X_u2-net6 RESET VSS VSS nmos W=0.31u L=0.04u
M9105 AND2_658/net6 WX1816 AND2_658/X_u2-net6 VSS nmos W=0.31u L=0.04u
M9106 WX1813 AND2_658/net6 VDD VDD pmos W=0.41u L=0.04u
M9107 AND2_658/net6 RESET VDD VDD pmos W=0.41u L=0.04u
M9108 AND2_658/net6 WX1816 VDD VDD pmos W=0.41u L=0.04u
M9109 WX1811 AND2_657/net6 VSS VSS nmos W=0.31u L=0.04u
M9110 AND2_657/X_u2-net6 RESET VSS VSS nmos W=0.31u L=0.04u
M9111 AND2_657/net6 WX1814 AND2_657/X_u2-net6 VSS nmos W=0.31u L=0.04u
M9112 WX1811 AND2_657/net6 VDD VDD pmos W=0.41u L=0.04u
M9113 AND2_657/net6 RESET VDD VDD pmos W=0.41u L=0.04u
M9114 AND2_657/net6 WX1814 VDD VDD pmos W=0.41u L=0.04u
M9115 WX1809 AND2_656/net6 VSS VSS nmos W=0.31u L=0.04u
M9116 AND2_656/X_u2-net6 RESET VSS VSS nmos W=0.31u L=0.04u
M9117 AND2_656/net6 WX1812 AND2_656/X_u2-net6 VSS nmos W=0.31u L=0.04u
M9118 WX1809 AND2_656/net6 VDD VDD pmos W=0.41u L=0.04u
M9119 AND2_656/net6 RESET VDD VDD pmos W=0.41u L=0.04u
M9120 AND2_656/net6 WX1812 VDD VDD pmos W=0.41u L=0.04u
M9121 WX1807 AND2_655/net6 VSS VSS nmos W=0.31u L=0.04u
M9122 AND2_655/X_u2-net6 RESET VSS VSS nmos W=0.31u L=0.04u
M9123 AND2_655/net6 WX1810 AND2_655/X_u2-net6 VSS nmos W=0.31u L=0.04u
M9124 WX1807 AND2_655/net6 VDD VDD pmos W=0.41u L=0.04u
M9125 AND2_655/net6 RESET VDD VDD pmos W=0.41u L=0.04u
M9126 AND2_655/net6 WX1810 VDD VDD pmos W=0.41u L=0.04u
M9127 WX1805 AND2_654/net6 VSS VSS nmos W=0.31u L=0.04u
M9128 AND2_654/X_u2-net6 RESET VSS VSS nmos W=0.31u L=0.04u
M9129 AND2_654/net6 WX1808 AND2_654/X_u2-net6 VSS nmos W=0.31u L=0.04u
M9130 WX1805 AND2_654/net6 VDD VDD pmos W=0.41u L=0.04u
M9131 AND2_654/net6 RESET VDD VDD pmos W=0.41u L=0.04u
M9132 AND2_654/net6 WX1808 VDD VDD pmos W=0.41u L=0.04u
M9133 WX1803 AND2_653/net6 VSS VSS nmos W=0.31u L=0.04u
M9134 AND2_653/X_u2-net6 RESET VSS VSS nmos W=0.31u L=0.04u
M9135 AND2_653/net6 WX1806 AND2_653/X_u2-net6 VSS nmos W=0.31u L=0.04u
M9136 WX1803 AND2_653/net6 VDD VDD pmos W=0.41u L=0.04u
M9137 AND2_653/net6 RESET VDD VDD pmos W=0.41u L=0.04u
M9138 AND2_653/net6 WX1806 VDD VDD pmos W=0.41u L=0.04u
M9139 WX1801 AND2_652/net6 VSS VSS nmos W=0.31u L=0.04u
M9140 AND2_652/X_u2-net6 RESET VSS VSS nmos W=0.31u L=0.04u
M9141 AND2_652/net6 WX1804 AND2_652/X_u2-net6 VSS nmos W=0.31u L=0.04u
M9142 WX1801 AND2_652/net6 VDD VDD pmos W=0.41u L=0.04u
M9143 AND2_652/net6 RESET VDD VDD pmos W=0.41u L=0.04u
M9144 AND2_652/net6 WX1804 VDD VDD pmos W=0.41u L=0.04u
M9145 WX1799 AND2_651/net6 VSS VSS nmos W=0.31u L=0.04u
M9146 AND2_651/X_u2-net6 RESET VSS VSS nmos W=0.31u L=0.04u
M9147 AND2_651/net6 WX1802 AND2_651/X_u2-net6 VSS nmos W=0.31u L=0.04u
M9148 WX1799 AND2_651/net6 VDD VDD pmos W=0.41u L=0.04u
M9149 AND2_651/net6 RESET VDD VDD pmos W=0.41u L=0.04u
M9150 AND2_651/net6 WX1802 VDD VDD pmos W=0.41u L=0.04u
M9151 WX1797 AND2_650/net6 VSS VSS nmos W=0.31u L=0.04u
M9152 AND2_650/X_u2-net6 RESET VSS VSS nmos W=0.31u L=0.04u
M9153 AND2_650/net6 WX1800 AND2_650/X_u2-net6 VSS nmos W=0.31u L=0.04u
M9154 WX1797 AND2_650/net6 VDD VDD pmos W=0.41u L=0.04u
M9155 AND2_650/net6 RESET VDD VDD pmos W=0.41u L=0.04u
M9156 AND2_650/net6 WX1800 VDD VDD pmos W=0.41u L=0.04u
M9157 WX1795 AND2_649/net6 VSS VSS nmos W=0.31u L=0.04u
M9158 AND2_649/X_u2-net6 RESET VSS VSS nmos W=0.31u L=0.04u
M9159 AND2_649/net6 WX1798 AND2_649/X_u2-net6 VSS nmos W=0.31u L=0.04u
M9160 WX1795 AND2_649/net6 VDD VDD pmos W=0.41u L=0.04u
M9161 AND2_649/net6 RESET VDD VDD pmos W=0.41u L=0.04u
M9162 AND2_649/net6 WX1798 VDD VDD pmos W=0.41u L=0.04u
M9163 WX1793 AND2_648/net6 VSS VSS nmos W=0.31u L=0.04u
M9164 AND2_648/X_u2-net6 RESET VSS VSS nmos W=0.31u L=0.04u
M9165 AND2_648/net6 WX1796 AND2_648/X_u2-net6 VSS nmos W=0.31u L=0.04u
M9166 WX1793 AND2_648/net6 VDD VDD pmos W=0.41u L=0.04u
M9167 AND2_648/net6 RESET VDD VDD pmos W=0.41u L=0.04u
M9168 AND2_648/net6 WX1796 VDD VDD pmos W=0.41u L=0.04u
M9169 WX1791 AND2_647/net6 VSS VSS nmos W=0.31u L=0.04u
M9170 AND2_647/X_u2-net6 RESET VSS VSS nmos W=0.31u L=0.04u
M9171 AND2_647/net6 WX1794 AND2_647/X_u2-net6 VSS nmos W=0.31u L=0.04u
M9172 WX1791 AND2_647/net6 VDD VDD pmos W=0.41u L=0.04u
M9173 AND2_647/net6 RESET VDD VDD pmos W=0.41u L=0.04u
M9174 AND2_647/net6 WX1794 VDD VDD pmos W=0.41u L=0.04u
M9175 WX1789 AND2_646/net6 VSS VSS nmos W=0.31u L=0.04u
M9176 AND2_646/X_u2-net6 RESET VSS VSS nmos W=0.31u L=0.04u
M9177 AND2_646/net6 WX1792 AND2_646/X_u2-net6 VSS nmos W=0.31u L=0.04u
M9178 WX1789 AND2_646/net6 VDD VDD pmos W=0.41u L=0.04u
M9179 AND2_646/net6 RESET VDD VDD pmos W=0.41u L=0.04u
M9180 AND2_646/net6 WX1792 VDD VDD pmos W=0.41u L=0.04u
M9181 WX1787 AND2_645/net6 VSS VSS nmos W=0.31u L=0.04u
M9182 AND2_645/X_u2-net6 RESET VSS VSS nmos W=0.31u L=0.04u
M9183 AND2_645/net6 WX1790 AND2_645/X_u2-net6 VSS nmos W=0.31u L=0.04u
M9184 WX1787 AND2_645/net6 VDD VDD pmos W=0.41u L=0.04u
M9185 AND2_645/net6 RESET VDD VDD pmos W=0.41u L=0.04u
M9186 AND2_645/net6 WX1790 VDD VDD pmos W=0.41u L=0.04u
M9187 WX1785 AND2_644/net6 VSS VSS nmos W=0.31u L=0.04u
M9188 AND2_644/X_u2-net6 RESET VSS VSS nmos W=0.31u L=0.04u
M9189 AND2_644/net6 WX1788 AND2_644/X_u2-net6 VSS nmos W=0.31u L=0.04u
M9190 WX1785 AND2_644/net6 VDD VDD pmos W=0.41u L=0.04u
M9191 AND2_644/net6 RESET VDD VDD pmos W=0.41u L=0.04u
M9192 AND2_644/net6 WX1788 VDD VDD pmos W=0.41u L=0.04u
M9193 WX1783 AND2_643/net6 VSS VSS nmos W=0.31u L=0.04u
M9194 AND2_643/X_u2-net6 RESET VSS VSS nmos W=0.31u L=0.04u
M9195 AND2_643/net6 WX1786 AND2_643/X_u2-net6 VSS nmos W=0.31u L=0.04u
M9196 WX1783 AND2_643/net6 VDD VDD pmos W=0.41u L=0.04u
M9197 AND2_643/net6 RESET VDD VDD pmos W=0.41u L=0.04u
M9198 AND2_643/net6 WX1786 VDD VDD pmos W=0.41u L=0.04u
M9199 WX1781 AND2_642/net6 VSS VSS nmos W=0.31u L=0.04u
M9200 AND2_642/X_u2-net6 RESET VSS VSS nmos W=0.31u L=0.04u
M9201 AND2_642/net6 WX1784 AND2_642/X_u2-net6 VSS nmos W=0.31u L=0.04u
M9202 WX1781 AND2_642/net6 VDD VDD pmos W=0.41u L=0.04u
M9203 AND2_642/net6 RESET VDD VDD pmos W=0.41u L=0.04u
M9204 AND2_642/net6 WX1784 VDD VDD pmos W=0.41u L=0.04u
M9205 WX1779 AND2_641/net6 VSS VSS nmos W=0.31u L=0.04u
M9206 AND2_641/X_u2-net6 RESET VSS VSS nmos W=0.31u L=0.04u
M9207 AND2_641/net6 WX1782 AND2_641/X_u2-net6 VSS nmos W=0.31u L=0.04u
M9208 WX1779 AND2_641/net6 VDD VDD pmos W=0.41u L=0.04u
M9209 AND2_641/net6 RESET VDD VDD pmos W=0.41u L=0.04u
M9210 AND2_641/net6 WX1782 VDD VDD pmos W=0.41u L=0.04u
M9211 WX1777 AND2_640/net6 VSS VSS nmos W=0.31u L=0.04u
M9212 AND2_640/X_u2-net6 RESET VSS VSS nmos W=0.31u L=0.04u
M9213 AND2_640/net6 WX1780 AND2_640/X_u2-net6 VSS nmos W=0.31u L=0.04u
M9214 WX1777 AND2_640/net6 VDD VDD pmos W=0.41u L=0.04u
M9215 AND2_640/net6 RESET VDD VDD pmos W=0.41u L=0.04u
M9216 AND2_640/net6 WX1780 VDD VDD pmos W=0.41u L=0.04u
M9217 WX1326 AND2_447/net6 VSS VSS nmos W=0.31u L=0.04u
M9218 AND2_447/X_u2-net6 RESET VSS VSS nmos W=0.31u L=0.04u
M9219 AND2_447/net6 n952 AND2_447/X_u2-net6 VSS nmos W=0.31u L=0.04u
M9220 WX1326 AND2_447/net6 VDD VDD pmos W=0.41u L=0.04u
M9221 AND2_447/net6 RESET VDD VDD pmos W=0.41u L=0.04u
M9222 AND2_447/net6 n952 VDD VDD pmos W=0.41u L=0.04u
M9223 WX1324 AND2_446/net6 VSS VSS nmos W=0.31u L=0.04u
M9224 AND2_446/X_u2-net6 RESET VSS VSS nmos W=0.31u L=0.04u
M9225 AND2_446/net6 n953 AND2_446/X_u2-net6 VSS nmos W=0.31u L=0.04u
M9226 WX1324 AND2_446/net6 VDD VDD pmos W=0.41u L=0.04u
M9227 AND2_446/net6 RESET VDD VDD pmos W=0.41u L=0.04u
M9228 AND2_446/net6 n953 VDD VDD pmos W=0.41u L=0.04u
M9229 WX1322 AND2_445/net6 VSS VSS nmos W=0.31u L=0.04u
M9230 AND2_445/X_u2-net6 RESET VSS VSS nmos W=0.31u L=0.04u
M9231 AND2_445/net6 n954 AND2_445/X_u2-net6 VSS nmos W=0.31u L=0.04u
M9232 WX1322 AND2_445/net6 VDD VDD pmos W=0.41u L=0.04u
M9233 AND2_445/net6 RESET VDD VDD pmos W=0.41u L=0.04u
M9234 AND2_445/net6 n954 VDD VDD pmos W=0.41u L=0.04u
M9235 WX1320 AND2_444/net6 VSS VSS nmos W=0.31u L=0.04u
M9236 AND2_444/X_u2-net6 RESET VSS VSS nmos W=0.31u L=0.04u
M9237 AND2_444/net6 n955 AND2_444/X_u2-net6 VSS nmos W=0.31u L=0.04u
M9238 WX1320 AND2_444/net6 VDD VDD pmos W=0.41u L=0.04u
M9239 AND2_444/net6 RESET VDD VDD pmos W=0.41u L=0.04u
M9240 AND2_444/net6 n955 VDD VDD pmos W=0.41u L=0.04u
M9241 WX1318 AND2_443/net6 VSS VSS nmos W=0.31u L=0.04u
M9242 AND2_443/X_u2-net6 RESET VSS VSS nmos W=0.31u L=0.04u
M9243 AND2_443/net6 n956 AND2_443/X_u2-net6 VSS nmos W=0.31u L=0.04u
M9244 WX1318 AND2_443/net6 VDD VDD pmos W=0.41u L=0.04u
M9245 AND2_443/net6 RESET VDD VDD pmos W=0.41u L=0.04u
M9246 AND2_443/net6 n956 VDD VDD pmos W=0.41u L=0.04u
M9247 WX1316 AND2_442/net6 VSS VSS nmos W=0.31u L=0.04u
M9248 AND2_442/X_u2-net6 RESET VSS VSS nmos W=0.31u L=0.04u
M9249 AND2_442/net6 n957 AND2_442/X_u2-net6 VSS nmos W=0.31u L=0.04u
M9250 WX1316 AND2_442/net6 VDD VDD pmos W=0.41u L=0.04u
M9251 AND2_442/net6 RESET VDD VDD pmos W=0.41u L=0.04u
M9252 AND2_442/net6 n957 VDD VDD pmos W=0.41u L=0.04u
M9253 WX1314 AND2_441/net6 VSS VSS nmos W=0.31u L=0.04u
M9254 AND2_441/X_u2-net6 RESET VSS VSS nmos W=0.31u L=0.04u
M9255 AND2_441/net6 n958 AND2_441/X_u2-net6 VSS nmos W=0.31u L=0.04u
M9256 WX1314 AND2_441/net6 VDD VDD pmos W=0.41u L=0.04u
M9257 AND2_441/net6 RESET VDD VDD pmos W=0.41u L=0.04u
M9258 AND2_441/net6 n958 VDD VDD pmos W=0.41u L=0.04u
M9259 WX1312 AND2_440/net6 VSS VSS nmos W=0.31u L=0.04u
M9260 AND2_440/X_u2-net6 RESET VSS VSS nmos W=0.31u L=0.04u
M9261 AND2_440/net6 n959 AND2_440/X_u2-net6 VSS nmos W=0.31u L=0.04u
M9262 WX1312 AND2_440/net6 VDD VDD pmos W=0.41u L=0.04u
M9263 AND2_440/net6 RESET VDD VDD pmos W=0.41u L=0.04u
M9264 AND2_440/net6 n959 VDD VDD pmos W=0.41u L=0.04u
M9265 WX1310 AND2_439/net6 VSS VSS nmos W=0.31u L=0.04u
M9266 AND2_439/X_u2-net6 RESET VSS VSS nmos W=0.31u L=0.04u
M9267 AND2_439/net6 n960 AND2_439/X_u2-net6 VSS nmos W=0.31u L=0.04u
M9268 WX1310 AND2_439/net6 VDD VDD pmos W=0.41u L=0.04u
M9269 AND2_439/net6 RESET VDD VDD pmos W=0.41u L=0.04u
M9270 AND2_439/net6 n960 VDD VDD pmos W=0.41u L=0.04u
M9271 WX1308 AND2_438/net6 VSS VSS nmos W=0.31u L=0.04u
M9272 AND2_438/X_u2-net6 RESET VSS VSS nmos W=0.31u L=0.04u
M9273 AND2_438/net6 n961 AND2_438/X_u2-net6 VSS nmos W=0.31u L=0.04u
M9274 WX1308 AND2_438/net6 VDD VDD pmos W=0.41u L=0.04u
M9275 AND2_438/net6 RESET VDD VDD pmos W=0.41u L=0.04u
M9276 AND2_438/net6 n961 VDD VDD pmos W=0.41u L=0.04u
M9277 WX1306 AND2_437/net6 VSS VSS nmos W=0.31u L=0.04u
M9278 AND2_437/X_u2-net6 RESET VSS VSS nmos W=0.31u L=0.04u
M9279 AND2_437/net6 n962 AND2_437/X_u2-net6 VSS nmos W=0.31u L=0.04u
M9280 WX1306 AND2_437/net6 VDD VDD pmos W=0.41u L=0.04u
M9281 AND2_437/net6 RESET VDD VDD pmos W=0.41u L=0.04u
M9282 AND2_437/net6 n962 VDD VDD pmos W=0.41u L=0.04u
M9283 WX1304 AND2_436/net6 VSS VSS nmos W=0.31u L=0.04u
M9284 AND2_436/X_u2-net6 RESET VSS VSS nmos W=0.31u L=0.04u
M9285 AND2_436/net6 n963 AND2_436/X_u2-net6 VSS nmos W=0.31u L=0.04u
M9286 WX1304 AND2_436/net6 VDD VDD pmos W=0.41u L=0.04u
M9287 AND2_436/net6 RESET VDD VDD pmos W=0.41u L=0.04u
M9288 AND2_436/net6 n963 VDD VDD pmos W=0.41u L=0.04u
M9289 WX1302 AND2_435/net6 VSS VSS nmos W=0.31u L=0.04u
M9290 AND2_435/X_u2-net6 RESET VSS VSS nmos W=0.31u L=0.04u
M9291 AND2_435/net6 n964 AND2_435/X_u2-net6 VSS nmos W=0.31u L=0.04u
M9292 WX1302 AND2_435/net6 VDD VDD pmos W=0.41u L=0.04u
M9293 AND2_435/net6 RESET VDD VDD pmos W=0.41u L=0.04u
M9294 AND2_435/net6 n964 VDD VDD pmos W=0.41u L=0.04u
M9295 WX1300 AND2_434/net6 VSS VSS nmos W=0.31u L=0.04u
M9296 AND2_434/X_u2-net6 RESET VSS VSS nmos W=0.31u L=0.04u
M9297 AND2_434/net6 n965 AND2_434/X_u2-net6 VSS nmos W=0.31u L=0.04u
M9298 WX1300 AND2_434/net6 VDD VDD pmos W=0.41u L=0.04u
M9299 AND2_434/net6 RESET VDD VDD pmos W=0.41u L=0.04u
M9300 AND2_434/net6 n965 VDD VDD pmos W=0.41u L=0.04u
M9301 WX1298 AND2_433/net6 VSS VSS nmos W=0.31u L=0.04u
M9302 AND2_433/X_u2-net6 RESET VSS VSS nmos W=0.31u L=0.04u
M9303 AND2_433/net6 n966 AND2_433/X_u2-net6 VSS nmos W=0.31u L=0.04u
M9304 WX1298 AND2_433/net6 VDD VDD pmos W=0.41u L=0.04u
M9305 AND2_433/net6 RESET VDD VDD pmos W=0.41u L=0.04u
M9306 AND2_433/net6 n966 VDD VDD pmos W=0.41u L=0.04u
M9307 WX1296 AND2_432/net6 VSS VSS nmos W=0.31u L=0.04u
M9308 AND2_432/X_u2-net6 RESET VSS VSS nmos W=0.31u L=0.04u
M9309 AND2_432/net6 n967 AND2_432/X_u2-net6 VSS nmos W=0.31u L=0.04u
M9310 WX1296 AND2_432/net6 VDD VDD pmos W=0.41u L=0.04u
M9311 AND2_432/net6 RESET VDD VDD pmos W=0.41u L=0.04u
M9312 AND2_432/net6 n967 VDD VDD pmos W=0.41u L=0.04u
M9313 WX1294 AND2_431/net6 VSS VSS nmos W=0.31u L=0.04u
M9314 AND2_431/X_u2-net6 RESET VSS VSS nmos W=0.31u L=0.04u
M9315 AND2_431/net6 n968 AND2_431/X_u2-net6 VSS nmos W=0.31u L=0.04u
M9316 WX1294 AND2_431/net6 VDD VDD pmos W=0.41u L=0.04u
M9317 AND2_431/net6 RESET VDD VDD pmos W=0.41u L=0.04u
M9318 AND2_431/net6 n968 VDD VDD pmos W=0.41u L=0.04u
M9319 WX1292 AND2_430/net6 VSS VSS nmos W=0.31u L=0.04u
M9320 AND2_430/X_u2-net6 RESET VSS VSS nmos W=0.31u L=0.04u
M9321 AND2_430/net6 n969 AND2_430/X_u2-net6 VSS nmos W=0.31u L=0.04u
M9322 WX1292 AND2_430/net6 VDD VDD pmos W=0.41u L=0.04u
M9323 AND2_430/net6 RESET VDD VDD pmos W=0.41u L=0.04u
M9324 AND2_430/net6 n969 VDD VDD pmos W=0.41u L=0.04u
M9325 WX1290 AND2_429/net6 VSS VSS nmos W=0.31u L=0.04u
M9326 AND2_429/X_u2-net6 RESET VSS VSS nmos W=0.31u L=0.04u
M9327 AND2_429/net6 n970 AND2_429/X_u2-net6 VSS nmos W=0.31u L=0.04u
M9328 WX1290 AND2_429/net6 VDD VDD pmos W=0.41u L=0.04u
M9329 AND2_429/net6 RESET VDD VDD pmos W=0.41u L=0.04u
M9330 AND2_429/net6 n970 VDD VDD pmos W=0.41u L=0.04u
M9331 WX1288 AND2_428/net6 VSS VSS nmos W=0.31u L=0.04u
M9332 AND2_428/X_u2-net6 RESET VSS VSS nmos W=0.31u L=0.04u
M9333 AND2_428/net6 n971 AND2_428/X_u2-net6 VSS nmos W=0.31u L=0.04u
M9334 WX1288 AND2_428/net6 VDD VDD pmos W=0.41u L=0.04u
M9335 AND2_428/net6 RESET VDD VDD pmos W=0.41u L=0.04u
M9336 AND2_428/net6 n971 VDD VDD pmos W=0.41u L=0.04u
M9337 WX1286 AND2_427/net6 VSS VSS nmos W=0.31u L=0.04u
M9338 AND2_427/X_u2-net6 RESET VSS VSS nmos W=0.31u L=0.04u
M9339 AND2_427/net6 n972 AND2_427/X_u2-net6 VSS nmos W=0.31u L=0.04u
M9340 WX1286 AND2_427/net6 VDD VDD pmos W=0.41u L=0.04u
M9341 AND2_427/net6 RESET VDD VDD pmos W=0.41u L=0.04u
M9342 AND2_427/net6 n972 VDD VDD pmos W=0.41u L=0.04u
M9343 WX1284 AND2_426/net6 VSS VSS nmos W=0.31u L=0.04u
M9344 AND2_426/X_u2-net6 RESET VSS VSS nmos W=0.31u L=0.04u
M9345 AND2_426/net6 n973 AND2_426/X_u2-net6 VSS nmos W=0.31u L=0.04u
M9346 WX1284 AND2_426/net6 VDD VDD pmos W=0.41u L=0.04u
M9347 AND2_426/net6 RESET VDD VDD pmos W=0.41u L=0.04u
M9348 AND2_426/net6 n973 VDD VDD pmos W=0.41u L=0.04u
M9349 WX1282 AND2_425/net6 VSS VSS nmos W=0.31u L=0.04u
M9350 AND2_425/X_u2-net6 RESET VSS VSS nmos W=0.31u L=0.04u
M9351 AND2_425/net6 n974 AND2_425/X_u2-net6 VSS nmos W=0.31u L=0.04u
M9352 WX1282 AND2_425/net6 VDD VDD pmos W=0.41u L=0.04u
M9353 AND2_425/net6 RESET VDD VDD pmos W=0.41u L=0.04u
M9354 AND2_425/net6 n974 VDD VDD pmos W=0.41u L=0.04u
M9355 WX1280 AND2_424/net6 VSS VSS nmos W=0.31u L=0.04u
M9356 AND2_424/X_u2-net6 RESET VSS VSS nmos W=0.31u L=0.04u
M9357 AND2_424/net6 n975 AND2_424/X_u2-net6 VSS nmos W=0.31u L=0.04u
M9358 WX1280 AND2_424/net6 VDD VDD pmos W=0.41u L=0.04u
M9359 AND2_424/net6 RESET VDD VDD pmos W=0.41u L=0.04u
M9360 AND2_424/net6 n975 VDD VDD pmos W=0.41u L=0.04u
M9361 WX1278 AND2_423/net6 VSS VSS nmos W=0.31u L=0.04u
M9362 AND2_423/X_u2-net6 RESET VSS VSS nmos W=0.31u L=0.04u
M9363 AND2_423/net6 n976 AND2_423/X_u2-net6 VSS nmos W=0.31u L=0.04u
M9364 WX1278 AND2_423/net6 VDD VDD pmos W=0.41u L=0.04u
M9365 AND2_423/net6 RESET VDD VDD pmos W=0.41u L=0.04u
M9366 AND2_423/net6 n976 VDD VDD pmos W=0.41u L=0.04u
M9367 WX1276 AND2_422/net6 VSS VSS nmos W=0.31u L=0.04u
M9368 AND2_422/X_u2-net6 RESET VSS VSS nmos W=0.31u L=0.04u
M9369 AND2_422/net6 n977 AND2_422/X_u2-net6 VSS nmos W=0.31u L=0.04u
M9370 WX1276 AND2_422/net6 VDD VDD pmos W=0.41u L=0.04u
M9371 AND2_422/net6 RESET VDD VDD pmos W=0.41u L=0.04u
M9372 AND2_422/net6 n977 VDD VDD pmos W=0.41u L=0.04u
M9373 WX1274 AND2_421/net6 VSS VSS nmos W=0.31u L=0.04u
M9374 AND2_421/X_u2-net6 RESET VSS VSS nmos W=0.31u L=0.04u
M9375 AND2_421/net6 n978 AND2_421/X_u2-net6 VSS nmos W=0.31u L=0.04u
M9376 WX1274 AND2_421/net6 VDD VDD pmos W=0.41u L=0.04u
M9377 AND2_421/net6 RESET VDD VDD pmos W=0.41u L=0.04u
M9378 AND2_421/net6 n978 VDD VDD pmos W=0.41u L=0.04u
M9379 WX1272 AND2_420/net6 VSS VSS nmos W=0.31u L=0.04u
M9380 AND2_420/X_u2-net6 RESET VSS VSS nmos W=0.31u L=0.04u
M9381 AND2_420/net6 n979 AND2_420/X_u2-net6 VSS nmos W=0.31u L=0.04u
M9382 WX1272 AND2_420/net6 VDD VDD pmos W=0.41u L=0.04u
M9383 AND2_420/net6 RESET VDD VDD pmos W=0.41u L=0.04u
M9384 AND2_420/net6 n979 VDD VDD pmos W=0.41u L=0.04u
M9385 WX1270 AND2_419/net6 VSS VSS nmos W=0.31u L=0.04u
M9386 AND2_419/X_u2-net6 RESET VSS VSS nmos W=0.31u L=0.04u
M9387 AND2_419/net6 n980 AND2_419/X_u2-net6 VSS nmos W=0.31u L=0.04u
M9388 WX1270 AND2_419/net6 VDD VDD pmos W=0.41u L=0.04u
M9389 AND2_419/net6 RESET VDD VDD pmos W=0.41u L=0.04u
M9390 AND2_419/net6 n980 VDD VDD pmos W=0.41u L=0.04u
M9391 WX1268 AND2_418/net6 VSS VSS nmos W=0.31u L=0.04u
M9392 AND2_418/X_u2-net6 RESET VSS VSS nmos W=0.31u L=0.04u
M9393 AND2_418/net6 n981 AND2_418/X_u2-net6 VSS nmos W=0.31u L=0.04u
M9394 WX1268 AND2_418/net6 VDD VDD pmos W=0.41u L=0.04u
M9395 AND2_418/net6 RESET VDD VDD pmos W=0.41u L=0.04u
M9396 AND2_418/net6 n981 VDD VDD pmos W=0.41u L=0.04u
M9397 WX1266 AND2_417/net6 VSS VSS nmos W=0.31u L=0.04u
M9398 AND2_417/X_u2-net6 RESET VSS VSS nmos W=0.31u L=0.04u
M9399 AND2_417/net6 n982 AND2_417/X_u2-net6 VSS nmos W=0.31u L=0.04u
M9400 WX1266 AND2_417/net6 VDD VDD pmos W=0.41u L=0.04u
M9401 AND2_417/net6 RESET VDD VDD pmos W=0.41u L=0.04u
M9402 AND2_417/net6 n982 VDD VDD pmos W=0.41u L=0.04u
M9403 WX1264 AND2_416/net6 VSS VSS nmos W=0.31u L=0.04u
M9404 AND2_416/X_u2-net6 RESET VSS VSS nmos W=0.31u L=0.04u
M9405 AND2_416/net6 n983 AND2_416/X_u2-net6 VSS nmos W=0.31u L=0.04u
M9406 WX1264 AND2_416/net6 VDD VDD pmos W=0.41u L=0.04u
M9407 AND2_416/net6 RESET VDD VDD pmos W=0.41u L=0.04u
M9408 AND2_416/net6 n983 VDD VDD pmos W=0.41u L=0.04u
M9409 WX898 AND2_351/net6 VSS VSS nmos W=0.31u L=0.04u
M9410 AND2_351/X_u2-net6 RESET VSS VSS nmos W=0.31u L=0.04u
M9411 AND2_351/net6 WX835 AND2_351/X_u2-net6 VSS nmos W=0.31u L=0.04u
M9412 WX898 AND2_351/net6 VDD VDD pmos W=0.41u L=0.04u
M9413 AND2_351/net6 RESET VDD VDD pmos W=0.41u L=0.04u
M9414 AND2_351/net6 WX835 VDD VDD pmos W=0.41u L=0.04u
M9415 WX896 AND2_350/net6 VSS VSS nmos W=0.31u L=0.04u
M9416 AND2_350/X_u2-net6 RESET VSS VSS nmos W=0.31u L=0.04u
M9417 AND2_350/net6 WX833 AND2_350/X_u2-net6 VSS nmos W=0.31u L=0.04u
M9418 WX896 AND2_350/net6 VDD VDD pmos W=0.41u L=0.04u
M9419 AND2_350/net6 RESET VDD VDD pmos W=0.41u L=0.04u
M9420 AND2_350/net6 WX833 VDD VDD pmos W=0.41u L=0.04u
M9421 WX894 AND2_349/net6 VSS VSS nmos W=0.31u L=0.04u
M9422 AND2_349/X_u2-net6 RESET VSS VSS nmos W=0.31u L=0.04u
M9423 AND2_349/net6 WX831 AND2_349/X_u2-net6 VSS nmos W=0.31u L=0.04u
M9424 WX894 AND2_349/net6 VDD VDD pmos W=0.41u L=0.04u
M9425 AND2_349/net6 RESET VDD VDD pmos W=0.41u L=0.04u
M9426 AND2_349/net6 WX831 VDD VDD pmos W=0.41u L=0.04u
M9427 WX892 AND2_348/net6 VSS VSS nmos W=0.31u L=0.04u
M9428 AND2_348/X_u2-net6 RESET VSS VSS nmos W=0.31u L=0.04u
M9429 AND2_348/net6 WX829 AND2_348/X_u2-net6 VSS nmos W=0.31u L=0.04u
M9430 WX892 AND2_348/net6 VDD VDD pmos W=0.41u L=0.04u
M9431 AND2_348/net6 RESET VDD VDD pmos W=0.41u L=0.04u
M9432 AND2_348/net6 WX829 VDD VDD pmos W=0.41u L=0.04u
M9433 WX890 AND2_347/net6 VSS VSS nmos W=0.31u L=0.04u
M9434 AND2_347/X_u2-net6 RESET VSS VSS nmos W=0.31u L=0.04u
M9435 AND2_347/net6 WX827 AND2_347/X_u2-net6 VSS nmos W=0.31u L=0.04u
M9436 WX890 AND2_347/net6 VDD VDD pmos W=0.41u L=0.04u
M9437 AND2_347/net6 RESET VDD VDD pmos W=0.41u L=0.04u
M9438 AND2_347/net6 WX827 VDD VDD pmos W=0.41u L=0.04u
M9439 WX888 AND2_346/net6 VSS VSS nmos W=0.31u L=0.04u
M9440 AND2_346/X_u2-net6 RESET VSS VSS nmos W=0.31u L=0.04u
M9441 AND2_346/net6 WX825 AND2_346/X_u2-net6 VSS nmos W=0.31u L=0.04u
M9442 WX888 AND2_346/net6 VDD VDD pmos W=0.41u L=0.04u
M9443 AND2_346/net6 RESET VDD VDD pmos W=0.41u L=0.04u
M9444 AND2_346/net6 WX825 VDD VDD pmos W=0.41u L=0.04u
M9445 WX886 AND2_345/net6 VSS VSS nmos W=0.31u L=0.04u
M9446 AND2_345/X_u2-net6 RESET VSS VSS nmos W=0.31u L=0.04u
M9447 AND2_345/net6 WX823 AND2_345/X_u2-net6 VSS nmos W=0.31u L=0.04u
M9448 WX886 AND2_345/net6 VDD VDD pmos W=0.41u L=0.04u
M9449 AND2_345/net6 RESET VDD VDD pmos W=0.41u L=0.04u
M9450 AND2_345/net6 WX823 VDD VDD pmos W=0.41u L=0.04u
M9451 WX884 AND2_344/net6 VSS VSS nmos W=0.31u L=0.04u
M9452 AND2_344/X_u2-net6 RESET VSS VSS nmos W=0.31u L=0.04u
M9453 AND2_344/net6 WX821 AND2_344/X_u2-net6 VSS nmos W=0.31u L=0.04u
M9454 WX884 AND2_344/net6 VDD VDD pmos W=0.41u L=0.04u
M9455 AND2_344/net6 RESET VDD VDD pmos W=0.41u L=0.04u
M9456 AND2_344/net6 WX821 VDD VDD pmos W=0.41u L=0.04u
M9457 WX882 AND2_343/net6 VSS VSS nmos W=0.31u L=0.04u
M9458 AND2_343/X_u2-net6 RESET VSS VSS nmos W=0.31u L=0.04u
M9459 AND2_343/net6 WX819 AND2_343/X_u2-net6 VSS nmos W=0.31u L=0.04u
M9460 WX882 AND2_343/net6 VDD VDD pmos W=0.41u L=0.04u
M9461 AND2_343/net6 RESET VDD VDD pmos W=0.41u L=0.04u
M9462 AND2_343/net6 WX819 VDD VDD pmos W=0.41u L=0.04u
M9463 WX880 AND2_342/net6 VSS VSS nmos W=0.31u L=0.04u
M9464 AND2_342/X_u2-net6 RESET VSS VSS nmos W=0.31u L=0.04u
M9465 AND2_342/net6 WX817 AND2_342/X_u2-net6 VSS nmos W=0.31u L=0.04u
M9466 WX880 AND2_342/net6 VDD VDD pmos W=0.41u L=0.04u
M9467 AND2_342/net6 RESET VDD VDD pmos W=0.41u L=0.04u
M9468 AND2_342/net6 WX817 VDD VDD pmos W=0.41u L=0.04u
M9469 WX878 AND2_341/net6 VSS VSS nmos W=0.31u L=0.04u
M9470 AND2_341/X_u2-net6 RESET VSS VSS nmos W=0.31u L=0.04u
M9471 AND2_341/net6 WX815 AND2_341/X_u2-net6 VSS nmos W=0.31u L=0.04u
M9472 WX878 AND2_341/net6 VDD VDD pmos W=0.41u L=0.04u
M9473 AND2_341/net6 RESET VDD VDD pmos W=0.41u L=0.04u
M9474 AND2_341/net6 WX815 VDD VDD pmos W=0.41u L=0.04u
M9475 WX876 AND2_340/net6 VSS VSS nmos W=0.31u L=0.04u
M9476 AND2_340/X_u2-net6 RESET VSS VSS nmos W=0.31u L=0.04u
M9477 AND2_340/net6 WX813 AND2_340/X_u2-net6 VSS nmos W=0.31u L=0.04u
M9478 WX876 AND2_340/net6 VDD VDD pmos W=0.41u L=0.04u
M9479 AND2_340/net6 RESET VDD VDD pmos W=0.41u L=0.04u
M9480 AND2_340/net6 WX813 VDD VDD pmos W=0.41u L=0.04u
M9481 WX874 AND2_339/net6 VSS VSS nmos W=0.31u L=0.04u
M9482 AND2_339/X_u2-net6 RESET VSS VSS nmos W=0.31u L=0.04u
M9483 AND2_339/net6 WX811 AND2_339/X_u2-net6 VSS nmos W=0.31u L=0.04u
M9484 WX874 AND2_339/net6 VDD VDD pmos W=0.41u L=0.04u
M9485 AND2_339/net6 RESET VDD VDD pmos W=0.41u L=0.04u
M9486 AND2_339/net6 WX811 VDD VDD pmos W=0.41u L=0.04u
M9487 WX872 AND2_338/net6 VSS VSS nmos W=0.31u L=0.04u
M9488 AND2_338/X_u2-net6 RESET VSS VSS nmos W=0.31u L=0.04u
M9489 AND2_338/net6 WX809 AND2_338/X_u2-net6 VSS nmos W=0.31u L=0.04u
M9490 WX872 AND2_338/net6 VDD VDD pmos W=0.41u L=0.04u
M9491 AND2_338/net6 RESET VDD VDD pmos W=0.41u L=0.04u
M9492 AND2_338/net6 WX809 VDD VDD pmos W=0.41u L=0.04u
M9493 WX870 AND2_337/net6 VSS VSS nmos W=0.31u L=0.04u
M9494 AND2_337/X_u2-net6 RESET VSS VSS nmos W=0.31u L=0.04u
M9495 AND2_337/net6 WX807 AND2_337/X_u2-net6 VSS nmos W=0.31u L=0.04u
M9496 WX870 AND2_337/net6 VDD VDD pmos W=0.41u L=0.04u
M9497 AND2_337/net6 RESET VDD VDD pmos W=0.41u L=0.04u
M9498 AND2_337/net6 WX807 VDD VDD pmos W=0.41u L=0.04u
M9499 WX868 AND2_336/net6 VSS VSS nmos W=0.31u L=0.04u
M9500 AND2_336/X_u2-net6 RESET VSS VSS nmos W=0.31u L=0.04u
M9501 AND2_336/net6 WX805 AND2_336/X_u2-net6 VSS nmos W=0.31u L=0.04u
M9502 WX868 AND2_336/net6 VDD VDD pmos W=0.41u L=0.04u
M9503 AND2_336/net6 RESET VDD VDD pmos W=0.41u L=0.04u
M9504 AND2_336/net6 WX805 VDD VDD pmos W=0.41u L=0.04u
M9505 WX866 AND2_335/net6 VSS VSS nmos W=0.31u L=0.04u
M9506 AND2_335/X_u2-net6 RESET VSS VSS nmos W=0.31u L=0.04u
M9507 AND2_335/net6 WX803 AND2_335/X_u2-net6 VSS nmos W=0.31u L=0.04u
M9508 WX866 AND2_335/net6 VDD VDD pmos W=0.41u L=0.04u
M9509 AND2_335/net6 RESET VDD VDD pmos W=0.41u L=0.04u
M9510 AND2_335/net6 WX803 VDD VDD pmos W=0.41u L=0.04u
M9511 WX864 AND2_334/net6 VSS VSS nmos W=0.31u L=0.04u
M9512 AND2_334/X_u2-net6 RESET VSS VSS nmos W=0.31u L=0.04u
M9513 AND2_334/net6 WX801 AND2_334/X_u2-net6 VSS nmos W=0.31u L=0.04u
M9514 WX864 AND2_334/net6 VDD VDD pmos W=0.41u L=0.04u
M9515 AND2_334/net6 RESET VDD VDD pmos W=0.41u L=0.04u
M9516 AND2_334/net6 WX801 VDD VDD pmos W=0.41u L=0.04u
M9517 WX862 AND2_333/net6 VSS VSS nmos W=0.31u L=0.04u
M9518 AND2_333/X_u2-net6 RESET VSS VSS nmos W=0.31u L=0.04u
M9519 AND2_333/net6 WX799 AND2_333/X_u2-net6 VSS nmos W=0.31u L=0.04u
M9520 WX862 AND2_333/net6 VDD VDD pmos W=0.41u L=0.04u
M9521 AND2_333/net6 RESET VDD VDD pmos W=0.41u L=0.04u
M9522 AND2_333/net6 WX799 VDD VDD pmos W=0.41u L=0.04u
M9523 WX860 AND2_332/net6 VSS VSS nmos W=0.31u L=0.04u
M9524 AND2_332/X_u2-net6 RESET VSS VSS nmos W=0.31u L=0.04u
M9525 AND2_332/net6 WX797 AND2_332/X_u2-net6 VSS nmos W=0.31u L=0.04u
M9526 WX860 AND2_332/net6 VDD VDD pmos W=0.41u L=0.04u
M9527 AND2_332/net6 RESET VDD VDD pmos W=0.41u L=0.04u
M9528 AND2_332/net6 WX797 VDD VDD pmos W=0.41u L=0.04u
M9529 WX858 AND2_331/net6 VSS VSS nmos W=0.31u L=0.04u
M9530 AND2_331/X_u2-net6 RESET VSS VSS nmos W=0.31u L=0.04u
M9531 AND2_331/net6 WX795 AND2_331/X_u2-net6 VSS nmos W=0.31u L=0.04u
M9532 WX858 AND2_331/net6 VDD VDD pmos W=0.41u L=0.04u
M9533 AND2_331/net6 RESET VDD VDD pmos W=0.41u L=0.04u
M9534 AND2_331/net6 WX795 VDD VDD pmos W=0.41u L=0.04u
M9535 WX856 AND2_330/net6 VSS VSS nmos W=0.31u L=0.04u
M9536 AND2_330/X_u2-net6 RESET VSS VSS nmos W=0.31u L=0.04u
M9537 AND2_330/net6 WX793 AND2_330/X_u2-net6 VSS nmos W=0.31u L=0.04u
M9538 WX856 AND2_330/net6 VDD VDD pmos W=0.41u L=0.04u
M9539 AND2_330/net6 RESET VDD VDD pmos W=0.41u L=0.04u
M9540 AND2_330/net6 WX793 VDD VDD pmos W=0.41u L=0.04u
M9541 WX854 AND2_329/net6 VSS VSS nmos W=0.31u L=0.04u
M9542 AND2_329/X_u2-net6 RESET VSS VSS nmos W=0.31u L=0.04u
M9543 AND2_329/net6 WX791 AND2_329/X_u2-net6 VSS nmos W=0.31u L=0.04u
M9544 WX854 AND2_329/net6 VDD VDD pmos W=0.41u L=0.04u
M9545 AND2_329/net6 RESET VDD VDD pmos W=0.41u L=0.04u
M9546 AND2_329/net6 WX791 VDD VDD pmos W=0.41u L=0.04u
M9547 WX852 AND2_328/net6 VSS VSS nmos W=0.31u L=0.04u
M9548 AND2_328/X_u2-net6 RESET VSS VSS nmos W=0.31u L=0.04u
M9549 AND2_328/net6 WX789 AND2_328/X_u2-net6 VSS nmos W=0.31u L=0.04u
M9550 WX852 AND2_328/net6 VDD VDD pmos W=0.41u L=0.04u
M9551 AND2_328/net6 RESET VDD VDD pmos W=0.41u L=0.04u
M9552 AND2_328/net6 WX789 VDD VDD pmos W=0.41u L=0.04u
M9553 WX850 AND2_327/net6 VSS VSS nmos W=0.31u L=0.04u
M9554 AND2_327/X_u2-net6 RESET VSS VSS nmos W=0.31u L=0.04u
M9555 AND2_327/net6 WX787 AND2_327/X_u2-net6 VSS nmos W=0.31u L=0.04u
M9556 WX850 AND2_327/net6 VDD VDD pmos W=0.41u L=0.04u
M9557 AND2_327/net6 RESET VDD VDD pmos W=0.41u L=0.04u
M9558 AND2_327/net6 WX787 VDD VDD pmos W=0.41u L=0.04u
M9559 WX848 AND2_326/net6 VSS VSS nmos W=0.31u L=0.04u
M9560 AND2_326/X_u2-net6 RESET VSS VSS nmos W=0.31u L=0.04u
M9561 AND2_326/net6 WX785 AND2_326/X_u2-net6 VSS nmos W=0.31u L=0.04u
M9562 WX848 AND2_326/net6 VDD VDD pmos W=0.41u L=0.04u
M9563 AND2_326/net6 RESET VDD VDD pmos W=0.41u L=0.04u
M9564 AND2_326/net6 WX785 VDD VDD pmos W=0.41u L=0.04u
M9565 WX846 AND2_325/net6 VSS VSS nmos W=0.31u L=0.04u
M9566 AND2_325/X_u2-net6 RESET VSS VSS nmos W=0.31u L=0.04u
M9567 AND2_325/net6 WX783 AND2_325/X_u2-net6 VSS nmos W=0.31u L=0.04u
M9568 WX846 AND2_325/net6 VDD VDD pmos W=0.41u L=0.04u
M9569 AND2_325/net6 RESET VDD VDD pmos W=0.41u L=0.04u
M9570 AND2_325/net6 WX783 VDD VDD pmos W=0.41u L=0.04u
M9571 WX844 AND2_324/net6 VSS VSS nmos W=0.31u L=0.04u
M9572 AND2_324/X_u2-net6 RESET VSS VSS nmos W=0.31u L=0.04u
M9573 AND2_324/net6 WX781 AND2_324/X_u2-net6 VSS nmos W=0.31u L=0.04u
M9574 WX844 AND2_324/net6 VDD VDD pmos W=0.41u L=0.04u
M9575 AND2_324/net6 RESET VDD VDD pmos W=0.41u L=0.04u
M9576 AND2_324/net6 WX781 VDD VDD pmos W=0.41u L=0.04u
M9577 WX842 AND2_323/net6 VSS VSS nmos W=0.31u L=0.04u
M9578 AND2_323/X_u2-net6 RESET VSS VSS nmos W=0.31u L=0.04u
M9579 AND2_323/net6 WX779 AND2_323/X_u2-net6 VSS nmos W=0.31u L=0.04u
M9580 WX842 AND2_323/net6 VDD VDD pmos W=0.41u L=0.04u
M9581 AND2_323/net6 RESET VDD VDD pmos W=0.41u L=0.04u
M9582 AND2_323/net6 WX779 VDD VDD pmos W=0.41u L=0.04u
M9583 WX840 AND2_322/net6 VSS VSS nmos W=0.31u L=0.04u
M9584 AND2_322/X_u2-net6 RESET VSS VSS nmos W=0.31u L=0.04u
M9585 AND2_322/net6 WX777 AND2_322/X_u2-net6 VSS nmos W=0.31u L=0.04u
M9586 WX840 AND2_322/net6 VDD VDD pmos W=0.41u L=0.04u
M9587 AND2_322/net6 RESET VDD VDD pmos W=0.41u L=0.04u
M9588 AND2_322/net6 WX777 VDD VDD pmos W=0.41u L=0.04u
M9589 WX838 AND2_321/net6 VSS VSS nmos W=0.31u L=0.04u
M9590 AND2_321/X_u2-net6 RESET VSS VSS nmos W=0.31u L=0.04u
M9591 AND2_321/net6 WX775 AND2_321/X_u2-net6 VSS nmos W=0.31u L=0.04u
M9592 WX838 AND2_321/net6 VDD VDD pmos W=0.41u L=0.04u
M9593 AND2_321/net6 RESET VDD VDD pmos W=0.41u L=0.04u
M9594 AND2_321/net6 WX775 VDD VDD pmos W=0.41u L=0.04u
M9595 WX836 AND2_320/net6 VSS VSS nmos W=0.31u L=0.04u
M9596 AND2_320/X_u2-net6 RESET VSS VSS nmos W=0.31u L=0.04u
M9597 AND2_320/net6 WX773 AND2_320/X_u2-net6 VSS nmos W=0.31u L=0.04u
M9598 WX836 AND2_320/net6 VDD VDD pmos W=0.41u L=0.04u
M9599 AND2_320/net6 RESET VDD VDD pmos W=0.41u L=0.04u
M9600 AND2_320/net6 WX773 VDD VDD pmos W=0.41u L=0.04u
M9601 WX834 AND2_319/net6 VSS VSS nmos W=0.31u L=0.04u
M9602 AND2_319/X_u2-net6 RESET VSS VSS nmos W=0.31u L=0.04u
M9603 AND2_319/net6 WX771 AND2_319/X_u2-net6 VSS nmos W=0.31u L=0.04u
M9604 WX834 AND2_319/net6 VDD VDD pmos W=0.41u L=0.04u
M9605 AND2_319/net6 RESET VDD VDD pmos W=0.41u L=0.04u
M9606 AND2_319/net6 WX771 VDD VDD pmos W=0.41u L=0.04u
M9607 WX832 AND2_318/net6 VSS VSS nmos W=0.31u L=0.04u
M9608 AND2_318/X_u2-net6 RESET VSS VSS nmos W=0.31u L=0.04u
M9609 AND2_318/net6 WX769 AND2_318/X_u2-net6 VSS nmos W=0.31u L=0.04u
M9610 WX832 AND2_318/net6 VDD VDD pmos W=0.41u L=0.04u
M9611 AND2_318/net6 RESET VDD VDD pmos W=0.41u L=0.04u
M9612 AND2_318/net6 WX769 VDD VDD pmos W=0.41u L=0.04u
M9613 WX830 AND2_317/net6 VSS VSS nmos W=0.31u L=0.04u
M9614 AND2_317/X_u2-net6 RESET VSS VSS nmos W=0.31u L=0.04u
M9615 AND2_317/net6 WX767 AND2_317/X_u2-net6 VSS nmos W=0.31u L=0.04u
M9616 WX830 AND2_317/net6 VDD VDD pmos W=0.41u L=0.04u
M9617 AND2_317/net6 RESET VDD VDD pmos W=0.41u L=0.04u
M9618 AND2_317/net6 WX767 VDD VDD pmos W=0.41u L=0.04u
M9619 WX828 AND2_316/net6 VSS VSS nmos W=0.31u L=0.04u
M9620 AND2_316/X_u2-net6 RESET VSS VSS nmos W=0.31u L=0.04u
M9621 AND2_316/net6 WX765 AND2_316/X_u2-net6 VSS nmos W=0.31u L=0.04u
M9622 WX828 AND2_316/net6 VDD VDD pmos W=0.41u L=0.04u
M9623 AND2_316/net6 RESET VDD VDD pmos W=0.41u L=0.04u
M9624 AND2_316/net6 WX765 VDD VDD pmos W=0.41u L=0.04u
M9625 WX826 AND2_315/net6 VSS VSS nmos W=0.31u L=0.04u
M9626 AND2_315/X_u2-net6 RESET VSS VSS nmos W=0.31u L=0.04u
M9627 AND2_315/net6 WX763 AND2_315/X_u2-net6 VSS nmos W=0.31u L=0.04u
M9628 WX826 AND2_315/net6 VDD VDD pmos W=0.41u L=0.04u
M9629 AND2_315/net6 RESET VDD VDD pmos W=0.41u L=0.04u
M9630 AND2_315/net6 WX763 VDD VDD pmos W=0.41u L=0.04u
M9631 WX824 AND2_314/net6 VSS VSS nmos W=0.31u L=0.04u
M9632 AND2_314/X_u2-net6 RESET VSS VSS nmos W=0.31u L=0.04u
M9633 AND2_314/net6 WX761 AND2_314/X_u2-net6 VSS nmos W=0.31u L=0.04u
M9634 WX824 AND2_314/net6 VDD VDD pmos W=0.41u L=0.04u
M9635 AND2_314/net6 RESET VDD VDD pmos W=0.41u L=0.04u
M9636 AND2_314/net6 WX761 VDD VDD pmos W=0.41u L=0.04u
M9637 WX822 AND2_313/net6 VSS VSS nmos W=0.31u L=0.04u
M9638 AND2_313/X_u2-net6 RESET VSS VSS nmos W=0.31u L=0.04u
M9639 AND2_313/net6 WX759 AND2_313/X_u2-net6 VSS nmos W=0.31u L=0.04u
M9640 WX822 AND2_313/net6 VDD VDD pmos W=0.41u L=0.04u
M9641 AND2_313/net6 RESET VDD VDD pmos W=0.41u L=0.04u
M9642 AND2_313/net6 WX759 VDD VDD pmos W=0.41u L=0.04u
M9643 WX820 AND2_312/net6 VSS VSS nmos W=0.31u L=0.04u
M9644 AND2_312/X_u2-net6 RESET VSS VSS nmos W=0.31u L=0.04u
M9645 AND2_312/net6 WX757 AND2_312/X_u2-net6 VSS nmos W=0.31u L=0.04u
M9646 WX820 AND2_312/net6 VDD VDD pmos W=0.41u L=0.04u
M9647 AND2_312/net6 RESET VDD VDD pmos W=0.41u L=0.04u
M9648 AND2_312/net6 WX757 VDD VDD pmos W=0.41u L=0.04u
M9649 WX818 AND2_311/net6 VSS VSS nmos W=0.31u L=0.04u
M9650 AND2_311/X_u2-net6 RESET VSS VSS nmos W=0.31u L=0.04u
M9651 AND2_311/net6 WX755 AND2_311/X_u2-net6 VSS nmos W=0.31u L=0.04u
M9652 WX818 AND2_311/net6 VDD VDD pmos W=0.41u L=0.04u
M9653 AND2_311/net6 RESET VDD VDD pmos W=0.41u L=0.04u
M9654 AND2_311/net6 WX755 VDD VDD pmos W=0.41u L=0.04u
M9655 WX816 AND2_310/net6 VSS VSS nmos W=0.31u L=0.04u
M9656 AND2_310/X_u2-net6 RESET VSS VSS nmos W=0.31u L=0.04u
M9657 AND2_310/net6 WX753 AND2_310/X_u2-net6 VSS nmos W=0.31u L=0.04u
M9658 WX816 AND2_310/net6 VDD VDD pmos W=0.41u L=0.04u
M9659 AND2_310/net6 RESET VDD VDD pmos W=0.41u L=0.04u
M9660 AND2_310/net6 WX753 VDD VDD pmos W=0.41u L=0.04u
M9661 WX814 AND2_309/net6 VSS VSS nmos W=0.31u L=0.04u
M9662 AND2_309/X_u2-net6 RESET VSS VSS nmos W=0.31u L=0.04u
M9663 AND2_309/net6 WX751 AND2_309/X_u2-net6 VSS nmos W=0.31u L=0.04u
M9664 WX814 AND2_309/net6 VDD VDD pmos W=0.41u L=0.04u
M9665 AND2_309/net6 RESET VDD VDD pmos W=0.41u L=0.04u
M9666 AND2_309/net6 WX751 VDD VDD pmos W=0.41u L=0.04u
M9667 WX812 AND2_308/net6 VSS VSS nmos W=0.31u L=0.04u
M9668 AND2_308/X_u2-net6 RESET VSS VSS nmos W=0.31u L=0.04u
M9669 AND2_308/net6 WX749 AND2_308/X_u2-net6 VSS nmos W=0.31u L=0.04u
M9670 WX812 AND2_308/net6 VDD VDD pmos W=0.41u L=0.04u
M9671 AND2_308/net6 RESET VDD VDD pmos W=0.41u L=0.04u
M9672 AND2_308/net6 WX749 VDD VDD pmos W=0.41u L=0.04u
M9673 WX810 AND2_307/net6 VSS VSS nmos W=0.31u L=0.04u
M9674 AND2_307/X_u2-net6 RESET VSS VSS nmos W=0.31u L=0.04u
M9675 AND2_307/net6 WX747 AND2_307/X_u2-net6 VSS nmos W=0.31u L=0.04u
M9676 WX810 AND2_307/net6 VDD VDD pmos W=0.41u L=0.04u
M9677 AND2_307/net6 RESET VDD VDD pmos W=0.41u L=0.04u
M9678 AND2_307/net6 WX747 VDD VDD pmos W=0.41u L=0.04u
M9679 WX808 AND2_306/net6 VSS VSS nmos W=0.31u L=0.04u
M9680 AND2_306/X_u2-net6 RESET VSS VSS nmos W=0.31u L=0.04u
M9681 AND2_306/net6 WX745 AND2_306/X_u2-net6 VSS nmos W=0.31u L=0.04u
M9682 WX808 AND2_306/net6 VDD VDD pmos W=0.41u L=0.04u
M9683 AND2_306/net6 RESET VDD VDD pmos W=0.41u L=0.04u
M9684 AND2_306/net6 WX745 VDD VDD pmos W=0.41u L=0.04u
M9685 WX806 AND2_305/net6 VSS VSS nmos W=0.31u L=0.04u
M9686 AND2_305/X_u2-net6 RESET VSS VSS nmos W=0.31u L=0.04u
M9687 AND2_305/net6 WX743 AND2_305/X_u2-net6 VSS nmos W=0.31u L=0.04u
M9688 WX806 AND2_305/net6 VDD VDD pmos W=0.41u L=0.04u
M9689 AND2_305/net6 RESET VDD VDD pmos W=0.41u L=0.04u
M9690 AND2_305/net6 WX743 VDD VDD pmos W=0.41u L=0.04u
M9691 WX804 AND2_304/net6 VSS VSS nmos W=0.31u L=0.04u
M9692 AND2_304/X_u2-net6 RESET VSS VSS nmos W=0.31u L=0.04u
M9693 AND2_304/net6 WX741 AND2_304/X_u2-net6 VSS nmos W=0.31u L=0.04u
M9694 WX804 AND2_304/net6 VDD VDD pmos W=0.41u L=0.04u
M9695 AND2_304/net6 RESET VDD VDD pmos W=0.41u L=0.04u
M9696 AND2_304/net6 WX741 VDD VDD pmos W=0.41u L=0.04u
M9697 WX802 AND2_303/net6 VSS VSS nmos W=0.31u L=0.04u
M9698 AND2_303/X_u2-net6 RESET VSS VSS nmos W=0.31u L=0.04u
M9699 AND2_303/net6 WX739 AND2_303/X_u2-net6 VSS nmos W=0.31u L=0.04u
M9700 WX802 AND2_303/net6 VDD VDD pmos W=0.41u L=0.04u
M9701 AND2_303/net6 RESET VDD VDD pmos W=0.41u L=0.04u
M9702 AND2_303/net6 WX739 VDD VDD pmos W=0.41u L=0.04u
M9703 WX800 AND2_302/net6 VSS VSS nmos W=0.31u L=0.04u
M9704 AND2_302/X_u2-net6 RESET VSS VSS nmos W=0.31u L=0.04u
M9705 AND2_302/net6 WX737 AND2_302/X_u2-net6 VSS nmos W=0.31u L=0.04u
M9706 WX800 AND2_302/net6 VDD VDD pmos W=0.41u L=0.04u
M9707 AND2_302/net6 RESET VDD VDD pmos W=0.41u L=0.04u
M9708 AND2_302/net6 WX737 VDD VDD pmos W=0.41u L=0.04u
M9709 WX798 AND2_301/net6 VSS VSS nmos W=0.31u L=0.04u
M9710 AND2_301/X_u2-net6 RESET VSS VSS nmos W=0.31u L=0.04u
M9711 AND2_301/net6 WX735 AND2_301/X_u2-net6 VSS nmos W=0.31u L=0.04u
M9712 WX798 AND2_301/net6 VDD VDD pmos W=0.41u L=0.04u
M9713 AND2_301/net6 RESET VDD VDD pmos W=0.41u L=0.04u
M9714 AND2_301/net6 WX735 VDD VDD pmos W=0.41u L=0.04u
M9715 WX796 AND2_300/net6 VSS VSS nmos W=0.31u L=0.04u
M9716 AND2_300/X_u2-net6 RESET VSS VSS nmos W=0.31u L=0.04u
M9717 AND2_300/net6 WX733 AND2_300/X_u2-net6 VSS nmos W=0.31u L=0.04u
M9718 WX796 AND2_300/net6 VDD VDD pmos W=0.41u L=0.04u
M9719 AND2_300/net6 RESET VDD VDD pmos W=0.41u L=0.04u
M9720 AND2_300/net6 WX733 VDD VDD pmos W=0.41u L=0.04u
M9721 WX794 AND2_299/net6 VSS VSS nmos W=0.31u L=0.04u
M9722 AND2_299/X_u2-net6 RESET VSS VSS nmos W=0.31u L=0.04u
M9723 AND2_299/net6 WX731 AND2_299/X_u2-net6 VSS nmos W=0.31u L=0.04u
M9724 WX794 AND2_299/net6 VDD VDD pmos W=0.41u L=0.04u
M9725 AND2_299/net6 RESET VDD VDD pmos W=0.41u L=0.04u
M9726 AND2_299/net6 WX731 VDD VDD pmos W=0.41u L=0.04u
M9727 WX792 AND2_298/net6 VSS VSS nmos W=0.31u L=0.04u
M9728 AND2_298/X_u2-net6 RESET VSS VSS nmos W=0.31u L=0.04u
M9729 AND2_298/net6 WX729 AND2_298/X_u2-net6 VSS nmos W=0.31u L=0.04u
M9730 WX792 AND2_298/net6 VDD VDD pmos W=0.41u L=0.04u
M9731 AND2_298/net6 RESET VDD VDD pmos W=0.41u L=0.04u
M9732 AND2_298/net6 WX729 VDD VDD pmos W=0.41u L=0.04u
M9733 WX790 AND2_297/net6 VSS VSS nmos W=0.31u L=0.04u
M9734 AND2_297/X_u2-net6 RESET VSS VSS nmos W=0.31u L=0.04u
M9735 AND2_297/net6 WX727 AND2_297/X_u2-net6 VSS nmos W=0.31u L=0.04u
M9736 WX790 AND2_297/net6 VDD VDD pmos W=0.41u L=0.04u
M9737 AND2_297/net6 RESET VDD VDD pmos W=0.41u L=0.04u
M9738 AND2_297/net6 WX727 VDD VDD pmos W=0.41u L=0.04u
M9739 WX788 AND2_296/net6 VSS VSS nmos W=0.31u L=0.04u
M9740 AND2_296/X_u2-net6 RESET VSS VSS nmos W=0.31u L=0.04u
M9741 AND2_296/net6 WX725 AND2_296/X_u2-net6 VSS nmos W=0.31u L=0.04u
M9742 WX788 AND2_296/net6 VDD VDD pmos W=0.41u L=0.04u
M9743 AND2_296/net6 RESET VDD VDD pmos W=0.41u L=0.04u
M9744 AND2_296/net6 WX725 VDD VDD pmos W=0.41u L=0.04u
M9745 WX786 AND2_295/net6 VSS VSS nmos W=0.31u L=0.04u
M9746 AND2_295/X_u2-net6 RESET VSS VSS nmos W=0.31u L=0.04u
M9747 AND2_295/net6 WX723 AND2_295/X_u2-net6 VSS nmos W=0.31u L=0.04u
M9748 WX786 AND2_295/net6 VDD VDD pmos W=0.41u L=0.04u
M9749 AND2_295/net6 RESET VDD VDD pmos W=0.41u L=0.04u
M9750 AND2_295/net6 WX723 VDD VDD pmos W=0.41u L=0.04u
M9751 WX784 AND2_294/net6 VSS VSS nmos W=0.31u L=0.04u
M9752 AND2_294/X_u2-net6 RESET VSS VSS nmos W=0.31u L=0.04u
M9753 AND2_294/net6 WX721 AND2_294/X_u2-net6 VSS nmos W=0.31u L=0.04u
M9754 WX784 AND2_294/net6 VDD VDD pmos W=0.41u L=0.04u
M9755 AND2_294/net6 RESET VDD VDD pmos W=0.41u L=0.04u
M9756 AND2_294/net6 WX721 VDD VDD pmos W=0.41u L=0.04u
M9757 WX782 AND2_293/net6 VSS VSS nmos W=0.31u L=0.04u
M9758 AND2_293/X_u2-net6 RESET VSS VSS nmos W=0.31u L=0.04u
M9759 AND2_293/net6 WX719 AND2_293/X_u2-net6 VSS nmos W=0.31u L=0.04u
M9760 WX782 AND2_293/net6 VDD VDD pmos W=0.41u L=0.04u
M9761 AND2_293/net6 RESET VDD VDD pmos W=0.41u L=0.04u
M9762 AND2_293/net6 WX719 VDD VDD pmos W=0.41u L=0.04u
M9763 WX780 AND2_292/net6 VSS VSS nmos W=0.31u L=0.04u
M9764 AND2_292/X_u2-net6 RESET VSS VSS nmos W=0.31u L=0.04u
M9765 AND2_292/net6 WX717 AND2_292/X_u2-net6 VSS nmos W=0.31u L=0.04u
M9766 WX780 AND2_292/net6 VDD VDD pmos W=0.41u L=0.04u
M9767 AND2_292/net6 RESET VDD VDD pmos W=0.41u L=0.04u
M9768 AND2_292/net6 WX717 VDD VDD pmos W=0.41u L=0.04u
M9769 WX778 AND2_291/net6 VSS VSS nmos W=0.31u L=0.04u
M9770 AND2_291/X_u2-net6 RESET VSS VSS nmos W=0.31u L=0.04u
M9771 AND2_291/net6 WX715 AND2_291/X_u2-net6 VSS nmos W=0.31u L=0.04u
M9772 WX778 AND2_291/net6 VDD VDD pmos W=0.41u L=0.04u
M9773 AND2_291/net6 RESET VDD VDD pmos W=0.41u L=0.04u
M9774 AND2_291/net6 WX715 VDD VDD pmos W=0.41u L=0.04u
M9775 WX776 AND2_290/net6 VSS VSS nmos W=0.31u L=0.04u
M9776 AND2_290/X_u2-net6 RESET VSS VSS nmos W=0.31u L=0.04u
M9777 AND2_290/net6 WX713 AND2_290/X_u2-net6 VSS nmos W=0.31u L=0.04u
M9778 WX776 AND2_290/net6 VDD VDD pmos W=0.41u L=0.04u
M9779 AND2_290/net6 RESET VDD VDD pmos W=0.41u L=0.04u
M9780 AND2_290/net6 WX713 VDD VDD pmos W=0.41u L=0.04u
M9781 WX774 AND2_289/net6 VSS VSS nmos W=0.31u L=0.04u
M9782 AND2_289/X_u2-net6 RESET VSS VSS nmos W=0.31u L=0.04u
M9783 AND2_289/net6 WX711 AND2_289/X_u2-net6 VSS nmos W=0.31u L=0.04u
M9784 WX774 AND2_289/net6 VDD VDD pmos W=0.41u L=0.04u
M9785 AND2_289/net6 RESET VDD VDD pmos W=0.41u L=0.04u
M9786 AND2_289/net6 WX711 VDD VDD pmos W=0.41u L=0.04u
M9787 WX772 AND2_288/net6 VSS VSS nmos W=0.31u L=0.04u
M9788 AND2_288/X_u2-net6 RESET VSS VSS nmos W=0.31u L=0.04u
M9789 AND2_288/net6 WX709 AND2_288/X_u2-net6 VSS nmos W=0.31u L=0.04u
M9790 WX772 AND2_288/net6 VDD VDD pmos W=0.41u L=0.04u
M9791 AND2_288/net6 RESET VDD VDD pmos W=0.41u L=0.04u
M9792 AND2_288/net6 WX709 VDD VDD pmos W=0.41u L=0.04u
M9793 WX770 AND2_287/net6 VSS VSS nmos W=0.31u L=0.04u
M9794 AND2_287/X_u2-net6 RESET VSS VSS nmos W=0.31u L=0.04u
M9795 AND2_287/net6 WX707 AND2_287/X_u2-net6 VSS nmos W=0.31u L=0.04u
M9796 WX770 AND2_287/net6 VDD VDD pmos W=0.41u L=0.04u
M9797 AND2_287/net6 RESET VDD VDD pmos W=0.41u L=0.04u
M9798 AND2_287/net6 WX707 VDD VDD pmos W=0.41u L=0.04u
M9799 WX768 AND2_286/net6 VSS VSS nmos W=0.31u L=0.04u
M9800 AND2_286/X_u2-net6 RESET VSS VSS nmos W=0.31u L=0.04u
M9801 AND2_286/net6 WX705 AND2_286/X_u2-net6 VSS nmos W=0.31u L=0.04u
M9802 WX768 AND2_286/net6 VDD VDD pmos W=0.41u L=0.04u
M9803 AND2_286/net6 RESET VDD VDD pmos W=0.41u L=0.04u
M9804 AND2_286/net6 WX705 VDD VDD pmos W=0.41u L=0.04u
M9805 WX766 AND2_285/net6 VSS VSS nmos W=0.31u L=0.04u
M9806 AND2_285/X_u2-net6 RESET VSS VSS nmos W=0.31u L=0.04u
M9807 AND2_285/net6 WX703 AND2_285/X_u2-net6 VSS nmos W=0.31u L=0.04u
M9808 WX766 AND2_285/net6 VDD VDD pmos W=0.41u L=0.04u
M9809 AND2_285/net6 RESET VDD VDD pmos W=0.41u L=0.04u
M9810 AND2_285/net6 WX703 VDD VDD pmos W=0.41u L=0.04u
M9811 WX764 AND2_284/net6 VSS VSS nmos W=0.31u L=0.04u
M9812 AND2_284/X_u2-net6 RESET VSS VSS nmos W=0.31u L=0.04u
M9813 AND2_284/net6 WX701 AND2_284/X_u2-net6 VSS nmos W=0.31u L=0.04u
M9814 WX764 AND2_284/net6 VDD VDD pmos W=0.41u L=0.04u
M9815 AND2_284/net6 RESET VDD VDD pmos W=0.41u L=0.04u
M9816 AND2_284/net6 WX701 VDD VDD pmos W=0.41u L=0.04u
M9817 WX762 AND2_283/net6 VSS VSS nmos W=0.31u L=0.04u
M9818 AND2_283/X_u2-net6 RESET VSS VSS nmos W=0.31u L=0.04u
M9819 AND2_283/net6 WX699 AND2_283/X_u2-net6 VSS nmos W=0.31u L=0.04u
M9820 WX762 AND2_283/net6 VDD VDD pmos W=0.41u L=0.04u
M9821 AND2_283/net6 RESET VDD VDD pmos W=0.41u L=0.04u
M9822 AND2_283/net6 WX699 VDD VDD pmos W=0.41u L=0.04u
M9823 WX760 AND2_282/net6 VSS VSS nmos W=0.31u L=0.04u
M9824 AND2_282/X_u2-net6 RESET VSS VSS nmos W=0.31u L=0.04u
M9825 AND2_282/net6 WX697 AND2_282/X_u2-net6 VSS nmos W=0.31u L=0.04u
M9826 WX760 AND2_282/net6 VDD VDD pmos W=0.41u L=0.04u
M9827 AND2_282/net6 RESET VDD VDD pmos W=0.41u L=0.04u
M9828 AND2_282/net6 WX697 VDD VDD pmos W=0.41u L=0.04u
M9829 WX758 AND2_281/net6 VSS VSS nmos W=0.31u L=0.04u
M9830 AND2_281/X_u2-net6 RESET VSS VSS nmos W=0.31u L=0.04u
M9831 AND2_281/net6 WX695 AND2_281/X_u2-net6 VSS nmos W=0.31u L=0.04u
M9832 WX758 AND2_281/net6 VDD VDD pmos W=0.41u L=0.04u
M9833 AND2_281/net6 RESET VDD VDD pmos W=0.41u L=0.04u
M9834 AND2_281/net6 WX695 VDD VDD pmos W=0.41u L=0.04u
M9835 WX756 AND2_280/net6 VSS VSS nmos W=0.31u L=0.04u
M9836 AND2_280/X_u2-net6 RESET VSS VSS nmos W=0.31u L=0.04u
M9837 AND2_280/net6 WX693 AND2_280/X_u2-net6 VSS nmos W=0.31u L=0.04u
M9838 WX756 AND2_280/net6 VDD VDD pmos W=0.41u L=0.04u
M9839 AND2_280/net6 RESET VDD VDD pmos W=0.41u L=0.04u
M9840 AND2_280/net6 WX693 VDD VDD pmos W=0.41u L=0.04u
M9841 WX754 AND2_279/net6 VSS VSS nmos W=0.31u L=0.04u
M9842 AND2_279/X_u2-net6 RESET VSS VSS nmos W=0.31u L=0.04u
M9843 AND2_279/net6 WX691 AND2_279/X_u2-net6 VSS nmos W=0.31u L=0.04u
M9844 WX754 AND2_279/net6 VDD VDD pmos W=0.41u L=0.04u
M9845 AND2_279/net6 RESET VDD VDD pmos W=0.41u L=0.04u
M9846 AND2_279/net6 WX691 VDD VDD pmos W=0.41u L=0.04u
M9847 WX752 AND2_278/net6 VSS VSS nmos W=0.31u L=0.04u
M9848 AND2_278/X_u2-net6 RESET VSS VSS nmos W=0.31u L=0.04u
M9849 AND2_278/net6 WX689 AND2_278/X_u2-net6 VSS nmos W=0.31u L=0.04u
M9850 WX752 AND2_278/net6 VDD VDD pmos W=0.41u L=0.04u
M9851 AND2_278/net6 RESET VDD VDD pmos W=0.41u L=0.04u
M9852 AND2_278/net6 WX689 VDD VDD pmos W=0.41u L=0.04u
M9853 WX750 AND2_277/net6 VSS VSS nmos W=0.31u L=0.04u
M9854 AND2_277/X_u2-net6 RESET VSS VSS nmos W=0.31u L=0.04u
M9855 AND2_277/net6 WX687 AND2_277/X_u2-net6 VSS nmos W=0.31u L=0.04u
M9856 WX750 AND2_277/net6 VDD VDD pmos W=0.41u L=0.04u
M9857 AND2_277/net6 RESET VDD VDD pmos W=0.41u L=0.04u
M9858 AND2_277/net6 WX687 VDD VDD pmos W=0.41u L=0.04u
M9859 WX748 AND2_276/net6 VSS VSS nmos W=0.31u L=0.04u
M9860 AND2_276/X_u2-net6 RESET VSS VSS nmos W=0.31u L=0.04u
M9861 AND2_276/net6 WX685 AND2_276/X_u2-net6 VSS nmos W=0.31u L=0.04u
M9862 WX748 AND2_276/net6 VDD VDD pmos W=0.41u L=0.04u
M9863 AND2_276/net6 RESET VDD VDD pmos W=0.41u L=0.04u
M9864 AND2_276/net6 WX685 VDD VDD pmos W=0.41u L=0.04u
M9865 WX746 AND2_275/net6 VSS VSS nmos W=0.31u L=0.04u
M9866 AND2_275/X_u2-net6 RESET VSS VSS nmos W=0.31u L=0.04u
M9867 AND2_275/net6 WX683 AND2_275/X_u2-net6 VSS nmos W=0.31u L=0.04u
M9868 WX746 AND2_275/net6 VDD VDD pmos W=0.41u L=0.04u
M9869 AND2_275/net6 RESET VDD VDD pmos W=0.41u L=0.04u
M9870 AND2_275/net6 WX683 VDD VDD pmos W=0.41u L=0.04u
M9871 WX744 AND2_274/net6 VSS VSS nmos W=0.31u L=0.04u
M9872 AND2_274/X_u2-net6 RESET VSS VSS nmos W=0.31u L=0.04u
M9873 AND2_274/net6 WX681 AND2_274/X_u2-net6 VSS nmos W=0.31u L=0.04u
M9874 WX744 AND2_274/net6 VDD VDD pmos W=0.41u L=0.04u
M9875 AND2_274/net6 RESET VDD VDD pmos W=0.41u L=0.04u
M9876 AND2_274/net6 WX681 VDD VDD pmos W=0.41u L=0.04u
M9877 WX742 AND2_273/net6 VSS VSS nmos W=0.31u L=0.04u
M9878 AND2_273/X_u2-net6 RESET VSS VSS nmos W=0.31u L=0.04u
M9879 AND2_273/net6 WX679 AND2_273/X_u2-net6 VSS nmos W=0.31u L=0.04u
M9880 WX742 AND2_273/net6 VDD VDD pmos W=0.41u L=0.04u
M9881 AND2_273/net6 RESET VDD VDD pmos W=0.41u L=0.04u
M9882 AND2_273/net6 WX679 VDD VDD pmos W=0.41u L=0.04u
M9883 WX740 AND2_272/net6 VSS VSS nmos W=0.31u L=0.04u
M9884 AND2_272/X_u2-net6 RESET VSS VSS nmos W=0.31u L=0.04u
M9885 AND2_272/net6 WX677 AND2_272/X_u2-net6 VSS nmos W=0.31u L=0.04u
M9886 WX740 AND2_272/net6 VDD VDD pmos W=0.41u L=0.04u
M9887 AND2_272/net6 RESET VDD VDD pmos W=0.41u L=0.04u
M9888 AND2_272/net6 WX677 VDD VDD pmos W=0.41u L=0.04u
M9889 WX738 AND2_271/net6 VSS VSS nmos W=0.31u L=0.04u
M9890 AND2_271/X_u2-net6 RESET VSS VSS nmos W=0.31u L=0.04u
M9891 AND2_271/net6 WX675 AND2_271/X_u2-net6 VSS nmos W=0.31u L=0.04u
M9892 WX738 AND2_271/net6 VDD VDD pmos W=0.41u L=0.04u
M9893 AND2_271/net6 RESET VDD VDD pmos W=0.41u L=0.04u
M9894 AND2_271/net6 WX675 VDD VDD pmos W=0.41u L=0.04u
M9895 WX736 AND2_270/net6 VSS VSS nmos W=0.31u L=0.04u
M9896 AND2_270/X_u2-net6 RESET VSS VSS nmos W=0.31u L=0.04u
M9897 AND2_270/net6 WX673 AND2_270/X_u2-net6 VSS nmos W=0.31u L=0.04u
M9898 WX736 AND2_270/net6 VDD VDD pmos W=0.41u L=0.04u
M9899 AND2_270/net6 RESET VDD VDD pmos W=0.41u L=0.04u
M9900 AND2_270/net6 WX673 VDD VDD pmos W=0.41u L=0.04u
M9901 WX734 AND2_269/net6 VSS VSS nmos W=0.31u L=0.04u
M9902 AND2_269/X_u2-net6 RESET VSS VSS nmos W=0.31u L=0.04u
M9903 AND2_269/net6 WX671 AND2_269/X_u2-net6 VSS nmos W=0.31u L=0.04u
M9904 WX734 AND2_269/net6 VDD VDD pmos W=0.41u L=0.04u
M9905 AND2_269/net6 RESET VDD VDD pmos W=0.41u L=0.04u
M9906 AND2_269/net6 WX671 VDD VDD pmos W=0.41u L=0.04u
M9907 WX732 AND2_268/net6 VSS VSS nmos W=0.31u L=0.04u
M9908 AND2_268/X_u2-net6 RESET VSS VSS nmos W=0.31u L=0.04u
M9909 AND2_268/net6 WX669 AND2_268/X_u2-net6 VSS nmos W=0.31u L=0.04u
M9910 WX732 AND2_268/net6 VDD VDD pmos W=0.41u L=0.04u
M9911 AND2_268/net6 RESET VDD VDD pmos W=0.41u L=0.04u
M9912 AND2_268/net6 WX669 VDD VDD pmos W=0.41u L=0.04u
M9913 WX730 AND2_267/net6 VSS VSS nmos W=0.31u L=0.04u
M9914 AND2_267/X_u2-net6 RESET VSS VSS nmos W=0.31u L=0.04u
M9915 AND2_267/net6 WX667 AND2_267/X_u2-net6 VSS nmos W=0.31u L=0.04u
M9916 WX730 AND2_267/net6 VDD VDD pmos W=0.41u L=0.04u
M9917 AND2_267/net6 RESET VDD VDD pmos W=0.41u L=0.04u
M9918 AND2_267/net6 WX667 VDD VDD pmos W=0.41u L=0.04u
M9919 WX728 AND2_266/net6 VSS VSS nmos W=0.31u L=0.04u
M9920 AND2_266/X_u2-net6 RESET VSS VSS nmos W=0.31u L=0.04u
M9921 AND2_266/net6 WX665 AND2_266/X_u2-net6 VSS nmos W=0.31u L=0.04u
M9922 WX728 AND2_266/net6 VDD VDD pmos W=0.41u L=0.04u
M9923 AND2_266/net6 RESET VDD VDD pmos W=0.41u L=0.04u
M9924 AND2_266/net6 WX665 VDD VDD pmos W=0.41u L=0.04u
M9925 WX726 AND2_265/net6 VSS VSS nmos W=0.31u L=0.04u
M9926 AND2_265/X_u2-net6 RESET VSS VSS nmos W=0.31u L=0.04u
M9927 AND2_265/net6 WX663 AND2_265/X_u2-net6 VSS nmos W=0.31u L=0.04u
M9928 WX726 AND2_265/net6 VDD VDD pmos W=0.41u L=0.04u
M9929 AND2_265/net6 RESET VDD VDD pmos W=0.41u L=0.04u
M9930 AND2_265/net6 WX663 VDD VDD pmos W=0.41u L=0.04u
M9931 WX724 AND2_264/net6 VSS VSS nmos W=0.31u L=0.04u
M9932 AND2_264/X_u2-net6 RESET VSS VSS nmos W=0.31u L=0.04u
M9933 AND2_264/net6 WX661 AND2_264/X_u2-net6 VSS nmos W=0.31u L=0.04u
M9934 WX724 AND2_264/net6 VDD VDD pmos W=0.41u L=0.04u
M9935 AND2_264/net6 RESET VDD VDD pmos W=0.41u L=0.04u
M9936 AND2_264/net6 WX661 VDD VDD pmos W=0.41u L=0.04u
M9937 WX722 AND2_263/net6 VSS VSS nmos W=0.31u L=0.04u
M9938 AND2_263/X_u2-net6 RESET VSS VSS nmos W=0.31u L=0.04u
M9939 AND2_263/net6 WX659 AND2_263/X_u2-net6 VSS nmos W=0.31u L=0.04u
M9940 WX722 AND2_263/net6 VDD VDD pmos W=0.41u L=0.04u
M9941 AND2_263/net6 RESET VDD VDD pmos W=0.41u L=0.04u
M9942 AND2_263/net6 WX659 VDD VDD pmos W=0.41u L=0.04u
M9943 WX720 AND2_262/net6 VSS VSS nmos W=0.31u L=0.04u
M9944 AND2_262/X_u2-net6 RESET VSS VSS nmos W=0.31u L=0.04u
M9945 AND2_262/net6 WX657 AND2_262/X_u2-net6 VSS nmos W=0.31u L=0.04u
M9946 WX720 AND2_262/net6 VDD VDD pmos W=0.41u L=0.04u
M9947 AND2_262/net6 RESET VDD VDD pmos W=0.41u L=0.04u
M9948 AND2_262/net6 WX657 VDD VDD pmos W=0.41u L=0.04u
M9949 WX718 AND2_261/net6 VSS VSS nmos W=0.31u L=0.04u
M9950 AND2_261/X_u2-net6 RESET VSS VSS nmos W=0.31u L=0.04u
M9951 AND2_261/net6 WX655 AND2_261/X_u2-net6 VSS nmos W=0.31u L=0.04u
M9952 WX718 AND2_261/net6 VDD VDD pmos W=0.41u L=0.04u
M9953 AND2_261/net6 RESET VDD VDD pmos W=0.41u L=0.04u
M9954 AND2_261/net6 WX655 VDD VDD pmos W=0.41u L=0.04u
M9955 WX716 AND2_260/net6 VSS VSS nmos W=0.31u L=0.04u
M9956 AND2_260/X_u2-net6 RESET VSS VSS nmos W=0.31u L=0.04u
M9957 AND2_260/net6 WX653 AND2_260/X_u2-net6 VSS nmos W=0.31u L=0.04u
M9958 WX716 AND2_260/net6 VDD VDD pmos W=0.41u L=0.04u
M9959 AND2_260/net6 RESET VDD VDD pmos W=0.41u L=0.04u
M9960 AND2_260/net6 WX653 VDD VDD pmos W=0.41u L=0.04u
M9961 WX714 AND2_259/net6 VSS VSS nmos W=0.31u L=0.04u
M9962 AND2_259/X_u2-net6 RESET VSS VSS nmos W=0.31u L=0.04u
M9963 AND2_259/net6 WX651 AND2_259/X_u2-net6 VSS nmos W=0.31u L=0.04u
M9964 WX714 AND2_259/net6 VDD VDD pmos W=0.41u L=0.04u
M9965 AND2_259/net6 RESET VDD VDD pmos W=0.41u L=0.04u
M9966 AND2_259/net6 WX651 VDD VDD pmos W=0.41u L=0.04u
M9967 WX712 AND2_258/net6 VSS VSS nmos W=0.31u L=0.04u
M9968 AND2_258/X_u2-net6 RESET VSS VSS nmos W=0.31u L=0.04u
M9969 AND2_258/net6 WX649 AND2_258/X_u2-net6 VSS nmos W=0.31u L=0.04u
M9970 WX712 AND2_258/net6 VDD VDD pmos W=0.41u L=0.04u
M9971 AND2_258/net6 RESET VDD VDD pmos W=0.41u L=0.04u
M9972 AND2_258/net6 WX649 VDD VDD pmos W=0.41u L=0.04u
M9973 WX710 AND2_257/net6 VSS VSS nmos W=0.31u L=0.04u
M9974 AND2_257/X_u2-net6 RESET VSS VSS nmos W=0.31u L=0.04u
M9975 AND2_257/net6 WX647 AND2_257/X_u2-net6 VSS nmos W=0.31u L=0.04u
M9976 WX710 AND2_257/net6 VDD VDD pmos W=0.41u L=0.04u
M9977 AND2_257/net6 RESET VDD VDD pmos W=0.41u L=0.04u
M9978 AND2_257/net6 WX647 VDD VDD pmos W=0.41u L=0.04u
M9979 WX708 AND2_256/net6 VSS VSS nmos W=0.31u L=0.04u
M9980 AND2_256/X_u2-net6 RESET VSS VSS nmos W=0.31u L=0.04u
M9981 AND2_256/net6 WX645 AND2_256/X_u2-net6 VSS nmos W=0.31u L=0.04u
M9982 WX708 AND2_256/net6 VDD VDD pmos W=0.41u L=0.04u
M9983 AND2_256/net6 RESET VDD VDD pmos W=0.41u L=0.04u
M9984 AND2_256/net6 WX645 VDD VDD pmos W=0.41u L=0.04u
M9985 WX706 AND2_255/net6 VSS VSS nmos W=0.31u L=0.04u
M9986 AND2_255/X_u2-net6 RESET VSS VSS nmos W=0.31u L=0.04u
M9987 AND2_255/net6 WX472 AND2_255/X_u2-net6 VSS nmos W=0.31u L=0.04u
M9988 WX706 AND2_255/net6 VDD VDD pmos W=0.41u L=0.04u
M9989 AND2_255/net6 RESET VDD VDD pmos W=0.41u L=0.04u
M9990 AND2_255/net6 WX472 VDD VDD pmos W=0.41u L=0.04u
M9991 WX704 AND2_254/net6 VSS VSS nmos W=0.31u L=0.04u
M9992 AND2_254/X_u2-net6 RESET VSS VSS nmos W=0.31u L=0.04u
M9993 AND2_254/net6 WX458 AND2_254/X_u2-net6 VSS nmos W=0.31u L=0.04u
M9994 WX704 AND2_254/net6 VDD VDD pmos W=0.41u L=0.04u
M9995 AND2_254/net6 RESET VDD VDD pmos W=0.41u L=0.04u
M9996 AND2_254/net6 WX458 VDD VDD pmos W=0.41u L=0.04u
M9997 WX702 AND2_253/net6 VSS VSS nmos W=0.31u L=0.04u
M9998 AND2_253/X_u2-net6 RESET VSS VSS nmos W=0.31u L=0.04u
M9999 AND2_253/net6 WX444 AND2_253/X_u2-net6 VSS nmos W=0.31u L=0.04u
M10000 WX702 AND2_253/net6 VDD VDD pmos W=0.41u L=0.04u
M10001 AND2_253/net6 RESET VDD VDD pmos W=0.41u L=0.04u
M10002 AND2_253/net6 WX444 VDD VDD pmos W=0.41u L=0.04u
M10003 WX700 AND2_252/net6 VSS VSS nmos W=0.31u L=0.04u
M10004 AND2_252/X_u2-net6 RESET VSS VSS nmos W=0.31u L=0.04u
M10005 AND2_252/net6 WX430 AND2_252/X_u2-net6 VSS nmos W=0.31u L=0.04u
M10006 WX700 AND2_252/net6 VDD VDD pmos W=0.41u L=0.04u
M10007 AND2_252/net6 RESET VDD VDD pmos W=0.41u L=0.04u
M10008 AND2_252/net6 WX430 VDD VDD pmos W=0.41u L=0.04u
M10009 WX698 AND2_251/net6 VSS VSS nmos W=0.31u L=0.04u
M10010 AND2_251/X_u2-net6 RESET VSS VSS nmos W=0.31u L=0.04u
M10011 AND2_251/net6 WX416 AND2_251/X_u2-net6 VSS nmos W=0.31u L=0.04u
M10012 WX698 AND2_251/net6 VDD VDD pmos W=0.41u L=0.04u
M10013 AND2_251/net6 RESET VDD VDD pmos W=0.41u L=0.04u
M10014 AND2_251/net6 WX416 VDD VDD pmos W=0.41u L=0.04u
M10015 WX696 AND2_250/net6 VSS VSS nmos W=0.31u L=0.04u
M10016 AND2_250/X_u2-net6 RESET VSS VSS nmos W=0.31u L=0.04u
M10017 AND2_250/net6 WX402 AND2_250/X_u2-net6 VSS nmos W=0.31u L=0.04u
M10018 WX696 AND2_250/net6 VDD VDD pmos W=0.41u L=0.04u
M10019 AND2_250/net6 RESET VDD VDD pmos W=0.41u L=0.04u
M10020 AND2_250/net6 WX402 VDD VDD pmos W=0.41u L=0.04u
M10021 WX694 AND2_249/net6 VSS VSS nmos W=0.31u L=0.04u
M10022 AND2_249/X_u2-net6 RESET VSS VSS nmos W=0.31u L=0.04u
M10023 AND2_249/net6 WX388 AND2_249/X_u2-net6 VSS nmos W=0.31u L=0.04u
M10024 WX694 AND2_249/net6 VDD VDD pmos W=0.41u L=0.04u
M10025 AND2_249/net6 RESET VDD VDD pmos W=0.41u L=0.04u
M10026 AND2_249/net6 WX388 VDD VDD pmos W=0.41u L=0.04u
M10027 WX692 AND2_248/net6 VSS VSS nmos W=0.31u L=0.04u
M10028 AND2_248/X_u2-net6 RESET VSS VSS nmos W=0.31u L=0.04u
M10029 AND2_248/net6 WX374 AND2_248/X_u2-net6 VSS nmos W=0.31u L=0.04u
M10030 WX692 AND2_248/net6 VDD VDD pmos W=0.41u L=0.04u
M10031 AND2_248/net6 RESET VDD VDD pmos W=0.41u L=0.04u
M10032 AND2_248/net6 WX374 VDD VDD pmos W=0.41u L=0.04u
M10033 WX690 AND2_247/net6 VSS VSS nmos W=0.31u L=0.04u
M10034 AND2_247/X_u2-net6 RESET VSS VSS nmos W=0.31u L=0.04u
M10035 AND2_247/net6 WX360 AND2_247/X_u2-net6 VSS nmos W=0.31u L=0.04u
M10036 WX690 AND2_247/net6 VDD VDD pmos W=0.41u L=0.04u
M10037 AND2_247/net6 RESET VDD VDD pmos W=0.41u L=0.04u
M10038 AND2_247/net6 WX360 VDD VDD pmos W=0.41u L=0.04u
M10039 WX688 AND2_246/net6 VSS VSS nmos W=0.31u L=0.04u
M10040 AND2_246/X_u2-net6 RESET VSS VSS nmos W=0.31u L=0.04u
M10041 AND2_246/net6 WX346 AND2_246/X_u2-net6 VSS nmos W=0.31u L=0.04u
M10042 WX688 AND2_246/net6 VDD VDD pmos W=0.41u L=0.04u
M10043 AND2_246/net6 RESET VDD VDD pmos W=0.41u L=0.04u
M10044 AND2_246/net6 WX346 VDD VDD pmos W=0.41u L=0.04u
M10045 WX686 AND2_245/net6 VSS VSS nmos W=0.31u L=0.04u
M10046 AND2_245/X_u2-net6 RESET VSS VSS nmos W=0.31u L=0.04u
M10047 AND2_245/net6 WX332 AND2_245/X_u2-net6 VSS nmos W=0.31u L=0.04u
M10048 WX686 AND2_245/net6 VDD VDD pmos W=0.41u L=0.04u
M10049 AND2_245/net6 RESET VDD VDD pmos W=0.41u L=0.04u
M10050 AND2_245/net6 WX332 VDD VDD pmos W=0.41u L=0.04u
M10051 WX684 AND2_244/net6 VSS VSS nmos W=0.31u L=0.04u
M10052 AND2_244/X_u2-net6 RESET VSS VSS nmos W=0.31u L=0.04u
M10053 AND2_244/net6 WX318 AND2_244/X_u2-net6 VSS nmos W=0.31u L=0.04u
M10054 WX684 AND2_244/net6 VDD VDD pmos W=0.41u L=0.04u
M10055 AND2_244/net6 RESET VDD VDD pmos W=0.41u L=0.04u
M10056 AND2_244/net6 WX318 VDD VDD pmos W=0.41u L=0.04u
M10057 WX682 AND2_243/net6 VSS VSS nmos W=0.31u L=0.04u
M10058 AND2_243/X_u2-net6 RESET VSS VSS nmos W=0.31u L=0.04u
M10059 AND2_243/net6 WX304 AND2_243/X_u2-net6 VSS nmos W=0.31u L=0.04u
M10060 WX682 AND2_243/net6 VDD VDD pmos W=0.41u L=0.04u
M10061 AND2_243/net6 RESET VDD VDD pmos W=0.41u L=0.04u
M10062 AND2_243/net6 WX304 VDD VDD pmos W=0.41u L=0.04u
M10063 WX680 AND2_242/net6 VSS VSS nmos W=0.31u L=0.04u
M10064 AND2_242/X_u2-net6 RESET VSS VSS nmos W=0.31u L=0.04u
M10065 AND2_242/net6 WX290 AND2_242/X_u2-net6 VSS nmos W=0.31u L=0.04u
M10066 WX680 AND2_242/net6 VDD VDD pmos W=0.41u L=0.04u
M10067 AND2_242/net6 RESET VDD VDD pmos W=0.41u L=0.04u
M10068 AND2_242/net6 WX290 VDD VDD pmos W=0.41u L=0.04u
M10069 WX678 AND2_241/net6 VSS VSS nmos W=0.31u L=0.04u
M10070 AND2_241/X_u2-net6 RESET VSS VSS nmos W=0.31u L=0.04u
M10071 AND2_241/net6 WX276 AND2_241/X_u2-net6 VSS nmos W=0.31u L=0.04u
M10072 WX678 AND2_241/net6 VDD VDD pmos W=0.41u L=0.04u
M10073 AND2_241/net6 RESET VDD VDD pmos W=0.41u L=0.04u
M10074 AND2_241/net6 WX276 VDD VDD pmos W=0.41u L=0.04u
M10075 WX676 AND2_240/net6 VSS VSS nmos W=0.31u L=0.04u
M10076 AND2_240/X_u2-net6 RESET VSS VSS nmos W=0.31u L=0.04u
M10077 AND2_240/net6 WX262 AND2_240/X_u2-net6 VSS nmos W=0.31u L=0.04u
M10078 WX676 AND2_240/net6 VDD VDD pmos W=0.41u L=0.04u
M10079 AND2_240/net6 RESET VDD VDD pmos W=0.41u L=0.04u
M10080 AND2_240/net6 WX262 VDD VDD pmos W=0.41u L=0.04u
M10081 WX674 AND2_239/net6 VSS VSS nmos W=0.31u L=0.04u
M10082 AND2_239/X_u2-net6 RESET VSS VSS nmos W=0.31u L=0.04u
M10083 AND2_239/net6 WX248 AND2_239/X_u2-net6 VSS nmos W=0.31u L=0.04u
M10084 WX674 AND2_239/net6 VDD VDD pmos W=0.41u L=0.04u
M10085 AND2_239/net6 RESET VDD VDD pmos W=0.41u L=0.04u
M10086 AND2_239/net6 WX248 VDD VDD pmos W=0.41u L=0.04u
M10087 WX672 AND2_238/net6 VSS VSS nmos W=0.31u L=0.04u
M10088 AND2_238/X_u2-net6 RESET VSS VSS nmos W=0.31u L=0.04u
M10089 AND2_238/net6 WX234 AND2_238/X_u2-net6 VSS nmos W=0.31u L=0.04u
M10090 WX672 AND2_238/net6 VDD VDD pmos W=0.41u L=0.04u
M10091 AND2_238/net6 RESET VDD VDD pmos W=0.41u L=0.04u
M10092 AND2_238/net6 WX234 VDD VDD pmos W=0.41u L=0.04u
M10093 WX670 AND2_237/net6 VSS VSS nmos W=0.31u L=0.04u
M10094 AND2_237/X_u2-net6 RESET VSS VSS nmos W=0.31u L=0.04u
M10095 AND2_237/net6 WX220 AND2_237/X_u2-net6 VSS nmos W=0.31u L=0.04u
M10096 WX670 AND2_237/net6 VDD VDD pmos W=0.41u L=0.04u
M10097 AND2_237/net6 RESET VDD VDD pmos W=0.41u L=0.04u
M10098 AND2_237/net6 WX220 VDD VDD pmos W=0.41u L=0.04u
M10099 WX668 AND2_236/net6 VSS VSS nmos W=0.31u L=0.04u
M10100 AND2_236/X_u2-net6 RESET VSS VSS nmos W=0.31u L=0.04u
M10101 AND2_236/net6 WX206 AND2_236/X_u2-net6 VSS nmos W=0.31u L=0.04u
M10102 WX668 AND2_236/net6 VDD VDD pmos W=0.41u L=0.04u
M10103 AND2_236/net6 RESET VDD VDD pmos W=0.41u L=0.04u
M10104 AND2_236/net6 WX206 VDD VDD pmos W=0.41u L=0.04u
M10105 WX666 AND2_235/net6 VSS VSS nmos W=0.31u L=0.04u
M10106 AND2_235/X_u2-net6 RESET VSS VSS nmos W=0.31u L=0.04u
M10107 AND2_235/net6 WX192 AND2_235/X_u2-net6 VSS nmos W=0.31u L=0.04u
M10108 WX666 AND2_235/net6 VDD VDD pmos W=0.41u L=0.04u
M10109 AND2_235/net6 RESET VDD VDD pmos W=0.41u L=0.04u
M10110 AND2_235/net6 WX192 VDD VDD pmos W=0.41u L=0.04u
M10111 WX664 AND2_234/net6 VSS VSS nmos W=0.31u L=0.04u
M10112 AND2_234/X_u2-net6 RESET VSS VSS nmos W=0.31u L=0.04u
M10113 AND2_234/net6 WX178 AND2_234/X_u2-net6 VSS nmos W=0.31u L=0.04u
M10114 WX664 AND2_234/net6 VDD VDD pmos W=0.41u L=0.04u
M10115 AND2_234/net6 RESET VDD VDD pmos W=0.41u L=0.04u
M10116 AND2_234/net6 WX178 VDD VDD pmos W=0.41u L=0.04u
M10117 WX662 AND2_233/net6 VSS VSS nmos W=0.31u L=0.04u
M10118 AND2_233/X_u2-net6 RESET VSS VSS nmos W=0.31u L=0.04u
M10119 AND2_233/net6 WX164 AND2_233/X_u2-net6 VSS nmos W=0.31u L=0.04u
M10120 WX662 AND2_233/net6 VDD VDD pmos W=0.41u L=0.04u
M10121 AND2_233/net6 RESET VDD VDD pmos W=0.41u L=0.04u
M10122 AND2_233/net6 WX164 VDD VDD pmos W=0.41u L=0.04u
M10123 WX660 AND2_232/net6 VSS VSS nmos W=0.31u L=0.04u
M10124 AND2_232/X_u2-net6 RESET VSS VSS nmos W=0.31u L=0.04u
M10125 AND2_232/net6 WX150 AND2_232/X_u2-net6 VSS nmos W=0.31u L=0.04u
M10126 WX660 AND2_232/net6 VDD VDD pmos W=0.41u L=0.04u
M10127 AND2_232/net6 RESET VDD VDD pmos W=0.41u L=0.04u
M10128 AND2_232/net6 WX150 VDD VDD pmos W=0.41u L=0.04u
M10129 WX658 AND2_231/net6 VSS VSS nmos W=0.31u L=0.04u
M10130 AND2_231/X_u2-net6 RESET VSS VSS nmos W=0.31u L=0.04u
M10131 AND2_231/net6 WX136 AND2_231/X_u2-net6 VSS nmos W=0.31u L=0.04u
M10132 WX658 AND2_231/net6 VDD VDD pmos W=0.41u L=0.04u
M10133 AND2_231/net6 RESET VDD VDD pmos W=0.41u L=0.04u
M10134 AND2_231/net6 WX136 VDD VDD pmos W=0.41u L=0.04u
M10135 WX656 AND2_230/net6 VSS VSS nmos W=0.31u L=0.04u
M10136 AND2_230/X_u2-net6 RESET VSS VSS nmos W=0.31u L=0.04u
M10137 AND2_230/net6 WX122 AND2_230/X_u2-net6 VSS nmos W=0.31u L=0.04u
M10138 WX656 AND2_230/net6 VDD VDD pmos W=0.41u L=0.04u
M10139 AND2_230/net6 RESET VDD VDD pmos W=0.41u L=0.04u
M10140 AND2_230/net6 WX122 VDD VDD pmos W=0.41u L=0.04u
M10141 WX654 AND2_229/net6 VSS VSS nmos W=0.31u L=0.04u
M10142 AND2_229/X_u2-net6 RESET VSS VSS nmos W=0.31u L=0.04u
M10143 AND2_229/net6 WX108 AND2_229/X_u2-net6 VSS nmos W=0.31u L=0.04u
M10144 WX654 AND2_229/net6 VDD VDD pmos W=0.41u L=0.04u
M10145 AND2_229/net6 RESET VDD VDD pmos W=0.41u L=0.04u
M10146 AND2_229/net6 WX108 VDD VDD pmos W=0.41u L=0.04u
M10147 WX652 AND2_228/net6 VSS VSS nmos W=0.31u L=0.04u
M10148 AND2_228/X_u2-net6 RESET VSS VSS nmos W=0.31u L=0.04u
M10149 AND2_228/net6 WX94 AND2_228/X_u2-net6 VSS nmos W=0.31u L=0.04u
M10150 WX652 AND2_228/net6 VDD VDD pmos W=0.41u L=0.04u
M10151 AND2_228/net6 RESET VDD VDD pmos W=0.41u L=0.04u
M10152 AND2_228/net6 WX94 VDD VDD pmos W=0.41u L=0.04u
M10153 WX650 AND2_227/net6 VSS VSS nmos W=0.31u L=0.04u
M10154 AND2_227/X_u2-net6 RESET VSS VSS nmos W=0.31u L=0.04u
M10155 AND2_227/net6 WX80 AND2_227/X_u2-net6 VSS nmos W=0.31u L=0.04u
M10156 WX650 AND2_227/net6 VDD VDD pmos W=0.41u L=0.04u
M10157 AND2_227/net6 RESET VDD VDD pmos W=0.41u L=0.04u
M10158 AND2_227/net6 WX80 VDD VDD pmos W=0.41u L=0.04u
M10159 WX648 AND2_226/net6 VSS VSS nmos W=0.31u L=0.04u
M10160 AND2_226/X_u2-net6 RESET VSS VSS nmos W=0.31u L=0.04u
M10161 AND2_226/net6 WX66 AND2_226/X_u2-net6 VSS nmos W=0.31u L=0.04u
M10162 WX648 AND2_226/net6 VDD VDD pmos W=0.41u L=0.04u
M10163 AND2_226/net6 RESET VDD VDD pmos W=0.41u L=0.04u
M10164 AND2_226/net6 WX66 VDD VDD pmos W=0.41u L=0.04u
M10165 WX646 AND2_225/net6 VSS VSS nmos W=0.31u L=0.04u
M10166 AND2_225/X_u2-net6 RESET VSS VSS nmos W=0.31u L=0.04u
M10167 AND2_225/net6 WX52 AND2_225/X_u2-net6 VSS nmos W=0.31u L=0.04u
M10168 WX646 AND2_225/net6 VDD VDD pmos W=0.41u L=0.04u
M10169 AND2_225/net6 RESET VDD VDD pmos W=0.41u L=0.04u
M10170 AND2_225/net6 WX52 VDD VDD pmos W=0.41u L=0.04u
M10171 WX644 AND2_224/net6 VSS VSS nmos W=0.31u L=0.04u
M10172 AND2_224/X_u2-net6 RESET VSS VSS nmos W=0.31u L=0.04u
M10173 AND2_224/net6 WX38 AND2_224/X_u2-net6 VSS nmos W=0.31u L=0.04u
M10174 WX644 AND2_224/net6 VDD VDD pmos W=0.41u L=0.04u
M10175 AND2_224/net6 RESET VDD VDD pmos W=0.41u L=0.04u
M10176 AND2_224/net6 WX38 VDD VDD pmos W=0.41u L=0.04u
M10177 WX546 AND2_223/net6 VSS VSS nmos W=0.31u L=0.04u
M10178 AND2_223/X_u2-net6 RESET VSS VSS nmos W=0.31u L=0.04u
M10179 AND2_223/net6 WX483 AND2_223/X_u2-net6 VSS nmos W=0.31u L=0.04u
M10180 WX546 AND2_223/net6 VDD VDD pmos W=0.41u L=0.04u
M10181 AND2_223/net6 RESET VDD VDD pmos W=0.41u L=0.04u
M10182 AND2_223/net6 WX483 VDD VDD pmos W=0.41u L=0.04u
M10183 WX544 AND2_222/net6 VSS VSS nmos W=0.31u L=0.04u
M10184 AND2_222/X_u2-net6 RESET VSS VSS nmos W=0.31u L=0.04u
M10185 AND2_222/net6 WX547 AND2_222/X_u2-net6 VSS nmos W=0.31u L=0.04u
M10186 WX544 AND2_222/net6 VDD VDD pmos W=0.41u L=0.04u
M10187 AND2_222/net6 RESET VDD VDD pmos W=0.41u L=0.04u
M10188 AND2_222/net6 WX547 VDD VDD pmos W=0.41u L=0.04u
M10189 WX542 AND2_221/net6 VSS VSS nmos W=0.31u L=0.04u
M10190 AND2_221/X_u2-net6 RESET VSS VSS nmos W=0.31u L=0.04u
M10191 AND2_221/net6 WX545 AND2_221/X_u2-net6 VSS nmos W=0.31u L=0.04u
M10192 WX542 AND2_221/net6 VDD VDD pmos W=0.41u L=0.04u
M10193 AND2_221/net6 RESET VDD VDD pmos W=0.41u L=0.04u
M10194 AND2_221/net6 WX545 VDD VDD pmos W=0.41u L=0.04u
M10195 WX540 AND2_220/net6 VSS VSS nmos W=0.31u L=0.04u
M10196 AND2_220/X_u2-net6 RESET VSS VSS nmos W=0.31u L=0.04u
M10197 AND2_220/net6 WX543 AND2_220/X_u2-net6 VSS nmos W=0.31u L=0.04u
M10198 WX540 AND2_220/net6 VDD VDD pmos W=0.41u L=0.04u
M10199 AND2_220/net6 RESET VDD VDD pmos W=0.41u L=0.04u
M10200 AND2_220/net6 WX543 VDD VDD pmos W=0.41u L=0.04u
M10201 WX538 AND2_219/net6 VSS VSS nmos W=0.31u L=0.04u
M10202 AND2_219/X_u2-net6 RESET VSS VSS nmos W=0.31u L=0.04u
M10203 AND2_219/net6 WX541 AND2_219/X_u2-net6 VSS nmos W=0.31u L=0.04u
M10204 WX538 AND2_219/net6 VDD VDD pmos W=0.41u L=0.04u
M10205 AND2_219/net6 RESET VDD VDD pmos W=0.41u L=0.04u
M10206 AND2_219/net6 WX541 VDD VDD pmos W=0.41u L=0.04u
M10207 WX536 AND2_218/net6 VSS VSS nmos W=0.31u L=0.04u
M10208 AND2_218/X_u2-net6 RESET VSS VSS nmos W=0.31u L=0.04u
M10209 AND2_218/net6 WX539 AND2_218/X_u2-net6 VSS nmos W=0.31u L=0.04u
M10210 WX536 AND2_218/net6 VDD VDD pmos W=0.41u L=0.04u
M10211 AND2_218/net6 RESET VDD VDD pmos W=0.41u L=0.04u
M10212 AND2_218/net6 WX539 VDD VDD pmos W=0.41u L=0.04u
M10213 WX534 AND2_217/net6 VSS VSS nmos W=0.31u L=0.04u
M10214 AND2_217/X_u2-net6 RESET VSS VSS nmos W=0.31u L=0.04u
M10215 AND2_217/net6 WX537 AND2_217/X_u2-net6 VSS nmos W=0.31u L=0.04u
M10216 WX534 AND2_217/net6 VDD VDD pmos W=0.41u L=0.04u
M10217 AND2_217/net6 RESET VDD VDD pmos W=0.41u L=0.04u
M10218 AND2_217/net6 WX537 VDD VDD pmos W=0.41u L=0.04u
M10219 WX532 AND2_216/net6 VSS VSS nmos W=0.31u L=0.04u
M10220 AND2_216/X_u2-net6 RESET VSS VSS nmos W=0.31u L=0.04u
M10221 AND2_216/net6 WX535 AND2_216/X_u2-net6 VSS nmos W=0.31u L=0.04u
M10222 WX532 AND2_216/net6 VDD VDD pmos W=0.41u L=0.04u
M10223 AND2_216/net6 RESET VDD VDD pmos W=0.41u L=0.04u
M10224 AND2_216/net6 WX535 VDD VDD pmos W=0.41u L=0.04u
M10225 WX530 AND2_215/net6 VSS VSS nmos W=0.31u L=0.04u
M10226 AND2_215/X_u2-net6 RESET VSS VSS nmos W=0.31u L=0.04u
M10227 AND2_215/net6 WX533 AND2_215/X_u2-net6 VSS nmos W=0.31u L=0.04u
M10228 WX530 AND2_215/net6 VDD VDD pmos W=0.41u L=0.04u
M10229 AND2_215/net6 RESET VDD VDD pmos W=0.41u L=0.04u
M10230 AND2_215/net6 WX533 VDD VDD pmos W=0.41u L=0.04u
M10231 WX528 AND2_214/net6 VSS VSS nmos W=0.31u L=0.04u
M10232 AND2_214/X_u2-net6 RESET VSS VSS nmos W=0.31u L=0.04u
M10233 AND2_214/net6 WX531 AND2_214/X_u2-net6 VSS nmos W=0.31u L=0.04u
M10234 WX528 AND2_214/net6 VDD VDD pmos W=0.41u L=0.04u
M10235 AND2_214/net6 RESET VDD VDD pmos W=0.41u L=0.04u
M10236 AND2_214/net6 WX531 VDD VDD pmos W=0.41u L=0.04u
M10237 WX526 AND2_213/net6 VSS VSS nmos W=0.31u L=0.04u
M10238 AND2_213/X_u2-net6 RESET VSS VSS nmos W=0.31u L=0.04u
M10239 AND2_213/net6 WX529 AND2_213/X_u2-net6 VSS nmos W=0.31u L=0.04u
M10240 WX526 AND2_213/net6 VDD VDD pmos W=0.41u L=0.04u
M10241 AND2_213/net6 RESET VDD VDD pmos W=0.41u L=0.04u
M10242 AND2_213/net6 WX529 VDD VDD pmos W=0.41u L=0.04u
M10243 WX524 AND2_212/net6 VSS VSS nmos W=0.31u L=0.04u
M10244 AND2_212/X_u2-net6 RESET VSS VSS nmos W=0.31u L=0.04u
M10245 AND2_212/net6 WX527 AND2_212/X_u2-net6 VSS nmos W=0.31u L=0.04u
M10246 WX524 AND2_212/net6 VDD VDD pmos W=0.41u L=0.04u
M10247 AND2_212/net6 RESET VDD VDD pmos W=0.41u L=0.04u
M10248 AND2_212/net6 WX527 VDD VDD pmos W=0.41u L=0.04u
M10249 WX522 AND2_211/net6 VSS VSS nmos W=0.31u L=0.04u
M10250 AND2_211/X_u2-net6 RESET VSS VSS nmos W=0.31u L=0.04u
M10251 AND2_211/net6 WX525 AND2_211/X_u2-net6 VSS nmos W=0.31u L=0.04u
M10252 WX522 AND2_211/net6 VDD VDD pmos W=0.41u L=0.04u
M10253 AND2_211/net6 RESET VDD VDD pmos W=0.41u L=0.04u
M10254 AND2_211/net6 WX525 VDD VDD pmos W=0.41u L=0.04u
M10255 WX520 AND2_210/net6 VSS VSS nmos W=0.31u L=0.04u
M10256 AND2_210/X_u2-net6 RESET VSS VSS nmos W=0.31u L=0.04u
M10257 AND2_210/net6 WX523 AND2_210/X_u2-net6 VSS nmos W=0.31u L=0.04u
M10258 WX520 AND2_210/net6 VDD VDD pmos W=0.41u L=0.04u
M10259 AND2_210/net6 RESET VDD VDD pmos W=0.41u L=0.04u
M10260 AND2_210/net6 WX523 VDD VDD pmos W=0.41u L=0.04u
M10261 WX518 AND2_209/net6 VSS VSS nmos W=0.31u L=0.04u
M10262 AND2_209/X_u2-net6 RESET VSS VSS nmos W=0.31u L=0.04u
M10263 AND2_209/net6 WX521 AND2_209/X_u2-net6 VSS nmos W=0.31u L=0.04u
M10264 WX518 AND2_209/net6 VDD VDD pmos W=0.41u L=0.04u
M10265 AND2_209/net6 RESET VDD VDD pmos W=0.41u L=0.04u
M10266 AND2_209/net6 WX521 VDD VDD pmos W=0.41u L=0.04u
M10267 WX516 AND2_208/net6 VSS VSS nmos W=0.31u L=0.04u
M10268 AND2_208/X_u2-net6 RESET VSS VSS nmos W=0.31u L=0.04u
M10269 AND2_208/net6 WX519 AND2_208/X_u2-net6 VSS nmos W=0.31u L=0.04u
M10270 WX516 AND2_208/net6 VDD VDD pmos W=0.41u L=0.04u
M10271 AND2_208/net6 RESET VDD VDD pmos W=0.41u L=0.04u
M10272 AND2_208/net6 WX519 VDD VDD pmos W=0.41u L=0.04u
M10273 WX514 AND2_207/net6 VSS VSS nmos W=0.31u L=0.04u
M10274 AND2_207/X_u2-net6 RESET VSS VSS nmos W=0.31u L=0.04u
M10275 AND2_207/net6 WX517 AND2_207/X_u2-net6 VSS nmos W=0.31u L=0.04u
M10276 WX514 AND2_207/net6 VDD VDD pmos W=0.41u L=0.04u
M10277 AND2_207/net6 RESET VDD VDD pmos W=0.41u L=0.04u
M10278 AND2_207/net6 WX517 VDD VDD pmos W=0.41u L=0.04u
M10279 WX512 AND2_206/net6 VSS VSS nmos W=0.31u L=0.04u
M10280 AND2_206/X_u2-net6 RESET VSS VSS nmos W=0.31u L=0.04u
M10281 AND2_206/net6 WX515 AND2_206/X_u2-net6 VSS nmos W=0.31u L=0.04u
M10282 WX512 AND2_206/net6 VDD VDD pmos W=0.41u L=0.04u
M10283 AND2_206/net6 RESET VDD VDD pmos W=0.41u L=0.04u
M10284 AND2_206/net6 WX515 VDD VDD pmos W=0.41u L=0.04u
M10285 WX510 AND2_205/net6 VSS VSS nmos W=0.31u L=0.04u
M10286 AND2_205/X_u2-net6 RESET VSS VSS nmos W=0.31u L=0.04u
M10287 AND2_205/net6 WX513 AND2_205/X_u2-net6 VSS nmos W=0.31u L=0.04u
M10288 WX510 AND2_205/net6 VDD VDD pmos W=0.41u L=0.04u
M10289 AND2_205/net6 RESET VDD VDD pmos W=0.41u L=0.04u
M10290 AND2_205/net6 WX513 VDD VDD pmos W=0.41u L=0.04u
M10291 WX508 AND2_204/net6 VSS VSS nmos W=0.31u L=0.04u
M10292 AND2_204/X_u2-net6 RESET VSS VSS nmos W=0.31u L=0.04u
M10293 AND2_204/net6 WX511 AND2_204/X_u2-net6 VSS nmos W=0.31u L=0.04u
M10294 WX508 AND2_204/net6 VDD VDD pmos W=0.41u L=0.04u
M10295 AND2_204/net6 RESET VDD VDD pmos W=0.41u L=0.04u
M10296 AND2_204/net6 WX511 VDD VDD pmos W=0.41u L=0.04u
M10297 WX506 AND2_203/net6 VSS VSS nmos W=0.31u L=0.04u
M10298 AND2_203/X_u2-net6 RESET VSS VSS nmos W=0.31u L=0.04u
M10299 AND2_203/net6 WX509 AND2_203/X_u2-net6 VSS nmos W=0.31u L=0.04u
M10300 WX506 AND2_203/net6 VDD VDD pmos W=0.41u L=0.04u
M10301 AND2_203/net6 RESET VDD VDD pmos W=0.41u L=0.04u
M10302 AND2_203/net6 WX509 VDD VDD pmos W=0.41u L=0.04u
M10303 WX504 AND2_202/net6 VSS VSS nmos W=0.31u L=0.04u
M10304 AND2_202/X_u2-net6 RESET VSS VSS nmos W=0.31u L=0.04u
M10305 AND2_202/net6 WX507 AND2_202/X_u2-net6 VSS nmos W=0.31u L=0.04u
M10306 WX504 AND2_202/net6 VDD VDD pmos W=0.41u L=0.04u
M10307 AND2_202/net6 RESET VDD VDD pmos W=0.41u L=0.04u
M10308 AND2_202/net6 WX507 VDD VDD pmos W=0.41u L=0.04u
M10309 WX502 AND2_201/net6 VSS VSS nmos W=0.31u L=0.04u
M10310 AND2_201/X_u2-net6 RESET VSS VSS nmos W=0.31u L=0.04u
M10311 AND2_201/net6 WX505 AND2_201/X_u2-net6 VSS nmos W=0.31u L=0.04u
M10312 WX502 AND2_201/net6 VDD VDD pmos W=0.41u L=0.04u
M10313 AND2_201/net6 RESET VDD VDD pmos W=0.41u L=0.04u
M10314 AND2_201/net6 WX505 VDD VDD pmos W=0.41u L=0.04u
M10315 WX500 AND2_200/net6 VSS VSS nmos W=0.31u L=0.04u
M10316 AND2_200/X_u2-net6 RESET VSS VSS nmos W=0.31u L=0.04u
M10317 AND2_200/net6 WX503 AND2_200/X_u2-net6 VSS nmos W=0.31u L=0.04u
M10318 WX500 AND2_200/net6 VDD VDD pmos W=0.41u L=0.04u
M10319 AND2_200/net6 RESET VDD VDD pmos W=0.41u L=0.04u
M10320 AND2_200/net6 WX503 VDD VDD pmos W=0.41u L=0.04u
M10321 WX498 AND2_199/net6 VSS VSS nmos W=0.31u L=0.04u
M10322 AND2_199/X_u2-net6 RESET VSS VSS nmos W=0.31u L=0.04u
M10323 AND2_199/net6 WX501 AND2_199/X_u2-net6 VSS nmos W=0.31u L=0.04u
M10324 WX498 AND2_199/net6 VDD VDD pmos W=0.41u L=0.04u
M10325 AND2_199/net6 RESET VDD VDD pmos W=0.41u L=0.04u
M10326 AND2_199/net6 WX501 VDD VDD pmos W=0.41u L=0.04u
M10327 WX496 AND2_198/net6 VSS VSS nmos W=0.31u L=0.04u
M10328 AND2_198/X_u2-net6 RESET VSS VSS nmos W=0.31u L=0.04u
M10329 AND2_198/net6 WX499 AND2_198/X_u2-net6 VSS nmos W=0.31u L=0.04u
M10330 WX496 AND2_198/net6 VDD VDD pmos W=0.41u L=0.04u
M10331 AND2_198/net6 RESET VDD VDD pmos W=0.41u L=0.04u
M10332 AND2_198/net6 WX499 VDD VDD pmos W=0.41u L=0.04u
M10333 WX494 AND2_197/net6 VSS VSS nmos W=0.31u L=0.04u
M10334 AND2_197/X_u2-net6 RESET VSS VSS nmos W=0.31u L=0.04u
M10335 AND2_197/net6 WX497 AND2_197/X_u2-net6 VSS nmos W=0.31u L=0.04u
M10336 WX494 AND2_197/net6 VDD VDD pmos W=0.41u L=0.04u
M10337 AND2_197/net6 RESET VDD VDD pmos W=0.41u L=0.04u
M10338 AND2_197/net6 WX497 VDD VDD pmos W=0.41u L=0.04u
M10339 WX492 AND2_196/net6 VSS VSS nmos W=0.31u L=0.04u
M10340 AND2_196/X_u2-net6 RESET VSS VSS nmos W=0.31u L=0.04u
M10341 AND2_196/net6 WX495 AND2_196/X_u2-net6 VSS nmos W=0.31u L=0.04u
M10342 WX492 AND2_196/net6 VDD VDD pmos W=0.41u L=0.04u
M10343 AND2_196/net6 RESET VDD VDD pmos W=0.41u L=0.04u
M10344 AND2_196/net6 WX495 VDD VDD pmos W=0.41u L=0.04u
M10345 WX490 AND2_195/net6 VSS VSS nmos W=0.31u L=0.04u
M10346 AND2_195/X_u2-net6 RESET VSS VSS nmos W=0.31u L=0.04u
M10347 AND2_195/net6 WX493 AND2_195/X_u2-net6 VSS nmos W=0.31u L=0.04u
M10348 WX490 AND2_195/net6 VDD VDD pmos W=0.41u L=0.04u
M10349 AND2_195/net6 RESET VDD VDD pmos W=0.41u L=0.04u
M10350 AND2_195/net6 WX493 VDD VDD pmos W=0.41u L=0.04u
M10351 WX488 AND2_194/net6 VSS VSS nmos W=0.31u L=0.04u
M10352 AND2_194/X_u2-net6 RESET VSS VSS nmos W=0.31u L=0.04u
M10353 AND2_194/net6 WX491 AND2_194/X_u2-net6 VSS nmos W=0.31u L=0.04u
M10354 WX488 AND2_194/net6 VDD VDD pmos W=0.41u L=0.04u
M10355 AND2_194/net6 RESET VDD VDD pmos W=0.41u L=0.04u
M10356 AND2_194/net6 WX491 VDD VDD pmos W=0.41u L=0.04u
M10357 WX486 AND2_193/net6 VSS VSS nmos W=0.31u L=0.04u
M10358 AND2_193/X_u2-net6 RESET VSS VSS nmos W=0.31u L=0.04u
M10359 AND2_193/net6 WX489 AND2_193/X_u2-net6 VSS nmos W=0.31u L=0.04u
M10360 WX486 AND2_193/net6 VDD VDD pmos W=0.41u L=0.04u
M10361 AND2_193/net6 RESET VDD VDD pmos W=0.41u L=0.04u
M10362 AND2_193/net6 WX489 VDD VDD pmos W=0.41u L=0.04u
M10363 WX484 AND2_192/net6 VSS VSS nmos W=0.31u L=0.04u
M10364 AND2_192/X_u2-net6 RESET VSS VSS nmos W=0.31u L=0.04u
M10365 AND2_192/net6 WX487 AND2_192/X_u2-net6 VSS nmos W=0.31u L=0.04u
M10366 WX484 AND2_192/net6 VDD VDD pmos W=0.41u L=0.04u
M10367 AND2_192/net6 RESET VDD VDD pmos W=0.41u L=0.04u
M10368 AND2_192/net6 WX487 VDD VDD pmos W=0.41u L=0.04u
M10369 U1497/XI1-net6 n1380 VSS VSS nmos W=0.31u L=0.04u
M10370 n1615 TM0 U1497/XI1-net6 VSS nmos W=0.31u L=0.04u
M10371 n1615 n1380 VDD VDD pmos W=0.41u L=0.04u
M10372 n1615 TM0 VDD VDD pmos W=0.41u L=0.04u
M10373 n1617 TM0 VSS VSS nmos W=0.31u L=0.04u
M10374 n1617 TM1 VSS VSS nmos W=0.31u L=0.04u
M10375 U1498/XI1-net8 TM1 VDD VDD pmos W=0.41u L=0.04u
M10376 n1617 TM0 U1498/XI1-net8 VDD pmos W=0.41u L=0.04u
M10377 n1245 U1499/net21 VSS VSS nmos W=0.27u L=0.04u
M10378 U1499/net21 n1267 VSS VSS nmos W=0.27u L=0.04u
M10379 n1245 U1499/net21 VDD VDD pmos W=0.41u L=0.04u
M10380 U1499/net21 n1267 VDD VDD pmos W=0.41u L=0.04u
M10381 n1280 U1500/net21 VSS VSS nmos W=0.27u L=0.04u
M10382 U1500/net21 n1297 VSS VSS nmos W=0.27u L=0.04u
M10383 n1280 U1500/net21 VDD VDD pmos W=0.41u L=0.04u
M10384 U1500/net21 n1297 VDD VDD pmos W=0.41u L=0.04u
M10385 n1279 U1501/net21 VSS VSS nmos W=0.27u L=0.04u
M10386 U1501/net21 n1297 VSS VSS nmos W=0.27u L=0.04u
M10387 n1279 U1501/net21 VDD VDD pmos W=0.41u L=0.04u
M10388 U1501/net21 n1297 VDD VDD pmos W=0.41u L=0.04u
M10389 n1278 U1502/net21 VSS VSS nmos W=0.27u L=0.04u
M10390 U1502/net21 n1297 VSS VSS nmos W=0.27u L=0.04u
M10391 n1278 U1502/net21 VDD VDD pmos W=0.41u L=0.04u
M10392 U1502/net21 n1297 VDD VDD pmos W=0.41u L=0.04u
M10393 n1276 U1503/net21 VSS VSS nmos W=0.27u L=0.04u
M10394 U1503/net21 n1298 VSS VSS nmos W=0.27u L=0.04u
M10395 n1276 U1503/net21 VDD VDD pmos W=0.41u L=0.04u
M10396 U1503/net21 n1298 VDD VDD pmos W=0.41u L=0.04u
M10397 n1275 U1504/net21 VSS VSS nmos W=0.27u L=0.04u
M10398 U1504/net21 n1298 VSS VSS nmos W=0.27u L=0.04u
M10399 n1275 U1504/net21 VDD VDD pmos W=0.41u L=0.04u
M10400 U1504/net21 n1298 VDD VDD pmos W=0.41u L=0.04u
M10401 n1277 U1505/net21 VSS VSS nmos W=0.27u L=0.04u
M10402 U1505/net21 n1298 VSS VSS nmos W=0.27u L=0.04u
M10403 n1277 U1505/net21 VDD VDD pmos W=0.41u L=0.04u
M10404 U1505/net21 n1298 VDD VDD pmos W=0.41u L=0.04u
M10405 n1241 U1506/net21 VSS VSS nmos W=0.27u L=0.04u
M10406 U1506/net21 n1268 VSS VSS nmos W=0.27u L=0.04u
M10407 n1241 U1506/net21 VDD VDD pmos W=0.41u L=0.04u
M10408 U1506/net21 n1268 VDD VDD pmos W=0.41u L=0.04u
M10409 n1242 U1507/net21 VSS VSS nmos W=0.27u L=0.04u
M10410 U1507/net21 n1268 VSS VSS nmos W=0.27u L=0.04u
M10411 n1242 U1507/net21 VDD VDD pmos W=0.41u L=0.04u
M10412 U1507/net21 n1268 VDD VDD pmos W=0.41u L=0.04u
M10413 n1243 U1508/net21 VSS VSS nmos W=0.27u L=0.04u
M10414 U1508/net21 n1268 VSS VSS nmos W=0.27u L=0.04u
M10415 n1243 U1508/net21 VDD VDD pmos W=0.41u L=0.04u
M10416 U1508/net21 n1268 VDD VDD pmos W=0.41u L=0.04u
M10417 n1244 U1509/net21 VSS VSS nmos W=0.27u L=0.04u
M10418 U1509/net21 n1267 VSS VSS nmos W=0.27u L=0.04u
M10419 n1244 U1509/net21 VDD VDD pmos W=0.41u L=0.04u
M10420 U1509/net21 n1267 VDD VDD pmos W=0.41u L=0.04u
M10421 n1286 U1510/net21 VSS VSS nmos W=0.27u L=0.04u
M10422 U1510/net21 n1295 VSS VSS nmos W=0.27u L=0.04u
M10423 n1286 U1510/net21 VDD VDD pmos W=0.41u L=0.04u
M10424 U1510/net21 n1295 VDD VDD pmos W=0.41u L=0.04u
M10425 n1285 U1511/net21 VSS VSS nmos W=0.27u L=0.04u
M10426 U1511/net21 n1295 VSS VSS nmos W=0.27u L=0.04u
M10427 n1285 U1511/net21 VDD VDD pmos W=0.41u L=0.04u
M10428 U1511/net21 n1295 VDD VDD pmos W=0.41u L=0.04u
M10429 n1283 U1512/net21 VSS VSS nmos W=0.27u L=0.04u
M10430 U1512/net21 n1296 VSS VSS nmos W=0.27u L=0.04u
M10431 n1283 U1512/net21 VDD VDD pmos W=0.41u L=0.04u
M10432 U1512/net21 n1296 VDD VDD pmos W=0.41u L=0.04u
M10433 n1282 U1513/net21 VSS VSS nmos W=0.27u L=0.04u
M10434 U1513/net21 n1296 VSS VSS nmos W=0.27u L=0.04u
M10435 n1282 U1513/net21 VDD VDD pmos W=0.41u L=0.04u
M10436 U1513/net21 n1296 VDD VDD pmos W=0.41u L=0.04u
M10437 n1281 U1514/net21 VSS VSS nmos W=0.27u L=0.04u
M10438 U1514/net21 n1296 VSS VSS nmos W=0.27u L=0.04u
M10439 n1281 U1514/net21 VDD VDD pmos W=0.41u L=0.04u
M10440 U1514/net21 n1296 VDD VDD pmos W=0.41u L=0.04u
M10441 n1284 U1515/net21 VSS VSS nmos W=0.27u L=0.04u
M10442 U1515/net21 n1295 VSS VSS nmos W=0.27u L=0.04u
M10443 n1284 U1515/net21 VDD VDD pmos W=0.41u L=0.04u
M10444 U1515/net21 n1295 VDD VDD pmos W=0.41u L=0.04u
M10445 n1246 U1516/net21 VSS VSS nmos W=0.27u L=0.04u
M10446 U1516/net21 n1267 VSS VSS nmos W=0.27u L=0.04u
M10447 n1246 U1516/net21 VDD VDD pmos W=0.41u L=0.04u
M10448 U1516/net21 n1267 VDD VDD pmos W=0.41u L=0.04u
M10449 n1274 U1517/net21 VSS VSS nmos W=0.27u L=0.04u
M10450 U1517/net21 n1299 VSS VSS nmos W=0.27u L=0.04u
M10451 n1274 U1517/net21 VDD VDD pmos W=0.41u L=0.04u
M10452 U1517/net21 n1299 VDD VDD pmos W=0.41u L=0.04u
M10453 n1273 U1518/net21 VSS VSS nmos W=0.27u L=0.04u
M10454 U1518/net21 n1299 VSS VSS nmos W=0.27u L=0.04u
M10455 n1273 U1518/net21 VDD VDD pmos W=0.41u L=0.04u
M10456 U1518/net21 n1299 VDD VDD pmos W=0.41u L=0.04u
M10457 n1344 U1519/net21 VSS VSS nmos W=0.27u L=0.04u
M10458 U1519/net21 n1358 VSS VSS nmos W=0.27u L=0.04u
M10459 n1344 U1519/net21 VDD VDD pmos W=0.41u L=0.04u
M10460 U1519/net21 n1358 VDD VDD pmos W=0.41u L=0.04u
M10461 n1343 U1520/net21 VSS VSS nmos W=0.27u L=0.04u
M10462 U1520/net21 n1358 VSS VSS nmos W=0.27u L=0.04u
M10463 n1343 U1520/net21 VDD VDD pmos W=0.41u L=0.04u
M10464 U1520/net21 n1358 VDD VDD pmos W=0.41u L=0.04u
M10465 n1342 U1521/net21 VSS VSS nmos W=0.27u L=0.04u
M10466 U1521/net21 n1359 VSS VSS nmos W=0.27u L=0.04u
M10467 n1342 U1521/net21 VDD VDD pmos W=0.41u L=0.04u
M10468 U1521/net21 n1359 VDD VDD pmos W=0.41u L=0.04u
M10469 n1341 U1522/net21 VSS VSS nmos W=0.27u L=0.04u
M10470 U1522/net21 n1359 VSS VSS nmos W=0.27u L=0.04u
M10471 n1341 U1522/net21 VDD VDD pmos W=0.41u L=0.04u
M10472 U1522/net21 n1359 VDD VDD pmos W=0.41u L=0.04u
M10473 n1340 U1523/net21 VSS VSS nmos W=0.27u L=0.04u
M10474 U1523/net21 n1359 VSS VSS nmos W=0.27u L=0.04u
M10475 n1340 U1523/net21 VDD VDD pmos W=0.41u L=0.04u
M10476 U1523/net21 n1359 VDD VDD pmos W=0.41u L=0.04u
M10477 n1339 U1524/net21 VSS VSS nmos W=0.27u L=0.04u
M10478 U1524/net21 n1360 VSS VSS nmos W=0.27u L=0.04u
M10479 n1339 U1524/net21 VDD VDD pmos W=0.41u L=0.04u
M10480 U1524/net21 n1360 VDD VDD pmos W=0.41u L=0.04u
M10481 n1337 U1525/net21 VSS VSS nmos W=0.27u L=0.04u
M10482 U1525/net21 n1360 VSS VSS nmos W=0.27u L=0.04u
M10483 n1337 U1525/net21 VDD VDD pmos W=0.41u L=0.04u
M10484 U1525/net21 n1360 VDD VDD pmos W=0.41u L=0.04u
M10485 n1336 U1526/net21 VSS VSS nmos W=0.27u L=0.04u
M10486 U1526/net21 n1361 VSS VSS nmos W=0.27u L=0.04u
M10487 n1336 U1526/net21 VDD VDD pmos W=0.41u L=0.04u
M10488 U1526/net21 n1361 VDD VDD pmos W=0.41u L=0.04u
M10489 n1335 U1527/net21 VSS VSS nmos W=0.27u L=0.04u
M10490 U1527/net21 n1361 VSS VSS nmos W=0.27u L=0.04u
M10491 n1335 U1527/net21 VDD VDD pmos W=0.41u L=0.04u
M10492 U1527/net21 n1361 VDD VDD pmos W=0.41u L=0.04u
M10493 n1334 U1528/net21 VSS VSS nmos W=0.27u L=0.04u
M10494 U1528/net21 n1361 VSS VSS nmos W=0.27u L=0.04u
M10495 n1334 U1528/net21 VDD VDD pmos W=0.41u L=0.04u
M10496 U1528/net21 n1361 VDD VDD pmos W=0.41u L=0.04u
M10497 n1338 U1529/net21 VSS VSS nmos W=0.27u L=0.04u
M10498 U1529/net21 n1360 VSS VSS nmos W=0.27u L=0.04u
M10499 n1338 U1529/net21 VDD VDD pmos W=0.41u L=0.04u
M10500 U1529/net21 n1360 VDD VDD pmos W=0.41u L=0.04u
M10501 n1353 U1530/net21 VSS VSS nmos W=0.27u L=0.04u
M10502 U1530/net21 n1355 VSS VSS nmos W=0.27u L=0.04u
M10503 n1353 U1530/net21 VDD VDD pmos W=0.41u L=0.04u
M10504 U1530/net21 n1355 VDD VDD pmos W=0.41u L=0.04u
M10505 n1352 U1531/net21 VSS VSS nmos W=0.27u L=0.04u
M10506 U1531/net21 n1355 VSS VSS nmos W=0.27u L=0.04u
M10507 n1352 U1531/net21 VDD VDD pmos W=0.41u L=0.04u
M10508 U1531/net21 n1355 VDD VDD pmos W=0.41u L=0.04u
M10509 n1351 U1532/net21 VSS VSS nmos W=0.27u L=0.04u
M10510 U1532/net21 n1356 VSS VSS nmos W=0.27u L=0.04u
M10511 n1351 U1532/net21 VDD VDD pmos W=0.41u L=0.04u
M10512 U1532/net21 n1356 VDD VDD pmos W=0.41u L=0.04u
M10513 n1350 U1533/net21 VSS VSS nmos W=0.27u L=0.04u
M10514 U1533/net21 n1356 VSS VSS nmos W=0.27u L=0.04u
M10515 n1350 U1533/net21 VDD VDD pmos W=0.41u L=0.04u
M10516 U1533/net21 n1356 VDD VDD pmos W=0.41u L=0.04u
M10517 n1349 U1534/net21 VSS VSS nmos W=0.27u L=0.04u
M10518 U1534/net21 n1356 VSS VSS nmos W=0.27u L=0.04u
M10519 n1349 U1534/net21 VDD VDD pmos W=0.41u L=0.04u
M10520 U1534/net21 n1356 VDD VDD pmos W=0.41u L=0.04u
M10521 n1348 U1535/net21 VSS VSS nmos W=0.27u L=0.04u
M10522 U1535/net21 n1357 VSS VSS nmos W=0.27u L=0.04u
M10523 n1348 U1535/net21 VDD VDD pmos W=0.41u L=0.04u
M10524 U1535/net21 n1357 VDD VDD pmos W=0.41u L=0.04u
M10525 n1347 U1536/net21 VSS VSS nmos W=0.27u L=0.04u
M10526 U1536/net21 n1357 VSS VSS nmos W=0.27u L=0.04u
M10527 n1347 U1536/net21 VDD VDD pmos W=0.41u L=0.04u
M10528 U1536/net21 n1357 VDD VDD pmos W=0.41u L=0.04u
M10529 n1346 U1537/net21 VSS VSS nmos W=0.27u L=0.04u
M10530 U1537/net21 n1357 VSS VSS nmos W=0.27u L=0.04u
M10531 n1346 U1537/net21 VDD VDD pmos W=0.41u L=0.04u
M10532 U1537/net21 n1357 VDD VDD pmos W=0.41u L=0.04u
M10533 n1345 U1538/net21 VSS VSS nmos W=0.27u L=0.04u
M10534 U1538/net21 n1358 VSS VSS nmos W=0.27u L=0.04u
M10535 n1345 U1538/net21 VDD VDD pmos W=0.41u L=0.04u
M10536 U1538/net21 n1358 VDD VDD pmos W=0.41u L=0.04u
M10537 n1287 U1539/net21 VSS VSS nmos W=0.27u L=0.04u
M10538 U1539/net21 n1294 VSS VSS nmos W=0.27u L=0.04u
M10539 n1287 U1539/net21 VDD VDD pmos W=0.41u L=0.04u
M10540 U1539/net21 n1294 VDD VDD pmos W=0.41u L=0.04u
M10541 n1288 U1540/net21 VSS VSS nmos W=0.27u L=0.04u
M10542 U1540/net21 n1294 VSS VSS nmos W=0.27u L=0.04u
M10543 n1288 U1540/net21 VDD VDD pmos W=0.41u L=0.04u
M10544 U1540/net21 n1294 VDD VDD pmos W=0.41u L=0.04u
M10545 n1251 U1541/net21 VSS VSS nmos W=0.27u L=0.04u
M10546 U1541/net21 n1265 VSS VSS nmos W=0.27u L=0.04u
M10547 n1251 U1541/net21 VDD VDD pmos W=0.41u L=0.04u
M10548 U1541/net21 n1265 VDD VDD pmos W=0.41u L=0.04u
M10549 n1252 U1542/net21 VSS VSS nmos W=0.27u L=0.04u
M10550 U1542/net21 n1265 VSS VSS nmos W=0.27u L=0.04u
M10551 n1252 U1542/net21 VDD VDD pmos W=0.41u L=0.04u
M10552 U1542/net21 n1265 VDD VDD pmos W=0.41u L=0.04u
M10553 n1250 U1543/net21 VSS VSS nmos W=0.27u L=0.04u
M10554 U1543/net21 n1265 VSS VSS nmos W=0.27u L=0.04u
M10555 n1250 U1543/net21 VDD VDD pmos W=0.41u L=0.04u
M10556 U1543/net21 n1265 VDD VDD pmos W=0.41u L=0.04u
M10557 n1249 U1544/net21 VSS VSS nmos W=0.27u L=0.04u
M10558 U1544/net21 n1266 VSS VSS nmos W=0.27u L=0.04u
M10559 n1249 U1544/net21 VDD VDD pmos W=0.41u L=0.04u
M10560 U1544/net21 n1266 VDD VDD pmos W=0.41u L=0.04u
M10561 n1248 U1545/net21 VSS VSS nmos W=0.27u L=0.04u
M10562 U1545/net21 n1266 VSS VSS nmos W=0.27u L=0.04u
M10563 n1248 U1545/net21 VDD VDD pmos W=0.41u L=0.04u
M10564 U1545/net21 n1266 VDD VDD pmos W=0.41u L=0.04u
M10565 n1247 U1546/net21 VSS VSS nmos W=0.27u L=0.04u
M10566 U1546/net21 n1266 VSS VSS nmos W=0.27u L=0.04u
M10567 n1247 U1546/net21 VDD VDD pmos W=0.41u L=0.04u
M10568 U1546/net21 n1266 VDD VDD pmos W=0.41u L=0.04u
M10569 n1289 U1547/net21 VSS VSS nmos W=0.27u L=0.04u
M10570 U1547/net21 n1294 VSS VSS nmos W=0.27u L=0.04u
M10571 n1289 U1547/net21 VDD VDD pmos W=0.41u L=0.04u
M10572 U1547/net21 n1294 VDD VDD pmos W=0.41u L=0.04u
M10573 n1260 U1548/net21 VSS VSS nmos W=0.27u L=0.04u
M10574 U1548/net21 n1262 VSS VSS nmos W=0.27u L=0.04u
M10575 n1260 U1548/net21 VDD VDD pmos W=0.41u L=0.04u
M10576 U1548/net21 n1262 VDD VDD pmos W=0.41u L=0.04u
M10577 n1259 U1549/net21 VSS VSS nmos W=0.27u L=0.04u
M10578 U1549/net21 n1262 VSS VSS nmos W=0.27u L=0.04u
M10579 n1259 U1549/net21 VDD VDD pmos W=0.41u L=0.04u
M10580 U1549/net21 n1262 VDD VDD pmos W=0.41u L=0.04u
M10581 n1258 U1550/net21 VSS VSS nmos W=0.27u L=0.04u
M10582 U1550/net21 n1263 VSS VSS nmos W=0.27u L=0.04u
M10583 n1258 U1550/net21 VDD VDD pmos W=0.41u L=0.04u
M10584 U1550/net21 n1263 VDD VDD pmos W=0.41u L=0.04u
M10585 n1256 U1551/net21 VSS VSS nmos W=0.27u L=0.04u
M10586 U1551/net21 n1263 VSS VSS nmos W=0.27u L=0.04u
M10587 n1256 U1551/net21 VDD VDD pmos W=0.41u L=0.04u
M10588 U1551/net21 n1263 VDD VDD pmos W=0.41u L=0.04u
M10589 n1255 U1552/net21 VSS VSS nmos W=0.27u L=0.04u
M10590 U1552/net21 n1264 VSS VSS nmos W=0.27u L=0.04u
M10591 n1255 U1552/net21 VDD VDD pmos W=0.41u L=0.04u
M10592 U1552/net21 n1264 VDD VDD pmos W=0.41u L=0.04u
M10593 n1254 U1553/net21 VSS VSS nmos W=0.27u L=0.04u
M10594 U1553/net21 n1264 VSS VSS nmos W=0.27u L=0.04u
M10595 n1254 U1553/net21 VDD VDD pmos W=0.41u L=0.04u
M10596 U1553/net21 n1264 VDD VDD pmos W=0.41u L=0.04u
M10597 n1253 U1554/net21 VSS VSS nmos W=0.27u L=0.04u
M10598 U1554/net21 n1264 VSS VSS nmos W=0.27u L=0.04u
M10599 n1253 U1554/net21 VDD VDD pmos W=0.41u L=0.04u
M10600 U1554/net21 n1264 VDD VDD pmos W=0.41u L=0.04u
M10601 n1257 U1555/net21 VSS VSS nmos W=0.27u L=0.04u
M10602 U1555/net21 n1263 VSS VSS nmos W=0.27u L=0.04u
M10603 n1257 U1555/net21 VDD VDD pmos W=0.41u L=0.04u
M10604 U1555/net21 n1263 VDD VDD pmos W=0.41u L=0.04u
M10605 n1303 U1556/net21 VSS VSS nmos W=0.27u L=0.04u
M10606 U1556/net21 n1329 VSS VSS nmos W=0.27u L=0.04u
M10607 n1303 U1556/net21 VDD VDD pmos W=0.41u L=0.04u
M10608 U1556/net21 n1329 VDD VDD pmos W=0.41u L=0.04u
M10609 n1311 U1557/net21 VSS VSS nmos W=0.27u L=0.04u
M10610 U1557/net21 n1326 VSS VSS nmos W=0.27u L=0.04u
M10611 n1311 U1557/net21 VDD VDD pmos W=0.41u L=0.04u
M10612 U1557/net21 n1326 VDD VDD pmos W=0.41u L=0.04u
M10613 n1310 U1558/net21 VSS VSS nmos W=0.27u L=0.04u
M10614 U1558/net21 n1327 VSS VSS nmos W=0.27u L=0.04u
M10615 n1310 U1558/net21 VDD VDD pmos W=0.41u L=0.04u
M10616 U1558/net21 n1327 VDD VDD pmos W=0.41u L=0.04u
M10617 n1309 U1559/net21 VSS VSS nmos W=0.27u L=0.04u
M10618 U1559/net21 n1327 VSS VSS nmos W=0.27u L=0.04u
M10619 n1309 U1559/net21 VDD VDD pmos W=0.41u L=0.04u
M10620 U1559/net21 n1327 VDD VDD pmos W=0.41u L=0.04u
M10621 n1308 U1560/net21 VSS VSS nmos W=0.27u L=0.04u
M10622 U1560/net21 n1327 VSS VSS nmos W=0.27u L=0.04u
M10623 n1308 U1560/net21 VDD VDD pmos W=0.41u L=0.04u
M10624 U1560/net21 n1327 VDD VDD pmos W=0.41u L=0.04u
M10625 n1306 U1561/net21 VSS VSS nmos W=0.27u L=0.04u
M10626 U1561/net21 n1328 VSS VSS nmos W=0.27u L=0.04u
M10627 n1306 U1561/net21 VDD VDD pmos W=0.41u L=0.04u
M10628 U1561/net21 n1328 VDD VDD pmos W=0.41u L=0.04u
M10629 n1305 U1562/net21 VSS VSS nmos W=0.27u L=0.04u
M10630 U1562/net21 n1328 VSS VSS nmos W=0.27u L=0.04u
M10631 n1305 U1562/net21 VDD VDD pmos W=0.41u L=0.04u
M10632 U1562/net21 n1328 VDD VDD pmos W=0.41u L=0.04u
M10633 n1307 U1563/net21 VSS VSS nmos W=0.27u L=0.04u
M10634 U1563/net21 n1328 VSS VSS nmos W=0.27u L=0.04u
M10635 n1307 U1563/net21 VDD VDD pmos W=0.41u L=0.04u
M10636 U1563/net21 n1328 VDD VDD pmos W=0.41u L=0.04u
M10637 n1319 U1564/net21 VSS VSS nmos W=0.27u L=0.04u
M10638 U1564/net21 n1324 VSS VSS nmos W=0.27u L=0.04u
M10639 n1319 U1564/net21 VDD VDD pmos W=0.41u L=0.04u
M10640 U1564/net21 n1324 VDD VDD pmos W=0.41u L=0.04u
M10641 n1318 U1565/net21 VSS VSS nmos W=0.27u L=0.04u
M10642 U1565/net21 n1324 VSS VSS nmos W=0.27u L=0.04u
M10643 n1318 U1565/net21 VDD VDD pmos W=0.41u L=0.04u
M10644 U1565/net21 n1324 VDD VDD pmos W=0.41u L=0.04u
M10645 n1316 U1566/net21 VSS VSS nmos W=0.27u L=0.04u
M10646 U1566/net21 n1325 VSS VSS nmos W=0.27u L=0.04u
M10647 n1316 U1566/net21 VDD VDD pmos W=0.41u L=0.04u
M10648 U1566/net21 n1325 VDD VDD pmos W=0.41u L=0.04u
M10649 n1315 U1567/net21 VSS VSS nmos W=0.27u L=0.04u
M10650 U1567/net21 n1325 VSS VSS nmos W=0.27u L=0.04u
M10651 n1315 U1567/net21 VDD VDD pmos W=0.41u L=0.04u
M10652 U1567/net21 n1325 VDD VDD pmos W=0.41u L=0.04u
M10653 n1314 U1568/net21 VSS VSS nmos W=0.27u L=0.04u
M10654 U1568/net21 n1325 VSS VSS nmos W=0.27u L=0.04u
M10655 n1314 U1568/net21 VDD VDD pmos W=0.41u L=0.04u
M10656 U1568/net21 n1325 VDD VDD pmos W=0.41u L=0.04u
M10657 n1313 U1569/net21 VSS VSS nmos W=0.27u L=0.04u
M10658 U1569/net21 n1326 VSS VSS nmos W=0.27u L=0.04u
M10659 n1313 U1569/net21 VDD VDD pmos W=0.41u L=0.04u
M10660 U1569/net21 n1326 VDD VDD pmos W=0.41u L=0.04u
M10661 n1312 U1570/net21 VSS VSS nmos W=0.27u L=0.04u
M10662 U1570/net21 n1326 VSS VSS nmos W=0.27u L=0.04u
M10663 n1312 U1570/net21 VDD VDD pmos W=0.41u L=0.04u
M10664 U1570/net21 n1326 VDD VDD pmos W=0.41u L=0.04u
M10665 n1317 U1571/net21 VSS VSS nmos W=0.27u L=0.04u
M10666 U1571/net21 n1324 VSS VSS nmos W=0.27u L=0.04u
M10667 n1317 U1571/net21 VDD VDD pmos W=0.41u L=0.04u
M10668 U1571/net21 n1324 VDD VDD pmos W=0.41u L=0.04u
M10669 n1304 U1572/net21 VSS VSS nmos W=0.27u L=0.04u
M10670 U1572/net21 n1329 VSS VSS nmos W=0.27u L=0.04u
M10671 n1304 U1572/net21 VDD VDD pmos W=0.41u L=0.04u
M10672 U1572/net21 n1329 VDD VDD pmos W=0.41u L=0.04u
M10673 n1354 U1573/net21 VSS VSS nmos W=0.27u L=0.04u
M10674 U1573/net21 n1355 VSS VSS nmos W=0.27u L=0.04u
M10675 n1354 U1573/net21 VDD VDD pmos W=0.41u L=0.04u
M10676 U1573/net21 n1355 VDD VDD pmos W=0.41u L=0.04u
M10677 n1261 U1574/net21 VSS VSS nmos W=0.27u L=0.04u
M10678 U1574/net21 n1262 VSS VSS nmos W=0.27u L=0.04u
M10679 n1261 U1574/net21 VDD VDD pmos W=0.41u L=0.04u
M10680 U1574/net21 n1262 VDD VDD pmos W=0.41u L=0.04u
M10681 n1359 U1575/net21 VSS VSS nmos W=0.27u L=0.04u
M10682 U1575/net21 n1364 VSS VSS nmos W=0.27u L=0.04u
M10683 n1359 U1575/net21 VDD VDD pmos W=0.41u L=0.04u
M10684 U1575/net21 n1364 VDD VDD pmos W=0.41u L=0.04u
M10685 n1327 U1576/net21 VSS VSS nmos W=0.27u L=0.04u
M10686 U1576/net21 n1330 VSS VSS nmos W=0.27u L=0.04u
M10687 n1327 U1576/net21 VDD VDD pmos W=0.41u L=0.04u
M10688 U1576/net21 n1330 VDD VDD pmos W=0.41u L=0.04u
M10689 n1328 U1577/net21 VSS VSS nmos W=0.27u L=0.04u
M10690 U1577/net21 n1330 VSS VSS nmos W=0.27u L=0.04u
M10691 n1328 U1577/net21 VDD VDD pmos W=0.41u L=0.04u
M10692 U1577/net21 n1330 VDD VDD pmos W=0.41u L=0.04u
M10693 n1361 U1578/net21 VSS VSS nmos W=0.27u L=0.04u
M10694 U1578/net21 n1363 VSS VSS nmos W=0.27u L=0.04u
M10695 n1361 U1578/net21 VDD VDD pmos W=0.41u L=0.04u
M10696 U1578/net21 n1363 VDD VDD pmos W=0.41u L=0.04u
M10697 n1360 U1579/net21 VSS VSS nmos W=0.27u L=0.04u
M10698 U1579/net21 n1363 VSS VSS nmos W=0.27u L=0.04u
M10699 n1360 U1579/net21 VDD VDD pmos W=0.41u L=0.04u
M10700 U1579/net21 n1363 VDD VDD pmos W=0.41u L=0.04u
M10701 n1325 U1580/net21 VSS VSS nmos W=0.27u L=0.04u
M10702 U1580/net21 n1331 VSS VSS nmos W=0.27u L=0.04u
M10703 n1325 U1580/net21 VDD VDD pmos W=0.41u L=0.04u
M10704 U1580/net21 n1331 VDD VDD pmos W=0.41u L=0.04u
M10705 n1357 U1581/net21 VSS VSS nmos W=0.27u L=0.04u
M10706 U1581/net21 n1364 VSS VSS nmos W=0.27u L=0.04u
M10707 n1357 U1581/net21 VDD VDD pmos W=0.41u L=0.04u
M10708 U1581/net21 n1364 VDD VDD pmos W=0.41u L=0.04u
M10709 n1326 U1582/net21 VSS VSS nmos W=0.27u L=0.04u
M10710 U1582/net21 n1331 VSS VSS nmos W=0.27u L=0.04u
M10711 n1326 U1582/net21 VDD VDD pmos W=0.41u L=0.04u
M10712 U1582/net21 n1331 VDD VDD pmos W=0.41u L=0.04u
M10713 n1358 U1583/net21 VSS VSS nmos W=0.27u L=0.04u
M10714 U1583/net21 n1364 VSS VSS nmos W=0.27u L=0.04u
M10715 n1358 U1583/net21 VDD VDD pmos W=0.41u L=0.04u
M10716 U1583/net21 n1364 VDD VDD pmos W=0.41u L=0.04u
M10717 n1324 U1584/net21 VSS VSS nmos W=0.27u L=0.04u
M10718 U1584/net21 n1331 VSS VSS nmos W=0.27u L=0.04u
M10719 n1324 U1584/net21 VDD VDD pmos W=0.41u L=0.04u
M10720 U1584/net21 n1331 VDD VDD pmos W=0.41u L=0.04u
M10721 n1265 U1585/net21 VSS VSS nmos W=0.27u L=0.04u
M10722 U1585/net21 n1271 VSS VSS nmos W=0.27u L=0.04u
M10723 n1265 U1585/net21 VDD VDD pmos W=0.41u L=0.04u
M10724 U1585/net21 n1271 VDD VDD pmos W=0.41u L=0.04u
M10725 n1297 U1586/net21 VSS VSS nmos W=0.27u L=0.04u
M10726 U1586/net21 n1300 VSS VSS nmos W=0.27u L=0.04u
M10727 n1297 U1586/net21 VDD VDD pmos W=0.41u L=0.04u
M10728 U1586/net21 n1300 VDD VDD pmos W=0.41u L=0.04u
M10729 n1266 U1587/net21 VSS VSS nmos W=0.27u L=0.04u
M10730 U1587/net21 n1271 VSS VSS nmos W=0.27u L=0.04u
M10731 n1266 U1587/net21 VDD VDD pmos W=0.41u L=0.04u
M10732 U1587/net21 n1271 VDD VDD pmos W=0.41u L=0.04u
M10733 n1298 U1588/net21 VSS VSS nmos W=0.27u L=0.04u
M10734 U1588/net21 n1300 VSS VSS nmos W=0.27u L=0.04u
M10735 n1298 U1588/net21 VDD VDD pmos W=0.41u L=0.04u
M10736 U1588/net21 n1300 VDD VDD pmos W=0.41u L=0.04u
M10737 n1268 U1589/net21 VSS VSS nmos W=0.27u L=0.04u
M10738 U1589/net21 n1270 VSS VSS nmos W=0.27u L=0.04u
M10739 n1268 U1589/net21 VDD VDD pmos W=0.41u L=0.04u
M10740 U1589/net21 n1270 VDD VDD pmos W=0.41u L=0.04u
M10741 n1267 U1590/net21 VSS VSS nmos W=0.27u L=0.04u
M10742 U1590/net21 n1270 VSS VSS nmos W=0.27u L=0.04u
M10743 n1267 U1590/net21 VDD VDD pmos W=0.41u L=0.04u
M10744 U1590/net21 n1270 VDD VDD pmos W=0.41u L=0.04u
M10745 n1294 U1591/net21 VSS VSS nmos W=0.27u L=0.04u
M10746 U1591/net21 n1301 VSS VSS nmos W=0.27u L=0.04u
M10747 n1294 U1591/net21 VDD VDD pmos W=0.41u L=0.04u
M10748 U1591/net21 n1301 VDD VDD pmos W=0.41u L=0.04u
M10749 n1296 U1592/net21 VSS VSS nmos W=0.27u L=0.04u
M10750 U1592/net21 n1301 VSS VSS nmos W=0.27u L=0.04u
M10751 n1296 U1592/net21 VDD VDD pmos W=0.41u L=0.04u
M10752 U1592/net21 n1301 VDD VDD pmos W=0.41u L=0.04u
M10753 n1264 U1593/net21 VSS VSS nmos W=0.27u L=0.04u
M10754 U1593/net21 n1271 VSS VSS nmos W=0.27u L=0.04u
M10755 n1264 U1593/net21 VDD VDD pmos W=0.41u L=0.04u
M10756 U1593/net21 n1271 VDD VDD pmos W=0.41u L=0.04u
M10757 n1295 U1594/net21 VSS VSS nmos W=0.27u L=0.04u
M10758 U1594/net21 n1301 VSS VSS nmos W=0.27u L=0.04u
M10759 n1295 U1594/net21 VDD VDD pmos W=0.41u L=0.04u
M10760 U1594/net21 n1301 VDD VDD pmos W=0.41u L=0.04u
M10761 n1355 U1595/net21 VSS VSS nmos W=0.27u L=0.04u
M10762 U1595/net21 n1365 VSS VSS nmos W=0.27u L=0.04u
M10763 n1355 U1595/net21 VDD VDD pmos W=0.41u L=0.04u
M10764 U1595/net21 n1365 VDD VDD pmos W=0.41u L=0.04u
M10765 n1356 U1596/net21 VSS VSS nmos W=0.27u L=0.04u
M10766 U1596/net21 n1365 VSS VSS nmos W=0.27u L=0.04u
M10767 n1356 U1596/net21 VDD VDD pmos W=0.41u L=0.04u
M10768 U1596/net21 n1365 VDD VDD pmos W=0.41u L=0.04u
M10769 n1262 U1597/net21 VSS VSS nmos W=0.27u L=0.04u
M10770 U1597/net21 n1272 VSS VSS nmos W=0.27u L=0.04u
M10771 n1262 U1597/net21 VDD VDD pmos W=0.41u L=0.04u
M10772 U1597/net21 n1272 VDD VDD pmos W=0.41u L=0.04u
M10773 n1263 U1598/net21 VSS VSS nmos W=0.27u L=0.04u
M10774 U1598/net21 n1272 VSS VSS nmos W=0.27u L=0.04u
M10775 n1263 U1598/net21 VDD VDD pmos W=0.41u L=0.04u
M10776 U1598/net21 n1272 VDD VDD pmos W=0.41u L=0.04u
M10777 n1329 U1599/net21 VSS VSS nmos W=0.27u L=0.04u
M10778 U1599/net21 n1330 VSS VSS nmos W=0.27u L=0.04u
M10779 n1329 U1599/net21 VDD VDD pmos W=0.41u L=0.04u
M10780 U1599/net21 n1330 VDD VDD pmos W=0.41u L=0.04u
M10781 n1299 U1600/net21 VSS VSS nmos W=0.27u L=0.04u
M10782 U1600/net21 n1300 VSS VSS nmos W=0.27u L=0.04u
M10783 n1299 U1600/net21 VDD VDD pmos W=0.41u L=0.04u
M10784 U1600/net21 n1300 VDD VDD pmos W=0.41u L=0.04u
M10785 n1372 U1601/net21 VSS VSS nmos W=0.27u L=0.04u
M10786 U1601/net21 n1383 VSS VSS nmos W=0.27u L=0.04u
M10787 n1372 U1601/net21 VDD VDD pmos W=0.41u L=0.04u
M10788 U1601/net21 n1383 VDD VDD pmos W=0.41u L=0.04u
M10789 n1373 U1602/net21 VSS VSS nmos W=0.27u L=0.04u
M10790 U1602/net21 n1383 VSS VSS nmos W=0.27u L=0.04u
M10791 n1373 U1602/net21 VDD VDD pmos W=0.41u L=0.04u
M10792 U1602/net21 n1383 VDD VDD pmos W=0.41u L=0.04u
M10793 n1374 U1603/net21 VSS VSS nmos W=0.27u L=0.04u
M10794 U1603/net21 n1383 VSS VSS nmos W=0.27u L=0.04u
M10795 n1374 U1603/net21 VDD VDD pmos W=0.41u L=0.04u
M10796 U1603/net21 n1383 VDD VDD pmos W=0.41u L=0.04u
M10797 n1375 U1604/net21 VSS VSS nmos W=0.27u L=0.04u
M10798 U1604/net21 n1382 VSS VSS nmos W=0.27u L=0.04u
M10799 n1375 U1604/net21 VDD VDD pmos W=0.41u L=0.04u
M10800 U1604/net21 n1382 VDD VDD pmos W=0.41u L=0.04u
M10801 n1376 U1605/net21 VSS VSS nmos W=0.27u L=0.04u
M10802 U1605/net21 n1382 VSS VSS nmos W=0.27u L=0.04u
M10803 n1376 U1605/net21 VDD VDD pmos W=0.41u L=0.04u
M10804 U1605/net21 n1382 VDD VDD pmos W=0.41u L=0.04u
M10805 n1377 U1606/net21 VSS VSS nmos W=0.27u L=0.04u
M10806 U1606/net21 n1382 VSS VSS nmos W=0.27u L=0.04u
M10807 n1377 U1606/net21 VDD VDD pmos W=0.41u L=0.04u
M10808 U1606/net21 n1382 VDD VDD pmos W=0.41u L=0.04u
M10809 n1378 U1607/net21 VSS VSS nmos W=0.27u L=0.04u
M10810 U1607/net21 n1381 VSS VSS nmos W=0.27u L=0.04u
M10811 n1378 U1607/net21 VDD VDD pmos W=0.41u L=0.04u
M10812 U1607/net21 n1381 VDD VDD pmos W=0.41u L=0.04u
M10813 n1379 U1608/net21 VSS VSS nmos W=0.27u L=0.04u
M10814 U1608/net21 n1381 VSS VSS nmos W=0.27u L=0.04u
M10815 n1379 U1608/net21 VDD VDD pmos W=0.41u L=0.04u
M10816 U1608/net21 n1381 VDD VDD pmos W=0.41u L=0.04u
M10817 n1240 U1609/net21 VSS VSS nmos W=0.27u L=0.04u
M10818 U1609/net21 n1269 VSS VSS nmos W=0.27u L=0.04u
M10819 n1240 U1609/net21 VDD VDD pmos W=0.41u L=0.04u
M10820 U1609/net21 n1269 VDD VDD pmos W=0.41u L=0.04u
M10821 n1269 U1610/net21 VSS VSS nmos W=0.27u L=0.04u
M10822 U1610/net21 n1270 VSS VSS nmos W=0.27u L=0.04u
M10823 n1269 U1610/net21 VDD VDD pmos W=0.41u L=0.04u
M10824 U1610/net21 n1270 VDD VDD pmos W=0.41u L=0.04u
M10825 n1369 U1611/net21 VSS VSS nmos W=0.27u L=0.04u
M10826 U1611/net21 n1384 VSS VSS nmos W=0.27u L=0.04u
M10827 n1369 U1611/net21 VDD VDD pmos W=0.41u L=0.04u
M10828 U1611/net21 n1384 VDD VDD pmos W=0.41u L=0.04u
M10829 n1370 U1612/net21 VSS VSS nmos W=0.27u L=0.04u
M10830 U1612/net21 n1384 VSS VSS nmos W=0.27u L=0.04u
M10831 n1370 U1612/net21 VDD VDD pmos W=0.41u L=0.04u
M10832 U1612/net21 n1384 VDD VDD pmos W=0.41u L=0.04u
M10833 n1371 U1613/net21 VSS VSS nmos W=0.27u L=0.04u
M10834 U1613/net21 n1384 VSS VSS nmos W=0.27u L=0.04u
M10835 n1371 U1613/net21 VDD VDD pmos W=0.41u L=0.04u
M10836 U1613/net21 n1384 VDD VDD pmos W=0.41u L=0.04u
M10837 n1333 U1614/net21 VSS VSS nmos W=0.27u L=0.04u
M10838 U1614/net21 n1362 VSS VSS nmos W=0.27u L=0.04u
M10839 n1333 U1614/net21 VDD VDD pmos W=0.41u L=0.04u
M10840 U1614/net21 n1362 VDD VDD pmos W=0.41u L=0.04u
M10841 n1362 U1615/net21 VSS VSS nmos W=0.27u L=0.04u
M10842 U1615/net21 n1363 VSS VSS nmos W=0.27u L=0.04u
M10843 n1362 U1615/net21 VDD VDD pmos W=0.41u L=0.04u
M10844 U1615/net21 n1363 VDD VDD pmos W=0.41u L=0.04u
M10845 n1290 U1616/net21 VSS VSS nmos W=0.27u L=0.04u
M10846 U1616/net21 n1293 VSS VSS nmos W=0.27u L=0.04u
M10847 n1290 U1616/net21 VDD VDD pmos W=0.41u L=0.04u
M10848 U1616/net21 n1293 VDD VDD pmos W=0.41u L=0.04u
M10849 n1291 U1617/net21 VSS VSS nmos W=0.27u L=0.04u
M10850 U1617/net21 n1293 VSS VSS nmos W=0.27u L=0.04u
M10851 n1291 U1617/net21 VDD VDD pmos W=0.41u L=0.04u
M10852 U1617/net21 n1293 VDD VDD pmos W=0.41u L=0.04u
M10853 n1321 U1618/net21 VSS VSS nmos W=0.27u L=0.04u
M10854 U1618/net21 n1323 VSS VSS nmos W=0.27u L=0.04u
M10855 n1321 U1618/net21 VDD VDD pmos W=0.41u L=0.04u
M10856 U1618/net21 n1323 VDD VDD pmos W=0.41u L=0.04u
M10857 n1320 U1619/net21 VSS VSS nmos W=0.27u L=0.04u
M10858 U1619/net21 n1323 VSS VSS nmos W=0.27u L=0.04u
M10859 n1320 U1619/net21 VDD VDD pmos W=0.41u L=0.04u
M10860 U1619/net21 n1323 VDD VDD pmos W=0.41u L=0.04u
M10861 n1322 U1620/net21 VSS VSS nmos W=0.27u L=0.04u
M10862 U1620/net21 n1323 VSS VSS nmos W=0.27u L=0.04u
M10863 n1322 U1620/net21 VDD VDD pmos W=0.41u L=0.04u
M10864 U1620/net21 n1323 VDD VDD pmos W=0.41u L=0.04u
M10865 n1380 U1621/net21 VSS VSS nmos W=0.27u L=0.04u
M10866 U1621/net21 n1381 VSS VSS nmos W=0.27u L=0.04u
M10867 n1380 U1621/net21 VDD VDD pmos W=0.41u L=0.04u
M10868 U1621/net21 n1381 VDD VDD pmos W=0.41u L=0.04u
M10869 n1292 U1622/net21 VSS VSS nmos W=0.27u L=0.04u
M10870 U1622/net21 n1293 VSS VSS nmos W=0.27u L=0.04u
M10871 n1292 U1622/net21 VDD VDD pmos W=0.41u L=0.04u
M10872 U1622/net21 n1293 VDD VDD pmos W=0.41u L=0.04u
M10873 n1331 U1623/net21 VSS VSS nmos W=0.27u L=0.04u
M10874 U1623/net21 n1403 VSS VSS nmos W=0.27u L=0.04u
M10875 n1331 U1623/net21 VDD VDD pmos W=0.41u L=0.04u
M10876 U1623/net21 n1403 VDD VDD pmos W=0.41u L=0.04u
M10877 n1330 U1624/net21 VSS VSS nmos W=0.27u L=0.04u
M10878 U1624/net21 n1403 VSS VSS nmos W=0.27u L=0.04u
M10879 n1330 U1624/net21 VDD VDD pmos W=0.41u L=0.04u
M10880 U1624/net21 n1403 VDD VDD pmos W=0.41u L=0.04u
M10881 n1300 U1625/net21 VSS VSS nmos W=0.27u L=0.04u
M10882 U1625/net21 n1401 VSS VSS nmos W=0.27u L=0.04u
M10883 n1300 U1625/net21 VDD VDD pmos W=0.41u L=0.04u
M10884 U1625/net21 n1401 VDD VDD pmos W=0.41u L=0.04u
M10885 n1301 U1626/net21 VSS VSS nmos W=0.27u L=0.04u
M10886 U1626/net21 n1401 VSS VSS nmos W=0.27u L=0.04u
M10887 n1301 U1626/net21 VDD VDD pmos W=0.41u L=0.04u
M10888 U1626/net21 n1401 VDD VDD pmos W=0.41u L=0.04u
M10889 n1363 U1627/net21 VSS VSS nmos W=0.27u L=0.04u
M10890 U1627/net21 n1404 VSS VSS nmos W=0.27u L=0.04u
M10891 n1363 U1627/net21 VDD VDD pmos W=0.41u L=0.04u
M10892 U1627/net21 n1404 VDD VDD pmos W=0.41u L=0.04u
M10893 n1364 U1628/net21 VSS VSS nmos W=0.27u L=0.04u
M10894 U1628/net21 n1404 VSS VSS nmos W=0.27u L=0.04u
M10895 n1364 U1628/net21 VDD VDD pmos W=0.41u L=0.04u
M10896 U1628/net21 n1404 VDD VDD pmos W=0.41u L=0.04u
M10897 n1270 U1629/net21 VSS VSS nmos W=0.27u L=0.04u
M10898 U1629/net21 n1399 VSS VSS nmos W=0.27u L=0.04u
M10899 n1270 U1629/net21 VDD VDD pmos W=0.41u L=0.04u
M10900 U1629/net21 n1399 VDD VDD pmos W=0.41u L=0.04u
M10901 n1271 U1630/net21 VSS VSS nmos W=0.27u L=0.04u
M10902 U1630/net21 n1399 VSS VSS nmos W=0.27u L=0.04u
M10903 n1271 U1630/net21 VDD VDD pmos W=0.41u L=0.04u
M10904 U1630/net21 n1399 VDD VDD pmos W=0.41u L=0.04u
M10905 n1383 U1631/net21 VSS VSS nmos W=0.27u L=0.04u
M10906 U1631/net21 n1366 VSS VSS nmos W=0.27u L=0.04u
M10907 n1383 U1631/net21 VDD VDD pmos W=0.41u L=0.04u
M10908 U1631/net21 n1366 VDD VDD pmos W=0.41u L=0.04u
M10909 n1382 U1632/net21 VSS VSS nmos W=0.27u L=0.04u
M10910 U1632/net21 n1366 VSS VSS nmos W=0.27u L=0.04u
M10911 n1382 U1632/net21 VDD VDD pmos W=0.41u L=0.04u
M10912 U1632/net21 n1366 VDD VDD pmos W=0.41u L=0.04u
M10913 n1381 U1633/net21 VSS VSS nmos W=0.27u L=0.04u
M10914 U1633/net21 n1366 VSS VSS nmos W=0.27u L=0.04u
M10915 n1381 U1633/net21 VDD VDD pmos W=0.41u L=0.04u
M10916 U1633/net21 n1366 VDD VDD pmos W=0.41u L=0.04u
M10917 n1384 U1634/net21 VSS VSS nmos W=0.27u L=0.04u
M10918 U1634/net21 n1367 VSS VSS nmos W=0.27u L=0.04u
M10919 n1384 U1634/net21 VDD VDD pmos W=0.41u L=0.04u
M10920 U1634/net21 n1367 VDD VDD pmos W=0.41u L=0.04u
M10921 n1323 U1635/net21 VSS VSS nmos W=0.27u L=0.04u
M10922 U1635/net21 n1332 VSS VSS nmos W=0.27u L=0.04u
M10923 n1323 U1635/net21 VDD VDD pmos W=0.41u L=0.04u
M10924 U1635/net21 n1332 VDD VDD pmos W=0.41u L=0.04u
M10925 n1332 U1636/net21 VSS VSS nmos W=0.27u L=0.04u
M10926 U1636/net21 n1403 VSS VSS nmos W=0.27u L=0.04u
M10927 n1332 U1636/net21 VDD VDD pmos W=0.41u L=0.04u
M10928 U1636/net21 n1403 VDD VDD pmos W=0.41u L=0.04u
M10929 n1293 U1637/net21 VSS VSS nmos W=0.27u L=0.04u
M10930 U1637/net21 n1302 VSS VSS nmos W=0.27u L=0.04u
M10931 n1293 U1637/net21 VDD VDD pmos W=0.41u L=0.04u
M10932 U1637/net21 n1302 VDD VDD pmos W=0.41u L=0.04u
M10933 n1302 U1638/net21 VSS VSS nmos W=0.27u L=0.04u
M10934 U1638/net21 n1401 VSS VSS nmos W=0.27u L=0.04u
M10935 n1302 U1638/net21 VDD VDD pmos W=0.41u L=0.04u
M10936 U1638/net21 n1401 VDD VDD pmos W=0.41u L=0.04u
M10937 n1365 U1639/net21 VSS VSS nmos W=0.27u L=0.04u
M10938 U1639/net21 n1404 VSS VSS nmos W=0.27u L=0.04u
M10939 n1365 U1639/net21 VDD VDD pmos W=0.41u L=0.04u
M10940 U1639/net21 n1404 VDD VDD pmos W=0.41u L=0.04u
M10941 n1272 U1640/net21 VSS VSS nmos W=0.27u L=0.04u
M10942 U1640/net21 n1399 VSS VSS nmos W=0.27u L=0.04u
M10943 n1272 U1640/net21 VDD VDD pmos W=0.41u L=0.04u
M10944 U1640/net21 n1399 VDD VDD pmos W=0.41u L=0.04u
M10945 n1368 U1641/net21 VSS VSS nmos W=0.27u L=0.04u
M10946 U1641/net21 n1385 VSS VSS nmos W=0.27u L=0.04u
M10947 n1368 U1641/net21 VDD VDD pmos W=0.41u L=0.04u
M10948 U1641/net21 n1385 VDD VDD pmos W=0.41u L=0.04u
M10949 n1385 U1642/net21 VSS VSS nmos W=0.27u L=0.04u
M10950 U1642/net21 n1367 VSS VSS nmos W=0.27u L=0.04u
M10951 n1385 U1642/net21 VDD VDD pmos W=0.41u L=0.04u
M10952 U1642/net21 n1367 VDD VDD pmos W=0.41u L=0.04u
M10953 n1366 U1643/net21 VSS VSS nmos W=0.27u L=0.04u
M10954 U1643/net21 n1555 VSS VSS nmos W=0.27u L=0.04u
M10955 n1366 U1643/net21 VDD VDD pmos W=0.41u L=0.04u
M10956 U1643/net21 n1555 VDD VDD pmos W=0.41u L=0.04u
M10957 n1367 U1644/net21 VSS VSS nmos W=0.27u L=0.04u
M10958 U1644/net21 n1555 VSS VSS nmos W=0.27u L=0.04u
M10959 n1367 U1644/net21 VDD VDD pmos W=0.41u L=0.04u
M10960 U1644/net21 n1555 VDD VDD pmos W=0.41u L=0.04u
M10961 U1645/net11 CRC_OUT_8_31 U1645/net17 VSS nmos W=0.155u L=0.04u
M10962 U1645/net5 U1645/net17 U1645/net21 VSS nmos W=0.155u L=0.04u
M10963 U1645/net5 CRC_OUT_8_15 VSS VSS nmos W=0.155u L=0.04u
M10964 n999 U1645/net21 VSS VSS nmos W=0.155u L=0.04u
M10965 U1645/net16 CRC_OUT_8_31 VSS VSS nmos W=0.155u L=0.04u
M10966 U1645/net11 WX2160 VSS VSS nmos W=0.155u L=0.04u
M10967 U1645/net13 U1645/net17 VSS VSS nmos W=0.155u L=0.04u
M10968 U1645/net17 U1645/net16 U1645/XI2-net16 VSS nmos W=0.155u L=0.04u
M10969 U1645/XI2-net16 U1645/net11 VSS VSS nmos W=0.155u L=0.04u
M10970 U1645/net21 U1645/net13 U1645/XU21-net16 VSS nmos W=0.155u L=0.04u
M10971 U1645/XU21-net16 U1645/net5 VSS VSS nmos W=0.155u L=0.04u
M10972 U1645/net11 U1645/net16 U1645/net17 VDD pmos W=0.205u L=0.04u
M10973 U1645/net5 U1645/net13 U1645/net21 VDD pmos W=0.205u L=0.04u
M10974 U1645/net5 CRC_OUT_8_15 VDD VDD pmos W=0.205u L=0.04u
M10975 n999 U1645/net21 VDD VDD pmos W=0.205u L=0.04u
M10976 U1645/net16 CRC_OUT_8_31 VDD VDD pmos W=0.205u L=0.04u
M10977 U1645/net11 WX2160 VDD VDD pmos W=0.205u L=0.04u
M10978 U1645/net13 U1645/net17 VDD VDD pmos W=0.205u L=0.04u
M10979 U1645/net17 CRC_OUT_8_31 U1645/XI2-net6 VDD pmos W=0.205u L=0.04u
M10980 U1645/XI2-net6 U1645/net11 VDD VDD pmos W=0.205u L=0.04u
M10981 U1645/net21 U1645/net17 U1645/XU21-net6 VDD pmos W=0.205u L=0.04u
M10982 U1645/XU21-net6 U1645/net5 VDD VDD pmos W=0.205u L=0.04u
M10983 U1646/net4 WX2158 U1646/net14 VSS nmos W=0.155u L=0.04u
M10984 U1646/net6 U1646/net10 U1646/net14 VSS nmos W=0.17u L=0.04u
M10985 U1646/net4 CRC_OUT_8_16 VSS VSS nmos W=0.155u L=0.04u
M10986 U1646/net6 U1646/net4 VSS VSS nmos W=0.17u L=0.04u
M10987 n998 U1646/net14 VSS VSS nmos W=0.155u L=0.04u
M10988 U1646/net10 WX2158 VSS VSS nmos W=0.155u L=0.04u
M10989 U1646/net4 U1646/net10 U1646/net14 VDD pmos W=0.255u L=0.04u
M10990 U1646/net6 WX2158 U1646/net14 VDD pmos W=0.28u L=0.04u
M10991 U1646/net4 CRC_OUT_8_16 VDD VDD pmos W=0.205u L=0.04u
M10992 U1646/net6 U1646/net4 VDD VDD pmos W=0.24u L=0.04u
M10993 n998 U1646/net14 VDD VDD pmos W=0.205u L=0.04u
M10994 U1646/net10 WX2158 VDD VDD pmos W=0.205u L=0.04u
M10995 U1647/net4 WX2156 U1647/net14 VSS nmos W=0.155u L=0.04u
M10996 U1647/net6 U1647/net10 U1647/net14 VSS nmos W=0.17u L=0.04u
M10997 U1647/net4 CRC_OUT_8_17 VSS VSS nmos W=0.155u L=0.04u
M10998 U1647/net6 U1647/net4 VSS VSS nmos W=0.17u L=0.04u
M10999 n997 U1647/net14 VSS VSS nmos W=0.155u L=0.04u
M11000 U1647/net10 WX2156 VSS VSS nmos W=0.155u L=0.04u
M11001 U1647/net4 U1647/net10 U1647/net14 VDD pmos W=0.255u L=0.04u
M11002 U1647/net6 WX2156 U1647/net14 VDD pmos W=0.28u L=0.04u
M11003 U1647/net4 CRC_OUT_8_17 VDD VDD pmos W=0.205u L=0.04u
M11004 U1647/net6 U1647/net4 VDD VDD pmos W=0.24u L=0.04u
M11005 n997 U1647/net14 VDD VDD pmos W=0.205u L=0.04u
M11006 U1647/net10 WX2156 VDD VDD pmos W=0.205u L=0.04u
M11007 U1648/net4 WX2154 U1648/net14 VSS nmos W=0.155u L=0.04u
M11008 U1648/net6 U1648/net10 U1648/net14 VSS nmos W=0.17u L=0.04u
M11009 U1648/net4 CRC_OUT_8_18 VSS VSS nmos W=0.155u L=0.04u
M11010 U1648/net6 U1648/net4 VSS VSS nmos W=0.17u L=0.04u
M11011 n996 U1648/net14 VSS VSS nmos W=0.155u L=0.04u
M11012 U1648/net10 WX2154 VSS VSS nmos W=0.155u L=0.04u
M11013 U1648/net4 U1648/net10 U1648/net14 VDD pmos W=0.255u L=0.04u
M11014 U1648/net6 WX2154 U1648/net14 VDD pmos W=0.28u L=0.04u
M11015 U1648/net4 CRC_OUT_8_18 VDD VDD pmos W=0.205u L=0.04u
M11016 U1648/net6 U1648/net4 VDD VDD pmos W=0.24u L=0.04u
M11017 n996 U1648/net14 VDD VDD pmos W=0.205u L=0.04u
M11018 U1648/net10 WX2154 VDD VDD pmos W=0.205u L=0.04u
M11019 U1649/net4 WX2152 U1649/net14 VSS nmos W=0.155u L=0.04u
M11020 U1649/net6 U1649/net10 U1649/net14 VSS nmos W=0.17u L=0.04u
M11021 U1649/net4 CRC_OUT_8_19 VSS VSS nmos W=0.155u L=0.04u
M11022 U1649/net6 U1649/net4 VSS VSS nmos W=0.17u L=0.04u
M11023 n995 U1649/net14 VSS VSS nmos W=0.155u L=0.04u
M11024 U1649/net10 WX2152 VSS VSS nmos W=0.155u L=0.04u
M11025 U1649/net4 U1649/net10 U1649/net14 VDD pmos W=0.255u L=0.04u
M11026 U1649/net6 WX2152 U1649/net14 VDD pmos W=0.28u L=0.04u
M11027 U1649/net4 CRC_OUT_8_19 VDD VDD pmos W=0.205u L=0.04u
M11028 U1649/net6 U1649/net4 VDD VDD pmos W=0.24u L=0.04u
M11029 n995 U1649/net14 VDD VDD pmos W=0.205u L=0.04u
M11030 U1649/net10 WX2152 VDD VDD pmos W=0.205u L=0.04u
M11031 U1650/net4 WX2150 U1650/net14 VSS nmos W=0.155u L=0.04u
M11032 U1650/net6 U1650/net10 U1650/net14 VSS nmos W=0.17u L=0.04u
M11033 U1650/net4 CRC_OUT_8_20 VSS VSS nmos W=0.155u L=0.04u
M11034 U1650/net6 U1650/net4 VSS VSS nmos W=0.17u L=0.04u
M11035 n994 U1650/net14 VSS VSS nmos W=0.155u L=0.04u
M11036 U1650/net10 WX2150 VSS VSS nmos W=0.155u L=0.04u
M11037 U1650/net4 U1650/net10 U1650/net14 VDD pmos W=0.255u L=0.04u
M11038 U1650/net6 WX2150 U1650/net14 VDD pmos W=0.28u L=0.04u
M11039 U1650/net4 CRC_OUT_8_20 VDD VDD pmos W=0.205u L=0.04u
M11040 U1650/net6 U1650/net4 VDD VDD pmos W=0.24u L=0.04u
M11041 n994 U1650/net14 VDD VDD pmos W=0.205u L=0.04u
M11042 U1650/net10 WX2150 VDD VDD pmos W=0.205u L=0.04u
M11043 U1651/net4 WX2148 U1651/net14 VSS nmos W=0.155u L=0.04u
M11044 U1651/net6 U1651/net10 U1651/net14 VSS nmos W=0.17u L=0.04u
M11045 U1651/net4 CRC_OUT_8_21 VSS VSS nmos W=0.155u L=0.04u
M11046 U1651/net6 U1651/net4 VSS VSS nmos W=0.17u L=0.04u
M11047 n993 U1651/net14 VSS VSS nmos W=0.155u L=0.04u
M11048 U1651/net10 WX2148 VSS VSS nmos W=0.155u L=0.04u
M11049 U1651/net4 U1651/net10 U1651/net14 VDD pmos W=0.255u L=0.04u
M11050 U1651/net6 WX2148 U1651/net14 VDD pmos W=0.28u L=0.04u
M11051 U1651/net4 CRC_OUT_8_21 VDD VDD pmos W=0.205u L=0.04u
M11052 U1651/net6 U1651/net4 VDD VDD pmos W=0.24u L=0.04u
M11053 n993 U1651/net14 VDD VDD pmos W=0.205u L=0.04u
M11054 U1651/net10 WX2148 VDD VDD pmos W=0.205u L=0.04u
M11055 U1652/net4 WX2146 U1652/net14 VSS nmos W=0.155u L=0.04u
M11056 U1652/net6 U1652/net10 U1652/net14 VSS nmos W=0.17u L=0.04u
M11057 U1652/net4 CRC_OUT_8_22 VSS VSS nmos W=0.155u L=0.04u
M11058 U1652/net6 U1652/net4 VSS VSS nmos W=0.17u L=0.04u
M11059 n992 U1652/net14 VSS VSS nmos W=0.155u L=0.04u
M11060 U1652/net10 WX2146 VSS VSS nmos W=0.155u L=0.04u
M11061 U1652/net4 U1652/net10 U1652/net14 VDD pmos W=0.255u L=0.04u
M11062 U1652/net6 WX2146 U1652/net14 VDD pmos W=0.28u L=0.04u
M11063 U1652/net4 CRC_OUT_8_22 VDD VDD pmos W=0.205u L=0.04u
M11064 U1652/net6 U1652/net4 VDD VDD pmos W=0.24u L=0.04u
M11065 n992 U1652/net14 VDD VDD pmos W=0.205u L=0.04u
M11066 U1652/net10 WX2146 VDD VDD pmos W=0.205u L=0.04u
M11067 U1653/net4 WX2144 U1653/net14 VSS nmos W=0.155u L=0.04u
M11068 U1653/net6 U1653/net10 U1653/net14 VSS nmos W=0.17u L=0.04u
M11069 U1653/net4 CRC_OUT_8_23 VSS VSS nmos W=0.155u L=0.04u
M11070 U1653/net6 U1653/net4 VSS VSS nmos W=0.17u L=0.04u
M11071 n991 U1653/net14 VSS VSS nmos W=0.155u L=0.04u
M11072 U1653/net10 WX2144 VSS VSS nmos W=0.155u L=0.04u
M11073 U1653/net4 U1653/net10 U1653/net14 VDD pmos W=0.255u L=0.04u
M11074 U1653/net6 WX2144 U1653/net14 VDD pmos W=0.28u L=0.04u
M11075 U1653/net4 CRC_OUT_8_23 VDD VDD pmos W=0.205u L=0.04u
M11076 U1653/net6 U1653/net4 VDD VDD pmos W=0.24u L=0.04u
M11077 n991 U1653/net14 VDD VDD pmos W=0.205u L=0.04u
M11078 U1653/net10 WX2144 VDD VDD pmos W=0.205u L=0.04u
M11079 U1654/net4 WX2142 U1654/net14 VSS nmos W=0.155u L=0.04u
M11080 U1654/net6 U1654/net10 U1654/net14 VSS nmos W=0.17u L=0.04u
M11081 U1654/net4 CRC_OUT_8_24 VSS VSS nmos W=0.155u L=0.04u
M11082 U1654/net6 U1654/net4 VSS VSS nmos W=0.17u L=0.04u
M11083 n990 U1654/net14 VSS VSS nmos W=0.155u L=0.04u
M11084 U1654/net10 WX2142 VSS VSS nmos W=0.155u L=0.04u
M11085 U1654/net4 U1654/net10 U1654/net14 VDD pmos W=0.255u L=0.04u
M11086 U1654/net6 WX2142 U1654/net14 VDD pmos W=0.28u L=0.04u
M11087 U1654/net4 CRC_OUT_8_24 VDD VDD pmos W=0.205u L=0.04u
M11088 U1654/net6 U1654/net4 VDD VDD pmos W=0.24u L=0.04u
M11089 n990 U1654/net14 VDD VDD pmos W=0.205u L=0.04u
M11090 U1654/net10 WX2142 VDD VDD pmos W=0.205u L=0.04u
M11091 U1655/net4 WX2140 U1655/net14 VSS nmos W=0.155u L=0.04u
M11092 U1655/net6 U1655/net10 U1655/net14 VSS nmos W=0.17u L=0.04u
M11093 U1655/net4 CRC_OUT_8_25 VSS VSS nmos W=0.155u L=0.04u
M11094 U1655/net6 U1655/net4 VSS VSS nmos W=0.17u L=0.04u
M11095 n989 U1655/net14 VSS VSS nmos W=0.155u L=0.04u
M11096 U1655/net10 WX2140 VSS VSS nmos W=0.155u L=0.04u
M11097 U1655/net4 U1655/net10 U1655/net14 VDD pmos W=0.255u L=0.04u
M11098 U1655/net6 WX2140 U1655/net14 VDD pmos W=0.28u L=0.04u
M11099 U1655/net4 CRC_OUT_8_25 VDD VDD pmos W=0.205u L=0.04u
M11100 U1655/net6 U1655/net4 VDD VDD pmos W=0.24u L=0.04u
M11101 n989 U1655/net14 VDD VDD pmos W=0.205u L=0.04u
M11102 U1655/net10 WX2140 VDD VDD pmos W=0.205u L=0.04u
M11103 U1656/net4 WX2138 U1656/net14 VSS nmos W=0.155u L=0.04u
M11104 U1656/net6 U1656/net10 U1656/net14 VSS nmos W=0.17u L=0.04u
M11105 U1656/net4 CRC_OUT_8_26 VSS VSS nmos W=0.155u L=0.04u
M11106 U1656/net6 U1656/net4 VSS VSS nmos W=0.17u L=0.04u
M11107 n988 U1656/net14 VSS VSS nmos W=0.155u L=0.04u
M11108 U1656/net10 WX2138 VSS VSS nmos W=0.155u L=0.04u
M11109 U1656/net4 U1656/net10 U1656/net14 VDD pmos W=0.255u L=0.04u
M11110 U1656/net6 WX2138 U1656/net14 VDD pmos W=0.28u L=0.04u
M11111 U1656/net4 CRC_OUT_8_26 VDD VDD pmos W=0.205u L=0.04u
M11112 U1656/net6 U1656/net4 VDD VDD pmos W=0.24u L=0.04u
M11113 n988 U1656/net14 VDD VDD pmos W=0.205u L=0.04u
M11114 U1656/net10 WX2138 VDD VDD pmos W=0.205u L=0.04u
M11115 U1657/net4 WX2136 U1657/net14 VSS nmos W=0.155u L=0.04u
M11116 U1657/net6 U1657/net10 U1657/net14 VSS nmos W=0.17u L=0.04u
M11117 U1657/net4 CRC_OUT_8_27 VSS VSS nmos W=0.155u L=0.04u
M11118 U1657/net6 U1657/net4 VSS VSS nmos W=0.17u L=0.04u
M11119 n987 U1657/net14 VSS VSS nmos W=0.155u L=0.04u
M11120 U1657/net10 WX2136 VSS VSS nmos W=0.155u L=0.04u
M11121 U1657/net4 U1657/net10 U1657/net14 VDD pmos W=0.255u L=0.04u
M11122 U1657/net6 WX2136 U1657/net14 VDD pmos W=0.28u L=0.04u
M11123 U1657/net4 CRC_OUT_8_27 VDD VDD pmos W=0.205u L=0.04u
M11124 U1657/net6 U1657/net4 VDD VDD pmos W=0.24u L=0.04u
M11125 n987 U1657/net14 VDD VDD pmos W=0.205u L=0.04u
M11126 U1657/net10 WX2136 VDD VDD pmos W=0.205u L=0.04u
M11127 U1658/net4 WX2134 U1658/net14 VSS nmos W=0.155u L=0.04u
M11128 U1658/net6 U1658/net10 U1658/net14 VSS nmos W=0.17u L=0.04u
M11129 U1658/net4 CRC_OUT_8_28 VSS VSS nmos W=0.155u L=0.04u
M11130 U1658/net6 U1658/net4 VSS VSS nmos W=0.17u L=0.04u
M11131 n986 U1658/net14 VSS VSS nmos W=0.155u L=0.04u
M11132 U1658/net10 WX2134 VSS VSS nmos W=0.155u L=0.04u
M11133 U1658/net4 U1658/net10 U1658/net14 VDD pmos W=0.255u L=0.04u
M11134 U1658/net6 WX2134 U1658/net14 VDD pmos W=0.28u L=0.04u
M11135 U1658/net4 CRC_OUT_8_28 VDD VDD pmos W=0.205u L=0.04u
M11136 U1658/net6 U1658/net4 VDD VDD pmos W=0.24u L=0.04u
M11137 n986 U1658/net14 VDD VDD pmos W=0.205u L=0.04u
M11138 U1658/net10 WX2134 VDD VDD pmos W=0.205u L=0.04u
M11139 U1659/net4 WX2132 U1659/net14 VSS nmos W=0.155u L=0.04u
M11140 U1659/net6 U1659/net10 U1659/net14 VSS nmos W=0.17u L=0.04u
M11141 U1659/net4 CRC_OUT_8_29 VSS VSS nmos W=0.155u L=0.04u
M11142 U1659/net6 U1659/net4 VSS VSS nmos W=0.17u L=0.04u
M11143 n985 U1659/net14 VSS VSS nmos W=0.155u L=0.04u
M11144 U1659/net10 WX2132 VSS VSS nmos W=0.155u L=0.04u
M11145 U1659/net4 U1659/net10 U1659/net14 VDD pmos W=0.255u L=0.04u
M11146 U1659/net6 WX2132 U1659/net14 VDD pmos W=0.28u L=0.04u
M11147 U1659/net4 CRC_OUT_8_29 VDD VDD pmos W=0.205u L=0.04u
M11148 U1659/net6 U1659/net4 VDD VDD pmos W=0.24u L=0.04u
M11149 n985 U1659/net14 VDD VDD pmos W=0.205u L=0.04u
M11150 U1659/net10 WX2132 VDD VDD pmos W=0.205u L=0.04u
M11151 U1660/net4 WX2130 U1660/net14 VSS nmos W=0.155u L=0.04u
M11152 U1660/net6 U1660/net10 U1660/net14 VSS nmos W=0.17u L=0.04u
M11153 U1660/net4 CRC_OUT_8_30 VSS VSS nmos W=0.155u L=0.04u
M11154 U1660/net6 U1660/net4 VSS VSS nmos W=0.17u L=0.04u
M11155 n984 U1660/net14 VSS VSS nmos W=0.155u L=0.04u
M11156 U1660/net10 WX2130 VSS VSS nmos W=0.155u L=0.04u
M11157 U1660/net4 U1660/net10 U1660/net14 VDD pmos W=0.255u L=0.04u
M11158 U1660/net6 WX2130 U1660/net14 VDD pmos W=0.28u L=0.04u
M11159 U1660/net4 CRC_OUT_8_30 VDD VDD pmos W=0.205u L=0.04u
M11160 U1660/net6 U1660/net4 VDD VDD pmos W=0.24u L=0.04u
M11161 n984 U1660/net14 VDD VDD pmos W=0.205u L=0.04u
M11162 U1660/net10 WX2130 VDD VDD pmos W=0.205u L=0.04u
M11163 U1661/net4 CRC_OUT_9_31 U1661/net14 VSS nmos W=0.155u L=0.04u
M11164 U1661/net6 U1661/net10 U1661/net14 VSS nmos W=0.17u L=0.04u
M11165 U1661/net4 WX899 VSS VSS nmos W=0.155u L=0.04u
M11166 U1661/net6 U1661/net4 VSS VSS nmos W=0.17u L=0.04u
M11167 n983 U1661/net14 VSS VSS nmos W=0.155u L=0.04u
M11168 U1661/net10 CRC_OUT_9_31 VSS VSS nmos W=0.155u L=0.04u
M11169 U1661/net4 U1661/net10 U1661/net14 VDD pmos W=0.255u L=0.04u
M11170 U1661/net6 CRC_OUT_9_31 U1661/net14 VDD pmos W=0.28u L=0.04u
M11171 U1661/net4 WX899 VDD VDD pmos W=0.205u L=0.04u
M11172 U1661/net6 U1661/net4 VDD VDD pmos W=0.24u L=0.04u
M11173 n983 U1661/net14 VDD VDD pmos W=0.205u L=0.04u
M11174 U1661/net10 CRC_OUT_9_31 VDD VDD pmos W=0.205u L=0.04u
M11175 U1662/net4 WX897 U1662/net14 VSS nmos W=0.155u L=0.04u
M11176 U1662/net6 U1662/net10 U1662/net14 VSS nmos W=0.17u L=0.04u
M11177 U1662/net4 CRC_OUT_9_0 VSS VSS nmos W=0.155u L=0.04u
M11178 U1662/net6 U1662/net4 VSS VSS nmos W=0.17u L=0.04u
M11179 n982 U1662/net14 VSS VSS nmos W=0.155u L=0.04u
M11180 U1662/net10 WX897 VSS VSS nmos W=0.155u L=0.04u
M11181 U1662/net4 U1662/net10 U1662/net14 VDD pmos W=0.255u L=0.04u
M11182 U1662/net6 WX897 U1662/net14 VDD pmos W=0.28u L=0.04u
M11183 U1662/net4 CRC_OUT_9_0 VDD VDD pmos W=0.205u L=0.04u
M11184 U1662/net6 U1662/net4 VDD VDD pmos W=0.24u L=0.04u
M11185 n982 U1662/net14 VDD VDD pmos W=0.205u L=0.04u
M11186 U1662/net10 WX897 VDD VDD pmos W=0.205u L=0.04u
M11187 U1663/net4 WX895 U1663/net14 VSS nmos W=0.155u L=0.04u
M11188 U1663/net6 U1663/net10 U1663/net14 VSS nmos W=0.17u L=0.04u
M11189 U1663/net4 CRC_OUT_9_1 VSS VSS nmos W=0.155u L=0.04u
M11190 U1663/net6 U1663/net4 VSS VSS nmos W=0.17u L=0.04u
M11191 n981 U1663/net14 VSS VSS nmos W=0.155u L=0.04u
M11192 U1663/net10 WX895 VSS VSS nmos W=0.155u L=0.04u
M11193 U1663/net4 U1663/net10 U1663/net14 VDD pmos W=0.255u L=0.04u
M11194 U1663/net6 WX895 U1663/net14 VDD pmos W=0.28u L=0.04u
M11195 U1663/net4 CRC_OUT_9_1 VDD VDD pmos W=0.205u L=0.04u
M11196 U1663/net6 U1663/net4 VDD VDD pmos W=0.24u L=0.04u
M11197 n981 U1663/net14 VDD VDD pmos W=0.205u L=0.04u
M11198 U1663/net10 WX895 VDD VDD pmos W=0.205u L=0.04u
M11199 U1664/net4 WX893 U1664/net14 VSS nmos W=0.155u L=0.04u
M11200 U1664/net6 U1664/net10 U1664/net14 VSS nmos W=0.17u L=0.04u
M11201 U1664/net4 CRC_OUT_9_2 VSS VSS nmos W=0.155u L=0.04u
M11202 U1664/net6 U1664/net4 VSS VSS nmos W=0.17u L=0.04u
M11203 n980 U1664/net14 VSS VSS nmos W=0.155u L=0.04u
M11204 U1664/net10 WX893 VSS VSS nmos W=0.155u L=0.04u
M11205 U1664/net4 U1664/net10 U1664/net14 VDD pmos W=0.255u L=0.04u
M11206 U1664/net6 WX893 U1664/net14 VDD pmos W=0.28u L=0.04u
M11207 U1664/net4 CRC_OUT_9_2 VDD VDD pmos W=0.205u L=0.04u
M11208 U1664/net6 U1664/net4 VDD VDD pmos W=0.24u L=0.04u
M11209 n980 U1664/net14 VDD VDD pmos W=0.205u L=0.04u
M11210 U1664/net10 WX893 VDD VDD pmos W=0.205u L=0.04u
M11211 U1665/net11 CRC_OUT_9_31 U1665/net17 VSS nmos W=0.155u L=0.04u
M11212 U1665/net5 U1665/net17 U1665/net21 VSS nmos W=0.155u L=0.04u
M11213 U1665/net5 CRC_OUT_9_3 VSS VSS nmos W=0.155u L=0.04u
M11214 n979 U1665/net21 VSS VSS nmos W=0.155u L=0.04u
M11215 U1665/net16 CRC_OUT_9_31 VSS VSS nmos W=0.155u L=0.04u
M11216 U1665/net11 WX891 VSS VSS nmos W=0.155u L=0.04u
M11217 U1665/net13 U1665/net17 VSS VSS nmos W=0.155u L=0.04u
M11218 U1665/net17 U1665/net16 U1665/XI2-net16 VSS nmos W=0.155u L=0.04u
M11219 U1665/XI2-net16 U1665/net11 VSS VSS nmos W=0.155u L=0.04u
M11220 U1665/net21 U1665/net13 U1665/XU21-net16 VSS nmos W=0.155u L=0.04u
M11221 U1665/XU21-net16 U1665/net5 VSS VSS nmos W=0.155u L=0.04u
M11222 U1665/net11 U1665/net16 U1665/net17 VDD pmos W=0.205u L=0.04u
M11223 U1665/net5 U1665/net13 U1665/net21 VDD pmos W=0.205u L=0.04u
M11224 U1665/net5 CRC_OUT_9_3 VDD VDD pmos W=0.205u L=0.04u
M11225 n979 U1665/net21 VDD VDD pmos W=0.205u L=0.04u
M11226 U1665/net16 CRC_OUT_9_31 VDD VDD pmos W=0.205u L=0.04u
M11227 U1665/net11 WX891 VDD VDD pmos W=0.205u L=0.04u
M11228 U1665/net13 U1665/net17 VDD VDD pmos W=0.205u L=0.04u
M11229 U1665/net17 CRC_OUT_9_31 U1665/XI2-net6 VDD pmos W=0.205u L=0.04u
M11230 U1665/XI2-net6 U1665/net11 VDD VDD pmos W=0.205u L=0.04u
M11231 U1665/net21 U1665/net17 U1665/XU21-net6 VDD pmos W=0.205u L=0.04u
M11232 U1665/XU21-net6 U1665/net5 VDD VDD pmos W=0.205u L=0.04u
M11233 U1666/net4 WX889 U1666/net14 VSS nmos W=0.155u L=0.04u
M11234 U1666/net6 U1666/net10 U1666/net14 VSS nmos W=0.17u L=0.04u
M11235 U1666/net4 CRC_OUT_9_4 VSS VSS nmos W=0.155u L=0.04u
M11236 U1666/net6 U1666/net4 VSS VSS nmos W=0.17u L=0.04u
M11237 n978 U1666/net14 VSS VSS nmos W=0.155u L=0.04u
M11238 U1666/net10 WX889 VSS VSS nmos W=0.155u L=0.04u
M11239 U1666/net4 U1666/net10 U1666/net14 VDD pmos W=0.255u L=0.04u
M11240 U1666/net6 WX889 U1666/net14 VDD pmos W=0.28u L=0.04u
M11241 U1666/net4 CRC_OUT_9_4 VDD VDD pmos W=0.205u L=0.04u
M11242 U1666/net6 U1666/net4 VDD VDD pmos W=0.24u L=0.04u
M11243 n978 U1666/net14 VDD VDD pmos W=0.205u L=0.04u
M11244 U1666/net10 WX889 VDD VDD pmos W=0.205u L=0.04u
M11245 U1667/net4 WX887 U1667/net14 VSS nmos W=0.155u L=0.04u
M11246 U1667/net6 U1667/net10 U1667/net14 VSS nmos W=0.17u L=0.04u
M11247 U1667/net4 CRC_OUT_9_5 VSS VSS nmos W=0.155u L=0.04u
M11248 U1667/net6 U1667/net4 VSS VSS nmos W=0.17u L=0.04u
M11249 n977 U1667/net14 VSS VSS nmos W=0.155u L=0.04u
M11250 U1667/net10 WX887 VSS VSS nmos W=0.155u L=0.04u
M11251 U1667/net4 U1667/net10 U1667/net14 VDD pmos W=0.255u L=0.04u
M11252 U1667/net6 WX887 U1667/net14 VDD pmos W=0.28u L=0.04u
M11253 U1667/net4 CRC_OUT_9_5 VDD VDD pmos W=0.205u L=0.04u
M11254 U1667/net6 U1667/net4 VDD VDD pmos W=0.24u L=0.04u
M11255 n977 U1667/net14 VDD VDD pmos W=0.205u L=0.04u
M11256 U1667/net10 WX887 VDD VDD pmos W=0.205u L=0.04u
M11257 U1668/net4 WX885 U1668/net14 VSS nmos W=0.155u L=0.04u
M11258 U1668/net6 U1668/net10 U1668/net14 VSS nmos W=0.17u L=0.04u
M11259 U1668/net4 CRC_OUT_9_6 VSS VSS nmos W=0.155u L=0.04u
M11260 U1668/net6 U1668/net4 VSS VSS nmos W=0.17u L=0.04u
M11261 n976 U1668/net14 VSS VSS nmos W=0.155u L=0.04u
M11262 U1668/net10 WX885 VSS VSS nmos W=0.155u L=0.04u
M11263 U1668/net4 U1668/net10 U1668/net14 VDD pmos W=0.255u L=0.04u
M11264 U1668/net6 WX885 U1668/net14 VDD pmos W=0.28u L=0.04u
M11265 U1668/net4 CRC_OUT_9_6 VDD VDD pmos W=0.205u L=0.04u
M11266 U1668/net6 U1668/net4 VDD VDD pmos W=0.24u L=0.04u
M11267 n976 U1668/net14 VDD VDD pmos W=0.205u L=0.04u
M11268 U1668/net10 WX885 VDD VDD pmos W=0.205u L=0.04u
M11269 U1669/net4 WX883 U1669/net14 VSS nmos W=0.155u L=0.04u
M11270 U1669/net6 U1669/net10 U1669/net14 VSS nmos W=0.17u L=0.04u
M11271 U1669/net4 CRC_OUT_9_7 VSS VSS nmos W=0.155u L=0.04u
M11272 U1669/net6 U1669/net4 VSS VSS nmos W=0.17u L=0.04u
M11273 n975 U1669/net14 VSS VSS nmos W=0.155u L=0.04u
M11274 U1669/net10 WX883 VSS VSS nmos W=0.155u L=0.04u
M11275 U1669/net4 U1669/net10 U1669/net14 VDD pmos W=0.255u L=0.04u
M11276 U1669/net6 WX883 U1669/net14 VDD pmos W=0.28u L=0.04u
M11277 U1669/net4 CRC_OUT_9_7 VDD VDD pmos W=0.205u L=0.04u
M11278 U1669/net6 U1669/net4 VDD VDD pmos W=0.24u L=0.04u
M11279 n975 U1669/net14 VDD VDD pmos W=0.205u L=0.04u
M11280 U1669/net10 WX883 VDD VDD pmos W=0.205u L=0.04u
M11281 U1670/net4 WX881 U1670/net14 VSS nmos W=0.155u L=0.04u
M11282 U1670/net6 U1670/net10 U1670/net14 VSS nmos W=0.17u L=0.04u
M11283 U1670/net4 CRC_OUT_9_8 VSS VSS nmos W=0.155u L=0.04u
M11284 U1670/net6 U1670/net4 VSS VSS nmos W=0.17u L=0.04u
M11285 n974 U1670/net14 VSS VSS nmos W=0.155u L=0.04u
M11286 U1670/net10 WX881 VSS VSS nmos W=0.155u L=0.04u
M11287 U1670/net4 U1670/net10 U1670/net14 VDD pmos W=0.255u L=0.04u
M11288 U1670/net6 WX881 U1670/net14 VDD pmos W=0.28u L=0.04u
M11289 U1670/net4 CRC_OUT_9_8 VDD VDD pmos W=0.205u L=0.04u
M11290 U1670/net6 U1670/net4 VDD VDD pmos W=0.24u L=0.04u
M11291 n974 U1670/net14 VDD VDD pmos W=0.205u L=0.04u
M11292 U1670/net10 WX881 VDD VDD pmos W=0.205u L=0.04u
M11293 U1671/net4 WX879 U1671/net14 VSS nmos W=0.155u L=0.04u
M11294 U1671/net6 U1671/net10 U1671/net14 VSS nmos W=0.17u L=0.04u
M11295 U1671/net4 CRC_OUT_9_9 VSS VSS nmos W=0.155u L=0.04u
M11296 U1671/net6 U1671/net4 VSS VSS nmos W=0.17u L=0.04u
M11297 n973 U1671/net14 VSS VSS nmos W=0.155u L=0.04u
M11298 U1671/net10 WX879 VSS VSS nmos W=0.155u L=0.04u
M11299 U1671/net4 U1671/net10 U1671/net14 VDD pmos W=0.255u L=0.04u
M11300 U1671/net6 WX879 U1671/net14 VDD pmos W=0.28u L=0.04u
M11301 U1671/net4 CRC_OUT_9_9 VDD VDD pmos W=0.205u L=0.04u
M11302 U1671/net6 U1671/net4 VDD VDD pmos W=0.24u L=0.04u
M11303 n973 U1671/net14 VDD VDD pmos W=0.205u L=0.04u
M11304 U1671/net10 WX879 VDD VDD pmos W=0.205u L=0.04u
M11305 U1672/net11 CRC_OUT_9_31 U1672/net17 VSS nmos W=0.155u L=0.04u
M11306 U1672/net5 U1672/net17 U1672/net21 VSS nmos W=0.155u L=0.04u
M11307 U1672/net5 CRC_OUT_9_10 VSS VSS nmos W=0.155u L=0.04u
M11308 n972 U1672/net21 VSS VSS nmos W=0.155u L=0.04u
M11309 U1672/net16 CRC_OUT_9_31 VSS VSS nmos W=0.155u L=0.04u
M11310 U1672/net11 WX877 VSS VSS nmos W=0.155u L=0.04u
M11311 U1672/net13 U1672/net17 VSS VSS nmos W=0.155u L=0.04u
M11312 U1672/net17 U1672/net16 U1672/XI2-net16 VSS nmos W=0.155u L=0.04u
M11313 U1672/XI2-net16 U1672/net11 VSS VSS nmos W=0.155u L=0.04u
M11314 U1672/net21 U1672/net13 U1672/XU21-net16 VSS nmos W=0.155u L=0.04u
M11315 U1672/XU21-net16 U1672/net5 VSS VSS nmos W=0.155u L=0.04u
M11316 U1672/net11 U1672/net16 U1672/net17 VDD pmos W=0.205u L=0.04u
M11317 U1672/net5 U1672/net13 U1672/net21 VDD pmos W=0.205u L=0.04u
M11318 U1672/net5 CRC_OUT_9_10 VDD VDD pmos W=0.205u L=0.04u
M11319 n972 U1672/net21 VDD VDD pmos W=0.205u L=0.04u
M11320 U1672/net16 CRC_OUT_9_31 VDD VDD pmos W=0.205u L=0.04u
M11321 U1672/net11 WX877 VDD VDD pmos W=0.205u L=0.04u
M11322 U1672/net13 U1672/net17 VDD VDD pmos W=0.205u L=0.04u
M11323 U1672/net17 CRC_OUT_9_31 U1672/XI2-net6 VDD pmos W=0.205u L=0.04u
M11324 U1672/XI2-net6 U1672/net11 VDD VDD pmos W=0.205u L=0.04u
M11325 U1672/net21 U1672/net17 U1672/XU21-net6 VDD pmos W=0.205u L=0.04u
M11326 U1672/XU21-net6 U1672/net5 VDD VDD pmos W=0.205u L=0.04u
M11327 U1673/net4 WX875 U1673/net14 VSS nmos W=0.155u L=0.04u
M11328 U1673/net6 U1673/net10 U1673/net14 VSS nmos W=0.17u L=0.04u
M11329 U1673/net4 CRC_OUT_9_11 VSS VSS nmos W=0.155u L=0.04u
M11330 U1673/net6 U1673/net4 VSS VSS nmos W=0.17u L=0.04u
M11331 n971 U1673/net14 VSS VSS nmos W=0.155u L=0.04u
M11332 U1673/net10 WX875 VSS VSS nmos W=0.155u L=0.04u
M11333 U1673/net4 U1673/net10 U1673/net14 VDD pmos W=0.255u L=0.04u
M11334 U1673/net6 WX875 U1673/net14 VDD pmos W=0.28u L=0.04u
M11335 U1673/net4 CRC_OUT_9_11 VDD VDD pmos W=0.205u L=0.04u
M11336 U1673/net6 U1673/net4 VDD VDD pmos W=0.24u L=0.04u
M11337 n971 U1673/net14 VDD VDD pmos W=0.205u L=0.04u
M11338 U1673/net10 WX875 VDD VDD pmos W=0.205u L=0.04u
M11339 U1674/net4 WX873 U1674/net14 VSS nmos W=0.155u L=0.04u
M11340 U1674/net6 U1674/net10 U1674/net14 VSS nmos W=0.17u L=0.04u
M11341 U1674/net4 CRC_OUT_9_12 VSS VSS nmos W=0.155u L=0.04u
M11342 U1674/net6 U1674/net4 VSS VSS nmos W=0.17u L=0.04u
M11343 n970 U1674/net14 VSS VSS nmos W=0.155u L=0.04u
M11344 U1674/net10 WX873 VSS VSS nmos W=0.155u L=0.04u
M11345 U1674/net4 U1674/net10 U1674/net14 VDD pmos W=0.255u L=0.04u
M11346 U1674/net6 WX873 U1674/net14 VDD pmos W=0.28u L=0.04u
M11347 U1674/net4 CRC_OUT_9_12 VDD VDD pmos W=0.205u L=0.04u
M11348 U1674/net6 U1674/net4 VDD VDD pmos W=0.24u L=0.04u
M11349 n970 U1674/net14 VDD VDD pmos W=0.205u L=0.04u
M11350 U1674/net10 WX873 VDD VDD pmos W=0.205u L=0.04u
M11351 U1675/net4 WX871 U1675/net14 VSS nmos W=0.155u L=0.04u
M11352 U1675/net6 U1675/net10 U1675/net14 VSS nmos W=0.17u L=0.04u
M11353 U1675/net4 CRC_OUT_9_13 VSS VSS nmos W=0.155u L=0.04u
M11354 U1675/net6 U1675/net4 VSS VSS nmos W=0.17u L=0.04u
M11355 n969 U1675/net14 VSS VSS nmos W=0.155u L=0.04u
M11356 U1675/net10 WX871 VSS VSS nmos W=0.155u L=0.04u
M11357 U1675/net4 U1675/net10 U1675/net14 VDD pmos W=0.255u L=0.04u
M11358 U1675/net6 WX871 U1675/net14 VDD pmos W=0.28u L=0.04u
M11359 U1675/net4 CRC_OUT_9_13 VDD VDD pmos W=0.205u L=0.04u
M11360 U1675/net6 U1675/net4 VDD VDD pmos W=0.24u L=0.04u
M11361 n969 U1675/net14 VDD VDD pmos W=0.205u L=0.04u
M11362 U1675/net10 WX871 VDD VDD pmos W=0.205u L=0.04u
M11363 U1676/net4 WX869 U1676/net14 VSS nmos W=0.155u L=0.04u
M11364 U1676/net6 U1676/net10 U1676/net14 VSS nmos W=0.17u L=0.04u
M11365 U1676/net4 CRC_OUT_9_14 VSS VSS nmos W=0.155u L=0.04u
M11366 U1676/net6 U1676/net4 VSS VSS nmos W=0.17u L=0.04u
M11367 n968 U1676/net14 VSS VSS nmos W=0.155u L=0.04u
M11368 U1676/net10 WX869 VSS VSS nmos W=0.155u L=0.04u
M11369 U1676/net4 U1676/net10 U1676/net14 VDD pmos W=0.255u L=0.04u
M11370 U1676/net6 WX869 U1676/net14 VDD pmos W=0.28u L=0.04u
M11371 U1676/net4 CRC_OUT_9_14 VDD VDD pmos W=0.205u L=0.04u
M11372 U1676/net6 U1676/net4 VDD VDD pmos W=0.24u L=0.04u
M11373 n968 U1676/net14 VDD VDD pmos W=0.205u L=0.04u
M11374 U1676/net10 WX869 VDD VDD pmos W=0.205u L=0.04u
M11375 U1677/net11 CRC_OUT_9_31 U1677/net17 VSS nmos W=0.155u L=0.04u
M11376 U1677/net5 U1677/net17 U1677/net21 VSS nmos W=0.155u L=0.04u
M11377 U1677/net5 CRC_OUT_9_15 VSS VSS nmos W=0.155u L=0.04u
M11378 n967 U1677/net21 VSS VSS nmos W=0.155u L=0.04u
M11379 U1677/net16 CRC_OUT_9_31 VSS VSS nmos W=0.155u L=0.04u
M11380 U1677/net11 WX867 VSS VSS nmos W=0.155u L=0.04u
M11381 U1677/net13 U1677/net17 VSS VSS nmos W=0.155u L=0.04u
M11382 U1677/net17 U1677/net16 U1677/XI2-net16 VSS nmos W=0.155u L=0.04u
M11383 U1677/XI2-net16 U1677/net11 VSS VSS nmos W=0.155u L=0.04u
M11384 U1677/net21 U1677/net13 U1677/XU21-net16 VSS nmos W=0.155u L=0.04u
M11385 U1677/XU21-net16 U1677/net5 VSS VSS nmos W=0.155u L=0.04u
M11386 U1677/net11 U1677/net16 U1677/net17 VDD pmos W=0.205u L=0.04u
M11387 U1677/net5 U1677/net13 U1677/net21 VDD pmos W=0.205u L=0.04u
M11388 U1677/net5 CRC_OUT_9_15 VDD VDD pmos W=0.205u L=0.04u
M11389 n967 U1677/net21 VDD VDD pmos W=0.205u L=0.04u
M11390 U1677/net16 CRC_OUT_9_31 VDD VDD pmos W=0.205u L=0.04u
M11391 U1677/net11 WX867 VDD VDD pmos W=0.205u L=0.04u
M11392 U1677/net13 U1677/net17 VDD VDD pmos W=0.205u L=0.04u
M11393 U1677/net17 CRC_OUT_9_31 U1677/XI2-net6 VDD pmos W=0.205u L=0.04u
M11394 U1677/XI2-net6 U1677/net11 VDD VDD pmos W=0.205u L=0.04u
M11395 U1677/net21 U1677/net17 U1677/XU21-net6 VDD pmos W=0.205u L=0.04u
M11396 U1677/XU21-net6 U1677/net5 VDD VDD pmos W=0.205u L=0.04u
M11397 U1678/net4 WX865 U1678/net14 VSS nmos W=0.155u L=0.04u
M11398 U1678/net6 U1678/net10 U1678/net14 VSS nmos W=0.17u L=0.04u
M11399 U1678/net4 CRC_OUT_9_16 VSS VSS nmos W=0.155u L=0.04u
M11400 U1678/net6 U1678/net4 VSS VSS nmos W=0.17u L=0.04u
M11401 n966 U1678/net14 VSS VSS nmos W=0.155u L=0.04u
M11402 U1678/net10 WX865 VSS VSS nmos W=0.155u L=0.04u
M11403 U1678/net4 U1678/net10 U1678/net14 VDD pmos W=0.255u L=0.04u
M11404 U1678/net6 WX865 U1678/net14 VDD pmos W=0.28u L=0.04u
M11405 U1678/net4 CRC_OUT_9_16 VDD VDD pmos W=0.205u L=0.04u
M11406 U1678/net6 U1678/net4 VDD VDD pmos W=0.24u L=0.04u
M11407 n966 U1678/net14 VDD VDD pmos W=0.205u L=0.04u
M11408 U1678/net10 WX865 VDD VDD pmos W=0.205u L=0.04u
M11409 U1679/net4 WX863 U1679/net14 VSS nmos W=0.155u L=0.04u
M11410 U1679/net6 U1679/net10 U1679/net14 VSS nmos W=0.17u L=0.04u
M11411 U1679/net4 CRC_OUT_9_17 VSS VSS nmos W=0.155u L=0.04u
M11412 U1679/net6 U1679/net4 VSS VSS nmos W=0.17u L=0.04u
M11413 n965 U1679/net14 VSS VSS nmos W=0.155u L=0.04u
M11414 U1679/net10 WX863 VSS VSS nmos W=0.155u L=0.04u
M11415 U1679/net4 U1679/net10 U1679/net14 VDD pmos W=0.255u L=0.04u
M11416 U1679/net6 WX863 U1679/net14 VDD pmos W=0.28u L=0.04u
M11417 U1679/net4 CRC_OUT_9_17 VDD VDD pmos W=0.205u L=0.04u
M11418 U1679/net6 U1679/net4 VDD VDD pmos W=0.24u L=0.04u
M11419 n965 U1679/net14 VDD VDD pmos W=0.205u L=0.04u
M11420 U1679/net10 WX863 VDD VDD pmos W=0.205u L=0.04u
M11421 U1680/net4 WX861 U1680/net14 VSS nmos W=0.155u L=0.04u
M11422 U1680/net6 U1680/net10 U1680/net14 VSS nmos W=0.17u L=0.04u
M11423 U1680/net4 CRC_OUT_9_18 VSS VSS nmos W=0.155u L=0.04u
M11424 U1680/net6 U1680/net4 VSS VSS nmos W=0.17u L=0.04u
M11425 n964 U1680/net14 VSS VSS nmos W=0.155u L=0.04u
M11426 U1680/net10 WX861 VSS VSS nmos W=0.155u L=0.04u
M11427 U1680/net4 U1680/net10 U1680/net14 VDD pmos W=0.255u L=0.04u
M11428 U1680/net6 WX861 U1680/net14 VDD pmos W=0.28u L=0.04u
M11429 U1680/net4 CRC_OUT_9_18 VDD VDD pmos W=0.205u L=0.04u
M11430 U1680/net6 U1680/net4 VDD VDD pmos W=0.24u L=0.04u
M11431 n964 U1680/net14 VDD VDD pmos W=0.205u L=0.04u
M11432 U1680/net10 WX861 VDD VDD pmos W=0.205u L=0.04u
M11433 U1681/net4 WX859 U1681/net14 VSS nmos W=0.155u L=0.04u
M11434 U1681/net6 U1681/net10 U1681/net14 VSS nmos W=0.17u L=0.04u
M11435 U1681/net4 CRC_OUT_9_19 VSS VSS nmos W=0.155u L=0.04u
M11436 U1681/net6 U1681/net4 VSS VSS nmos W=0.17u L=0.04u
M11437 n963 U1681/net14 VSS VSS nmos W=0.155u L=0.04u
M11438 U1681/net10 WX859 VSS VSS nmos W=0.155u L=0.04u
M11439 U1681/net4 U1681/net10 U1681/net14 VDD pmos W=0.255u L=0.04u
M11440 U1681/net6 WX859 U1681/net14 VDD pmos W=0.28u L=0.04u
M11441 U1681/net4 CRC_OUT_9_19 VDD VDD pmos W=0.205u L=0.04u
M11442 U1681/net6 U1681/net4 VDD VDD pmos W=0.24u L=0.04u
M11443 n963 U1681/net14 VDD VDD pmos W=0.205u L=0.04u
M11444 U1681/net10 WX859 VDD VDD pmos W=0.205u L=0.04u
M11445 U1682/net4 WX857 U1682/net14 VSS nmos W=0.155u L=0.04u
M11446 U1682/net6 U1682/net10 U1682/net14 VSS nmos W=0.17u L=0.04u
M11447 U1682/net4 CRC_OUT_9_20 VSS VSS nmos W=0.155u L=0.04u
M11448 U1682/net6 U1682/net4 VSS VSS nmos W=0.17u L=0.04u
M11449 n962 U1682/net14 VSS VSS nmos W=0.155u L=0.04u
M11450 U1682/net10 WX857 VSS VSS nmos W=0.155u L=0.04u
M11451 U1682/net4 U1682/net10 U1682/net14 VDD pmos W=0.255u L=0.04u
M11452 U1682/net6 WX857 U1682/net14 VDD pmos W=0.28u L=0.04u
M11453 U1682/net4 CRC_OUT_9_20 VDD VDD pmos W=0.205u L=0.04u
M11454 U1682/net6 U1682/net4 VDD VDD pmos W=0.24u L=0.04u
M11455 n962 U1682/net14 VDD VDD pmos W=0.205u L=0.04u
M11456 U1682/net10 WX857 VDD VDD pmos W=0.205u L=0.04u
M11457 U1683/net4 WX855 U1683/net14 VSS nmos W=0.155u L=0.04u
M11458 U1683/net6 U1683/net10 U1683/net14 VSS nmos W=0.17u L=0.04u
M11459 U1683/net4 CRC_OUT_9_21 VSS VSS nmos W=0.155u L=0.04u
M11460 U1683/net6 U1683/net4 VSS VSS nmos W=0.17u L=0.04u
M11461 n961 U1683/net14 VSS VSS nmos W=0.155u L=0.04u
M11462 U1683/net10 WX855 VSS VSS nmos W=0.155u L=0.04u
M11463 U1683/net4 U1683/net10 U1683/net14 VDD pmos W=0.255u L=0.04u
M11464 U1683/net6 WX855 U1683/net14 VDD pmos W=0.28u L=0.04u
M11465 U1683/net4 CRC_OUT_9_21 VDD VDD pmos W=0.205u L=0.04u
M11466 U1683/net6 U1683/net4 VDD VDD pmos W=0.24u L=0.04u
M11467 n961 U1683/net14 VDD VDD pmos W=0.205u L=0.04u
M11468 U1683/net10 WX855 VDD VDD pmos W=0.205u L=0.04u
M11469 U1684/net4 WX853 U1684/net14 VSS nmos W=0.155u L=0.04u
M11470 U1684/net6 U1684/net10 U1684/net14 VSS nmos W=0.17u L=0.04u
M11471 U1684/net4 CRC_OUT_9_22 VSS VSS nmos W=0.155u L=0.04u
M11472 U1684/net6 U1684/net4 VSS VSS nmos W=0.17u L=0.04u
M11473 n960 U1684/net14 VSS VSS nmos W=0.155u L=0.04u
M11474 U1684/net10 WX853 VSS VSS nmos W=0.155u L=0.04u
M11475 U1684/net4 U1684/net10 U1684/net14 VDD pmos W=0.255u L=0.04u
M11476 U1684/net6 WX853 U1684/net14 VDD pmos W=0.28u L=0.04u
M11477 U1684/net4 CRC_OUT_9_22 VDD VDD pmos W=0.205u L=0.04u
M11478 U1684/net6 U1684/net4 VDD VDD pmos W=0.24u L=0.04u
M11479 n960 U1684/net14 VDD VDD pmos W=0.205u L=0.04u
M11480 U1684/net10 WX853 VDD VDD pmos W=0.205u L=0.04u
M11481 U1685/net4 WX851 U1685/net14 VSS nmos W=0.155u L=0.04u
M11482 U1685/net6 U1685/net10 U1685/net14 VSS nmos W=0.17u L=0.04u
M11483 U1685/net4 CRC_OUT_9_23 VSS VSS nmos W=0.155u L=0.04u
M11484 U1685/net6 U1685/net4 VSS VSS nmos W=0.17u L=0.04u
M11485 n959 U1685/net14 VSS VSS nmos W=0.155u L=0.04u
M11486 U1685/net10 WX851 VSS VSS nmos W=0.155u L=0.04u
M11487 U1685/net4 U1685/net10 U1685/net14 VDD pmos W=0.255u L=0.04u
M11488 U1685/net6 WX851 U1685/net14 VDD pmos W=0.28u L=0.04u
M11489 U1685/net4 CRC_OUT_9_23 VDD VDD pmos W=0.205u L=0.04u
M11490 U1685/net6 U1685/net4 VDD VDD pmos W=0.24u L=0.04u
M11491 n959 U1685/net14 VDD VDD pmos W=0.205u L=0.04u
M11492 U1685/net10 WX851 VDD VDD pmos W=0.205u L=0.04u
M11493 U1686/net4 WX849 U1686/net14 VSS nmos W=0.155u L=0.04u
M11494 U1686/net6 U1686/net10 U1686/net14 VSS nmos W=0.17u L=0.04u
M11495 U1686/net4 CRC_OUT_9_24 VSS VSS nmos W=0.155u L=0.04u
M11496 U1686/net6 U1686/net4 VSS VSS nmos W=0.17u L=0.04u
M11497 n958 U1686/net14 VSS VSS nmos W=0.155u L=0.04u
M11498 U1686/net10 WX849 VSS VSS nmos W=0.155u L=0.04u
M11499 U1686/net4 U1686/net10 U1686/net14 VDD pmos W=0.255u L=0.04u
M11500 U1686/net6 WX849 U1686/net14 VDD pmos W=0.28u L=0.04u
M11501 U1686/net4 CRC_OUT_9_24 VDD VDD pmos W=0.205u L=0.04u
M11502 U1686/net6 U1686/net4 VDD VDD pmos W=0.24u L=0.04u
M11503 n958 U1686/net14 VDD VDD pmos W=0.205u L=0.04u
M11504 U1686/net10 WX849 VDD VDD pmos W=0.205u L=0.04u
M11505 U1687/net4 WX847 U1687/net14 VSS nmos W=0.155u L=0.04u
M11506 U1687/net6 U1687/net10 U1687/net14 VSS nmos W=0.17u L=0.04u
M11507 U1687/net4 CRC_OUT_9_25 VSS VSS nmos W=0.155u L=0.04u
M11508 U1687/net6 U1687/net4 VSS VSS nmos W=0.17u L=0.04u
M11509 n957 U1687/net14 VSS VSS nmos W=0.155u L=0.04u
M11510 U1687/net10 WX847 VSS VSS nmos W=0.155u L=0.04u
M11511 U1687/net4 U1687/net10 U1687/net14 VDD pmos W=0.255u L=0.04u
M11512 U1687/net6 WX847 U1687/net14 VDD pmos W=0.28u L=0.04u
M11513 U1687/net4 CRC_OUT_9_25 VDD VDD pmos W=0.205u L=0.04u
M11514 U1687/net6 U1687/net4 VDD VDD pmos W=0.24u L=0.04u
M11515 n957 U1687/net14 VDD VDD pmos W=0.205u L=0.04u
M11516 U1687/net10 WX847 VDD VDD pmos W=0.205u L=0.04u
M11517 U1688/net4 WX845 U1688/net14 VSS nmos W=0.155u L=0.04u
M11518 U1688/net6 U1688/net10 U1688/net14 VSS nmos W=0.17u L=0.04u
M11519 U1688/net4 CRC_OUT_9_26 VSS VSS nmos W=0.155u L=0.04u
M11520 U1688/net6 U1688/net4 VSS VSS nmos W=0.17u L=0.04u
M11521 n956 U1688/net14 VSS VSS nmos W=0.155u L=0.04u
M11522 U1688/net10 WX845 VSS VSS nmos W=0.155u L=0.04u
M11523 U1688/net4 U1688/net10 U1688/net14 VDD pmos W=0.255u L=0.04u
M11524 U1688/net6 WX845 U1688/net14 VDD pmos W=0.28u L=0.04u
M11525 U1688/net4 CRC_OUT_9_26 VDD VDD pmos W=0.205u L=0.04u
M11526 U1688/net6 U1688/net4 VDD VDD pmos W=0.24u L=0.04u
M11527 n956 U1688/net14 VDD VDD pmos W=0.205u L=0.04u
M11528 U1688/net10 WX845 VDD VDD pmos W=0.205u L=0.04u
M11529 U1689/net4 WX843 U1689/net14 VSS nmos W=0.155u L=0.04u
M11530 U1689/net6 U1689/net10 U1689/net14 VSS nmos W=0.17u L=0.04u
M11531 U1689/net4 CRC_OUT_9_27 VSS VSS nmos W=0.155u L=0.04u
M11532 U1689/net6 U1689/net4 VSS VSS nmos W=0.17u L=0.04u
M11533 n955 U1689/net14 VSS VSS nmos W=0.155u L=0.04u
M11534 U1689/net10 WX843 VSS VSS nmos W=0.155u L=0.04u
M11535 U1689/net4 U1689/net10 U1689/net14 VDD pmos W=0.255u L=0.04u
M11536 U1689/net6 WX843 U1689/net14 VDD pmos W=0.28u L=0.04u
M11537 U1689/net4 CRC_OUT_9_27 VDD VDD pmos W=0.205u L=0.04u
M11538 U1689/net6 U1689/net4 VDD VDD pmos W=0.24u L=0.04u
M11539 n955 U1689/net14 VDD VDD pmos W=0.205u L=0.04u
M11540 U1689/net10 WX843 VDD VDD pmos W=0.205u L=0.04u
M11541 U1690/net4 WX841 U1690/net14 VSS nmos W=0.155u L=0.04u
M11542 U1690/net6 U1690/net10 U1690/net14 VSS nmos W=0.17u L=0.04u
M11543 U1690/net4 CRC_OUT_9_28 VSS VSS nmos W=0.155u L=0.04u
M11544 U1690/net6 U1690/net4 VSS VSS nmos W=0.17u L=0.04u
M11545 n954 U1690/net14 VSS VSS nmos W=0.155u L=0.04u
M11546 U1690/net10 WX841 VSS VSS nmos W=0.155u L=0.04u
M11547 U1690/net4 U1690/net10 U1690/net14 VDD pmos W=0.255u L=0.04u
M11548 U1690/net6 WX841 U1690/net14 VDD pmos W=0.28u L=0.04u
M11549 U1690/net4 CRC_OUT_9_28 VDD VDD pmos W=0.205u L=0.04u
M11550 U1690/net6 U1690/net4 VDD VDD pmos W=0.24u L=0.04u
M11551 n954 U1690/net14 VDD VDD pmos W=0.205u L=0.04u
M11552 U1690/net10 WX841 VDD VDD pmos W=0.205u L=0.04u
M11553 U1691/net4 WX839 U1691/net14 VSS nmos W=0.155u L=0.04u
M11554 U1691/net6 U1691/net10 U1691/net14 VSS nmos W=0.17u L=0.04u
M11555 U1691/net4 CRC_OUT_9_29 VSS VSS nmos W=0.155u L=0.04u
M11556 U1691/net6 U1691/net4 VSS VSS nmos W=0.17u L=0.04u
M11557 n953 U1691/net14 VSS VSS nmos W=0.155u L=0.04u
M11558 U1691/net10 WX839 VSS VSS nmos W=0.155u L=0.04u
M11559 U1691/net4 U1691/net10 U1691/net14 VDD pmos W=0.255u L=0.04u
M11560 U1691/net6 WX839 U1691/net14 VDD pmos W=0.28u L=0.04u
M11561 U1691/net4 CRC_OUT_9_29 VDD VDD pmos W=0.205u L=0.04u
M11562 U1691/net6 U1691/net4 VDD VDD pmos W=0.24u L=0.04u
M11563 n953 U1691/net14 VDD VDD pmos W=0.205u L=0.04u
M11564 U1691/net10 WX839 VDD VDD pmos W=0.205u L=0.04u
M11565 U1692/net4 WX837 U1692/net14 VSS nmos W=0.155u L=0.04u
M11566 U1692/net6 U1692/net10 U1692/net14 VSS nmos W=0.17u L=0.04u
M11567 U1692/net4 CRC_OUT_9_30 VSS VSS nmos W=0.155u L=0.04u
M11568 U1692/net6 U1692/net4 VSS VSS nmos W=0.17u L=0.04u
M11569 n952 U1692/net14 VSS VSS nmos W=0.155u L=0.04u
M11570 U1692/net10 WX837 VSS VSS nmos W=0.155u L=0.04u
M11571 U1692/net4 U1692/net10 U1692/net14 VDD pmos W=0.255u L=0.04u
M11572 U1692/net6 WX837 U1692/net14 VDD pmos W=0.28u L=0.04u
M11573 U1692/net4 CRC_OUT_9_30 VDD VDD pmos W=0.205u L=0.04u
M11574 U1692/net6 U1692/net4 VDD VDD pmos W=0.24u L=0.04u
M11575 n952 U1692/net14 VDD VDD pmos W=0.205u L=0.04u
M11576 U1692/net10 WX837 VDD VDD pmos W=0.205u L=0.04u
M11577 U1693/net4 CRC_OUT_1_31 U1693/net14 VSS nmos W=0.155u L=0.04u
M11578 U1693/net6 U1693/net10 U1693/net14 VSS nmos W=0.17u L=0.04u
M11579 U1693/net4 WX11243 VSS VSS nmos W=0.155u L=0.04u
M11580 U1693/net6 U1693/net4 VSS VSS nmos W=0.17u L=0.04u
M11581 n1239 U1693/net14 VSS VSS nmos W=0.155u L=0.04u
M11582 U1693/net10 CRC_OUT_1_31 VSS VSS nmos W=0.155u L=0.04u
M11583 U1693/net4 U1693/net10 U1693/net14 VDD pmos W=0.255u L=0.04u
M11584 U1693/net6 CRC_OUT_1_31 U1693/net14 VDD pmos W=0.28u L=0.04u
M11585 U1693/net4 WX11243 VDD VDD pmos W=0.205u L=0.04u
M11586 U1693/net6 U1693/net4 VDD VDD pmos W=0.24u L=0.04u
M11587 n1239 U1693/net14 VDD VDD pmos W=0.205u L=0.04u
M11588 U1693/net10 CRC_OUT_1_31 VDD VDD pmos W=0.205u L=0.04u
M11589 U1694/net4 WX11241 U1694/net14 VSS nmos W=0.155u L=0.04u
M11590 U1694/net6 U1694/net10 U1694/net14 VSS nmos W=0.17u L=0.04u
M11591 U1694/net4 CRC_OUT_1_0 VSS VSS nmos W=0.155u L=0.04u
M11592 U1694/net6 U1694/net4 VSS VSS nmos W=0.17u L=0.04u
M11593 n1238 U1694/net14 VSS VSS nmos W=0.155u L=0.04u
M11594 U1694/net10 WX11241 VSS VSS nmos W=0.155u L=0.04u
M11595 U1694/net4 U1694/net10 U1694/net14 VDD pmos W=0.255u L=0.04u
M11596 U1694/net6 WX11241 U1694/net14 VDD pmos W=0.28u L=0.04u
M11597 U1694/net4 CRC_OUT_1_0 VDD VDD pmos W=0.205u L=0.04u
M11598 U1694/net6 U1694/net4 VDD VDD pmos W=0.24u L=0.04u
M11599 n1238 U1694/net14 VDD VDD pmos W=0.205u L=0.04u
M11600 U1694/net10 WX11241 VDD VDD pmos W=0.205u L=0.04u
M11601 U1695/net4 WX11239 U1695/net14 VSS nmos W=0.155u L=0.04u
M11602 U1695/net6 U1695/net10 U1695/net14 VSS nmos W=0.17u L=0.04u
M11603 U1695/net4 CRC_OUT_1_1 VSS VSS nmos W=0.155u L=0.04u
M11604 U1695/net6 U1695/net4 VSS VSS nmos W=0.17u L=0.04u
M11605 n1237 U1695/net14 VSS VSS nmos W=0.155u L=0.04u
M11606 U1695/net10 WX11239 VSS VSS nmos W=0.155u L=0.04u
M11607 U1695/net4 U1695/net10 U1695/net14 VDD pmos W=0.255u L=0.04u
M11608 U1695/net6 WX11239 U1695/net14 VDD pmos W=0.28u L=0.04u
M11609 U1695/net4 CRC_OUT_1_1 VDD VDD pmos W=0.205u L=0.04u
M11610 U1695/net6 U1695/net4 VDD VDD pmos W=0.24u L=0.04u
M11611 n1237 U1695/net14 VDD VDD pmos W=0.205u L=0.04u
M11612 U1695/net10 WX11239 VDD VDD pmos W=0.205u L=0.04u
M11613 U1696/net4 WX11237 U1696/net14 VSS nmos W=0.155u L=0.04u
M11614 U1696/net6 U1696/net10 U1696/net14 VSS nmos W=0.17u L=0.04u
M11615 U1696/net4 CRC_OUT_1_2 VSS VSS nmos W=0.155u L=0.04u
M11616 U1696/net6 U1696/net4 VSS VSS nmos W=0.17u L=0.04u
M11617 n1236 U1696/net14 VSS VSS nmos W=0.155u L=0.04u
M11618 U1696/net10 WX11237 VSS VSS nmos W=0.155u L=0.04u
M11619 U1696/net4 U1696/net10 U1696/net14 VDD pmos W=0.255u L=0.04u
M11620 U1696/net6 WX11237 U1696/net14 VDD pmos W=0.28u L=0.04u
M11621 U1696/net4 CRC_OUT_1_2 VDD VDD pmos W=0.205u L=0.04u
M11622 U1696/net6 U1696/net4 VDD VDD pmos W=0.24u L=0.04u
M11623 n1236 U1696/net14 VDD VDD pmos W=0.205u L=0.04u
M11624 U1696/net10 WX11237 VDD VDD pmos W=0.205u L=0.04u
M11625 U1697/net11 CRC_OUT_1_31 U1697/net17 VSS nmos W=0.155u L=0.04u
M11626 U1697/net5 U1697/net17 U1697/net21 VSS nmos W=0.155u L=0.04u
M11627 U1697/net5 CRC_OUT_1_3 VSS VSS nmos W=0.155u L=0.04u
M11628 n1235 U1697/net21 VSS VSS nmos W=0.155u L=0.04u
M11629 U1697/net16 CRC_OUT_1_31 VSS VSS nmos W=0.155u L=0.04u
M11630 U1697/net11 WX11235 VSS VSS nmos W=0.155u L=0.04u
M11631 U1697/net13 U1697/net17 VSS VSS nmos W=0.155u L=0.04u
M11632 U1697/net17 U1697/net16 U1697/XI2-net16 VSS nmos W=0.155u L=0.04u
M11633 U1697/XI2-net16 U1697/net11 VSS VSS nmos W=0.155u L=0.04u
M11634 U1697/net21 U1697/net13 U1697/XU21-net16 VSS nmos W=0.155u L=0.04u
M11635 U1697/XU21-net16 U1697/net5 VSS VSS nmos W=0.155u L=0.04u
M11636 U1697/net11 U1697/net16 U1697/net17 VDD pmos W=0.205u L=0.04u
M11637 U1697/net5 U1697/net13 U1697/net21 VDD pmos W=0.205u L=0.04u
M11638 U1697/net5 CRC_OUT_1_3 VDD VDD pmos W=0.205u L=0.04u
M11639 n1235 U1697/net21 VDD VDD pmos W=0.205u L=0.04u
M11640 U1697/net16 CRC_OUT_1_31 VDD VDD pmos W=0.205u L=0.04u
M11641 U1697/net11 WX11235 VDD VDD pmos W=0.205u L=0.04u
M11642 U1697/net13 U1697/net17 VDD VDD pmos W=0.205u L=0.04u
M11643 U1697/net17 CRC_OUT_1_31 U1697/XI2-net6 VDD pmos W=0.205u L=0.04u
M11644 U1697/XI2-net6 U1697/net11 VDD VDD pmos W=0.205u L=0.04u
M11645 U1697/net21 U1697/net17 U1697/XU21-net6 VDD pmos W=0.205u L=0.04u
M11646 U1697/XU21-net6 U1697/net5 VDD VDD pmos W=0.205u L=0.04u
M11647 U1698/net4 WX11233 U1698/net14 VSS nmos W=0.155u L=0.04u
M11648 U1698/net6 U1698/net10 U1698/net14 VSS nmos W=0.17u L=0.04u
M11649 U1698/net4 CRC_OUT_1_4 VSS VSS nmos W=0.155u L=0.04u
M11650 U1698/net6 U1698/net4 VSS VSS nmos W=0.17u L=0.04u
M11651 n1234 U1698/net14 VSS VSS nmos W=0.155u L=0.04u
M11652 U1698/net10 WX11233 VSS VSS nmos W=0.155u L=0.04u
M11653 U1698/net4 U1698/net10 U1698/net14 VDD pmos W=0.255u L=0.04u
M11654 U1698/net6 WX11233 U1698/net14 VDD pmos W=0.28u L=0.04u
M11655 U1698/net4 CRC_OUT_1_4 VDD VDD pmos W=0.205u L=0.04u
M11656 U1698/net6 U1698/net4 VDD VDD pmos W=0.24u L=0.04u
M11657 n1234 U1698/net14 VDD VDD pmos W=0.205u L=0.04u
M11658 U1698/net10 WX11233 VDD VDD pmos W=0.205u L=0.04u
M11659 U1699/net4 WX11231 U1699/net14 VSS nmos W=0.155u L=0.04u
M11660 U1699/net6 U1699/net10 U1699/net14 VSS nmos W=0.17u L=0.04u
M11661 U1699/net4 CRC_OUT_1_5 VSS VSS nmos W=0.155u L=0.04u
M11662 U1699/net6 U1699/net4 VSS VSS nmos W=0.17u L=0.04u
M11663 n1233 U1699/net14 VSS VSS nmos W=0.155u L=0.04u
M11664 U1699/net10 WX11231 VSS VSS nmos W=0.155u L=0.04u
M11665 U1699/net4 U1699/net10 U1699/net14 VDD pmos W=0.255u L=0.04u
M11666 U1699/net6 WX11231 U1699/net14 VDD pmos W=0.28u L=0.04u
M11667 U1699/net4 CRC_OUT_1_5 VDD VDD pmos W=0.205u L=0.04u
M11668 U1699/net6 U1699/net4 VDD VDD pmos W=0.24u L=0.04u
M11669 n1233 U1699/net14 VDD VDD pmos W=0.205u L=0.04u
M11670 U1699/net10 WX11231 VDD VDD pmos W=0.205u L=0.04u
M11671 U1700/net4 WX11229 U1700/net14 VSS nmos W=0.155u L=0.04u
M11672 U1700/net6 U1700/net10 U1700/net14 VSS nmos W=0.17u L=0.04u
M11673 U1700/net4 CRC_OUT_1_6 VSS VSS nmos W=0.155u L=0.04u
M11674 U1700/net6 U1700/net4 VSS VSS nmos W=0.17u L=0.04u
M11675 n1232 U1700/net14 VSS VSS nmos W=0.155u L=0.04u
M11676 U1700/net10 WX11229 VSS VSS nmos W=0.155u L=0.04u
M11677 U1700/net4 U1700/net10 U1700/net14 VDD pmos W=0.255u L=0.04u
M11678 U1700/net6 WX11229 U1700/net14 VDD pmos W=0.28u L=0.04u
M11679 U1700/net4 CRC_OUT_1_6 VDD VDD pmos W=0.205u L=0.04u
M11680 U1700/net6 U1700/net4 VDD VDD pmos W=0.24u L=0.04u
M11681 n1232 U1700/net14 VDD VDD pmos W=0.205u L=0.04u
M11682 U1700/net10 WX11229 VDD VDD pmos W=0.205u L=0.04u
M11683 U1701/net4 WX11227 U1701/net14 VSS nmos W=0.155u L=0.04u
M11684 U1701/net6 U1701/net10 U1701/net14 VSS nmos W=0.17u L=0.04u
M11685 U1701/net4 CRC_OUT_1_7 VSS VSS nmos W=0.155u L=0.04u
M11686 U1701/net6 U1701/net4 VSS VSS nmos W=0.17u L=0.04u
M11687 n1231 U1701/net14 VSS VSS nmos W=0.155u L=0.04u
M11688 U1701/net10 WX11227 VSS VSS nmos W=0.155u L=0.04u
M11689 U1701/net4 U1701/net10 U1701/net14 VDD pmos W=0.255u L=0.04u
M11690 U1701/net6 WX11227 U1701/net14 VDD pmos W=0.28u L=0.04u
M11691 U1701/net4 CRC_OUT_1_7 VDD VDD pmos W=0.205u L=0.04u
M11692 U1701/net6 U1701/net4 VDD VDD pmos W=0.24u L=0.04u
M11693 n1231 U1701/net14 VDD VDD pmos W=0.205u L=0.04u
M11694 U1701/net10 WX11227 VDD VDD pmos W=0.205u L=0.04u
M11695 U1702/net4 WX11225 U1702/net14 VSS nmos W=0.155u L=0.04u
M11696 U1702/net6 U1702/net10 U1702/net14 VSS nmos W=0.17u L=0.04u
M11697 U1702/net4 CRC_OUT_1_8 VSS VSS nmos W=0.155u L=0.04u
M11698 U1702/net6 U1702/net4 VSS VSS nmos W=0.17u L=0.04u
M11699 n1230 U1702/net14 VSS VSS nmos W=0.155u L=0.04u
M11700 U1702/net10 WX11225 VSS VSS nmos W=0.155u L=0.04u
M11701 U1702/net4 U1702/net10 U1702/net14 VDD pmos W=0.255u L=0.04u
M11702 U1702/net6 WX11225 U1702/net14 VDD pmos W=0.28u L=0.04u
M11703 U1702/net4 CRC_OUT_1_8 VDD VDD pmos W=0.205u L=0.04u
M11704 U1702/net6 U1702/net4 VDD VDD pmos W=0.24u L=0.04u
M11705 n1230 U1702/net14 VDD VDD pmos W=0.205u L=0.04u
M11706 U1702/net10 WX11225 VDD VDD pmos W=0.205u L=0.04u
M11707 U1703/net4 WX11223 U1703/net14 VSS nmos W=0.155u L=0.04u
M11708 U1703/net6 U1703/net10 U1703/net14 VSS nmos W=0.17u L=0.04u
M11709 U1703/net4 CRC_OUT_1_9 VSS VSS nmos W=0.155u L=0.04u
M11710 U1703/net6 U1703/net4 VSS VSS nmos W=0.17u L=0.04u
M11711 n1229 U1703/net14 VSS VSS nmos W=0.155u L=0.04u
M11712 U1703/net10 WX11223 VSS VSS nmos W=0.155u L=0.04u
M11713 U1703/net4 U1703/net10 U1703/net14 VDD pmos W=0.255u L=0.04u
M11714 U1703/net6 WX11223 U1703/net14 VDD pmos W=0.28u L=0.04u
M11715 U1703/net4 CRC_OUT_1_9 VDD VDD pmos W=0.205u L=0.04u
M11716 U1703/net6 U1703/net4 VDD VDD pmos W=0.24u L=0.04u
M11717 n1229 U1703/net14 VDD VDD pmos W=0.205u L=0.04u
M11718 U1703/net10 WX11223 VDD VDD pmos W=0.205u L=0.04u
M11719 U1704/net11 CRC_OUT_1_31 U1704/net17 VSS nmos W=0.155u L=0.04u
M11720 U1704/net5 U1704/net17 U1704/net21 VSS nmos W=0.155u L=0.04u
M11721 U1704/net5 CRC_OUT_1_10 VSS VSS nmos W=0.155u L=0.04u
M11722 n1228 U1704/net21 VSS VSS nmos W=0.155u L=0.04u
M11723 U1704/net16 CRC_OUT_1_31 VSS VSS nmos W=0.155u L=0.04u
M11724 U1704/net11 WX11221 VSS VSS nmos W=0.155u L=0.04u
M11725 U1704/net13 U1704/net17 VSS VSS nmos W=0.155u L=0.04u
M11726 U1704/net17 U1704/net16 U1704/XI2-net16 VSS nmos W=0.155u L=0.04u
M11727 U1704/XI2-net16 U1704/net11 VSS VSS nmos W=0.155u L=0.04u
M11728 U1704/net21 U1704/net13 U1704/XU21-net16 VSS nmos W=0.155u L=0.04u
M11729 U1704/XU21-net16 U1704/net5 VSS VSS nmos W=0.155u L=0.04u
M11730 U1704/net11 U1704/net16 U1704/net17 VDD pmos W=0.205u L=0.04u
M11731 U1704/net5 U1704/net13 U1704/net21 VDD pmos W=0.205u L=0.04u
M11732 U1704/net5 CRC_OUT_1_10 VDD VDD pmos W=0.205u L=0.04u
M11733 n1228 U1704/net21 VDD VDD pmos W=0.205u L=0.04u
M11734 U1704/net16 CRC_OUT_1_31 VDD VDD pmos W=0.205u L=0.04u
M11735 U1704/net11 WX11221 VDD VDD pmos W=0.205u L=0.04u
M11736 U1704/net13 U1704/net17 VDD VDD pmos W=0.205u L=0.04u
M11737 U1704/net17 CRC_OUT_1_31 U1704/XI2-net6 VDD pmos W=0.205u L=0.04u
M11738 U1704/XI2-net6 U1704/net11 VDD VDD pmos W=0.205u L=0.04u
M11739 U1704/net21 U1704/net17 U1704/XU21-net6 VDD pmos W=0.205u L=0.04u
M11740 U1704/XU21-net6 U1704/net5 VDD VDD pmos W=0.205u L=0.04u
M11741 U1705/net4 WX11219 U1705/net14 VSS nmos W=0.155u L=0.04u
M11742 U1705/net6 U1705/net10 U1705/net14 VSS nmos W=0.17u L=0.04u
M11743 U1705/net4 CRC_OUT_1_11 VSS VSS nmos W=0.155u L=0.04u
M11744 U1705/net6 U1705/net4 VSS VSS nmos W=0.17u L=0.04u
M11745 n1227 U1705/net14 VSS VSS nmos W=0.155u L=0.04u
M11746 U1705/net10 WX11219 VSS VSS nmos W=0.155u L=0.04u
M11747 U1705/net4 U1705/net10 U1705/net14 VDD pmos W=0.255u L=0.04u
M11748 U1705/net6 WX11219 U1705/net14 VDD pmos W=0.28u L=0.04u
M11749 U1705/net4 CRC_OUT_1_11 VDD VDD pmos W=0.205u L=0.04u
M11750 U1705/net6 U1705/net4 VDD VDD pmos W=0.24u L=0.04u
M11751 n1227 U1705/net14 VDD VDD pmos W=0.205u L=0.04u
M11752 U1705/net10 WX11219 VDD VDD pmos W=0.205u L=0.04u
M11753 U1706/net4 WX11217 U1706/net14 VSS nmos W=0.155u L=0.04u
M11754 U1706/net6 U1706/net10 U1706/net14 VSS nmos W=0.17u L=0.04u
M11755 U1706/net4 CRC_OUT_1_12 VSS VSS nmos W=0.155u L=0.04u
M11756 U1706/net6 U1706/net4 VSS VSS nmos W=0.17u L=0.04u
M11757 n1226 U1706/net14 VSS VSS nmos W=0.155u L=0.04u
M11758 U1706/net10 WX11217 VSS VSS nmos W=0.155u L=0.04u
M11759 U1706/net4 U1706/net10 U1706/net14 VDD pmos W=0.255u L=0.04u
M11760 U1706/net6 WX11217 U1706/net14 VDD pmos W=0.28u L=0.04u
M11761 U1706/net4 CRC_OUT_1_12 VDD VDD pmos W=0.205u L=0.04u
M11762 U1706/net6 U1706/net4 VDD VDD pmos W=0.24u L=0.04u
M11763 n1226 U1706/net14 VDD VDD pmos W=0.205u L=0.04u
M11764 U1706/net10 WX11217 VDD VDD pmos W=0.205u L=0.04u
M11765 U1707/net4 WX11215 U1707/net14 VSS nmos W=0.155u L=0.04u
M11766 U1707/net6 U1707/net10 U1707/net14 VSS nmos W=0.17u L=0.04u
M11767 U1707/net4 CRC_OUT_1_13 VSS VSS nmos W=0.155u L=0.04u
M11768 U1707/net6 U1707/net4 VSS VSS nmos W=0.17u L=0.04u
M11769 n1225 U1707/net14 VSS VSS nmos W=0.155u L=0.04u
M11770 U1707/net10 WX11215 VSS VSS nmos W=0.155u L=0.04u
M11771 U1707/net4 U1707/net10 U1707/net14 VDD pmos W=0.255u L=0.04u
M11772 U1707/net6 WX11215 U1707/net14 VDD pmos W=0.28u L=0.04u
M11773 U1707/net4 CRC_OUT_1_13 VDD VDD pmos W=0.205u L=0.04u
M11774 U1707/net6 U1707/net4 VDD VDD pmos W=0.24u L=0.04u
M11775 n1225 U1707/net14 VDD VDD pmos W=0.205u L=0.04u
M11776 U1707/net10 WX11215 VDD VDD pmos W=0.205u L=0.04u
M11777 U1708/net4 WX11213 U1708/net14 VSS nmos W=0.155u L=0.04u
M11778 U1708/net6 U1708/net10 U1708/net14 VSS nmos W=0.17u L=0.04u
M11779 U1708/net4 CRC_OUT_1_14 VSS VSS nmos W=0.155u L=0.04u
M11780 U1708/net6 U1708/net4 VSS VSS nmos W=0.17u L=0.04u
M11781 n1224 U1708/net14 VSS VSS nmos W=0.155u L=0.04u
M11782 U1708/net10 WX11213 VSS VSS nmos W=0.155u L=0.04u
M11783 U1708/net4 U1708/net10 U1708/net14 VDD pmos W=0.255u L=0.04u
M11784 U1708/net6 WX11213 U1708/net14 VDD pmos W=0.28u L=0.04u
M11785 U1708/net4 CRC_OUT_1_14 VDD VDD pmos W=0.205u L=0.04u
M11786 U1708/net6 U1708/net4 VDD VDD pmos W=0.24u L=0.04u
M11787 n1224 U1708/net14 VDD VDD pmos W=0.205u L=0.04u
M11788 U1708/net10 WX11213 VDD VDD pmos W=0.205u L=0.04u
M11789 U1709/net11 CRC_OUT_1_31 U1709/net17 VSS nmos W=0.155u L=0.04u
M11790 U1709/net5 U1709/net17 U1709/net21 VSS nmos W=0.155u L=0.04u
M11791 U1709/net5 CRC_OUT_1_15 VSS VSS nmos W=0.155u L=0.04u
M11792 n1223 U1709/net21 VSS VSS nmos W=0.155u L=0.04u
M11793 U1709/net16 CRC_OUT_1_31 VSS VSS nmos W=0.155u L=0.04u
M11794 U1709/net11 WX11211 VSS VSS nmos W=0.155u L=0.04u
M11795 U1709/net13 U1709/net17 VSS VSS nmos W=0.155u L=0.04u
M11796 U1709/net17 U1709/net16 U1709/XI2-net16 VSS nmos W=0.155u L=0.04u
M11797 U1709/XI2-net16 U1709/net11 VSS VSS nmos W=0.155u L=0.04u
M11798 U1709/net21 U1709/net13 U1709/XU21-net16 VSS nmos W=0.155u L=0.04u
M11799 U1709/XU21-net16 U1709/net5 VSS VSS nmos W=0.155u L=0.04u
M11800 U1709/net11 U1709/net16 U1709/net17 VDD pmos W=0.205u L=0.04u
M11801 U1709/net5 U1709/net13 U1709/net21 VDD pmos W=0.205u L=0.04u
M11802 U1709/net5 CRC_OUT_1_15 VDD VDD pmos W=0.205u L=0.04u
M11803 n1223 U1709/net21 VDD VDD pmos W=0.205u L=0.04u
M11804 U1709/net16 CRC_OUT_1_31 VDD VDD pmos W=0.205u L=0.04u
M11805 U1709/net11 WX11211 VDD VDD pmos W=0.205u L=0.04u
M11806 U1709/net13 U1709/net17 VDD VDD pmos W=0.205u L=0.04u
M11807 U1709/net17 CRC_OUT_1_31 U1709/XI2-net6 VDD pmos W=0.205u L=0.04u
M11808 U1709/XI2-net6 U1709/net11 VDD VDD pmos W=0.205u L=0.04u
M11809 U1709/net21 U1709/net17 U1709/XU21-net6 VDD pmos W=0.205u L=0.04u
M11810 U1709/XU21-net6 U1709/net5 VDD VDD pmos W=0.205u L=0.04u
M11811 U1710/net4 WX11209 U1710/net14 VSS nmos W=0.155u L=0.04u
M11812 U1710/net6 U1710/net10 U1710/net14 VSS nmos W=0.17u L=0.04u
M11813 U1710/net4 CRC_OUT_1_16 VSS VSS nmos W=0.155u L=0.04u
M11814 U1710/net6 U1710/net4 VSS VSS nmos W=0.17u L=0.04u
M11815 n1222 U1710/net14 VSS VSS nmos W=0.155u L=0.04u
M11816 U1710/net10 WX11209 VSS VSS nmos W=0.155u L=0.04u
M11817 U1710/net4 U1710/net10 U1710/net14 VDD pmos W=0.255u L=0.04u
M11818 U1710/net6 WX11209 U1710/net14 VDD pmos W=0.28u L=0.04u
M11819 U1710/net4 CRC_OUT_1_16 VDD VDD pmos W=0.205u L=0.04u
M11820 U1710/net6 U1710/net4 VDD VDD pmos W=0.24u L=0.04u
M11821 n1222 U1710/net14 VDD VDD pmos W=0.205u L=0.04u
M11822 U1710/net10 WX11209 VDD VDD pmos W=0.205u L=0.04u
M11823 U1711/net4 WX11207 U1711/net14 VSS nmos W=0.155u L=0.04u
M11824 U1711/net6 U1711/net10 U1711/net14 VSS nmos W=0.17u L=0.04u
M11825 U1711/net4 CRC_OUT_1_17 VSS VSS nmos W=0.155u L=0.04u
M11826 U1711/net6 U1711/net4 VSS VSS nmos W=0.17u L=0.04u
M11827 n1221 U1711/net14 VSS VSS nmos W=0.155u L=0.04u
M11828 U1711/net10 WX11207 VSS VSS nmos W=0.155u L=0.04u
M11829 U1711/net4 U1711/net10 U1711/net14 VDD pmos W=0.255u L=0.04u
M11830 U1711/net6 WX11207 U1711/net14 VDD pmos W=0.28u L=0.04u
M11831 U1711/net4 CRC_OUT_1_17 VDD VDD pmos W=0.205u L=0.04u
M11832 U1711/net6 U1711/net4 VDD VDD pmos W=0.24u L=0.04u
M11833 n1221 U1711/net14 VDD VDD pmos W=0.205u L=0.04u
M11834 U1711/net10 WX11207 VDD VDD pmos W=0.205u L=0.04u
M11835 U1712/net4 WX11205 U1712/net14 VSS nmos W=0.155u L=0.04u
M11836 U1712/net6 U1712/net10 U1712/net14 VSS nmos W=0.17u L=0.04u
M11837 U1712/net4 CRC_OUT_1_18 VSS VSS nmos W=0.155u L=0.04u
M11838 U1712/net6 U1712/net4 VSS VSS nmos W=0.17u L=0.04u
M11839 n1220 U1712/net14 VSS VSS nmos W=0.155u L=0.04u
M11840 U1712/net10 WX11205 VSS VSS nmos W=0.155u L=0.04u
M11841 U1712/net4 U1712/net10 U1712/net14 VDD pmos W=0.255u L=0.04u
M11842 U1712/net6 WX11205 U1712/net14 VDD pmos W=0.28u L=0.04u
M11843 U1712/net4 CRC_OUT_1_18 VDD VDD pmos W=0.205u L=0.04u
M11844 U1712/net6 U1712/net4 VDD VDD pmos W=0.24u L=0.04u
M11845 n1220 U1712/net14 VDD VDD pmos W=0.205u L=0.04u
M11846 U1712/net10 WX11205 VDD VDD pmos W=0.205u L=0.04u
M11847 U1713/net4 WX11203 U1713/net14 VSS nmos W=0.155u L=0.04u
M11848 U1713/net6 U1713/net10 U1713/net14 VSS nmos W=0.17u L=0.04u
M11849 U1713/net4 CRC_OUT_1_19 VSS VSS nmos W=0.155u L=0.04u
M11850 U1713/net6 U1713/net4 VSS VSS nmos W=0.17u L=0.04u
M11851 n1219 U1713/net14 VSS VSS nmos W=0.155u L=0.04u
M11852 U1713/net10 WX11203 VSS VSS nmos W=0.155u L=0.04u
M11853 U1713/net4 U1713/net10 U1713/net14 VDD pmos W=0.255u L=0.04u
M11854 U1713/net6 WX11203 U1713/net14 VDD pmos W=0.28u L=0.04u
M11855 U1713/net4 CRC_OUT_1_19 VDD VDD pmos W=0.205u L=0.04u
M11856 U1713/net6 U1713/net4 VDD VDD pmos W=0.24u L=0.04u
M11857 n1219 U1713/net14 VDD VDD pmos W=0.205u L=0.04u
M11858 U1713/net10 WX11203 VDD VDD pmos W=0.205u L=0.04u
M11859 U1714/net4 WX11201 U1714/net14 VSS nmos W=0.155u L=0.04u
M11860 U1714/net6 U1714/net10 U1714/net14 VSS nmos W=0.17u L=0.04u
M11861 U1714/net4 CRC_OUT_1_20 VSS VSS nmos W=0.155u L=0.04u
M11862 U1714/net6 U1714/net4 VSS VSS nmos W=0.17u L=0.04u
M11863 n1218 U1714/net14 VSS VSS nmos W=0.155u L=0.04u
M11864 U1714/net10 WX11201 VSS VSS nmos W=0.155u L=0.04u
M11865 U1714/net4 U1714/net10 U1714/net14 VDD pmos W=0.255u L=0.04u
M11866 U1714/net6 WX11201 U1714/net14 VDD pmos W=0.28u L=0.04u
M11867 U1714/net4 CRC_OUT_1_20 VDD VDD pmos W=0.205u L=0.04u
M11868 U1714/net6 U1714/net4 VDD VDD pmos W=0.24u L=0.04u
M11869 n1218 U1714/net14 VDD VDD pmos W=0.205u L=0.04u
M11870 U1714/net10 WX11201 VDD VDD pmos W=0.205u L=0.04u
M11871 U1715/net4 WX11199 U1715/net14 VSS nmos W=0.155u L=0.04u
M11872 U1715/net6 U1715/net10 U1715/net14 VSS nmos W=0.17u L=0.04u
M11873 U1715/net4 CRC_OUT_1_21 VSS VSS nmos W=0.155u L=0.04u
M11874 U1715/net6 U1715/net4 VSS VSS nmos W=0.17u L=0.04u
M11875 n1217 U1715/net14 VSS VSS nmos W=0.155u L=0.04u
M11876 U1715/net10 WX11199 VSS VSS nmos W=0.155u L=0.04u
M11877 U1715/net4 U1715/net10 U1715/net14 VDD pmos W=0.255u L=0.04u
M11878 U1715/net6 WX11199 U1715/net14 VDD pmos W=0.28u L=0.04u
M11879 U1715/net4 CRC_OUT_1_21 VDD VDD pmos W=0.205u L=0.04u
M11880 U1715/net6 U1715/net4 VDD VDD pmos W=0.24u L=0.04u
M11881 n1217 U1715/net14 VDD VDD pmos W=0.205u L=0.04u
M11882 U1715/net10 WX11199 VDD VDD pmos W=0.205u L=0.04u
M11883 U1716/net4 WX11197 U1716/net14 VSS nmos W=0.155u L=0.04u
M11884 U1716/net6 U1716/net10 U1716/net14 VSS nmos W=0.17u L=0.04u
M11885 U1716/net4 CRC_OUT_1_22 VSS VSS nmos W=0.155u L=0.04u
M11886 U1716/net6 U1716/net4 VSS VSS nmos W=0.17u L=0.04u
M11887 n1216 U1716/net14 VSS VSS nmos W=0.155u L=0.04u
M11888 U1716/net10 WX11197 VSS VSS nmos W=0.155u L=0.04u
M11889 U1716/net4 U1716/net10 U1716/net14 VDD pmos W=0.255u L=0.04u
M11890 U1716/net6 WX11197 U1716/net14 VDD pmos W=0.28u L=0.04u
M11891 U1716/net4 CRC_OUT_1_22 VDD VDD pmos W=0.205u L=0.04u
M11892 U1716/net6 U1716/net4 VDD VDD pmos W=0.24u L=0.04u
M11893 n1216 U1716/net14 VDD VDD pmos W=0.205u L=0.04u
M11894 U1716/net10 WX11197 VDD VDD pmos W=0.205u L=0.04u
M11895 U1717/net4 WX11195 U1717/net14 VSS nmos W=0.155u L=0.04u
M11896 U1717/net6 U1717/net10 U1717/net14 VSS nmos W=0.17u L=0.04u
M11897 U1717/net4 CRC_OUT_1_23 VSS VSS nmos W=0.155u L=0.04u
M11898 U1717/net6 U1717/net4 VSS VSS nmos W=0.17u L=0.04u
M11899 n1215 U1717/net14 VSS VSS nmos W=0.155u L=0.04u
M11900 U1717/net10 WX11195 VSS VSS nmos W=0.155u L=0.04u
M11901 U1717/net4 U1717/net10 U1717/net14 VDD pmos W=0.255u L=0.04u
M11902 U1717/net6 WX11195 U1717/net14 VDD pmos W=0.28u L=0.04u
M11903 U1717/net4 CRC_OUT_1_23 VDD VDD pmos W=0.205u L=0.04u
M11904 U1717/net6 U1717/net4 VDD VDD pmos W=0.24u L=0.04u
M11905 n1215 U1717/net14 VDD VDD pmos W=0.205u L=0.04u
M11906 U1717/net10 WX11195 VDD VDD pmos W=0.205u L=0.04u
M11907 U1718/net4 WX11193 U1718/net14 VSS nmos W=0.155u L=0.04u
M11908 U1718/net6 U1718/net10 U1718/net14 VSS nmos W=0.17u L=0.04u
M11909 U1718/net4 CRC_OUT_1_24 VSS VSS nmos W=0.155u L=0.04u
M11910 U1718/net6 U1718/net4 VSS VSS nmos W=0.17u L=0.04u
M11911 n1214 U1718/net14 VSS VSS nmos W=0.155u L=0.04u
M11912 U1718/net10 WX11193 VSS VSS nmos W=0.155u L=0.04u
M11913 U1718/net4 U1718/net10 U1718/net14 VDD pmos W=0.255u L=0.04u
M11914 U1718/net6 WX11193 U1718/net14 VDD pmos W=0.28u L=0.04u
M11915 U1718/net4 CRC_OUT_1_24 VDD VDD pmos W=0.205u L=0.04u
M11916 U1718/net6 U1718/net4 VDD VDD pmos W=0.24u L=0.04u
M11917 n1214 U1718/net14 VDD VDD pmos W=0.205u L=0.04u
M11918 U1718/net10 WX11193 VDD VDD pmos W=0.205u L=0.04u
M11919 U1719/net4 WX11191 U1719/net14 VSS nmos W=0.155u L=0.04u
M11920 U1719/net6 U1719/net10 U1719/net14 VSS nmos W=0.17u L=0.04u
M11921 U1719/net4 CRC_OUT_1_25 VSS VSS nmos W=0.155u L=0.04u
M11922 U1719/net6 U1719/net4 VSS VSS nmos W=0.17u L=0.04u
M11923 n1213 U1719/net14 VSS VSS nmos W=0.155u L=0.04u
M11924 U1719/net10 WX11191 VSS VSS nmos W=0.155u L=0.04u
M11925 U1719/net4 U1719/net10 U1719/net14 VDD pmos W=0.255u L=0.04u
M11926 U1719/net6 WX11191 U1719/net14 VDD pmos W=0.28u L=0.04u
M11927 U1719/net4 CRC_OUT_1_25 VDD VDD pmos W=0.205u L=0.04u
M11928 U1719/net6 U1719/net4 VDD VDD pmos W=0.24u L=0.04u
M11929 n1213 U1719/net14 VDD VDD pmos W=0.205u L=0.04u
M11930 U1719/net10 WX11191 VDD VDD pmos W=0.205u L=0.04u
M11931 U1720/net4 WX11189 U1720/net14 VSS nmos W=0.155u L=0.04u
M11932 U1720/net6 U1720/net10 U1720/net14 VSS nmos W=0.17u L=0.04u
M11933 U1720/net4 CRC_OUT_1_26 VSS VSS nmos W=0.155u L=0.04u
M11934 U1720/net6 U1720/net4 VSS VSS nmos W=0.17u L=0.04u
M11935 n1212 U1720/net14 VSS VSS nmos W=0.155u L=0.04u
M11936 U1720/net10 WX11189 VSS VSS nmos W=0.155u L=0.04u
M11937 U1720/net4 U1720/net10 U1720/net14 VDD pmos W=0.255u L=0.04u
M11938 U1720/net6 WX11189 U1720/net14 VDD pmos W=0.28u L=0.04u
M11939 U1720/net4 CRC_OUT_1_26 VDD VDD pmos W=0.205u L=0.04u
M11940 U1720/net6 U1720/net4 VDD VDD pmos W=0.24u L=0.04u
M11941 n1212 U1720/net14 VDD VDD pmos W=0.205u L=0.04u
M11942 U1720/net10 WX11189 VDD VDD pmos W=0.205u L=0.04u
M11943 U1721/net4 WX11187 U1721/net14 VSS nmos W=0.155u L=0.04u
M11944 U1721/net6 U1721/net10 U1721/net14 VSS nmos W=0.17u L=0.04u
M11945 U1721/net4 CRC_OUT_1_27 VSS VSS nmos W=0.155u L=0.04u
M11946 U1721/net6 U1721/net4 VSS VSS nmos W=0.17u L=0.04u
M11947 n1211 U1721/net14 VSS VSS nmos W=0.155u L=0.04u
M11948 U1721/net10 WX11187 VSS VSS nmos W=0.155u L=0.04u
M11949 U1721/net4 U1721/net10 U1721/net14 VDD pmos W=0.255u L=0.04u
M11950 U1721/net6 WX11187 U1721/net14 VDD pmos W=0.28u L=0.04u
M11951 U1721/net4 CRC_OUT_1_27 VDD VDD pmos W=0.205u L=0.04u
M11952 U1721/net6 U1721/net4 VDD VDD pmos W=0.24u L=0.04u
M11953 n1211 U1721/net14 VDD VDD pmos W=0.205u L=0.04u
M11954 U1721/net10 WX11187 VDD VDD pmos W=0.205u L=0.04u
M11955 U1722/net4 WX11185 U1722/net14 VSS nmos W=0.155u L=0.04u
M11956 U1722/net6 U1722/net10 U1722/net14 VSS nmos W=0.17u L=0.04u
M11957 U1722/net4 CRC_OUT_1_28 VSS VSS nmos W=0.155u L=0.04u
M11958 U1722/net6 U1722/net4 VSS VSS nmos W=0.17u L=0.04u
M11959 n1210 U1722/net14 VSS VSS nmos W=0.155u L=0.04u
M11960 U1722/net10 WX11185 VSS VSS nmos W=0.155u L=0.04u
M11961 U1722/net4 U1722/net10 U1722/net14 VDD pmos W=0.255u L=0.04u
M11962 U1722/net6 WX11185 U1722/net14 VDD pmos W=0.28u L=0.04u
M11963 U1722/net4 CRC_OUT_1_28 VDD VDD pmos W=0.205u L=0.04u
M11964 U1722/net6 U1722/net4 VDD VDD pmos W=0.24u L=0.04u
M11965 n1210 U1722/net14 VDD VDD pmos W=0.205u L=0.04u
M11966 U1722/net10 WX11185 VDD VDD pmos W=0.205u L=0.04u
M11967 U1723/net4 WX11183 U1723/net14 VSS nmos W=0.155u L=0.04u
M11968 U1723/net6 U1723/net10 U1723/net14 VSS nmos W=0.17u L=0.04u
M11969 U1723/net4 CRC_OUT_1_29 VSS VSS nmos W=0.155u L=0.04u
M11970 U1723/net6 U1723/net4 VSS VSS nmos W=0.17u L=0.04u
M11971 n1209 U1723/net14 VSS VSS nmos W=0.155u L=0.04u
M11972 U1723/net10 WX11183 VSS VSS nmos W=0.155u L=0.04u
M11973 U1723/net4 U1723/net10 U1723/net14 VDD pmos W=0.255u L=0.04u
M11974 U1723/net6 WX11183 U1723/net14 VDD pmos W=0.28u L=0.04u
M11975 U1723/net4 CRC_OUT_1_29 VDD VDD pmos W=0.205u L=0.04u
M11976 U1723/net6 U1723/net4 VDD VDD pmos W=0.24u L=0.04u
M11977 n1209 U1723/net14 VDD VDD pmos W=0.205u L=0.04u
M11978 U1723/net10 WX11183 VDD VDD pmos W=0.205u L=0.04u
M11979 U1724/net4 WX11181 U1724/net14 VSS nmos W=0.155u L=0.04u
M11980 U1724/net6 U1724/net10 U1724/net14 VSS nmos W=0.17u L=0.04u
M11981 U1724/net4 CRC_OUT_1_30 VSS VSS nmos W=0.155u L=0.04u
M11982 U1724/net6 U1724/net4 VSS VSS nmos W=0.17u L=0.04u
M11983 n1208 U1724/net14 VSS VSS nmos W=0.155u L=0.04u
M11984 U1724/net10 WX11181 VSS VSS nmos W=0.155u L=0.04u
M11985 U1724/net4 U1724/net10 U1724/net14 VDD pmos W=0.255u L=0.04u
M11986 U1724/net6 WX11181 U1724/net14 VDD pmos W=0.28u L=0.04u
M11987 U1724/net4 CRC_OUT_1_30 VDD VDD pmos W=0.205u L=0.04u
M11988 U1724/net6 U1724/net4 VDD VDD pmos W=0.24u L=0.04u
M11989 n1208 U1724/net14 VDD VDD pmos W=0.205u L=0.04u
M11990 U1724/net10 WX11181 VDD VDD pmos W=0.205u L=0.04u
M11991 U1725/net4 CRC_OUT_2_31 U1725/net14 VSS nmos W=0.155u L=0.04u
M11992 U1725/net6 U1725/net10 U1725/net14 VSS nmos W=0.17u L=0.04u
M11993 U1725/net4 WX9950 VSS VSS nmos W=0.155u L=0.04u
M11994 U1725/net6 U1725/net4 VSS VSS nmos W=0.17u L=0.04u
M11995 n1207 U1725/net14 VSS VSS nmos W=0.155u L=0.04u
M11996 U1725/net10 CRC_OUT_2_31 VSS VSS nmos W=0.155u L=0.04u
M11997 U1725/net4 U1725/net10 U1725/net14 VDD pmos W=0.255u L=0.04u
M11998 U1725/net6 CRC_OUT_2_31 U1725/net14 VDD pmos W=0.28u L=0.04u
M11999 U1725/net4 WX9950 VDD VDD pmos W=0.205u L=0.04u
M12000 U1725/net6 U1725/net4 VDD VDD pmos W=0.24u L=0.04u
M12001 n1207 U1725/net14 VDD VDD pmos W=0.205u L=0.04u
M12002 U1725/net10 CRC_OUT_2_31 VDD VDD pmos W=0.205u L=0.04u
M12003 U1726/net4 WX9948 U1726/net14 VSS nmos W=0.155u L=0.04u
M12004 U1726/net6 U1726/net10 U1726/net14 VSS nmos W=0.17u L=0.04u
M12005 U1726/net4 CRC_OUT_2_0 VSS VSS nmos W=0.155u L=0.04u
M12006 U1726/net6 U1726/net4 VSS VSS nmos W=0.17u L=0.04u
M12007 n1206 U1726/net14 VSS VSS nmos W=0.155u L=0.04u
M12008 U1726/net10 WX9948 VSS VSS nmos W=0.155u L=0.04u
M12009 U1726/net4 U1726/net10 U1726/net14 VDD pmos W=0.255u L=0.04u
M12010 U1726/net6 WX9948 U1726/net14 VDD pmos W=0.28u L=0.04u
M12011 U1726/net4 CRC_OUT_2_0 VDD VDD pmos W=0.205u L=0.04u
M12012 U1726/net6 U1726/net4 VDD VDD pmos W=0.24u L=0.04u
M12013 n1206 U1726/net14 VDD VDD pmos W=0.205u L=0.04u
M12014 U1726/net10 WX9948 VDD VDD pmos W=0.205u L=0.04u
M12015 U1727/net4 WX9946 U1727/net14 VSS nmos W=0.155u L=0.04u
M12016 U1727/net6 U1727/net10 U1727/net14 VSS nmos W=0.17u L=0.04u
M12017 U1727/net4 CRC_OUT_2_1 VSS VSS nmos W=0.155u L=0.04u
M12018 U1727/net6 U1727/net4 VSS VSS nmos W=0.17u L=0.04u
M12019 n1205 U1727/net14 VSS VSS nmos W=0.155u L=0.04u
M12020 U1727/net10 WX9946 VSS VSS nmos W=0.155u L=0.04u
M12021 U1727/net4 U1727/net10 U1727/net14 VDD pmos W=0.255u L=0.04u
M12022 U1727/net6 WX9946 U1727/net14 VDD pmos W=0.28u L=0.04u
M12023 U1727/net4 CRC_OUT_2_1 VDD VDD pmos W=0.205u L=0.04u
M12024 U1727/net6 U1727/net4 VDD VDD pmos W=0.24u L=0.04u
M12025 n1205 U1727/net14 VDD VDD pmos W=0.205u L=0.04u
M12026 U1727/net10 WX9946 VDD VDD pmos W=0.205u L=0.04u
M12027 U1728/net4 WX9944 U1728/net14 VSS nmos W=0.155u L=0.04u
M12028 U1728/net6 U1728/net10 U1728/net14 VSS nmos W=0.17u L=0.04u
M12029 U1728/net4 CRC_OUT_2_2 VSS VSS nmos W=0.155u L=0.04u
M12030 U1728/net6 U1728/net4 VSS VSS nmos W=0.17u L=0.04u
M12031 n1204 U1728/net14 VSS VSS nmos W=0.155u L=0.04u
M12032 U1728/net10 WX9944 VSS VSS nmos W=0.155u L=0.04u
M12033 U1728/net4 U1728/net10 U1728/net14 VDD pmos W=0.255u L=0.04u
M12034 U1728/net6 WX9944 U1728/net14 VDD pmos W=0.28u L=0.04u
M12035 U1728/net4 CRC_OUT_2_2 VDD VDD pmos W=0.205u L=0.04u
M12036 U1728/net6 U1728/net4 VDD VDD pmos W=0.24u L=0.04u
M12037 n1204 U1728/net14 VDD VDD pmos W=0.205u L=0.04u
M12038 U1728/net10 WX9944 VDD VDD pmos W=0.205u L=0.04u
M12039 U1729/net11 CRC_OUT_2_31 U1729/net17 VSS nmos W=0.155u L=0.04u
M12040 U1729/net5 U1729/net17 U1729/net21 VSS nmos W=0.155u L=0.04u
M12041 U1729/net5 CRC_OUT_2_3 VSS VSS nmos W=0.155u L=0.04u
M12042 n1203 U1729/net21 VSS VSS nmos W=0.155u L=0.04u
M12043 U1729/net16 CRC_OUT_2_31 VSS VSS nmos W=0.155u L=0.04u
M12044 U1729/net11 WX9942 VSS VSS nmos W=0.155u L=0.04u
M12045 U1729/net13 U1729/net17 VSS VSS nmos W=0.155u L=0.04u
M12046 U1729/net17 U1729/net16 U1729/XI2-net16 VSS nmos W=0.155u L=0.04u
M12047 U1729/XI2-net16 U1729/net11 VSS VSS nmos W=0.155u L=0.04u
M12048 U1729/net21 U1729/net13 U1729/XU21-net16 VSS nmos W=0.155u L=0.04u
M12049 U1729/XU21-net16 U1729/net5 VSS VSS nmos W=0.155u L=0.04u
M12050 U1729/net11 U1729/net16 U1729/net17 VDD pmos W=0.205u L=0.04u
M12051 U1729/net5 U1729/net13 U1729/net21 VDD pmos W=0.205u L=0.04u
M12052 U1729/net5 CRC_OUT_2_3 VDD VDD pmos W=0.205u L=0.04u
M12053 n1203 U1729/net21 VDD VDD pmos W=0.205u L=0.04u
M12054 U1729/net16 CRC_OUT_2_31 VDD VDD pmos W=0.205u L=0.04u
M12055 U1729/net11 WX9942 VDD VDD pmos W=0.205u L=0.04u
M12056 U1729/net13 U1729/net17 VDD VDD pmos W=0.205u L=0.04u
M12057 U1729/net17 CRC_OUT_2_31 U1729/XI2-net6 VDD pmos W=0.205u L=0.04u
M12058 U1729/XI2-net6 U1729/net11 VDD VDD pmos W=0.205u L=0.04u
M12059 U1729/net21 U1729/net17 U1729/XU21-net6 VDD pmos W=0.205u L=0.04u
M12060 U1729/XU21-net6 U1729/net5 VDD VDD pmos W=0.205u L=0.04u
M12061 U1730/net4 WX9940 U1730/net14 VSS nmos W=0.155u L=0.04u
M12062 U1730/net6 U1730/net10 U1730/net14 VSS nmos W=0.17u L=0.04u
M12063 U1730/net4 CRC_OUT_2_4 VSS VSS nmos W=0.155u L=0.04u
M12064 U1730/net6 U1730/net4 VSS VSS nmos W=0.17u L=0.04u
M12065 n1202 U1730/net14 VSS VSS nmos W=0.155u L=0.04u
M12066 U1730/net10 WX9940 VSS VSS nmos W=0.155u L=0.04u
M12067 U1730/net4 U1730/net10 U1730/net14 VDD pmos W=0.255u L=0.04u
M12068 U1730/net6 WX9940 U1730/net14 VDD pmos W=0.28u L=0.04u
M12069 U1730/net4 CRC_OUT_2_4 VDD VDD pmos W=0.205u L=0.04u
M12070 U1730/net6 U1730/net4 VDD VDD pmos W=0.24u L=0.04u
M12071 n1202 U1730/net14 VDD VDD pmos W=0.205u L=0.04u
M12072 U1730/net10 WX9940 VDD VDD pmos W=0.205u L=0.04u
M12073 U1731/net4 WX9938 U1731/net14 VSS nmos W=0.155u L=0.04u
M12074 U1731/net6 U1731/net10 U1731/net14 VSS nmos W=0.17u L=0.04u
M12075 U1731/net4 CRC_OUT_2_5 VSS VSS nmos W=0.155u L=0.04u
M12076 U1731/net6 U1731/net4 VSS VSS nmos W=0.17u L=0.04u
M12077 n1201 U1731/net14 VSS VSS nmos W=0.155u L=0.04u
M12078 U1731/net10 WX9938 VSS VSS nmos W=0.155u L=0.04u
M12079 U1731/net4 U1731/net10 U1731/net14 VDD pmos W=0.255u L=0.04u
M12080 U1731/net6 WX9938 U1731/net14 VDD pmos W=0.28u L=0.04u
M12081 U1731/net4 CRC_OUT_2_5 VDD VDD pmos W=0.205u L=0.04u
M12082 U1731/net6 U1731/net4 VDD VDD pmos W=0.24u L=0.04u
M12083 n1201 U1731/net14 VDD VDD pmos W=0.205u L=0.04u
M12084 U1731/net10 WX9938 VDD VDD pmos W=0.205u L=0.04u
M12085 U1732/net4 WX9936 U1732/net14 VSS nmos W=0.155u L=0.04u
M12086 U1732/net6 U1732/net10 U1732/net14 VSS nmos W=0.17u L=0.04u
M12087 U1732/net4 CRC_OUT_2_6 VSS VSS nmos W=0.155u L=0.04u
M12088 U1732/net6 U1732/net4 VSS VSS nmos W=0.17u L=0.04u
M12089 n1200 U1732/net14 VSS VSS nmos W=0.155u L=0.04u
M12090 U1732/net10 WX9936 VSS VSS nmos W=0.155u L=0.04u
M12091 U1732/net4 U1732/net10 U1732/net14 VDD pmos W=0.255u L=0.04u
M12092 U1732/net6 WX9936 U1732/net14 VDD pmos W=0.28u L=0.04u
M12093 U1732/net4 CRC_OUT_2_6 VDD VDD pmos W=0.205u L=0.04u
M12094 U1732/net6 U1732/net4 VDD VDD pmos W=0.24u L=0.04u
M12095 n1200 U1732/net14 VDD VDD pmos W=0.205u L=0.04u
M12096 U1732/net10 WX9936 VDD VDD pmos W=0.205u L=0.04u
M12097 U1733/net4 WX9934 U1733/net14 VSS nmos W=0.155u L=0.04u
M12098 U1733/net6 U1733/net10 U1733/net14 VSS nmos W=0.17u L=0.04u
M12099 U1733/net4 CRC_OUT_2_7 VSS VSS nmos W=0.155u L=0.04u
M12100 U1733/net6 U1733/net4 VSS VSS nmos W=0.17u L=0.04u
M12101 n1199 U1733/net14 VSS VSS nmos W=0.155u L=0.04u
M12102 U1733/net10 WX9934 VSS VSS nmos W=0.155u L=0.04u
M12103 U1733/net4 U1733/net10 U1733/net14 VDD pmos W=0.255u L=0.04u
M12104 U1733/net6 WX9934 U1733/net14 VDD pmos W=0.28u L=0.04u
M12105 U1733/net4 CRC_OUT_2_7 VDD VDD pmos W=0.205u L=0.04u
M12106 U1733/net6 U1733/net4 VDD VDD pmos W=0.24u L=0.04u
M12107 n1199 U1733/net14 VDD VDD pmos W=0.205u L=0.04u
M12108 U1733/net10 WX9934 VDD VDD pmos W=0.205u L=0.04u
M12109 U1734/net4 WX9932 U1734/net14 VSS nmos W=0.155u L=0.04u
M12110 U1734/net6 U1734/net10 U1734/net14 VSS nmos W=0.17u L=0.04u
M12111 U1734/net4 CRC_OUT_2_8 VSS VSS nmos W=0.155u L=0.04u
M12112 U1734/net6 U1734/net4 VSS VSS nmos W=0.17u L=0.04u
M12113 n1198 U1734/net14 VSS VSS nmos W=0.155u L=0.04u
M12114 U1734/net10 WX9932 VSS VSS nmos W=0.155u L=0.04u
M12115 U1734/net4 U1734/net10 U1734/net14 VDD pmos W=0.255u L=0.04u
M12116 U1734/net6 WX9932 U1734/net14 VDD pmos W=0.28u L=0.04u
M12117 U1734/net4 CRC_OUT_2_8 VDD VDD pmos W=0.205u L=0.04u
M12118 U1734/net6 U1734/net4 VDD VDD pmos W=0.24u L=0.04u
M12119 n1198 U1734/net14 VDD VDD pmos W=0.205u L=0.04u
M12120 U1734/net10 WX9932 VDD VDD pmos W=0.205u L=0.04u
M12121 U1735/net4 WX9930 U1735/net14 VSS nmos W=0.155u L=0.04u
M12122 U1735/net6 U1735/net10 U1735/net14 VSS nmos W=0.17u L=0.04u
M12123 U1735/net4 CRC_OUT_2_9 VSS VSS nmos W=0.155u L=0.04u
M12124 U1735/net6 U1735/net4 VSS VSS nmos W=0.17u L=0.04u
M12125 n1197 U1735/net14 VSS VSS nmos W=0.155u L=0.04u
M12126 U1735/net10 WX9930 VSS VSS nmos W=0.155u L=0.04u
M12127 U1735/net4 U1735/net10 U1735/net14 VDD pmos W=0.255u L=0.04u
M12128 U1735/net6 WX9930 U1735/net14 VDD pmos W=0.28u L=0.04u
M12129 U1735/net4 CRC_OUT_2_9 VDD VDD pmos W=0.205u L=0.04u
M12130 U1735/net6 U1735/net4 VDD VDD pmos W=0.24u L=0.04u
M12131 n1197 U1735/net14 VDD VDD pmos W=0.205u L=0.04u
M12132 U1735/net10 WX9930 VDD VDD pmos W=0.205u L=0.04u
M12133 U1736/net11 CRC_OUT_2_31 U1736/net17 VSS nmos W=0.155u L=0.04u
M12134 U1736/net5 U1736/net17 U1736/net21 VSS nmos W=0.155u L=0.04u
M12135 U1736/net5 CRC_OUT_2_10 VSS VSS nmos W=0.155u L=0.04u
M12136 n1196 U1736/net21 VSS VSS nmos W=0.155u L=0.04u
M12137 U1736/net16 CRC_OUT_2_31 VSS VSS nmos W=0.155u L=0.04u
M12138 U1736/net11 WX9928 VSS VSS nmos W=0.155u L=0.04u
M12139 U1736/net13 U1736/net17 VSS VSS nmos W=0.155u L=0.04u
M12140 U1736/net17 U1736/net16 U1736/XI2-net16 VSS nmos W=0.155u L=0.04u
M12141 U1736/XI2-net16 U1736/net11 VSS VSS nmos W=0.155u L=0.04u
M12142 U1736/net21 U1736/net13 U1736/XU21-net16 VSS nmos W=0.155u L=0.04u
M12143 U1736/XU21-net16 U1736/net5 VSS VSS nmos W=0.155u L=0.04u
M12144 U1736/net11 U1736/net16 U1736/net17 VDD pmos W=0.205u L=0.04u
M12145 U1736/net5 U1736/net13 U1736/net21 VDD pmos W=0.205u L=0.04u
M12146 U1736/net5 CRC_OUT_2_10 VDD VDD pmos W=0.205u L=0.04u
M12147 n1196 U1736/net21 VDD VDD pmos W=0.205u L=0.04u
M12148 U1736/net16 CRC_OUT_2_31 VDD VDD pmos W=0.205u L=0.04u
M12149 U1736/net11 WX9928 VDD VDD pmos W=0.205u L=0.04u
M12150 U1736/net13 U1736/net17 VDD VDD pmos W=0.205u L=0.04u
M12151 U1736/net17 CRC_OUT_2_31 U1736/XI2-net6 VDD pmos W=0.205u L=0.04u
M12152 U1736/XI2-net6 U1736/net11 VDD VDD pmos W=0.205u L=0.04u
M12153 U1736/net21 U1736/net17 U1736/XU21-net6 VDD pmos W=0.205u L=0.04u
M12154 U1736/XU21-net6 U1736/net5 VDD VDD pmos W=0.205u L=0.04u
M12155 U1737/net4 WX9926 U1737/net14 VSS nmos W=0.155u L=0.04u
M12156 U1737/net6 U1737/net10 U1737/net14 VSS nmos W=0.17u L=0.04u
M12157 U1737/net4 CRC_OUT_2_11 VSS VSS nmos W=0.155u L=0.04u
M12158 U1737/net6 U1737/net4 VSS VSS nmos W=0.17u L=0.04u
M12159 n1195 U1737/net14 VSS VSS nmos W=0.155u L=0.04u
M12160 U1737/net10 WX9926 VSS VSS nmos W=0.155u L=0.04u
M12161 U1737/net4 U1737/net10 U1737/net14 VDD pmos W=0.255u L=0.04u
M12162 U1737/net6 WX9926 U1737/net14 VDD pmos W=0.28u L=0.04u
M12163 U1737/net4 CRC_OUT_2_11 VDD VDD pmos W=0.205u L=0.04u
M12164 U1737/net6 U1737/net4 VDD VDD pmos W=0.24u L=0.04u
M12165 n1195 U1737/net14 VDD VDD pmos W=0.205u L=0.04u
M12166 U1737/net10 WX9926 VDD VDD pmos W=0.205u L=0.04u
M12167 U1738/net4 WX9924 U1738/net14 VSS nmos W=0.155u L=0.04u
M12168 U1738/net6 U1738/net10 U1738/net14 VSS nmos W=0.17u L=0.04u
M12169 U1738/net4 CRC_OUT_2_12 VSS VSS nmos W=0.155u L=0.04u
M12170 U1738/net6 U1738/net4 VSS VSS nmos W=0.17u L=0.04u
M12171 n1194 U1738/net14 VSS VSS nmos W=0.155u L=0.04u
M12172 U1738/net10 WX9924 VSS VSS nmos W=0.155u L=0.04u
M12173 U1738/net4 U1738/net10 U1738/net14 VDD pmos W=0.255u L=0.04u
M12174 U1738/net6 WX9924 U1738/net14 VDD pmos W=0.28u L=0.04u
M12175 U1738/net4 CRC_OUT_2_12 VDD VDD pmos W=0.205u L=0.04u
M12176 U1738/net6 U1738/net4 VDD VDD pmos W=0.24u L=0.04u
M12177 n1194 U1738/net14 VDD VDD pmos W=0.205u L=0.04u
M12178 U1738/net10 WX9924 VDD VDD pmos W=0.205u L=0.04u
M12179 U1739/net4 WX9922 U1739/net14 VSS nmos W=0.155u L=0.04u
M12180 U1739/net6 U1739/net10 U1739/net14 VSS nmos W=0.17u L=0.04u
M12181 U1739/net4 CRC_OUT_2_13 VSS VSS nmos W=0.155u L=0.04u
M12182 U1739/net6 U1739/net4 VSS VSS nmos W=0.17u L=0.04u
M12183 n1193 U1739/net14 VSS VSS nmos W=0.155u L=0.04u
M12184 U1739/net10 WX9922 VSS VSS nmos W=0.155u L=0.04u
M12185 U1739/net4 U1739/net10 U1739/net14 VDD pmos W=0.255u L=0.04u
M12186 U1739/net6 WX9922 U1739/net14 VDD pmos W=0.28u L=0.04u
M12187 U1739/net4 CRC_OUT_2_13 VDD VDD pmos W=0.205u L=0.04u
M12188 U1739/net6 U1739/net4 VDD VDD pmos W=0.24u L=0.04u
M12189 n1193 U1739/net14 VDD VDD pmos W=0.205u L=0.04u
M12190 U1739/net10 WX9922 VDD VDD pmos W=0.205u L=0.04u
M12191 U1740/net4 WX9920 U1740/net14 VSS nmos W=0.155u L=0.04u
M12192 U1740/net6 U1740/net10 U1740/net14 VSS nmos W=0.17u L=0.04u
M12193 U1740/net4 CRC_OUT_2_14 VSS VSS nmos W=0.155u L=0.04u
M12194 U1740/net6 U1740/net4 VSS VSS nmos W=0.17u L=0.04u
M12195 n1192 U1740/net14 VSS VSS nmos W=0.155u L=0.04u
M12196 U1740/net10 WX9920 VSS VSS nmos W=0.155u L=0.04u
M12197 U1740/net4 U1740/net10 U1740/net14 VDD pmos W=0.255u L=0.04u
M12198 U1740/net6 WX9920 U1740/net14 VDD pmos W=0.28u L=0.04u
M12199 U1740/net4 CRC_OUT_2_14 VDD VDD pmos W=0.205u L=0.04u
M12200 U1740/net6 U1740/net4 VDD VDD pmos W=0.24u L=0.04u
M12201 n1192 U1740/net14 VDD VDD pmos W=0.205u L=0.04u
M12202 U1740/net10 WX9920 VDD VDD pmos W=0.205u L=0.04u
M12203 U1741/net11 CRC_OUT_2_31 U1741/net17 VSS nmos W=0.155u L=0.04u
M12204 U1741/net5 U1741/net17 U1741/net21 VSS nmos W=0.155u L=0.04u
M12205 U1741/net5 CRC_OUT_2_15 VSS VSS nmos W=0.155u L=0.04u
M12206 n1191 U1741/net21 VSS VSS nmos W=0.155u L=0.04u
M12207 U1741/net16 CRC_OUT_2_31 VSS VSS nmos W=0.155u L=0.04u
M12208 U1741/net11 WX9918 VSS VSS nmos W=0.155u L=0.04u
M12209 U1741/net13 U1741/net17 VSS VSS nmos W=0.155u L=0.04u
M12210 U1741/net17 U1741/net16 U1741/XI2-net16 VSS nmos W=0.155u L=0.04u
M12211 U1741/XI2-net16 U1741/net11 VSS VSS nmos W=0.155u L=0.04u
M12212 U1741/net21 U1741/net13 U1741/XU21-net16 VSS nmos W=0.155u L=0.04u
M12213 U1741/XU21-net16 U1741/net5 VSS VSS nmos W=0.155u L=0.04u
M12214 U1741/net11 U1741/net16 U1741/net17 VDD pmos W=0.205u L=0.04u
M12215 U1741/net5 U1741/net13 U1741/net21 VDD pmos W=0.205u L=0.04u
M12216 U1741/net5 CRC_OUT_2_15 VDD VDD pmos W=0.205u L=0.04u
M12217 n1191 U1741/net21 VDD VDD pmos W=0.205u L=0.04u
M12218 U1741/net16 CRC_OUT_2_31 VDD VDD pmos W=0.205u L=0.04u
M12219 U1741/net11 WX9918 VDD VDD pmos W=0.205u L=0.04u
M12220 U1741/net13 U1741/net17 VDD VDD pmos W=0.205u L=0.04u
M12221 U1741/net17 CRC_OUT_2_31 U1741/XI2-net6 VDD pmos W=0.205u L=0.04u
M12222 U1741/XI2-net6 U1741/net11 VDD VDD pmos W=0.205u L=0.04u
M12223 U1741/net21 U1741/net17 U1741/XU21-net6 VDD pmos W=0.205u L=0.04u
M12224 U1741/XU21-net6 U1741/net5 VDD VDD pmos W=0.205u L=0.04u
M12225 U1742/net4 WX9916 U1742/net14 VSS nmos W=0.155u L=0.04u
M12226 U1742/net6 U1742/net10 U1742/net14 VSS nmos W=0.17u L=0.04u
M12227 U1742/net4 CRC_OUT_2_16 VSS VSS nmos W=0.155u L=0.04u
M12228 U1742/net6 U1742/net4 VSS VSS nmos W=0.17u L=0.04u
M12229 n1190 U1742/net14 VSS VSS nmos W=0.155u L=0.04u
M12230 U1742/net10 WX9916 VSS VSS nmos W=0.155u L=0.04u
M12231 U1742/net4 U1742/net10 U1742/net14 VDD pmos W=0.255u L=0.04u
M12232 U1742/net6 WX9916 U1742/net14 VDD pmos W=0.28u L=0.04u
M12233 U1742/net4 CRC_OUT_2_16 VDD VDD pmos W=0.205u L=0.04u
M12234 U1742/net6 U1742/net4 VDD VDD pmos W=0.24u L=0.04u
M12235 n1190 U1742/net14 VDD VDD pmos W=0.205u L=0.04u
M12236 U1742/net10 WX9916 VDD VDD pmos W=0.205u L=0.04u
M12237 U1743/net4 WX9914 U1743/net14 VSS nmos W=0.155u L=0.04u
M12238 U1743/net6 U1743/net10 U1743/net14 VSS nmos W=0.17u L=0.04u
M12239 U1743/net4 CRC_OUT_2_17 VSS VSS nmos W=0.155u L=0.04u
M12240 U1743/net6 U1743/net4 VSS VSS nmos W=0.17u L=0.04u
M12241 n1189 U1743/net14 VSS VSS nmos W=0.155u L=0.04u
M12242 U1743/net10 WX9914 VSS VSS nmos W=0.155u L=0.04u
M12243 U1743/net4 U1743/net10 U1743/net14 VDD pmos W=0.255u L=0.04u
M12244 U1743/net6 WX9914 U1743/net14 VDD pmos W=0.28u L=0.04u
M12245 U1743/net4 CRC_OUT_2_17 VDD VDD pmos W=0.205u L=0.04u
M12246 U1743/net6 U1743/net4 VDD VDD pmos W=0.24u L=0.04u
M12247 n1189 U1743/net14 VDD VDD pmos W=0.205u L=0.04u
M12248 U1743/net10 WX9914 VDD VDD pmos W=0.205u L=0.04u
M12249 U1744/net4 WX9912 U1744/net14 VSS nmos W=0.155u L=0.04u
M12250 U1744/net6 U1744/net10 U1744/net14 VSS nmos W=0.17u L=0.04u
M12251 U1744/net4 CRC_OUT_2_18 VSS VSS nmos W=0.155u L=0.04u
M12252 U1744/net6 U1744/net4 VSS VSS nmos W=0.17u L=0.04u
M12253 n1188 U1744/net14 VSS VSS nmos W=0.155u L=0.04u
M12254 U1744/net10 WX9912 VSS VSS nmos W=0.155u L=0.04u
M12255 U1744/net4 U1744/net10 U1744/net14 VDD pmos W=0.255u L=0.04u
M12256 U1744/net6 WX9912 U1744/net14 VDD pmos W=0.28u L=0.04u
M12257 U1744/net4 CRC_OUT_2_18 VDD VDD pmos W=0.205u L=0.04u
M12258 U1744/net6 U1744/net4 VDD VDD pmos W=0.24u L=0.04u
M12259 n1188 U1744/net14 VDD VDD pmos W=0.205u L=0.04u
M12260 U1744/net10 WX9912 VDD VDD pmos W=0.205u L=0.04u
M12261 U1745/net4 WX9910 U1745/net14 VSS nmos W=0.155u L=0.04u
M12262 U1745/net6 U1745/net10 U1745/net14 VSS nmos W=0.17u L=0.04u
M12263 U1745/net4 CRC_OUT_2_19 VSS VSS nmos W=0.155u L=0.04u
M12264 U1745/net6 U1745/net4 VSS VSS nmos W=0.17u L=0.04u
M12265 n1187 U1745/net14 VSS VSS nmos W=0.155u L=0.04u
M12266 U1745/net10 WX9910 VSS VSS nmos W=0.155u L=0.04u
M12267 U1745/net4 U1745/net10 U1745/net14 VDD pmos W=0.255u L=0.04u
M12268 U1745/net6 WX9910 U1745/net14 VDD pmos W=0.28u L=0.04u
M12269 U1745/net4 CRC_OUT_2_19 VDD VDD pmos W=0.205u L=0.04u
M12270 U1745/net6 U1745/net4 VDD VDD pmos W=0.24u L=0.04u
M12271 n1187 U1745/net14 VDD VDD pmos W=0.205u L=0.04u
M12272 U1745/net10 WX9910 VDD VDD pmos W=0.205u L=0.04u
M12273 U1746/net4 WX9908 U1746/net14 VSS nmos W=0.155u L=0.04u
M12274 U1746/net6 U1746/net10 U1746/net14 VSS nmos W=0.17u L=0.04u
M12275 U1746/net4 CRC_OUT_2_20 VSS VSS nmos W=0.155u L=0.04u
M12276 U1746/net6 U1746/net4 VSS VSS nmos W=0.17u L=0.04u
M12277 n1186 U1746/net14 VSS VSS nmos W=0.155u L=0.04u
M12278 U1746/net10 WX9908 VSS VSS nmos W=0.155u L=0.04u
M12279 U1746/net4 U1746/net10 U1746/net14 VDD pmos W=0.255u L=0.04u
M12280 U1746/net6 WX9908 U1746/net14 VDD pmos W=0.28u L=0.04u
M12281 U1746/net4 CRC_OUT_2_20 VDD VDD pmos W=0.205u L=0.04u
M12282 U1746/net6 U1746/net4 VDD VDD pmos W=0.24u L=0.04u
M12283 n1186 U1746/net14 VDD VDD pmos W=0.205u L=0.04u
M12284 U1746/net10 WX9908 VDD VDD pmos W=0.205u L=0.04u
M12285 U1747/net4 WX9906 U1747/net14 VSS nmos W=0.155u L=0.04u
M12286 U1747/net6 U1747/net10 U1747/net14 VSS nmos W=0.17u L=0.04u
M12287 U1747/net4 CRC_OUT_2_21 VSS VSS nmos W=0.155u L=0.04u
M12288 U1747/net6 U1747/net4 VSS VSS nmos W=0.17u L=0.04u
M12289 n1185 U1747/net14 VSS VSS nmos W=0.155u L=0.04u
M12290 U1747/net10 WX9906 VSS VSS nmos W=0.155u L=0.04u
M12291 U1747/net4 U1747/net10 U1747/net14 VDD pmos W=0.255u L=0.04u
M12292 U1747/net6 WX9906 U1747/net14 VDD pmos W=0.28u L=0.04u
M12293 U1747/net4 CRC_OUT_2_21 VDD VDD pmos W=0.205u L=0.04u
M12294 U1747/net6 U1747/net4 VDD VDD pmos W=0.24u L=0.04u
M12295 n1185 U1747/net14 VDD VDD pmos W=0.205u L=0.04u
M12296 U1747/net10 WX9906 VDD VDD pmos W=0.205u L=0.04u
M12297 U1748/net4 WX9904 U1748/net14 VSS nmos W=0.155u L=0.04u
M12298 U1748/net6 U1748/net10 U1748/net14 VSS nmos W=0.17u L=0.04u
M12299 U1748/net4 CRC_OUT_2_22 VSS VSS nmos W=0.155u L=0.04u
M12300 U1748/net6 U1748/net4 VSS VSS nmos W=0.17u L=0.04u
M12301 n1184 U1748/net14 VSS VSS nmos W=0.155u L=0.04u
M12302 U1748/net10 WX9904 VSS VSS nmos W=0.155u L=0.04u
M12303 U1748/net4 U1748/net10 U1748/net14 VDD pmos W=0.255u L=0.04u
M12304 U1748/net6 WX9904 U1748/net14 VDD pmos W=0.28u L=0.04u
M12305 U1748/net4 CRC_OUT_2_22 VDD VDD pmos W=0.205u L=0.04u
M12306 U1748/net6 U1748/net4 VDD VDD pmos W=0.24u L=0.04u
M12307 n1184 U1748/net14 VDD VDD pmos W=0.205u L=0.04u
M12308 U1748/net10 WX9904 VDD VDD pmos W=0.205u L=0.04u
M12309 U1749/net4 WX9902 U1749/net14 VSS nmos W=0.155u L=0.04u
M12310 U1749/net6 U1749/net10 U1749/net14 VSS nmos W=0.17u L=0.04u
M12311 U1749/net4 CRC_OUT_2_23 VSS VSS nmos W=0.155u L=0.04u
M12312 U1749/net6 U1749/net4 VSS VSS nmos W=0.17u L=0.04u
M12313 n1183 U1749/net14 VSS VSS nmos W=0.155u L=0.04u
M12314 U1749/net10 WX9902 VSS VSS nmos W=0.155u L=0.04u
M12315 U1749/net4 U1749/net10 U1749/net14 VDD pmos W=0.255u L=0.04u
M12316 U1749/net6 WX9902 U1749/net14 VDD pmos W=0.28u L=0.04u
M12317 U1749/net4 CRC_OUT_2_23 VDD VDD pmos W=0.205u L=0.04u
M12318 U1749/net6 U1749/net4 VDD VDD pmos W=0.24u L=0.04u
M12319 n1183 U1749/net14 VDD VDD pmos W=0.205u L=0.04u
M12320 U1749/net10 WX9902 VDD VDD pmos W=0.205u L=0.04u
M12321 U1750/net4 WX9900 U1750/net14 VSS nmos W=0.155u L=0.04u
M12322 U1750/net6 U1750/net10 U1750/net14 VSS nmos W=0.17u L=0.04u
M12323 U1750/net4 CRC_OUT_2_24 VSS VSS nmos W=0.155u L=0.04u
M12324 U1750/net6 U1750/net4 VSS VSS nmos W=0.17u L=0.04u
M12325 n1182 U1750/net14 VSS VSS nmos W=0.155u L=0.04u
M12326 U1750/net10 WX9900 VSS VSS nmos W=0.155u L=0.04u
M12327 U1750/net4 U1750/net10 U1750/net14 VDD pmos W=0.255u L=0.04u
M12328 U1750/net6 WX9900 U1750/net14 VDD pmos W=0.28u L=0.04u
M12329 U1750/net4 CRC_OUT_2_24 VDD VDD pmos W=0.205u L=0.04u
M12330 U1750/net6 U1750/net4 VDD VDD pmos W=0.24u L=0.04u
M12331 n1182 U1750/net14 VDD VDD pmos W=0.205u L=0.04u
M12332 U1750/net10 WX9900 VDD VDD pmos W=0.205u L=0.04u
M12333 U1751/net4 WX9898 U1751/net14 VSS nmos W=0.155u L=0.04u
M12334 U1751/net6 U1751/net10 U1751/net14 VSS nmos W=0.17u L=0.04u
M12335 U1751/net4 CRC_OUT_2_25 VSS VSS nmos W=0.155u L=0.04u
M12336 U1751/net6 U1751/net4 VSS VSS nmos W=0.17u L=0.04u
M12337 n1181 U1751/net14 VSS VSS nmos W=0.155u L=0.04u
M12338 U1751/net10 WX9898 VSS VSS nmos W=0.155u L=0.04u
M12339 U1751/net4 U1751/net10 U1751/net14 VDD pmos W=0.255u L=0.04u
M12340 U1751/net6 WX9898 U1751/net14 VDD pmos W=0.28u L=0.04u
M12341 U1751/net4 CRC_OUT_2_25 VDD VDD pmos W=0.205u L=0.04u
M12342 U1751/net6 U1751/net4 VDD VDD pmos W=0.24u L=0.04u
M12343 n1181 U1751/net14 VDD VDD pmos W=0.205u L=0.04u
M12344 U1751/net10 WX9898 VDD VDD pmos W=0.205u L=0.04u
M12345 U1752/net4 WX9896 U1752/net14 VSS nmos W=0.155u L=0.04u
M12346 U1752/net6 U1752/net10 U1752/net14 VSS nmos W=0.17u L=0.04u
M12347 U1752/net4 CRC_OUT_2_26 VSS VSS nmos W=0.155u L=0.04u
M12348 U1752/net6 U1752/net4 VSS VSS nmos W=0.17u L=0.04u
M12349 n1180 U1752/net14 VSS VSS nmos W=0.155u L=0.04u
M12350 U1752/net10 WX9896 VSS VSS nmos W=0.155u L=0.04u
M12351 U1752/net4 U1752/net10 U1752/net14 VDD pmos W=0.255u L=0.04u
M12352 U1752/net6 WX9896 U1752/net14 VDD pmos W=0.28u L=0.04u
M12353 U1752/net4 CRC_OUT_2_26 VDD VDD pmos W=0.205u L=0.04u
M12354 U1752/net6 U1752/net4 VDD VDD pmos W=0.24u L=0.04u
M12355 n1180 U1752/net14 VDD VDD pmos W=0.205u L=0.04u
M12356 U1752/net10 WX9896 VDD VDD pmos W=0.205u L=0.04u
M12357 U1753/net4 WX9894 U1753/net14 VSS nmos W=0.155u L=0.04u
M12358 U1753/net6 U1753/net10 U1753/net14 VSS nmos W=0.17u L=0.04u
M12359 U1753/net4 CRC_OUT_2_27 VSS VSS nmos W=0.155u L=0.04u
M12360 U1753/net6 U1753/net4 VSS VSS nmos W=0.17u L=0.04u
M12361 n1179 U1753/net14 VSS VSS nmos W=0.155u L=0.04u
M12362 U1753/net10 WX9894 VSS VSS nmos W=0.155u L=0.04u
M12363 U1753/net4 U1753/net10 U1753/net14 VDD pmos W=0.255u L=0.04u
M12364 U1753/net6 WX9894 U1753/net14 VDD pmos W=0.28u L=0.04u
M12365 U1753/net4 CRC_OUT_2_27 VDD VDD pmos W=0.205u L=0.04u
M12366 U1753/net6 U1753/net4 VDD VDD pmos W=0.24u L=0.04u
M12367 n1179 U1753/net14 VDD VDD pmos W=0.205u L=0.04u
M12368 U1753/net10 WX9894 VDD VDD pmos W=0.205u L=0.04u
M12369 U1754/net4 WX9892 U1754/net14 VSS nmos W=0.155u L=0.04u
M12370 U1754/net6 U1754/net10 U1754/net14 VSS nmos W=0.17u L=0.04u
M12371 U1754/net4 CRC_OUT_2_28 VSS VSS nmos W=0.155u L=0.04u
M12372 U1754/net6 U1754/net4 VSS VSS nmos W=0.17u L=0.04u
M12373 n1178 U1754/net14 VSS VSS nmos W=0.155u L=0.04u
M12374 U1754/net10 WX9892 VSS VSS nmos W=0.155u L=0.04u
M12375 U1754/net4 U1754/net10 U1754/net14 VDD pmos W=0.255u L=0.04u
M12376 U1754/net6 WX9892 U1754/net14 VDD pmos W=0.28u L=0.04u
M12377 U1754/net4 CRC_OUT_2_28 VDD VDD pmos W=0.205u L=0.04u
M12378 U1754/net6 U1754/net4 VDD VDD pmos W=0.24u L=0.04u
M12379 n1178 U1754/net14 VDD VDD pmos W=0.205u L=0.04u
M12380 U1754/net10 WX9892 VDD VDD pmos W=0.205u L=0.04u
M12381 U1755/net4 WX9890 U1755/net14 VSS nmos W=0.155u L=0.04u
M12382 U1755/net6 U1755/net10 U1755/net14 VSS nmos W=0.17u L=0.04u
M12383 U1755/net4 CRC_OUT_2_29 VSS VSS nmos W=0.155u L=0.04u
M12384 U1755/net6 U1755/net4 VSS VSS nmos W=0.17u L=0.04u
M12385 n1177 U1755/net14 VSS VSS nmos W=0.155u L=0.04u
M12386 U1755/net10 WX9890 VSS VSS nmos W=0.155u L=0.04u
M12387 U1755/net4 U1755/net10 U1755/net14 VDD pmos W=0.255u L=0.04u
M12388 U1755/net6 WX9890 U1755/net14 VDD pmos W=0.28u L=0.04u
M12389 U1755/net4 CRC_OUT_2_29 VDD VDD pmos W=0.205u L=0.04u
M12390 U1755/net6 U1755/net4 VDD VDD pmos W=0.24u L=0.04u
M12391 n1177 U1755/net14 VDD VDD pmos W=0.205u L=0.04u
M12392 U1755/net10 WX9890 VDD VDD pmos W=0.205u L=0.04u
M12393 U1756/net4 WX9888 U1756/net14 VSS nmos W=0.155u L=0.04u
M12394 U1756/net6 U1756/net10 U1756/net14 VSS nmos W=0.17u L=0.04u
M12395 U1756/net4 CRC_OUT_2_30 VSS VSS nmos W=0.155u L=0.04u
M12396 U1756/net6 U1756/net4 VSS VSS nmos W=0.17u L=0.04u
M12397 n1176 U1756/net14 VSS VSS nmos W=0.155u L=0.04u
M12398 U1756/net10 WX9888 VSS VSS nmos W=0.155u L=0.04u
M12399 U1756/net4 U1756/net10 U1756/net14 VDD pmos W=0.255u L=0.04u
M12400 U1756/net6 WX9888 U1756/net14 VDD pmos W=0.28u L=0.04u
M12401 U1756/net4 CRC_OUT_2_30 VDD VDD pmos W=0.205u L=0.04u
M12402 U1756/net6 U1756/net4 VDD VDD pmos W=0.24u L=0.04u
M12403 n1176 U1756/net14 VDD VDD pmos W=0.205u L=0.04u
M12404 U1756/net10 WX9888 VDD VDD pmos W=0.205u L=0.04u
M12405 U1757/net4 n1386 U1757/net14 VSS nmos W=0.155u L=0.04u
M12406 U1757/net6 U1757/net10 U1757/net14 VSS nmos W=0.17u L=0.04u
M12407 U1757/net4 n1387 VSS VSS nmos W=0.155u L=0.04u
M12408 U1757/net6 U1757/net4 VSS VSS nmos W=0.17u L=0.04u
M12409 n1175 U1757/net14 VSS VSS nmos W=0.155u L=0.04u
M12410 U1757/net10 n1386 VSS VSS nmos W=0.155u L=0.04u
M12411 U1757/net4 U1757/net10 U1757/net14 VDD pmos W=0.255u L=0.04u
M12412 U1757/net6 n1386 U1757/net14 VDD pmos W=0.28u L=0.04u
M12413 U1757/net4 n1387 VDD VDD pmos W=0.205u L=0.04u
M12414 U1757/net6 U1757/net4 VDD VDD pmos W=0.24u L=0.04u
M12415 n1175 U1757/net14 VDD VDD pmos W=0.205u L=0.04u
M12416 U1757/net10 n1386 VDD VDD pmos W=0.205u L=0.04u
M12417 U1758/net4 WX8655 U1758/net14 VSS nmos W=0.155u L=0.04u
M12418 U1758/net6 U1758/net10 U1758/net14 VSS nmos W=0.17u L=0.04u
M12419 U1758/net4 CRC_OUT_3_0 VSS VSS nmos W=0.155u L=0.04u
M12420 U1758/net6 U1758/net4 VSS VSS nmos W=0.17u L=0.04u
M12421 n1174 U1758/net14 VSS VSS nmos W=0.155u L=0.04u
M12422 U1758/net10 WX8655 VSS VSS nmos W=0.155u L=0.04u
M12423 U1758/net4 U1758/net10 U1758/net14 VDD pmos W=0.255u L=0.04u
M12424 U1758/net6 WX8655 U1758/net14 VDD pmos W=0.28u L=0.04u
M12425 U1758/net4 CRC_OUT_3_0 VDD VDD pmos W=0.205u L=0.04u
M12426 U1758/net6 U1758/net4 VDD VDD pmos W=0.24u L=0.04u
M12427 n1174 U1758/net14 VDD VDD pmos W=0.205u L=0.04u
M12428 U1758/net10 WX8655 VDD VDD pmos W=0.205u L=0.04u
M12429 U1759/net4 WX8653 U1759/net14 VSS nmos W=0.155u L=0.04u
M12430 U1759/net6 U1759/net10 U1759/net14 VSS nmos W=0.17u L=0.04u
M12431 U1759/net4 CRC_OUT_3_1 VSS VSS nmos W=0.155u L=0.04u
M12432 U1759/net6 U1759/net4 VSS VSS nmos W=0.17u L=0.04u
M12433 n1173 U1759/net14 VSS VSS nmos W=0.155u L=0.04u
M12434 U1759/net10 WX8653 VSS VSS nmos W=0.155u L=0.04u
M12435 U1759/net4 U1759/net10 U1759/net14 VDD pmos W=0.255u L=0.04u
M12436 U1759/net6 WX8653 U1759/net14 VDD pmos W=0.28u L=0.04u
M12437 U1759/net4 CRC_OUT_3_1 VDD VDD pmos W=0.205u L=0.04u
M12438 U1759/net6 U1759/net4 VDD VDD pmos W=0.24u L=0.04u
M12439 n1173 U1759/net14 VDD VDD pmos W=0.205u L=0.04u
M12440 U1759/net10 WX8653 VDD VDD pmos W=0.205u L=0.04u
M12441 U1760/net4 WX8651 U1760/net14 VSS nmos W=0.155u L=0.04u
M12442 U1760/net6 U1760/net10 U1760/net14 VSS nmos W=0.17u L=0.04u
M12443 U1760/net4 CRC_OUT_3_2 VSS VSS nmos W=0.155u L=0.04u
M12444 U1760/net6 U1760/net4 VSS VSS nmos W=0.17u L=0.04u
M12445 n1172 U1760/net14 VSS VSS nmos W=0.155u L=0.04u
M12446 U1760/net10 WX8651 VSS VSS nmos W=0.155u L=0.04u
M12447 U1760/net4 U1760/net10 U1760/net14 VDD pmos W=0.255u L=0.04u
M12448 U1760/net6 WX8651 U1760/net14 VDD pmos W=0.28u L=0.04u
M12449 U1760/net4 CRC_OUT_3_2 VDD VDD pmos W=0.205u L=0.04u
M12450 U1760/net6 U1760/net4 VDD VDD pmos W=0.24u L=0.04u
M12451 n1172 U1760/net14 VDD VDD pmos W=0.205u L=0.04u
M12452 U1760/net10 WX8651 VDD VDD pmos W=0.205u L=0.04u
M12453 U1761/net11 CRC_OUT_3_31 U1761/net17 VSS nmos W=0.155u L=0.04u
M12454 U1761/net5 U1761/net17 U1761/net21 VSS nmos W=0.155u L=0.04u
M12455 U1761/net5 CRC_OUT_3_3 VSS VSS nmos W=0.155u L=0.04u
M12456 n1171 U1761/net21 VSS VSS nmos W=0.155u L=0.04u
M12457 U1761/net16 CRC_OUT_3_31 VSS VSS nmos W=0.155u L=0.04u
M12458 U1761/net11 WX8649 VSS VSS nmos W=0.155u L=0.04u
M12459 U1761/net13 U1761/net17 VSS VSS nmos W=0.155u L=0.04u
M12460 U1761/net17 U1761/net16 U1761/XI2-net16 VSS nmos W=0.155u L=0.04u
M12461 U1761/XI2-net16 U1761/net11 VSS VSS nmos W=0.155u L=0.04u
M12462 U1761/net21 U1761/net13 U1761/XU21-net16 VSS nmos W=0.155u L=0.04u
M12463 U1761/XU21-net16 U1761/net5 VSS VSS nmos W=0.155u L=0.04u
M12464 U1761/net11 U1761/net16 U1761/net17 VDD pmos W=0.205u L=0.04u
M12465 U1761/net5 U1761/net13 U1761/net21 VDD pmos W=0.205u L=0.04u
M12466 U1761/net5 CRC_OUT_3_3 VDD VDD pmos W=0.205u L=0.04u
M12467 n1171 U1761/net21 VDD VDD pmos W=0.205u L=0.04u
M12468 U1761/net16 CRC_OUT_3_31 VDD VDD pmos W=0.205u L=0.04u
M12469 U1761/net11 WX8649 VDD VDD pmos W=0.205u L=0.04u
M12470 U1761/net13 U1761/net17 VDD VDD pmos W=0.205u L=0.04u
M12471 U1761/net17 CRC_OUT_3_31 U1761/XI2-net6 VDD pmos W=0.205u L=0.04u
M12472 U1761/XI2-net6 U1761/net11 VDD VDD pmos W=0.205u L=0.04u
M12473 U1761/net21 U1761/net17 U1761/XU21-net6 VDD pmos W=0.205u L=0.04u
M12474 U1761/XU21-net6 U1761/net5 VDD VDD pmos W=0.205u L=0.04u
M12475 U1762/net4 WX8647 U1762/net14 VSS nmos W=0.155u L=0.04u
M12476 U1762/net6 U1762/net10 U1762/net14 VSS nmos W=0.17u L=0.04u
M12477 U1762/net4 CRC_OUT_3_4 VSS VSS nmos W=0.155u L=0.04u
M12478 U1762/net6 U1762/net4 VSS VSS nmos W=0.17u L=0.04u
M12479 n1170 U1762/net14 VSS VSS nmos W=0.155u L=0.04u
M12480 U1762/net10 WX8647 VSS VSS nmos W=0.155u L=0.04u
M12481 U1762/net4 U1762/net10 U1762/net14 VDD pmos W=0.255u L=0.04u
M12482 U1762/net6 WX8647 U1762/net14 VDD pmos W=0.28u L=0.04u
M12483 U1762/net4 CRC_OUT_3_4 VDD VDD pmos W=0.205u L=0.04u
M12484 U1762/net6 U1762/net4 VDD VDD pmos W=0.24u L=0.04u
M12485 n1170 U1762/net14 VDD VDD pmos W=0.205u L=0.04u
M12486 U1762/net10 WX8647 VDD VDD pmos W=0.205u L=0.04u
M12487 U1763/net4 WX8645 U1763/net14 VSS nmos W=0.155u L=0.04u
M12488 U1763/net6 U1763/net10 U1763/net14 VSS nmos W=0.17u L=0.04u
M12489 U1763/net4 CRC_OUT_3_5 VSS VSS nmos W=0.155u L=0.04u
M12490 U1763/net6 U1763/net4 VSS VSS nmos W=0.17u L=0.04u
M12491 n1169 U1763/net14 VSS VSS nmos W=0.155u L=0.04u
M12492 U1763/net10 WX8645 VSS VSS nmos W=0.155u L=0.04u
M12493 U1763/net4 U1763/net10 U1763/net14 VDD pmos W=0.255u L=0.04u
M12494 U1763/net6 WX8645 U1763/net14 VDD pmos W=0.28u L=0.04u
M12495 U1763/net4 CRC_OUT_3_5 VDD VDD pmos W=0.205u L=0.04u
M12496 U1763/net6 U1763/net4 VDD VDD pmos W=0.24u L=0.04u
M12497 n1169 U1763/net14 VDD VDD pmos W=0.205u L=0.04u
M12498 U1763/net10 WX8645 VDD VDD pmos W=0.205u L=0.04u
M12499 U1764/net4 WX8643 U1764/net14 VSS nmos W=0.155u L=0.04u
M12500 U1764/net6 U1764/net10 U1764/net14 VSS nmos W=0.17u L=0.04u
M12501 U1764/net4 CRC_OUT_3_6 VSS VSS nmos W=0.155u L=0.04u
M12502 U1764/net6 U1764/net4 VSS VSS nmos W=0.17u L=0.04u
M12503 n1168 U1764/net14 VSS VSS nmos W=0.155u L=0.04u
M12504 U1764/net10 WX8643 VSS VSS nmos W=0.155u L=0.04u
M12505 U1764/net4 U1764/net10 U1764/net14 VDD pmos W=0.255u L=0.04u
M12506 U1764/net6 WX8643 U1764/net14 VDD pmos W=0.28u L=0.04u
M12507 U1764/net4 CRC_OUT_3_6 VDD VDD pmos W=0.205u L=0.04u
M12508 U1764/net6 U1764/net4 VDD VDD pmos W=0.24u L=0.04u
M12509 n1168 U1764/net14 VDD VDD pmos W=0.205u L=0.04u
M12510 U1764/net10 WX8643 VDD VDD pmos W=0.205u L=0.04u
M12511 U1765/net4 WX8641 U1765/net14 VSS nmos W=0.155u L=0.04u
M12512 U1765/net6 U1765/net10 U1765/net14 VSS nmos W=0.17u L=0.04u
M12513 U1765/net4 CRC_OUT_3_7 VSS VSS nmos W=0.155u L=0.04u
M12514 U1765/net6 U1765/net4 VSS VSS nmos W=0.17u L=0.04u
M12515 n1167 U1765/net14 VSS VSS nmos W=0.155u L=0.04u
M12516 U1765/net10 WX8641 VSS VSS nmos W=0.155u L=0.04u
M12517 U1765/net4 U1765/net10 U1765/net14 VDD pmos W=0.255u L=0.04u
M12518 U1765/net6 WX8641 U1765/net14 VDD pmos W=0.28u L=0.04u
M12519 U1765/net4 CRC_OUT_3_7 VDD VDD pmos W=0.205u L=0.04u
M12520 U1765/net6 U1765/net4 VDD VDD pmos W=0.24u L=0.04u
M12521 n1167 U1765/net14 VDD VDD pmos W=0.205u L=0.04u
M12522 U1765/net10 WX8641 VDD VDD pmos W=0.205u L=0.04u
M12523 U1766/net4 WX8639 U1766/net14 VSS nmos W=0.155u L=0.04u
M12524 U1766/net6 U1766/net10 U1766/net14 VSS nmos W=0.17u L=0.04u
M12525 U1766/net4 CRC_OUT_3_8 VSS VSS nmos W=0.155u L=0.04u
M12526 U1766/net6 U1766/net4 VSS VSS nmos W=0.17u L=0.04u
M12527 n1166 U1766/net14 VSS VSS nmos W=0.155u L=0.04u
M12528 U1766/net10 WX8639 VSS VSS nmos W=0.155u L=0.04u
M12529 U1766/net4 U1766/net10 U1766/net14 VDD pmos W=0.255u L=0.04u
M12530 U1766/net6 WX8639 U1766/net14 VDD pmos W=0.28u L=0.04u
M12531 U1766/net4 CRC_OUT_3_8 VDD VDD pmos W=0.205u L=0.04u
M12532 U1766/net6 U1766/net4 VDD VDD pmos W=0.24u L=0.04u
M12533 n1166 U1766/net14 VDD VDD pmos W=0.205u L=0.04u
M12534 U1766/net10 WX8639 VDD VDD pmos W=0.205u L=0.04u
M12535 U1767/net4 WX8637 U1767/net14 VSS nmos W=0.155u L=0.04u
M12536 U1767/net6 U1767/net10 U1767/net14 VSS nmos W=0.17u L=0.04u
M12537 U1767/net4 CRC_OUT_3_9 VSS VSS nmos W=0.155u L=0.04u
M12538 U1767/net6 U1767/net4 VSS VSS nmos W=0.17u L=0.04u
M12539 n1165 U1767/net14 VSS VSS nmos W=0.155u L=0.04u
M12540 U1767/net10 WX8637 VSS VSS nmos W=0.155u L=0.04u
M12541 U1767/net4 U1767/net10 U1767/net14 VDD pmos W=0.255u L=0.04u
M12542 U1767/net6 WX8637 U1767/net14 VDD pmos W=0.28u L=0.04u
M12543 U1767/net4 CRC_OUT_3_9 VDD VDD pmos W=0.205u L=0.04u
M12544 U1767/net6 U1767/net4 VDD VDD pmos W=0.24u L=0.04u
M12545 n1165 U1767/net14 VDD VDD pmos W=0.205u L=0.04u
M12546 U1767/net10 WX8637 VDD VDD pmos W=0.205u L=0.04u
M12547 U1768/net11 CRC_OUT_3_31 U1768/net17 VSS nmos W=0.155u L=0.04u
M12548 U1768/net5 U1768/net17 U1768/net21 VSS nmos W=0.155u L=0.04u
M12549 U1768/net5 CRC_OUT_3_10 VSS VSS nmos W=0.155u L=0.04u
M12550 n1164 U1768/net21 VSS VSS nmos W=0.155u L=0.04u
M12551 U1768/net16 CRC_OUT_3_31 VSS VSS nmos W=0.155u L=0.04u
M12552 U1768/net11 WX8635 VSS VSS nmos W=0.155u L=0.04u
M12553 U1768/net13 U1768/net17 VSS VSS nmos W=0.155u L=0.04u
M12554 U1768/net17 U1768/net16 U1768/XI2-net16 VSS nmos W=0.155u L=0.04u
M12555 U1768/XI2-net16 U1768/net11 VSS VSS nmos W=0.155u L=0.04u
M12556 U1768/net21 U1768/net13 U1768/XU21-net16 VSS nmos W=0.155u L=0.04u
M12557 U1768/XU21-net16 U1768/net5 VSS VSS nmos W=0.155u L=0.04u
M12558 U1768/net11 U1768/net16 U1768/net17 VDD pmos W=0.205u L=0.04u
M12559 U1768/net5 U1768/net13 U1768/net21 VDD pmos W=0.205u L=0.04u
M12560 U1768/net5 CRC_OUT_3_10 VDD VDD pmos W=0.205u L=0.04u
M12561 n1164 U1768/net21 VDD VDD pmos W=0.205u L=0.04u
M12562 U1768/net16 CRC_OUT_3_31 VDD VDD pmos W=0.205u L=0.04u
M12563 U1768/net11 WX8635 VDD VDD pmos W=0.205u L=0.04u
M12564 U1768/net13 U1768/net17 VDD VDD pmos W=0.205u L=0.04u
M12565 U1768/net17 CRC_OUT_3_31 U1768/XI2-net6 VDD pmos W=0.205u L=0.04u
M12566 U1768/XI2-net6 U1768/net11 VDD VDD pmos W=0.205u L=0.04u
M12567 U1768/net21 U1768/net17 U1768/XU21-net6 VDD pmos W=0.205u L=0.04u
M12568 U1768/XU21-net6 U1768/net5 VDD VDD pmos W=0.205u L=0.04u
M12569 U1769/net4 WX8633 U1769/net14 VSS nmos W=0.155u L=0.04u
M12570 U1769/net6 U1769/net10 U1769/net14 VSS nmos W=0.17u L=0.04u
M12571 U1769/net4 CRC_OUT_3_11 VSS VSS nmos W=0.155u L=0.04u
M12572 U1769/net6 U1769/net4 VSS VSS nmos W=0.17u L=0.04u
M12573 n1163 U1769/net14 VSS VSS nmos W=0.155u L=0.04u
M12574 U1769/net10 WX8633 VSS VSS nmos W=0.155u L=0.04u
M12575 U1769/net4 U1769/net10 U1769/net14 VDD pmos W=0.255u L=0.04u
M12576 U1769/net6 WX8633 U1769/net14 VDD pmos W=0.28u L=0.04u
M12577 U1769/net4 CRC_OUT_3_11 VDD VDD pmos W=0.205u L=0.04u
M12578 U1769/net6 U1769/net4 VDD VDD pmos W=0.24u L=0.04u
M12579 n1163 U1769/net14 VDD VDD pmos W=0.205u L=0.04u
M12580 U1769/net10 WX8633 VDD VDD pmos W=0.205u L=0.04u
M12581 U1770/net4 WX8631 U1770/net14 VSS nmos W=0.155u L=0.04u
M12582 U1770/net6 U1770/net10 U1770/net14 VSS nmos W=0.17u L=0.04u
M12583 U1770/net4 CRC_OUT_3_12 VSS VSS nmos W=0.155u L=0.04u
M12584 U1770/net6 U1770/net4 VSS VSS nmos W=0.17u L=0.04u
M12585 n1162 U1770/net14 VSS VSS nmos W=0.155u L=0.04u
M12586 U1770/net10 WX8631 VSS VSS nmos W=0.155u L=0.04u
M12587 U1770/net4 U1770/net10 U1770/net14 VDD pmos W=0.255u L=0.04u
M12588 U1770/net6 WX8631 U1770/net14 VDD pmos W=0.28u L=0.04u
M12589 U1770/net4 CRC_OUT_3_12 VDD VDD pmos W=0.205u L=0.04u
M12590 U1770/net6 U1770/net4 VDD VDD pmos W=0.24u L=0.04u
M12591 n1162 U1770/net14 VDD VDD pmos W=0.205u L=0.04u
M12592 U1770/net10 WX8631 VDD VDD pmos W=0.205u L=0.04u
M12593 U1771/net4 WX8629 U1771/net14 VSS nmos W=0.155u L=0.04u
M12594 U1771/net6 U1771/net10 U1771/net14 VSS nmos W=0.17u L=0.04u
M12595 U1771/net4 CRC_OUT_3_13 VSS VSS nmos W=0.155u L=0.04u
M12596 U1771/net6 U1771/net4 VSS VSS nmos W=0.17u L=0.04u
M12597 n1161 U1771/net14 VSS VSS nmos W=0.155u L=0.04u
M12598 U1771/net10 WX8629 VSS VSS nmos W=0.155u L=0.04u
M12599 U1771/net4 U1771/net10 U1771/net14 VDD pmos W=0.255u L=0.04u
M12600 U1771/net6 WX8629 U1771/net14 VDD pmos W=0.28u L=0.04u
M12601 U1771/net4 CRC_OUT_3_13 VDD VDD pmos W=0.205u L=0.04u
M12602 U1771/net6 U1771/net4 VDD VDD pmos W=0.24u L=0.04u
M12603 n1161 U1771/net14 VDD VDD pmos W=0.205u L=0.04u
M12604 U1771/net10 WX8629 VDD VDD pmos W=0.205u L=0.04u
M12605 U1772/net4 WX8627 U1772/net14 VSS nmos W=0.155u L=0.04u
M12606 U1772/net6 U1772/net10 U1772/net14 VSS nmos W=0.17u L=0.04u
M12607 U1772/net4 CRC_OUT_3_14 VSS VSS nmos W=0.155u L=0.04u
M12608 U1772/net6 U1772/net4 VSS VSS nmos W=0.17u L=0.04u
M12609 n1160 U1772/net14 VSS VSS nmos W=0.155u L=0.04u
M12610 U1772/net10 WX8627 VSS VSS nmos W=0.155u L=0.04u
M12611 U1772/net4 U1772/net10 U1772/net14 VDD pmos W=0.255u L=0.04u
M12612 U1772/net6 WX8627 U1772/net14 VDD pmos W=0.28u L=0.04u
M12613 U1772/net4 CRC_OUT_3_14 VDD VDD pmos W=0.205u L=0.04u
M12614 U1772/net6 U1772/net4 VDD VDD pmos W=0.24u L=0.04u
M12615 n1160 U1772/net14 VDD VDD pmos W=0.205u L=0.04u
M12616 U1772/net10 WX8627 VDD VDD pmos W=0.205u L=0.04u
M12617 U1773/net11 CRC_OUT_3_31 U1773/net17 VSS nmos W=0.155u L=0.04u
M12618 U1773/net5 U1773/net17 U1773/net21 VSS nmos W=0.155u L=0.04u
M12619 U1773/net5 CRC_OUT_3_15 VSS VSS nmos W=0.155u L=0.04u
M12620 n1159 U1773/net21 VSS VSS nmos W=0.155u L=0.04u
M12621 U1773/net16 CRC_OUT_3_31 VSS VSS nmos W=0.155u L=0.04u
M12622 U1773/net11 WX8625 VSS VSS nmos W=0.155u L=0.04u
M12623 U1773/net13 U1773/net17 VSS VSS nmos W=0.155u L=0.04u
M12624 U1773/net17 U1773/net16 U1773/XI2-net16 VSS nmos W=0.155u L=0.04u
M12625 U1773/XI2-net16 U1773/net11 VSS VSS nmos W=0.155u L=0.04u
M12626 U1773/net21 U1773/net13 U1773/XU21-net16 VSS nmos W=0.155u L=0.04u
M12627 U1773/XU21-net16 U1773/net5 VSS VSS nmos W=0.155u L=0.04u
M12628 U1773/net11 U1773/net16 U1773/net17 VDD pmos W=0.205u L=0.04u
M12629 U1773/net5 U1773/net13 U1773/net21 VDD pmos W=0.205u L=0.04u
M12630 U1773/net5 CRC_OUT_3_15 VDD VDD pmos W=0.205u L=0.04u
M12631 n1159 U1773/net21 VDD VDD pmos W=0.205u L=0.04u
M12632 U1773/net16 CRC_OUT_3_31 VDD VDD pmos W=0.205u L=0.04u
M12633 U1773/net11 WX8625 VDD VDD pmos W=0.205u L=0.04u
M12634 U1773/net13 U1773/net17 VDD VDD pmos W=0.205u L=0.04u
M12635 U1773/net17 CRC_OUT_3_31 U1773/XI2-net6 VDD pmos W=0.205u L=0.04u
M12636 U1773/XI2-net6 U1773/net11 VDD VDD pmos W=0.205u L=0.04u
M12637 U1773/net21 U1773/net17 U1773/XU21-net6 VDD pmos W=0.205u L=0.04u
M12638 U1773/XU21-net6 U1773/net5 VDD VDD pmos W=0.205u L=0.04u
M12639 U1774/net4 WX8623 U1774/net14 VSS nmos W=0.155u L=0.04u
M12640 U1774/net6 U1774/net10 U1774/net14 VSS nmos W=0.17u L=0.04u
M12641 U1774/net4 CRC_OUT_3_16 VSS VSS nmos W=0.155u L=0.04u
M12642 U1774/net6 U1774/net4 VSS VSS nmos W=0.17u L=0.04u
M12643 n1158 U1774/net14 VSS VSS nmos W=0.155u L=0.04u
M12644 U1774/net10 WX8623 VSS VSS nmos W=0.155u L=0.04u
M12645 U1774/net4 U1774/net10 U1774/net14 VDD pmos W=0.255u L=0.04u
M12646 U1774/net6 WX8623 U1774/net14 VDD pmos W=0.28u L=0.04u
M12647 U1774/net4 CRC_OUT_3_16 VDD VDD pmos W=0.205u L=0.04u
M12648 U1774/net6 U1774/net4 VDD VDD pmos W=0.24u L=0.04u
M12649 n1158 U1774/net14 VDD VDD pmos W=0.205u L=0.04u
M12650 U1774/net10 WX8623 VDD VDD pmos W=0.205u L=0.04u
M12651 U1775/net4 WX8621 U1775/net14 VSS nmos W=0.155u L=0.04u
M12652 U1775/net6 U1775/net10 U1775/net14 VSS nmos W=0.17u L=0.04u
M12653 U1775/net4 CRC_OUT_3_17 VSS VSS nmos W=0.155u L=0.04u
M12654 U1775/net6 U1775/net4 VSS VSS nmos W=0.17u L=0.04u
M12655 n1157 U1775/net14 VSS VSS nmos W=0.155u L=0.04u
M12656 U1775/net10 WX8621 VSS VSS nmos W=0.155u L=0.04u
M12657 U1775/net4 U1775/net10 U1775/net14 VDD pmos W=0.255u L=0.04u
M12658 U1775/net6 WX8621 U1775/net14 VDD pmos W=0.28u L=0.04u
M12659 U1775/net4 CRC_OUT_3_17 VDD VDD pmos W=0.205u L=0.04u
M12660 U1775/net6 U1775/net4 VDD VDD pmos W=0.24u L=0.04u
M12661 n1157 U1775/net14 VDD VDD pmos W=0.205u L=0.04u
M12662 U1775/net10 WX8621 VDD VDD pmos W=0.205u L=0.04u
M12663 U1776/net4 WX8619 U1776/net14 VSS nmos W=0.155u L=0.04u
M12664 U1776/net6 U1776/net10 U1776/net14 VSS nmos W=0.17u L=0.04u
M12665 U1776/net4 CRC_OUT_3_18 VSS VSS nmos W=0.155u L=0.04u
M12666 U1776/net6 U1776/net4 VSS VSS nmos W=0.17u L=0.04u
M12667 n1156 U1776/net14 VSS VSS nmos W=0.155u L=0.04u
M12668 U1776/net10 WX8619 VSS VSS nmos W=0.155u L=0.04u
M12669 U1776/net4 U1776/net10 U1776/net14 VDD pmos W=0.255u L=0.04u
M12670 U1776/net6 WX8619 U1776/net14 VDD pmos W=0.28u L=0.04u
M12671 U1776/net4 CRC_OUT_3_18 VDD VDD pmos W=0.205u L=0.04u
M12672 U1776/net6 U1776/net4 VDD VDD pmos W=0.24u L=0.04u
M12673 n1156 U1776/net14 VDD VDD pmos W=0.205u L=0.04u
M12674 U1776/net10 WX8619 VDD VDD pmos W=0.205u L=0.04u
M12675 U1777/net4 WX8617 U1777/net14 VSS nmos W=0.155u L=0.04u
M12676 U1777/net6 U1777/net10 U1777/net14 VSS nmos W=0.17u L=0.04u
M12677 U1777/net4 CRC_OUT_3_19 VSS VSS nmos W=0.155u L=0.04u
M12678 U1777/net6 U1777/net4 VSS VSS nmos W=0.17u L=0.04u
M12679 n1155 U1777/net14 VSS VSS nmos W=0.155u L=0.04u
M12680 U1777/net10 WX8617 VSS VSS nmos W=0.155u L=0.04u
M12681 U1777/net4 U1777/net10 U1777/net14 VDD pmos W=0.255u L=0.04u
M12682 U1777/net6 WX8617 U1777/net14 VDD pmos W=0.28u L=0.04u
M12683 U1777/net4 CRC_OUT_3_19 VDD VDD pmos W=0.205u L=0.04u
M12684 U1777/net6 U1777/net4 VDD VDD pmos W=0.24u L=0.04u
M12685 n1155 U1777/net14 VDD VDD pmos W=0.205u L=0.04u
M12686 U1777/net10 WX8617 VDD VDD pmos W=0.205u L=0.04u
M12687 U1778/net4 WX8615 U1778/net14 VSS nmos W=0.155u L=0.04u
M12688 U1778/net6 U1778/net10 U1778/net14 VSS nmos W=0.17u L=0.04u
M12689 U1778/net4 CRC_OUT_3_20 VSS VSS nmos W=0.155u L=0.04u
M12690 U1778/net6 U1778/net4 VSS VSS nmos W=0.17u L=0.04u
M12691 n1154 U1778/net14 VSS VSS nmos W=0.155u L=0.04u
M12692 U1778/net10 WX8615 VSS VSS nmos W=0.155u L=0.04u
M12693 U1778/net4 U1778/net10 U1778/net14 VDD pmos W=0.255u L=0.04u
M12694 U1778/net6 WX8615 U1778/net14 VDD pmos W=0.28u L=0.04u
M12695 U1778/net4 CRC_OUT_3_20 VDD VDD pmos W=0.205u L=0.04u
M12696 U1778/net6 U1778/net4 VDD VDD pmos W=0.24u L=0.04u
M12697 n1154 U1778/net14 VDD VDD pmos W=0.205u L=0.04u
M12698 U1778/net10 WX8615 VDD VDD pmos W=0.205u L=0.04u
M12699 U1779/net4 WX8613 U1779/net14 VSS nmos W=0.155u L=0.04u
M12700 U1779/net6 U1779/net10 U1779/net14 VSS nmos W=0.17u L=0.04u
M12701 U1779/net4 CRC_OUT_3_21 VSS VSS nmos W=0.155u L=0.04u
M12702 U1779/net6 U1779/net4 VSS VSS nmos W=0.17u L=0.04u
M12703 n1153 U1779/net14 VSS VSS nmos W=0.155u L=0.04u
M12704 U1779/net10 WX8613 VSS VSS nmos W=0.155u L=0.04u
M12705 U1779/net4 U1779/net10 U1779/net14 VDD pmos W=0.255u L=0.04u
M12706 U1779/net6 WX8613 U1779/net14 VDD pmos W=0.28u L=0.04u
M12707 U1779/net4 CRC_OUT_3_21 VDD VDD pmos W=0.205u L=0.04u
M12708 U1779/net6 U1779/net4 VDD VDD pmos W=0.24u L=0.04u
M12709 n1153 U1779/net14 VDD VDD pmos W=0.205u L=0.04u
M12710 U1779/net10 WX8613 VDD VDD pmos W=0.205u L=0.04u
M12711 U1780/net4 WX8611 U1780/net14 VSS nmos W=0.155u L=0.04u
M12712 U1780/net6 U1780/net10 U1780/net14 VSS nmos W=0.17u L=0.04u
M12713 U1780/net4 CRC_OUT_3_22 VSS VSS nmos W=0.155u L=0.04u
M12714 U1780/net6 U1780/net4 VSS VSS nmos W=0.17u L=0.04u
M12715 n1152 U1780/net14 VSS VSS nmos W=0.155u L=0.04u
M12716 U1780/net10 WX8611 VSS VSS nmos W=0.155u L=0.04u
M12717 U1780/net4 U1780/net10 U1780/net14 VDD pmos W=0.255u L=0.04u
M12718 U1780/net6 WX8611 U1780/net14 VDD pmos W=0.28u L=0.04u
M12719 U1780/net4 CRC_OUT_3_22 VDD VDD pmos W=0.205u L=0.04u
M12720 U1780/net6 U1780/net4 VDD VDD pmos W=0.24u L=0.04u
M12721 n1152 U1780/net14 VDD VDD pmos W=0.205u L=0.04u
M12722 U1780/net10 WX8611 VDD VDD pmos W=0.205u L=0.04u
M12723 U1781/net4 WX8609 U1781/net14 VSS nmos W=0.155u L=0.04u
M12724 U1781/net6 U1781/net10 U1781/net14 VSS nmos W=0.17u L=0.04u
M12725 U1781/net4 CRC_OUT_3_23 VSS VSS nmos W=0.155u L=0.04u
M12726 U1781/net6 U1781/net4 VSS VSS nmos W=0.17u L=0.04u
M12727 n1151 U1781/net14 VSS VSS nmos W=0.155u L=0.04u
M12728 U1781/net10 WX8609 VSS VSS nmos W=0.155u L=0.04u
M12729 U1781/net4 U1781/net10 U1781/net14 VDD pmos W=0.255u L=0.04u
M12730 U1781/net6 WX8609 U1781/net14 VDD pmos W=0.28u L=0.04u
M12731 U1781/net4 CRC_OUT_3_23 VDD VDD pmos W=0.205u L=0.04u
M12732 U1781/net6 U1781/net4 VDD VDD pmos W=0.24u L=0.04u
M12733 n1151 U1781/net14 VDD VDD pmos W=0.205u L=0.04u
M12734 U1781/net10 WX8609 VDD VDD pmos W=0.205u L=0.04u
M12735 U1782/net4 WX8607 U1782/net14 VSS nmos W=0.155u L=0.04u
M12736 U1782/net6 U1782/net10 U1782/net14 VSS nmos W=0.17u L=0.04u
M12737 U1782/net4 CRC_OUT_3_24 VSS VSS nmos W=0.155u L=0.04u
M12738 U1782/net6 U1782/net4 VSS VSS nmos W=0.17u L=0.04u
M12739 n1150 U1782/net14 VSS VSS nmos W=0.155u L=0.04u
M12740 U1782/net10 WX8607 VSS VSS nmos W=0.155u L=0.04u
M12741 U1782/net4 U1782/net10 U1782/net14 VDD pmos W=0.255u L=0.04u
M12742 U1782/net6 WX8607 U1782/net14 VDD pmos W=0.28u L=0.04u
M12743 U1782/net4 CRC_OUT_3_24 VDD VDD pmos W=0.205u L=0.04u
M12744 U1782/net6 U1782/net4 VDD VDD pmos W=0.24u L=0.04u
M12745 n1150 U1782/net14 VDD VDD pmos W=0.205u L=0.04u
M12746 U1782/net10 WX8607 VDD VDD pmos W=0.205u L=0.04u
M12747 U1783/net4 WX8605 U1783/net14 VSS nmos W=0.155u L=0.04u
M12748 U1783/net6 U1783/net10 U1783/net14 VSS nmos W=0.17u L=0.04u
M12749 U1783/net4 CRC_OUT_3_25 VSS VSS nmos W=0.155u L=0.04u
M12750 U1783/net6 U1783/net4 VSS VSS nmos W=0.17u L=0.04u
M12751 n1149 U1783/net14 VSS VSS nmos W=0.155u L=0.04u
M12752 U1783/net10 WX8605 VSS VSS nmos W=0.155u L=0.04u
M12753 U1783/net4 U1783/net10 U1783/net14 VDD pmos W=0.255u L=0.04u
M12754 U1783/net6 WX8605 U1783/net14 VDD pmos W=0.28u L=0.04u
M12755 U1783/net4 CRC_OUT_3_25 VDD VDD pmos W=0.205u L=0.04u
M12756 U1783/net6 U1783/net4 VDD VDD pmos W=0.24u L=0.04u
M12757 n1149 U1783/net14 VDD VDD pmos W=0.205u L=0.04u
M12758 U1783/net10 WX8605 VDD VDD pmos W=0.205u L=0.04u
M12759 U1784/net4 WX8603 U1784/net14 VSS nmos W=0.155u L=0.04u
M12760 U1784/net6 U1784/net10 U1784/net14 VSS nmos W=0.17u L=0.04u
M12761 U1784/net4 CRC_OUT_3_26 VSS VSS nmos W=0.155u L=0.04u
M12762 U1784/net6 U1784/net4 VSS VSS nmos W=0.17u L=0.04u
M12763 n1148 U1784/net14 VSS VSS nmos W=0.155u L=0.04u
M12764 U1784/net10 WX8603 VSS VSS nmos W=0.155u L=0.04u
M12765 U1784/net4 U1784/net10 U1784/net14 VDD pmos W=0.255u L=0.04u
M12766 U1784/net6 WX8603 U1784/net14 VDD pmos W=0.28u L=0.04u
M12767 U1784/net4 CRC_OUT_3_26 VDD VDD pmos W=0.205u L=0.04u
M12768 U1784/net6 U1784/net4 VDD VDD pmos W=0.24u L=0.04u
M12769 n1148 U1784/net14 VDD VDD pmos W=0.205u L=0.04u
M12770 U1784/net10 WX8603 VDD VDD pmos W=0.205u L=0.04u
M12771 U1785/net4 WX8601 U1785/net14 VSS nmos W=0.155u L=0.04u
M12772 U1785/net6 U1785/net10 U1785/net14 VSS nmos W=0.17u L=0.04u
M12773 U1785/net4 CRC_OUT_3_27 VSS VSS nmos W=0.155u L=0.04u
M12774 U1785/net6 U1785/net4 VSS VSS nmos W=0.17u L=0.04u
M12775 n1147 U1785/net14 VSS VSS nmos W=0.155u L=0.04u
M12776 U1785/net10 WX8601 VSS VSS nmos W=0.155u L=0.04u
M12777 U1785/net4 U1785/net10 U1785/net14 VDD pmos W=0.255u L=0.04u
M12778 U1785/net6 WX8601 U1785/net14 VDD pmos W=0.28u L=0.04u
M12779 U1785/net4 CRC_OUT_3_27 VDD VDD pmos W=0.205u L=0.04u
M12780 U1785/net6 U1785/net4 VDD VDD pmos W=0.24u L=0.04u
M12781 n1147 U1785/net14 VDD VDD pmos W=0.205u L=0.04u
M12782 U1785/net10 WX8601 VDD VDD pmos W=0.205u L=0.04u
M12783 U1786/net4 WX8599 U1786/net14 VSS nmos W=0.155u L=0.04u
M12784 U1786/net6 U1786/net10 U1786/net14 VSS nmos W=0.17u L=0.04u
M12785 U1786/net4 CRC_OUT_3_28 VSS VSS nmos W=0.155u L=0.04u
M12786 U1786/net6 U1786/net4 VSS VSS nmos W=0.17u L=0.04u
M12787 n1146 U1786/net14 VSS VSS nmos W=0.155u L=0.04u
M12788 U1786/net10 WX8599 VSS VSS nmos W=0.155u L=0.04u
M12789 U1786/net4 U1786/net10 U1786/net14 VDD pmos W=0.255u L=0.04u
M12790 U1786/net6 WX8599 U1786/net14 VDD pmos W=0.28u L=0.04u
M12791 U1786/net4 CRC_OUT_3_28 VDD VDD pmos W=0.205u L=0.04u
M12792 U1786/net6 U1786/net4 VDD VDD pmos W=0.24u L=0.04u
M12793 n1146 U1786/net14 VDD VDD pmos W=0.205u L=0.04u
M12794 U1786/net10 WX8599 VDD VDD pmos W=0.205u L=0.04u
M12795 U1787/net4 WX8597 U1787/net14 VSS nmos W=0.155u L=0.04u
M12796 U1787/net6 U1787/net10 U1787/net14 VSS nmos W=0.17u L=0.04u
M12797 U1787/net4 CRC_OUT_3_29 VSS VSS nmos W=0.155u L=0.04u
M12798 U1787/net6 U1787/net4 VSS VSS nmos W=0.17u L=0.04u
M12799 n1145 U1787/net14 VSS VSS nmos W=0.155u L=0.04u
M12800 U1787/net10 WX8597 VSS VSS nmos W=0.155u L=0.04u
M12801 U1787/net4 U1787/net10 U1787/net14 VDD pmos W=0.255u L=0.04u
M12802 U1787/net6 WX8597 U1787/net14 VDD pmos W=0.28u L=0.04u
M12803 U1787/net4 CRC_OUT_3_29 VDD VDD pmos W=0.205u L=0.04u
M12804 U1787/net6 U1787/net4 VDD VDD pmos W=0.24u L=0.04u
M12805 n1145 U1787/net14 VDD VDD pmos W=0.205u L=0.04u
M12806 U1787/net10 WX8597 VDD VDD pmos W=0.205u L=0.04u
M12807 U1788/net4 WX8595 U1788/net14 VSS nmos W=0.155u L=0.04u
M12808 U1788/net6 U1788/net10 U1788/net14 VSS nmos W=0.17u L=0.04u
M12809 U1788/net4 CRC_OUT_3_30 VSS VSS nmos W=0.155u L=0.04u
M12810 U1788/net6 U1788/net4 VSS VSS nmos W=0.17u L=0.04u
M12811 n1144 U1788/net14 VSS VSS nmos W=0.155u L=0.04u
M12812 U1788/net10 WX8595 VSS VSS nmos W=0.155u L=0.04u
M12813 U1788/net4 U1788/net10 U1788/net14 VDD pmos W=0.255u L=0.04u
M12814 U1788/net6 WX8595 U1788/net14 VDD pmos W=0.28u L=0.04u
M12815 U1788/net4 CRC_OUT_3_30 VDD VDD pmos W=0.205u L=0.04u
M12816 U1788/net6 U1788/net4 VDD VDD pmos W=0.24u L=0.04u
M12817 n1144 U1788/net14 VDD VDD pmos W=0.205u L=0.04u
M12818 U1788/net10 WX8595 VDD VDD pmos W=0.205u L=0.04u
M12819 U1789/net4 n1388 U1789/net14 VSS nmos W=0.155u L=0.04u
M12820 U1789/net6 U1789/net10 U1789/net14 VSS nmos W=0.17u L=0.04u
M12821 U1789/net4 n1389 VSS VSS nmos W=0.155u L=0.04u
M12822 U1789/net6 U1789/net4 VSS VSS nmos W=0.17u L=0.04u
M12823 n1143 U1789/net14 VSS VSS nmos W=0.155u L=0.04u
M12824 U1789/net10 n1388 VSS VSS nmos W=0.155u L=0.04u
M12825 U1789/net4 U1789/net10 U1789/net14 VDD pmos W=0.255u L=0.04u
M12826 U1789/net6 n1388 U1789/net14 VDD pmos W=0.28u L=0.04u
M12827 U1789/net4 n1389 VDD VDD pmos W=0.205u L=0.04u
M12828 U1789/net6 U1789/net4 VDD VDD pmos W=0.24u L=0.04u
M12829 n1143 U1789/net14 VDD VDD pmos W=0.205u L=0.04u
M12830 U1789/net10 n1388 VDD VDD pmos W=0.205u L=0.04u
M12831 U1790/net4 WX7362 U1790/net14 VSS nmos W=0.155u L=0.04u
M12832 U1790/net6 U1790/net10 U1790/net14 VSS nmos W=0.17u L=0.04u
M12833 U1790/net4 CRC_OUT_4_0 VSS VSS nmos W=0.155u L=0.04u
M12834 U1790/net6 U1790/net4 VSS VSS nmos W=0.17u L=0.04u
M12835 n1142 U1790/net14 VSS VSS nmos W=0.155u L=0.04u
M12836 U1790/net10 WX7362 VSS VSS nmos W=0.155u L=0.04u
M12837 U1790/net4 U1790/net10 U1790/net14 VDD pmos W=0.255u L=0.04u
M12838 U1790/net6 WX7362 U1790/net14 VDD pmos W=0.28u L=0.04u
M12839 U1790/net4 CRC_OUT_4_0 VDD VDD pmos W=0.205u L=0.04u
M12840 U1790/net6 U1790/net4 VDD VDD pmos W=0.24u L=0.04u
M12841 n1142 U1790/net14 VDD VDD pmos W=0.205u L=0.04u
M12842 U1790/net10 WX7362 VDD VDD pmos W=0.205u L=0.04u
M12843 U1791/net4 WX7360 U1791/net14 VSS nmos W=0.155u L=0.04u
M12844 U1791/net6 U1791/net10 U1791/net14 VSS nmos W=0.17u L=0.04u
M12845 U1791/net4 CRC_OUT_4_1 VSS VSS nmos W=0.155u L=0.04u
M12846 U1791/net6 U1791/net4 VSS VSS nmos W=0.17u L=0.04u
M12847 n1141 U1791/net14 VSS VSS nmos W=0.155u L=0.04u
M12848 U1791/net10 WX7360 VSS VSS nmos W=0.155u L=0.04u
M12849 U1791/net4 U1791/net10 U1791/net14 VDD pmos W=0.255u L=0.04u
M12850 U1791/net6 WX7360 U1791/net14 VDD pmos W=0.28u L=0.04u
M12851 U1791/net4 CRC_OUT_4_1 VDD VDD pmos W=0.205u L=0.04u
M12852 U1791/net6 U1791/net4 VDD VDD pmos W=0.24u L=0.04u
M12853 n1141 U1791/net14 VDD VDD pmos W=0.205u L=0.04u
M12854 U1791/net10 WX7360 VDD VDD pmos W=0.205u L=0.04u
M12855 U1792/net4 WX7358 U1792/net14 VSS nmos W=0.155u L=0.04u
M12856 U1792/net6 U1792/net10 U1792/net14 VSS nmos W=0.17u L=0.04u
M12857 U1792/net4 CRC_OUT_4_2 VSS VSS nmos W=0.155u L=0.04u
M12858 U1792/net6 U1792/net4 VSS VSS nmos W=0.17u L=0.04u
M12859 n1140 U1792/net14 VSS VSS nmos W=0.155u L=0.04u
M12860 U1792/net10 WX7358 VSS VSS nmos W=0.155u L=0.04u
M12861 U1792/net4 U1792/net10 U1792/net14 VDD pmos W=0.255u L=0.04u
M12862 U1792/net6 WX7358 U1792/net14 VDD pmos W=0.28u L=0.04u
M12863 U1792/net4 CRC_OUT_4_2 VDD VDD pmos W=0.205u L=0.04u
M12864 U1792/net6 U1792/net4 VDD VDD pmos W=0.24u L=0.04u
M12865 n1140 U1792/net14 VDD VDD pmos W=0.205u L=0.04u
M12866 U1792/net10 WX7358 VDD VDD pmos W=0.205u L=0.04u
M12867 U1793/net11 CRC_OUT_4_31 U1793/net17 VSS nmos W=0.155u L=0.04u
M12868 U1793/net5 U1793/net17 U1793/net21 VSS nmos W=0.155u L=0.04u
M12869 U1793/net5 CRC_OUT_4_3 VSS VSS nmos W=0.155u L=0.04u
M12870 n1139 U1793/net21 VSS VSS nmos W=0.155u L=0.04u
M12871 U1793/net16 CRC_OUT_4_31 VSS VSS nmos W=0.155u L=0.04u
M12872 U1793/net11 WX7356 VSS VSS nmos W=0.155u L=0.04u
M12873 U1793/net13 U1793/net17 VSS VSS nmos W=0.155u L=0.04u
M12874 U1793/net17 U1793/net16 U1793/XI2-net16 VSS nmos W=0.155u L=0.04u
M12875 U1793/XI2-net16 U1793/net11 VSS VSS nmos W=0.155u L=0.04u
M12876 U1793/net21 U1793/net13 U1793/XU21-net16 VSS nmos W=0.155u L=0.04u
M12877 U1793/XU21-net16 U1793/net5 VSS VSS nmos W=0.155u L=0.04u
M12878 U1793/net11 U1793/net16 U1793/net17 VDD pmos W=0.205u L=0.04u
M12879 U1793/net5 U1793/net13 U1793/net21 VDD pmos W=0.205u L=0.04u
M12880 U1793/net5 CRC_OUT_4_3 VDD VDD pmos W=0.205u L=0.04u
M12881 n1139 U1793/net21 VDD VDD pmos W=0.205u L=0.04u
M12882 U1793/net16 CRC_OUT_4_31 VDD VDD pmos W=0.205u L=0.04u
M12883 U1793/net11 WX7356 VDD VDD pmos W=0.205u L=0.04u
M12884 U1793/net13 U1793/net17 VDD VDD pmos W=0.205u L=0.04u
M12885 U1793/net17 CRC_OUT_4_31 U1793/XI2-net6 VDD pmos W=0.205u L=0.04u
M12886 U1793/XI2-net6 U1793/net11 VDD VDD pmos W=0.205u L=0.04u
M12887 U1793/net21 U1793/net17 U1793/XU21-net6 VDD pmos W=0.205u L=0.04u
M12888 U1793/XU21-net6 U1793/net5 VDD VDD pmos W=0.205u L=0.04u
M12889 U1794/net4 WX7354 U1794/net14 VSS nmos W=0.155u L=0.04u
M12890 U1794/net6 U1794/net10 U1794/net14 VSS nmos W=0.17u L=0.04u
M12891 U1794/net4 CRC_OUT_4_4 VSS VSS nmos W=0.155u L=0.04u
M12892 U1794/net6 U1794/net4 VSS VSS nmos W=0.17u L=0.04u
M12893 n1138 U1794/net14 VSS VSS nmos W=0.155u L=0.04u
M12894 U1794/net10 WX7354 VSS VSS nmos W=0.155u L=0.04u
M12895 U1794/net4 U1794/net10 U1794/net14 VDD pmos W=0.255u L=0.04u
M12896 U1794/net6 WX7354 U1794/net14 VDD pmos W=0.28u L=0.04u
M12897 U1794/net4 CRC_OUT_4_4 VDD VDD pmos W=0.205u L=0.04u
M12898 U1794/net6 U1794/net4 VDD VDD pmos W=0.24u L=0.04u
M12899 n1138 U1794/net14 VDD VDD pmos W=0.205u L=0.04u
M12900 U1794/net10 WX7354 VDD VDD pmos W=0.205u L=0.04u
M12901 U1795/net4 WX7352 U1795/net14 VSS nmos W=0.155u L=0.04u
M12902 U1795/net6 U1795/net10 U1795/net14 VSS nmos W=0.17u L=0.04u
M12903 U1795/net4 CRC_OUT_4_5 VSS VSS nmos W=0.155u L=0.04u
M12904 U1795/net6 U1795/net4 VSS VSS nmos W=0.17u L=0.04u
M12905 n1137 U1795/net14 VSS VSS nmos W=0.155u L=0.04u
M12906 U1795/net10 WX7352 VSS VSS nmos W=0.155u L=0.04u
M12907 U1795/net4 U1795/net10 U1795/net14 VDD pmos W=0.255u L=0.04u
M12908 U1795/net6 WX7352 U1795/net14 VDD pmos W=0.28u L=0.04u
M12909 U1795/net4 CRC_OUT_4_5 VDD VDD pmos W=0.205u L=0.04u
M12910 U1795/net6 U1795/net4 VDD VDD pmos W=0.24u L=0.04u
M12911 n1137 U1795/net14 VDD VDD pmos W=0.205u L=0.04u
M12912 U1795/net10 WX7352 VDD VDD pmos W=0.205u L=0.04u
M12913 U1796/net4 WX7350 U1796/net14 VSS nmos W=0.155u L=0.04u
M12914 U1796/net6 U1796/net10 U1796/net14 VSS nmos W=0.17u L=0.04u
M12915 U1796/net4 CRC_OUT_4_6 VSS VSS nmos W=0.155u L=0.04u
M12916 U1796/net6 U1796/net4 VSS VSS nmos W=0.17u L=0.04u
M12917 n1136 U1796/net14 VSS VSS nmos W=0.155u L=0.04u
M12918 U1796/net10 WX7350 VSS VSS nmos W=0.155u L=0.04u
M12919 U1796/net4 U1796/net10 U1796/net14 VDD pmos W=0.255u L=0.04u
M12920 U1796/net6 WX7350 U1796/net14 VDD pmos W=0.28u L=0.04u
M12921 U1796/net4 CRC_OUT_4_6 VDD VDD pmos W=0.205u L=0.04u
M12922 U1796/net6 U1796/net4 VDD VDD pmos W=0.24u L=0.04u
M12923 n1136 U1796/net14 VDD VDD pmos W=0.205u L=0.04u
M12924 U1796/net10 WX7350 VDD VDD pmos W=0.205u L=0.04u
M12925 U1797/net4 WX7348 U1797/net14 VSS nmos W=0.155u L=0.04u
M12926 U1797/net6 U1797/net10 U1797/net14 VSS nmos W=0.17u L=0.04u
M12927 U1797/net4 CRC_OUT_4_7 VSS VSS nmos W=0.155u L=0.04u
M12928 U1797/net6 U1797/net4 VSS VSS nmos W=0.17u L=0.04u
M12929 n1135 U1797/net14 VSS VSS nmos W=0.155u L=0.04u
M12930 U1797/net10 WX7348 VSS VSS nmos W=0.155u L=0.04u
M12931 U1797/net4 U1797/net10 U1797/net14 VDD pmos W=0.255u L=0.04u
M12932 U1797/net6 WX7348 U1797/net14 VDD pmos W=0.28u L=0.04u
M12933 U1797/net4 CRC_OUT_4_7 VDD VDD pmos W=0.205u L=0.04u
M12934 U1797/net6 U1797/net4 VDD VDD pmos W=0.24u L=0.04u
M12935 n1135 U1797/net14 VDD VDD pmos W=0.205u L=0.04u
M12936 U1797/net10 WX7348 VDD VDD pmos W=0.205u L=0.04u
M12937 U1798/net4 WX7346 U1798/net14 VSS nmos W=0.155u L=0.04u
M12938 U1798/net6 U1798/net10 U1798/net14 VSS nmos W=0.17u L=0.04u
M12939 U1798/net4 CRC_OUT_4_8 VSS VSS nmos W=0.155u L=0.04u
M12940 U1798/net6 U1798/net4 VSS VSS nmos W=0.17u L=0.04u
M12941 n1134 U1798/net14 VSS VSS nmos W=0.155u L=0.04u
M12942 U1798/net10 WX7346 VSS VSS nmos W=0.155u L=0.04u
M12943 U1798/net4 U1798/net10 U1798/net14 VDD pmos W=0.255u L=0.04u
M12944 U1798/net6 WX7346 U1798/net14 VDD pmos W=0.28u L=0.04u
M12945 U1798/net4 CRC_OUT_4_8 VDD VDD pmos W=0.205u L=0.04u
M12946 U1798/net6 U1798/net4 VDD VDD pmos W=0.24u L=0.04u
M12947 n1134 U1798/net14 VDD VDD pmos W=0.205u L=0.04u
M12948 U1798/net10 WX7346 VDD VDD pmos W=0.205u L=0.04u
M12949 U1799/net4 WX7344 U1799/net14 VSS nmos W=0.155u L=0.04u
M12950 U1799/net6 U1799/net10 U1799/net14 VSS nmos W=0.17u L=0.04u
M12951 U1799/net4 CRC_OUT_4_9 VSS VSS nmos W=0.155u L=0.04u
M12952 U1799/net6 U1799/net4 VSS VSS nmos W=0.17u L=0.04u
M12953 n1133 U1799/net14 VSS VSS nmos W=0.155u L=0.04u
M12954 U1799/net10 WX7344 VSS VSS nmos W=0.155u L=0.04u
M12955 U1799/net4 U1799/net10 U1799/net14 VDD pmos W=0.255u L=0.04u
M12956 U1799/net6 WX7344 U1799/net14 VDD pmos W=0.28u L=0.04u
M12957 U1799/net4 CRC_OUT_4_9 VDD VDD pmos W=0.205u L=0.04u
M12958 U1799/net6 U1799/net4 VDD VDD pmos W=0.24u L=0.04u
M12959 n1133 U1799/net14 VDD VDD pmos W=0.205u L=0.04u
M12960 U1799/net10 WX7344 VDD VDD pmos W=0.205u L=0.04u
M12961 U1800/net11 CRC_OUT_4_31 U1800/net17 VSS nmos W=0.155u L=0.04u
M12962 U1800/net5 U1800/net17 U1800/net21 VSS nmos W=0.155u L=0.04u
M12963 U1800/net5 CRC_OUT_4_10 VSS VSS nmos W=0.155u L=0.04u
M12964 n1132 U1800/net21 VSS VSS nmos W=0.155u L=0.04u
M12965 U1800/net16 CRC_OUT_4_31 VSS VSS nmos W=0.155u L=0.04u
M12966 U1800/net11 WX7342 VSS VSS nmos W=0.155u L=0.04u
M12967 U1800/net13 U1800/net17 VSS VSS nmos W=0.155u L=0.04u
M12968 U1800/net17 U1800/net16 U1800/XI2-net16 VSS nmos W=0.155u L=0.04u
M12969 U1800/XI2-net16 U1800/net11 VSS VSS nmos W=0.155u L=0.04u
M12970 U1800/net21 U1800/net13 U1800/XU21-net16 VSS nmos W=0.155u L=0.04u
M12971 U1800/XU21-net16 U1800/net5 VSS VSS nmos W=0.155u L=0.04u
M12972 U1800/net11 U1800/net16 U1800/net17 VDD pmos W=0.205u L=0.04u
M12973 U1800/net5 U1800/net13 U1800/net21 VDD pmos W=0.205u L=0.04u
M12974 U1800/net5 CRC_OUT_4_10 VDD VDD pmos W=0.205u L=0.04u
M12975 n1132 U1800/net21 VDD VDD pmos W=0.205u L=0.04u
M12976 U1800/net16 CRC_OUT_4_31 VDD VDD pmos W=0.205u L=0.04u
M12977 U1800/net11 WX7342 VDD VDD pmos W=0.205u L=0.04u
M12978 U1800/net13 U1800/net17 VDD VDD pmos W=0.205u L=0.04u
M12979 U1800/net17 CRC_OUT_4_31 U1800/XI2-net6 VDD pmos W=0.205u L=0.04u
M12980 U1800/XI2-net6 U1800/net11 VDD VDD pmos W=0.205u L=0.04u
M12981 U1800/net21 U1800/net17 U1800/XU21-net6 VDD pmos W=0.205u L=0.04u
M12982 U1800/XU21-net6 U1800/net5 VDD VDD pmos W=0.205u L=0.04u
M12983 U1801/net4 WX7340 U1801/net14 VSS nmos W=0.155u L=0.04u
M12984 U1801/net6 U1801/net10 U1801/net14 VSS nmos W=0.17u L=0.04u
M12985 U1801/net4 CRC_OUT_4_11 VSS VSS nmos W=0.155u L=0.04u
M12986 U1801/net6 U1801/net4 VSS VSS nmos W=0.17u L=0.04u
M12987 n1131 U1801/net14 VSS VSS nmos W=0.155u L=0.04u
M12988 U1801/net10 WX7340 VSS VSS nmos W=0.155u L=0.04u
M12989 U1801/net4 U1801/net10 U1801/net14 VDD pmos W=0.255u L=0.04u
M12990 U1801/net6 WX7340 U1801/net14 VDD pmos W=0.28u L=0.04u
M12991 U1801/net4 CRC_OUT_4_11 VDD VDD pmos W=0.205u L=0.04u
M12992 U1801/net6 U1801/net4 VDD VDD pmos W=0.24u L=0.04u
M12993 n1131 U1801/net14 VDD VDD pmos W=0.205u L=0.04u
M12994 U1801/net10 WX7340 VDD VDD pmos W=0.205u L=0.04u
M12995 U1802/net4 WX7338 U1802/net14 VSS nmos W=0.155u L=0.04u
M12996 U1802/net6 U1802/net10 U1802/net14 VSS nmos W=0.17u L=0.04u
M12997 U1802/net4 CRC_OUT_4_12 VSS VSS nmos W=0.155u L=0.04u
M12998 U1802/net6 U1802/net4 VSS VSS nmos W=0.17u L=0.04u
M12999 n1130 U1802/net14 VSS VSS nmos W=0.155u L=0.04u
M13000 U1802/net10 WX7338 VSS VSS nmos W=0.155u L=0.04u
M13001 U1802/net4 U1802/net10 U1802/net14 VDD pmos W=0.255u L=0.04u
M13002 U1802/net6 WX7338 U1802/net14 VDD pmos W=0.28u L=0.04u
M13003 U1802/net4 CRC_OUT_4_12 VDD VDD pmos W=0.205u L=0.04u
M13004 U1802/net6 U1802/net4 VDD VDD pmos W=0.24u L=0.04u
M13005 n1130 U1802/net14 VDD VDD pmos W=0.205u L=0.04u
M13006 U1802/net10 WX7338 VDD VDD pmos W=0.205u L=0.04u
M13007 U1803/net4 WX7336 U1803/net14 VSS nmos W=0.155u L=0.04u
M13008 U1803/net6 U1803/net10 U1803/net14 VSS nmos W=0.17u L=0.04u
M13009 U1803/net4 CRC_OUT_4_13 VSS VSS nmos W=0.155u L=0.04u
M13010 U1803/net6 U1803/net4 VSS VSS nmos W=0.17u L=0.04u
M13011 n1129 U1803/net14 VSS VSS nmos W=0.155u L=0.04u
M13012 U1803/net10 WX7336 VSS VSS nmos W=0.155u L=0.04u
M13013 U1803/net4 U1803/net10 U1803/net14 VDD pmos W=0.255u L=0.04u
M13014 U1803/net6 WX7336 U1803/net14 VDD pmos W=0.28u L=0.04u
M13015 U1803/net4 CRC_OUT_4_13 VDD VDD pmos W=0.205u L=0.04u
M13016 U1803/net6 U1803/net4 VDD VDD pmos W=0.24u L=0.04u
M13017 n1129 U1803/net14 VDD VDD pmos W=0.205u L=0.04u
M13018 U1803/net10 WX7336 VDD VDD pmos W=0.205u L=0.04u
M13019 U1804/net4 WX7334 U1804/net14 VSS nmos W=0.155u L=0.04u
M13020 U1804/net6 U1804/net10 U1804/net14 VSS nmos W=0.17u L=0.04u
M13021 U1804/net4 CRC_OUT_4_14 VSS VSS nmos W=0.155u L=0.04u
M13022 U1804/net6 U1804/net4 VSS VSS nmos W=0.17u L=0.04u
M13023 n1128 U1804/net14 VSS VSS nmos W=0.155u L=0.04u
M13024 U1804/net10 WX7334 VSS VSS nmos W=0.155u L=0.04u
M13025 U1804/net4 U1804/net10 U1804/net14 VDD pmos W=0.255u L=0.04u
M13026 U1804/net6 WX7334 U1804/net14 VDD pmos W=0.28u L=0.04u
M13027 U1804/net4 CRC_OUT_4_14 VDD VDD pmos W=0.205u L=0.04u
M13028 U1804/net6 U1804/net4 VDD VDD pmos W=0.24u L=0.04u
M13029 n1128 U1804/net14 VDD VDD pmos W=0.205u L=0.04u
M13030 U1804/net10 WX7334 VDD VDD pmos W=0.205u L=0.04u
M13031 U1805/net11 CRC_OUT_4_31 U1805/net17 VSS nmos W=0.155u L=0.04u
M13032 U1805/net5 U1805/net17 U1805/net21 VSS nmos W=0.155u L=0.04u
M13033 U1805/net5 CRC_OUT_4_15 VSS VSS nmos W=0.155u L=0.04u
M13034 n1127 U1805/net21 VSS VSS nmos W=0.155u L=0.04u
M13035 U1805/net16 CRC_OUT_4_31 VSS VSS nmos W=0.155u L=0.04u
M13036 U1805/net11 WX7332 VSS VSS nmos W=0.155u L=0.04u
M13037 U1805/net13 U1805/net17 VSS VSS nmos W=0.155u L=0.04u
M13038 U1805/net17 U1805/net16 U1805/XI2-net16 VSS nmos W=0.155u L=0.04u
M13039 U1805/XI2-net16 U1805/net11 VSS VSS nmos W=0.155u L=0.04u
M13040 U1805/net21 U1805/net13 U1805/XU21-net16 VSS nmos W=0.155u L=0.04u
M13041 U1805/XU21-net16 U1805/net5 VSS VSS nmos W=0.155u L=0.04u
M13042 U1805/net11 U1805/net16 U1805/net17 VDD pmos W=0.205u L=0.04u
M13043 U1805/net5 U1805/net13 U1805/net21 VDD pmos W=0.205u L=0.04u
M13044 U1805/net5 CRC_OUT_4_15 VDD VDD pmos W=0.205u L=0.04u
M13045 n1127 U1805/net21 VDD VDD pmos W=0.205u L=0.04u
M13046 U1805/net16 CRC_OUT_4_31 VDD VDD pmos W=0.205u L=0.04u
M13047 U1805/net11 WX7332 VDD VDD pmos W=0.205u L=0.04u
M13048 U1805/net13 U1805/net17 VDD VDD pmos W=0.205u L=0.04u
M13049 U1805/net17 CRC_OUT_4_31 U1805/XI2-net6 VDD pmos W=0.205u L=0.04u
M13050 U1805/XI2-net6 U1805/net11 VDD VDD pmos W=0.205u L=0.04u
M13051 U1805/net21 U1805/net17 U1805/XU21-net6 VDD pmos W=0.205u L=0.04u
M13052 U1805/XU21-net6 U1805/net5 VDD VDD pmos W=0.205u L=0.04u
M13053 U1806/net4 WX7330 U1806/net14 VSS nmos W=0.155u L=0.04u
M13054 U1806/net6 U1806/net10 U1806/net14 VSS nmos W=0.17u L=0.04u
M13055 U1806/net4 CRC_OUT_4_16 VSS VSS nmos W=0.155u L=0.04u
M13056 U1806/net6 U1806/net4 VSS VSS nmos W=0.17u L=0.04u
M13057 n1126 U1806/net14 VSS VSS nmos W=0.155u L=0.04u
M13058 U1806/net10 WX7330 VSS VSS nmos W=0.155u L=0.04u
M13059 U1806/net4 U1806/net10 U1806/net14 VDD pmos W=0.255u L=0.04u
M13060 U1806/net6 WX7330 U1806/net14 VDD pmos W=0.28u L=0.04u
M13061 U1806/net4 CRC_OUT_4_16 VDD VDD pmos W=0.205u L=0.04u
M13062 U1806/net6 U1806/net4 VDD VDD pmos W=0.24u L=0.04u
M13063 n1126 U1806/net14 VDD VDD pmos W=0.205u L=0.04u
M13064 U1806/net10 WX7330 VDD VDD pmos W=0.205u L=0.04u
M13065 U1807/net4 WX7328 U1807/net14 VSS nmos W=0.155u L=0.04u
M13066 U1807/net6 U1807/net10 U1807/net14 VSS nmos W=0.17u L=0.04u
M13067 U1807/net4 CRC_OUT_4_17 VSS VSS nmos W=0.155u L=0.04u
M13068 U1807/net6 U1807/net4 VSS VSS nmos W=0.17u L=0.04u
M13069 n1125 U1807/net14 VSS VSS nmos W=0.155u L=0.04u
M13070 U1807/net10 WX7328 VSS VSS nmos W=0.155u L=0.04u
M13071 U1807/net4 U1807/net10 U1807/net14 VDD pmos W=0.255u L=0.04u
M13072 U1807/net6 WX7328 U1807/net14 VDD pmos W=0.28u L=0.04u
M13073 U1807/net4 CRC_OUT_4_17 VDD VDD pmos W=0.205u L=0.04u
M13074 U1807/net6 U1807/net4 VDD VDD pmos W=0.24u L=0.04u
M13075 n1125 U1807/net14 VDD VDD pmos W=0.205u L=0.04u
M13076 U1807/net10 WX7328 VDD VDD pmos W=0.205u L=0.04u
M13077 U1808/net4 WX7326 U1808/net14 VSS nmos W=0.155u L=0.04u
M13078 U1808/net6 U1808/net10 U1808/net14 VSS nmos W=0.17u L=0.04u
M13079 U1808/net4 CRC_OUT_4_18 VSS VSS nmos W=0.155u L=0.04u
M13080 U1808/net6 U1808/net4 VSS VSS nmos W=0.17u L=0.04u
M13081 n1124 U1808/net14 VSS VSS nmos W=0.155u L=0.04u
M13082 U1808/net10 WX7326 VSS VSS nmos W=0.155u L=0.04u
M13083 U1808/net4 U1808/net10 U1808/net14 VDD pmos W=0.255u L=0.04u
M13084 U1808/net6 WX7326 U1808/net14 VDD pmos W=0.28u L=0.04u
M13085 U1808/net4 CRC_OUT_4_18 VDD VDD pmos W=0.205u L=0.04u
M13086 U1808/net6 U1808/net4 VDD VDD pmos W=0.24u L=0.04u
M13087 n1124 U1808/net14 VDD VDD pmos W=0.205u L=0.04u
M13088 U1808/net10 WX7326 VDD VDD pmos W=0.205u L=0.04u
M13089 U1809/net4 WX7324 U1809/net14 VSS nmos W=0.155u L=0.04u
M13090 U1809/net6 U1809/net10 U1809/net14 VSS nmos W=0.17u L=0.04u
M13091 U1809/net4 CRC_OUT_4_19 VSS VSS nmos W=0.155u L=0.04u
M13092 U1809/net6 U1809/net4 VSS VSS nmos W=0.17u L=0.04u
M13093 n1123 U1809/net14 VSS VSS nmos W=0.155u L=0.04u
M13094 U1809/net10 WX7324 VSS VSS nmos W=0.155u L=0.04u
M13095 U1809/net4 U1809/net10 U1809/net14 VDD pmos W=0.255u L=0.04u
M13096 U1809/net6 WX7324 U1809/net14 VDD pmos W=0.28u L=0.04u
M13097 U1809/net4 CRC_OUT_4_19 VDD VDD pmos W=0.205u L=0.04u
M13098 U1809/net6 U1809/net4 VDD VDD pmos W=0.24u L=0.04u
M13099 n1123 U1809/net14 VDD VDD pmos W=0.205u L=0.04u
M13100 U1809/net10 WX7324 VDD VDD pmos W=0.205u L=0.04u
M13101 U1810/net4 WX7322 U1810/net14 VSS nmos W=0.155u L=0.04u
M13102 U1810/net6 U1810/net10 U1810/net14 VSS nmos W=0.17u L=0.04u
M13103 U1810/net4 CRC_OUT_4_20 VSS VSS nmos W=0.155u L=0.04u
M13104 U1810/net6 U1810/net4 VSS VSS nmos W=0.17u L=0.04u
M13105 n1122 U1810/net14 VSS VSS nmos W=0.155u L=0.04u
M13106 U1810/net10 WX7322 VSS VSS nmos W=0.155u L=0.04u
M13107 U1810/net4 U1810/net10 U1810/net14 VDD pmos W=0.255u L=0.04u
M13108 U1810/net6 WX7322 U1810/net14 VDD pmos W=0.28u L=0.04u
M13109 U1810/net4 CRC_OUT_4_20 VDD VDD pmos W=0.205u L=0.04u
M13110 U1810/net6 U1810/net4 VDD VDD pmos W=0.24u L=0.04u
M13111 n1122 U1810/net14 VDD VDD pmos W=0.205u L=0.04u
M13112 U1810/net10 WX7322 VDD VDD pmos W=0.205u L=0.04u
M13113 U1811/net4 WX7320 U1811/net14 VSS nmos W=0.155u L=0.04u
M13114 U1811/net6 U1811/net10 U1811/net14 VSS nmos W=0.17u L=0.04u
M13115 U1811/net4 CRC_OUT_4_21 VSS VSS nmos W=0.155u L=0.04u
M13116 U1811/net6 U1811/net4 VSS VSS nmos W=0.17u L=0.04u
M13117 n1121 U1811/net14 VSS VSS nmos W=0.155u L=0.04u
M13118 U1811/net10 WX7320 VSS VSS nmos W=0.155u L=0.04u
M13119 U1811/net4 U1811/net10 U1811/net14 VDD pmos W=0.255u L=0.04u
M13120 U1811/net6 WX7320 U1811/net14 VDD pmos W=0.28u L=0.04u
M13121 U1811/net4 CRC_OUT_4_21 VDD VDD pmos W=0.205u L=0.04u
M13122 U1811/net6 U1811/net4 VDD VDD pmos W=0.24u L=0.04u
M13123 n1121 U1811/net14 VDD VDD pmos W=0.205u L=0.04u
M13124 U1811/net10 WX7320 VDD VDD pmos W=0.205u L=0.04u
M13125 U1812/net4 WX7318 U1812/net14 VSS nmos W=0.155u L=0.04u
M13126 U1812/net6 U1812/net10 U1812/net14 VSS nmos W=0.17u L=0.04u
M13127 U1812/net4 CRC_OUT_4_22 VSS VSS nmos W=0.155u L=0.04u
M13128 U1812/net6 U1812/net4 VSS VSS nmos W=0.17u L=0.04u
M13129 n1120 U1812/net14 VSS VSS nmos W=0.155u L=0.04u
M13130 U1812/net10 WX7318 VSS VSS nmos W=0.155u L=0.04u
M13131 U1812/net4 U1812/net10 U1812/net14 VDD pmos W=0.255u L=0.04u
M13132 U1812/net6 WX7318 U1812/net14 VDD pmos W=0.28u L=0.04u
M13133 U1812/net4 CRC_OUT_4_22 VDD VDD pmos W=0.205u L=0.04u
M13134 U1812/net6 U1812/net4 VDD VDD pmos W=0.24u L=0.04u
M13135 n1120 U1812/net14 VDD VDD pmos W=0.205u L=0.04u
M13136 U1812/net10 WX7318 VDD VDD pmos W=0.205u L=0.04u
M13137 U1813/net4 WX7316 U1813/net14 VSS nmos W=0.155u L=0.04u
M13138 U1813/net6 U1813/net10 U1813/net14 VSS nmos W=0.17u L=0.04u
M13139 U1813/net4 CRC_OUT_4_23 VSS VSS nmos W=0.155u L=0.04u
M13140 U1813/net6 U1813/net4 VSS VSS nmos W=0.17u L=0.04u
M13141 n1119 U1813/net14 VSS VSS nmos W=0.155u L=0.04u
M13142 U1813/net10 WX7316 VSS VSS nmos W=0.155u L=0.04u
M13143 U1813/net4 U1813/net10 U1813/net14 VDD pmos W=0.255u L=0.04u
M13144 U1813/net6 WX7316 U1813/net14 VDD pmos W=0.28u L=0.04u
M13145 U1813/net4 CRC_OUT_4_23 VDD VDD pmos W=0.205u L=0.04u
M13146 U1813/net6 U1813/net4 VDD VDD pmos W=0.24u L=0.04u
M13147 n1119 U1813/net14 VDD VDD pmos W=0.205u L=0.04u
M13148 U1813/net10 WX7316 VDD VDD pmos W=0.205u L=0.04u
M13149 U1814/net4 WX7314 U1814/net14 VSS nmos W=0.155u L=0.04u
M13150 U1814/net6 U1814/net10 U1814/net14 VSS nmos W=0.17u L=0.04u
M13151 U1814/net4 CRC_OUT_4_24 VSS VSS nmos W=0.155u L=0.04u
M13152 U1814/net6 U1814/net4 VSS VSS nmos W=0.17u L=0.04u
M13153 n1118 U1814/net14 VSS VSS nmos W=0.155u L=0.04u
M13154 U1814/net10 WX7314 VSS VSS nmos W=0.155u L=0.04u
M13155 U1814/net4 U1814/net10 U1814/net14 VDD pmos W=0.255u L=0.04u
M13156 U1814/net6 WX7314 U1814/net14 VDD pmos W=0.28u L=0.04u
M13157 U1814/net4 CRC_OUT_4_24 VDD VDD pmos W=0.205u L=0.04u
M13158 U1814/net6 U1814/net4 VDD VDD pmos W=0.24u L=0.04u
M13159 n1118 U1814/net14 VDD VDD pmos W=0.205u L=0.04u
M13160 U1814/net10 WX7314 VDD VDD pmos W=0.205u L=0.04u
M13161 U1815/net4 WX7312 U1815/net14 VSS nmos W=0.155u L=0.04u
M13162 U1815/net6 U1815/net10 U1815/net14 VSS nmos W=0.17u L=0.04u
M13163 U1815/net4 CRC_OUT_4_25 VSS VSS nmos W=0.155u L=0.04u
M13164 U1815/net6 U1815/net4 VSS VSS nmos W=0.17u L=0.04u
M13165 n1117 U1815/net14 VSS VSS nmos W=0.155u L=0.04u
M13166 U1815/net10 WX7312 VSS VSS nmos W=0.155u L=0.04u
M13167 U1815/net4 U1815/net10 U1815/net14 VDD pmos W=0.255u L=0.04u
M13168 U1815/net6 WX7312 U1815/net14 VDD pmos W=0.28u L=0.04u
M13169 U1815/net4 CRC_OUT_4_25 VDD VDD pmos W=0.205u L=0.04u
M13170 U1815/net6 U1815/net4 VDD VDD pmos W=0.24u L=0.04u
M13171 n1117 U1815/net14 VDD VDD pmos W=0.205u L=0.04u
M13172 U1815/net10 WX7312 VDD VDD pmos W=0.205u L=0.04u
M13173 U1816/net4 WX7310 U1816/net14 VSS nmos W=0.155u L=0.04u
M13174 U1816/net6 U1816/net10 U1816/net14 VSS nmos W=0.17u L=0.04u
M13175 U1816/net4 CRC_OUT_4_26 VSS VSS nmos W=0.155u L=0.04u
M13176 U1816/net6 U1816/net4 VSS VSS nmos W=0.17u L=0.04u
M13177 n1116 U1816/net14 VSS VSS nmos W=0.155u L=0.04u
M13178 U1816/net10 WX7310 VSS VSS nmos W=0.155u L=0.04u
M13179 U1816/net4 U1816/net10 U1816/net14 VDD pmos W=0.255u L=0.04u
M13180 U1816/net6 WX7310 U1816/net14 VDD pmos W=0.28u L=0.04u
M13181 U1816/net4 CRC_OUT_4_26 VDD VDD pmos W=0.205u L=0.04u
M13182 U1816/net6 U1816/net4 VDD VDD pmos W=0.24u L=0.04u
M13183 n1116 U1816/net14 VDD VDD pmos W=0.205u L=0.04u
M13184 U1816/net10 WX7310 VDD VDD pmos W=0.205u L=0.04u
M13185 U1817/net4 WX7308 U1817/net14 VSS nmos W=0.155u L=0.04u
M13186 U1817/net6 U1817/net10 U1817/net14 VSS nmos W=0.17u L=0.04u
M13187 U1817/net4 CRC_OUT_4_27 VSS VSS nmos W=0.155u L=0.04u
M13188 U1817/net6 U1817/net4 VSS VSS nmos W=0.17u L=0.04u
M13189 n1115 U1817/net14 VSS VSS nmos W=0.155u L=0.04u
M13190 U1817/net10 WX7308 VSS VSS nmos W=0.155u L=0.04u
M13191 U1817/net4 U1817/net10 U1817/net14 VDD pmos W=0.255u L=0.04u
M13192 U1817/net6 WX7308 U1817/net14 VDD pmos W=0.28u L=0.04u
M13193 U1817/net4 CRC_OUT_4_27 VDD VDD pmos W=0.205u L=0.04u
M13194 U1817/net6 U1817/net4 VDD VDD pmos W=0.24u L=0.04u
M13195 n1115 U1817/net14 VDD VDD pmos W=0.205u L=0.04u
M13196 U1817/net10 WX7308 VDD VDD pmos W=0.205u L=0.04u
M13197 U1818/net4 WX7306 U1818/net14 VSS nmos W=0.155u L=0.04u
M13198 U1818/net6 U1818/net10 U1818/net14 VSS nmos W=0.17u L=0.04u
M13199 U1818/net4 CRC_OUT_4_28 VSS VSS nmos W=0.155u L=0.04u
M13200 U1818/net6 U1818/net4 VSS VSS nmos W=0.17u L=0.04u
M13201 n1114 U1818/net14 VSS VSS nmos W=0.155u L=0.04u
M13202 U1818/net10 WX7306 VSS VSS nmos W=0.155u L=0.04u
M13203 U1818/net4 U1818/net10 U1818/net14 VDD pmos W=0.255u L=0.04u
M13204 U1818/net6 WX7306 U1818/net14 VDD pmos W=0.28u L=0.04u
M13205 U1818/net4 CRC_OUT_4_28 VDD VDD pmos W=0.205u L=0.04u
M13206 U1818/net6 U1818/net4 VDD VDD pmos W=0.24u L=0.04u
M13207 n1114 U1818/net14 VDD VDD pmos W=0.205u L=0.04u
M13208 U1818/net10 WX7306 VDD VDD pmos W=0.205u L=0.04u
M13209 U1819/net4 WX7304 U1819/net14 VSS nmos W=0.155u L=0.04u
M13210 U1819/net6 U1819/net10 U1819/net14 VSS nmos W=0.17u L=0.04u
M13211 U1819/net4 CRC_OUT_4_29 VSS VSS nmos W=0.155u L=0.04u
M13212 U1819/net6 U1819/net4 VSS VSS nmos W=0.17u L=0.04u
M13213 n1113 U1819/net14 VSS VSS nmos W=0.155u L=0.04u
M13214 U1819/net10 WX7304 VSS VSS nmos W=0.155u L=0.04u
M13215 U1819/net4 U1819/net10 U1819/net14 VDD pmos W=0.255u L=0.04u
M13216 U1819/net6 WX7304 U1819/net14 VDD pmos W=0.28u L=0.04u
M13217 U1819/net4 CRC_OUT_4_29 VDD VDD pmos W=0.205u L=0.04u
M13218 U1819/net6 U1819/net4 VDD VDD pmos W=0.24u L=0.04u
M13219 n1113 U1819/net14 VDD VDD pmos W=0.205u L=0.04u
M13220 U1819/net10 WX7304 VDD VDD pmos W=0.205u L=0.04u
M13221 U1820/net4 WX7302 U1820/net14 VSS nmos W=0.155u L=0.04u
M13222 U1820/net6 U1820/net10 U1820/net14 VSS nmos W=0.17u L=0.04u
M13223 U1820/net4 CRC_OUT_4_30 VSS VSS nmos W=0.155u L=0.04u
M13224 U1820/net6 U1820/net4 VSS VSS nmos W=0.17u L=0.04u
M13225 n1112 U1820/net14 VSS VSS nmos W=0.155u L=0.04u
M13226 U1820/net10 WX7302 VSS VSS nmos W=0.155u L=0.04u
M13227 U1820/net4 U1820/net10 U1820/net14 VDD pmos W=0.255u L=0.04u
M13228 U1820/net6 WX7302 U1820/net14 VDD pmos W=0.28u L=0.04u
M13229 U1820/net4 CRC_OUT_4_30 VDD VDD pmos W=0.205u L=0.04u
M13230 U1820/net6 U1820/net4 VDD VDD pmos W=0.24u L=0.04u
M13231 n1112 U1820/net14 VDD VDD pmos W=0.205u L=0.04u
M13232 U1820/net10 WX7302 VDD VDD pmos W=0.205u L=0.04u
M13233 U1821/net4 n1390 U1821/net14 VSS nmos W=0.155u L=0.04u
M13234 U1821/net6 U1821/net10 U1821/net14 VSS nmos W=0.17u L=0.04u
M13235 U1821/net4 n1391 VSS VSS nmos W=0.155u L=0.04u
M13236 U1821/net6 U1821/net4 VSS VSS nmos W=0.17u L=0.04u
M13237 n1111 U1821/net14 VSS VSS nmos W=0.155u L=0.04u
M13238 U1821/net10 n1390 VSS VSS nmos W=0.155u L=0.04u
M13239 U1821/net4 U1821/net10 U1821/net14 VDD pmos W=0.255u L=0.04u
M13240 U1821/net6 n1390 U1821/net14 VDD pmos W=0.28u L=0.04u
M13241 U1821/net4 n1391 VDD VDD pmos W=0.205u L=0.04u
M13242 U1821/net6 U1821/net4 VDD VDD pmos W=0.24u L=0.04u
M13243 n1111 U1821/net14 VDD VDD pmos W=0.205u L=0.04u
M13244 U1821/net10 n1390 VDD VDD pmos W=0.205u L=0.04u
M13245 U1822/net4 WX6069 U1822/net14 VSS nmos W=0.155u L=0.04u
M13246 U1822/net6 U1822/net10 U1822/net14 VSS nmos W=0.17u L=0.04u
M13247 U1822/net4 CRC_OUT_5_0 VSS VSS nmos W=0.155u L=0.04u
M13248 U1822/net6 U1822/net4 VSS VSS nmos W=0.17u L=0.04u
M13249 n1110 U1822/net14 VSS VSS nmos W=0.155u L=0.04u
M13250 U1822/net10 WX6069 VSS VSS nmos W=0.155u L=0.04u
M13251 U1822/net4 U1822/net10 U1822/net14 VDD pmos W=0.255u L=0.04u
M13252 U1822/net6 WX6069 U1822/net14 VDD pmos W=0.28u L=0.04u
M13253 U1822/net4 CRC_OUT_5_0 VDD VDD pmos W=0.205u L=0.04u
M13254 U1822/net6 U1822/net4 VDD VDD pmos W=0.24u L=0.04u
M13255 n1110 U1822/net14 VDD VDD pmos W=0.205u L=0.04u
M13256 U1822/net10 WX6069 VDD VDD pmos W=0.205u L=0.04u
M13257 U1823/net4 WX6067 U1823/net14 VSS nmos W=0.155u L=0.04u
M13258 U1823/net6 U1823/net10 U1823/net14 VSS nmos W=0.17u L=0.04u
M13259 U1823/net4 CRC_OUT_5_1 VSS VSS nmos W=0.155u L=0.04u
M13260 U1823/net6 U1823/net4 VSS VSS nmos W=0.17u L=0.04u
M13261 n1109 U1823/net14 VSS VSS nmos W=0.155u L=0.04u
M13262 U1823/net10 WX6067 VSS VSS nmos W=0.155u L=0.04u
M13263 U1823/net4 U1823/net10 U1823/net14 VDD pmos W=0.255u L=0.04u
M13264 U1823/net6 WX6067 U1823/net14 VDD pmos W=0.28u L=0.04u
M13265 U1823/net4 CRC_OUT_5_1 VDD VDD pmos W=0.205u L=0.04u
M13266 U1823/net6 U1823/net4 VDD VDD pmos W=0.24u L=0.04u
M13267 n1109 U1823/net14 VDD VDD pmos W=0.205u L=0.04u
M13268 U1823/net10 WX6067 VDD VDD pmos W=0.205u L=0.04u
M13269 U1824/net4 WX6065 U1824/net14 VSS nmos W=0.155u L=0.04u
M13270 U1824/net6 U1824/net10 U1824/net14 VSS nmos W=0.17u L=0.04u
M13271 U1824/net4 CRC_OUT_5_2 VSS VSS nmos W=0.155u L=0.04u
M13272 U1824/net6 U1824/net4 VSS VSS nmos W=0.17u L=0.04u
M13273 n1108 U1824/net14 VSS VSS nmos W=0.155u L=0.04u
M13274 U1824/net10 WX6065 VSS VSS nmos W=0.155u L=0.04u
M13275 U1824/net4 U1824/net10 U1824/net14 VDD pmos W=0.255u L=0.04u
M13276 U1824/net6 WX6065 U1824/net14 VDD pmos W=0.28u L=0.04u
M13277 U1824/net4 CRC_OUT_5_2 VDD VDD pmos W=0.205u L=0.04u
M13278 U1824/net6 U1824/net4 VDD VDD pmos W=0.24u L=0.04u
M13279 n1108 U1824/net14 VDD VDD pmos W=0.205u L=0.04u
M13280 U1824/net10 WX6065 VDD VDD pmos W=0.205u L=0.04u
M13281 U1825/net11 CRC_OUT_5_31 U1825/net17 VSS nmos W=0.155u L=0.04u
M13282 U1825/net5 U1825/net17 U1825/net21 VSS nmos W=0.155u L=0.04u
M13283 U1825/net5 CRC_OUT_5_3 VSS VSS nmos W=0.155u L=0.04u
M13284 n1107 U1825/net21 VSS VSS nmos W=0.155u L=0.04u
M13285 U1825/net16 CRC_OUT_5_31 VSS VSS nmos W=0.155u L=0.04u
M13286 U1825/net11 WX6063 VSS VSS nmos W=0.155u L=0.04u
M13287 U1825/net13 U1825/net17 VSS VSS nmos W=0.155u L=0.04u
M13288 U1825/net17 U1825/net16 U1825/XI2-net16 VSS nmos W=0.155u L=0.04u
M13289 U1825/XI2-net16 U1825/net11 VSS VSS nmos W=0.155u L=0.04u
M13290 U1825/net21 U1825/net13 U1825/XU21-net16 VSS nmos W=0.155u L=0.04u
M13291 U1825/XU21-net16 U1825/net5 VSS VSS nmos W=0.155u L=0.04u
M13292 U1825/net11 U1825/net16 U1825/net17 VDD pmos W=0.205u L=0.04u
M13293 U1825/net5 U1825/net13 U1825/net21 VDD pmos W=0.205u L=0.04u
M13294 U1825/net5 CRC_OUT_5_3 VDD VDD pmos W=0.205u L=0.04u
M13295 n1107 U1825/net21 VDD VDD pmos W=0.205u L=0.04u
M13296 U1825/net16 CRC_OUT_5_31 VDD VDD pmos W=0.205u L=0.04u
M13297 U1825/net11 WX6063 VDD VDD pmos W=0.205u L=0.04u
M13298 U1825/net13 U1825/net17 VDD VDD pmos W=0.205u L=0.04u
M13299 U1825/net17 CRC_OUT_5_31 U1825/XI2-net6 VDD pmos W=0.205u L=0.04u
M13300 U1825/XI2-net6 U1825/net11 VDD VDD pmos W=0.205u L=0.04u
M13301 U1825/net21 U1825/net17 U1825/XU21-net6 VDD pmos W=0.205u L=0.04u
M13302 U1825/XU21-net6 U1825/net5 VDD VDD pmos W=0.205u L=0.04u
M13303 U1826/net4 WX6061 U1826/net14 VSS nmos W=0.155u L=0.04u
M13304 U1826/net6 U1826/net10 U1826/net14 VSS nmos W=0.17u L=0.04u
M13305 U1826/net4 CRC_OUT_5_4 VSS VSS nmos W=0.155u L=0.04u
M13306 U1826/net6 U1826/net4 VSS VSS nmos W=0.17u L=0.04u
M13307 n1106 U1826/net14 VSS VSS nmos W=0.155u L=0.04u
M13308 U1826/net10 WX6061 VSS VSS nmos W=0.155u L=0.04u
M13309 U1826/net4 U1826/net10 U1826/net14 VDD pmos W=0.255u L=0.04u
M13310 U1826/net6 WX6061 U1826/net14 VDD pmos W=0.28u L=0.04u
M13311 U1826/net4 CRC_OUT_5_4 VDD VDD pmos W=0.205u L=0.04u
M13312 U1826/net6 U1826/net4 VDD VDD pmos W=0.24u L=0.04u
M13313 n1106 U1826/net14 VDD VDD pmos W=0.205u L=0.04u
M13314 U1826/net10 WX6061 VDD VDD pmos W=0.205u L=0.04u
M13315 U1827/net4 WX6059 U1827/net14 VSS nmos W=0.155u L=0.04u
M13316 U1827/net6 U1827/net10 U1827/net14 VSS nmos W=0.17u L=0.04u
M13317 U1827/net4 CRC_OUT_5_5 VSS VSS nmos W=0.155u L=0.04u
M13318 U1827/net6 U1827/net4 VSS VSS nmos W=0.17u L=0.04u
M13319 n1105 U1827/net14 VSS VSS nmos W=0.155u L=0.04u
M13320 U1827/net10 WX6059 VSS VSS nmos W=0.155u L=0.04u
M13321 U1827/net4 U1827/net10 U1827/net14 VDD pmos W=0.255u L=0.04u
M13322 U1827/net6 WX6059 U1827/net14 VDD pmos W=0.28u L=0.04u
M13323 U1827/net4 CRC_OUT_5_5 VDD VDD pmos W=0.205u L=0.04u
M13324 U1827/net6 U1827/net4 VDD VDD pmos W=0.24u L=0.04u
M13325 n1105 U1827/net14 VDD VDD pmos W=0.205u L=0.04u
M13326 U1827/net10 WX6059 VDD VDD pmos W=0.205u L=0.04u
M13327 U1828/net4 WX6057 U1828/net14 VSS nmos W=0.155u L=0.04u
M13328 U1828/net6 U1828/net10 U1828/net14 VSS nmos W=0.17u L=0.04u
M13329 U1828/net4 CRC_OUT_5_6 VSS VSS nmos W=0.155u L=0.04u
M13330 U1828/net6 U1828/net4 VSS VSS nmos W=0.17u L=0.04u
M13331 n1104 U1828/net14 VSS VSS nmos W=0.155u L=0.04u
M13332 U1828/net10 WX6057 VSS VSS nmos W=0.155u L=0.04u
M13333 U1828/net4 U1828/net10 U1828/net14 VDD pmos W=0.255u L=0.04u
M13334 U1828/net6 WX6057 U1828/net14 VDD pmos W=0.28u L=0.04u
M13335 U1828/net4 CRC_OUT_5_6 VDD VDD pmos W=0.205u L=0.04u
M13336 U1828/net6 U1828/net4 VDD VDD pmos W=0.24u L=0.04u
M13337 n1104 U1828/net14 VDD VDD pmos W=0.205u L=0.04u
M13338 U1828/net10 WX6057 VDD VDD pmos W=0.205u L=0.04u
M13339 U1829/net4 WX6055 U1829/net14 VSS nmos W=0.155u L=0.04u
M13340 U1829/net6 U1829/net10 U1829/net14 VSS nmos W=0.17u L=0.04u
M13341 U1829/net4 CRC_OUT_5_7 VSS VSS nmos W=0.155u L=0.04u
M13342 U1829/net6 U1829/net4 VSS VSS nmos W=0.17u L=0.04u
M13343 n1103 U1829/net14 VSS VSS nmos W=0.155u L=0.04u
M13344 U1829/net10 WX6055 VSS VSS nmos W=0.155u L=0.04u
M13345 U1829/net4 U1829/net10 U1829/net14 VDD pmos W=0.255u L=0.04u
M13346 U1829/net6 WX6055 U1829/net14 VDD pmos W=0.28u L=0.04u
M13347 U1829/net4 CRC_OUT_5_7 VDD VDD pmos W=0.205u L=0.04u
M13348 U1829/net6 U1829/net4 VDD VDD pmos W=0.24u L=0.04u
M13349 n1103 U1829/net14 VDD VDD pmos W=0.205u L=0.04u
M13350 U1829/net10 WX6055 VDD VDD pmos W=0.205u L=0.04u
M13351 U1830/net4 WX6053 U1830/net14 VSS nmos W=0.155u L=0.04u
M13352 U1830/net6 U1830/net10 U1830/net14 VSS nmos W=0.17u L=0.04u
M13353 U1830/net4 CRC_OUT_5_8 VSS VSS nmos W=0.155u L=0.04u
M13354 U1830/net6 U1830/net4 VSS VSS nmos W=0.17u L=0.04u
M13355 n1102 U1830/net14 VSS VSS nmos W=0.155u L=0.04u
M13356 U1830/net10 WX6053 VSS VSS nmos W=0.155u L=0.04u
M13357 U1830/net4 U1830/net10 U1830/net14 VDD pmos W=0.255u L=0.04u
M13358 U1830/net6 WX6053 U1830/net14 VDD pmos W=0.28u L=0.04u
M13359 U1830/net4 CRC_OUT_5_8 VDD VDD pmos W=0.205u L=0.04u
M13360 U1830/net6 U1830/net4 VDD VDD pmos W=0.24u L=0.04u
M13361 n1102 U1830/net14 VDD VDD pmos W=0.205u L=0.04u
M13362 U1830/net10 WX6053 VDD VDD pmos W=0.205u L=0.04u
M13363 U1831/net4 WX6051 U1831/net14 VSS nmos W=0.155u L=0.04u
M13364 U1831/net6 U1831/net10 U1831/net14 VSS nmos W=0.17u L=0.04u
M13365 U1831/net4 CRC_OUT_5_9 VSS VSS nmos W=0.155u L=0.04u
M13366 U1831/net6 U1831/net4 VSS VSS nmos W=0.17u L=0.04u
M13367 n1101 U1831/net14 VSS VSS nmos W=0.155u L=0.04u
M13368 U1831/net10 WX6051 VSS VSS nmos W=0.155u L=0.04u
M13369 U1831/net4 U1831/net10 U1831/net14 VDD pmos W=0.255u L=0.04u
M13370 U1831/net6 WX6051 U1831/net14 VDD pmos W=0.28u L=0.04u
M13371 U1831/net4 CRC_OUT_5_9 VDD VDD pmos W=0.205u L=0.04u
M13372 U1831/net6 U1831/net4 VDD VDD pmos W=0.24u L=0.04u
M13373 n1101 U1831/net14 VDD VDD pmos W=0.205u L=0.04u
M13374 U1831/net10 WX6051 VDD VDD pmos W=0.205u L=0.04u
M13375 U1832/net11 CRC_OUT_5_31 U1832/net17 VSS nmos W=0.155u L=0.04u
M13376 U1832/net5 U1832/net17 U1832/net21 VSS nmos W=0.155u L=0.04u
M13377 U1832/net5 CRC_OUT_5_10 VSS VSS nmos W=0.155u L=0.04u
M13378 n1100 U1832/net21 VSS VSS nmos W=0.155u L=0.04u
M13379 U1832/net16 CRC_OUT_5_31 VSS VSS nmos W=0.155u L=0.04u
M13380 U1832/net11 WX6049 VSS VSS nmos W=0.155u L=0.04u
M13381 U1832/net13 U1832/net17 VSS VSS nmos W=0.155u L=0.04u
M13382 U1832/net17 U1832/net16 U1832/XI2-net16 VSS nmos W=0.155u L=0.04u
M13383 U1832/XI2-net16 U1832/net11 VSS VSS nmos W=0.155u L=0.04u
M13384 U1832/net21 U1832/net13 U1832/XU21-net16 VSS nmos W=0.155u L=0.04u
M13385 U1832/XU21-net16 U1832/net5 VSS VSS nmos W=0.155u L=0.04u
M13386 U1832/net11 U1832/net16 U1832/net17 VDD pmos W=0.205u L=0.04u
M13387 U1832/net5 U1832/net13 U1832/net21 VDD pmos W=0.205u L=0.04u
M13388 U1832/net5 CRC_OUT_5_10 VDD VDD pmos W=0.205u L=0.04u
M13389 n1100 U1832/net21 VDD VDD pmos W=0.205u L=0.04u
M13390 U1832/net16 CRC_OUT_5_31 VDD VDD pmos W=0.205u L=0.04u
M13391 U1832/net11 WX6049 VDD VDD pmos W=0.205u L=0.04u
M13392 U1832/net13 U1832/net17 VDD VDD pmos W=0.205u L=0.04u
M13393 U1832/net17 CRC_OUT_5_31 U1832/XI2-net6 VDD pmos W=0.205u L=0.04u
M13394 U1832/XI2-net6 U1832/net11 VDD VDD pmos W=0.205u L=0.04u
M13395 U1832/net21 U1832/net17 U1832/XU21-net6 VDD pmos W=0.205u L=0.04u
M13396 U1832/XU21-net6 U1832/net5 VDD VDD pmos W=0.205u L=0.04u
M13397 U1833/net4 WX6047 U1833/net14 VSS nmos W=0.155u L=0.04u
M13398 U1833/net6 U1833/net10 U1833/net14 VSS nmos W=0.17u L=0.04u
M13399 U1833/net4 CRC_OUT_5_11 VSS VSS nmos W=0.155u L=0.04u
M13400 U1833/net6 U1833/net4 VSS VSS nmos W=0.17u L=0.04u
M13401 n1099 U1833/net14 VSS VSS nmos W=0.155u L=0.04u
M13402 U1833/net10 WX6047 VSS VSS nmos W=0.155u L=0.04u
M13403 U1833/net4 U1833/net10 U1833/net14 VDD pmos W=0.255u L=0.04u
M13404 U1833/net6 WX6047 U1833/net14 VDD pmos W=0.28u L=0.04u
M13405 U1833/net4 CRC_OUT_5_11 VDD VDD pmos W=0.205u L=0.04u
M13406 U1833/net6 U1833/net4 VDD VDD pmos W=0.24u L=0.04u
M13407 n1099 U1833/net14 VDD VDD pmos W=0.205u L=0.04u
M13408 U1833/net10 WX6047 VDD VDD pmos W=0.205u L=0.04u
M13409 U1834/net4 WX6045 U1834/net14 VSS nmos W=0.155u L=0.04u
M13410 U1834/net6 U1834/net10 U1834/net14 VSS nmos W=0.17u L=0.04u
M13411 U1834/net4 CRC_OUT_5_12 VSS VSS nmos W=0.155u L=0.04u
M13412 U1834/net6 U1834/net4 VSS VSS nmos W=0.17u L=0.04u
M13413 n1098 U1834/net14 VSS VSS nmos W=0.155u L=0.04u
M13414 U1834/net10 WX6045 VSS VSS nmos W=0.155u L=0.04u
M13415 U1834/net4 U1834/net10 U1834/net14 VDD pmos W=0.255u L=0.04u
M13416 U1834/net6 WX6045 U1834/net14 VDD pmos W=0.28u L=0.04u
M13417 U1834/net4 CRC_OUT_5_12 VDD VDD pmos W=0.205u L=0.04u
M13418 U1834/net6 U1834/net4 VDD VDD pmos W=0.24u L=0.04u
M13419 n1098 U1834/net14 VDD VDD pmos W=0.205u L=0.04u
M13420 U1834/net10 WX6045 VDD VDD pmos W=0.205u L=0.04u
M13421 U1835/net4 WX6043 U1835/net14 VSS nmos W=0.155u L=0.04u
M13422 U1835/net6 U1835/net10 U1835/net14 VSS nmos W=0.17u L=0.04u
M13423 U1835/net4 CRC_OUT_5_13 VSS VSS nmos W=0.155u L=0.04u
M13424 U1835/net6 U1835/net4 VSS VSS nmos W=0.17u L=0.04u
M13425 n1097 U1835/net14 VSS VSS nmos W=0.155u L=0.04u
M13426 U1835/net10 WX6043 VSS VSS nmos W=0.155u L=0.04u
M13427 U1835/net4 U1835/net10 U1835/net14 VDD pmos W=0.255u L=0.04u
M13428 U1835/net6 WX6043 U1835/net14 VDD pmos W=0.28u L=0.04u
M13429 U1835/net4 CRC_OUT_5_13 VDD VDD pmos W=0.205u L=0.04u
M13430 U1835/net6 U1835/net4 VDD VDD pmos W=0.24u L=0.04u
M13431 n1097 U1835/net14 VDD VDD pmos W=0.205u L=0.04u
M13432 U1835/net10 WX6043 VDD VDD pmos W=0.205u L=0.04u
M13433 U1836/net4 WX6041 U1836/net14 VSS nmos W=0.155u L=0.04u
M13434 U1836/net6 U1836/net10 U1836/net14 VSS nmos W=0.17u L=0.04u
M13435 U1836/net4 CRC_OUT_5_14 VSS VSS nmos W=0.155u L=0.04u
M13436 U1836/net6 U1836/net4 VSS VSS nmos W=0.17u L=0.04u
M13437 n1096 U1836/net14 VSS VSS nmos W=0.155u L=0.04u
M13438 U1836/net10 WX6041 VSS VSS nmos W=0.155u L=0.04u
M13439 U1836/net4 U1836/net10 U1836/net14 VDD pmos W=0.255u L=0.04u
M13440 U1836/net6 WX6041 U1836/net14 VDD pmos W=0.28u L=0.04u
M13441 U1836/net4 CRC_OUT_5_14 VDD VDD pmos W=0.205u L=0.04u
M13442 U1836/net6 U1836/net4 VDD VDD pmos W=0.24u L=0.04u
M13443 n1096 U1836/net14 VDD VDD pmos W=0.205u L=0.04u
M13444 U1836/net10 WX6041 VDD VDD pmos W=0.205u L=0.04u
M13445 U1837/net11 CRC_OUT_5_31 U1837/net17 VSS nmos W=0.155u L=0.04u
M13446 U1837/net5 U1837/net17 U1837/net21 VSS nmos W=0.155u L=0.04u
M13447 U1837/net5 CRC_OUT_5_15 VSS VSS nmos W=0.155u L=0.04u
M13448 n1095 U1837/net21 VSS VSS nmos W=0.155u L=0.04u
M13449 U1837/net16 CRC_OUT_5_31 VSS VSS nmos W=0.155u L=0.04u
M13450 U1837/net11 WX6039 VSS VSS nmos W=0.155u L=0.04u
M13451 U1837/net13 U1837/net17 VSS VSS nmos W=0.155u L=0.04u
M13452 U1837/net17 U1837/net16 U1837/XI2-net16 VSS nmos W=0.155u L=0.04u
M13453 U1837/XI2-net16 U1837/net11 VSS VSS nmos W=0.155u L=0.04u
M13454 U1837/net21 U1837/net13 U1837/XU21-net16 VSS nmos W=0.155u L=0.04u
M13455 U1837/XU21-net16 U1837/net5 VSS VSS nmos W=0.155u L=0.04u
M13456 U1837/net11 U1837/net16 U1837/net17 VDD pmos W=0.205u L=0.04u
M13457 U1837/net5 U1837/net13 U1837/net21 VDD pmos W=0.205u L=0.04u
M13458 U1837/net5 CRC_OUT_5_15 VDD VDD pmos W=0.205u L=0.04u
M13459 n1095 U1837/net21 VDD VDD pmos W=0.205u L=0.04u
M13460 U1837/net16 CRC_OUT_5_31 VDD VDD pmos W=0.205u L=0.04u
M13461 U1837/net11 WX6039 VDD VDD pmos W=0.205u L=0.04u
M13462 U1837/net13 U1837/net17 VDD VDD pmos W=0.205u L=0.04u
M13463 U1837/net17 CRC_OUT_5_31 U1837/XI2-net6 VDD pmos W=0.205u L=0.04u
M13464 U1837/XI2-net6 U1837/net11 VDD VDD pmos W=0.205u L=0.04u
M13465 U1837/net21 U1837/net17 U1837/XU21-net6 VDD pmos W=0.205u L=0.04u
M13466 U1837/XU21-net6 U1837/net5 VDD VDD pmos W=0.205u L=0.04u
M13467 U1838/net4 WX6037 U1838/net14 VSS nmos W=0.155u L=0.04u
M13468 U1838/net6 U1838/net10 U1838/net14 VSS nmos W=0.17u L=0.04u
M13469 U1838/net4 CRC_OUT_5_16 VSS VSS nmos W=0.155u L=0.04u
M13470 U1838/net6 U1838/net4 VSS VSS nmos W=0.17u L=0.04u
M13471 n1094 U1838/net14 VSS VSS nmos W=0.155u L=0.04u
M13472 U1838/net10 WX6037 VSS VSS nmos W=0.155u L=0.04u
M13473 U1838/net4 U1838/net10 U1838/net14 VDD pmos W=0.255u L=0.04u
M13474 U1838/net6 WX6037 U1838/net14 VDD pmos W=0.28u L=0.04u
M13475 U1838/net4 CRC_OUT_5_16 VDD VDD pmos W=0.205u L=0.04u
M13476 U1838/net6 U1838/net4 VDD VDD pmos W=0.24u L=0.04u
M13477 n1094 U1838/net14 VDD VDD pmos W=0.205u L=0.04u
M13478 U1838/net10 WX6037 VDD VDD pmos W=0.205u L=0.04u
M13479 U1839/net4 WX6035 U1839/net14 VSS nmos W=0.155u L=0.04u
M13480 U1839/net6 U1839/net10 U1839/net14 VSS nmos W=0.17u L=0.04u
M13481 U1839/net4 CRC_OUT_5_17 VSS VSS nmos W=0.155u L=0.04u
M13482 U1839/net6 U1839/net4 VSS VSS nmos W=0.17u L=0.04u
M13483 n1093 U1839/net14 VSS VSS nmos W=0.155u L=0.04u
M13484 U1839/net10 WX6035 VSS VSS nmos W=0.155u L=0.04u
M13485 U1839/net4 U1839/net10 U1839/net14 VDD pmos W=0.255u L=0.04u
M13486 U1839/net6 WX6035 U1839/net14 VDD pmos W=0.28u L=0.04u
M13487 U1839/net4 CRC_OUT_5_17 VDD VDD pmos W=0.205u L=0.04u
M13488 U1839/net6 U1839/net4 VDD VDD pmos W=0.24u L=0.04u
M13489 n1093 U1839/net14 VDD VDD pmos W=0.205u L=0.04u
M13490 U1839/net10 WX6035 VDD VDD pmos W=0.205u L=0.04u
M13491 U1840/net4 WX6033 U1840/net14 VSS nmos W=0.155u L=0.04u
M13492 U1840/net6 U1840/net10 U1840/net14 VSS nmos W=0.17u L=0.04u
M13493 U1840/net4 CRC_OUT_5_18 VSS VSS nmos W=0.155u L=0.04u
M13494 U1840/net6 U1840/net4 VSS VSS nmos W=0.17u L=0.04u
M13495 n1092 U1840/net14 VSS VSS nmos W=0.155u L=0.04u
M13496 U1840/net10 WX6033 VSS VSS nmos W=0.155u L=0.04u
M13497 U1840/net4 U1840/net10 U1840/net14 VDD pmos W=0.255u L=0.04u
M13498 U1840/net6 WX6033 U1840/net14 VDD pmos W=0.28u L=0.04u
M13499 U1840/net4 CRC_OUT_5_18 VDD VDD pmos W=0.205u L=0.04u
M13500 U1840/net6 U1840/net4 VDD VDD pmos W=0.24u L=0.04u
M13501 n1092 U1840/net14 VDD VDD pmos W=0.205u L=0.04u
M13502 U1840/net10 WX6033 VDD VDD pmos W=0.205u L=0.04u
M13503 U1841/net4 WX6031 U1841/net14 VSS nmos W=0.155u L=0.04u
M13504 U1841/net6 U1841/net10 U1841/net14 VSS nmos W=0.17u L=0.04u
M13505 U1841/net4 CRC_OUT_5_19 VSS VSS nmos W=0.155u L=0.04u
M13506 U1841/net6 U1841/net4 VSS VSS nmos W=0.17u L=0.04u
M13507 n1091 U1841/net14 VSS VSS nmos W=0.155u L=0.04u
M13508 U1841/net10 WX6031 VSS VSS nmos W=0.155u L=0.04u
M13509 U1841/net4 U1841/net10 U1841/net14 VDD pmos W=0.255u L=0.04u
M13510 U1841/net6 WX6031 U1841/net14 VDD pmos W=0.28u L=0.04u
M13511 U1841/net4 CRC_OUT_5_19 VDD VDD pmos W=0.205u L=0.04u
M13512 U1841/net6 U1841/net4 VDD VDD pmos W=0.24u L=0.04u
M13513 n1091 U1841/net14 VDD VDD pmos W=0.205u L=0.04u
M13514 U1841/net10 WX6031 VDD VDD pmos W=0.205u L=0.04u
M13515 U1842/net4 WX6029 U1842/net14 VSS nmos W=0.155u L=0.04u
M13516 U1842/net6 U1842/net10 U1842/net14 VSS nmos W=0.17u L=0.04u
M13517 U1842/net4 CRC_OUT_5_20 VSS VSS nmos W=0.155u L=0.04u
M13518 U1842/net6 U1842/net4 VSS VSS nmos W=0.17u L=0.04u
M13519 n1090 U1842/net14 VSS VSS nmos W=0.155u L=0.04u
M13520 U1842/net10 WX6029 VSS VSS nmos W=0.155u L=0.04u
M13521 U1842/net4 U1842/net10 U1842/net14 VDD pmos W=0.255u L=0.04u
M13522 U1842/net6 WX6029 U1842/net14 VDD pmos W=0.28u L=0.04u
M13523 U1842/net4 CRC_OUT_5_20 VDD VDD pmos W=0.205u L=0.04u
M13524 U1842/net6 U1842/net4 VDD VDD pmos W=0.24u L=0.04u
M13525 n1090 U1842/net14 VDD VDD pmos W=0.205u L=0.04u
M13526 U1842/net10 WX6029 VDD VDD pmos W=0.205u L=0.04u
M13527 U1843/net4 WX6027 U1843/net14 VSS nmos W=0.155u L=0.04u
M13528 U1843/net6 U1843/net10 U1843/net14 VSS nmos W=0.17u L=0.04u
M13529 U1843/net4 CRC_OUT_5_21 VSS VSS nmos W=0.155u L=0.04u
M13530 U1843/net6 U1843/net4 VSS VSS nmos W=0.17u L=0.04u
M13531 n1089 U1843/net14 VSS VSS nmos W=0.155u L=0.04u
M13532 U1843/net10 WX6027 VSS VSS nmos W=0.155u L=0.04u
M13533 U1843/net4 U1843/net10 U1843/net14 VDD pmos W=0.255u L=0.04u
M13534 U1843/net6 WX6027 U1843/net14 VDD pmos W=0.28u L=0.04u
M13535 U1843/net4 CRC_OUT_5_21 VDD VDD pmos W=0.205u L=0.04u
M13536 U1843/net6 U1843/net4 VDD VDD pmos W=0.24u L=0.04u
M13537 n1089 U1843/net14 VDD VDD pmos W=0.205u L=0.04u
M13538 U1843/net10 WX6027 VDD VDD pmos W=0.205u L=0.04u
M13539 U1844/net4 WX6025 U1844/net14 VSS nmos W=0.155u L=0.04u
M13540 U1844/net6 U1844/net10 U1844/net14 VSS nmos W=0.17u L=0.04u
M13541 U1844/net4 CRC_OUT_5_22 VSS VSS nmos W=0.155u L=0.04u
M13542 U1844/net6 U1844/net4 VSS VSS nmos W=0.17u L=0.04u
M13543 n1088 U1844/net14 VSS VSS nmos W=0.155u L=0.04u
M13544 U1844/net10 WX6025 VSS VSS nmos W=0.155u L=0.04u
M13545 U1844/net4 U1844/net10 U1844/net14 VDD pmos W=0.255u L=0.04u
M13546 U1844/net6 WX6025 U1844/net14 VDD pmos W=0.28u L=0.04u
M13547 U1844/net4 CRC_OUT_5_22 VDD VDD pmos W=0.205u L=0.04u
M13548 U1844/net6 U1844/net4 VDD VDD pmos W=0.24u L=0.04u
M13549 n1088 U1844/net14 VDD VDD pmos W=0.205u L=0.04u
M13550 U1844/net10 WX6025 VDD VDD pmos W=0.205u L=0.04u
M13551 U1845/net4 WX6023 U1845/net14 VSS nmos W=0.155u L=0.04u
M13552 U1845/net6 U1845/net10 U1845/net14 VSS nmos W=0.17u L=0.04u
M13553 U1845/net4 CRC_OUT_5_23 VSS VSS nmos W=0.155u L=0.04u
M13554 U1845/net6 U1845/net4 VSS VSS nmos W=0.17u L=0.04u
M13555 n1087 U1845/net14 VSS VSS nmos W=0.155u L=0.04u
M13556 U1845/net10 WX6023 VSS VSS nmos W=0.155u L=0.04u
M13557 U1845/net4 U1845/net10 U1845/net14 VDD pmos W=0.255u L=0.04u
M13558 U1845/net6 WX6023 U1845/net14 VDD pmos W=0.28u L=0.04u
M13559 U1845/net4 CRC_OUT_5_23 VDD VDD pmos W=0.205u L=0.04u
M13560 U1845/net6 U1845/net4 VDD VDD pmos W=0.24u L=0.04u
M13561 n1087 U1845/net14 VDD VDD pmos W=0.205u L=0.04u
M13562 U1845/net10 WX6023 VDD VDD pmos W=0.205u L=0.04u
M13563 U1846/net4 WX6021 U1846/net14 VSS nmos W=0.155u L=0.04u
M13564 U1846/net6 U1846/net10 U1846/net14 VSS nmos W=0.17u L=0.04u
M13565 U1846/net4 CRC_OUT_5_24 VSS VSS nmos W=0.155u L=0.04u
M13566 U1846/net6 U1846/net4 VSS VSS nmos W=0.17u L=0.04u
M13567 n1086 U1846/net14 VSS VSS nmos W=0.155u L=0.04u
M13568 U1846/net10 WX6021 VSS VSS nmos W=0.155u L=0.04u
M13569 U1846/net4 U1846/net10 U1846/net14 VDD pmos W=0.255u L=0.04u
M13570 U1846/net6 WX6021 U1846/net14 VDD pmos W=0.28u L=0.04u
M13571 U1846/net4 CRC_OUT_5_24 VDD VDD pmos W=0.205u L=0.04u
M13572 U1846/net6 U1846/net4 VDD VDD pmos W=0.24u L=0.04u
M13573 n1086 U1846/net14 VDD VDD pmos W=0.205u L=0.04u
M13574 U1846/net10 WX6021 VDD VDD pmos W=0.205u L=0.04u
M13575 U1847/net4 WX6019 U1847/net14 VSS nmos W=0.155u L=0.04u
M13576 U1847/net6 U1847/net10 U1847/net14 VSS nmos W=0.17u L=0.04u
M13577 U1847/net4 CRC_OUT_5_25 VSS VSS nmos W=0.155u L=0.04u
M13578 U1847/net6 U1847/net4 VSS VSS nmos W=0.17u L=0.04u
M13579 n1085 U1847/net14 VSS VSS nmos W=0.155u L=0.04u
M13580 U1847/net10 WX6019 VSS VSS nmos W=0.155u L=0.04u
M13581 U1847/net4 U1847/net10 U1847/net14 VDD pmos W=0.255u L=0.04u
M13582 U1847/net6 WX6019 U1847/net14 VDD pmos W=0.28u L=0.04u
M13583 U1847/net4 CRC_OUT_5_25 VDD VDD pmos W=0.205u L=0.04u
M13584 U1847/net6 U1847/net4 VDD VDD pmos W=0.24u L=0.04u
M13585 n1085 U1847/net14 VDD VDD pmos W=0.205u L=0.04u
M13586 U1847/net10 WX6019 VDD VDD pmos W=0.205u L=0.04u
M13587 U1848/net4 WX6017 U1848/net14 VSS nmos W=0.155u L=0.04u
M13588 U1848/net6 U1848/net10 U1848/net14 VSS nmos W=0.17u L=0.04u
M13589 U1848/net4 CRC_OUT_5_26 VSS VSS nmos W=0.155u L=0.04u
M13590 U1848/net6 U1848/net4 VSS VSS nmos W=0.17u L=0.04u
M13591 n1084 U1848/net14 VSS VSS nmos W=0.155u L=0.04u
M13592 U1848/net10 WX6017 VSS VSS nmos W=0.155u L=0.04u
M13593 U1848/net4 U1848/net10 U1848/net14 VDD pmos W=0.255u L=0.04u
M13594 U1848/net6 WX6017 U1848/net14 VDD pmos W=0.28u L=0.04u
M13595 U1848/net4 CRC_OUT_5_26 VDD VDD pmos W=0.205u L=0.04u
M13596 U1848/net6 U1848/net4 VDD VDD pmos W=0.24u L=0.04u
M13597 n1084 U1848/net14 VDD VDD pmos W=0.205u L=0.04u
M13598 U1848/net10 WX6017 VDD VDD pmos W=0.205u L=0.04u
M13599 U1849/net4 WX6015 U1849/net14 VSS nmos W=0.155u L=0.04u
M13600 U1849/net6 U1849/net10 U1849/net14 VSS nmos W=0.17u L=0.04u
M13601 U1849/net4 CRC_OUT_5_27 VSS VSS nmos W=0.155u L=0.04u
M13602 U1849/net6 U1849/net4 VSS VSS nmos W=0.17u L=0.04u
M13603 n1083 U1849/net14 VSS VSS nmos W=0.155u L=0.04u
M13604 U1849/net10 WX6015 VSS VSS nmos W=0.155u L=0.04u
M13605 U1849/net4 U1849/net10 U1849/net14 VDD pmos W=0.255u L=0.04u
M13606 U1849/net6 WX6015 U1849/net14 VDD pmos W=0.28u L=0.04u
M13607 U1849/net4 CRC_OUT_5_27 VDD VDD pmos W=0.205u L=0.04u
M13608 U1849/net6 U1849/net4 VDD VDD pmos W=0.24u L=0.04u
M13609 n1083 U1849/net14 VDD VDD pmos W=0.205u L=0.04u
M13610 U1849/net10 WX6015 VDD VDD pmos W=0.205u L=0.04u
M13611 U1850/net4 WX6013 U1850/net14 VSS nmos W=0.155u L=0.04u
M13612 U1850/net6 U1850/net10 U1850/net14 VSS nmos W=0.17u L=0.04u
M13613 U1850/net4 CRC_OUT_5_28 VSS VSS nmos W=0.155u L=0.04u
M13614 U1850/net6 U1850/net4 VSS VSS nmos W=0.17u L=0.04u
M13615 n1082 U1850/net14 VSS VSS nmos W=0.155u L=0.04u
M13616 U1850/net10 WX6013 VSS VSS nmos W=0.155u L=0.04u
M13617 U1850/net4 U1850/net10 U1850/net14 VDD pmos W=0.255u L=0.04u
M13618 U1850/net6 WX6013 U1850/net14 VDD pmos W=0.28u L=0.04u
M13619 U1850/net4 CRC_OUT_5_28 VDD VDD pmos W=0.205u L=0.04u
M13620 U1850/net6 U1850/net4 VDD VDD pmos W=0.24u L=0.04u
M13621 n1082 U1850/net14 VDD VDD pmos W=0.205u L=0.04u
M13622 U1850/net10 WX6013 VDD VDD pmos W=0.205u L=0.04u
M13623 U1851/net4 WX6011 U1851/net14 VSS nmos W=0.155u L=0.04u
M13624 U1851/net6 U1851/net10 U1851/net14 VSS nmos W=0.17u L=0.04u
M13625 U1851/net4 CRC_OUT_5_29 VSS VSS nmos W=0.155u L=0.04u
M13626 U1851/net6 U1851/net4 VSS VSS nmos W=0.17u L=0.04u
M13627 n1081 U1851/net14 VSS VSS nmos W=0.155u L=0.04u
M13628 U1851/net10 WX6011 VSS VSS nmos W=0.155u L=0.04u
M13629 U1851/net4 U1851/net10 U1851/net14 VDD pmos W=0.255u L=0.04u
M13630 U1851/net6 WX6011 U1851/net14 VDD pmos W=0.28u L=0.04u
M13631 U1851/net4 CRC_OUT_5_29 VDD VDD pmos W=0.205u L=0.04u
M13632 U1851/net6 U1851/net4 VDD VDD pmos W=0.24u L=0.04u
M13633 n1081 U1851/net14 VDD VDD pmos W=0.205u L=0.04u
M13634 U1851/net10 WX6011 VDD VDD pmos W=0.205u L=0.04u
M13635 U1852/net4 WX6009 U1852/net14 VSS nmos W=0.155u L=0.04u
M13636 U1852/net6 U1852/net10 U1852/net14 VSS nmos W=0.17u L=0.04u
M13637 U1852/net4 CRC_OUT_5_30 VSS VSS nmos W=0.155u L=0.04u
M13638 U1852/net6 U1852/net4 VSS VSS nmos W=0.17u L=0.04u
M13639 n1080 U1852/net14 VSS VSS nmos W=0.155u L=0.04u
M13640 U1852/net10 WX6009 VSS VSS nmos W=0.155u L=0.04u
M13641 U1852/net4 U1852/net10 U1852/net14 VDD pmos W=0.255u L=0.04u
M13642 U1852/net6 WX6009 U1852/net14 VDD pmos W=0.28u L=0.04u
M13643 U1852/net4 CRC_OUT_5_30 VDD VDD pmos W=0.205u L=0.04u
M13644 U1852/net6 U1852/net4 VDD VDD pmos W=0.24u L=0.04u
M13645 n1080 U1852/net14 VDD VDD pmos W=0.205u L=0.04u
M13646 U1852/net10 WX6009 VDD VDD pmos W=0.205u L=0.04u
M13647 U1853/net4 n1392 U1853/net14 VSS nmos W=0.155u L=0.04u
M13648 U1853/net6 U1853/net10 U1853/net14 VSS nmos W=0.17u L=0.04u
M13649 U1853/net4 n1393 VSS VSS nmos W=0.155u L=0.04u
M13650 U1853/net6 U1853/net4 VSS VSS nmos W=0.17u L=0.04u
M13651 n1079 U1853/net14 VSS VSS nmos W=0.155u L=0.04u
M13652 U1853/net10 n1392 VSS VSS nmos W=0.155u L=0.04u
M13653 U1853/net4 U1853/net10 U1853/net14 VDD pmos W=0.255u L=0.04u
M13654 U1853/net6 n1392 U1853/net14 VDD pmos W=0.28u L=0.04u
M13655 U1853/net4 n1393 VDD VDD pmos W=0.205u L=0.04u
M13656 U1853/net6 U1853/net4 VDD VDD pmos W=0.24u L=0.04u
M13657 n1079 U1853/net14 VDD VDD pmos W=0.205u L=0.04u
M13658 U1853/net10 n1392 VDD VDD pmos W=0.205u L=0.04u
M13659 U1854/net4 WX4776 U1854/net14 VSS nmos W=0.155u L=0.04u
M13660 U1854/net6 U1854/net10 U1854/net14 VSS nmos W=0.17u L=0.04u
M13661 U1854/net4 CRC_OUT_6_0 VSS VSS nmos W=0.155u L=0.04u
M13662 U1854/net6 U1854/net4 VSS VSS nmos W=0.17u L=0.04u
M13663 n1078 U1854/net14 VSS VSS nmos W=0.155u L=0.04u
M13664 U1854/net10 WX4776 VSS VSS nmos W=0.155u L=0.04u
M13665 U1854/net4 U1854/net10 U1854/net14 VDD pmos W=0.255u L=0.04u
M13666 U1854/net6 WX4776 U1854/net14 VDD pmos W=0.28u L=0.04u
M13667 U1854/net4 CRC_OUT_6_0 VDD VDD pmos W=0.205u L=0.04u
M13668 U1854/net6 U1854/net4 VDD VDD pmos W=0.24u L=0.04u
M13669 n1078 U1854/net14 VDD VDD pmos W=0.205u L=0.04u
M13670 U1854/net10 WX4776 VDD VDD pmos W=0.205u L=0.04u
M13671 U1855/net4 WX4774 U1855/net14 VSS nmos W=0.155u L=0.04u
M13672 U1855/net6 U1855/net10 U1855/net14 VSS nmos W=0.17u L=0.04u
M13673 U1855/net4 CRC_OUT_6_1 VSS VSS nmos W=0.155u L=0.04u
M13674 U1855/net6 U1855/net4 VSS VSS nmos W=0.17u L=0.04u
M13675 n1077 U1855/net14 VSS VSS nmos W=0.155u L=0.04u
M13676 U1855/net10 WX4774 VSS VSS nmos W=0.155u L=0.04u
M13677 U1855/net4 U1855/net10 U1855/net14 VDD pmos W=0.255u L=0.04u
M13678 U1855/net6 WX4774 U1855/net14 VDD pmos W=0.28u L=0.04u
M13679 U1855/net4 CRC_OUT_6_1 VDD VDD pmos W=0.205u L=0.04u
M13680 U1855/net6 U1855/net4 VDD VDD pmos W=0.24u L=0.04u
M13681 n1077 U1855/net14 VDD VDD pmos W=0.205u L=0.04u
M13682 U1855/net10 WX4774 VDD VDD pmos W=0.205u L=0.04u
M13683 U1856/net4 WX4772 U1856/net14 VSS nmos W=0.155u L=0.04u
M13684 U1856/net6 U1856/net10 U1856/net14 VSS nmos W=0.17u L=0.04u
M13685 U1856/net4 CRC_OUT_6_2 VSS VSS nmos W=0.155u L=0.04u
M13686 U1856/net6 U1856/net4 VSS VSS nmos W=0.17u L=0.04u
M13687 n1076 U1856/net14 VSS VSS nmos W=0.155u L=0.04u
M13688 U1856/net10 WX4772 VSS VSS nmos W=0.155u L=0.04u
M13689 U1856/net4 U1856/net10 U1856/net14 VDD pmos W=0.255u L=0.04u
M13690 U1856/net6 WX4772 U1856/net14 VDD pmos W=0.28u L=0.04u
M13691 U1856/net4 CRC_OUT_6_2 VDD VDD pmos W=0.205u L=0.04u
M13692 U1856/net6 U1856/net4 VDD VDD pmos W=0.24u L=0.04u
M13693 n1076 U1856/net14 VDD VDD pmos W=0.205u L=0.04u
M13694 U1856/net10 WX4772 VDD VDD pmos W=0.205u L=0.04u
M13695 U1857/net11 CRC_OUT_6_31 U1857/net17 VSS nmos W=0.155u L=0.04u
M13696 U1857/net5 U1857/net17 U1857/net21 VSS nmos W=0.155u L=0.04u
M13697 U1857/net5 CRC_OUT_6_3 VSS VSS nmos W=0.155u L=0.04u
M13698 n1075 U1857/net21 VSS VSS nmos W=0.155u L=0.04u
M13699 U1857/net16 CRC_OUT_6_31 VSS VSS nmos W=0.155u L=0.04u
M13700 U1857/net11 WX4770 VSS VSS nmos W=0.155u L=0.04u
M13701 U1857/net13 U1857/net17 VSS VSS nmos W=0.155u L=0.04u
M13702 U1857/net17 U1857/net16 U1857/XI2-net16 VSS nmos W=0.155u L=0.04u
M13703 U1857/XI2-net16 U1857/net11 VSS VSS nmos W=0.155u L=0.04u
M13704 U1857/net21 U1857/net13 U1857/XU21-net16 VSS nmos W=0.155u L=0.04u
M13705 U1857/XU21-net16 U1857/net5 VSS VSS nmos W=0.155u L=0.04u
M13706 U1857/net11 U1857/net16 U1857/net17 VDD pmos W=0.205u L=0.04u
M13707 U1857/net5 U1857/net13 U1857/net21 VDD pmos W=0.205u L=0.04u
M13708 U1857/net5 CRC_OUT_6_3 VDD VDD pmos W=0.205u L=0.04u
M13709 n1075 U1857/net21 VDD VDD pmos W=0.205u L=0.04u
M13710 U1857/net16 CRC_OUT_6_31 VDD VDD pmos W=0.205u L=0.04u
M13711 U1857/net11 WX4770 VDD VDD pmos W=0.205u L=0.04u
M13712 U1857/net13 U1857/net17 VDD VDD pmos W=0.205u L=0.04u
M13713 U1857/net17 CRC_OUT_6_31 U1857/XI2-net6 VDD pmos W=0.205u L=0.04u
M13714 U1857/XI2-net6 U1857/net11 VDD VDD pmos W=0.205u L=0.04u
M13715 U1857/net21 U1857/net17 U1857/XU21-net6 VDD pmos W=0.205u L=0.04u
M13716 U1857/XU21-net6 U1857/net5 VDD VDD pmos W=0.205u L=0.04u
M13717 U1858/net4 WX4768 U1858/net14 VSS nmos W=0.155u L=0.04u
M13718 U1858/net6 U1858/net10 U1858/net14 VSS nmos W=0.17u L=0.04u
M13719 U1858/net4 CRC_OUT_6_4 VSS VSS nmos W=0.155u L=0.04u
M13720 U1858/net6 U1858/net4 VSS VSS nmos W=0.17u L=0.04u
M13721 n1074 U1858/net14 VSS VSS nmos W=0.155u L=0.04u
M13722 U1858/net10 WX4768 VSS VSS nmos W=0.155u L=0.04u
M13723 U1858/net4 U1858/net10 U1858/net14 VDD pmos W=0.255u L=0.04u
M13724 U1858/net6 WX4768 U1858/net14 VDD pmos W=0.28u L=0.04u
M13725 U1858/net4 CRC_OUT_6_4 VDD VDD pmos W=0.205u L=0.04u
M13726 U1858/net6 U1858/net4 VDD VDD pmos W=0.24u L=0.04u
M13727 n1074 U1858/net14 VDD VDD pmos W=0.205u L=0.04u
M13728 U1858/net10 WX4768 VDD VDD pmos W=0.205u L=0.04u
M13729 U1859/net4 WX4766 U1859/net14 VSS nmos W=0.155u L=0.04u
M13730 U1859/net6 U1859/net10 U1859/net14 VSS nmos W=0.17u L=0.04u
M13731 U1859/net4 CRC_OUT_6_5 VSS VSS nmos W=0.155u L=0.04u
M13732 U1859/net6 U1859/net4 VSS VSS nmos W=0.17u L=0.04u
M13733 n1073 U1859/net14 VSS VSS nmos W=0.155u L=0.04u
M13734 U1859/net10 WX4766 VSS VSS nmos W=0.155u L=0.04u
M13735 U1859/net4 U1859/net10 U1859/net14 VDD pmos W=0.255u L=0.04u
M13736 U1859/net6 WX4766 U1859/net14 VDD pmos W=0.28u L=0.04u
M13737 U1859/net4 CRC_OUT_6_5 VDD VDD pmos W=0.205u L=0.04u
M13738 U1859/net6 U1859/net4 VDD VDD pmos W=0.24u L=0.04u
M13739 n1073 U1859/net14 VDD VDD pmos W=0.205u L=0.04u
M13740 U1859/net10 WX4766 VDD VDD pmos W=0.205u L=0.04u
M13741 U1860/net4 WX4764 U1860/net14 VSS nmos W=0.155u L=0.04u
M13742 U1860/net6 U1860/net10 U1860/net14 VSS nmos W=0.17u L=0.04u
M13743 U1860/net4 CRC_OUT_6_6 VSS VSS nmos W=0.155u L=0.04u
M13744 U1860/net6 U1860/net4 VSS VSS nmos W=0.17u L=0.04u
M13745 n1072 U1860/net14 VSS VSS nmos W=0.155u L=0.04u
M13746 U1860/net10 WX4764 VSS VSS nmos W=0.155u L=0.04u
M13747 U1860/net4 U1860/net10 U1860/net14 VDD pmos W=0.255u L=0.04u
M13748 U1860/net6 WX4764 U1860/net14 VDD pmos W=0.28u L=0.04u
M13749 U1860/net4 CRC_OUT_6_6 VDD VDD pmos W=0.205u L=0.04u
M13750 U1860/net6 U1860/net4 VDD VDD pmos W=0.24u L=0.04u
M13751 n1072 U1860/net14 VDD VDD pmos W=0.205u L=0.04u
M13752 U1860/net10 WX4764 VDD VDD pmos W=0.205u L=0.04u
M13753 U1861/net4 WX4762 U1861/net14 VSS nmos W=0.155u L=0.04u
M13754 U1861/net6 U1861/net10 U1861/net14 VSS nmos W=0.17u L=0.04u
M13755 U1861/net4 CRC_OUT_6_7 VSS VSS nmos W=0.155u L=0.04u
M13756 U1861/net6 U1861/net4 VSS VSS nmos W=0.17u L=0.04u
M13757 n1071 U1861/net14 VSS VSS nmos W=0.155u L=0.04u
M13758 U1861/net10 WX4762 VSS VSS nmos W=0.155u L=0.04u
M13759 U1861/net4 U1861/net10 U1861/net14 VDD pmos W=0.255u L=0.04u
M13760 U1861/net6 WX4762 U1861/net14 VDD pmos W=0.28u L=0.04u
M13761 U1861/net4 CRC_OUT_6_7 VDD VDD pmos W=0.205u L=0.04u
M13762 U1861/net6 U1861/net4 VDD VDD pmos W=0.24u L=0.04u
M13763 n1071 U1861/net14 VDD VDD pmos W=0.205u L=0.04u
M13764 U1861/net10 WX4762 VDD VDD pmos W=0.205u L=0.04u
M13765 U1862/net4 WX4760 U1862/net14 VSS nmos W=0.155u L=0.04u
M13766 U1862/net6 U1862/net10 U1862/net14 VSS nmos W=0.17u L=0.04u
M13767 U1862/net4 CRC_OUT_6_8 VSS VSS nmos W=0.155u L=0.04u
M13768 U1862/net6 U1862/net4 VSS VSS nmos W=0.17u L=0.04u
M13769 n1070 U1862/net14 VSS VSS nmos W=0.155u L=0.04u
M13770 U1862/net10 WX4760 VSS VSS nmos W=0.155u L=0.04u
M13771 U1862/net4 U1862/net10 U1862/net14 VDD pmos W=0.255u L=0.04u
M13772 U1862/net6 WX4760 U1862/net14 VDD pmos W=0.28u L=0.04u
M13773 U1862/net4 CRC_OUT_6_8 VDD VDD pmos W=0.205u L=0.04u
M13774 U1862/net6 U1862/net4 VDD VDD pmos W=0.24u L=0.04u
M13775 n1070 U1862/net14 VDD VDD pmos W=0.205u L=0.04u
M13776 U1862/net10 WX4760 VDD VDD pmos W=0.205u L=0.04u
M13777 U1863/net4 WX4758 U1863/net14 VSS nmos W=0.155u L=0.04u
M13778 U1863/net6 U1863/net10 U1863/net14 VSS nmos W=0.17u L=0.04u
M13779 U1863/net4 CRC_OUT_6_9 VSS VSS nmos W=0.155u L=0.04u
M13780 U1863/net6 U1863/net4 VSS VSS nmos W=0.17u L=0.04u
M13781 n1069 U1863/net14 VSS VSS nmos W=0.155u L=0.04u
M13782 U1863/net10 WX4758 VSS VSS nmos W=0.155u L=0.04u
M13783 U1863/net4 U1863/net10 U1863/net14 VDD pmos W=0.255u L=0.04u
M13784 U1863/net6 WX4758 U1863/net14 VDD pmos W=0.28u L=0.04u
M13785 U1863/net4 CRC_OUT_6_9 VDD VDD pmos W=0.205u L=0.04u
M13786 U1863/net6 U1863/net4 VDD VDD pmos W=0.24u L=0.04u
M13787 n1069 U1863/net14 VDD VDD pmos W=0.205u L=0.04u
M13788 U1863/net10 WX4758 VDD VDD pmos W=0.205u L=0.04u
M13789 U1864/net11 CRC_OUT_6_31 U1864/net17 VSS nmos W=0.155u L=0.04u
M13790 U1864/net5 U1864/net17 U1864/net21 VSS nmos W=0.155u L=0.04u
M13791 U1864/net5 CRC_OUT_6_10 VSS VSS nmos W=0.155u L=0.04u
M13792 n1068 U1864/net21 VSS VSS nmos W=0.155u L=0.04u
M13793 U1864/net16 CRC_OUT_6_31 VSS VSS nmos W=0.155u L=0.04u
M13794 U1864/net11 WX4756 VSS VSS nmos W=0.155u L=0.04u
M13795 U1864/net13 U1864/net17 VSS VSS nmos W=0.155u L=0.04u
M13796 U1864/net17 U1864/net16 U1864/XI2-net16 VSS nmos W=0.155u L=0.04u
M13797 U1864/XI2-net16 U1864/net11 VSS VSS nmos W=0.155u L=0.04u
M13798 U1864/net21 U1864/net13 U1864/XU21-net16 VSS nmos W=0.155u L=0.04u
M13799 U1864/XU21-net16 U1864/net5 VSS VSS nmos W=0.155u L=0.04u
M13800 U1864/net11 U1864/net16 U1864/net17 VDD pmos W=0.205u L=0.04u
M13801 U1864/net5 U1864/net13 U1864/net21 VDD pmos W=0.205u L=0.04u
M13802 U1864/net5 CRC_OUT_6_10 VDD VDD pmos W=0.205u L=0.04u
M13803 n1068 U1864/net21 VDD VDD pmos W=0.205u L=0.04u
M13804 U1864/net16 CRC_OUT_6_31 VDD VDD pmos W=0.205u L=0.04u
M13805 U1864/net11 WX4756 VDD VDD pmos W=0.205u L=0.04u
M13806 U1864/net13 U1864/net17 VDD VDD pmos W=0.205u L=0.04u
M13807 U1864/net17 CRC_OUT_6_31 U1864/XI2-net6 VDD pmos W=0.205u L=0.04u
M13808 U1864/XI2-net6 U1864/net11 VDD VDD pmos W=0.205u L=0.04u
M13809 U1864/net21 U1864/net17 U1864/XU21-net6 VDD pmos W=0.205u L=0.04u
M13810 U1864/XU21-net6 U1864/net5 VDD VDD pmos W=0.205u L=0.04u
M13811 U1865/net4 WX4754 U1865/net14 VSS nmos W=0.155u L=0.04u
M13812 U1865/net6 U1865/net10 U1865/net14 VSS nmos W=0.17u L=0.04u
M13813 U1865/net4 CRC_OUT_6_11 VSS VSS nmos W=0.155u L=0.04u
M13814 U1865/net6 U1865/net4 VSS VSS nmos W=0.17u L=0.04u
M13815 n1067 U1865/net14 VSS VSS nmos W=0.155u L=0.04u
M13816 U1865/net10 WX4754 VSS VSS nmos W=0.155u L=0.04u
M13817 U1865/net4 U1865/net10 U1865/net14 VDD pmos W=0.255u L=0.04u
M13818 U1865/net6 WX4754 U1865/net14 VDD pmos W=0.28u L=0.04u
M13819 U1865/net4 CRC_OUT_6_11 VDD VDD pmos W=0.205u L=0.04u
M13820 U1865/net6 U1865/net4 VDD VDD pmos W=0.24u L=0.04u
M13821 n1067 U1865/net14 VDD VDD pmos W=0.205u L=0.04u
M13822 U1865/net10 WX4754 VDD VDD pmos W=0.205u L=0.04u
M13823 U1866/net4 WX4752 U1866/net14 VSS nmos W=0.155u L=0.04u
M13824 U1866/net6 U1866/net10 U1866/net14 VSS nmos W=0.17u L=0.04u
M13825 U1866/net4 CRC_OUT_6_12 VSS VSS nmos W=0.155u L=0.04u
M13826 U1866/net6 U1866/net4 VSS VSS nmos W=0.17u L=0.04u
M13827 n1066 U1866/net14 VSS VSS nmos W=0.155u L=0.04u
M13828 U1866/net10 WX4752 VSS VSS nmos W=0.155u L=0.04u
M13829 U1866/net4 U1866/net10 U1866/net14 VDD pmos W=0.255u L=0.04u
M13830 U1866/net6 WX4752 U1866/net14 VDD pmos W=0.28u L=0.04u
M13831 U1866/net4 CRC_OUT_6_12 VDD VDD pmos W=0.205u L=0.04u
M13832 U1866/net6 U1866/net4 VDD VDD pmos W=0.24u L=0.04u
M13833 n1066 U1866/net14 VDD VDD pmos W=0.205u L=0.04u
M13834 U1866/net10 WX4752 VDD VDD pmos W=0.205u L=0.04u
M13835 U1867/net4 WX4750 U1867/net14 VSS nmos W=0.155u L=0.04u
M13836 U1867/net6 U1867/net10 U1867/net14 VSS nmos W=0.17u L=0.04u
M13837 U1867/net4 CRC_OUT_6_13 VSS VSS nmos W=0.155u L=0.04u
M13838 U1867/net6 U1867/net4 VSS VSS nmos W=0.17u L=0.04u
M13839 n1065 U1867/net14 VSS VSS nmos W=0.155u L=0.04u
M13840 U1867/net10 WX4750 VSS VSS nmos W=0.155u L=0.04u
M13841 U1867/net4 U1867/net10 U1867/net14 VDD pmos W=0.255u L=0.04u
M13842 U1867/net6 WX4750 U1867/net14 VDD pmos W=0.28u L=0.04u
M13843 U1867/net4 CRC_OUT_6_13 VDD VDD pmos W=0.205u L=0.04u
M13844 U1867/net6 U1867/net4 VDD VDD pmos W=0.24u L=0.04u
M13845 n1065 U1867/net14 VDD VDD pmos W=0.205u L=0.04u
M13846 U1867/net10 WX4750 VDD VDD pmos W=0.205u L=0.04u
M13847 U1868/net4 WX4748 U1868/net14 VSS nmos W=0.155u L=0.04u
M13848 U1868/net6 U1868/net10 U1868/net14 VSS nmos W=0.17u L=0.04u
M13849 U1868/net4 CRC_OUT_6_14 VSS VSS nmos W=0.155u L=0.04u
M13850 U1868/net6 U1868/net4 VSS VSS nmos W=0.17u L=0.04u
M13851 n1064 U1868/net14 VSS VSS nmos W=0.155u L=0.04u
M13852 U1868/net10 WX4748 VSS VSS nmos W=0.155u L=0.04u
M13853 U1868/net4 U1868/net10 U1868/net14 VDD pmos W=0.255u L=0.04u
M13854 U1868/net6 WX4748 U1868/net14 VDD pmos W=0.28u L=0.04u
M13855 U1868/net4 CRC_OUT_6_14 VDD VDD pmos W=0.205u L=0.04u
M13856 U1868/net6 U1868/net4 VDD VDD pmos W=0.24u L=0.04u
M13857 n1064 U1868/net14 VDD VDD pmos W=0.205u L=0.04u
M13858 U1868/net10 WX4748 VDD VDD pmos W=0.205u L=0.04u
M13859 U1869/net11 CRC_OUT_6_31 U1869/net17 VSS nmos W=0.155u L=0.04u
M13860 U1869/net5 U1869/net17 U1869/net21 VSS nmos W=0.155u L=0.04u
M13861 U1869/net5 CRC_OUT_6_15 VSS VSS nmos W=0.155u L=0.04u
M13862 n1063 U1869/net21 VSS VSS nmos W=0.155u L=0.04u
M13863 U1869/net16 CRC_OUT_6_31 VSS VSS nmos W=0.155u L=0.04u
M13864 U1869/net11 WX4746 VSS VSS nmos W=0.155u L=0.04u
M13865 U1869/net13 U1869/net17 VSS VSS nmos W=0.155u L=0.04u
M13866 U1869/net17 U1869/net16 U1869/XI2-net16 VSS nmos W=0.155u L=0.04u
M13867 U1869/XI2-net16 U1869/net11 VSS VSS nmos W=0.155u L=0.04u
M13868 U1869/net21 U1869/net13 U1869/XU21-net16 VSS nmos W=0.155u L=0.04u
M13869 U1869/XU21-net16 U1869/net5 VSS VSS nmos W=0.155u L=0.04u
M13870 U1869/net11 U1869/net16 U1869/net17 VDD pmos W=0.205u L=0.04u
M13871 U1869/net5 U1869/net13 U1869/net21 VDD pmos W=0.205u L=0.04u
M13872 U1869/net5 CRC_OUT_6_15 VDD VDD pmos W=0.205u L=0.04u
M13873 n1063 U1869/net21 VDD VDD pmos W=0.205u L=0.04u
M13874 U1869/net16 CRC_OUT_6_31 VDD VDD pmos W=0.205u L=0.04u
M13875 U1869/net11 WX4746 VDD VDD pmos W=0.205u L=0.04u
M13876 U1869/net13 U1869/net17 VDD VDD pmos W=0.205u L=0.04u
M13877 U1869/net17 CRC_OUT_6_31 U1869/XI2-net6 VDD pmos W=0.205u L=0.04u
M13878 U1869/XI2-net6 U1869/net11 VDD VDD pmos W=0.205u L=0.04u
M13879 U1869/net21 U1869/net17 U1869/XU21-net6 VDD pmos W=0.205u L=0.04u
M13880 U1869/XU21-net6 U1869/net5 VDD VDD pmos W=0.205u L=0.04u
M13881 U1870/net4 WX4744 U1870/net14 VSS nmos W=0.155u L=0.04u
M13882 U1870/net6 U1870/net10 U1870/net14 VSS nmos W=0.17u L=0.04u
M13883 U1870/net4 CRC_OUT_6_16 VSS VSS nmos W=0.155u L=0.04u
M13884 U1870/net6 U1870/net4 VSS VSS nmos W=0.17u L=0.04u
M13885 n1062 U1870/net14 VSS VSS nmos W=0.155u L=0.04u
M13886 U1870/net10 WX4744 VSS VSS nmos W=0.155u L=0.04u
M13887 U1870/net4 U1870/net10 U1870/net14 VDD pmos W=0.255u L=0.04u
M13888 U1870/net6 WX4744 U1870/net14 VDD pmos W=0.28u L=0.04u
M13889 U1870/net4 CRC_OUT_6_16 VDD VDD pmos W=0.205u L=0.04u
M13890 U1870/net6 U1870/net4 VDD VDD pmos W=0.24u L=0.04u
M13891 n1062 U1870/net14 VDD VDD pmos W=0.205u L=0.04u
M13892 U1870/net10 WX4744 VDD VDD pmos W=0.205u L=0.04u
M13893 U1871/net4 WX4742 U1871/net14 VSS nmos W=0.155u L=0.04u
M13894 U1871/net6 U1871/net10 U1871/net14 VSS nmos W=0.17u L=0.04u
M13895 U1871/net4 CRC_OUT_6_17 VSS VSS nmos W=0.155u L=0.04u
M13896 U1871/net6 U1871/net4 VSS VSS nmos W=0.17u L=0.04u
M13897 n1061 U1871/net14 VSS VSS nmos W=0.155u L=0.04u
M13898 U1871/net10 WX4742 VSS VSS nmos W=0.155u L=0.04u
M13899 U1871/net4 U1871/net10 U1871/net14 VDD pmos W=0.255u L=0.04u
M13900 U1871/net6 WX4742 U1871/net14 VDD pmos W=0.28u L=0.04u
M13901 U1871/net4 CRC_OUT_6_17 VDD VDD pmos W=0.205u L=0.04u
M13902 U1871/net6 U1871/net4 VDD VDD pmos W=0.24u L=0.04u
M13903 n1061 U1871/net14 VDD VDD pmos W=0.205u L=0.04u
M13904 U1871/net10 WX4742 VDD VDD pmos W=0.205u L=0.04u
M13905 U1872/net4 WX4740 U1872/net14 VSS nmos W=0.155u L=0.04u
M13906 U1872/net6 U1872/net10 U1872/net14 VSS nmos W=0.17u L=0.04u
M13907 U1872/net4 CRC_OUT_6_18 VSS VSS nmos W=0.155u L=0.04u
M13908 U1872/net6 U1872/net4 VSS VSS nmos W=0.17u L=0.04u
M13909 n1060 U1872/net14 VSS VSS nmos W=0.155u L=0.04u
M13910 U1872/net10 WX4740 VSS VSS nmos W=0.155u L=0.04u
M13911 U1872/net4 U1872/net10 U1872/net14 VDD pmos W=0.255u L=0.04u
M13912 U1872/net6 WX4740 U1872/net14 VDD pmos W=0.28u L=0.04u
M13913 U1872/net4 CRC_OUT_6_18 VDD VDD pmos W=0.205u L=0.04u
M13914 U1872/net6 U1872/net4 VDD VDD pmos W=0.24u L=0.04u
M13915 n1060 U1872/net14 VDD VDD pmos W=0.205u L=0.04u
M13916 U1872/net10 WX4740 VDD VDD pmos W=0.205u L=0.04u
M13917 U1873/net4 WX4738 U1873/net14 VSS nmos W=0.155u L=0.04u
M13918 U1873/net6 U1873/net10 U1873/net14 VSS nmos W=0.17u L=0.04u
M13919 U1873/net4 CRC_OUT_6_19 VSS VSS nmos W=0.155u L=0.04u
M13920 U1873/net6 U1873/net4 VSS VSS nmos W=0.17u L=0.04u
M13921 n1059 U1873/net14 VSS VSS nmos W=0.155u L=0.04u
M13922 U1873/net10 WX4738 VSS VSS nmos W=0.155u L=0.04u
M13923 U1873/net4 U1873/net10 U1873/net14 VDD pmos W=0.255u L=0.04u
M13924 U1873/net6 WX4738 U1873/net14 VDD pmos W=0.28u L=0.04u
M13925 U1873/net4 CRC_OUT_6_19 VDD VDD pmos W=0.205u L=0.04u
M13926 U1873/net6 U1873/net4 VDD VDD pmos W=0.24u L=0.04u
M13927 n1059 U1873/net14 VDD VDD pmos W=0.205u L=0.04u
M13928 U1873/net10 WX4738 VDD VDD pmos W=0.205u L=0.04u
M13929 U1874/net4 WX4736 U1874/net14 VSS nmos W=0.155u L=0.04u
M13930 U1874/net6 U1874/net10 U1874/net14 VSS nmos W=0.17u L=0.04u
M13931 U1874/net4 CRC_OUT_6_20 VSS VSS nmos W=0.155u L=0.04u
M13932 U1874/net6 U1874/net4 VSS VSS nmos W=0.17u L=0.04u
M13933 n1058 U1874/net14 VSS VSS nmos W=0.155u L=0.04u
M13934 U1874/net10 WX4736 VSS VSS nmos W=0.155u L=0.04u
M13935 U1874/net4 U1874/net10 U1874/net14 VDD pmos W=0.255u L=0.04u
M13936 U1874/net6 WX4736 U1874/net14 VDD pmos W=0.28u L=0.04u
M13937 U1874/net4 CRC_OUT_6_20 VDD VDD pmos W=0.205u L=0.04u
M13938 U1874/net6 U1874/net4 VDD VDD pmos W=0.24u L=0.04u
M13939 n1058 U1874/net14 VDD VDD pmos W=0.205u L=0.04u
M13940 U1874/net10 WX4736 VDD VDD pmos W=0.205u L=0.04u
M13941 U1875/net4 WX4734 U1875/net14 VSS nmos W=0.155u L=0.04u
M13942 U1875/net6 U1875/net10 U1875/net14 VSS nmos W=0.17u L=0.04u
M13943 U1875/net4 CRC_OUT_6_21 VSS VSS nmos W=0.155u L=0.04u
M13944 U1875/net6 U1875/net4 VSS VSS nmos W=0.17u L=0.04u
M13945 n1057 U1875/net14 VSS VSS nmos W=0.155u L=0.04u
M13946 U1875/net10 WX4734 VSS VSS nmos W=0.155u L=0.04u
M13947 U1875/net4 U1875/net10 U1875/net14 VDD pmos W=0.255u L=0.04u
M13948 U1875/net6 WX4734 U1875/net14 VDD pmos W=0.28u L=0.04u
M13949 U1875/net4 CRC_OUT_6_21 VDD VDD pmos W=0.205u L=0.04u
M13950 U1875/net6 U1875/net4 VDD VDD pmos W=0.24u L=0.04u
M13951 n1057 U1875/net14 VDD VDD pmos W=0.205u L=0.04u
M13952 U1875/net10 WX4734 VDD VDD pmos W=0.205u L=0.04u
M13953 U1876/net4 WX4732 U1876/net14 VSS nmos W=0.155u L=0.04u
M13954 U1876/net6 U1876/net10 U1876/net14 VSS nmos W=0.17u L=0.04u
M13955 U1876/net4 CRC_OUT_6_22 VSS VSS nmos W=0.155u L=0.04u
M13956 U1876/net6 U1876/net4 VSS VSS nmos W=0.17u L=0.04u
M13957 n1056 U1876/net14 VSS VSS nmos W=0.155u L=0.04u
M13958 U1876/net10 WX4732 VSS VSS nmos W=0.155u L=0.04u
M13959 U1876/net4 U1876/net10 U1876/net14 VDD pmos W=0.255u L=0.04u
M13960 U1876/net6 WX4732 U1876/net14 VDD pmos W=0.28u L=0.04u
M13961 U1876/net4 CRC_OUT_6_22 VDD VDD pmos W=0.205u L=0.04u
M13962 U1876/net6 U1876/net4 VDD VDD pmos W=0.24u L=0.04u
M13963 n1056 U1876/net14 VDD VDD pmos W=0.205u L=0.04u
M13964 U1876/net10 WX4732 VDD VDD pmos W=0.205u L=0.04u
M13965 U1877/net4 WX4730 U1877/net14 VSS nmos W=0.155u L=0.04u
M13966 U1877/net6 U1877/net10 U1877/net14 VSS nmos W=0.17u L=0.04u
M13967 U1877/net4 CRC_OUT_6_23 VSS VSS nmos W=0.155u L=0.04u
M13968 U1877/net6 U1877/net4 VSS VSS nmos W=0.17u L=0.04u
M13969 n1055 U1877/net14 VSS VSS nmos W=0.155u L=0.04u
M13970 U1877/net10 WX4730 VSS VSS nmos W=0.155u L=0.04u
M13971 U1877/net4 U1877/net10 U1877/net14 VDD pmos W=0.255u L=0.04u
M13972 U1877/net6 WX4730 U1877/net14 VDD pmos W=0.28u L=0.04u
M13973 U1877/net4 CRC_OUT_6_23 VDD VDD pmos W=0.205u L=0.04u
M13974 U1877/net6 U1877/net4 VDD VDD pmos W=0.24u L=0.04u
M13975 n1055 U1877/net14 VDD VDD pmos W=0.205u L=0.04u
M13976 U1877/net10 WX4730 VDD VDD pmos W=0.205u L=0.04u
M13977 U1878/net4 WX4728 U1878/net14 VSS nmos W=0.155u L=0.04u
M13978 U1878/net6 U1878/net10 U1878/net14 VSS nmos W=0.17u L=0.04u
M13979 U1878/net4 CRC_OUT_6_24 VSS VSS nmos W=0.155u L=0.04u
M13980 U1878/net6 U1878/net4 VSS VSS nmos W=0.17u L=0.04u
M13981 n1054 U1878/net14 VSS VSS nmos W=0.155u L=0.04u
M13982 U1878/net10 WX4728 VSS VSS nmos W=0.155u L=0.04u
M13983 U1878/net4 U1878/net10 U1878/net14 VDD pmos W=0.255u L=0.04u
M13984 U1878/net6 WX4728 U1878/net14 VDD pmos W=0.28u L=0.04u
M13985 U1878/net4 CRC_OUT_6_24 VDD VDD pmos W=0.205u L=0.04u
M13986 U1878/net6 U1878/net4 VDD VDD pmos W=0.24u L=0.04u
M13987 n1054 U1878/net14 VDD VDD pmos W=0.205u L=0.04u
M13988 U1878/net10 WX4728 VDD VDD pmos W=0.205u L=0.04u
M13989 U1879/net4 WX4726 U1879/net14 VSS nmos W=0.155u L=0.04u
M13990 U1879/net6 U1879/net10 U1879/net14 VSS nmos W=0.17u L=0.04u
M13991 U1879/net4 CRC_OUT_6_25 VSS VSS nmos W=0.155u L=0.04u
M13992 U1879/net6 U1879/net4 VSS VSS nmos W=0.17u L=0.04u
M13993 n1053 U1879/net14 VSS VSS nmos W=0.155u L=0.04u
M13994 U1879/net10 WX4726 VSS VSS nmos W=0.155u L=0.04u
M13995 U1879/net4 U1879/net10 U1879/net14 VDD pmos W=0.255u L=0.04u
M13996 U1879/net6 WX4726 U1879/net14 VDD pmos W=0.28u L=0.04u
M13997 U1879/net4 CRC_OUT_6_25 VDD VDD pmos W=0.205u L=0.04u
M13998 U1879/net6 U1879/net4 VDD VDD pmos W=0.24u L=0.04u
M13999 n1053 U1879/net14 VDD VDD pmos W=0.205u L=0.04u
M14000 U1879/net10 WX4726 VDD VDD pmos W=0.205u L=0.04u
M14001 U1880/net4 WX4724 U1880/net14 VSS nmos W=0.155u L=0.04u
M14002 U1880/net6 U1880/net10 U1880/net14 VSS nmos W=0.17u L=0.04u
M14003 U1880/net4 CRC_OUT_6_26 VSS VSS nmos W=0.155u L=0.04u
M14004 U1880/net6 U1880/net4 VSS VSS nmos W=0.17u L=0.04u
M14005 n1052 U1880/net14 VSS VSS nmos W=0.155u L=0.04u
M14006 U1880/net10 WX4724 VSS VSS nmos W=0.155u L=0.04u
M14007 U1880/net4 U1880/net10 U1880/net14 VDD pmos W=0.255u L=0.04u
M14008 U1880/net6 WX4724 U1880/net14 VDD pmos W=0.28u L=0.04u
M14009 U1880/net4 CRC_OUT_6_26 VDD VDD pmos W=0.205u L=0.04u
M14010 U1880/net6 U1880/net4 VDD VDD pmos W=0.24u L=0.04u
M14011 n1052 U1880/net14 VDD VDD pmos W=0.205u L=0.04u
M14012 U1880/net10 WX4724 VDD VDD pmos W=0.205u L=0.04u
M14013 U1881/net4 WX4722 U1881/net14 VSS nmos W=0.155u L=0.04u
M14014 U1881/net6 U1881/net10 U1881/net14 VSS nmos W=0.17u L=0.04u
M14015 U1881/net4 CRC_OUT_6_27 VSS VSS nmos W=0.155u L=0.04u
M14016 U1881/net6 U1881/net4 VSS VSS nmos W=0.17u L=0.04u
M14017 n1051 U1881/net14 VSS VSS nmos W=0.155u L=0.04u
M14018 U1881/net10 WX4722 VSS VSS nmos W=0.155u L=0.04u
M14019 U1881/net4 U1881/net10 U1881/net14 VDD pmos W=0.255u L=0.04u
M14020 U1881/net6 WX4722 U1881/net14 VDD pmos W=0.28u L=0.04u
M14021 U1881/net4 CRC_OUT_6_27 VDD VDD pmos W=0.205u L=0.04u
M14022 U1881/net6 U1881/net4 VDD VDD pmos W=0.24u L=0.04u
M14023 n1051 U1881/net14 VDD VDD pmos W=0.205u L=0.04u
M14024 U1881/net10 WX4722 VDD VDD pmos W=0.205u L=0.04u
M14025 U1882/net4 WX4720 U1882/net14 VSS nmos W=0.155u L=0.04u
M14026 U1882/net6 U1882/net10 U1882/net14 VSS nmos W=0.17u L=0.04u
M14027 U1882/net4 CRC_OUT_6_28 VSS VSS nmos W=0.155u L=0.04u
M14028 U1882/net6 U1882/net4 VSS VSS nmos W=0.17u L=0.04u
M14029 n1050 U1882/net14 VSS VSS nmos W=0.155u L=0.04u
M14030 U1882/net10 WX4720 VSS VSS nmos W=0.155u L=0.04u
M14031 U1882/net4 U1882/net10 U1882/net14 VDD pmos W=0.255u L=0.04u
M14032 U1882/net6 WX4720 U1882/net14 VDD pmos W=0.28u L=0.04u
M14033 U1882/net4 CRC_OUT_6_28 VDD VDD pmos W=0.205u L=0.04u
M14034 U1882/net6 U1882/net4 VDD VDD pmos W=0.24u L=0.04u
M14035 n1050 U1882/net14 VDD VDD pmos W=0.205u L=0.04u
M14036 U1882/net10 WX4720 VDD VDD pmos W=0.205u L=0.04u
M14037 U1883/net4 WX4718 U1883/net14 VSS nmos W=0.155u L=0.04u
M14038 U1883/net6 U1883/net10 U1883/net14 VSS nmos W=0.17u L=0.04u
M14039 U1883/net4 CRC_OUT_6_29 VSS VSS nmos W=0.155u L=0.04u
M14040 U1883/net6 U1883/net4 VSS VSS nmos W=0.17u L=0.04u
M14041 n1049 U1883/net14 VSS VSS nmos W=0.155u L=0.04u
M14042 U1883/net10 WX4718 VSS VSS nmos W=0.155u L=0.04u
M14043 U1883/net4 U1883/net10 U1883/net14 VDD pmos W=0.255u L=0.04u
M14044 U1883/net6 WX4718 U1883/net14 VDD pmos W=0.28u L=0.04u
M14045 U1883/net4 CRC_OUT_6_29 VDD VDD pmos W=0.205u L=0.04u
M14046 U1883/net6 U1883/net4 VDD VDD pmos W=0.24u L=0.04u
M14047 n1049 U1883/net14 VDD VDD pmos W=0.205u L=0.04u
M14048 U1883/net10 WX4718 VDD VDD pmos W=0.205u L=0.04u
M14049 U1884/net4 WX4716 U1884/net14 VSS nmos W=0.155u L=0.04u
M14050 U1884/net6 U1884/net10 U1884/net14 VSS nmos W=0.17u L=0.04u
M14051 U1884/net4 CRC_OUT_6_30 VSS VSS nmos W=0.155u L=0.04u
M14052 U1884/net6 U1884/net4 VSS VSS nmos W=0.17u L=0.04u
M14053 n1048 U1884/net14 VSS VSS nmos W=0.155u L=0.04u
M14054 U1884/net10 WX4716 VSS VSS nmos W=0.155u L=0.04u
M14055 U1884/net4 U1884/net10 U1884/net14 VDD pmos W=0.255u L=0.04u
M14056 U1884/net6 WX4716 U1884/net14 VDD pmos W=0.28u L=0.04u
M14057 U1884/net4 CRC_OUT_6_30 VDD VDD pmos W=0.205u L=0.04u
M14058 U1884/net6 U1884/net4 VDD VDD pmos W=0.24u L=0.04u
M14059 n1048 U1884/net14 VDD VDD pmos W=0.205u L=0.04u
M14060 U1884/net10 WX4716 VDD VDD pmos W=0.205u L=0.04u
M14061 U1885/net4 n1394 U1885/net14 VSS nmos W=0.155u L=0.04u
M14062 U1885/net6 U1885/net10 U1885/net14 VSS nmos W=0.17u L=0.04u
M14063 U1885/net4 n1395 VSS VSS nmos W=0.155u L=0.04u
M14064 U1885/net6 U1885/net4 VSS VSS nmos W=0.17u L=0.04u
M14065 n1047 U1885/net14 VSS VSS nmos W=0.155u L=0.04u
M14066 U1885/net10 n1394 VSS VSS nmos W=0.155u L=0.04u
M14067 U1885/net4 U1885/net10 U1885/net14 VDD pmos W=0.255u L=0.04u
M14068 U1885/net6 n1394 U1885/net14 VDD pmos W=0.28u L=0.04u
M14069 U1885/net4 n1395 VDD VDD pmos W=0.205u L=0.04u
M14070 U1885/net6 U1885/net4 VDD VDD pmos W=0.24u L=0.04u
M14071 n1047 U1885/net14 VDD VDD pmos W=0.205u L=0.04u
M14072 U1885/net10 n1394 VDD VDD pmos W=0.205u L=0.04u
M14073 U1886/net4 WX3483 U1886/net14 VSS nmos W=0.155u L=0.04u
M14074 U1886/net6 U1886/net10 U1886/net14 VSS nmos W=0.17u L=0.04u
M14075 U1886/net4 CRC_OUT_7_0 VSS VSS nmos W=0.155u L=0.04u
M14076 U1886/net6 U1886/net4 VSS VSS nmos W=0.17u L=0.04u
M14077 n1046 U1886/net14 VSS VSS nmos W=0.155u L=0.04u
M14078 U1886/net10 WX3483 VSS VSS nmos W=0.155u L=0.04u
M14079 U1886/net4 U1886/net10 U1886/net14 VDD pmos W=0.255u L=0.04u
M14080 U1886/net6 WX3483 U1886/net14 VDD pmos W=0.28u L=0.04u
M14081 U1886/net4 CRC_OUT_7_0 VDD VDD pmos W=0.205u L=0.04u
M14082 U1886/net6 U1886/net4 VDD VDD pmos W=0.24u L=0.04u
M14083 n1046 U1886/net14 VDD VDD pmos W=0.205u L=0.04u
M14084 U1886/net10 WX3483 VDD VDD pmos W=0.205u L=0.04u
M14085 U1887/net4 WX3481 U1887/net14 VSS nmos W=0.155u L=0.04u
M14086 U1887/net6 U1887/net10 U1887/net14 VSS nmos W=0.17u L=0.04u
M14087 U1887/net4 CRC_OUT_7_1 VSS VSS nmos W=0.155u L=0.04u
M14088 U1887/net6 U1887/net4 VSS VSS nmos W=0.17u L=0.04u
M14089 n1045 U1887/net14 VSS VSS nmos W=0.155u L=0.04u
M14090 U1887/net10 WX3481 VSS VSS nmos W=0.155u L=0.04u
M14091 U1887/net4 U1887/net10 U1887/net14 VDD pmos W=0.255u L=0.04u
M14092 U1887/net6 WX3481 U1887/net14 VDD pmos W=0.28u L=0.04u
M14093 U1887/net4 CRC_OUT_7_1 VDD VDD pmos W=0.205u L=0.04u
M14094 U1887/net6 U1887/net4 VDD VDD pmos W=0.24u L=0.04u
M14095 n1045 U1887/net14 VDD VDD pmos W=0.205u L=0.04u
M14096 U1887/net10 WX3481 VDD VDD pmos W=0.205u L=0.04u
M14097 U1888/net4 WX3479 U1888/net14 VSS nmos W=0.155u L=0.04u
M14098 U1888/net6 U1888/net10 U1888/net14 VSS nmos W=0.17u L=0.04u
M14099 U1888/net4 CRC_OUT_7_2 VSS VSS nmos W=0.155u L=0.04u
M14100 U1888/net6 U1888/net4 VSS VSS nmos W=0.17u L=0.04u
M14101 n1044 U1888/net14 VSS VSS nmos W=0.155u L=0.04u
M14102 U1888/net10 WX3479 VSS VSS nmos W=0.155u L=0.04u
M14103 U1888/net4 U1888/net10 U1888/net14 VDD pmos W=0.255u L=0.04u
M14104 U1888/net6 WX3479 U1888/net14 VDD pmos W=0.28u L=0.04u
M14105 U1888/net4 CRC_OUT_7_2 VDD VDD pmos W=0.205u L=0.04u
M14106 U1888/net6 U1888/net4 VDD VDD pmos W=0.24u L=0.04u
M14107 n1044 U1888/net14 VDD VDD pmos W=0.205u L=0.04u
M14108 U1888/net10 WX3479 VDD VDD pmos W=0.205u L=0.04u
M14109 U1889/net11 CRC_OUT_7_31 U1889/net17 VSS nmos W=0.155u L=0.04u
M14110 U1889/net5 U1889/net17 U1889/net21 VSS nmos W=0.155u L=0.04u
M14111 U1889/net5 CRC_OUT_7_3 VSS VSS nmos W=0.155u L=0.04u
M14112 n1043 U1889/net21 VSS VSS nmos W=0.155u L=0.04u
M14113 U1889/net16 CRC_OUT_7_31 VSS VSS nmos W=0.155u L=0.04u
M14114 U1889/net11 WX3477 VSS VSS nmos W=0.155u L=0.04u
M14115 U1889/net13 U1889/net17 VSS VSS nmos W=0.155u L=0.04u
M14116 U1889/net17 U1889/net16 U1889/XI2-net16 VSS nmos W=0.155u L=0.04u
M14117 U1889/XI2-net16 U1889/net11 VSS VSS nmos W=0.155u L=0.04u
M14118 U1889/net21 U1889/net13 U1889/XU21-net16 VSS nmos W=0.155u L=0.04u
M14119 U1889/XU21-net16 U1889/net5 VSS VSS nmos W=0.155u L=0.04u
M14120 U1889/net11 U1889/net16 U1889/net17 VDD pmos W=0.205u L=0.04u
M14121 U1889/net5 U1889/net13 U1889/net21 VDD pmos W=0.205u L=0.04u
M14122 U1889/net5 CRC_OUT_7_3 VDD VDD pmos W=0.205u L=0.04u
M14123 n1043 U1889/net21 VDD VDD pmos W=0.205u L=0.04u
M14124 U1889/net16 CRC_OUT_7_31 VDD VDD pmos W=0.205u L=0.04u
M14125 U1889/net11 WX3477 VDD VDD pmos W=0.205u L=0.04u
M14126 U1889/net13 U1889/net17 VDD VDD pmos W=0.205u L=0.04u
M14127 U1889/net17 CRC_OUT_7_31 U1889/XI2-net6 VDD pmos W=0.205u L=0.04u
M14128 U1889/XI2-net6 U1889/net11 VDD VDD pmos W=0.205u L=0.04u
M14129 U1889/net21 U1889/net17 U1889/XU21-net6 VDD pmos W=0.205u L=0.04u
M14130 U1889/XU21-net6 U1889/net5 VDD VDD pmos W=0.205u L=0.04u
M14131 U1890/net4 WX3475 U1890/net14 VSS nmos W=0.155u L=0.04u
M14132 U1890/net6 U1890/net10 U1890/net14 VSS nmos W=0.17u L=0.04u
M14133 U1890/net4 CRC_OUT_7_4 VSS VSS nmos W=0.155u L=0.04u
M14134 U1890/net6 U1890/net4 VSS VSS nmos W=0.17u L=0.04u
M14135 n1042 U1890/net14 VSS VSS nmos W=0.155u L=0.04u
M14136 U1890/net10 WX3475 VSS VSS nmos W=0.155u L=0.04u
M14137 U1890/net4 U1890/net10 U1890/net14 VDD pmos W=0.255u L=0.04u
M14138 U1890/net6 WX3475 U1890/net14 VDD pmos W=0.28u L=0.04u
M14139 U1890/net4 CRC_OUT_7_4 VDD VDD pmos W=0.205u L=0.04u
M14140 U1890/net6 U1890/net4 VDD VDD pmos W=0.24u L=0.04u
M14141 n1042 U1890/net14 VDD VDD pmos W=0.205u L=0.04u
M14142 U1890/net10 WX3475 VDD VDD pmos W=0.205u L=0.04u
M14143 U1891/net4 WX3473 U1891/net14 VSS nmos W=0.155u L=0.04u
M14144 U1891/net6 U1891/net10 U1891/net14 VSS nmos W=0.17u L=0.04u
M14145 U1891/net4 CRC_OUT_7_5 VSS VSS nmos W=0.155u L=0.04u
M14146 U1891/net6 U1891/net4 VSS VSS nmos W=0.17u L=0.04u
M14147 n1041 U1891/net14 VSS VSS nmos W=0.155u L=0.04u
M14148 U1891/net10 WX3473 VSS VSS nmos W=0.155u L=0.04u
M14149 U1891/net4 U1891/net10 U1891/net14 VDD pmos W=0.255u L=0.04u
M14150 U1891/net6 WX3473 U1891/net14 VDD pmos W=0.28u L=0.04u
M14151 U1891/net4 CRC_OUT_7_5 VDD VDD pmos W=0.205u L=0.04u
M14152 U1891/net6 U1891/net4 VDD VDD pmos W=0.24u L=0.04u
M14153 n1041 U1891/net14 VDD VDD pmos W=0.205u L=0.04u
M14154 U1891/net10 WX3473 VDD VDD pmos W=0.205u L=0.04u
M14155 U1892/net4 WX3471 U1892/net14 VSS nmos W=0.155u L=0.04u
M14156 U1892/net6 U1892/net10 U1892/net14 VSS nmos W=0.17u L=0.04u
M14157 U1892/net4 CRC_OUT_7_6 VSS VSS nmos W=0.155u L=0.04u
M14158 U1892/net6 U1892/net4 VSS VSS nmos W=0.17u L=0.04u
M14159 n1040 U1892/net14 VSS VSS nmos W=0.155u L=0.04u
M14160 U1892/net10 WX3471 VSS VSS nmos W=0.155u L=0.04u
M14161 U1892/net4 U1892/net10 U1892/net14 VDD pmos W=0.255u L=0.04u
M14162 U1892/net6 WX3471 U1892/net14 VDD pmos W=0.28u L=0.04u
M14163 U1892/net4 CRC_OUT_7_6 VDD VDD pmos W=0.205u L=0.04u
M14164 U1892/net6 U1892/net4 VDD VDD pmos W=0.24u L=0.04u
M14165 n1040 U1892/net14 VDD VDD pmos W=0.205u L=0.04u
M14166 U1892/net10 WX3471 VDD VDD pmos W=0.205u L=0.04u
M14167 U1893/net4 WX3469 U1893/net14 VSS nmos W=0.155u L=0.04u
M14168 U1893/net6 U1893/net10 U1893/net14 VSS nmos W=0.17u L=0.04u
M14169 U1893/net4 CRC_OUT_7_7 VSS VSS nmos W=0.155u L=0.04u
M14170 U1893/net6 U1893/net4 VSS VSS nmos W=0.17u L=0.04u
M14171 n1039 U1893/net14 VSS VSS nmos W=0.155u L=0.04u
M14172 U1893/net10 WX3469 VSS VSS nmos W=0.155u L=0.04u
M14173 U1893/net4 U1893/net10 U1893/net14 VDD pmos W=0.255u L=0.04u
M14174 U1893/net6 WX3469 U1893/net14 VDD pmos W=0.28u L=0.04u
M14175 U1893/net4 CRC_OUT_7_7 VDD VDD pmos W=0.205u L=0.04u
M14176 U1893/net6 U1893/net4 VDD VDD pmos W=0.24u L=0.04u
M14177 n1039 U1893/net14 VDD VDD pmos W=0.205u L=0.04u
M14178 U1893/net10 WX3469 VDD VDD pmos W=0.205u L=0.04u
M14179 U1894/net4 WX3467 U1894/net14 VSS nmos W=0.155u L=0.04u
M14180 U1894/net6 U1894/net10 U1894/net14 VSS nmos W=0.17u L=0.04u
M14181 U1894/net4 CRC_OUT_7_8 VSS VSS nmos W=0.155u L=0.04u
M14182 U1894/net6 U1894/net4 VSS VSS nmos W=0.17u L=0.04u
M14183 n1038 U1894/net14 VSS VSS nmos W=0.155u L=0.04u
M14184 U1894/net10 WX3467 VSS VSS nmos W=0.155u L=0.04u
M14185 U1894/net4 U1894/net10 U1894/net14 VDD pmos W=0.255u L=0.04u
M14186 U1894/net6 WX3467 U1894/net14 VDD pmos W=0.28u L=0.04u
M14187 U1894/net4 CRC_OUT_7_8 VDD VDD pmos W=0.205u L=0.04u
M14188 U1894/net6 U1894/net4 VDD VDD pmos W=0.24u L=0.04u
M14189 n1038 U1894/net14 VDD VDD pmos W=0.205u L=0.04u
M14190 U1894/net10 WX3467 VDD VDD pmos W=0.205u L=0.04u
M14191 U1895/net4 WX3465 U1895/net14 VSS nmos W=0.155u L=0.04u
M14192 U1895/net6 U1895/net10 U1895/net14 VSS nmos W=0.17u L=0.04u
M14193 U1895/net4 CRC_OUT_7_9 VSS VSS nmos W=0.155u L=0.04u
M14194 U1895/net6 U1895/net4 VSS VSS nmos W=0.17u L=0.04u
M14195 n1037 U1895/net14 VSS VSS nmos W=0.155u L=0.04u
M14196 U1895/net10 WX3465 VSS VSS nmos W=0.155u L=0.04u
M14197 U1895/net4 U1895/net10 U1895/net14 VDD pmos W=0.255u L=0.04u
M14198 U1895/net6 WX3465 U1895/net14 VDD pmos W=0.28u L=0.04u
M14199 U1895/net4 CRC_OUT_7_9 VDD VDD pmos W=0.205u L=0.04u
M14200 U1895/net6 U1895/net4 VDD VDD pmos W=0.24u L=0.04u
M14201 n1037 U1895/net14 VDD VDD pmos W=0.205u L=0.04u
M14202 U1895/net10 WX3465 VDD VDD pmos W=0.205u L=0.04u
M14203 U1896/net11 CRC_OUT_7_31 U1896/net17 VSS nmos W=0.155u L=0.04u
M14204 U1896/net5 U1896/net17 U1896/net21 VSS nmos W=0.155u L=0.04u
M14205 U1896/net5 CRC_OUT_7_10 VSS VSS nmos W=0.155u L=0.04u
M14206 n1036 U1896/net21 VSS VSS nmos W=0.155u L=0.04u
M14207 U1896/net16 CRC_OUT_7_31 VSS VSS nmos W=0.155u L=0.04u
M14208 U1896/net11 WX3463 VSS VSS nmos W=0.155u L=0.04u
M14209 U1896/net13 U1896/net17 VSS VSS nmos W=0.155u L=0.04u
M14210 U1896/net17 U1896/net16 U1896/XI2-net16 VSS nmos W=0.155u L=0.04u
M14211 U1896/XI2-net16 U1896/net11 VSS VSS nmos W=0.155u L=0.04u
M14212 U1896/net21 U1896/net13 U1896/XU21-net16 VSS nmos W=0.155u L=0.04u
M14213 U1896/XU21-net16 U1896/net5 VSS VSS nmos W=0.155u L=0.04u
M14214 U1896/net11 U1896/net16 U1896/net17 VDD pmos W=0.205u L=0.04u
M14215 U1896/net5 U1896/net13 U1896/net21 VDD pmos W=0.205u L=0.04u
M14216 U1896/net5 CRC_OUT_7_10 VDD VDD pmos W=0.205u L=0.04u
M14217 n1036 U1896/net21 VDD VDD pmos W=0.205u L=0.04u
M14218 U1896/net16 CRC_OUT_7_31 VDD VDD pmos W=0.205u L=0.04u
M14219 U1896/net11 WX3463 VDD VDD pmos W=0.205u L=0.04u
M14220 U1896/net13 U1896/net17 VDD VDD pmos W=0.205u L=0.04u
M14221 U1896/net17 CRC_OUT_7_31 U1896/XI2-net6 VDD pmos W=0.205u L=0.04u
M14222 U1896/XI2-net6 U1896/net11 VDD VDD pmos W=0.205u L=0.04u
M14223 U1896/net21 U1896/net17 U1896/XU21-net6 VDD pmos W=0.205u L=0.04u
M14224 U1896/XU21-net6 U1896/net5 VDD VDD pmos W=0.205u L=0.04u
M14225 U1897/net4 WX3461 U1897/net14 VSS nmos W=0.155u L=0.04u
M14226 U1897/net6 U1897/net10 U1897/net14 VSS nmos W=0.17u L=0.04u
M14227 U1897/net4 CRC_OUT_7_11 VSS VSS nmos W=0.155u L=0.04u
M14228 U1897/net6 U1897/net4 VSS VSS nmos W=0.17u L=0.04u
M14229 n1035 U1897/net14 VSS VSS nmos W=0.155u L=0.04u
M14230 U1897/net10 WX3461 VSS VSS nmos W=0.155u L=0.04u
M14231 U1897/net4 U1897/net10 U1897/net14 VDD pmos W=0.255u L=0.04u
M14232 U1897/net6 WX3461 U1897/net14 VDD pmos W=0.28u L=0.04u
M14233 U1897/net4 CRC_OUT_7_11 VDD VDD pmos W=0.205u L=0.04u
M14234 U1897/net6 U1897/net4 VDD VDD pmos W=0.24u L=0.04u
M14235 n1035 U1897/net14 VDD VDD pmos W=0.205u L=0.04u
M14236 U1897/net10 WX3461 VDD VDD pmos W=0.205u L=0.04u
M14237 U1898/net4 WX3459 U1898/net14 VSS nmos W=0.155u L=0.04u
M14238 U1898/net6 U1898/net10 U1898/net14 VSS nmos W=0.17u L=0.04u
M14239 U1898/net4 CRC_OUT_7_12 VSS VSS nmos W=0.155u L=0.04u
M14240 U1898/net6 U1898/net4 VSS VSS nmos W=0.17u L=0.04u
M14241 n1034 U1898/net14 VSS VSS nmos W=0.155u L=0.04u
M14242 U1898/net10 WX3459 VSS VSS nmos W=0.155u L=0.04u
M14243 U1898/net4 U1898/net10 U1898/net14 VDD pmos W=0.255u L=0.04u
M14244 U1898/net6 WX3459 U1898/net14 VDD pmos W=0.28u L=0.04u
M14245 U1898/net4 CRC_OUT_7_12 VDD VDD pmos W=0.205u L=0.04u
M14246 U1898/net6 U1898/net4 VDD VDD pmos W=0.24u L=0.04u
M14247 n1034 U1898/net14 VDD VDD pmos W=0.205u L=0.04u
M14248 U1898/net10 WX3459 VDD VDD pmos W=0.205u L=0.04u
M14249 U1899/net4 WX3457 U1899/net14 VSS nmos W=0.155u L=0.04u
M14250 U1899/net6 U1899/net10 U1899/net14 VSS nmos W=0.17u L=0.04u
M14251 U1899/net4 CRC_OUT_7_13 VSS VSS nmos W=0.155u L=0.04u
M14252 U1899/net6 U1899/net4 VSS VSS nmos W=0.17u L=0.04u
M14253 n1033 U1899/net14 VSS VSS nmos W=0.155u L=0.04u
M14254 U1899/net10 WX3457 VSS VSS nmos W=0.155u L=0.04u
M14255 U1899/net4 U1899/net10 U1899/net14 VDD pmos W=0.255u L=0.04u
M14256 U1899/net6 WX3457 U1899/net14 VDD pmos W=0.28u L=0.04u
M14257 U1899/net4 CRC_OUT_7_13 VDD VDD pmos W=0.205u L=0.04u
M14258 U1899/net6 U1899/net4 VDD VDD pmos W=0.24u L=0.04u
M14259 n1033 U1899/net14 VDD VDD pmos W=0.205u L=0.04u
M14260 U1899/net10 WX3457 VDD VDD pmos W=0.205u L=0.04u
M14261 U1900/net4 WX3455 U1900/net14 VSS nmos W=0.155u L=0.04u
M14262 U1900/net6 U1900/net10 U1900/net14 VSS nmos W=0.17u L=0.04u
M14263 U1900/net4 CRC_OUT_7_14 VSS VSS nmos W=0.155u L=0.04u
M14264 U1900/net6 U1900/net4 VSS VSS nmos W=0.17u L=0.04u
M14265 n1032 U1900/net14 VSS VSS nmos W=0.155u L=0.04u
M14266 U1900/net10 WX3455 VSS VSS nmos W=0.155u L=0.04u
M14267 U1900/net4 U1900/net10 U1900/net14 VDD pmos W=0.255u L=0.04u
M14268 U1900/net6 WX3455 U1900/net14 VDD pmos W=0.28u L=0.04u
M14269 U1900/net4 CRC_OUT_7_14 VDD VDD pmos W=0.205u L=0.04u
M14270 U1900/net6 U1900/net4 VDD VDD pmos W=0.24u L=0.04u
M14271 n1032 U1900/net14 VDD VDD pmos W=0.205u L=0.04u
M14272 U1900/net10 WX3455 VDD VDD pmos W=0.205u L=0.04u
M14273 U1901/net11 CRC_OUT_7_31 U1901/net17 VSS nmos W=0.155u L=0.04u
M14274 U1901/net5 U1901/net17 U1901/net21 VSS nmos W=0.155u L=0.04u
M14275 U1901/net5 CRC_OUT_7_15 VSS VSS nmos W=0.155u L=0.04u
M14276 n1031 U1901/net21 VSS VSS nmos W=0.155u L=0.04u
M14277 U1901/net16 CRC_OUT_7_31 VSS VSS nmos W=0.155u L=0.04u
M14278 U1901/net11 WX3453 VSS VSS nmos W=0.155u L=0.04u
M14279 U1901/net13 U1901/net17 VSS VSS nmos W=0.155u L=0.04u
M14280 U1901/net17 U1901/net16 U1901/XI2-net16 VSS nmos W=0.155u L=0.04u
M14281 U1901/XI2-net16 U1901/net11 VSS VSS nmos W=0.155u L=0.04u
M14282 U1901/net21 U1901/net13 U1901/XU21-net16 VSS nmos W=0.155u L=0.04u
M14283 U1901/XU21-net16 U1901/net5 VSS VSS nmos W=0.155u L=0.04u
M14284 U1901/net11 U1901/net16 U1901/net17 VDD pmos W=0.205u L=0.04u
M14285 U1901/net5 U1901/net13 U1901/net21 VDD pmos W=0.205u L=0.04u
M14286 U1901/net5 CRC_OUT_7_15 VDD VDD pmos W=0.205u L=0.04u
M14287 n1031 U1901/net21 VDD VDD pmos W=0.205u L=0.04u
M14288 U1901/net16 CRC_OUT_7_31 VDD VDD pmos W=0.205u L=0.04u
M14289 U1901/net11 WX3453 VDD VDD pmos W=0.205u L=0.04u
M14290 U1901/net13 U1901/net17 VDD VDD pmos W=0.205u L=0.04u
M14291 U1901/net17 CRC_OUT_7_31 U1901/XI2-net6 VDD pmos W=0.205u L=0.04u
M14292 U1901/XI2-net6 U1901/net11 VDD VDD pmos W=0.205u L=0.04u
M14293 U1901/net21 U1901/net17 U1901/XU21-net6 VDD pmos W=0.205u L=0.04u
M14294 U1901/XU21-net6 U1901/net5 VDD VDD pmos W=0.205u L=0.04u
M14295 U1902/net4 WX3451 U1902/net14 VSS nmos W=0.155u L=0.04u
M14296 U1902/net6 U1902/net10 U1902/net14 VSS nmos W=0.17u L=0.04u
M14297 U1902/net4 CRC_OUT_7_16 VSS VSS nmos W=0.155u L=0.04u
M14298 U1902/net6 U1902/net4 VSS VSS nmos W=0.17u L=0.04u
M14299 n1030 U1902/net14 VSS VSS nmos W=0.155u L=0.04u
M14300 U1902/net10 WX3451 VSS VSS nmos W=0.155u L=0.04u
M14301 U1902/net4 U1902/net10 U1902/net14 VDD pmos W=0.255u L=0.04u
M14302 U1902/net6 WX3451 U1902/net14 VDD pmos W=0.28u L=0.04u
M14303 U1902/net4 CRC_OUT_7_16 VDD VDD pmos W=0.205u L=0.04u
M14304 U1902/net6 U1902/net4 VDD VDD pmos W=0.24u L=0.04u
M14305 n1030 U1902/net14 VDD VDD pmos W=0.205u L=0.04u
M14306 U1902/net10 WX3451 VDD VDD pmos W=0.205u L=0.04u
M14307 U1903/net4 WX3449 U1903/net14 VSS nmos W=0.155u L=0.04u
M14308 U1903/net6 U1903/net10 U1903/net14 VSS nmos W=0.17u L=0.04u
M14309 U1903/net4 CRC_OUT_7_17 VSS VSS nmos W=0.155u L=0.04u
M14310 U1903/net6 U1903/net4 VSS VSS nmos W=0.17u L=0.04u
M14311 n1029 U1903/net14 VSS VSS nmos W=0.155u L=0.04u
M14312 U1903/net10 WX3449 VSS VSS nmos W=0.155u L=0.04u
M14313 U1903/net4 U1903/net10 U1903/net14 VDD pmos W=0.255u L=0.04u
M14314 U1903/net6 WX3449 U1903/net14 VDD pmos W=0.28u L=0.04u
M14315 U1903/net4 CRC_OUT_7_17 VDD VDD pmos W=0.205u L=0.04u
M14316 U1903/net6 U1903/net4 VDD VDD pmos W=0.24u L=0.04u
M14317 n1029 U1903/net14 VDD VDD pmos W=0.205u L=0.04u
M14318 U1903/net10 WX3449 VDD VDD pmos W=0.205u L=0.04u
M14319 U1904/net4 WX3447 U1904/net14 VSS nmos W=0.155u L=0.04u
M14320 U1904/net6 U1904/net10 U1904/net14 VSS nmos W=0.17u L=0.04u
M14321 U1904/net4 CRC_OUT_7_18 VSS VSS nmos W=0.155u L=0.04u
M14322 U1904/net6 U1904/net4 VSS VSS nmos W=0.17u L=0.04u
M14323 n1028 U1904/net14 VSS VSS nmos W=0.155u L=0.04u
M14324 U1904/net10 WX3447 VSS VSS nmos W=0.155u L=0.04u
M14325 U1904/net4 U1904/net10 U1904/net14 VDD pmos W=0.255u L=0.04u
M14326 U1904/net6 WX3447 U1904/net14 VDD pmos W=0.28u L=0.04u
M14327 U1904/net4 CRC_OUT_7_18 VDD VDD pmos W=0.205u L=0.04u
M14328 U1904/net6 U1904/net4 VDD VDD pmos W=0.24u L=0.04u
M14329 n1028 U1904/net14 VDD VDD pmos W=0.205u L=0.04u
M14330 U1904/net10 WX3447 VDD VDD pmos W=0.205u L=0.04u
M14331 U1905/net4 WX3445 U1905/net14 VSS nmos W=0.155u L=0.04u
M14332 U1905/net6 U1905/net10 U1905/net14 VSS nmos W=0.17u L=0.04u
M14333 U1905/net4 CRC_OUT_7_19 VSS VSS nmos W=0.155u L=0.04u
M14334 U1905/net6 U1905/net4 VSS VSS nmos W=0.17u L=0.04u
M14335 n1027 U1905/net14 VSS VSS nmos W=0.155u L=0.04u
M14336 U1905/net10 WX3445 VSS VSS nmos W=0.155u L=0.04u
M14337 U1905/net4 U1905/net10 U1905/net14 VDD pmos W=0.255u L=0.04u
M14338 U1905/net6 WX3445 U1905/net14 VDD pmos W=0.28u L=0.04u
M14339 U1905/net4 CRC_OUT_7_19 VDD VDD pmos W=0.205u L=0.04u
M14340 U1905/net6 U1905/net4 VDD VDD pmos W=0.24u L=0.04u
M14341 n1027 U1905/net14 VDD VDD pmos W=0.205u L=0.04u
M14342 U1905/net10 WX3445 VDD VDD pmos W=0.205u L=0.04u
M14343 U1906/net4 WX3443 U1906/net14 VSS nmos W=0.155u L=0.04u
M14344 U1906/net6 U1906/net10 U1906/net14 VSS nmos W=0.17u L=0.04u
M14345 U1906/net4 CRC_OUT_7_20 VSS VSS nmos W=0.155u L=0.04u
M14346 U1906/net6 U1906/net4 VSS VSS nmos W=0.17u L=0.04u
M14347 n1026 U1906/net14 VSS VSS nmos W=0.155u L=0.04u
M14348 U1906/net10 WX3443 VSS VSS nmos W=0.155u L=0.04u
M14349 U1906/net4 U1906/net10 U1906/net14 VDD pmos W=0.255u L=0.04u
M14350 U1906/net6 WX3443 U1906/net14 VDD pmos W=0.28u L=0.04u
M14351 U1906/net4 CRC_OUT_7_20 VDD VDD pmos W=0.205u L=0.04u
M14352 U1906/net6 U1906/net4 VDD VDD pmos W=0.24u L=0.04u
M14353 n1026 U1906/net14 VDD VDD pmos W=0.205u L=0.04u
M14354 U1906/net10 WX3443 VDD VDD pmos W=0.205u L=0.04u
M14355 U1907/net4 WX3441 U1907/net14 VSS nmos W=0.155u L=0.04u
M14356 U1907/net6 U1907/net10 U1907/net14 VSS nmos W=0.17u L=0.04u
M14357 U1907/net4 CRC_OUT_7_21 VSS VSS nmos W=0.155u L=0.04u
M14358 U1907/net6 U1907/net4 VSS VSS nmos W=0.17u L=0.04u
M14359 n1025 U1907/net14 VSS VSS nmos W=0.155u L=0.04u
M14360 U1907/net10 WX3441 VSS VSS nmos W=0.155u L=0.04u
M14361 U1907/net4 U1907/net10 U1907/net14 VDD pmos W=0.255u L=0.04u
M14362 U1907/net6 WX3441 U1907/net14 VDD pmos W=0.28u L=0.04u
M14363 U1907/net4 CRC_OUT_7_21 VDD VDD pmos W=0.205u L=0.04u
M14364 U1907/net6 U1907/net4 VDD VDD pmos W=0.24u L=0.04u
M14365 n1025 U1907/net14 VDD VDD pmos W=0.205u L=0.04u
M14366 U1907/net10 WX3441 VDD VDD pmos W=0.205u L=0.04u
M14367 U1908/net4 WX3439 U1908/net14 VSS nmos W=0.155u L=0.04u
M14368 U1908/net6 U1908/net10 U1908/net14 VSS nmos W=0.17u L=0.04u
M14369 U1908/net4 CRC_OUT_7_22 VSS VSS nmos W=0.155u L=0.04u
M14370 U1908/net6 U1908/net4 VSS VSS nmos W=0.17u L=0.04u
M14371 n1024 U1908/net14 VSS VSS nmos W=0.155u L=0.04u
M14372 U1908/net10 WX3439 VSS VSS nmos W=0.155u L=0.04u
M14373 U1908/net4 U1908/net10 U1908/net14 VDD pmos W=0.255u L=0.04u
M14374 U1908/net6 WX3439 U1908/net14 VDD pmos W=0.28u L=0.04u
M14375 U1908/net4 CRC_OUT_7_22 VDD VDD pmos W=0.205u L=0.04u
M14376 U1908/net6 U1908/net4 VDD VDD pmos W=0.24u L=0.04u
M14377 n1024 U1908/net14 VDD VDD pmos W=0.205u L=0.04u
M14378 U1908/net10 WX3439 VDD VDD pmos W=0.205u L=0.04u
M14379 U1909/net4 WX3437 U1909/net14 VSS nmos W=0.155u L=0.04u
M14380 U1909/net6 U1909/net10 U1909/net14 VSS nmos W=0.17u L=0.04u
M14381 U1909/net4 CRC_OUT_7_23 VSS VSS nmos W=0.155u L=0.04u
M14382 U1909/net6 U1909/net4 VSS VSS nmos W=0.17u L=0.04u
M14383 n1023 U1909/net14 VSS VSS nmos W=0.155u L=0.04u
M14384 U1909/net10 WX3437 VSS VSS nmos W=0.155u L=0.04u
M14385 U1909/net4 U1909/net10 U1909/net14 VDD pmos W=0.255u L=0.04u
M14386 U1909/net6 WX3437 U1909/net14 VDD pmos W=0.28u L=0.04u
M14387 U1909/net4 CRC_OUT_7_23 VDD VDD pmos W=0.205u L=0.04u
M14388 U1909/net6 U1909/net4 VDD VDD pmos W=0.24u L=0.04u
M14389 n1023 U1909/net14 VDD VDD pmos W=0.205u L=0.04u
M14390 U1909/net10 WX3437 VDD VDD pmos W=0.205u L=0.04u
M14391 U1910/net4 WX3435 U1910/net14 VSS nmos W=0.155u L=0.04u
M14392 U1910/net6 U1910/net10 U1910/net14 VSS nmos W=0.17u L=0.04u
M14393 U1910/net4 CRC_OUT_7_24 VSS VSS nmos W=0.155u L=0.04u
M14394 U1910/net6 U1910/net4 VSS VSS nmos W=0.17u L=0.04u
M14395 n1022 U1910/net14 VSS VSS nmos W=0.155u L=0.04u
M14396 U1910/net10 WX3435 VSS VSS nmos W=0.155u L=0.04u
M14397 U1910/net4 U1910/net10 U1910/net14 VDD pmos W=0.255u L=0.04u
M14398 U1910/net6 WX3435 U1910/net14 VDD pmos W=0.28u L=0.04u
M14399 U1910/net4 CRC_OUT_7_24 VDD VDD pmos W=0.205u L=0.04u
M14400 U1910/net6 U1910/net4 VDD VDD pmos W=0.24u L=0.04u
M14401 n1022 U1910/net14 VDD VDD pmos W=0.205u L=0.04u
M14402 U1910/net10 WX3435 VDD VDD pmos W=0.205u L=0.04u
M14403 U1911/net4 WX3433 U1911/net14 VSS nmos W=0.155u L=0.04u
M14404 U1911/net6 U1911/net10 U1911/net14 VSS nmos W=0.17u L=0.04u
M14405 U1911/net4 CRC_OUT_7_25 VSS VSS nmos W=0.155u L=0.04u
M14406 U1911/net6 U1911/net4 VSS VSS nmos W=0.17u L=0.04u
M14407 n1021 U1911/net14 VSS VSS nmos W=0.155u L=0.04u
M14408 U1911/net10 WX3433 VSS VSS nmos W=0.155u L=0.04u
M14409 U1911/net4 U1911/net10 U1911/net14 VDD pmos W=0.255u L=0.04u
M14410 U1911/net6 WX3433 U1911/net14 VDD pmos W=0.28u L=0.04u
M14411 U1911/net4 CRC_OUT_7_25 VDD VDD pmos W=0.205u L=0.04u
M14412 U1911/net6 U1911/net4 VDD VDD pmos W=0.24u L=0.04u
M14413 n1021 U1911/net14 VDD VDD pmos W=0.205u L=0.04u
M14414 U1911/net10 WX3433 VDD VDD pmos W=0.205u L=0.04u
M14415 U1912/net4 WX3431 U1912/net14 VSS nmos W=0.155u L=0.04u
M14416 U1912/net6 U1912/net10 U1912/net14 VSS nmos W=0.17u L=0.04u
M14417 U1912/net4 CRC_OUT_7_26 VSS VSS nmos W=0.155u L=0.04u
M14418 U1912/net6 U1912/net4 VSS VSS nmos W=0.17u L=0.04u
M14419 n1020 U1912/net14 VSS VSS nmos W=0.155u L=0.04u
M14420 U1912/net10 WX3431 VSS VSS nmos W=0.155u L=0.04u
M14421 U1912/net4 U1912/net10 U1912/net14 VDD pmos W=0.255u L=0.04u
M14422 U1912/net6 WX3431 U1912/net14 VDD pmos W=0.28u L=0.04u
M14423 U1912/net4 CRC_OUT_7_26 VDD VDD pmos W=0.205u L=0.04u
M14424 U1912/net6 U1912/net4 VDD VDD pmos W=0.24u L=0.04u
M14425 n1020 U1912/net14 VDD VDD pmos W=0.205u L=0.04u
M14426 U1912/net10 WX3431 VDD VDD pmos W=0.205u L=0.04u
M14427 U1913/net4 WX3429 U1913/net14 VSS nmos W=0.155u L=0.04u
M14428 U1913/net6 U1913/net10 U1913/net14 VSS nmos W=0.17u L=0.04u
M14429 U1913/net4 CRC_OUT_7_27 VSS VSS nmos W=0.155u L=0.04u
M14430 U1913/net6 U1913/net4 VSS VSS nmos W=0.17u L=0.04u
M14431 n1019 U1913/net14 VSS VSS nmos W=0.155u L=0.04u
M14432 U1913/net10 WX3429 VSS VSS nmos W=0.155u L=0.04u
M14433 U1913/net4 U1913/net10 U1913/net14 VDD pmos W=0.255u L=0.04u
M14434 U1913/net6 WX3429 U1913/net14 VDD pmos W=0.28u L=0.04u
M14435 U1913/net4 CRC_OUT_7_27 VDD VDD pmos W=0.205u L=0.04u
M14436 U1913/net6 U1913/net4 VDD VDD pmos W=0.24u L=0.04u
M14437 n1019 U1913/net14 VDD VDD pmos W=0.205u L=0.04u
M14438 U1913/net10 WX3429 VDD VDD pmos W=0.205u L=0.04u
M14439 U1914/net4 WX3427 U1914/net14 VSS nmos W=0.155u L=0.04u
M14440 U1914/net6 U1914/net10 U1914/net14 VSS nmos W=0.17u L=0.04u
M14441 U1914/net4 CRC_OUT_7_28 VSS VSS nmos W=0.155u L=0.04u
M14442 U1914/net6 U1914/net4 VSS VSS nmos W=0.17u L=0.04u
M14443 n1018 U1914/net14 VSS VSS nmos W=0.155u L=0.04u
M14444 U1914/net10 WX3427 VSS VSS nmos W=0.155u L=0.04u
M14445 U1914/net4 U1914/net10 U1914/net14 VDD pmos W=0.255u L=0.04u
M14446 U1914/net6 WX3427 U1914/net14 VDD pmos W=0.28u L=0.04u
M14447 U1914/net4 CRC_OUT_7_28 VDD VDD pmos W=0.205u L=0.04u
M14448 U1914/net6 U1914/net4 VDD VDD pmos W=0.24u L=0.04u
M14449 n1018 U1914/net14 VDD VDD pmos W=0.205u L=0.04u
M14450 U1914/net10 WX3427 VDD VDD pmos W=0.205u L=0.04u
M14451 U1915/net4 WX3425 U1915/net14 VSS nmos W=0.155u L=0.04u
M14452 U1915/net6 U1915/net10 U1915/net14 VSS nmos W=0.17u L=0.04u
M14453 U1915/net4 CRC_OUT_7_29 VSS VSS nmos W=0.155u L=0.04u
M14454 U1915/net6 U1915/net4 VSS VSS nmos W=0.17u L=0.04u
M14455 n1017 U1915/net14 VSS VSS nmos W=0.155u L=0.04u
M14456 U1915/net10 WX3425 VSS VSS nmos W=0.155u L=0.04u
M14457 U1915/net4 U1915/net10 U1915/net14 VDD pmos W=0.255u L=0.04u
M14458 U1915/net6 WX3425 U1915/net14 VDD pmos W=0.28u L=0.04u
M14459 U1915/net4 CRC_OUT_7_29 VDD VDD pmos W=0.205u L=0.04u
M14460 U1915/net6 U1915/net4 VDD VDD pmos W=0.24u L=0.04u
M14461 n1017 U1915/net14 VDD VDD pmos W=0.205u L=0.04u
M14462 U1915/net10 WX3425 VDD VDD pmos W=0.205u L=0.04u
M14463 U1916/net4 WX3423 U1916/net14 VSS nmos W=0.155u L=0.04u
M14464 U1916/net6 U1916/net10 U1916/net14 VSS nmos W=0.17u L=0.04u
M14465 U1916/net4 CRC_OUT_7_30 VSS VSS nmos W=0.155u L=0.04u
M14466 U1916/net6 U1916/net4 VSS VSS nmos W=0.17u L=0.04u
M14467 n1016 U1916/net14 VSS VSS nmos W=0.155u L=0.04u
M14468 U1916/net10 WX3423 VSS VSS nmos W=0.155u L=0.04u
M14469 U1916/net4 U1916/net10 U1916/net14 VDD pmos W=0.255u L=0.04u
M14470 U1916/net6 WX3423 U1916/net14 VDD pmos W=0.28u L=0.04u
M14471 U1916/net4 CRC_OUT_7_30 VDD VDD pmos W=0.205u L=0.04u
M14472 U1916/net6 U1916/net4 VDD VDD pmos W=0.24u L=0.04u
M14473 n1016 U1916/net14 VDD VDD pmos W=0.205u L=0.04u
M14474 U1916/net10 WX3423 VDD VDD pmos W=0.205u L=0.04u
M14475 U1917/net4 n1396 U1917/net14 VSS nmos W=0.155u L=0.04u
M14476 U1917/net6 U1917/net10 U1917/net14 VSS nmos W=0.17u L=0.04u
M14477 U1917/net4 n1397 VSS VSS nmos W=0.155u L=0.04u
M14478 U1917/net6 U1917/net4 VSS VSS nmos W=0.17u L=0.04u
M14479 n1015 U1917/net14 VSS VSS nmos W=0.155u L=0.04u
M14480 U1917/net10 n1396 VSS VSS nmos W=0.155u L=0.04u
M14481 U1917/net4 U1917/net10 U1917/net14 VDD pmos W=0.255u L=0.04u
M14482 U1917/net6 n1396 U1917/net14 VDD pmos W=0.28u L=0.04u
M14483 U1917/net4 n1397 VDD VDD pmos W=0.205u L=0.04u
M14484 U1917/net6 U1917/net4 VDD VDD pmos W=0.24u L=0.04u
M14485 n1015 U1917/net14 VDD VDD pmos W=0.205u L=0.04u
M14486 U1917/net10 n1396 VDD VDD pmos W=0.205u L=0.04u
M14487 U1918/net4 WX2190 U1918/net14 VSS nmos W=0.155u L=0.04u
M14488 U1918/net6 U1918/net10 U1918/net14 VSS nmos W=0.17u L=0.04u
M14489 U1918/net4 CRC_OUT_8_0 VSS VSS nmos W=0.155u L=0.04u
M14490 U1918/net6 U1918/net4 VSS VSS nmos W=0.17u L=0.04u
M14491 n1014 U1918/net14 VSS VSS nmos W=0.155u L=0.04u
M14492 U1918/net10 WX2190 VSS VSS nmos W=0.155u L=0.04u
M14493 U1918/net4 U1918/net10 U1918/net14 VDD pmos W=0.255u L=0.04u
M14494 U1918/net6 WX2190 U1918/net14 VDD pmos W=0.28u L=0.04u
M14495 U1918/net4 CRC_OUT_8_0 VDD VDD pmos W=0.205u L=0.04u
M14496 U1918/net6 U1918/net4 VDD VDD pmos W=0.24u L=0.04u
M14497 n1014 U1918/net14 VDD VDD pmos W=0.205u L=0.04u
M14498 U1918/net10 WX2190 VDD VDD pmos W=0.205u L=0.04u
M14499 U1919/net4 WX2188 U1919/net14 VSS nmos W=0.155u L=0.04u
M14500 U1919/net6 U1919/net10 U1919/net14 VSS nmos W=0.17u L=0.04u
M14501 U1919/net4 CRC_OUT_8_1 VSS VSS nmos W=0.155u L=0.04u
M14502 U1919/net6 U1919/net4 VSS VSS nmos W=0.17u L=0.04u
M14503 n1013 U1919/net14 VSS VSS nmos W=0.155u L=0.04u
M14504 U1919/net10 WX2188 VSS VSS nmos W=0.155u L=0.04u
M14505 U1919/net4 U1919/net10 U1919/net14 VDD pmos W=0.255u L=0.04u
M14506 U1919/net6 WX2188 U1919/net14 VDD pmos W=0.28u L=0.04u
M14507 U1919/net4 CRC_OUT_8_1 VDD VDD pmos W=0.205u L=0.04u
M14508 U1919/net6 U1919/net4 VDD VDD pmos W=0.24u L=0.04u
M14509 n1013 U1919/net14 VDD VDD pmos W=0.205u L=0.04u
M14510 U1919/net10 WX2188 VDD VDD pmos W=0.205u L=0.04u
M14511 U1920/net4 WX2186 U1920/net14 VSS nmos W=0.155u L=0.04u
M14512 U1920/net6 U1920/net10 U1920/net14 VSS nmos W=0.17u L=0.04u
M14513 U1920/net4 CRC_OUT_8_2 VSS VSS nmos W=0.155u L=0.04u
M14514 U1920/net6 U1920/net4 VSS VSS nmos W=0.17u L=0.04u
M14515 n1012 U1920/net14 VSS VSS nmos W=0.155u L=0.04u
M14516 U1920/net10 WX2186 VSS VSS nmos W=0.155u L=0.04u
M14517 U1920/net4 U1920/net10 U1920/net14 VDD pmos W=0.255u L=0.04u
M14518 U1920/net6 WX2186 U1920/net14 VDD pmos W=0.28u L=0.04u
M14519 U1920/net4 CRC_OUT_8_2 VDD VDD pmos W=0.205u L=0.04u
M14520 U1920/net6 U1920/net4 VDD VDD pmos W=0.24u L=0.04u
M14521 n1012 U1920/net14 VDD VDD pmos W=0.205u L=0.04u
M14522 U1920/net10 WX2186 VDD VDD pmos W=0.205u L=0.04u
M14523 U1921/net11 CRC_OUT_8_31 U1921/net17 VSS nmos W=0.155u L=0.04u
M14524 U1921/net5 U1921/net17 U1921/net21 VSS nmos W=0.155u L=0.04u
M14525 U1921/net5 CRC_OUT_8_3 VSS VSS nmos W=0.155u L=0.04u
M14526 n1011 U1921/net21 VSS VSS nmos W=0.155u L=0.04u
M14527 U1921/net16 CRC_OUT_8_31 VSS VSS nmos W=0.155u L=0.04u
M14528 U1921/net11 WX2184 VSS VSS nmos W=0.155u L=0.04u
M14529 U1921/net13 U1921/net17 VSS VSS nmos W=0.155u L=0.04u
M14530 U1921/net17 U1921/net16 U1921/XI2-net16 VSS nmos W=0.155u L=0.04u
M14531 U1921/XI2-net16 U1921/net11 VSS VSS nmos W=0.155u L=0.04u
M14532 U1921/net21 U1921/net13 U1921/XU21-net16 VSS nmos W=0.155u L=0.04u
M14533 U1921/XU21-net16 U1921/net5 VSS VSS nmos W=0.155u L=0.04u
M14534 U1921/net11 U1921/net16 U1921/net17 VDD pmos W=0.205u L=0.04u
M14535 U1921/net5 U1921/net13 U1921/net21 VDD pmos W=0.205u L=0.04u
M14536 U1921/net5 CRC_OUT_8_3 VDD VDD pmos W=0.205u L=0.04u
M14537 n1011 U1921/net21 VDD VDD pmos W=0.205u L=0.04u
M14538 U1921/net16 CRC_OUT_8_31 VDD VDD pmos W=0.205u L=0.04u
M14539 U1921/net11 WX2184 VDD VDD pmos W=0.205u L=0.04u
M14540 U1921/net13 U1921/net17 VDD VDD pmos W=0.205u L=0.04u
M14541 U1921/net17 CRC_OUT_8_31 U1921/XI2-net6 VDD pmos W=0.205u L=0.04u
M14542 U1921/XI2-net6 U1921/net11 VDD VDD pmos W=0.205u L=0.04u
M14543 U1921/net21 U1921/net17 U1921/XU21-net6 VDD pmos W=0.205u L=0.04u
M14544 U1921/XU21-net6 U1921/net5 VDD VDD pmos W=0.205u L=0.04u
M14545 U1922/net4 WX2182 U1922/net14 VSS nmos W=0.155u L=0.04u
M14546 U1922/net6 U1922/net10 U1922/net14 VSS nmos W=0.17u L=0.04u
M14547 U1922/net4 CRC_OUT_8_4 VSS VSS nmos W=0.155u L=0.04u
M14548 U1922/net6 U1922/net4 VSS VSS nmos W=0.17u L=0.04u
M14549 n1010 U1922/net14 VSS VSS nmos W=0.155u L=0.04u
M14550 U1922/net10 WX2182 VSS VSS nmos W=0.155u L=0.04u
M14551 U1922/net4 U1922/net10 U1922/net14 VDD pmos W=0.255u L=0.04u
M14552 U1922/net6 WX2182 U1922/net14 VDD pmos W=0.28u L=0.04u
M14553 U1922/net4 CRC_OUT_8_4 VDD VDD pmos W=0.205u L=0.04u
M14554 U1922/net6 U1922/net4 VDD VDD pmos W=0.24u L=0.04u
M14555 n1010 U1922/net14 VDD VDD pmos W=0.205u L=0.04u
M14556 U1922/net10 WX2182 VDD VDD pmos W=0.205u L=0.04u
M14557 U1923/net4 WX2180 U1923/net14 VSS nmos W=0.155u L=0.04u
M14558 U1923/net6 U1923/net10 U1923/net14 VSS nmos W=0.17u L=0.04u
M14559 U1923/net4 CRC_OUT_8_5 VSS VSS nmos W=0.155u L=0.04u
M14560 U1923/net6 U1923/net4 VSS VSS nmos W=0.17u L=0.04u
M14561 n1009 U1923/net14 VSS VSS nmos W=0.155u L=0.04u
M14562 U1923/net10 WX2180 VSS VSS nmos W=0.155u L=0.04u
M14563 U1923/net4 U1923/net10 U1923/net14 VDD pmos W=0.255u L=0.04u
M14564 U1923/net6 WX2180 U1923/net14 VDD pmos W=0.28u L=0.04u
M14565 U1923/net4 CRC_OUT_8_5 VDD VDD pmos W=0.205u L=0.04u
M14566 U1923/net6 U1923/net4 VDD VDD pmos W=0.24u L=0.04u
M14567 n1009 U1923/net14 VDD VDD pmos W=0.205u L=0.04u
M14568 U1923/net10 WX2180 VDD VDD pmos W=0.205u L=0.04u
M14569 U1924/net4 WX2178 U1924/net14 VSS nmos W=0.155u L=0.04u
M14570 U1924/net6 U1924/net10 U1924/net14 VSS nmos W=0.17u L=0.04u
M14571 U1924/net4 CRC_OUT_8_6 VSS VSS nmos W=0.155u L=0.04u
M14572 U1924/net6 U1924/net4 VSS VSS nmos W=0.17u L=0.04u
M14573 n1008 U1924/net14 VSS VSS nmos W=0.155u L=0.04u
M14574 U1924/net10 WX2178 VSS VSS nmos W=0.155u L=0.04u
M14575 U1924/net4 U1924/net10 U1924/net14 VDD pmos W=0.255u L=0.04u
M14576 U1924/net6 WX2178 U1924/net14 VDD pmos W=0.28u L=0.04u
M14577 U1924/net4 CRC_OUT_8_6 VDD VDD pmos W=0.205u L=0.04u
M14578 U1924/net6 U1924/net4 VDD VDD pmos W=0.24u L=0.04u
M14579 n1008 U1924/net14 VDD VDD pmos W=0.205u L=0.04u
M14580 U1924/net10 WX2178 VDD VDD pmos W=0.205u L=0.04u
M14581 U1925/net4 WX2176 U1925/net14 VSS nmos W=0.155u L=0.04u
M14582 U1925/net6 U1925/net10 U1925/net14 VSS nmos W=0.17u L=0.04u
M14583 U1925/net4 CRC_OUT_8_7 VSS VSS nmos W=0.155u L=0.04u
M14584 U1925/net6 U1925/net4 VSS VSS nmos W=0.17u L=0.04u
M14585 n1007 U1925/net14 VSS VSS nmos W=0.155u L=0.04u
M14586 U1925/net10 WX2176 VSS VSS nmos W=0.155u L=0.04u
M14587 U1925/net4 U1925/net10 U1925/net14 VDD pmos W=0.255u L=0.04u
M14588 U1925/net6 WX2176 U1925/net14 VDD pmos W=0.28u L=0.04u
M14589 U1925/net4 CRC_OUT_8_7 VDD VDD pmos W=0.205u L=0.04u
M14590 U1925/net6 U1925/net4 VDD VDD pmos W=0.24u L=0.04u
M14591 n1007 U1925/net14 VDD VDD pmos W=0.205u L=0.04u
M14592 U1925/net10 WX2176 VDD VDD pmos W=0.205u L=0.04u
M14593 U1926/net4 WX2174 U1926/net14 VSS nmos W=0.155u L=0.04u
M14594 U1926/net6 U1926/net10 U1926/net14 VSS nmos W=0.17u L=0.04u
M14595 U1926/net4 CRC_OUT_8_8 VSS VSS nmos W=0.155u L=0.04u
M14596 U1926/net6 U1926/net4 VSS VSS nmos W=0.17u L=0.04u
M14597 n1006 U1926/net14 VSS VSS nmos W=0.155u L=0.04u
M14598 U1926/net10 WX2174 VSS VSS nmos W=0.155u L=0.04u
M14599 U1926/net4 U1926/net10 U1926/net14 VDD pmos W=0.255u L=0.04u
M14600 U1926/net6 WX2174 U1926/net14 VDD pmos W=0.28u L=0.04u
M14601 U1926/net4 CRC_OUT_8_8 VDD VDD pmos W=0.205u L=0.04u
M14602 U1926/net6 U1926/net4 VDD VDD pmos W=0.24u L=0.04u
M14603 n1006 U1926/net14 VDD VDD pmos W=0.205u L=0.04u
M14604 U1926/net10 WX2174 VDD VDD pmos W=0.205u L=0.04u
M14605 U1927/net4 WX2172 U1927/net14 VSS nmos W=0.155u L=0.04u
M14606 U1927/net6 U1927/net10 U1927/net14 VSS nmos W=0.17u L=0.04u
M14607 U1927/net4 CRC_OUT_8_9 VSS VSS nmos W=0.155u L=0.04u
M14608 U1927/net6 U1927/net4 VSS VSS nmos W=0.17u L=0.04u
M14609 n1005 U1927/net14 VSS VSS nmos W=0.155u L=0.04u
M14610 U1927/net10 WX2172 VSS VSS nmos W=0.155u L=0.04u
M14611 U1927/net4 U1927/net10 U1927/net14 VDD pmos W=0.255u L=0.04u
M14612 U1927/net6 WX2172 U1927/net14 VDD pmos W=0.28u L=0.04u
M14613 U1927/net4 CRC_OUT_8_9 VDD VDD pmos W=0.205u L=0.04u
M14614 U1927/net6 U1927/net4 VDD VDD pmos W=0.24u L=0.04u
M14615 n1005 U1927/net14 VDD VDD pmos W=0.205u L=0.04u
M14616 U1927/net10 WX2172 VDD VDD pmos W=0.205u L=0.04u
M14617 U1928/net11 CRC_OUT_8_31 U1928/net17 VSS nmos W=0.155u L=0.04u
M14618 U1928/net5 U1928/net17 U1928/net21 VSS nmos W=0.155u L=0.04u
M14619 U1928/net5 CRC_OUT_8_10 VSS VSS nmos W=0.155u L=0.04u
M14620 n1004 U1928/net21 VSS VSS nmos W=0.155u L=0.04u
M14621 U1928/net16 CRC_OUT_8_31 VSS VSS nmos W=0.155u L=0.04u
M14622 U1928/net11 WX2170 VSS VSS nmos W=0.155u L=0.04u
M14623 U1928/net13 U1928/net17 VSS VSS nmos W=0.155u L=0.04u
M14624 U1928/net17 U1928/net16 U1928/XI2-net16 VSS nmos W=0.155u L=0.04u
M14625 U1928/XI2-net16 U1928/net11 VSS VSS nmos W=0.155u L=0.04u
M14626 U1928/net21 U1928/net13 U1928/XU21-net16 VSS nmos W=0.155u L=0.04u
M14627 U1928/XU21-net16 U1928/net5 VSS VSS nmos W=0.155u L=0.04u
M14628 U1928/net11 U1928/net16 U1928/net17 VDD pmos W=0.205u L=0.04u
M14629 U1928/net5 U1928/net13 U1928/net21 VDD pmos W=0.205u L=0.04u
M14630 U1928/net5 CRC_OUT_8_10 VDD VDD pmos W=0.205u L=0.04u
M14631 n1004 U1928/net21 VDD VDD pmos W=0.205u L=0.04u
M14632 U1928/net16 CRC_OUT_8_31 VDD VDD pmos W=0.205u L=0.04u
M14633 U1928/net11 WX2170 VDD VDD pmos W=0.205u L=0.04u
M14634 U1928/net13 U1928/net17 VDD VDD pmos W=0.205u L=0.04u
M14635 U1928/net17 CRC_OUT_8_31 U1928/XI2-net6 VDD pmos W=0.205u L=0.04u
M14636 U1928/XI2-net6 U1928/net11 VDD VDD pmos W=0.205u L=0.04u
M14637 U1928/net21 U1928/net17 U1928/XU21-net6 VDD pmos W=0.205u L=0.04u
M14638 U1928/XU21-net6 U1928/net5 VDD VDD pmos W=0.205u L=0.04u
M14639 U1929/net4 WX2168 U1929/net14 VSS nmos W=0.155u L=0.04u
M14640 U1929/net6 U1929/net10 U1929/net14 VSS nmos W=0.17u L=0.04u
M14641 U1929/net4 CRC_OUT_8_11 VSS VSS nmos W=0.155u L=0.04u
M14642 U1929/net6 U1929/net4 VSS VSS nmos W=0.17u L=0.04u
M14643 n1003 U1929/net14 VSS VSS nmos W=0.155u L=0.04u
M14644 U1929/net10 WX2168 VSS VSS nmos W=0.155u L=0.04u
M14645 U1929/net4 U1929/net10 U1929/net14 VDD pmos W=0.255u L=0.04u
M14646 U1929/net6 WX2168 U1929/net14 VDD pmos W=0.28u L=0.04u
M14647 U1929/net4 CRC_OUT_8_11 VDD VDD pmos W=0.205u L=0.04u
M14648 U1929/net6 U1929/net4 VDD VDD pmos W=0.24u L=0.04u
M14649 n1003 U1929/net14 VDD VDD pmos W=0.205u L=0.04u
M14650 U1929/net10 WX2168 VDD VDD pmos W=0.205u L=0.04u
M14651 U1930/net4 WX2166 U1930/net14 VSS nmos W=0.155u L=0.04u
M14652 U1930/net6 U1930/net10 U1930/net14 VSS nmos W=0.17u L=0.04u
M14653 U1930/net4 CRC_OUT_8_12 VSS VSS nmos W=0.155u L=0.04u
M14654 U1930/net6 U1930/net4 VSS VSS nmos W=0.17u L=0.04u
M14655 n1002 U1930/net14 VSS VSS nmos W=0.155u L=0.04u
M14656 U1930/net10 WX2166 VSS VSS nmos W=0.155u L=0.04u
M14657 U1930/net4 U1930/net10 U1930/net14 VDD pmos W=0.255u L=0.04u
M14658 U1930/net6 WX2166 U1930/net14 VDD pmos W=0.28u L=0.04u
M14659 U1930/net4 CRC_OUT_8_12 VDD VDD pmos W=0.205u L=0.04u
M14660 U1930/net6 U1930/net4 VDD VDD pmos W=0.24u L=0.04u
M14661 n1002 U1930/net14 VDD VDD pmos W=0.205u L=0.04u
M14662 U1930/net10 WX2166 VDD VDD pmos W=0.205u L=0.04u
M14663 U1931/net4 WX2164 U1931/net14 VSS nmos W=0.155u L=0.04u
M14664 U1931/net6 U1931/net10 U1931/net14 VSS nmos W=0.17u L=0.04u
M14665 U1931/net4 CRC_OUT_8_13 VSS VSS nmos W=0.155u L=0.04u
M14666 U1931/net6 U1931/net4 VSS VSS nmos W=0.17u L=0.04u
M14667 n1001 U1931/net14 VSS VSS nmos W=0.155u L=0.04u
M14668 U1931/net10 WX2164 VSS VSS nmos W=0.155u L=0.04u
M14669 U1931/net4 U1931/net10 U1931/net14 VDD pmos W=0.255u L=0.04u
M14670 U1931/net6 WX2164 U1931/net14 VDD pmos W=0.28u L=0.04u
M14671 U1931/net4 CRC_OUT_8_13 VDD VDD pmos W=0.205u L=0.04u
M14672 U1931/net6 U1931/net4 VDD VDD pmos W=0.24u L=0.04u
M14673 n1001 U1931/net14 VDD VDD pmos W=0.205u L=0.04u
M14674 U1931/net10 WX2164 VDD VDD pmos W=0.205u L=0.04u
M14675 U1932/net4 WX2162 U1932/net14 VSS nmos W=0.155u L=0.04u
M14676 U1932/net6 U1932/net10 U1932/net14 VSS nmos W=0.17u L=0.04u
M14677 U1932/net4 CRC_OUT_8_14 VSS VSS nmos W=0.155u L=0.04u
M14678 U1932/net6 U1932/net4 VSS VSS nmos W=0.17u L=0.04u
M14679 n1000 U1932/net14 VSS VSS nmos W=0.155u L=0.04u
M14680 U1932/net10 WX2162 VSS VSS nmos W=0.155u L=0.04u
M14681 U1932/net4 U1932/net10 U1932/net14 VDD pmos W=0.255u L=0.04u
M14682 U1932/net6 WX2162 U1932/net14 VDD pmos W=0.28u L=0.04u
M14683 U1932/net4 CRC_OUT_8_14 VDD VDD pmos W=0.205u L=0.04u
M14684 U1932/net6 U1932/net4 VDD VDD pmos W=0.24u L=0.04u
M14685 n1000 U1932/net14 VDD VDD pmos W=0.205u L=0.04u
M14686 U1932/net10 WX2162 VDD VDD pmos W=0.205u L=0.04u
M14687 WX9523 n1240 U1933/net26 VSS nmos W=0.155u L=0.04u
M14688 WX9523 n1398 U1933/net26 VSS nmos W=0.155u L=0.04u
M14689 U1933/net29 n1402 VSS VSS nmos W=0.155u L=0.04u
M14690 U1933/net26 n1400 U1933/net29 VSS nmos W=0.155u L=0.04u
M14691 U1933/net26 n1289 U1933/net29 VSS nmos W=0.155u L=0.04u
M14692 WX9523 n1398 U1933/net43 VDD pmos W=0.205u L=0.04u
M14693 WX9523 n1289 U1933/net49 VDD pmos W=0.205u L=0.04u
M14694 U1933/net49 n1400 VDD VDD pmos W=0.205u L=0.04u
M14695 U1933/net43 n1240 VDD VDD pmos W=0.205u L=0.04u
M14696 WX9523 n1402 VDD VDD pmos W=0.205u L=0.04u
M14697 U1934/net29 n1343 VSS VSS nmos W=0.155u L=0.04u
M14698 n1402 WX9598 U1934/net29 VSS nmos W=0.155u L=0.04u
M14699 n1402 n1312 U1934/net23 VSS nmos W=0.155u L=0.04u
M14700 U1934/net23 CRC_OUT_2_0 VSS VSS nmos W=0.155u L=0.04u
M14701 U1934/net20 CRC_OUT_2_0 n1402 VDD pmos W=0.205u L=0.04u
M14702 U1934/net20 n1312 n1402 VDD pmos W=0.205u L=0.04u
M14703 VDD WX9598 U1934/net20 VDD pmos W=0.205u L=0.04u
M14704 VDD n1343 U1934/net20 VDD pmos W=0.205u L=0.04u
M14705 WX9509 n1244 U1935/net26 VSS nmos W=0.155u L=0.04u
M14706 WX9509 n1405 U1935/net26 VSS nmos W=0.155u L=0.04u
M14707 U1935/net29 n1407 VSS VSS nmos W=0.155u L=0.04u
M14708 U1935/net26 n1406 U1935/net29 VSS nmos W=0.155u L=0.04u
M14709 U1935/net26 n1287 U1935/net29 VSS nmos W=0.155u L=0.04u
M14710 WX9509 n1405 U1935/net43 VDD pmos W=0.205u L=0.04u
M14711 WX9509 n1287 U1935/net49 VDD pmos W=0.205u L=0.04u
M14712 U1935/net49 n1406 VDD VDD pmos W=0.205u L=0.04u
M14713 U1935/net43 n1244 VDD VDD pmos W=0.205u L=0.04u
M14714 WX9509 n1407 VDD VDD pmos W=0.205u L=0.04u
M14715 U1936/net29 n1343 VSS VSS nmos W=0.155u L=0.04u
M14716 n1407 WX9596 U1936/net29 VSS nmos W=0.155u L=0.04u
M14717 n1407 n1312 U1936/net23 VSS nmos W=0.155u L=0.04u
M14718 U1936/net23 CRC_OUT_2_1 VSS VSS nmos W=0.155u L=0.04u
M14719 U1936/net20 CRC_OUT_2_1 n1407 VDD pmos W=0.205u L=0.04u
M14720 U1936/net20 n1312 n1407 VDD pmos W=0.205u L=0.04u
M14721 VDD WX9596 U1936/net20 VDD pmos W=0.205u L=0.04u
M14722 VDD n1343 U1936/net20 VDD pmos W=0.205u L=0.04u
M14723 WX9495 n1244 U1937/net26 VSS nmos W=0.155u L=0.04u
M14724 WX9495 n1408 U1937/net26 VSS nmos W=0.155u L=0.04u
M14725 U1937/net29 n1410 VSS VSS nmos W=0.155u L=0.04u
M14726 U1937/net26 n1409 U1937/net29 VSS nmos W=0.155u L=0.04u
M14727 U1937/net26 n1288 U1937/net29 VSS nmos W=0.155u L=0.04u
M14728 WX9495 n1408 U1937/net43 VDD pmos W=0.205u L=0.04u
M14729 WX9495 n1288 U1937/net49 VDD pmos W=0.205u L=0.04u
M14730 U1937/net49 n1409 VDD VDD pmos W=0.205u L=0.04u
M14731 U1937/net43 n1244 VDD VDD pmos W=0.205u L=0.04u
M14732 WX9495 n1410 VDD VDD pmos W=0.205u L=0.04u
M14733 U1938/net29 n1343 VSS VSS nmos W=0.155u L=0.04u
M14734 n1410 WX9594 U1938/net29 VSS nmos W=0.155u L=0.04u
M14735 n1410 n1312 U1938/net23 VSS nmos W=0.155u L=0.04u
M14736 U1938/net23 CRC_OUT_2_2 VSS VSS nmos W=0.155u L=0.04u
M14737 U1938/net20 CRC_OUT_2_2 n1410 VDD pmos W=0.205u L=0.04u
M14738 U1938/net20 n1312 n1410 VDD pmos W=0.205u L=0.04u
M14739 VDD WX9594 U1938/net20 VDD pmos W=0.205u L=0.04u
M14740 VDD n1343 U1938/net20 VDD pmos W=0.205u L=0.04u
M14741 WX9481 n1244 U1939/net26 VSS nmos W=0.155u L=0.04u
M14742 WX9481 n1411 U1939/net26 VSS nmos W=0.155u L=0.04u
M14743 U1939/net29 n1413 VSS VSS nmos W=0.155u L=0.04u
M14744 U1939/net26 n1412 U1939/net29 VSS nmos W=0.155u L=0.04u
M14745 U1939/net26 n1287 U1939/net29 VSS nmos W=0.155u L=0.04u
M14746 WX9481 n1411 U1939/net43 VDD pmos W=0.205u L=0.04u
M14747 WX9481 n1287 U1939/net49 VDD pmos W=0.205u L=0.04u
M14748 U1939/net49 n1412 VDD VDD pmos W=0.205u L=0.04u
M14749 U1939/net43 n1244 VDD VDD pmos W=0.205u L=0.04u
M14750 WX9481 n1413 VDD VDD pmos W=0.205u L=0.04u
M14751 U1940/net29 n1343 VSS VSS nmos W=0.155u L=0.04u
M14752 n1413 WX9592 U1940/net29 VSS nmos W=0.155u L=0.04u
M14753 n1413 n1312 U1940/net23 VSS nmos W=0.155u L=0.04u
M14754 U1940/net23 CRC_OUT_2_3 VSS VSS nmos W=0.155u L=0.04u
M14755 U1940/net20 CRC_OUT_2_3 n1413 VDD pmos W=0.205u L=0.04u
M14756 U1940/net20 n1312 n1413 VDD pmos W=0.205u L=0.04u
M14757 VDD WX9592 U1940/net20 VDD pmos W=0.205u L=0.04u
M14758 VDD n1343 U1940/net20 VDD pmos W=0.205u L=0.04u
M14759 WX9467 n1243 U1941/net26 VSS nmos W=0.155u L=0.04u
M14760 WX9467 n1414 U1941/net26 VSS nmos W=0.155u L=0.04u
M14761 U1941/net29 n1416 VSS VSS nmos W=0.155u L=0.04u
M14762 U1941/net26 n1415 U1941/net29 VSS nmos W=0.155u L=0.04u
M14763 U1941/net26 n1287 U1941/net29 VSS nmos W=0.155u L=0.04u
M14764 WX9467 n1414 U1941/net43 VDD pmos W=0.205u L=0.04u
M14765 WX9467 n1287 U1941/net49 VDD pmos W=0.205u L=0.04u
M14766 U1941/net49 n1415 VDD VDD pmos W=0.205u L=0.04u
M14767 U1941/net43 n1243 VDD VDD pmos W=0.205u L=0.04u
M14768 WX9467 n1416 VDD VDD pmos W=0.205u L=0.04u
M14769 U1942/net29 n1343 VSS VSS nmos W=0.155u L=0.04u
M14770 n1416 WX9590 U1942/net29 VSS nmos W=0.155u L=0.04u
M14771 n1416 n1312 U1942/net23 VSS nmos W=0.155u L=0.04u
M14772 U1942/net23 CRC_OUT_2_4 VSS VSS nmos W=0.155u L=0.04u
M14773 U1942/net20 CRC_OUT_2_4 n1416 VDD pmos W=0.205u L=0.04u
M14774 U1942/net20 n1312 n1416 VDD pmos W=0.205u L=0.04u
M14775 VDD WX9590 U1942/net20 VDD pmos W=0.205u L=0.04u
M14776 VDD n1343 U1942/net20 VDD pmos W=0.205u L=0.04u
M14777 WX9453 n1243 U1943/net26 VSS nmos W=0.155u L=0.04u
M14778 WX9453 n1417 U1943/net26 VSS nmos W=0.155u L=0.04u
M14779 U1943/net29 n1419 VSS VSS nmos W=0.155u L=0.04u
M14780 U1943/net26 n1418 U1943/net29 VSS nmos W=0.155u L=0.04u
M14781 U1943/net26 n1287 U1943/net29 VSS nmos W=0.155u L=0.04u
M14782 WX9453 n1417 U1943/net43 VDD pmos W=0.205u L=0.04u
M14783 WX9453 n1287 U1943/net49 VDD pmos W=0.205u L=0.04u
M14784 U1943/net49 n1418 VDD VDD pmos W=0.205u L=0.04u
M14785 U1943/net43 n1243 VDD VDD pmos W=0.205u L=0.04u
M14786 WX9453 n1419 VDD VDD pmos W=0.205u L=0.04u
M14787 U1944/net29 n1343 VSS VSS nmos W=0.155u L=0.04u
M14788 n1419 WX9588 U1944/net29 VSS nmos W=0.155u L=0.04u
M14789 n1419 n1312 U1944/net23 VSS nmos W=0.155u L=0.04u
M14790 U1944/net23 CRC_OUT_2_5 VSS VSS nmos W=0.155u L=0.04u
M14791 U1944/net20 CRC_OUT_2_5 n1419 VDD pmos W=0.205u L=0.04u
M14792 U1944/net20 n1312 n1419 VDD pmos W=0.205u L=0.04u
M14793 VDD WX9588 U1944/net20 VDD pmos W=0.205u L=0.04u
M14794 VDD n1343 U1944/net20 VDD pmos W=0.205u L=0.04u
M14795 WX9439 n1243 U1945/net26 VSS nmos W=0.155u L=0.04u
M14796 WX9439 n1420 U1945/net26 VSS nmos W=0.155u L=0.04u
M14797 U1945/net29 n1422 VSS VSS nmos W=0.155u L=0.04u
M14798 U1945/net26 n1421 U1945/net29 VSS nmos W=0.155u L=0.04u
M14799 U1945/net26 n1287 U1945/net29 VSS nmos W=0.155u L=0.04u
M14800 WX9439 n1420 U1945/net43 VDD pmos W=0.205u L=0.04u
M14801 WX9439 n1287 U1945/net49 VDD pmos W=0.205u L=0.04u
M14802 U1945/net49 n1421 VDD VDD pmos W=0.205u L=0.04u
M14803 U1945/net43 n1243 VDD VDD pmos W=0.205u L=0.04u
M14804 WX9439 n1422 VDD VDD pmos W=0.205u L=0.04u
M14805 U1946/net29 n1343 VSS VSS nmos W=0.155u L=0.04u
M14806 n1422 WX9586 U1946/net29 VSS nmos W=0.155u L=0.04u
M14807 n1422 n1312 U1946/net23 VSS nmos W=0.155u L=0.04u
M14808 U1946/net23 CRC_OUT_2_6 VSS VSS nmos W=0.155u L=0.04u
M14809 U1946/net20 CRC_OUT_2_6 n1422 VDD pmos W=0.205u L=0.04u
M14810 U1946/net20 n1312 n1422 VDD pmos W=0.205u L=0.04u
M14811 VDD WX9586 U1946/net20 VDD pmos W=0.205u L=0.04u
M14812 VDD n1343 U1946/net20 VDD pmos W=0.205u L=0.04u
M14813 WX9425 n1243 U1947/net26 VSS nmos W=0.155u L=0.04u
M14814 WX9425 n1423 U1947/net26 VSS nmos W=0.155u L=0.04u
M14815 U1947/net29 n1425 VSS VSS nmos W=0.155u L=0.04u
M14816 U1947/net26 n1424 U1947/net29 VSS nmos W=0.155u L=0.04u
M14817 U1947/net26 n1289 U1947/net29 VSS nmos W=0.155u L=0.04u
M14818 WX9425 n1423 U1947/net43 VDD pmos W=0.205u L=0.04u
M14819 WX9425 n1289 U1947/net49 VDD pmos W=0.205u L=0.04u
M14820 U1947/net49 n1424 VDD VDD pmos W=0.205u L=0.04u
M14821 U1947/net43 n1243 VDD VDD pmos W=0.205u L=0.04u
M14822 WX9425 n1425 VDD VDD pmos W=0.205u L=0.04u
M14823 U1948/net29 n1343 VSS VSS nmos W=0.155u L=0.04u
M14824 n1425 WX9584 U1948/net29 VSS nmos W=0.155u L=0.04u
M14825 n1425 n1312 U1948/net23 VSS nmos W=0.155u L=0.04u
M14826 U1948/net23 CRC_OUT_2_7 VSS VSS nmos W=0.155u L=0.04u
M14827 U1948/net20 CRC_OUT_2_7 n1425 VDD pmos W=0.205u L=0.04u
M14828 U1948/net20 n1312 n1425 VDD pmos W=0.205u L=0.04u
M14829 VDD WX9584 U1948/net20 VDD pmos W=0.205u L=0.04u
M14830 VDD n1343 U1948/net20 VDD pmos W=0.205u L=0.04u
M14831 WX9411 n1242 U1949/net26 VSS nmos W=0.155u L=0.04u
M14832 WX9411 n1426 U1949/net26 VSS nmos W=0.155u L=0.04u
M14833 U1949/net29 n1428 VSS VSS nmos W=0.155u L=0.04u
M14834 U1949/net26 n1427 U1949/net29 VSS nmos W=0.155u L=0.04u
M14835 U1949/net26 n1287 U1949/net29 VSS nmos W=0.155u L=0.04u
M14836 WX9411 n1426 U1949/net43 VDD pmos W=0.205u L=0.04u
M14837 WX9411 n1287 U1949/net49 VDD pmos W=0.205u L=0.04u
M14838 U1949/net49 n1427 VDD VDD pmos W=0.205u L=0.04u
M14839 U1949/net43 n1242 VDD VDD pmos W=0.205u L=0.04u
M14840 WX9411 n1428 VDD VDD pmos W=0.205u L=0.04u
M14841 U1950/net29 n1342 VSS VSS nmos W=0.155u L=0.04u
M14842 n1428 WX9582 U1950/net29 VSS nmos W=0.155u L=0.04u
M14843 n1428 n1312 U1950/net23 VSS nmos W=0.155u L=0.04u
M14844 U1950/net23 CRC_OUT_2_8 VSS VSS nmos W=0.155u L=0.04u
M14845 U1950/net20 CRC_OUT_2_8 n1428 VDD pmos W=0.205u L=0.04u
M14846 U1950/net20 n1312 n1428 VDD pmos W=0.205u L=0.04u
M14847 VDD WX9582 U1950/net20 VDD pmos W=0.205u L=0.04u
M14848 VDD n1342 U1950/net20 VDD pmos W=0.205u L=0.04u
M14849 WX94 U1951/net31 VDD VDD pmos W=0.205u L=0.04u
M14850 U1951/net30 n1354 U1951/net31 VDD pmos W=0.205u L=0.04u
M14851 U1951/net30 WX493 U1951/net31 VDD pmos W=0.205u L=0.04u
M14852 VDD n1431 U1951/net36 VDD pmos W=0.205u L=0.04u
M14853 U1951/net36 n1430 U1951/net30 VDD pmos W=0.205u L=0.04u
M14854 U1951/net36 n1429 U1951/net30 VDD pmos W=0.205u L=0.04u
M14855 U1951/net31 n1431 VSS VSS nmos W=0.155u L=0.04u
M14856 WX94 U1951/net31 VSS VSS nmos W=0.155u L=0.04u
M14857 U1951/net31 n1429 U1951/XI17-net17 VSS nmos W=0.155u L=0.04u
M14858 U1951/XI17-net17 n1430 VSS VSS nmos W=0.155u L=0.04u
M14859 U1951/net31 n1354 U1951/XI1-net17 VSS nmos W=0.155u L=0.04u
M14860 U1951/XI1-net17 WX493 VSS VSS nmos W=0.155u L=0.04u
M14861 U1952/net8 n1303 U1952/net26 VSS nmos W=0.155u L=0.04u
M14862 U1952/net26 CRC_OUT_9_27 VSS VSS nmos W=0.155u L=0.04u
M14863 U1952/net29 U1952/net8 VSS VSS nmos W=0.155u L=0.04u
M14864 U1952/net29 n1291 n1431 VSS nmos W=0.155u L=0.04u
M14865 U1952/net29 n1432 n1431 VSS nmos W=0.155u L=0.04u
M14866 U1952/net8 CRC_OUT_9_27 VDD VDD pmos W=0.205u L=0.04u
M14867 U1952/net8 n1303 VDD VDD pmos W=0.205u L=0.04u
M14868 n1431 U1952/net8 VDD VDD pmos W=0.205u L=0.04u
M14869 n1431 n1291 U1952/net20 VDD pmos W=0.205u L=0.04u
M14870 U1952/net20 n1432 VDD VDD pmos W=0.205u L=0.04u
M14871 WX9397 n1241 U1953/net26 VSS nmos W=0.155u L=0.04u
M14872 WX9397 n1433 U1953/net26 VSS nmos W=0.155u L=0.04u
M14873 U1953/net29 n1435 VSS VSS nmos W=0.155u L=0.04u
M14874 U1953/net26 n1434 U1953/net29 VSS nmos W=0.155u L=0.04u
M14875 U1953/net26 n1287 U1953/net29 VSS nmos W=0.155u L=0.04u
M14876 WX9397 n1433 U1953/net43 VDD pmos W=0.205u L=0.04u
M14877 WX9397 n1287 U1953/net49 VDD pmos W=0.205u L=0.04u
M14878 U1953/net49 n1434 VDD VDD pmos W=0.205u L=0.04u
M14879 U1953/net43 n1241 VDD VDD pmos W=0.205u L=0.04u
M14880 WX9397 n1435 VDD VDD pmos W=0.205u L=0.04u
M14881 U1954/net29 n1342 VSS VSS nmos W=0.155u L=0.04u
M14882 n1435 WX9580 U1954/net29 VSS nmos W=0.155u L=0.04u
M14883 n1435 n1312 U1954/net23 VSS nmos W=0.155u L=0.04u
M14884 U1954/net23 CRC_OUT_2_9 VSS VSS nmos W=0.155u L=0.04u
M14885 U1954/net20 CRC_OUT_2_9 n1435 VDD pmos W=0.205u L=0.04u
M14886 U1954/net20 n1312 n1435 VDD pmos W=0.205u L=0.04u
M14887 VDD WX9580 U1954/net20 VDD pmos W=0.205u L=0.04u
M14888 VDD n1342 U1954/net20 VDD pmos W=0.205u L=0.04u
M14889 WX9383 n1241 U1955/net26 VSS nmos W=0.155u L=0.04u
M14890 WX9383 n1436 U1955/net26 VSS nmos W=0.155u L=0.04u
M14891 U1955/net29 n1438 VSS VSS nmos W=0.155u L=0.04u
M14892 U1955/net26 n1437 U1955/net29 VSS nmos W=0.155u L=0.04u
M14893 U1955/net26 n1287 U1955/net29 VSS nmos W=0.155u L=0.04u
M14894 WX9383 n1436 U1955/net43 VDD pmos W=0.205u L=0.04u
M14895 WX9383 n1287 U1955/net49 VDD pmos W=0.205u L=0.04u
M14896 U1955/net49 n1437 VDD VDD pmos W=0.205u L=0.04u
M14897 U1955/net43 n1241 VDD VDD pmos W=0.205u L=0.04u
M14898 WX9383 n1438 VDD VDD pmos W=0.205u L=0.04u
M14899 U1956/net29 n1342 VSS VSS nmos W=0.155u L=0.04u
M14900 n1438 WX9578 U1956/net29 VSS nmos W=0.155u L=0.04u
M14901 n1438 n1311 U1956/net23 VSS nmos W=0.155u L=0.04u
M14902 U1956/net23 CRC_OUT_2_10 VSS VSS nmos W=0.155u L=0.04u
M14903 U1956/net20 CRC_OUT_2_10 n1438 VDD pmos W=0.205u L=0.04u
M14904 U1956/net20 n1311 n1438 VDD pmos W=0.205u L=0.04u
M14905 VDD WX9578 U1956/net20 VDD pmos W=0.205u L=0.04u
M14906 VDD n1342 U1956/net20 VDD pmos W=0.205u L=0.04u
M14907 WX9369 n1241 U1957/net26 VSS nmos W=0.155u L=0.04u
M14908 WX9369 n1439 U1957/net26 VSS nmos W=0.155u L=0.04u
M14909 U1957/net29 n1441 VSS VSS nmos W=0.155u L=0.04u
M14910 U1957/net26 n1440 U1957/net29 VSS nmos W=0.155u L=0.04u
M14911 U1957/net26 n1288 U1957/net29 VSS nmos W=0.155u L=0.04u
M14912 WX9369 n1439 U1957/net43 VDD pmos W=0.205u L=0.04u
M14913 WX9369 n1288 U1957/net49 VDD pmos W=0.205u L=0.04u
M14914 U1957/net49 n1440 VDD VDD pmos W=0.205u L=0.04u
M14915 U1957/net43 n1241 VDD VDD pmos W=0.205u L=0.04u
M14916 WX9369 n1441 VDD VDD pmos W=0.205u L=0.04u
M14917 U1958/net29 n1342 VSS VSS nmos W=0.155u L=0.04u
M14918 n1441 WX9576 U1958/net29 VSS nmos W=0.155u L=0.04u
M14919 n1441 n1311 U1958/net23 VSS nmos W=0.155u L=0.04u
M14920 U1958/net23 CRC_OUT_2_11 VSS VSS nmos W=0.155u L=0.04u
M14921 U1958/net20 CRC_OUT_2_11 n1441 VDD pmos W=0.205u L=0.04u
M14922 U1958/net20 n1311 n1441 VDD pmos W=0.205u L=0.04u
M14923 VDD WX9576 U1958/net20 VDD pmos W=0.205u L=0.04u
M14924 VDD n1342 U1958/net20 VDD pmos W=0.205u L=0.04u
M14925 WX9355 n1241 U1959/net26 VSS nmos W=0.155u L=0.04u
M14926 WX9355 n1442 U1959/net26 VSS nmos W=0.155u L=0.04u
M14927 U1959/net29 n1444 VSS VSS nmos W=0.155u L=0.04u
M14928 U1959/net26 n1443 U1959/net29 VSS nmos W=0.155u L=0.04u
M14929 U1959/net26 n1288 U1959/net29 VSS nmos W=0.155u L=0.04u
M14930 WX9355 n1442 U1959/net43 VDD pmos W=0.205u L=0.04u
M14931 WX9355 n1288 U1959/net49 VDD pmos W=0.205u L=0.04u
M14932 U1959/net49 n1443 VDD VDD pmos W=0.205u L=0.04u
M14933 U1959/net43 n1241 VDD VDD pmos W=0.205u L=0.04u
M14934 WX9355 n1444 VDD VDD pmos W=0.205u L=0.04u
M14935 U1960/net29 n1342 VSS VSS nmos W=0.155u L=0.04u
M14936 n1444 WX9574 U1960/net29 VSS nmos W=0.155u L=0.04u
M14937 n1444 n1311 U1960/net23 VSS nmos W=0.155u L=0.04u
M14938 U1960/net23 CRC_OUT_2_12 VSS VSS nmos W=0.155u L=0.04u
M14939 U1960/net20 CRC_OUT_2_12 n1444 VDD pmos W=0.205u L=0.04u
M14940 U1960/net20 n1311 n1444 VDD pmos W=0.205u L=0.04u
M14941 VDD WX9574 U1960/net20 VDD pmos W=0.205u L=0.04u
M14942 VDD n1342 U1960/net20 VDD pmos W=0.205u L=0.04u
M14943 WX9341 n1241 U1961/net26 VSS nmos W=0.155u L=0.04u
M14944 WX9341 n1445 U1961/net26 VSS nmos W=0.155u L=0.04u
M14945 U1961/net29 n1447 VSS VSS nmos W=0.155u L=0.04u
M14946 U1961/net26 n1446 U1961/net29 VSS nmos W=0.155u L=0.04u
M14947 U1961/net26 n1287 U1961/net29 VSS nmos W=0.155u L=0.04u
M14948 WX9341 n1445 U1961/net43 VDD pmos W=0.205u L=0.04u
M14949 WX9341 n1287 U1961/net49 VDD pmos W=0.205u L=0.04u
M14950 U1961/net49 n1446 VDD VDD pmos W=0.205u L=0.04u
M14951 U1961/net43 n1241 VDD VDD pmos W=0.205u L=0.04u
M14952 WX9341 n1447 VDD VDD pmos W=0.205u L=0.04u
M14953 U1962/net29 n1342 VSS VSS nmos W=0.155u L=0.04u
M14954 n1447 WX9572 U1962/net29 VSS nmos W=0.155u L=0.04u
M14955 n1447 n1311 U1962/net23 VSS nmos W=0.155u L=0.04u
M14956 U1962/net23 CRC_OUT_2_13 VSS VSS nmos W=0.155u L=0.04u
M14957 U1962/net20 CRC_OUT_2_13 n1447 VDD pmos W=0.205u L=0.04u
M14958 U1962/net20 n1311 n1447 VDD pmos W=0.205u L=0.04u
M14959 VDD WX9572 U1962/net20 VDD pmos W=0.205u L=0.04u
M14960 VDD n1342 U1962/net20 VDD pmos W=0.205u L=0.04u
M14961 WX9327 n1241 U1963/net26 VSS nmos W=0.155u L=0.04u
M14962 WX9327 n1448 U1963/net26 VSS nmos W=0.155u L=0.04u
M14963 U1963/net29 n1450 VSS VSS nmos W=0.155u L=0.04u
M14964 U1963/net26 n1449 U1963/net29 VSS nmos W=0.155u L=0.04u
M14965 U1963/net26 n1288 U1963/net29 VSS nmos W=0.155u L=0.04u
M14966 WX9327 n1448 U1963/net43 VDD pmos W=0.205u L=0.04u
M14967 WX9327 n1288 U1963/net49 VDD pmos W=0.205u L=0.04u
M14968 U1963/net49 n1449 VDD VDD pmos W=0.205u L=0.04u
M14969 U1963/net43 n1241 VDD VDD pmos W=0.205u L=0.04u
M14970 WX9327 n1450 VDD VDD pmos W=0.205u L=0.04u
M14971 U1964/net29 n1342 VSS VSS nmos W=0.155u L=0.04u
M14972 n1450 WX9570 U1964/net29 VSS nmos W=0.155u L=0.04u
M14973 n1450 n1311 U1964/net23 VSS nmos W=0.155u L=0.04u
M14974 U1964/net23 CRC_OUT_2_14 VSS VSS nmos W=0.155u L=0.04u
M14975 U1964/net20 CRC_OUT_2_14 n1450 VDD pmos W=0.205u L=0.04u
M14976 U1964/net20 n1311 n1450 VDD pmos W=0.205u L=0.04u
M14977 VDD WX9570 U1964/net20 VDD pmos W=0.205u L=0.04u
M14978 VDD n1342 U1964/net20 VDD pmos W=0.205u L=0.04u
M14979 WX9313 n1241 U1965/net26 VSS nmos W=0.155u L=0.04u
M14980 WX9313 n1451 U1965/net26 VSS nmos W=0.155u L=0.04u
M14981 U1965/net29 n1453 VSS VSS nmos W=0.155u L=0.04u
M14982 U1965/net26 n1452 U1965/net29 VSS nmos W=0.155u L=0.04u
M14983 U1965/net26 n1288 U1965/net29 VSS nmos W=0.155u L=0.04u
M14984 WX9313 n1451 U1965/net43 VDD pmos W=0.205u L=0.04u
M14985 WX9313 n1288 U1965/net49 VDD pmos W=0.205u L=0.04u
M14986 U1965/net49 n1452 VDD VDD pmos W=0.205u L=0.04u
M14987 U1965/net43 n1241 VDD VDD pmos W=0.205u L=0.04u
M14988 WX9313 n1453 VDD VDD pmos W=0.205u L=0.04u
M14989 U1966/net29 n1342 VSS VSS nmos W=0.155u L=0.04u
M14990 n1453 WX9568 U1966/net29 VSS nmos W=0.155u L=0.04u
M14991 n1453 n1311 U1966/net23 VSS nmos W=0.155u L=0.04u
M14992 U1966/net23 CRC_OUT_2_15 VSS VSS nmos W=0.155u L=0.04u
M14993 U1966/net20 CRC_OUT_2_15 n1453 VDD pmos W=0.205u L=0.04u
M14994 U1966/net20 n1311 n1453 VDD pmos W=0.205u L=0.04u
M14995 VDD WX9568 U1966/net20 VDD pmos W=0.205u L=0.04u
M14996 VDD n1342 U1966/net20 VDD pmos W=0.205u L=0.04u
M14997 WX9299 n1241 U1967/net26 VSS nmos W=0.155u L=0.04u
M14998 WX9299 n1454 U1967/net26 VSS nmos W=0.155u L=0.04u
M14999 U1967/net29 n1456 VSS VSS nmos W=0.155u L=0.04u
M15000 U1967/net26 n1455 U1967/net29 VSS nmos W=0.155u L=0.04u
M15001 U1967/net26 n1288 U1967/net29 VSS nmos W=0.155u L=0.04u
M15002 WX9299 n1454 U1967/net43 VDD pmos W=0.205u L=0.04u
M15003 WX9299 n1288 U1967/net49 VDD pmos W=0.205u L=0.04u
M15004 U1967/net49 n1455 VDD VDD pmos W=0.205u L=0.04u
M15005 U1967/net43 n1241 VDD VDD pmos W=0.205u L=0.04u
M15006 WX9299 n1456 VDD VDD pmos W=0.205u L=0.04u
M15007 U1968/net29 n1342 VSS VSS nmos W=0.155u L=0.04u
M15008 n1456 WX9566 U1968/net29 VSS nmos W=0.155u L=0.04u
M15009 n1456 n1311 U1968/net23 VSS nmos W=0.155u L=0.04u
M15010 U1968/net23 CRC_OUT_2_16 VSS VSS nmos W=0.155u L=0.04u
M15011 U1968/net20 CRC_OUT_2_16 n1456 VDD pmos W=0.205u L=0.04u
M15012 U1968/net20 n1311 n1456 VDD pmos W=0.205u L=0.04u
M15013 VDD WX9566 U1968/net20 VDD pmos W=0.205u L=0.04u
M15014 VDD n1342 U1968/net20 VDD pmos W=0.205u L=0.04u
M15015 WX9285 n1241 U1969/net26 VSS nmos W=0.155u L=0.04u
M15016 WX9285 n1457 U1969/net26 VSS nmos W=0.155u L=0.04u
M15017 U1969/net29 n1459 VSS VSS nmos W=0.155u L=0.04u
M15018 U1969/net26 n1458 U1969/net29 VSS nmos W=0.155u L=0.04u
M15019 U1969/net26 n1288 U1969/net29 VSS nmos W=0.155u L=0.04u
M15020 WX9285 n1457 U1969/net43 VDD pmos W=0.205u L=0.04u
M15021 WX9285 n1288 U1969/net49 VDD pmos W=0.205u L=0.04u
M15022 U1969/net49 n1458 VDD VDD pmos W=0.205u L=0.04u
M15023 U1969/net43 n1241 VDD VDD pmos W=0.205u L=0.04u
M15024 WX9285 n1459 VDD VDD pmos W=0.205u L=0.04u
M15025 U1970/net29 n1342 VSS VSS nmos W=0.155u L=0.04u
M15026 n1459 WX9564 U1970/net29 VSS nmos W=0.155u L=0.04u
M15027 n1459 n1311 U1970/net23 VSS nmos W=0.155u L=0.04u
M15028 U1970/net23 CRC_OUT_2_17 VSS VSS nmos W=0.155u L=0.04u
M15029 U1970/net20 CRC_OUT_2_17 n1459 VDD pmos W=0.205u L=0.04u
M15030 U1970/net20 n1311 n1459 VDD pmos W=0.205u L=0.04u
M15031 VDD WX9564 U1970/net20 VDD pmos W=0.205u L=0.04u
M15032 VDD n1342 U1970/net20 VDD pmos W=0.205u L=0.04u
M15033 WX9271 n1241 U1971/net26 VSS nmos W=0.155u L=0.04u
M15034 WX9271 n1460 U1971/net26 VSS nmos W=0.155u L=0.04u
M15035 U1971/net29 n1462 VSS VSS nmos W=0.155u L=0.04u
M15036 U1971/net26 n1461 U1971/net29 VSS nmos W=0.155u L=0.04u
M15037 U1971/net26 n1288 U1971/net29 VSS nmos W=0.155u L=0.04u
M15038 WX9271 n1460 U1971/net43 VDD pmos W=0.205u L=0.04u
M15039 WX9271 n1288 U1971/net49 VDD pmos W=0.205u L=0.04u
M15040 U1971/net49 n1461 VDD VDD pmos W=0.205u L=0.04u
M15041 U1971/net43 n1241 VDD VDD pmos W=0.205u L=0.04u
M15042 WX9271 n1462 VDD VDD pmos W=0.205u L=0.04u
M15043 U1972/net29 n1342 VSS VSS nmos W=0.155u L=0.04u
M15044 n1462 WX9562 U1972/net29 VSS nmos W=0.155u L=0.04u
M15045 n1462 n1311 U1972/net23 VSS nmos W=0.155u L=0.04u
M15046 U1972/net23 CRC_OUT_2_18 VSS VSS nmos W=0.155u L=0.04u
M15047 U1972/net20 CRC_OUT_2_18 n1462 VDD pmos W=0.205u L=0.04u
M15048 U1972/net20 n1311 n1462 VDD pmos W=0.205u L=0.04u
M15049 VDD WX9562 U1972/net20 VDD pmos W=0.205u L=0.04u
M15050 VDD n1342 U1972/net20 VDD pmos W=0.205u L=0.04u
M15051 WX9257 n1240 U1973/net26 VSS nmos W=0.155u L=0.04u
M15052 WX9257 n1463 U1973/net26 VSS nmos W=0.155u L=0.04u
M15053 U1973/net29 n1465 VSS VSS nmos W=0.155u L=0.04u
M15054 U1973/net26 n1464 U1973/net29 VSS nmos W=0.155u L=0.04u
M15055 U1973/net26 n1288 U1973/net29 VSS nmos W=0.155u L=0.04u
M15056 WX9257 n1463 U1973/net43 VDD pmos W=0.205u L=0.04u
M15057 WX9257 n1288 U1973/net49 VDD pmos W=0.205u L=0.04u
M15058 U1973/net49 n1464 VDD VDD pmos W=0.205u L=0.04u
M15059 U1973/net43 n1240 VDD VDD pmos W=0.205u L=0.04u
M15060 WX9257 n1465 VDD VDD pmos W=0.205u L=0.04u
M15061 U1974/net29 n1342 VSS VSS nmos W=0.155u L=0.04u
M15062 n1465 WX9560 U1974/net29 VSS nmos W=0.155u L=0.04u
M15063 n1465 n1311 U1974/net23 VSS nmos W=0.155u L=0.04u
M15064 U1974/net23 CRC_OUT_2_19 VSS VSS nmos W=0.155u L=0.04u
M15065 U1974/net20 CRC_OUT_2_19 n1465 VDD pmos W=0.205u L=0.04u
M15066 U1974/net20 n1311 n1465 VDD pmos W=0.205u L=0.04u
M15067 VDD WX9560 U1974/net20 VDD pmos W=0.205u L=0.04u
M15068 VDD n1342 U1974/net20 VDD pmos W=0.205u L=0.04u
M15069 WX9243 n1240 U1975/net26 VSS nmos W=0.155u L=0.04u
M15070 WX9243 n1466 U1975/net26 VSS nmos W=0.155u L=0.04u
M15071 U1975/net29 n1468 VSS VSS nmos W=0.155u L=0.04u
M15072 U1975/net26 n1467 U1975/net29 VSS nmos W=0.155u L=0.04u
M15073 U1975/net26 n1288 U1975/net29 VSS nmos W=0.155u L=0.04u
M15074 WX9243 n1466 U1975/net43 VDD pmos W=0.205u L=0.04u
M15075 WX9243 n1288 U1975/net49 VDD pmos W=0.205u L=0.04u
M15076 U1975/net49 n1467 VDD VDD pmos W=0.205u L=0.04u
M15077 U1975/net43 n1240 VDD VDD pmos W=0.205u L=0.04u
M15078 WX9243 n1468 VDD VDD pmos W=0.205u L=0.04u
M15079 U1976/net29 n1342 VSS VSS nmos W=0.155u L=0.04u
M15080 n1468 WX9558 U1976/net29 VSS nmos W=0.155u L=0.04u
M15081 n1468 n1311 U1976/net23 VSS nmos W=0.155u L=0.04u
M15082 U1976/net23 CRC_OUT_2_20 VSS VSS nmos W=0.155u L=0.04u
M15083 U1976/net20 CRC_OUT_2_20 n1468 VDD pmos W=0.205u L=0.04u
M15084 U1976/net20 n1311 n1468 VDD pmos W=0.205u L=0.04u
M15085 VDD WX9558 U1976/net20 VDD pmos W=0.205u L=0.04u
M15086 VDD n1342 U1976/net20 VDD pmos W=0.205u L=0.04u
M15087 WX9229 n1240 U1977/net26 VSS nmos W=0.155u L=0.04u
M15088 WX9229 n1469 U1977/net26 VSS nmos W=0.155u L=0.04u
M15089 U1977/net29 n1471 VSS VSS nmos W=0.155u L=0.04u
M15090 U1977/net26 n1470 U1977/net29 VSS nmos W=0.155u L=0.04u
M15091 U1977/net26 n1289 U1977/net29 VSS nmos W=0.155u L=0.04u
M15092 WX9229 n1469 U1977/net43 VDD pmos W=0.205u L=0.04u
M15093 WX9229 n1289 U1977/net49 VDD pmos W=0.205u L=0.04u
M15094 U1977/net49 n1470 VDD VDD pmos W=0.205u L=0.04u
M15095 U1977/net43 n1240 VDD VDD pmos W=0.205u L=0.04u
M15096 WX9229 n1471 VDD VDD pmos W=0.205u L=0.04u
M15097 U1978/net29 n1341 VSS VSS nmos W=0.155u L=0.04u
M15098 n1471 WX9556 U1978/net29 VSS nmos W=0.155u L=0.04u
M15099 n1471 n1311 U1978/net23 VSS nmos W=0.155u L=0.04u
M15100 U1978/net23 CRC_OUT_2_21 VSS VSS nmos W=0.155u L=0.04u
M15101 U1978/net20 CRC_OUT_2_21 n1471 VDD pmos W=0.205u L=0.04u
M15102 U1978/net20 n1311 n1471 VDD pmos W=0.205u L=0.04u
M15103 VDD WX9556 U1978/net20 VDD pmos W=0.205u L=0.04u
M15104 VDD n1341 U1978/net20 VDD pmos W=0.205u L=0.04u
M15105 WX9215 n1240 U1979/net26 VSS nmos W=0.155u L=0.04u
M15106 WX9215 n1472 U1979/net26 VSS nmos W=0.155u L=0.04u
M15107 U1979/net29 n1474 VSS VSS nmos W=0.155u L=0.04u
M15108 U1979/net26 n1473 U1979/net29 VSS nmos W=0.155u L=0.04u
M15109 U1979/net26 n1288 U1979/net29 VSS nmos W=0.155u L=0.04u
M15110 WX9215 n1472 U1979/net43 VDD pmos W=0.205u L=0.04u
M15111 WX9215 n1288 U1979/net49 VDD pmos W=0.205u L=0.04u
M15112 U1979/net49 n1473 VDD VDD pmos W=0.205u L=0.04u
M15113 U1979/net43 n1240 VDD VDD pmos W=0.205u L=0.04u
M15114 WX9215 n1474 VDD VDD pmos W=0.205u L=0.04u
M15115 U1980/net29 n1341 VSS VSS nmos W=0.155u L=0.04u
M15116 n1474 WX9554 U1980/net29 VSS nmos W=0.155u L=0.04u
M15117 n1474 n1311 U1980/net23 VSS nmos W=0.155u L=0.04u
M15118 U1980/net23 CRC_OUT_2_22 VSS VSS nmos W=0.155u L=0.04u
M15119 U1980/net20 CRC_OUT_2_22 n1474 VDD pmos W=0.205u L=0.04u
M15120 U1980/net20 n1311 n1474 VDD pmos W=0.205u L=0.04u
M15121 VDD WX9554 U1980/net20 VDD pmos W=0.205u L=0.04u
M15122 VDD n1341 U1980/net20 VDD pmos W=0.205u L=0.04u
M15123 WX9201 n1240 U1981/net26 VSS nmos W=0.155u L=0.04u
M15124 WX9201 n1475 U1981/net26 VSS nmos W=0.155u L=0.04u
M15125 U1981/net29 n1477 VSS VSS nmos W=0.155u L=0.04u
M15126 U1981/net26 n1476 U1981/net29 VSS nmos W=0.155u L=0.04u
M15127 U1981/net26 n1289 U1981/net29 VSS nmos W=0.155u L=0.04u
M15128 WX9201 n1475 U1981/net43 VDD pmos W=0.205u L=0.04u
M15129 WX9201 n1289 U1981/net49 VDD pmos W=0.205u L=0.04u
M15130 U1981/net49 n1476 VDD VDD pmos W=0.205u L=0.04u
M15131 U1981/net43 n1240 VDD VDD pmos W=0.205u L=0.04u
M15132 WX9201 n1477 VDD VDD pmos W=0.205u L=0.04u
M15133 U1982/net29 n1341 VSS VSS nmos W=0.155u L=0.04u
M15134 n1477 WX9552 U1982/net29 VSS nmos W=0.155u L=0.04u
M15135 n1477 n1310 U1982/net23 VSS nmos W=0.155u L=0.04u
M15136 U1982/net23 CRC_OUT_2_23 VSS VSS nmos W=0.155u L=0.04u
M15137 U1982/net20 CRC_OUT_2_23 n1477 VDD pmos W=0.205u L=0.04u
M15138 U1982/net20 n1310 n1477 VDD pmos W=0.205u L=0.04u
M15139 VDD WX9552 U1982/net20 VDD pmos W=0.205u L=0.04u
M15140 VDD n1341 U1982/net20 VDD pmos W=0.205u L=0.04u
M15141 WX9187 n1240 U1983/net26 VSS nmos W=0.155u L=0.04u
M15142 WX9187 n1478 U1983/net26 VSS nmos W=0.155u L=0.04u
M15143 U1983/net29 n1480 VSS VSS nmos W=0.155u L=0.04u
M15144 U1983/net26 n1479 U1983/net29 VSS nmos W=0.155u L=0.04u
M15145 U1983/net26 n1288 U1983/net29 VSS nmos W=0.155u L=0.04u
M15146 WX9187 n1478 U1983/net43 VDD pmos W=0.205u L=0.04u
M15147 WX9187 n1288 U1983/net49 VDD pmos W=0.205u L=0.04u
M15148 U1983/net49 n1479 VDD VDD pmos W=0.205u L=0.04u
M15149 U1983/net43 n1240 VDD VDD pmos W=0.205u L=0.04u
M15150 WX9187 n1480 VDD VDD pmos W=0.205u L=0.04u
M15151 U1984/net29 n1341 VSS VSS nmos W=0.155u L=0.04u
M15152 n1480 WX9550 U1984/net29 VSS nmos W=0.155u L=0.04u
M15153 n1480 n1310 U1984/net23 VSS nmos W=0.155u L=0.04u
M15154 U1984/net23 CRC_OUT_2_24 VSS VSS nmos W=0.155u L=0.04u
M15155 U1984/net20 CRC_OUT_2_24 n1480 VDD pmos W=0.205u L=0.04u
M15156 U1984/net20 n1310 n1480 VDD pmos W=0.205u L=0.04u
M15157 VDD WX9550 U1984/net20 VDD pmos W=0.205u L=0.04u
M15158 VDD n1341 U1984/net20 VDD pmos W=0.205u L=0.04u
M15159 WX9173 n1240 U1985/net26 VSS nmos W=0.155u L=0.04u
M15160 WX9173 n1481 U1985/net26 VSS nmos W=0.155u L=0.04u
M15161 U1985/net29 n1483 VSS VSS nmos W=0.155u L=0.04u
M15162 U1985/net26 n1482 U1985/net29 VSS nmos W=0.155u L=0.04u
M15163 U1985/net26 n1289 U1985/net29 VSS nmos W=0.155u L=0.04u
M15164 WX9173 n1481 U1985/net43 VDD pmos W=0.205u L=0.04u
M15165 WX9173 n1289 U1985/net49 VDD pmos W=0.205u L=0.04u
M15166 U1985/net49 n1482 VDD VDD pmos W=0.205u L=0.04u
M15167 U1985/net43 n1240 VDD VDD pmos W=0.205u L=0.04u
M15168 WX9173 n1483 VDD VDD pmos W=0.205u L=0.04u
M15169 U1986/net29 n1341 VSS VSS nmos W=0.155u L=0.04u
M15170 n1483 WX9548 U1986/net29 VSS nmos W=0.155u L=0.04u
M15171 n1483 n1310 U1986/net23 VSS nmos W=0.155u L=0.04u
M15172 U1986/net23 CRC_OUT_2_25 VSS VSS nmos W=0.155u L=0.04u
M15173 U1986/net20 CRC_OUT_2_25 n1483 VDD pmos W=0.205u L=0.04u
M15174 U1986/net20 n1310 n1483 VDD pmos W=0.205u L=0.04u
M15175 VDD WX9548 U1986/net20 VDD pmos W=0.205u L=0.04u
M15176 VDD n1341 U1986/net20 VDD pmos W=0.205u L=0.04u
M15177 WX9159 n1240 U1987/net26 VSS nmos W=0.155u L=0.04u
M15178 WX9159 n1484 U1987/net26 VSS nmos W=0.155u L=0.04u
M15179 U1987/net29 n1486 VSS VSS nmos W=0.155u L=0.04u
M15180 U1987/net26 n1485 U1987/net29 VSS nmos W=0.155u L=0.04u
M15181 U1987/net26 n1288 U1987/net29 VSS nmos W=0.155u L=0.04u
M15182 WX9159 n1484 U1987/net43 VDD pmos W=0.205u L=0.04u
M15183 WX9159 n1288 U1987/net49 VDD pmos W=0.205u L=0.04u
M15184 U1987/net49 n1485 VDD VDD pmos W=0.205u L=0.04u
M15185 U1987/net43 n1240 VDD VDD pmos W=0.205u L=0.04u
M15186 WX9159 n1486 VDD VDD pmos W=0.205u L=0.04u
M15187 U1988/net29 n1341 VSS VSS nmos W=0.155u L=0.04u
M15188 n1486 WX9546 U1988/net29 VSS nmos W=0.155u L=0.04u
M15189 n1486 n1310 U1988/net23 VSS nmos W=0.155u L=0.04u
M15190 U1988/net23 CRC_OUT_2_26 VSS VSS nmos W=0.155u L=0.04u
M15191 U1988/net20 CRC_OUT_2_26 n1486 VDD pmos W=0.205u L=0.04u
M15192 U1988/net20 n1310 n1486 VDD pmos W=0.205u L=0.04u
M15193 VDD WX9546 U1988/net20 VDD pmos W=0.205u L=0.04u
M15194 VDD n1341 U1988/net20 VDD pmos W=0.205u L=0.04u
M15195 WX9145 n1240 U1989/net26 VSS nmos W=0.155u L=0.04u
M15196 WX9145 n1487 U1989/net26 VSS nmos W=0.155u L=0.04u
M15197 U1989/net29 n1489 VSS VSS nmos W=0.155u L=0.04u
M15198 U1989/net26 n1488 U1989/net29 VSS nmos W=0.155u L=0.04u
M15199 U1989/net26 n1289 U1989/net29 VSS nmos W=0.155u L=0.04u
M15200 WX9145 n1487 U1989/net43 VDD pmos W=0.205u L=0.04u
M15201 WX9145 n1289 U1989/net49 VDD pmos W=0.205u L=0.04u
M15202 U1989/net49 n1488 VDD VDD pmos W=0.205u L=0.04u
M15203 U1989/net43 n1240 VDD VDD pmos W=0.205u L=0.04u
M15204 WX9145 n1489 VDD VDD pmos W=0.205u L=0.04u
M15205 U1990/net29 n1341 VSS VSS nmos W=0.155u L=0.04u
M15206 n1489 WX9544 U1990/net29 VSS nmos W=0.155u L=0.04u
M15207 n1489 n1310 U1990/net23 VSS nmos W=0.155u L=0.04u
M15208 U1990/net23 CRC_OUT_2_27 VSS VSS nmos W=0.155u L=0.04u
M15209 U1990/net20 CRC_OUT_2_27 n1489 VDD pmos W=0.205u L=0.04u
M15210 U1990/net20 n1310 n1489 VDD pmos W=0.205u L=0.04u
M15211 VDD WX9544 U1990/net20 VDD pmos W=0.205u L=0.04u
M15212 VDD n1341 U1990/net20 VDD pmos W=0.205u L=0.04u
M15213 WX9131 n1240 U1991/net26 VSS nmos W=0.155u L=0.04u
M15214 WX9131 n1490 U1991/net26 VSS nmos W=0.155u L=0.04u
M15215 U1991/net29 n1492 VSS VSS nmos W=0.155u L=0.04u
M15216 U1991/net26 n1491 U1991/net29 VSS nmos W=0.155u L=0.04u
M15217 U1991/net26 n1289 U1991/net29 VSS nmos W=0.155u L=0.04u
M15218 WX9131 n1490 U1991/net43 VDD pmos W=0.205u L=0.04u
M15219 WX9131 n1289 U1991/net49 VDD pmos W=0.205u L=0.04u
M15220 U1991/net49 n1491 VDD VDD pmos W=0.205u L=0.04u
M15221 U1991/net43 n1240 VDD VDD pmos W=0.205u L=0.04u
M15222 WX9131 n1492 VDD VDD pmos W=0.205u L=0.04u
M15223 U1992/net29 n1341 VSS VSS nmos W=0.155u L=0.04u
M15224 n1492 WX9542 U1992/net29 VSS nmos W=0.155u L=0.04u
M15225 n1492 n1310 U1992/net23 VSS nmos W=0.155u L=0.04u
M15226 U1992/net23 CRC_OUT_2_28 VSS VSS nmos W=0.155u L=0.04u
M15227 U1992/net20 CRC_OUT_2_28 n1492 VDD pmos W=0.205u L=0.04u
M15228 U1992/net20 n1310 n1492 VDD pmos W=0.205u L=0.04u
M15229 VDD WX9542 U1992/net20 VDD pmos W=0.205u L=0.04u
M15230 VDD n1341 U1992/net20 VDD pmos W=0.205u L=0.04u
M15231 WX9117 n1240 U1993/net26 VSS nmos W=0.155u L=0.04u
M15232 WX9117 n1493 U1993/net26 VSS nmos W=0.155u L=0.04u
M15233 U1993/net29 n1495 VSS VSS nmos W=0.155u L=0.04u
M15234 U1993/net26 n1494 U1993/net29 VSS nmos W=0.155u L=0.04u
M15235 U1993/net26 n1289 U1993/net29 VSS nmos W=0.155u L=0.04u
M15236 WX9117 n1493 U1993/net43 VDD pmos W=0.205u L=0.04u
M15237 WX9117 n1289 U1993/net49 VDD pmos W=0.205u L=0.04u
M15238 U1993/net49 n1494 VDD VDD pmos W=0.205u L=0.04u
M15239 U1993/net43 n1240 VDD VDD pmos W=0.205u L=0.04u
M15240 WX9117 n1495 VDD VDD pmos W=0.205u L=0.04u
M15241 U1994/net29 n1341 VSS VSS nmos W=0.155u L=0.04u
M15242 n1495 WX9540 U1994/net29 VSS nmos W=0.155u L=0.04u
M15243 n1495 n1310 U1994/net23 VSS nmos W=0.155u L=0.04u
M15244 U1994/net23 CRC_OUT_2_29 VSS VSS nmos W=0.155u L=0.04u
M15245 U1994/net20 CRC_OUT_2_29 n1495 VDD pmos W=0.205u L=0.04u
M15246 U1994/net20 n1310 n1495 VDD pmos W=0.205u L=0.04u
M15247 VDD WX9540 U1994/net20 VDD pmos W=0.205u L=0.04u
M15248 VDD n1341 U1994/net20 VDD pmos W=0.205u L=0.04u
M15249 WX9103 n1240 U1995/net26 VSS nmos W=0.155u L=0.04u
M15250 WX9103 n1496 U1995/net26 VSS nmos W=0.155u L=0.04u
M15251 U1995/net29 n1498 VSS VSS nmos W=0.155u L=0.04u
M15252 U1995/net26 n1497 U1995/net29 VSS nmos W=0.155u L=0.04u
M15253 U1995/net26 n1289 U1995/net29 VSS nmos W=0.155u L=0.04u
M15254 WX9103 n1496 U1995/net43 VDD pmos W=0.205u L=0.04u
M15255 WX9103 n1289 U1995/net49 VDD pmos W=0.205u L=0.04u
M15256 U1995/net49 n1497 VDD VDD pmos W=0.205u L=0.04u
M15257 U1995/net43 n1240 VDD VDD pmos W=0.205u L=0.04u
M15258 WX9103 n1498 VDD VDD pmos W=0.205u L=0.04u
M15259 U1996/net29 n1341 VSS VSS nmos W=0.155u L=0.04u
M15260 n1498 WX9538 U1996/net29 VSS nmos W=0.155u L=0.04u
M15261 n1498 n1310 U1996/net23 VSS nmos W=0.155u L=0.04u
M15262 U1996/net23 CRC_OUT_2_30 VSS VSS nmos W=0.155u L=0.04u
M15263 U1996/net20 CRC_OUT_2_30 n1498 VDD pmos W=0.205u L=0.04u
M15264 U1996/net20 n1310 n1498 VDD pmos W=0.205u L=0.04u
M15265 VDD WX9538 U1996/net20 VDD pmos W=0.205u L=0.04u
M15266 VDD n1341 U1996/net20 VDD pmos W=0.205u L=0.04u
M15267 WX9089 n1273 U1997/net26 VSS nmos W=0.155u L=0.04u
M15268 WX9089 n1499 U1997/net26 VSS nmos W=0.155u L=0.04u
M15269 U1997/net29 n1501 VSS VSS nmos W=0.155u L=0.04u
M15270 U1997/net26 WX9534 U1997/net29 VSS nmos W=0.155u L=0.04u
M15271 U1997/net26 n1500 U1997/net29 VSS nmos W=0.155u L=0.04u
M15272 WX9089 n1499 U1997/net43 VDD pmos W=0.205u L=0.04u
M15273 WX9089 n1500 U1997/net49 VDD pmos W=0.205u L=0.04u
M15274 U1997/net49 WX9534 VDD VDD pmos W=0.205u L=0.04u
M15275 U1997/net43 n1273 VDD VDD pmos W=0.205u L=0.04u
M15276 WX9089 n1501 VDD VDD pmos W=0.205u L=0.04u
M15277 U1998/net29 CRC_OUT_2_31 VSS VSS nmos W=0.155u L=0.04u
M15278 n1501 n1303 U1998/net29 VSS nmos W=0.155u L=0.04u
M15279 n1501 n1430 U1998/net23 VSS nmos W=0.155u L=0.04u
M15280 U1998/net23 n1502 VSS VSS nmos W=0.155u L=0.04u
M15281 U1998/net20 n1502 n1501 VDD pmos W=0.205u L=0.04u
M15282 U1998/net20 n1430 n1501 VDD pmos W=0.205u L=0.04u
M15283 VDD n1303 U1998/net20 VDD pmos W=0.205u L=0.04u
M15284 VDD CRC_OUT_2_31 U1998/net20 VDD pmos W=0.205u L=0.04u
M15285 WX9534 WX9536 VSS VSS nmos W=0.135u L=0.04u
M15286 WX9534 WX9536 VDD VDD pmos W=0.205u L=0.04u
M15287 WX8230 n1281 U2000/net26 VSS nmos W=0.155u L=0.04u
M15288 WX8230 n1398 U2000/net26 VSS nmos W=0.155u L=0.04u
M15289 U2000/net29 n1504 VSS VSS nmos W=0.155u L=0.04u
M15290 U2000/net26 n1503 U2000/net29 VSS nmos W=0.155u L=0.04u
M15291 U2000/net26 n1252 U2000/net29 VSS nmos W=0.155u L=0.04u
M15292 WX8230 n1398 U2000/net43 VDD pmos W=0.205u L=0.04u
M15293 WX8230 n1252 U2000/net49 VDD pmos W=0.205u L=0.04u
M15294 U2000/net49 n1503 VDD VDD pmos W=0.205u L=0.04u
M15295 U2000/net43 n1281 VDD VDD pmos W=0.205u L=0.04u
M15296 WX8230 n1504 VDD VDD pmos W=0.205u L=0.04u
M15297 U2001/net29 n1341 VSS VSS nmos W=0.155u L=0.04u
M15298 n1504 WX8305 U2001/net29 VSS nmos W=0.155u L=0.04u
M15299 n1504 n1310 U2001/net23 VSS nmos W=0.155u L=0.04u
M15300 U2001/net23 CRC_OUT_3_0 VSS VSS nmos W=0.155u L=0.04u
M15301 U2001/net20 CRC_OUT_3_0 n1504 VDD pmos W=0.205u L=0.04u
M15302 U2001/net20 n1310 n1504 VDD pmos W=0.205u L=0.04u
M15303 VDD WX8305 U2001/net20 VDD pmos W=0.205u L=0.04u
M15304 VDD n1341 U2001/net20 VDD pmos W=0.205u L=0.04u
M15305 n1398 n1505 VSS VSS nmos W=0.135u L=0.04u
M15306 n1398 n1505 VDD VDD pmos W=0.205u L=0.04u
M15307 U2003/net28 U2003/net20 U2003/net64 VSS nmos W=0.155u L=0.04u
M15308 U2003/net24 U2003/net30 U2003/net32 VSS nmos W=0.155u L=0.04u
M15309 U2003/net28 U2003/net40 U2003/net24 VSS nmos W=0.155u L=0.04u
M15310 U2003/net40 WX9886 U2003/net108 VSS nmos W=0.155u L=0.04u
M15311 U2003/net40 U2003/net106 U2003/net104 VSS nmos W=0.155u L=0.04u
M15312 U2003/net24 WX9822 U2003/net050 VSS nmos W=0.155u L=0.04u
M15313 U2003/net050 U2003/net32 VSS VSS nmos W=0.155u L=0.04u
M15314 U2003/net20 U2003/net40 VSS VSS nmos W=0.155u L=0.04u
M15315 U2003/net106 WX9886 VSS VSS nmos W=0.155u L=0.04u
M15316 U2003/net104 WX9950 VSS VSS nmos W=0.155u L=0.04u
M15317 U2003/net30 WX9822 VSS VSS nmos W=0.155u L=0.04u
M15318 U2003/net108 U2003/net104 VSS VSS nmos W=0.155u L=0.04u
M15319 n1505 U2003/net28 VSS VSS nmos W=0.155u L=0.04u
M15320 U2003/net32 WX9758 VSS VSS nmos W=0.155u L=0.04u
M15321 U2003/net64 U2003/net24 VSS VSS nmos W=0.2u L=0.04u
M15322 U2003/net28 U2003/net40 U2003/net64 VDD pmos W=0.205u L=0.04u
M15323 U2003/net24 WX9822 U2003/net32 VDD pmos W=0.205u L=0.04u
M15324 U2003/net28 U2003/net20 U2003/net24 VDD pmos W=0.205u L=0.04u
M15325 U2003/net40 U2003/net106 U2003/net108 VDD pmos W=0.205u L=0.04u
M15326 U2003/net40 WX9886 U2003/net104 VDD pmos W=0.205u L=0.04u
M15327 U2003/net20 U2003/net40 VDD VDD pmos W=0.205u L=0.04u
M15328 U2003/net106 WX9886 VDD VDD pmos W=0.205u L=0.04u
M15329 U2003/net104 WX9950 VDD VDD pmos W=0.205u L=0.04u
M15330 U2003/net30 WX9822 VDD VDD pmos W=0.205u L=0.04u
M15331 U2003/net108 U2003/net104 VDD VDD pmos W=0.205u L=0.04u
M15332 n1505 U2003/net28 VDD VDD pmos W=0.205u L=0.04u
M15333 U2003/net32 WX9758 VDD VDD pmos W=0.205u L=0.04u
M15334 U2003/net64 U2003/net24 VDD VDD pmos W=0.28u L=0.04u
M15335 U2003/net24 U2003/net30 U2003/net045 VDD pmos W=0.205u L=0.04u
M15336 U2003/net045 U2003/net32 VDD VDD pmos W=0.205u L=0.04u
M15337 WX8216 n1281 U2004/net26 VSS nmos W=0.155u L=0.04u
M15338 WX8216 n1405 U2004/net26 VSS nmos W=0.155u L=0.04u
M15339 U2004/net29 n1507 VSS VSS nmos W=0.155u L=0.04u
M15340 U2004/net26 n1506 U2004/net29 VSS nmos W=0.155u L=0.04u
M15341 U2004/net26 n1252 U2004/net29 VSS nmos W=0.155u L=0.04u
M15342 WX8216 n1405 U2004/net43 VDD pmos W=0.205u L=0.04u
M15343 WX8216 n1252 U2004/net49 VDD pmos W=0.205u L=0.04u
M15344 U2004/net49 n1506 VDD VDD pmos W=0.205u L=0.04u
M15345 U2004/net43 n1281 VDD VDD pmos W=0.205u L=0.04u
M15346 WX8216 n1507 VDD VDD pmos W=0.205u L=0.04u
M15347 U2005/net29 n1341 VSS VSS nmos W=0.155u L=0.04u
M15348 n1507 WX8303 U2005/net29 VSS nmos W=0.155u L=0.04u
M15349 n1507 n1310 U2005/net23 VSS nmos W=0.155u L=0.04u
M15350 U2005/net23 CRC_OUT_3_1 VSS VSS nmos W=0.155u L=0.04u
M15351 U2005/net20 CRC_OUT_3_1 n1507 VDD pmos W=0.205u L=0.04u
M15352 U2005/net20 n1310 n1507 VDD pmos W=0.205u L=0.04u
M15353 VDD WX8303 U2005/net20 VDD pmos W=0.205u L=0.04u
M15354 VDD n1341 U2005/net20 VDD pmos W=0.205u L=0.04u
M15355 n1405 n1508 VSS VSS nmos W=0.135u L=0.04u
M15356 n1405 n1508 VDD VDD pmos W=0.205u L=0.04u
M15357 U2007/net28 U2007/net20 U2007/net64 VSS nmos W=0.155u L=0.04u
M15358 U2007/net24 U2007/net30 U2007/net32 VSS nmos W=0.155u L=0.04u
M15359 U2007/net28 U2007/net40 U2007/net24 VSS nmos W=0.155u L=0.04u
M15360 U2007/net40 WX9884 U2007/net108 VSS nmos W=0.155u L=0.04u
M15361 U2007/net40 U2007/net106 U2007/net104 VSS nmos W=0.155u L=0.04u
M15362 U2007/net24 WX9820 U2007/net050 VSS nmos W=0.155u L=0.04u
M15363 U2007/net050 U2007/net32 VSS VSS nmos W=0.155u L=0.04u
M15364 U2007/net20 U2007/net40 VSS VSS nmos W=0.155u L=0.04u
M15365 U2007/net106 WX9884 VSS VSS nmos W=0.155u L=0.04u
M15366 U2007/net104 WX9948 VSS VSS nmos W=0.155u L=0.04u
M15367 U2007/net30 WX9820 VSS VSS nmos W=0.155u L=0.04u
M15368 U2007/net108 U2007/net104 VSS VSS nmos W=0.155u L=0.04u
M15369 n1508 U2007/net28 VSS VSS nmos W=0.155u L=0.04u
M15370 U2007/net32 WX9756 VSS VSS nmos W=0.155u L=0.04u
M15371 U2007/net64 U2007/net24 VSS VSS nmos W=0.2u L=0.04u
M15372 U2007/net28 U2007/net40 U2007/net64 VDD pmos W=0.205u L=0.04u
M15373 U2007/net24 WX9820 U2007/net32 VDD pmos W=0.205u L=0.04u
M15374 U2007/net28 U2007/net20 U2007/net24 VDD pmos W=0.205u L=0.04u
M15375 U2007/net40 U2007/net106 U2007/net108 VDD pmos W=0.205u L=0.04u
M15376 U2007/net40 WX9884 U2007/net104 VDD pmos W=0.205u L=0.04u
M15377 U2007/net20 U2007/net40 VDD VDD pmos W=0.205u L=0.04u
M15378 U2007/net106 WX9884 VDD VDD pmos W=0.205u L=0.04u
M15379 U2007/net104 WX9948 VDD VDD pmos W=0.205u L=0.04u
M15380 U2007/net30 WX9820 VDD VDD pmos W=0.205u L=0.04u
M15381 U2007/net108 U2007/net104 VDD VDD pmos W=0.205u L=0.04u
M15382 n1508 U2007/net28 VDD VDD pmos W=0.205u L=0.04u
M15383 U2007/net32 WX9756 VDD VDD pmos W=0.205u L=0.04u
M15384 U2007/net64 U2007/net24 VDD VDD pmos W=0.28u L=0.04u
M15385 U2007/net24 U2007/net30 U2007/net045 VDD pmos W=0.205u L=0.04u
M15386 U2007/net045 U2007/net32 VDD VDD pmos W=0.205u L=0.04u
M15387 WX8202 n1281 U2008/net26 VSS nmos W=0.155u L=0.04u
M15388 WX8202 n1408 U2008/net26 VSS nmos W=0.155u L=0.04u
M15389 U2008/net29 n1510 VSS VSS nmos W=0.155u L=0.04u
M15390 U2008/net26 n1509 U2008/net29 VSS nmos W=0.155u L=0.04u
M15391 U2008/net26 n1252 U2008/net29 VSS nmos W=0.155u L=0.04u
M15392 WX8202 n1408 U2008/net43 VDD pmos W=0.205u L=0.04u
M15393 WX8202 n1252 U2008/net49 VDD pmos W=0.205u L=0.04u
M15394 U2008/net49 n1509 VDD VDD pmos W=0.205u L=0.04u
M15395 U2008/net43 n1281 VDD VDD pmos W=0.205u L=0.04u
M15396 WX8202 n1510 VDD VDD pmos W=0.205u L=0.04u
M15397 U2009/net29 n1341 VSS VSS nmos W=0.155u L=0.04u
M15398 n1510 WX8301 U2009/net29 VSS nmos W=0.155u L=0.04u
M15399 n1510 n1310 U2009/net23 VSS nmos W=0.155u L=0.04u
M15400 U2009/net23 CRC_OUT_3_2 VSS VSS nmos W=0.155u L=0.04u
M15401 U2009/net20 CRC_OUT_3_2 n1510 VDD pmos W=0.205u L=0.04u
M15402 U2009/net20 n1310 n1510 VDD pmos W=0.205u L=0.04u
M15403 VDD WX8301 U2009/net20 VDD pmos W=0.205u L=0.04u
M15404 VDD n1341 U2009/net20 VDD pmos W=0.205u L=0.04u
M15405 n1408 n1511 VSS VSS nmos W=0.135u L=0.04u
M15406 n1408 n1511 VDD VDD pmos W=0.205u L=0.04u
M15407 U2011/net28 U2011/net20 U2011/net64 VSS nmos W=0.155u L=0.04u
M15408 U2011/net24 U2011/net30 U2011/net32 VSS nmos W=0.155u L=0.04u
M15409 U2011/net28 U2011/net40 U2011/net24 VSS nmos W=0.155u L=0.04u
M15410 U2011/net40 WX9882 U2011/net108 VSS nmos W=0.155u L=0.04u
M15411 U2011/net40 U2011/net106 U2011/net104 VSS nmos W=0.155u L=0.04u
M15412 U2011/net24 WX9818 U2011/net050 VSS nmos W=0.155u L=0.04u
M15413 U2011/net050 U2011/net32 VSS VSS nmos W=0.155u L=0.04u
M15414 U2011/net20 U2011/net40 VSS VSS nmos W=0.155u L=0.04u
M15415 U2011/net106 WX9882 VSS VSS nmos W=0.155u L=0.04u
M15416 U2011/net104 WX9946 VSS VSS nmos W=0.155u L=0.04u
M15417 U2011/net30 WX9818 VSS VSS nmos W=0.155u L=0.04u
M15418 U2011/net108 U2011/net104 VSS VSS nmos W=0.155u L=0.04u
M15419 n1511 U2011/net28 VSS VSS nmos W=0.155u L=0.04u
M15420 U2011/net32 WX9754 VSS VSS nmos W=0.155u L=0.04u
M15421 U2011/net64 U2011/net24 VSS VSS nmos W=0.2u L=0.04u
M15422 U2011/net28 U2011/net40 U2011/net64 VDD pmos W=0.205u L=0.04u
M15423 U2011/net24 WX9818 U2011/net32 VDD pmos W=0.205u L=0.04u
M15424 U2011/net28 U2011/net20 U2011/net24 VDD pmos W=0.205u L=0.04u
M15425 U2011/net40 U2011/net106 U2011/net108 VDD pmos W=0.205u L=0.04u
M15426 U2011/net40 WX9882 U2011/net104 VDD pmos W=0.205u L=0.04u
M15427 U2011/net20 U2011/net40 VDD VDD pmos W=0.205u L=0.04u
M15428 U2011/net106 WX9882 VDD VDD pmos W=0.205u L=0.04u
M15429 U2011/net104 WX9946 VDD VDD pmos W=0.205u L=0.04u
M15430 U2011/net30 WX9818 VDD VDD pmos W=0.205u L=0.04u
M15431 U2011/net108 U2011/net104 VDD VDD pmos W=0.205u L=0.04u
M15432 n1511 U2011/net28 VDD VDD pmos W=0.205u L=0.04u
M15433 U2011/net32 WX9754 VDD VDD pmos W=0.205u L=0.04u
M15434 U2011/net64 U2011/net24 VDD VDD pmos W=0.28u L=0.04u
M15435 U2011/net24 U2011/net30 U2011/net045 VDD pmos W=0.205u L=0.04u
M15436 U2011/net045 U2011/net32 VDD VDD pmos W=0.205u L=0.04u
M15437 WX8188 n1280 U2012/net26 VSS nmos W=0.155u L=0.04u
M15438 WX8188 n1411 U2012/net26 VSS nmos W=0.155u L=0.04u
M15439 U2012/net29 n1513 VSS VSS nmos W=0.155u L=0.04u
M15440 U2012/net26 n1512 U2012/net29 VSS nmos W=0.155u L=0.04u
M15441 U2012/net26 n1252 U2012/net29 VSS nmos W=0.155u L=0.04u
M15442 WX8188 n1411 U2012/net43 VDD pmos W=0.205u L=0.04u
M15443 WX8188 n1252 U2012/net49 VDD pmos W=0.205u L=0.04u
M15444 U2012/net49 n1512 VDD VDD pmos W=0.205u L=0.04u
M15445 U2012/net43 n1280 VDD VDD pmos W=0.205u L=0.04u
M15446 WX8188 n1513 VDD VDD pmos W=0.205u L=0.04u
M15447 U2013/net29 n1340 VSS VSS nmos W=0.155u L=0.04u
M15448 n1513 WX8299 U2013/net29 VSS nmos W=0.155u L=0.04u
M15449 n1513 n1310 U2013/net23 VSS nmos W=0.155u L=0.04u
M15450 U2013/net23 CRC_OUT_3_3 VSS VSS nmos W=0.155u L=0.04u
M15451 U2013/net20 CRC_OUT_3_3 n1513 VDD pmos W=0.205u L=0.04u
M15452 U2013/net20 n1310 n1513 VDD pmos W=0.205u L=0.04u
M15453 VDD WX8299 U2013/net20 VDD pmos W=0.205u L=0.04u
M15454 VDD n1340 U2013/net20 VDD pmos W=0.205u L=0.04u
M15455 n1411 n1514 VSS VSS nmos W=0.135u L=0.04u
M15456 n1411 n1514 VDD VDD pmos W=0.205u L=0.04u
M15457 U2015/net28 U2015/net20 U2015/net64 VSS nmos W=0.155u L=0.04u
M15458 U2015/net24 U2015/net30 U2015/net32 VSS nmos W=0.155u L=0.04u
M15459 U2015/net28 U2015/net40 U2015/net24 VSS nmos W=0.155u L=0.04u
M15460 U2015/net40 WX9880 U2015/net108 VSS nmos W=0.155u L=0.04u
M15461 U2015/net40 U2015/net106 U2015/net104 VSS nmos W=0.155u L=0.04u
M15462 U2015/net24 WX9816 U2015/net050 VSS nmos W=0.155u L=0.04u
M15463 U2015/net050 U2015/net32 VSS VSS nmos W=0.155u L=0.04u
M15464 U2015/net20 U2015/net40 VSS VSS nmos W=0.155u L=0.04u
M15465 U2015/net106 WX9880 VSS VSS nmos W=0.155u L=0.04u
M15466 U2015/net104 WX9944 VSS VSS nmos W=0.155u L=0.04u
M15467 U2015/net30 WX9816 VSS VSS nmos W=0.155u L=0.04u
M15468 U2015/net108 U2015/net104 VSS VSS nmos W=0.155u L=0.04u
M15469 n1514 U2015/net28 VSS VSS nmos W=0.155u L=0.04u
M15470 U2015/net32 WX9752 VSS VSS nmos W=0.155u L=0.04u
M15471 U2015/net64 U2015/net24 VSS VSS nmos W=0.2u L=0.04u
M15472 U2015/net28 U2015/net40 U2015/net64 VDD pmos W=0.205u L=0.04u
M15473 U2015/net24 WX9816 U2015/net32 VDD pmos W=0.205u L=0.04u
M15474 U2015/net28 U2015/net20 U2015/net24 VDD pmos W=0.205u L=0.04u
M15475 U2015/net40 U2015/net106 U2015/net108 VDD pmos W=0.205u L=0.04u
M15476 U2015/net40 WX9880 U2015/net104 VDD pmos W=0.205u L=0.04u
M15477 U2015/net20 U2015/net40 VDD VDD pmos W=0.205u L=0.04u
M15478 U2015/net106 WX9880 VDD VDD pmos W=0.205u L=0.04u
M15479 U2015/net104 WX9944 VDD VDD pmos W=0.205u L=0.04u
M15480 U2015/net30 WX9816 VDD VDD pmos W=0.205u L=0.04u
M15481 U2015/net108 U2015/net104 VDD VDD pmos W=0.205u L=0.04u
M15482 n1514 U2015/net28 VDD VDD pmos W=0.205u L=0.04u
M15483 U2015/net32 WX9752 VDD VDD pmos W=0.205u L=0.04u
M15484 U2015/net64 U2015/net24 VDD VDD pmos W=0.28u L=0.04u
M15485 U2015/net24 U2015/net30 U2015/net045 VDD pmos W=0.205u L=0.04u
M15486 U2015/net045 U2015/net32 VDD VDD pmos W=0.205u L=0.04u
M15487 WX8174 n1280 U2016/net26 VSS nmos W=0.155u L=0.04u
M15488 WX8174 n1414 U2016/net26 VSS nmos W=0.155u L=0.04u
M15489 U2016/net29 n1516 VSS VSS nmos W=0.155u L=0.04u
M15490 U2016/net26 n1515 U2016/net29 VSS nmos W=0.155u L=0.04u
M15491 U2016/net26 n1252 U2016/net29 VSS nmos W=0.155u L=0.04u
M15492 WX8174 n1414 U2016/net43 VDD pmos W=0.205u L=0.04u
M15493 WX8174 n1252 U2016/net49 VDD pmos W=0.205u L=0.04u
M15494 U2016/net49 n1515 VDD VDD pmos W=0.205u L=0.04u
M15495 U2016/net43 n1280 VDD VDD pmos W=0.205u L=0.04u
M15496 WX8174 n1516 VDD VDD pmos W=0.205u L=0.04u
M15497 U2017/net29 n1340 VSS VSS nmos W=0.155u L=0.04u
M15498 n1516 WX8297 U2017/net29 VSS nmos W=0.155u L=0.04u
M15499 n1516 n1310 U2017/net23 VSS nmos W=0.155u L=0.04u
M15500 U2017/net23 CRC_OUT_3_4 VSS VSS nmos W=0.155u L=0.04u
M15501 U2017/net20 CRC_OUT_3_4 n1516 VDD pmos W=0.205u L=0.04u
M15502 U2017/net20 n1310 n1516 VDD pmos W=0.205u L=0.04u
M15503 VDD WX8297 U2017/net20 VDD pmos W=0.205u L=0.04u
M15504 VDD n1340 U2017/net20 VDD pmos W=0.205u L=0.04u
M15505 n1414 n1517 VSS VSS nmos W=0.135u L=0.04u
M15506 n1414 n1517 VDD VDD pmos W=0.205u L=0.04u
M15507 U2019/net28 U2019/net20 U2019/net64 VSS nmos W=0.155u L=0.04u
M15508 U2019/net24 U2019/net30 U2019/net32 VSS nmos W=0.155u L=0.04u
M15509 U2019/net28 U2019/net40 U2019/net24 VSS nmos W=0.155u L=0.04u
M15510 U2019/net40 WX9878 U2019/net108 VSS nmos W=0.155u L=0.04u
M15511 U2019/net40 U2019/net106 U2019/net104 VSS nmos W=0.155u L=0.04u
M15512 U2019/net24 WX9814 U2019/net050 VSS nmos W=0.155u L=0.04u
M15513 U2019/net050 U2019/net32 VSS VSS nmos W=0.155u L=0.04u
M15514 U2019/net20 U2019/net40 VSS VSS nmos W=0.155u L=0.04u
M15515 U2019/net106 WX9878 VSS VSS nmos W=0.155u L=0.04u
M15516 U2019/net104 WX9942 VSS VSS nmos W=0.155u L=0.04u
M15517 U2019/net30 WX9814 VSS VSS nmos W=0.155u L=0.04u
M15518 U2019/net108 U2019/net104 VSS VSS nmos W=0.155u L=0.04u
M15519 n1517 U2019/net28 VSS VSS nmos W=0.155u L=0.04u
M15520 U2019/net32 WX9750 VSS VSS nmos W=0.155u L=0.04u
M15521 U2019/net64 U2019/net24 VSS VSS nmos W=0.2u L=0.04u
M15522 U2019/net28 U2019/net40 U2019/net64 VDD pmos W=0.205u L=0.04u
M15523 U2019/net24 WX9814 U2019/net32 VDD pmos W=0.205u L=0.04u
M15524 U2019/net28 U2019/net20 U2019/net24 VDD pmos W=0.205u L=0.04u
M15525 U2019/net40 U2019/net106 U2019/net108 VDD pmos W=0.205u L=0.04u
M15526 U2019/net40 WX9878 U2019/net104 VDD pmos W=0.205u L=0.04u
M15527 U2019/net20 U2019/net40 VDD VDD pmos W=0.205u L=0.04u
M15528 U2019/net106 WX9878 VDD VDD pmos W=0.205u L=0.04u
M15529 U2019/net104 WX9942 VDD VDD pmos W=0.205u L=0.04u
M15530 U2019/net30 WX9814 VDD VDD pmos W=0.205u L=0.04u
M15531 U2019/net108 U2019/net104 VDD VDD pmos W=0.205u L=0.04u
M15532 n1517 U2019/net28 VDD VDD pmos W=0.205u L=0.04u
M15533 U2019/net32 WX9750 VDD VDD pmos W=0.205u L=0.04u
M15534 U2019/net64 U2019/net24 VDD VDD pmos W=0.28u L=0.04u
M15535 U2019/net24 U2019/net30 U2019/net045 VDD pmos W=0.205u L=0.04u
M15536 U2019/net045 U2019/net32 VDD VDD pmos W=0.205u L=0.04u
M15537 WX8160 n1280 U2020/net26 VSS nmos W=0.155u L=0.04u
M15538 WX8160 n1417 U2020/net26 VSS nmos W=0.155u L=0.04u
M15539 U2020/net29 n1519 VSS VSS nmos W=0.155u L=0.04u
M15540 U2020/net26 n1518 U2020/net29 VSS nmos W=0.155u L=0.04u
M15541 U2020/net26 n1252 U2020/net29 VSS nmos W=0.155u L=0.04u
M15542 WX8160 n1417 U2020/net43 VDD pmos W=0.205u L=0.04u
M15543 WX8160 n1252 U2020/net49 VDD pmos W=0.205u L=0.04u
M15544 U2020/net49 n1518 VDD VDD pmos W=0.205u L=0.04u
M15545 U2020/net43 n1280 VDD VDD pmos W=0.205u L=0.04u
M15546 WX8160 n1519 VDD VDD pmos W=0.205u L=0.04u
M15547 U2021/net29 n1340 VSS VSS nmos W=0.155u L=0.04u
M15548 n1519 WX8295 U2021/net29 VSS nmos W=0.155u L=0.04u
M15549 n1519 n1309 U2021/net23 VSS nmos W=0.155u L=0.04u
M15550 U2021/net23 CRC_OUT_3_5 VSS VSS nmos W=0.155u L=0.04u
M15551 U2021/net20 CRC_OUT_3_5 n1519 VDD pmos W=0.205u L=0.04u
M15552 U2021/net20 n1309 n1519 VDD pmos W=0.205u L=0.04u
M15553 VDD WX8295 U2021/net20 VDD pmos W=0.205u L=0.04u
M15554 VDD n1340 U2021/net20 VDD pmos W=0.205u L=0.04u
M15555 n1417 n1520 VSS VSS nmos W=0.135u L=0.04u
M15556 n1417 n1520 VDD VDD pmos W=0.205u L=0.04u
M15557 U2023/net28 U2023/net20 U2023/net64 VSS nmos W=0.155u L=0.04u
M15558 U2023/net24 U2023/net30 U2023/net32 VSS nmos W=0.155u L=0.04u
M15559 U2023/net28 U2023/net40 U2023/net24 VSS nmos W=0.155u L=0.04u
M15560 U2023/net40 WX9876 U2023/net108 VSS nmos W=0.155u L=0.04u
M15561 U2023/net40 U2023/net106 U2023/net104 VSS nmos W=0.155u L=0.04u
M15562 U2023/net24 WX9812 U2023/net050 VSS nmos W=0.155u L=0.04u
M15563 U2023/net050 U2023/net32 VSS VSS nmos W=0.155u L=0.04u
M15564 U2023/net20 U2023/net40 VSS VSS nmos W=0.155u L=0.04u
M15565 U2023/net106 WX9876 VSS VSS nmos W=0.155u L=0.04u
M15566 U2023/net104 WX9940 VSS VSS nmos W=0.155u L=0.04u
M15567 U2023/net30 WX9812 VSS VSS nmos W=0.155u L=0.04u
M15568 U2023/net108 U2023/net104 VSS VSS nmos W=0.155u L=0.04u
M15569 n1520 U2023/net28 VSS VSS nmos W=0.155u L=0.04u
M15570 U2023/net32 WX9748 VSS VSS nmos W=0.155u L=0.04u
M15571 U2023/net64 U2023/net24 VSS VSS nmos W=0.2u L=0.04u
M15572 U2023/net28 U2023/net40 U2023/net64 VDD pmos W=0.205u L=0.04u
M15573 U2023/net24 WX9812 U2023/net32 VDD pmos W=0.205u L=0.04u
M15574 U2023/net28 U2023/net20 U2023/net24 VDD pmos W=0.205u L=0.04u
M15575 U2023/net40 U2023/net106 U2023/net108 VDD pmos W=0.205u L=0.04u
M15576 U2023/net40 WX9876 U2023/net104 VDD pmos W=0.205u L=0.04u
M15577 U2023/net20 U2023/net40 VDD VDD pmos W=0.205u L=0.04u
M15578 U2023/net106 WX9876 VDD VDD pmos W=0.205u L=0.04u
M15579 U2023/net104 WX9940 VDD VDD pmos W=0.205u L=0.04u
M15580 U2023/net30 WX9812 VDD VDD pmos W=0.205u L=0.04u
M15581 U2023/net108 U2023/net104 VDD VDD pmos W=0.205u L=0.04u
M15582 n1520 U2023/net28 VDD VDD pmos W=0.205u L=0.04u
M15583 U2023/net32 WX9748 VDD VDD pmos W=0.205u L=0.04u
M15584 U2023/net64 U2023/net24 VDD VDD pmos W=0.28u L=0.04u
M15585 U2023/net24 U2023/net30 U2023/net045 VDD pmos W=0.205u L=0.04u
M15586 U2023/net045 U2023/net32 VDD VDD pmos W=0.205u L=0.04u
M15587 WX8146 n1280 U2024/net26 VSS nmos W=0.155u L=0.04u
M15588 WX8146 n1420 U2024/net26 VSS nmos W=0.155u L=0.04u
M15589 U2024/net29 n1522 VSS VSS nmos W=0.155u L=0.04u
M15590 U2024/net26 n1521 U2024/net29 VSS nmos W=0.155u L=0.04u
M15591 U2024/net26 n1252 U2024/net29 VSS nmos W=0.155u L=0.04u
M15592 WX8146 n1420 U2024/net43 VDD pmos W=0.205u L=0.04u
M15593 WX8146 n1252 U2024/net49 VDD pmos W=0.205u L=0.04u
M15594 U2024/net49 n1521 VDD VDD pmos W=0.205u L=0.04u
M15595 U2024/net43 n1280 VDD VDD pmos W=0.205u L=0.04u
M15596 WX8146 n1522 VDD VDD pmos W=0.205u L=0.04u
M15597 U2025/net29 n1340 VSS VSS nmos W=0.155u L=0.04u
M15598 n1522 WX8293 U2025/net29 VSS nmos W=0.155u L=0.04u
M15599 n1522 n1309 U2025/net23 VSS nmos W=0.155u L=0.04u
M15600 U2025/net23 CRC_OUT_3_6 VSS VSS nmos W=0.155u L=0.04u
M15601 U2025/net20 CRC_OUT_3_6 n1522 VDD pmos W=0.205u L=0.04u
M15602 U2025/net20 n1309 n1522 VDD pmos W=0.205u L=0.04u
M15603 VDD WX8293 U2025/net20 VDD pmos W=0.205u L=0.04u
M15604 VDD n1340 U2025/net20 VDD pmos W=0.205u L=0.04u
M15605 n1420 n1523 VSS VSS nmos W=0.135u L=0.04u
M15606 n1420 n1523 VDD VDD pmos W=0.205u L=0.04u
M15607 U2027/net28 U2027/net20 U2027/net64 VSS nmos W=0.155u L=0.04u
M15608 U2027/net24 U2027/net30 U2027/net32 VSS nmos W=0.155u L=0.04u
M15609 U2027/net28 U2027/net40 U2027/net24 VSS nmos W=0.155u L=0.04u
M15610 U2027/net40 WX9874 U2027/net108 VSS nmos W=0.155u L=0.04u
M15611 U2027/net40 U2027/net106 U2027/net104 VSS nmos W=0.155u L=0.04u
M15612 U2027/net24 WX9810 U2027/net050 VSS nmos W=0.155u L=0.04u
M15613 U2027/net050 U2027/net32 VSS VSS nmos W=0.155u L=0.04u
M15614 U2027/net20 U2027/net40 VSS VSS nmos W=0.155u L=0.04u
M15615 U2027/net106 WX9874 VSS VSS nmos W=0.155u L=0.04u
M15616 U2027/net104 WX9938 VSS VSS nmos W=0.155u L=0.04u
M15617 U2027/net30 WX9810 VSS VSS nmos W=0.155u L=0.04u
M15618 U2027/net108 U2027/net104 VSS VSS nmos W=0.155u L=0.04u
M15619 n1523 U2027/net28 VSS VSS nmos W=0.155u L=0.04u
M15620 U2027/net32 WX9746 VSS VSS nmos W=0.155u L=0.04u
M15621 U2027/net64 U2027/net24 VSS VSS nmos W=0.2u L=0.04u
M15622 U2027/net28 U2027/net40 U2027/net64 VDD pmos W=0.205u L=0.04u
M15623 U2027/net24 WX9810 U2027/net32 VDD pmos W=0.205u L=0.04u
M15624 U2027/net28 U2027/net20 U2027/net24 VDD pmos W=0.205u L=0.04u
M15625 U2027/net40 U2027/net106 U2027/net108 VDD pmos W=0.205u L=0.04u
M15626 U2027/net40 WX9874 U2027/net104 VDD pmos W=0.205u L=0.04u
M15627 U2027/net20 U2027/net40 VDD VDD pmos W=0.205u L=0.04u
M15628 U2027/net106 WX9874 VDD VDD pmos W=0.205u L=0.04u
M15629 U2027/net104 WX9938 VDD VDD pmos W=0.205u L=0.04u
M15630 U2027/net30 WX9810 VDD VDD pmos W=0.205u L=0.04u
M15631 U2027/net108 U2027/net104 VDD VDD pmos W=0.205u L=0.04u
M15632 n1523 U2027/net28 VDD VDD pmos W=0.205u L=0.04u
M15633 U2027/net32 WX9746 VDD VDD pmos W=0.205u L=0.04u
M15634 U2027/net64 U2027/net24 VDD VDD pmos W=0.28u L=0.04u
M15635 U2027/net24 U2027/net30 U2027/net045 VDD pmos W=0.205u L=0.04u
M15636 U2027/net045 U2027/net32 VDD VDD pmos W=0.205u L=0.04u
M15637 WX8132 n1280 U2028/net26 VSS nmos W=0.155u L=0.04u
M15638 WX8132 n1423 U2028/net26 VSS nmos W=0.155u L=0.04u
M15639 U2028/net29 n1525 VSS VSS nmos W=0.155u L=0.04u
M15640 U2028/net26 n1524 U2028/net29 VSS nmos W=0.155u L=0.04u
M15641 U2028/net26 n1252 U2028/net29 VSS nmos W=0.155u L=0.04u
M15642 WX8132 n1423 U2028/net43 VDD pmos W=0.205u L=0.04u
M15643 WX8132 n1252 U2028/net49 VDD pmos W=0.205u L=0.04u
M15644 U2028/net49 n1524 VDD VDD pmos W=0.205u L=0.04u
M15645 U2028/net43 n1280 VDD VDD pmos W=0.205u L=0.04u
M15646 WX8132 n1525 VDD VDD pmos W=0.205u L=0.04u
M15647 U2029/net29 n1340 VSS VSS nmos W=0.155u L=0.04u
M15648 n1525 WX8291 U2029/net29 VSS nmos W=0.155u L=0.04u
M15649 n1525 n1309 U2029/net23 VSS nmos W=0.155u L=0.04u
M15650 U2029/net23 CRC_OUT_3_7 VSS VSS nmos W=0.155u L=0.04u
M15651 U2029/net20 CRC_OUT_3_7 n1525 VDD pmos W=0.205u L=0.04u
M15652 U2029/net20 n1309 n1525 VDD pmos W=0.205u L=0.04u
M15653 VDD WX8291 U2029/net20 VDD pmos W=0.205u L=0.04u
M15654 VDD n1340 U2029/net20 VDD pmos W=0.205u L=0.04u
M15655 n1423 n1526 VSS VSS nmos W=0.135u L=0.04u
M15656 n1423 n1526 VDD VDD pmos W=0.205u L=0.04u
M15657 U2031/net28 U2031/net20 U2031/net64 VSS nmos W=0.155u L=0.04u
M15658 U2031/net24 U2031/net30 U2031/net32 VSS nmos W=0.155u L=0.04u
M15659 U2031/net28 U2031/net40 U2031/net24 VSS nmos W=0.155u L=0.04u
M15660 U2031/net40 WX9872 U2031/net108 VSS nmos W=0.155u L=0.04u
M15661 U2031/net40 U2031/net106 U2031/net104 VSS nmos W=0.155u L=0.04u
M15662 U2031/net24 WX9808 U2031/net050 VSS nmos W=0.155u L=0.04u
M15663 U2031/net050 U2031/net32 VSS VSS nmos W=0.155u L=0.04u
M15664 U2031/net20 U2031/net40 VSS VSS nmos W=0.155u L=0.04u
M15665 U2031/net106 WX9872 VSS VSS nmos W=0.155u L=0.04u
M15666 U2031/net104 WX9936 VSS VSS nmos W=0.155u L=0.04u
M15667 U2031/net30 WX9808 VSS VSS nmos W=0.155u L=0.04u
M15668 U2031/net108 U2031/net104 VSS VSS nmos W=0.155u L=0.04u
M15669 n1526 U2031/net28 VSS VSS nmos W=0.155u L=0.04u
M15670 U2031/net32 WX9744 VSS VSS nmos W=0.155u L=0.04u
M15671 U2031/net64 U2031/net24 VSS VSS nmos W=0.2u L=0.04u
M15672 U2031/net28 U2031/net40 U2031/net64 VDD pmos W=0.205u L=0.04u
M15673 U2031/net24 WX9808 U2031/net32 VDD pmos W=0.205u L=0.04u
M15674 U2031/net28 U2031/net20 U2031/net24 VDD pmos W=0.205u L=0.04u
M15675 U2031/net40 U2031/net106 U2031/net108 VDD pmos W=0.205u L=0.04u
M15676 U2031/net40 WX9872 U2031/net104 VDD pmos W=0.205u L=0.04u
M15677 U2031/net20 U2031/net40 VDD VDD pmos W=0.205u L=0.04u
M15678 U2031/net106 WX9872 VDD VDD pmos W=0.205u L=0.04u
M15679 U2031/net104 WX9936 VDD VDD pmos W=0.205u L=0.04u
M15680 U2031/net30 WX9808 VDD VDD pmos W=0.205u L=0.04u
M15681 U2031/net108 U2031/net104 VDD VDD pmos W=0.205u L=0.04u
M15682 n1526 U2031/net28 VDD VDD pmos W=0.205u L=0.04u
M15683 U2031/net32 WX9744 VDD VDD pmos W=0.205u L=0.04u
M15684 U2031/net64 U2031/net24 VDD VDD pmos W=0.28u L=0.04u
M15685 U2031/net24 U2031/net30 U2031/net045 VDD pmos W=0.205u L=0.04u
M15686 U2031/net045 U2031/net32 VDD VDD pmos W=0.205u L=0.04u
M15687 WX8118 n1280 U2032/net26 VSS nmos W=0.155u L=0.04u
M15688 WX8118 n1426 U2032/net26 VSS nmos W=0.155u L=0.04u
M15689 U2032/net29 n1528 VSS VSS nmos W=0.155u L=0.04u
M15690 U2032/net26 n1527 U2032/net29 VSS nmos W=0.155u L=0.04u
M15691 U2032/net26 n1252 U2032/net29 VSS nmos W=0.155u L=0.04u
M15692 WX8118 n1426 U2032/net43 VDD pmos W=0.205u L=0.04u
M15693 WX8118 n1252 U2032/net49 VDD pmos W=0.205u L=0.04u
M15694 U2032/net49 n1527 VDD VDD pmos W=0.205u L=0.04u
M15695 U2032/net43 n1280 VDD VDD pmos W=0.205u L=0.04u
M15696 WX8118 n1528 VDD VDD pmos W=0.205u L=0.04u
M15697 U2033/net29 n1340 VSS VSS nmos W=0.155u L=0.04u
M15698 n1528 WX8289 U2033/net29 VSS nmos W=0.155u L=0.04u
M15699 n1528 n1309 U2033/net23 VSS nmos W=0.155u L=0.04u
M15700 U2033/net23 CRC_OUT_3_8 VSS VSS nmos W=0.155u L=0.04u
M15701 U2033/net20 CRC_OUT_3_8 n1528 VDD pmos W=0.205u L=0.04u
M15702 U2033/net20 n1309 n1528 VDD pmos W=0.205u L=0.04u
M15703 VDD WX8289 U2033/net20 VDD pmos W=0.205u L=0.04u
M15704 VDD n1340 U2033/net20 VDD pmos W=0.205u L=0.04u
M15705 n1426 n1529 VSS VSS nmos W=0.135u L=0.04u
M15706 n1426 n1529 VDD VDD pmos W=0.205u L=0.04u
M15707 U2035/net28 U2035/net20 U2035/net64 VSS nmos W=0.155u L=0.04u
M15708 U2035/net24 U2035/net30 U2035/net32 VSS nmos W=0.155u L=0.04u
M15709 U2035/net28 U2035/net40 U2035/net24 VSS nmos W=0.155u L=0.04u
M15710 U2035/net40 WX9870 U2035/net108 VSS nmos W=0.155u L=0.04u
M15711 U2035/net40 U2035/net106 U2035/net104 VSS nmos W=0.155u L=0.04u
M15712 U2035/net24 WX9806 U2035/net050 VSS nmos W=0.155u L=0.04u
M15713 U2035/net050 U2035/net32 VSS VSS nmos W=0.155u L=0.04u
M15714 U2035/net20 U2035/net40 VSS VSS nmos W=0.155u L=0.04u
M15715 U2035/net106 WX9870 VSS VSS nmos W=0.155u L=0.04u
M15716 U2035/net104 WX9934 VSS VSS nmos W=0.155u L=0.04u
M15717 U2035/net30 WX9806 VSS VSS nmos W=0.155u L=0.04u
M15718 U2035/net108 U2035/net104 VSS VSS nmos W=0.155u L=0.04u
M15719 n1529 U2035/net28 VSS VSS nmos W=0.155u L=0.04u
M15720 U2035/net32 WX9742 VSS VSS nmos W=0.155u L=0.04u
M15721 U2035/net64 U2035/net24 VSS VSS nmos W=0.2u L=0.04u
M15722 U2035/net28 U2035/net40 U2035/net64 VDD pmos W=0.205u L=0.04u
M15723 U2035/net24 WX9806 U2035/net32 VDD pmos W=0.205u L=0.04u
M15724 U2035/net28 U2035/net20 U2035/net24 VDD pmos W=0.205u L=0.04u
M15725 U2035/net40 U2035/net106 U2035/net108 VDD pmos W=0.205u L=0.04u
M15726 U2035/net40 WX9870 U2035/net104 VDD pmos W=0.205u L=0.04u
M15727 U2035/net20 U2035/net40 VDD VDD pmos W=0.205u L=0.04u
M15728 U2035/net106 WX9870 VDD VDD pmos W=0.205u L=0.04u
M15729 U2035/net104 WX9934 VDD VDD pmos W=0.205u L=0.04u
M15730 U2035/net30 WX9806 VDD VDD pmos W=0.205u L=0.04u
M15731 U2035/net108 U2035/net104 VDD VDD pmos W=0.205u L=0.04u
M15732 n1529 U2035/net28 VDD VDD pmos W=0.205u L=0.04u
M15733 U2035/net32 WX9742 VDD VDD pmos W=0.205u L=0.04u
M15734 U2035/net64 U2035/net24 VDD VDD pmos W=0.28u L=0.04u
M15735 U2035/net24 U2035/net30 U2035/net045 VDD pmos W=0.205u L=0.04u
M15736 U2035/net045 U2035/net32 VDD VDD pmos W=0.205u L=0.04u
M15737 WX8104 n1280 U2036/net26 VSS nmos W=0.155u L=0.04u
M15738 WX8104 n1433 U2036/net26 VSS nmos W=0.155u L=0.04u
M15739 U2036/net29 n1531 VSS VSS nmos W=0.155u L=0.04u
M15740 U2036/net26 n1530 U2036/net29 VSS nmos W=0.155u L=0.04u
M15741 U2036/net26 n1252 U2036/net29 VSS nmos W=0.155u L=0.04u
M15742 WX8104 n1433 U2036/net43 VDD pmos W=0.205u L=0.04u
M15743 WX8104 n1252 U2036/net49 VDD pmos W=0.205u L=0.04u
M15744 U2036/net49 n1530 VDD VDD pmos W=0.205u L=0.04u
M15745 U2036/net43 n1280 VDD VDD pmos W=0.205u L=0.04u
M15746 WX8104 n1531 VDD VDD pmos W=0.205u L=0.04u
M15747 U2037/net29 n1340 VSS VSS nmos W=0.155u L=0.04u
M15748 n1531 WX8287 U2037/net29 VSS nmos W=0.155u L=0.04u
M15749 n1531 n1309 U2037/net23 VSS nmos W=0.155u L=0.04u
M15750 U2037/net23 CRC_OUT_3_9 VSS VSS nmos W=0.155u L=0.04u
M15751 U2037/net20 CRC_OUT_3_9 n1531 VDD pmos W=0.205u L=0.04u
M15752 U2037/net20 n1309 n1531 VDD pmos W=0.205u L=0.04u
M15753 VDD WX8287 U2037/net20 VDD pmos W=0.205u L=0.04u
M15754 VDD n1340 U2037/net20 VDD pmos W=0.205u L=0.04u
M15755 n1433 n1532 VSS VSS nmos W=0.135u L=0.04u
M15756 n1433 n1532 VDD VDD pmos W=0.205u L=0.04u
M15757 U2039/net28 U2039/net20 U2039/net64 VSS nmos W=0.155u L=0.04u
M15758 U2039/net24 U2039/net30 U2039/net32 VSS nmos W=0.155u L=0.04u
M15759 U2039/net28 U2039/net40 U2039/net24 VSS nmos W=0.155u L=0.04u
M15760 U2039/net40 WX9868 U2039/net108 VSS nmos W=0.155u L=0.04u
M15761 U2039/net40 U2039/net106 U2039/net104 VSS nmos W=0.155u L=0.04u
M15762 U2039/net24 WX9804 U2039/net050 VSS nmos W=0.155u L=0.04u
M15763 U2039/net050 U2039/net32 VSS VSS nmos W=0.155u L=0.04u
M15764 U2039/net20 U2039/net40 VSS VSS nmos W=0.155u L=0.04u
M15765 U2039/net106 WX9868 VSS VSS nmos W=0.155u L=0.04u
M15766 U2039/net104 WX9932 VSS VSS nmos W=0.155u L=0.04u
M15767 U2039/net30 WX9804 VSS VSS nmos W=0.155u L=0.04u
M15768 U2039/net108 U2039/net104 VSS VSS nmos W=0.155u L=0.04u
M15769 n1532 U2039/net28 VSS VSS nmos W=0.155u L=0.04u
M15770 U2039/net32 WX9740 VSS VSS nmos W=0.155u L=0.04u
M15771 U2039/net64 U2039/net24 VSS VSS nmos W=0.2u L=0.04u
M15772 U2039/net28 U2039/net40 U2039/net64 VDD pmos W=0.205u L=0.04u
M15773 U2039/net24 WX9804 U2039/net32 VDD pmos W=0.205u L=0.04u
M15774 U2039/net28 U2039/net20 U2039/net24 VDD pmos W=0.205u L=0.04u
M15775 U2039/net40 U2039/net106 U2039/net108 VDD pmos W=0.205u L=0.04u
M15776 U2039/net40 WX9868 U2039/net104 VDD pmos W=0.205u L=0.04u
M15777 U2039/net20 U2039/net40 VDD VDD pmos W=0.205u L=0.04u
M15778 U2039/net106 WX9868 VDD VDD pmos W=0.205u L=0.04u
M15779 U2039/net104 WX9932 VDD VDD pmos W=0.205u L=0.04u
M15780 U2039/net30 WX9804 VDD VDD pmos W=0.205u L=0.04u
M15781 U2039/net108 U2039/net104 VDD VDD pmos W=0.205u L=0.04u
M15782 n1532 U2039/net28 VDD VDD pmos W=0.205u L=0.04u
M15783 U2039/net32 WX9740 VDD VDD pmos W=0.205u L=0.04u
M15784 U2039/net64 U2039/net24 VDD VDD pmos W=0.28u L=0.04u
M15785 U2039/net24 U2039/net30 U2039/net045 VDD pmos W=0.205u L=0.04u
M15786 U2039/net045 U2039/net32 VDD VDD pmos W=0.205u L=0.04u
M15787 WX8090 n1280 U2040/net26 VSS nmos W=0.155u L=0.04u
M15788 WX8090 n1436 U2040/net26 VSS nmos W=0.155u L=0.04u
M15789 U2040/net29 n1534 VSS VSS nmos W=0.155u L=0.04u
M15790 U2040/net26 n1533 U2040/net29 VSS nmos W=0.155u L=0.04u
M15791 U2040/net26 n1252 U2040/net29 VSS nmos W=0.155u L=0.04u
M15792 WX8090 n1436 U2040/net43 VDD pmos W=0.205u L=0.04u
M15793 WX8090 n1252 U2040/net49 VDD pmos W=0.205u L=0.04u
M15794 U2040/net49 n1533 VDD VDD pmos W=0.205u L=0.04u
M15795 U2040/net43 n1280 VDD VDD pmos W=0.205u L=0.04u
M15796 WX8090 n1534 VDD VDD pmos W=0.205u L=0.04u
M15797 U2041/net29 n1340 VSS VSS nmos W=0.155u L=0.04u
M15798 n1534 WX8285 U2041/net29 VSS nmos W=0.155u L=0.04u
M15799 n1534 n1309 U2041/net23 VSS nmos W=0.155u L=0.04u
M15800 U2041/net23 CRC_OUT_3_10 VSS VSS nmos W=0.155u L=0.04u
M15801 U2041/net20 CRC_OUT_3_10 n1534 VDD pmos W=0.205u L=0.04u
M15802 U2041/net20 n1309 n1534 VDD pmos W=0.205u L=0.04u
M15803 VDD WX8285 U2041/net20 VDD pmos W=0.205u L=0.04u
M15804 VDD n1340 U2041/net20 VDD pmos W=0.205u L=0.04u
M15805 n1436 n1535 VSS VSS nmos W=0.135u L=0.04u
M15806 n1436 n1535 VDD VDD pmos W=0.205u L=0.04u
M15807 U2043/net28 U2043/net20 U2043/net64 VSS nmos W=0.155u L=0.04u
M15808 U2043/net24 U2043/net30 U2043/net32 VSS nmos W=0.155u L=0.04u
M15809 U2043/net28 U2043/net40 U2043/net24 VSS nmos W=0.155u L=0.04u
M15810 U2043/net40 WX9866 U2043/net108 VSS nmos W=0.155u L=0.04u
M15811 U2043/net40 U2043/net106 U2043/net104 VSS nmos W=0.155u L=0.04u
M15812 U2043/net24 WX9802 U2043/net050 VSS nmos W=0.155u L=0.04u
M15813 U2043/net050 U2043/net32 VSS VSS nmos W=0.155u L=0.04u
M15814 U2043/net20 U2043/net40 VSS VSS nmos W=0.155u L=0.04u
M15815 U2043/net106 WX9866 VSS VSS nmos W=0.155u L=0.04u
M15816 U2043/net104 WX9930 VSS VSS nmos W=0.155u L=0.04u
M15817 U2043/net30 WX9802 VSS VSS nmos W=0.155u L=0.04u
M15818 U2043/net108 U2043/net104 VSS VSS nmos W=0.155u L=0.04u
M15819 n1535 U2043/net28 VSS VSS nmos W=0.155u L=0.04u
M15820 U2043/net32 WX9738 VSS VSS nmos W=0.155u L=0.04u
M15821 U2043/net64 U2043/net24 VSS VSS nmos W=0.2u L=0.04u
M15822 U2043/net28 U2043/net40 U2043/net64 VDD pmos W=0.205u L=0.04u
M15823 U2043/net24 WX9802 U2043/net32 VDD pmos W=0.205u L=0.04u
M15824 U2043/net28 U2043/net20 U2043/net24 VDD pmos W=0.205u L=0.04u
M15825 U2043/net40 U2043/net106 U2043/net108 VDD pmos W=0.205u L=0.04u
M15826 U2043/net40 WX9866 U2043/net104 VDD pmos W=0.205u L=0.04u
M15827 U2043/net20 U2043/net40 VDD VDD pmos W=0.205u L=0.04u
M15828 U2043/net106 WX9866 VDD VDD pmos W=0.205u L=0.04u
M15829 U2043/net104 WX9930 VDD VDD pmos W=0.205u L=0.04u
M15830 U2043/net30 WX9802 VDD VDD pmos W=0.205u L=0.04u
M15831 U2043/net108 U2043/net104 VDD VDD pmos W=0.205u L=0.04u
M15832 n1535 U2043/net28 VDD VDD pmos W=0.205u L=0.04u
M15833 U2043/net32 WX9738 VDD VDD pmos W=0.205u L=0.04u
M15834 U2043/net64 U2043/net24 VDD VDD pmos W=0.28u L=0.04u
M15835 U2043/net24 U2043/net30 U2043/net045 VDD pmos W=0.205u L=0.04u
M15836 U2043/net045 U2043/net32 VDD VDD pmos W=0.205u L=0.04u
M15837 WX8076 n1280 U2044/net26 VSS nmos W=0.155u L=0.04u
M15838 WX8076 n1439 U2044/net26 VSS nmos W=0.155u L=0.04u
M15839 U2044/net29 n1537 VSS VSS nmos W=0.155u L=0.04u
M15840 U2044/net26 n1536 U2044/net29 VSS nmos W=0.155u L=0.04u
M15841 U2044/net26 n1252 U2044/net29 VSS nmos W=0.155u L=0.04u
M15842 WX8076 n1439 U2044/net43 VDD pmos W=0.205u L=0.04u
M15843 WX8076 n1252 U2044/net49 VDD pmos W=0.205u L=0.04u
M15844 U2044/net49 n1536 VDD VDD pmos W=0.205u L=0.04u
M15845 U2044/net43 n1280 VDD VDD pmos W=0.205u L=0.04u
M15846 WX8076 n1537 VDD VDD pmos W=0.205u L=0.04u
M15847 U2045/net29 n1340 VSS VSS nmos W=0.155u L=0.04u
M15848 n1537 WX8283 U2045/net29 VSS nmos W=0.155u L=0.04u
M15849 n1537 n1309 U2045/net23 VSS nmos W=0.155u L=0.04u
M15850 U2045/net23 CRC_OUT_3_11 VSS VSS nmos W=0.155u L=0.04u
M15851 U2045/net20 CRC_OUT_3_11 n1537 VDD pmos W=0.205u L=0.04u
M15852 U2045/net20 n1309 n1537 VDD pmos W=0.205u L=0.04u
M15853 VDD WX8283 U2045/net20 VDD pmos W=0.205u L=0.04u
M15854 VDD n1340 U2045/net20 VDD pmos W=0.205u L=0.04u
M15855 n1439 n1538 VSS VSS nmos W=0.135u L=0.04u
M15856 n1439 n1538 VDD VDD pmos W=0.205u L=0.04u
M15857 U2047/net28 U2047/net20 U2047/net64 VSS nmos W=0.155u L=0.04u
M15858 U2047/net24 U2047/net30 U2047/net32 VSS nmos W=0.155u L=0.04u
M15859 U2047/net28 U2047/net40 U2047/net24 VSS nmos W=0.155u L=0.04u
M15860 U2047/net40 WX9864 U2047/net108 VSS nmos W=0.155u L=0.04u
M15861 U2047/net40 U2047/net106 U2047/net104 VSS nmos W=0.155u L=0.04u
M15862 U2047/net24 WX9800 U2047/net050 VSS nmos W=0.155u L=0.04u
M15863 U2047/net050 U2047/net32 VSS VSS nmos W=0.155u L=0.04u
M15864 U2047/net20 U2047/net40 VSS VSS nmos W=0.155u L=0.04u
M15865 U2047/net106 WX9864 VSS VSS nmos W=0.155u L=0.04u
M15866 U2047/net104 WX9928 VSS VSS nmos W=0.155u L=0.04u
M15867 U2047/net30 WX9800 VSS VSS nmos W=0.155u L=0.04u
M15868 U2047/net108 U2047/net104 VSS VSS nmos W=0.155u L=0.04u
M15869 n1538 U2047/net28 VSS VSS nmos W=0.155u L=0.04u
M15870 U2047/net32 WX9736 VSS VSS nmos W=0.155u L=0.04u
M15871 U2047/net64 U2047/net24 VSS VSS nmos W=0.2u L=0.04u
M15872 U2047/net28 U2047/net40 U2047/net64 VDD pmos W=0.205u L=0.04u
M15873 U2047/net24 WX9800 U2047/net32 VDD pmos W=0.205u L=0.04u
M15874 U2047/net28 U2047/net20 U2047/net24 VDD pmos W=0.205u L=0.04u
M15875 U2047/net40 U2047/net106 U2047/net108 VDD pmos W=0.205u L=0.04u
M15876 U2047/net40 WX9864 U2047/net104 VDD pmos W=0.205u L=0.04u
M15877 U2047/net20 U2047/net40 VDD VDD pmos W=0.205u L=0.04u
M15878 U2047/net106 WX9864 VDD VDD pmos W=0.205u L=0.04u
M15879 U2047/net104 WX9928 VDD VDD pmos W=0.205u L=0.04u
M15880 U2047/net30 WX9800 VDD VDD pmos W=0.205u L=0.04u
M15881 U2047/net108 U2047/net104 VDD VDD pmos W=0.205u L=0.04u
M15882 n1538 U2047/net28 VDD VDD pmos W=0.205u L=0.04u
M15883 U2047/net32 WX9736 VDD VDD pmos W=0.205u L=0.04u
M15884 U2047/net64 U2047/net24 VDD VDD pmos W=0.28u L=0.04u
M15885 U2047/net24 U2047/net30 U2047/net045 VDD pmos W=0.205u L=0.04u
M15886 U2047/net045 U2047/net32 VDD VDD pmos W=0.205u L=0.04u
M15887 WX8062 n1280 U2048/net26 VSS nmos W=0.155u L=0.04u
M15888 WX8062 n1442 U2048/net26 VSS nmos W=0.155u L=0.04u
M15889 U2048/net29 n1540 VSS VSS nmos W=0.155u L=0.04u
M15890 U2048/net26 n1539 U2048/net29 VSS nmos W=0.155u L=0.04u
M15891 U2048/net26 n1251 U2048/net29 VSS nmos W=0.155u L=0.04u
M15892 WX8062 n1442 U2048/net43 VDD pmos W=0.205u L=0.04u
M15893 WX8062 n1251 U2048/net49 VDD pmos W=0.205u L=0.04u
M15894 U2048/net49 n1539 VDD VDD pmos W=0.205u L=0.04u
M15895 U2048/net43 n1280 VDD VDD pmos W=0.205u L=0.04u
M15896 WX8062 n1540 VDD VDD pmos W=0.205u L=0.04u
M15897 U2049/net29 n1340 VSS VSS nmos W=0.155u L=0.04u
M15898 n1540 WX8281 U2049/net29 VSS nmos W=0.155u L=0.04u
M15899 n1540 n1309 U2049/net23 VSS nmos W=0.155u L=0.04u
M15900 U2049/net23 CRC_OUT_3_12 VSS VSS nmos W=0.155u L=0.04u
M15901 U2049/net20 CRC_OUT_3_12 n1540 VDD pmos W=0.205u L=0.04u
M15902 U2049/net20 n1309 n1540 VDD pmos W=0.205u L=0.04u
M15903 VDD WX8281 U2049/net20 VDD pmos W=0.205u L=0.04u
M15904 VDD n1340 U2049/net20 VDD pmos W=0.205u L=0.04u
M15905 n1442 n1541 VSS VSS nmos W=0.135u L=0.04u
M15906 n1442 n1541 VDD VDD pmos W=0.205u L=0.04u
M15907 U2051/net28 U2051/net20 U2051/net64 VSS nmos W=0.155u L=0.04u
M15908 U2051/net24 U2051/net30 U2051/net32 VSS nmos W=0.155u L=0.04u
M15909 U2051/net28 U2051/net40 U2051/net24 VSS nmos W=0.155u L=0.04u
M15910 U2051/net40 WX9862 U2051/net108 VSS nmos W=0.155u L=0.04u
M15911 U2051/net40 U2051/net106 U2051/net104 VSS nmos W=0.155u L=0.04u
M15912 U2051/net24 WX9798 U2051/net050 VSS nmos W=0.155u L=0.04u
M15913 U2051/net050 U2051/net32 VSS VSS nmos W=0.155u L=0.04u
M15914 U2051/net20 U2051/net40 VSS VSS nmos W=0.155u L=0.04u
M15915 U2051/net106 WX9862 VSS VSS nmos W=0.155u L=0.04u
M15916 U2051/net104 WX9926 VSS VSS nmos W=0.155u L=0.04u
M15917 U2051/net30 WX9798 VSS VSS nmos W=0.155u L=0.04u
M15918 U2051/net108 U2051/net104 VSS VSS nmos W=0.155u L=0.04u
M15919 n1541 U2051/net28 VSS VSS nmos W=0.155u L=0.04u
M15920 U2051/net32 WX9734 VSS VSS nmos W=0.155u L=0.04u
M15921 U2051/net64 U2051/net24 VSS VSS nmos W=0.2u L=0.04u
M15922 U2051/net28 U2051/net40 U2051/net64 VDD pmos W=0.205u L=0.04u
M15923 U2051/net24 WX9798 U2051/net32 VDD pmos W=0.205u L=0.04u
M15924 U2051/net28 U2051/net20 U2051/net24 VDD pmos W=0.205u L=0.04u
M15925 U2051/net40 U2051/net106 U2051/net108 VDD pmos W=0.205u L=0.04u
M15926 U2051/net40 WX9862 U2051/net104 VDD pmos W=0.205u L=0.04u
M15927 U2051/net20 U2051/net40 VDD VDD pmos W=0.205u L=0.04u
M15928 U2051/net106 WX9862 VDD VDD pmos W=0.205u L=0.04u
M15929 U2051/net104 WX9926 VDD VDD pmos W=0.205u L=0.04u
M15930 U2051/net30 WX9798 VDD VDD pmos W=0.205u L=0.04u
M15931 U2051/net108 U2051/net104 VDD VDD pmos W=0.205u L=0.04u
M15932 n1541 U2051/net28 VDD VDD pmos W=0.205u L=0.04u
M15933 U2051/net32 WX9734 VDD VDD pmos W=0.205u L=0.04u
M15934 U2051/net64 U2051/net24 VDD VDD pmos W=0.28u L=0.04u
M15935 U2051/net24 U2051/net30 U2051/net045 VDD pmos W=0.205u L=0.04u
M15936 U2051/net045 U2051/net32 VDD VDD pmos W=0.205u L=0.04u
M15937 WX8048 n1280 U2052/net26 VSS nmos W=0.155u L=0.04u
M15938 WX8048 n1445 U2052/net26 VSS nmos W=0.155u L=0.04u
M15939 U2052/net29 n1543 VSS VSS nmos W=0.155u L=0.04u
M15940 U2052/net26 n1542 U2052/net29 VSS nmos W=0.155u L=0.04u
M15941 U2052/net26 n1251 U2052/net29 VSS nmos W=0.155u L=0.04u
M15942 WX8048 n1445 U2052/net43 VDD pmos W=0.205u L=0.04u
M15943 WX8048 n1251 U2052/net49 VDD pmos W=0.205u L=0.04u
M15944 U2052/net49 n1542 VDD VDD pmos W=0.205u L=0.04u
M15945 U2052/net43 n1280 VDD VDD pmos W=0.205u L=0.04u
M15946 WX8048 n1543 VDD VDD pmos W=0.205u L=0.04u
M15947 U2053/net29 n1340 VSS VSS nmos W=0.155u L=0.04u
M15948 n1543 WX8279 U2053/net29 VSS nmos W=0.155u L=0.04u
M15949 n1543 n1309 U2053/net23 VSS nmos W=0.155u L=0.04u
M15950 U2053/net23 CRC_OUT_3_13 VSS VSS nmos W=0.155u L=0.04u
M15951 U2053/net20 CRC_OUT_3_13 n1543 VDD pmos W=0.205u L=0.04u
M15952 U2053/net20 n1309 n1543 VDD pmos W=0.205u L=0.04u
M15953 VDD WX8279 U2053/net20 VDD pmos W=0.205u L=0.04u
M15954 VDD n1340 U2053/net20 VDD pmos W=0.205u L=0.04u
M15955 n1445 n1544 VSS VSS nmos W=0.135u L=0.04u
M15956 n1445 n1544 VDD VDD pmos W=0.205u L=0.04u
M15957 U2055/net28 U2055/net20 U2055/net64 VSS nmos W=0.155u L=0.04u
M15958 U2055/net24 U2055/net30 U2055/net32 VSS nmos W=0.155u L=0.04u
M15959 U2055/net28 U2055/net40 U2055/net24 VSS nmos W=0.155u L=0.04u
M15960 U2055/net40 WX9860 U2055/net108 VSS nmos W=0.155u L=0.04u
M15961 U2055/net40 U2055/net106 U2055/net104 VSS nmos W=0.155u L=0.04u
M15962 U2055/net24 WX9796 U2055/net050 VSS nmos W=0.155u L=0.04u
M15963 U2055/net050 U2055/net32 VSS VSS nmos W=0.155u L=0.04u
M15964 U2055/net20 U2055/net40 VSS VSS nmos W=0.155u L=0.04u
M15965 U2055/net106 WX9860 VSS VSS nmos W=0.155u L=0.04u
M15966 U2055/net104 WX9924 VSS VSS nmos W=0.155u L=0.04u
M15967 U2055/net30 WX9796 VSS VSS nmos W=0.155u L=0.04u
M15968 U2055/net108 U2055/net104 VSS VSS nmos W=0.155u L=0.04u
M15969 n1544 U2055/net28 VSS VSS nmos W=0.155u L=0.04u
M15970 U2055/net32 WX9732 VSS VSS nmos W=0.155u L=0.04u
M15971 U2055/net64 U2055/net24 VSS VSS nmos W=0.2u L=0.04u
M15972 U2055/net28 U2055/net40 U2055/net64 VDD pmos W=0.205u L=0.04u
M15973 U2055/net24 WX9796 U2055/net32 VDD pmos W=0.205u L=0.04u
M15974 U2055/net28 U2055/net20 U2055/net24 VDD pmos W=0.205u L=0.04u
M15975 U2055/net40 U2055/net106 U2055/net108 VDD pmos W=0.205u L=0.04u
M15976 U2055/net40 WX9860 U2055/net104 VDD pmos W=0.205u L=0.04u
M15977 U2055/net20 U2055/net40 VDD VDD pmos W=0.205u L=0.04u
M15978 U2055/net106 WX9860 VDD VDD pmos W=0.205u L=0.04u
M15979 U2055/net104 WX9924 VDD VDD pmos W=0.205u L=0.04u
M15980 U2055/net30 WX9796 VDD VDD pmos W=0.205u L=0.04u
M15981 U2055/net108 U2055/net104 VDD VDD pmos W=0.205u L=0.04u
M15982 n1544 U2055/net28 VDD VDD pmos W=0.205u L=0.04u
M15983 U2055/net32 WX9732 VDD VDD pmos W=0.205u L=0.04u
M15984 U2055/net64 U2055/net24 VDD VDD pmos W=0.28u L=0.04u
M15985 U2055/net24 U2055/net30 U2055/net045 VDD pmos W=0.205u L=0.04u
M15986 U2055/net045 U2055/net32 VDD VDD pmos W=0.205u L=0.04u
M15987 WX8034 n1280 U2056/net26 VSS nmos W=0.155u L=0.04u
M15988 WX8034 n1448 U2056/net26 VSS nmos W=0.155u L=0.04u
M15989 U2056/net29 n1546 VSS VSS nmos W=0.155u L=0.04u
M15990 U2056/net26 n1545 U2056/net29 VSS nmos W=0.155u L=0.04u
M15991 U2056/net26 n1251 U2056/net29 VSS nmos W=0.155u L=0.04u
M15992 WX8034 n1448 U2056/net43 VDD pmos W=0.205u L=0.04u
M15993 WX8034 n1251 U2056/net49 VDD pmos W=0.205u L=0.04u
M15994 U2056/net49 n1545 VDD VDD pmos W=0.205u L=0.04u
M15995 U2056/net43 n1280 VDD VDD pmos W=0.205u L=0.04u
M15996 WX8034 n1546 VDD VDD pmos W=0.205u L=0.04u
M15997 U2057/net29 n1340 VSS VSS nmos W=0.155u L=0.04u
M15998 n1546 WX8277 U2057/net29 VSS nmos W=0.155u L=0.04u
M15999 n1546 n1309 U2057/net23 VSS nmos W=0.155u L=0.04u
M16000 U2057/net23 CRC_OUT_3_14 VSS VSS nmos W=0.155u L=0.04u
M16001 U2057/net20 CRC_OUT_3_14 n1546 VDD pmos W=0.205u L=0.04u
M16002 U2057/net20 n1309 n1546 VDD pmos W=0.205u L=0.04u
M16003 VDD WX8277 U2057/net20 VDD pmos W=0.205u L=0.04u
M16004 VDD n1340 U2057/net20 VDD pmos W=0.205u L=0.04u
M16005 n1448 n1547 VSS VSS nmos W=0.135u L=0.04u
M16006 n1448 n1547 VDD VDD pmos W=0.205u L=0.04u
M16007 U2059/net28 U2059/net20 U2059/net64 VSS nmos W=0.155u L=0.04u
M16008 U2059/net24 U2059/net30 U2059/net32 VSS nmos W=0.155u L=0.04u
M16009 U2059/net28 U2059/net40 U2059/net24 VSS nmos W=0.155u L=0.04u
M16010 U2059/net40 WX9858 U2059/net108 VSS nmos W=0.155u L=0.04u
M16011 U2059/net40 U2059/net106 U2059/net104 VSS nmos W=0.155u L=0.04u
M16012 U2059/net24 WX9794 U2059/net050 VSS nmos W=0.155u L=0.04u
M16013 U2059/net050 U2059/net32 VSS VSS nmos W=0.155u L=0.04u
M16014 U2059/net20 U2059/net40 VSS VSS nmos W=0.155u L=0.04u
M16015 U2059/net106 WX9858 VSS VSS nmos W=0.155u L=0.04u
M16016 U2059/net104 WX9922 VSS VSS nmos W=0.155u L=0.04u
M16017 U2059/net30 WX9794 VSS VSS nmos W=0.155u L=0.04u
M16018 U2059/net108 U2059/net104 VSS VSS nmos W=0.155u L=0.04u
M16019 n1547 U2059/net28 VSS VSS nmos W=0.155u L=0.04u
M16020 U2059/net32 WX9730 VSS VSS nmos W=0.155u L=0.04u
M16021 U2059/net64 U2059/net24 VSS VSS nmos W=0.2u L=0.04u
M16022 U2059/net28 U2059/net40 U2059/net64 VDD pmos W=0.205u L=0.04u
M16023 U2059/net24 WX9794 U2059/net32 VDD pmos W=0.205u L=0.04u
M16024 U2059/net28 U2059/net20 U2059/net24 VDD pmos W=0.205u L=0.04u
M16025 U2059/net40 U2059/net106 U2059/net108 VDD pmos W=0.205u L=0.04u
M16026 U2059/net40 WX9858 U2059/net104 VDD pmos W=0.205u L=0.04u
M16027 U2059/net20 U2059/net40 VDD VDD pmos W=0.205u L=0.04u
M16028 U2059/net106 WX9858 VDD VDD pmos W=0.205u L=0.04u
M16029 U2059/net104 WX9922 VDD VDD pmos W=0.205u L=0.04u
M16030 U2059/net30 WX9794 VDD VDD pmos W=0.205u L=0.04u
M16031 U2059/net108 U2059/net104 VDD VDD pmos W=0.205u L=0.04u
M16032 n1547 U2059/net28 VDD VDD pmos W=0.205u L=0.04u
M16033 U2059/net32 WX9730 VDD VDD pmos W=0.205u L=0.04u
M16034 U2059/net64 U2059/net24 VDD VDD pmos W=0.28u L=0.04u
M16035 U2059/net24 U2059/net30 U2059/net045 VDD pmos W=0.205u L=0.04u
M16036 U2059/net045 U2059/net32 VDD VDD pmos W=0.205u L=0.04u
M16037 WX8020 n1280 U2060/net26 VSS nmos W=0.155u L=0.04u
M16038 WX8020 n1451 U2060/net26 VSS nmos W=0.155u L=0.04u
M16039 U2060/net29 n1549 VSS VSS nmos W=0.155u L=0.04u
M16040 U2060/net26 n1548 U2060/net29 VSS nmos W=0.155u L=0.04u
M16041 U2060/net26 n1251 U2060/net29 VSS nmos W=0.155u L=0.04u
M16042 WX8020 n1451 U2060/net43 VDD pmos W=0.205u L=0.04u
M16043 WX8020 n1251 U2060/net49 VDD pmos W=0.205u L=0.04u
M16044 U2060/net49 n1548 VDD VDD pmos W=0.205u L=0.04u
M16045 U2060/net43 n1280 VDD VDD pmos W=0.205u L=0.04u
M16046 WX8020 n1549 VDD VDD pmos W=0.205u L=0.04u
M16047 U2061/net29 n1340 VSS VSS nmos W=0.155u L=0.04u
M16048 n1549 WX8275 U2061/net29 VSS nmos W=0.155u L=0.04u
M16049 n1549 n1309 U2061/net23 VSS nmos W=0.155u L=0.04u
M16050 U2061/net23 CRC_OUT_3_15 VSS VSS nmos W=0.155u L=0.04u
M16051 U2061/net20 CRC_OUT_3_15 n1549 VDD pmos W=0.205u L=0.04u
M16052 U2061/net20 n1309 n1549 VDD pmos W=0.205u L=0.04u
M16053 VDD WX8275 U2061/net20 VDD pmos W=0.205u L=0.04u
M16054 VDD n1340 U2061/net20 VDD pmos W=0.205u L=0.04u
M16055 n1451 n1550 VSS VSS nmos W=0.135u L=0.04u
M16056 n1451 n1550 VDD VDD pmos W=0.205u L=0.04u
M16057 U2063/net28 U2063/net20 U2063/net64 VSS nmos W=0.155u L=0.04u
M16058 U2063/net24 U2063/net30 U2063/net32 VSS nmos W=0.155u L=0.04u
M16059 U2063/net28 U2063/net40 U2063/net24 VSS nmos W=0.155u L=0.04u
M16060 U2063/net40 WX9856 U2063/net108 VSS nmos W=0.155u L=0.04u
M16061 U2063/net40 U2063/net106 U2063/net104 VSS nmos W=0.155u L=0.04u
M16062 U2063/net24 WX9792 U2063/net050 VSS nmos W=0.155u L=0.04u
M16063 U2063/net050 U2063/net32 VSS VSS nmos W=0.155u L=0.04u
M16064 U2063/net20 U2063/net40 VSS VSS nmos W=0.155u L=0.04u
M16065 U2063/net106 WX9856 VSS VSS nmos W=0.155u L=0.04u
M16066 U2063/net104 WX9920 VSS VSS nmos W=0.155u L=0.04u
M16067 U2063/net30 WX9792 VSS VSS nmos W=0.155u L=0.04u
M16068 U2063/net108 U2063/net104 VSS VSS nmos W=0.155u L=0.04u
M16069 n1550 U2063/net28 VSS VSS nmos W=0.155u L=0.04u
M16070 U2063/net32 WX9728 VSS VSS nmos W=0.155u L=0.04u
M16071 U2063/net64 U2063/net24 VSS VSS nmos W=0.2u L=0.04u
M16072 U2063/net28 U2063/net40 U2063/net64 VDD pmos W=0.205u L=0.04u
M16073 U2063/net24 WX9792 U2063/net32 VDD pmos W=0.205u L=0.04u
M16074 U2063/net28 U2063/net20 U2063/net24 VDD pmos W=0.205u L=0.04u
M16075 U2063/net40 U2063/net106 U2063/net108 VDD pmos W=0.205u L=0.04u
M16076 U2063/net40 WX9856 U2063/net104 VDD pmos W=0.205u L=0.04u
M16077 U2063/net20 U2063/net40 VDD VDD pmos W=0.205u L=0.04u
M16078 U2063/net106 WX9856 VDD VDD pmos W=0.205u L=0.04u
M16079 U2063/net104 WX9920 VDD VDD pmos W=0.205u L=0.04u
M16080 U2063/net30 WX9792 VDD VDD pmos W=0.205u L=0.04u
M16081 U2063/net108 U2063/net104 VDD VDD pmos W=0.205u L=0.04u
M16082 n1550 U2063/net28 VDD VDD pmos W=0.205u L=0.04u
M16083 U2063/net32 WX9728 VDD VDD pmos W=0.205u L=0.04u
M16084 U2063/net64 U2063/net24 VDD VDD pmos W=0.28u L=0.04u
M16085 U2063/net24 U2063/net30 U2063/net045 VDD pmos W=0.205u L=0.04u
M16086 U2063/net045 U2063/net32 VDD VDD pmos W=0.205u L=0.04u
M16087 WX8006 n1279 U2064/net26 VSS nmos W=0.155u L=0.04u
M16088 WX8006 n1454 U2064/net26 VSS nmos W=0.155u L=0.04u
M16089 U2064/net29 n1552 VSS VSS nmos W=0.155u L=0.04u
M16090 U2064/net26 n1551 U2064/net29 VSS nmos W=0.155u L=0.04u
M16091 U2064/net26 n1251 U2064/net29 VSS nmos W=0.155u L=0.04u
M16092 WX8006 n1454 U2064/net43 VDD pmos W=0.205u L=0.04u
M16093 WX8006 n1251 U2064/net49 VDD pmos W=0.205u L=0.04u
M16094 U2064/net49 n1551 VDD VDD pmos W=0.205u L=0.04u
M16095 U2064/net43 n1279 VDD VDD pmos W=0.205u L=0.04u
M16096 WX8006 n1552 VDD VDD pmos W=0.205u L=0.04u
M16097 U2065/net29 n1339 VSS VSS nmos W=0.155u L=0.04u
M16098 n1552 WX8273 U2065/net29 VSS nmos W=0.155u L=0.04u
M16099 n1552 n1309 U2065/net23 VSS nmos W=0.155u L=0.04u
M16100 U2065/net23 CRC_OUT_3_16 VSS VSS nmos W=0.155u L=0.04u
M16101 U2065/net20 CRC_OUT_3_16 n1552 VDD pmos W=0.205u L=0.04u
M16102 U2065/net20 n1309 n1552 VDD pmos W=0.205u L=0.04u
M16103 VDD WX8273 U2065/net20 VDD pmos W=0.205u L=0.04u
M16104 VDD n1339 U2065/net20 VDD pmos W=0.205u L=0.04u
M16105 n1454 n1553 VSS VSS nmos W=0.135u L=0.04u
M16106 n1454 n1553 VDD VDD pmos W=0.205u L=0.04u
M16107 U2067/net28 U2067/net20 U2067/net64 VSS nmos W=0.155u L=0.04u
M16108 U2067/net24 U2067/net30 U2067/net32 VSS nmos W=0.155u L=0.04u
M16109 U2067/net28 U2067/net40 U2067/net24 VSS nmos W=0.155u L=0.04u
M16110 U2067/net40 n1554 U2067/net108 VSS nmos W=0.155u L=0.04u
M16111 U2067/net40 U2067/net106 U2067/net104 VSS nmos W=0.155u L=0.04u
M16112 U2067/net24 WX9854 U2067/net050 VSS nmos W=0.155u L=0.04u
M16113 U2067/net050 U2067/net32 VSS VSS nmos W=0.155u L=0.04u
M16114 U2067/net20 U2067/net40 VSS VSS nmos W=0.155u L=0.04u
M16115 U2067/net106 n1554 VSS VSS nmos W=0.155u L=0.04u
M16116 U2067/net104 WX9918 VSS VSS nmos W=0.155u L=0.04u
M16117 U2067/net30 WX9854 VSS VSS nmos W=0.155u L=0.04u
M16118 U2067/net108 U2067/net104 VSS VSS nmos W=0.155u L=0.04u
M16119 n1553 U2067/net28 VSS VSS nmos W=0.155u L=0.04u
M16120 U2067/net32 WX9790 VSS VSS nmos W=0.155u L=0.04u
M16121 U2067/net64 U2067/net24 VSS VSS nmos W=0.2u L=0.04u
M16122 U2067/net28 U2067/net40 U2067/net64 VDD pmos W=0.205u L=0.04u
M16123 U2067/net24 WX9854 U2067/net32 VDD pmos W=0.205u L=0.04u
M16124 U2067/net28 U2067/net20 U2067/net24 VDD pmos W=0.205u L=0.04u
M16125 U2067/net40 U2067/net106 U2067/net108 VDD pmos W=0.205u L=0.04u
M16126 U2067/net40 n1554 U2067/net104 VDD pmos W=0.205u L=0.04u
M16127 U2067/net20 U2067/net40 VDD VDD pmos W=0.205u L=0.04u
M16128 U2067/net106 n1554 VDD VDD pmos W=0.205u L=0.04u
M16129 U2067/net104 WX9918 VDD VDD pmos W=0.205u L=0.04u
M16130 U2067/net30 WX9854 VDD VDD pmos W=0.205u L=0.04u
M16131 U2067/net108 U2067/net104 VDD VDD pmos W=0.205u L=0.04u
M16132 n1553 U2067/net28 VDD VDD pmos W=0.205u L=0.04u
M16133 U2067/net32 WX9790 VDD VDD pmos W=0.205u L=0.04u
M16134 U2067/net64 U2067/net24 VDD VDD pmos W=0.28u L=0.04u
M16135 U2067/net24 U2067/net30 U2067/net045 VDD pmos W=0.205u L=0.04u
M16136 U2067/net045 U2067/net32 VDD VDD pmos W=0.205u L=0.04u
M16137 U2068/net4 WX9726 U2068/net14 VSS nmos W=0.155u L=0.04u
M16138 U2068/net6 U2068/net10 U2068/net14 VSS nmos W=0.17u L=0.04u
M16139 U2068/net4 n1374 VSS VSS nmos W=0.155u L=0.04u
M16140 U2068/net6 U2068/net4 VSS VSS nmos W=0.17u L=0.04u
M16141 n1554 U2068/net14 VSS VSS nmos W=0.155u L=0.04u
M16142 U2068/net10 WX9726 VSS VSS nmos W=0.155u L=0.04u
M16143 U2068/net4 U2068/net10 U2068/net14 VDD pmos W=0.255u L=0.04u
M16144 U2068/net6 WX9726 U2068/net14 VDD pmos W=0.28u L=0.04u
M16145 U2068/net4 n1374 VDD VDD pmos W=0.205u L=0.04u
M16146 U2068/net6 U2068/net4 VDD VDD pmos W=0.24u L=0.04u
M16147 n1554 U2068/net14 VDD VDD pmos W=0.205u L=0.04u
M16148 U2068/net10 WX9726 VDD VDD pmos W=0.205u L=0.04u
M16149 WX80 U2069/net31 VDD VDD pmos W=0.205u L=0.04u
M16150 U2069/net30 n1354 U2069/net31 VDD pmos W=0.205u L=0.04u
M16151 U2069/net30 WX491 U2069/net31 VDD pmos W=0.205u L=0.04u
M16152 VDD n1557 U2069/net36 VDD pmos W=0.205u L=0.04u
M16153 U2069/net36 n1430 U2069/net30 VDD pmos W=0.205u L=0.04u
M16154 U2069/net36 n1556 U2069/net30 VDD pmos W=0.205u L=0.04u
M16155 U2069/net31 n1557 VSS VSS nmos W=0.155u L=0.04u
M16156 WX80 U2069/net31 VSS VSS nmos W=0.155u L=0.04u
M16157 U2069/net31 n1556 U2069/XI17-net17 VSS nmos W=0.155u L=0.04u
M16158 U2069/XI17-net17 n1430 VSS VSS nmos W=0.155u L=0.04u
M16159 U2069/net31 n1354 U2069/XI1-net17 VSS nmos W=0.155u L=0.04u
M16160 U2069/XI1-net17 WX491 VSS VSS nmos W=0.155u L=0.04u
M16161 U2070/net8 n1303 U2070/net26 VSS nmos W=0.155u L=0.04u
M16162 U2070/net26 CRC_OUT_9_28 VSS VSS nmos W=0.155u L=0.04u
M16163 U2070/net29 U2070/net8 VSS VSS nmos W=0.155u L=0.04u
M16164 U2070/net29 n1291 n1557 VSS nmos W=0.155u L=0.04u
M16165 U2070/net29 n1558 n1557 VSS nmos W=0.155u L=0.04u
M16166 U2070/net8 CRC_OUT_9_28 VDD VDD pmos W=0.205u L=0.04u
M16167 U2070/net8 n1303 VDD VDD pmos W=0.205u L=0.04u
M16168 n1557 U2070/net8 VDD VDD pmos W=0.205u L=0.04u
M16169 n1557 n1291 U2070/net20 VDD pmos W=0.205u L=0.04u
M16170 U2070/net20 n1558 VDD VDD pmos W=0.205u L=0.04u
M16171 WX7992 n1279 U2071/net26 VSS nmos W=0.155u L=0.04u
M16172 WX7992 n1457 U2071/net26 VSS nmos W=0.155u L=0.04u
M16173 U2071/net29 n1560 VSS VSS nmos W=0.155u L=0.04u
M16174 U2071/net26 n1559 U2071/net29 VSS nmos W=0.155u L=0.04u
M16175 U2071/net26 n1251 U2071/net29 VSS nmos W=0.155u L=0.04u
M16176 WX7992 n1457 U2071/net43 VDD pmos W=0.205u L=0.04u
M16177 WX7992 n1251 U2071/net49 VDD pmos W=0.205u L=0.04u
M16178 U2071/net49 n1559 VDD VDD pmos W=0.205u L=0.04u
M16179 U2071/net43 n1279 VDD VDD pmos W=0.205u L=0.04u
M16180 WX7992 n1560 VDD VDD pmos W=0.205u L=0.04u
M16181 U2072/net29 n1339 VSS VSS nmos W=0.155u L=0.04u
M16182 n1560 WX8271 U2072/net29 VSS nmos W=0.155u L=0.04u
M16183 n1560 n1309 U2072/net23 VSS nmos W=0.155u L=0.04u
M16184 U2072/net23 CRC_OUT_3_17 VSS VSS nmos W=0.155u L=0.04u
M16185 U2072/net20 CRC_OUT_3_17 n1560 VDD pmos W=0.205u L=0.04u
M16186 U2072/net20 n1309 n1560 VDD pmos W=0.205u L=0.04u
M16187 VDD WX8271 U2072/net20 VDD pmos W=0.205u L=0.04u
M16188 VDD n1339 U2072/net20 VDD pmos W=0.205u L=0.04u
M16189 n1457 n1561 VSS VSS nmos W=0.135u L=0.04u
M16190 n1457 n1561 VDD VDD pmos W=0.205u L=0.04u
M16191 U2074/net28 U2074/net20 U2074/net64 VSS nmos W=0.155u L=0.04u
M16192 U2074/net24 U2074/net30 U2074/net32 VSS nmos W=0.155u L=0.04u
M16193 U2074/net28 U2074/net40 U2074/net24 VSS nmos W=0.155u L=0.04u
M16194 U2074/net40 n1562 U2074/net108 VSS nmos W=0.155u L=0.04u
M16195 U2074/net40 U2074/net106 U2074/net104 VSS nmos W=0.155u L=0.04u
M16196 U2074/net24 WX9852 U2074/net050 VSS nmos W=0.155u L=0.04u
M16197 U2074/net050 U2074/net32 VSS VSS nmos W=0.155u L=0.04u
M16198 U2074/net20 U2074/net40 VSS VSS nmos W=0.155u L=0.04u
M16199 U2074/net106 n1562 VSS VSS nmos W=0.155u L=0.04u
M16200 U2074/net104 WX9916 VSS VSS nmos W=0.155u L=0.04u
M16201 U2074/net30 WX9852 VSS VSS nmos W=0.155u L=0.04u
M16202 U2074/net108 U2074/net104 VSS VSS nmos W=0.155u L=0.04u
M16203 n1561 U2074/net28 VSS VSS nmos W=0.155u L=0.04u
M16204 U2074/net32 WX9788 VSS VSS nmos W=0.155u L=0.04u
M16205 U2074/net64 U2074/net24 VSS VSS nmos W=0.2u L=0.04u
M16206 U2074/net28 U2074/net40 U2074/net64 VDD pmos W=0.205u L=0.04u
M16207 U2074/net24 WX9852 U2074/net32 VDD pmos W=0.205u L=0.04u
M16208 U2074/net28 U2074/net20 U2074/net24 VDD pmos W=0.205u L=0.04u
M16209 U2074/net40 U2074/net106 U2074/net108 VDD pmos W=0.205u L=0.04u
M16210 U2074/net40 n1562 U2074/net104 VDD pmos W=0.205u L=0.04u
M16211 U2074/net20 U2074/net40 VDD VDD pmos W=0.205u L=0.04u
M16212 U2074/net106 n1562 VDD VDD pmos W=0.205u L=0.04u
M16213 U2074/net104 WX9916 VDD VDD pmos W=0.205u L=0.04u
M16214 U2074/net30 WX9852 VDD VDD pmos W=0.205u L=0.04u
M16215 U2074/net108 U2074/net104 VDD VDD pmos W=0.205u L=0.04u
M16216 n1561 U2074/net28 VDD VDD pmos W=0.205u L=0.04u
M16217 U2074/net32 WX9788 VDD VDD pmos W=0.205u L=0.04u
M16218 U2074/net64 U2074/net24 VDD VDD pmos W=0.28u L=0.04u
M16219 U2074/net24 U2074/net30 U2074/net045 VDD pmos W=0.205u L=0.04u
M16220 U2074/net045 U2074/net32 VDD VDD pmos W=0.205u L=0.04u
M16221 U2075/net4 WX9724 U2075/net14 VSS nmos W=0.155u L=0.04u
M16222 U2075/net6 U2075/net10 U2075/net14 VSS nmos W=0.17u L=0.04u
M16223 U2075/net4 n1368 VSS VSS nmos W=0.155u L=0.04u
M16224 U2075/net6 U2075/net4 VSS VSS nmos W=0.17u L=0.04u
M16225 n1562 U2075/net14 VSS VSS nmos W=0.155u L=0.04u
M16226 U2075/net10 WX9724 VSS VSS nmos W=0.155u L=0.04u
M16227 U2075/net4 U2075/net10 U2075/net14 VDD pmos W=0.255u L=0.04u
M16228 U2075/net6 WX9724 U2075/net14 VDD pmos W=0.28u L=0.04u
M16229 U2075/net4 n1368 VDD VDD pmos W=0.205u L=0.04u
M16230 U2075/net6 U2075/net4 VDD VDD pmos W=0.24u L=0.04u
M16231 n1562 U2075/net14 VDD VDD pmos W=0.205u L=0.04u
M16232 U2075/net10 WX9724 VDD VDD pmos W=0.205u L=0.04u
M16233 WX7978 n1279 U2076/net26 VSS nmos W=0.155u L=0.04u
M16234 WX7978 n1460 U2076/net26 VSS nmos W=0.155u L=0.04u
M16235 U2076/net29 n1564 VSS VSS nmos W=0.155u L=0.04u
M16236 U2076/net26 n1563 U2076/net29 VSS nmos W=0.155u L=0.04u
M16237 U2076/net26 n1251 U2076/net29 VSS nmos W=0.155u L=0.04u
M16238 WX7978 n1460 U2076/net43 VDD pmos W=0.205u L=0.04u
M16239 WX7978 n1251 U2076/net49 VDD pmos W=0.205u L=0.04u
M16240 U2076/net49 n1563 VDD VDD pmos W=0.205u L=0.04u
M16241 U2076/net43 n1279 VDD VDD pmos W=0.205u L=0.04u
M16242 WX7978 n1564 VDD VDD pmos W=0.205u L=0.04u
M16243 U2077/net29 n1339 VSS VSS nmos W=0.155u L=0.04u
M16244 n1564 WX8269 U2077/net29 VSS nmos W=0.155u L=0.04u
M16245 n1564 n1308 U2077/net23 VSS nmos W=0.155u L=0.04u
M16246 U2077/net23 CRC_OUT_3_18 VSS VSS nmos W=0.155u L=0.04u
M16247 U2077/net20 CRC_OUT_3_18 n1564 VDD pmos W=0.205u L=0.04u
M16248 U2077/net20 n1308 n1564 VDD pmos W=0.205u L=0.04u
M16249 VDD WX8269 U2077/net20 VDD pmos W=0.205u L=0.04u
M16250 VDD n1339 U2077/net20 VDD pmos W=0.205u L=0.04u
M16251 n1460 n1565 VSS VSS nmos W=0.135u L=0.04u
M16252 n1460 n1565 VDD VDD pmos W=0.205u L=0.04u
M16253 U2079/net28 U2079/net20 U2079/net64 VSS nmos W=0.155u L=0.04u
M16254 U2079/net24 U2079/net30 U2079/net32 VSS nmos W=0.155u L=0.04u
M16255 U2079/net28 U2079/net40 U2079/net24 VSS nmos W=0.155u L=0.04u
M16256 U2079/net40 n1566 U2079/net108 VSS nmos W=0.155u L=0.04u
M16257 U2079/net40 U2079/net106 U2079/net104 VSS nmos W=0.155u L=0.04u
M16258 U2079/net24 WX9850 U2079/net050 VSS nmos W=0.155u L=0.04u
M16259 U2079/net050 U2079/net32 VSS VSS nmos W=0.155u L=0.04u
M16260 U2079/net20 U2079/net40 VSS VSS nmos W=0.155u L=0.04u
M16261 U2079/net106 n1566 VSS VSS nmos W=0.155u L=0.04u
M16262 U2079/net104 WX9914 VSS VSS nmos W=0.155u L=0.04u
M16263 U2079/net30 WX9850 VSS VSS nmos W=0.155u L=0.04u
M16264 U2079/net108 U2079/net104 VSS VSS nmos W=0.155u L=0.04u
M16265 n1565 U2079/net28 VSS VSS nmos W=0.155u L=0.04u
M16266 U2079/net32 WX9786 VSS VSS nmos W=0.155u L=0.04u
M16267 U2079/net64 U2079/net24 VSS VSS nmos W=0.2u L=0.04u
M16268 U2079/net28 U2079/net40 U2079/net64 VDD pmos W=0.205u L=0.04u
M16269 U2079/net24 WX9850 U2079/net32 VDD pmos W=0.205u L=0.04u
M16270 U2079/net28 U2079/net20 U2079/net24 VDD pmos W=0.205u L=0.04u
M16271 U2079/net40 U2079/net106 U2079/net108 VDD pmos W=0.205u L=0.04u
M16272 U2079/net40 n1566 U2079/net104 VDD pmos W=0.205u L=0.04u
M16273 U2079/net20 U2079/net40 VDD VDD pmos W=0.205u L=0.04u
M16274 U2079/net106 n1566 VDD VDD pmos W=0.205u L=0.04u
M16275 U2079/net104 WX9914 VDD VDD pmos W=0.205u L=0.04u
M16276 U2079/net30 WX9850 VDD VDD pmos W=0.205u L=0.04u
M16277 U2079/net108 U2079/net104 VDD VDD pmos W=0.205u L=0.04u
M16278 n1565 U2079/net28 VDD VDD pmos W=0.205u L=0.04u
M16279 U2079/net32 WX9786 VDD VDD pmos W=0.205u L=0.04u
M16280 U2079/net64 U2079/net24 VDD VDD pmos W=0.28u L=0.04u
M16281 U2079/net24 U2079/net30 U2079/net045 VDD pmos W=0.205u L=0.04u
M16282 U2079/net045 U2079/net32 VDD VDD pmos W=0.205u L=0.04u
M16283 U2080/net4 WX9722 U2080/net14 VSS nmos W=0.155u L=0.04u
M16284 U2080/net6 U2080/net10 U2080/net14 VSS nmos W=0.17u L=0.04u
M16285 U2080/net4 n1368 VSS VSS nmos W=0.155u L=0.04u
M16286 U2080/net6 U2080/net4 VSS VSS nmos W=0.17u L=0.04u
M16287 n1566 U2080/net14 VSS VSS nmos W=0.155u L=0.04u
M16288 U2080/net10 WX9722 VSS VSS nmos W=0.155u L=0.04u
M16289 U2080/net4 U2080/net10 U2080/net14 VDD pmos W=0.255u L=0.04u
M16290 U2080/net6 WX9722 U2080/net14 VDD pmos W=0.28u L=0.04u
M16291 U2080/net4 n1368 VDD VDD pmos W=0.205u L=0.04u
M16292 U2080/net6 U2080/net4 VDD VDD pmos W=0.24u L=0.04u
M16293 n1566 U2080/net14 VDD VDD pmos W=0.205u L=0.04u
M16294 U2080/net10 WX9722 VDD VDD pmos W=0.205u L=0.04u
M16295 WX7964 n1279 U2081/net26 VSS nmos W=0.155u L=0.04u
M16296 WX7964 n1463 U2081/net26 VSS nmos W=0.155u L=0.04u
M16297 U2081/net29 n1568 VSS VSS nmos W=0.155u L=0.04u
M16298 U2081/net26 n1567 U2081/net29 VSS nmos W=0.155u L=0.04u
M16299 U2081/net26 n1251 U2081/net29 VSS nmos W=0.155u L=0.04u
M16300 WX7964 n1463 U2081/net43 VDD pmos W=0.205u L=0.04u
M16301 WX7964 n1251 U2081/net49 VDD pmos W=0.205u L=0.04u
M16302 U2081/net49 n1567 VDD VDD pmos W=0.205u L=0.04u
M16303 U2081/net43 n1279 VDD VDD pmos W=0.205u L=0.04u
M16304 WX7964 n1568 VDD VDD pmos W=0.205u L=0.04u
M16305 U2082/net29 n1339 VSS VSS nmos W=0.155u L=0.04u
M16306 n1568 WX8267 U2082/net29 VSS nmos W=0.155u L=0.04u
M16307 n1568 n1308 U2082/net23 VSS nmos W=0.155u L=0.04u
M16308 U2082/net23 CRC_OUT_3_19 VSS VSS nmos W=0.155u L=0.04u
M16309 U2082/net20 CRC_OUT_3_19 n1568 VDD pmos W=0.205u L=0.04u
M16310 U2082/net20 n1308 n1568 VDD pmos W=0.205u L=0.04u
M16311 VDD WX8267 U2082/net20 VDD pmos W=0.205u L=0.04u
M16312 VDD n1339 U2082/net20 VDD pmos W=0.205u L=0.04u
M16313 n1463 n1569 VSS VSS nmos W=0.135u L=0.04u
M16314 n1463 n1569 VDD VDD pmos W=0.205u L=0.04u
M16315 U2084/net28 U2084/net20 U2084/net64 VSS nmos W=0.155u L=0.04u
M16316 U2084/net24 U2084/net30 U2084/net32 VSS nmos W=0.155u L=0.04u
M16317 U2084/net28 U2084/net40 U2084/net24 VSS nmos W=0.155u L=0.04u
M16318 U2084/net40 n1570 U2084/net108 VSS nmos W=0.155u L=0.04u
M16319 U2084/net40 U2084/net106 U2084/net104 VSS nmos W=0.155u L=0.04u
M16320 U2084/net24 WX9848 U2084/net050 VSS nmos W=0.155u L=0.04u
M16321 U2084/net050 U2084/net32 VSS VSS nmos W=0.155u L=0.04u
M16322 U2084/net20 U2084/net40 VSS VSS nmos W=0.155u L=0.04u
M16323 U2084/net106 n1570 VSS VSS nmos W=0.155u L=0.04u
M16324 U2084/net104 WX9912 VSS VSS nmos W=0.155u L=0.04u
M16325 U2084/net30 WX9848 VSS VSS nmos W=0.155u L=0.04u
M16326 U2084/net108 U2084/net104 VSS VSS nmos W=0.155u L=0.04u
M16327 n1569 U2084/net28 VSS VSS nmos W=0.155u L=0.04u
M16328 U2084/net32 WX9784 VSS VSS nmos W=0.155u L=0.04u
M16329 U2084/net64 U2084/net24 VSS VSS nmos W=0.2u L=0.04u
M16330 U2084/net28 U2084/net40 U2084/net64 VDD pmos W=0.205u L=0.04u
M16331 U2084/net24 WX9848 U2084/net32 VDD pmos W=0.205u L=0.04u
M16332 U2084/net28 U2084/net20 U2084/net24 VDD pmos W=0.205u L=0.04u
M16333 U2084/net40 U2084/net106 U2084/net108 VDD pmos W=0.205u L=0.04u
M16334 U2084/net40 n1570 U2084/net104 VDD pmos W=0.205u L=0.04u
M16335 U2084/net20 U2084/net40 VDD VDD pmos W=0.205u L=0.04u
M16336 U2084/net106 n1570 VDD VDD pmos W=0.205u L=0.04u
M16337 U2084/net104 WX9912 VDD VDD pmos W=0.205u L=0.04u
M16338 U2084/net30 WX9848 VDD VDD pmos W=0.205u L=0.04u
M16339 U2084/net108 U2084/net104 VDD VDD pmos W=0.205u L=0.04u
M16340 n1569 U2084/net28 VDD VDD pmos W=0.205u L=0.04u
M16341 U2084/net32 WX9784 VDD VDD pmos W=0.205u L=0.04u
M16342 U2084/net64 U2084/net24 VDD VDD pmos W=0.28u L=0.04u
M16343 U2084/net24 U2084/net30 U2084/net045 VDD pmos W=0.205u L=0.04u
M16344 U2084/net045 U2084/net32 VDD VDD pmos W=0.205u L=0.04u
M16345 U2085/net4 WX9720 U2085/net14 VSS nmos W=0.155u L=0.04u
M16346 U2085/net6 U2085/net10 U2085/net14 VSS nmos W=0.17u L=0.04u
M16347 U2085/net4 n1368 VSS VSS nmos W=0.155u L=0.04u
M16348 U2085/net6 U2085/net4 VSS VSS nmos W=0.17u L=0.04u
M16349 n1570 U2085/net14 VSS VSS nmos W=0.155u L=0.04u
M16350 U2085/net10 WX9720 VSS VSS nmos W=0.155u L=0.04u
M16351 U2085/net4 U2085/net10 U2085/net14 VDD pmos W=0.255u L=0.04u
M16352 U2085/net6 WX9720 U2085/net14 VDD pmos W=0.28u L=0.04u
M16353 U2085/net4 n1368 VDD VDD pmos W=0.205u L=0.04u
M16354 U2085/net6 U2085/net4 VDD VDD pmos W=0.24u L=0.04u
M16355 n1570 U2085/net14 VDD VDD pmos W=0.205u L=0.04u
M16356 U2085/net10 WX9720 VDD VDD pmos W=0.205u L=0.04u
M16357 WX7950 n1279 U2086/net26 VSS nmos W=0.155u L=0.04u
M16358 WX7950 n1466 U2086/net26 VSS nmos W=0.155u L=0.04u
M16359 U2086/net29 n1572 VSS VSS nmos W=0.155u L=0.04u
M16360 U2086/net26 n1571 U2086/net29 VSS nmos W=0.155u L=0.04u
M16361 U2086/net26 n1251 U2086/net29 VSS nmos W=0.155u L=0.04u
M16362 WX7950 n1466 U2086/net43 VDD pmos W=0.205u L=0.04u
M16363 WX7950 n1251 U2086/net49 VDD pmos W=0.205u L=0.04u
M16364 U2086/net49 n1571 VDD VDD pmos W=0.205u L=0.04u
M16365 U2086/net43 n1279 VDD VDD pmos W=0.205u L=0.04u
M16366 WX7950 n1572 VDD VDD pmos W=0.205u L=0.04u
M16367 U2087/net29 n1339 VSS VSS nmos W=0.155u L=0.04u
M16368 n1572 WX8265 U2087/net29 VSS nmos W=0.155u L=0.04u
M16369 n1572 n1308 U2087/net23 VSS nmos W=0.155u L=0.04u
M16370 U2087/net23 CRC_OUT_3_20 VSS VSS nmos W=0.155u L=0.04u
M16371 U2087/net20 CRC_OUT_3_20 n1572 VDD pmos W=0.205u L=0.04u
M16372 U2087/net20 n1308 n1572 VDD pmos W=0.205u L=0.04u
M16373 VDD WX8265 U2087/net20 VDD pmos W=0.205u L=0.04u
M16374 VDD n1339 U2087/net20 VDD pmos W=0.205u L=0.04u
M16375 n1466 n1573 VSS VSS nmos W=0.135u L=0.04u
M16376 n1466 n1573 VDD VDD pmos W=0.205u L=0.04u
M16377 U2089/net28 U2089/net20 U2089/net64 VSS nmos W=0.155u L=0.04u
M16378 U2089/net24 U2089/net30 U2089/net32 VSS nmos W=0.155u L=0.04u
M16379 U2089/net28 U2089/net40 U2089/net24 VSS nmos W=0.155u L=0.04u
M16380 U2089/net40 n1574 U2089/net108 VSS nmos W=0.155u L=0.04u
M16381 U2089/net40 U2089/net106 U2089/net104 VSS nmos W=0.155u L=0.04u
M16382 U2089/net24 WX9846 U2089/net050 VSS nmos W=0.155u L=0.04u
M16383 U2089/net050 U2089/net32 VSS VSS nmos W=0.155u L=0.04u
M16384 U2089/net20 U2089/net40 VSS VSS nmos W=0.155u L=0.04u
M16385 U2089/net106 n1574 VSS VSS nmos W=0.155u L=0.04u
M16386 U2089/net104 WX9910 VSS VSS nmos W=0.155u L=0.04u
M16387 U2089/net30 WX9846 VSS VSS nmos W=0.155u L=0.04u
M16388 U2089/net108 U2089/net104 VSS VSS nmos W=0.155u L=0.04u
M16389 n1573 U2089/net28 VSS VSS nmos W=0.155u L=0.04u
M16390 U2089/net32 WX9782 VSS VSS nmos W=0.155u L=0.04u
M16391 U2089/net64 U2089/net24 VSS VSS nmos W=0.2u L=0.04u
M16392 U2089/net28 U2089/net40 U2089/net64 VDD pmos W=0.205u L=0.04u
M16393 U2089/net24 WX9846 U2089/net32 VDD pmos W=0.205u L=0.04u
M16394 U2089/net28 U2089/net20 U2089/net24 VDD pmos W=0.205u L=0.04u
M16395 U2089/net40 U2089/net106 U2089/net108 VDD pmos W=0.205u L=0.04u
M16396 U2089/net40 n1574 U2089/net104 VDD pmos W=0.205u L=0.04u
M16397 U2089/net20 U2089/net40 VDD VDD pmos W=0.205u L=0.04u
M16398 U2089/net106 n1574 VDD VDD pmos W=0.205u L=0.04u
M16399 U2089/net104 WX9910 VDD VDD pmos W=0.205u L=0.04u
M16400 U2089/net30 WX9846 VDD VDD pmos W=0.205u L=0.04u
M16401 U2089/net108 U2089/net104 VDD VDD pmos W=0.205u L=0.04u
M16402 n1573 U2089/net28 VDD VDD pmos W=0.205u L=0.04u
M16403 U2089/net32 WX9782 VDD VDD pmos W=0.205u L=0.04u
M16404 U2089/net64 U2089/net24 VDD VDD pmos W=0.28u L=0.04u
M16405 U2089/net24 U2089/net30 U2089/net045 VDD pmos W=0.205u L=0.04u
M16406 U2089/net045 U2089/net32 VDD VDD pmos W=0.205u L=0.04u
M16407 U2090/net4 WX9718 U2090/net14 VSS nmos W=0.155u L=0.04u
M16408 U2090/net6 U2090/net10 U2090/net14 VSS nmos W=0.17u L=0.04u
M16409 U2090/net4 n1368 VSS VSS nmos W=0.155u L=0.04u
M16410 U2090/net6 U2090/net4 VSS VSS nmos W=0.17u L=0.04u
M16411 n1574 U2090/net14 VSS VSS nmos W=0.155u L=0.04u
M16412 U2090/net10 WX9718 VSS VSS nmos W=0.155u L=0.04u
M16413 U2090/net4 U2090/net10 U2090/net14 VDD pmos W=0.255u L=0.04u
M16414 U2090/net6 WX9718 U2090/net14 VDD pmos W=0.28u L=0.04u
M16415 U2090/net4 n1368 VDD VDD pmos W=0.205u L=0.04u
M16416 U2090/net6 U2090/net4 VDD VDD pmos W=0.24u L=0.04u
M16417 n1574 U2090/net14 VDD VDD pmos W=0.205u L=0.04u
M16418 U2090/net10 WX9718 VDD VDD pmos W=0.205u L=0.04u
M16419 WX7936 n1279 U2091/net26 VSS nmos W=0.155u L=0.04u
M16420 WX7936 n1469 U2091/net26 VSS nmos W=0.155u L=0.04u
M16421 U2091/net29 n1576 VSS VSS nmos W=0.155u L=0.04u
M16422 U2091/net26 n1575 U2091/net29 VSS nmos W=0.155u L=0.04u
M16423 U2091/net26 n1251 U2091/net29 VSS nmos W=0.155u L=0.04u
M16424 WX7936 n1469 U2091/net43 VDD pmos W=0.205u L=0.04u
M16425 WX7936 n1251 U2091/net49 VDD pmos W=0.205u L=0.04u
M16426 U2091/net49 n1575 VDD VDD pmos W=0.205u L=0.04u
M16427 U2091/net43 n1279 VDD VDD pmos W=0.205u L=0.04u
M16428 WX7936 n1576 VDD VDD pmos W=0.205u L=0.04u
M16429 U2092/net29 n1339 VSS VSS nmos W=0.155u L=0.04u
M16430 n1576 WX8263 U2092/net29 VSS nmos W=0.155u L=0.04u
M16431 n1576 n1308 U2092/net23 VSS nmos W=0.155u L=0.04u
M16432 U2092/net23 CRC_OUT_3_21 VSS VSS nmos W=0.155u L=0.04u
M16433 U2092/net20 CRC_OUT_3_21 n1576 VDD pmos W=0.205u L=0.04u
M16434 U2092/net20 n1308 n1576 VDD pmos W=0.205u L=0.04u
M16435 VDD WX8263 U2092/net20 VDD pmos W=0.205u L=0.04u
M16436 VDD n1339 U2092/net20 VDD pmos W=0.205u L=0.04u
M16437 n1469 n1577 VSS VSS nmos W=0.135u L=0.04u
M16438 n1469 n1577 VDD VDD pmos W=0.205u L=0.04u
M16439 U2094/net28 U2094/net20 U2094/net64 VSS nmos W=0.155u L=0.04u
M16440 U2094/net24 U2094/net30 U2094/net32 VSS nmos W=0.155u L=0.04u
M16441 U2094/net28 U2094/net40 U2094/net24 VSS nmos W=0.155u L=0.04u
M16442 U2094/net40 n1578 U2094/net108 VSS nmos W=0.155u L=0.04u
M16443 U2094/net40 U2094/net106 U2094/net104 VSS nmos W=0.155u L=0.04u
M16444 U2094/net24 WX9844 U2094/net050 VSS nmos W=0.155u L=0.04u
M16445 U2094/net050 U2094/net32 VSS VSS nmos W=0.155u L=0.04u
M16446 U2094/net20 U2094/net40 VSS VSS nmos W=0.155u L=0.04u
M16447 U2094/net106 n1578 VSS VSS nmos W=0.155u L=0.04u
M16448 U2094/net104 WX9908 VSS VSS nmos W=0.155u L=0.04u
M16449 U2094/net30 WX9844 VSS VSS nmos W=0.155u L=0.04u
M16450 U2094/net108 U2094/net104 VSS VSS nmos W=0.155u L=0.04u
M16451 n1577 U2094/net28 VSS VSS nmos W=0.155u L=0.04u
M16452 U2094/net32 WX9780 VSS VSS nmos W=0.155u L=0.04u
M16453 U2094/net64 U2094/net24 VSS VSS nmos W=0.2u L=0.04u
M16454 U2094/net28 U2094/net40 U2094/net64 VDD pmos W=0.205u L=0.04u
M16455 U2094/net24 WX9844 U2094/net32 VDD pmos W=0.205u L=0.04u
M16456 U2094/net28 U2094/net20 U2094/net24 VDD pmos W=0.205u L=0.04u
M16457 U2094/net40 U2094/net106 U2094/net108 VDD pmos W=0.205u L=0.04u
M16458 U2094/net40 n1578 U2094/net104 VDD pmos W=0.205u L=0.04u
M16459 U2094/net20 U2094/net40 VDD VDD pmos W=0.205u L=0.04u
M16460 U2094/net106 n1578 VDD VDD pmos W=0.205u L=0.04u
M16461 U2094/net104 WX9908 VDD VDD pmos W=0.205u L=0.04u
M16462 U2094/net30 WX9844 VDD VDD pmos W=0.205u L=0.04u
M16463 U2094/net108 U2094/net104 VDD VDD pmos W=0.205u L=0.04u
M16464 n1577 U2094/net28 VDD VDD pmos W=0.205u L=0.04u
M16465 U2094/net32 WX9780 VDD VDD pmos W=0.205u L=0.04u
M16466 U2094/net64 U2094/net24 VDD VDD pmos W=0.28u L=0.04u
M16467 U2094/net24 U2094/net30 U2094/net045 VDD pmos W=0.205u L=0.04u
M16468 U2094/net045 U2094/net32 VDD VDD pmos W=0.205u L=0.04u
M16469 U2095/net4 WX9716 U2095/net14 VSS nmos W=0.155u L=0.04u
M16470 U2095/net6 U2095/net10 U2095/net14 VSS nmos W=0.17u L=0.04u
M16471 U2095/net4 n1368 VSS VSS nmos W=0.155u L=0.04u
M16472 U2095/net6 U2095/net4 VSS VSS nmos W=0.17u L=0.04u
M16473 n1578 U2095/net14 VSS VSS nmos W=0.155u L=0.04u
M16474 U2095/net10 WX9716 VSS VSS nmos W=0.155u L=0.04u
M16475 U2095/net4 U2095/net10 U2095/net14 VDD pmos W=0.255u L=0.04u
M16476 U2095/net6 WX9716 U2095/net14 VDD pmos W=0.28u L=0.04u
M16477 U2095/net4 n1368 VDD VDD pmos W=0.205u L=0.04u
M16478 U2095/net6 U2095/net4 VDD VDD pmos W=0.24u L=0.04u
M16479 n1578 U2095/net14 VDD VDD pmos W=0.205u L=0.04u
M16480 U2095/net10 WX9716 VDD VDD pmos W=0.205u L=0.04u
M16481 WX7922 n1279 U2096/net26 VSS nmos W=0.155u L=0.04u
M16482 WX7922 n1472 U2096/net26 VSS nmos W=0.155u L=0.04u
M16483 U2096/net29 n1580 VSS VSS nmos W=0.155u L=0.04u
M16484 U2096/net26 n1579 U2096/net29 VSS nmos W=0.155u L=0.04u
M16485 U2096/net26 n1251 U2096/net29 VSS nmos W=0.155u L=0.04u
M16486 WX7922 n1472 U2096/net43 VDD pmos W=0.205u L=0.04u
M16487 WX7922 n1251 U2096/net49 VDD pmos W=0.205u L=0.04u
M16488 U2096/net49 n1579 VDD VDD pmos W=0.205u L=0.04u
M16489 U2096/net43 n1279 VDD VDD pmos W=0.205u L=0.04u
M16490 WX7922 n1580 VDD VDD pmos W=0.205u L=0.04u
M16491 U2097/net29 n1339 VSS VSS nmos W=0.155u L=0.04u
M16492 n1580 WX8261 U2097/net29 VSS nmos W=0.155u L=0.04u
M16493 n1580 n1308 U2097/net23 VSS nmos W=0.155u L=0.04u
M16494 U2097/net23 CRC_OUT_3_22 VSS VSS nmos W=0.155u L=0.04u
M16495 U2097/net20 CRC_OUT_3_22 n1580 VDD pmos W=0.205u L=0.04u
M16496 U2097/net20 n1308 n1580 VDD pmos W=0.205u L=0.04u
M16497 VDD WX8261 U2097/net20 VDD pmos W=0.205u L=0.04u
M16498 VDD n1339 U2097/net20 VDD pmos W=0.205u L=0.04u
M16499 n1472 n1581 VSS VSS nmos W=0.135u L=0.04u
M16500 n1472 n1581 VDD VDD pmos W=0.205u L=0.04u
M16501 U2099/net28 U2099/net20 U2099/net64 VSS nmos W=0.155u L=0.04u
M16502 U2099/net24 U2099/net30 U2099/net32 VSS nmos W=0.155u L=0.04u
M16503 U2099/net28 U2099/net40 U2099/net24 VSS nmos W=0.155u L=0.04u
M16504 U2099/net40 n1582 U2099/net108 VSS nmos W=0.155u L=0.04u
M16505 U2099/net40 U2099/net106 U2099/net104 VSS nmos W=0.155u L=0.04u
M16506 U2099/net24 WX9842 U2099/net050 VSS nmos W=0.155u L=0.04u
M16507 U2099/net050 U2099/net32 VSS VSS nmos W=0.155u L=0.04u
M16508 U2099/net20 U2099/net40 VSS VSS nmos W=0.155u L=0.04u
M16509 U2099/net106 n1582 VSS VSS nmos W=0.155u L=0.04u
M16510 U2099/net104 WX9906 VSS VSS nmos W=0.155u L=0.04u
M16511 U2099/net30 WX9842 VSS VSS nmos W=0.155u L=0.04u
M16512 U2099/net108 U2099/net104 VSS VSS nmos W=0.155u L=0.04u
M16513 n1581 U2099/net28 VSS VSS nmos W=0.155u L=0.04u
M16514 U2099/net32 WX9778 VSS VSS nmos W=0.155u L=0.04u
M16515 U2099/net64 U2099/net24 VSS VSS nmos W=0.2u L=0.04u
M16516 U2099/net28 U2099/net40 U2099/net64 VDD pmos W=0.205u L=0.04u
M16517 U2099/net24 WX9842 U2099/net32 VDD pmos W=0.205u L=0.04u
M16518 U2099/net28 U2099/net20 U2099/net24 VDD pmos W=0.205u L=0.04u
M16519 U2099/net40 U2099/net106 U2099/net108 VDD pmos W=0.205u L=0.04u
M16520 U2099/net40 n1582 U2099/net104 VDD pmos W=0.205u L=0.04u
M16521 U2099/net20 U2099/net40 VDD VDD pmos W=0.205u L=0.04u
M16522 U2099/net106 n1582 VDD VDD pmos W=0.205u L=0.04u
M16523 U2099/net104 WX9906 VDD VDD pmos W=0.205u L=0.04u
M16524 U2099/net30 WX9842 VDD VDD pmos W=0.205u L=0.04u
M16525 U2099/net108 U2099/net104 VDD VDD pmos W=0.205u L=0.04u
M16526 n1581 U2099/net28 VDD VDD pmos W=0.205u L=0.04u
M16527 U2099/net32 WX9778 VDD VDD pmos W=0.205u L=0.04u
M16528 U2099/net64 U2099/net24 VDD VDD pmos W=0.28u L=0.04u
M16529 U2099/net24 U2099/net30 U2099/net045 VDD pmos W=0.205u L=0.04u
M16530 U2099/net045 U2099/net32 VDD VDD pmos W=0.205u L=0.04u
M16531 U2100/net4 WX9714 U2100/net14 VSS nmos W=0.155u L=0.04u
M16532 U2100/net6 U2100/net10 U2100/net14 VSS nmos W=0.17u L=0.04u
M16533 U2100/net4 n1368 VSS VSS nmos W=0.155u L=0.04u
M16534 U2100/net6 U2100/net4 VSS VSS nmos W=0.17u L=0.04u
M16535 n1582 U2100/net14 VSS VSS nmos W=0.155u L=0.04u
M16536 U2100/net10 WX9714 VSS VSS nmos W=0.155u L=0.04u
M16537 U2100/net4 U2100/net10 U2100/net14 VDD pmos W=0.255u L=0.04u
M16538 U2100/net6 WX9714 U2100/net14 VDD pmos W=0.28u L=0.04u
M16539 U2100/net4 n1368 VDD VDD pmos W=0.205u L=0.04u
M16540 U2100/net6 U2100/net4 VDD VDD pmos W=0.24u L=0.04u
M16541 n1582 U2100/net14 VDD VDD pmos W=0.205u L=0.04u
M16542 U2100/net10 WX9714 VDD VDD pmos W=0.205u L=0.04u
M16543 WX7908 n1279 U2101/net26 VSS nmos W=0.155u L=0.04u
M16544 WX7908 n1475 U2101/net26 VSS nmos W=0.155u L=0.04u
M16545 U2101/net29 n1584 VSS VSS nmos W=0.155u L=0.04u
M16546 U2101/net26 n1583 U2101/net29 VSS nmos W=0.155u L=0.04u
M16547 U2101/net26 n1251 U2101/net29 VSS nmos W=0.155u L=0.04u
M16548 WX7908 n1475 U2101/net43 VDD pmos W=0.205u L=0.04u
M16549 WX7908 n1251 U2101/net49 VDD pmos W=0.205u L=0.04u
M16550 U2101/net49 n1583 VDD VDD pmos W=0.205u L=0.04u
M16551 U2101/net43 n1279 VDD VDD pmos W=0.205u L=0.04u
M16552 WX7908 n1584 VDD VDD pmos W=0.205u L=0.04u
M16553 U2102/net29 n1339 VSS VSS nmos W=0.155u L=0.04u
M16554 n1584 WX8259 U2102/net29 VSS nmos W=0.155u L=0.04u
M16555 n1584 n1308 U2102/net23 VSS nmos W=0.155u L=0.04u
M16556 U2102/net23 CRC_OUT_3_23 VSS VSS nmos W=0.155u L=0.04u
M16557 U2102/net20 CRC_OUT_3_23 n1584 VDD pmos W=0.205u L=0.04u
M16558 U2102/net20 n1308 n1584 VDD pmos W=0.205u L=0.04u
M16559 VDD WX8259 U2102/net20 VDD pmos W=0.205u L=0.04u
M16560 VDD n1339 U2102/net20 VDD pmos W=0.205u L=0.04u
M16561 n1475 n1585 VSS VSS nmos W=0.135u L=0.04u
M16562 n1475 n1585 VDD VDD pmos W=0.205u L=0.04u
M16563 U2104/net28 U2104/net20 U2104/net64 VSS nmos W=0.155u L=0.04u
M16564 U2104/net24 U2104/net30 U2104/net32 VSS nmos W=0.155u L=0.04u
M16565 U2104/net28 U2104/net40 U2104/net24 VSS nmos W=0.155u L=0.04u
M16566 U2104/net40 n1586 U2104/net108 VSS nmos W=0.155u L=0.04u
M16567 U2104/net40 U2104/net106 U2104/net104 VSS nmos W=0.155u L=0.04u
M16568 U2104/net24 WX9840 U2104/net050 VSS nmos W=0.155u L=0.04u
M16569 U2104/net050 U2104/net32 VSS VSS nmos W=0.155u L=0.04u
M16570 U2104/net20 U2104/net40 VSS VSS nmos W=0.155u L=0.04u
M16571 U2104/net106 n1586 VSS VSS nmos W=0.155u L=0.04u
M16572 U2104/net104 WX9904 VSS VSS nmos W=0.155u L=0.04u
M16573 U2104/net30 WX9840 VSS VSS nmos W=0.155u L=0.04u
M16574 U2104/net108 U2104/net104 VSS VSS nmos W=0.155u L=0.04u
M16575 n1585 U2104/net28 VSS VSS nmos W=0.155u L=0.04u
M16576 U2104/net32 WX9776 VSS VSS nmos W=0.155u L=0.04u
M16577 U2104/net64 U2104/net24 VSS VSS nmos W=0.2u L=0.04u
M16578 U2104/net28 U2104/net40 U2104/net64 VDD pmos W=0.205u L=0.04u
M16579 U2104/net24 WX9840 U2104/net32 VDD pmos W=0.205u L=0.04u
M16580 U2104/net28 U2104/net20 U2104/net24 VDD pmos W=0.205u L=0.04u
M16581 U2104/net40 U2104/net106 U2104/net108 VDD pmos W=0.205u L=0.04u
M16582 U2104/net40 n1586 U2104/net104 VDD pmos W=0.205u L=0.04u
M16583 U2104/net20 U2104/net40 VDD VDD pmos W=0.205u L=0.04u
M16584 U2104/net106 n1586 VDD VDD pmos W=0.205u L=0.04u
M16585 U2104/net104 WX9904 VDD VDD pmos W=0.205u L=0.04u
M16586 U2104/net30 WX9840 VDD VDD pmos W=0.205u L=0.04u
M16587 U2104/net108 U2104/net104 VDD VDD pmos W=0.205u L=0.04u
M16588 n1585 U2104/net28 VDD VDD pmos W=0.205u L=0.04u
M16589 U2104/net32 WX9776 VDD VDD pmos W=0.205u L=0.04u
M16590 U2104/net64 U2104/net24 VDD VDD pmos W=0.28u L=0.04u
M16591 U2104/net24 U2104/net30 U2104/net045 VDD pmos W=0.205u L=0.04u
M16592 U2104/net045 U2104/net32 VDD VDD pmos W=0.205u L=0.04u
M16593 U2105/net4 WX9712 U2105/net14 VSS nmos W=0.155u L=0.04u
M16594 U2105/net6 U2105/net10 U2105/net14 VSS nmos W=0.17u L=0.04u
M16595 U2105/net4 n1368 VSS VSS nmos W=0.155u L=0.04u
M16596 U2105/net6 U2105/net4 VSS VSS nmos W=0.17u L=0.04u
M16597 n1586 U2105/net14 VSS VSS nmos W=0.155u L=0.04u
M16598 U2105/net10 WX9712 VSS VSS nmos W=0.155u L=0.04u
M16599 U2105/net4 U2105/net10 U2105/net14 VDD pmos W=0.255u L=0.04u
M16600 U2105/net6 WX9712 U2105/net14 VDD pmos W=0.28u L=0.04u
M16601 U2105/net4 n1368 VDD VDD pmos W=0.205u L=0.04u
M16602 U2105/net6 U2105/net4 VDD VDD pmos W=0.24u L=0.04u
M16603 n1586 U2105/net14 VDD VDD pmos W=0.205u L=0.04u
M16604 U2105/net10 WX9712 VDD VDD pmos W=0.205u L=0.04u
M16605 WX7894 n1279 U2106/net26 VSS nmos W=0.155u L=0.04u
M16606 WX7894 n1478 U2106/net26 VSS nmos W=0.155u L=0.04u
M16607 U2106/net29 n1588 VSS VSS nmos W=0.155u L=0.04u
M16608 U2106/net26 n1587 U2106/net29 VSS nmos W=0.155u L=0.04u
M16609 U2106/net26 n1251 U2106/net29 VSS nmos W=0.155u L=0.04u
M16610 WX7894 n1478 U2106/net43 VDD pmos W=0.205u L=0.04u
M16611 WX7894 n1251 U2106/net49 VDD pmos W=0.205u L=0.04u
M16612 U2106/net49 n1587 VDD VDD pmos W=0.205u L=0.04u
M16613 U2106/net43 n1279 VDD VDD pmos W=0.205u L=0.04u
M16614 WX7894 n1588 VDD VDD pmos W=0.205u L=0.04u
M16615 U2107/net29 n1339 VSS VSS nmos W=0.155u L=0.04u
M16616 n1588 WX8257 U2107/net29 VSS nmos W=0.155u L=0.04u
M16617 n1588 n1308 U2107/net23 VSS nmos W=0.155u L=0.04u
M16618 U2107/net23 CRC_OUT_3_24 VSS VSS nmos W=0.155u L=0.04u
M16619 U2107/net20 CRC_OUT_3_24 n1588 VDD pmos W=0.205u L=0.04u
M16620 U2107/net20 n1308 n1588 VDD pmos W=0.205u L=0.04u
M16621 VDD WX8257 U2107/net20 VDD pmos W=0.205u L=0.04u
M16622 VDD n1339 U2107/net20 VDD pmos W=0.205u L=0.04u
M16623 n1478 n1589 VSS VSS nmos W=0.135u L=0.04u
M16624 n1478 n1589 VDD VDD pmos W=0.205u L=0.04u
M16625 U2109/net28 U2109/net20 U2109/net64 VSS nmos W=0.155u L=0.04u
M16626 U2109/net24 U2109/net30 U2109/net32 VSS nmos W=0.155u L=0.04u
M16627 U2109/net28 U2109/net40 U2109/net24 VSS nmos W=0.155u L=0.04u
M16628 U2109/net40 n1590 U2109/net108 VSS nmos W=0.155u L=0.04u
M16629 U2109/net40 U2109/net106 U2109/net104 VSS nmos W=0.155u L=0.04u
M16630 U2109/net24 WX9838 U2109/net050 VSS nmos W=0.155u L=0.04u
M16631 U2109/net050 U2109/net32 VSS VSS nmos W=0.155u L=0.04u
M16632 U2109/net20 U2109/net40 VSS VSS nmos W=0.155u L=0.04u
M16633 U2109/net106 n1590 VSS VSS nmos W=0.155u L=0.04u
M16634 U2109/net104 WX9902 VSS VSS nmos W=0.155u L=0.04u
M16635 U2109/net30 WX9838 VSS VSS nmos W=0.155u L=0.04u
M16636 U2109/net108 U2109/net104 VSS VSS nmos W=0.155u L=0.04u
M16637 n1589 U2109/net28 VSS VSS nmos W=0.155u L=0.04u
M16638 U2109/net32 WX9774 VSS VSS nmos W=0.155u L=0.04u
M16639 U2109/net64 U2109/net24 VSS VSS nmos W=0.2u L=0.04u
M16640 U2109/net28 U2109/net40 U2109/net64 VDD pmos W=0.205u L=0.04u
M16641 U2109/net24 WX9838 U2109/net32 VDD pmos W=0.205u L=0.04u
M16642 U2109/net28 U2109/net20 U2109/net24 VDD pmos W=0.205u L=0.04u
M16643 U2109/net40 U2109/net106 U2109/net108 VDD pmos W=0.205u L=0.04u
M16644 U2109/net40 n1590 U2109/net104 VDD pmos W=0.205u L=0.04u
M16645 U2109/net20 U2109/net40 VDD VDD pmos W=0.205u L=0.04u
M16646 U2109/net106 n1590 VDD VDD pmos W=0.205u L=0.04u
M16647 U2109/net104 WX9902 VDD VDD pmos W=0.205u L=0.04u
M16648 U2109/net30 WX9838 VDD VDD pmos W=0.205u L=0.04u
M16649 U2109/net108 U2109/net104 VDD VDD pmos W=0.205u L=0.04u
M16650 n1589 U2109/net28 VDD VDD pmos W=0.205u L=0.04u
M16651 U2109/net32 WX9774 VDD VDD pmos W=0.205u L=0.04u
M16652 U2109/net64 U2109/net24 VDD VDD pmos W=0.28u L=0.04u
M16653 U2109/net24 U2109/net30 U2109/net045 VDD pmos W=0.205u L=0.04u
M16654 U2109/net045 U2109/net32 VDD VDD pmos W=0.205u L=0.04u
M16655 U2110/net4 WX9710 U2110/net14 VSS nmos W=0.155u L=0.04u
M16656 U2110/net6 U2110/net10 U2110/net14 VSS nmos W=0.17u L=0.04u
M16657 U2110/net4 n1368 VSS VSS nmos W=0.155u L=0.04u
M16658 U2110/net6 U2110/net4 VSS VSS nmos W=0.17u L=0.04u
M16659 n1590 U2110/net14 VSS VSS nmos W=0.155u L=0.04u
M16660 U2110/net10 WX9710 VSS VSS nmos W=0.155u L=0.04u
M16661 U2110/net4 U2110/net10 U2110/net14 VDD pmos W=0.255u L=0.04u
M16662 U2110/net6 WX9710 U2110/net14 VDD pmos W=0.28u L=0.04u
M16663 U2110/net4 n1368 VDD VDD pmos W=0.205u L=0.04u
M16664 U2110/net6 U2110/net4 VDD VDD pmos W=0.24u L=0.04u
M16665 n1590 U2110/net14 VDD VDD pmos W=0.205u L=0.04u
M16666 U2110/net10 WX9710 VDD VDD pmos W=0.205u L=0.04u
M16667 WX7880 n1279 U2111/net26 VSS nmos W=0.155u L=0.04u
M16668 WX7880 n1481 U2111/net26 VSS nmos W=0.155u L=0.04u
M16669 U2111/net29 n1592 VSS VSS nmos W=0.155u L=0.04u
M16670 U2111/net26 n1591 U2111/net29 VSS nmos W=0.155u L=0.04u
M16671 U2111/net26 n1250 U2111/net29 VSS nmos W=0.155u L=0.04u
M16672 WX7880 n1481 U2111/net43 VDD pmos W=0.205u L=0.04u
M16673 WX7880 n1250 U2111/net49 VDD pmos W=0.205u L=0.04u
M16674 U2111/net49 n1591 VDD VDD pmos W=0.205u L=0.04u
M16675 U2111/net43 n1279 VDD VDD pmos W=0.205u L=0.04u
M16676 WX7880 n1592 VDD VDD pmos W=0.205u L=0.04u
M16677 U2112/net29 n1339 VSS VSS nmos W=0.155u L=0.04u
M16678 n1592 WX8255 U2112/net29 VSS nmos W=0.155u L=0.04u
M16679 n1592 n1308 U2112/net23 VSS nmos W=0.155u L=0.04u
M16680 U2112/net23 CRC_OUT_3_25 VSS VSS nmos W=0.155u L=0.04u
M16681 U2112/net20 CRC_OUT_3_25 n1592 VDD pmos W=0.205u L=0.04u
M16682 U2112/net20 n1308 n1592 VDD pmos W=0.205u L=0.04u
M16683 VDD WX8255 U2112/net20 VDD pmos W=0.205u L=0.04u
M16684 VDD n1339 U2112/net20 VDD pmos W=0.205u L=0.04u
M16685 n1481 n1593 VSS VSS nmos W=0.135u L=0.04u
M16686 n1481 n1593 VDD VDD pmos W=0.205u L=0.04u
M16687 U2114/net28 U2114/net20 U2114/net64 VSS nmos W=0.155u L=0.04u
M16688 U2114/net24 U2114/net30 U2114/net32 VSS nmos W=0.155u L=0.04u
M16689 U2114/net28 U2114/net40 U2114/net24 VSS nmos W=0.155u L=0.04u
M16690 U2114/net40 n1594 U2114/net108 VSS nmos W=0.155u L=0.04u
M16691 U2114/net40 U2114/net106 U2114/net104 VSS nmos W=0.155u L=0.04u
M16692 U2114/net24 WX9836 U2114/net050 VSS nmos W=0.155u L=0.04u
M16693 U2114/net050 U2114/net32 VSS VSS nmos W=0.155u L=0.04u
M16694 U2114/net20 U2114/net40 VSS VSS nmos W=0.155u L=0.04u
M16695 U2114/net106 n1594 VSS VSS nmos W=0.155u L=0.04u
M16696 U2114/net104 WX9900 VSS VSS nmos W=0.155u L=0.04u
M16697 U2114/net30 WX9836 VSS VSS nmos W=0.155u L=0.04u
M16698 U2114/net108 U2114/net104 VSS VSS nmos W=0.155u L=0.04u
M16699 n1593 U2114/net28 VSS VSS nmos W=0.155u L=0.04u
M16700 U2114/net32 WX9772 VSS VSS nmos W=0.155u L=0.04u
M16701 U2114/net64 U2114/net24 VSS VSS nmos W=0.2u L=0.04u
M16702 U2114/net28 U2114/net40 U2114/net64 VDD pmos W=0.205u L=0.04u
M16703 U2114/net24 WX9836 U2114/net32 VDD pmos W=0.205u L=0.04u
M16704 U2114/net28 U2114/net20 U2114/net24 VDD pmos W=0.205u L=0.04u
M16705 U2114/net40 U2114/net106 U2114/net108 VDD pmos W=0.205u L=0.04u
M16706 U2114/net40 n1594 U2114/net104 VDD pmos W=0.205u L=0.04u
M16707 U2114/net20 U2114/net40 VDD VDD pmos W=0.205u L=0.04u
M16708 U2114/net106 n1594 VDD VDD pmos W=0.205u L=0.04u
M16709 U2114/net104 WX9900 VDD VDD pmos W=0.205u L=0.04u
M16710 U2114/net30 WX9836 VDD VDD pmos W=0.205u L=0.04u
M16711 U2114/net108 U2114/net104 VDD VDD pmos W=0.205u L=0.04u
M16712 n1593 U2114/net28 VDD VDD pmos W=0.205u L=0.04u
M16713 U2114/net32 WX9772 VDD VDD pmos W=0.205u L=0.04u
M16714 U2114/net64 U2114/net24 VDD VDD pmos W=0.28u L=0.04u
M16715 U2114/net24 U2114/net30 U2114/net045 VDD pmos W=0.205u L=0.04u
M16716 U2114/net045 U2114/net32 VDD VDD pmos W=0.205u L=0.04u
M16717 U2115/net4 WX9708 U2115/net14 VSS nmos W=0.155u L=0.04u
M16718 U2115/net6 U2115/net10 U2115/net14 VSS nmos W=0.17u L=0.04u
M16719 U2115/net4 n1368 VSS VSS nmos W=0.155u L=0.04u
M16720 U2115/net6 U2115/net4 VSS VSS nmos W=0.17u L=0.04u
M16721 n1594 U2115/net14 VSS VSS nmos W=0.155u L=0.04u
M16722 U2115/net10 WX9708 VSS VSS nmos W=0.155u L=0.04u
M16723 U2115/net4 U2115/net10 U2115/net14 VDD pmos W=0.255u L=0.04u
M16724 U2115/net6 WX9708 U2115/net14 VDD pmos W=0.28u L=0.04u
M16725 U2115/net4 n1368 VDD VDD pmos W=0.205u L=0.04u
M16726 U2115/net6 U2115/net4 VDD VDD pmos W=0.24u L=0.04u
M16727 n1594 U2115/net14 VDD VDD pmos W=0.205u L=0.04u
M16728 U2115/net10 WX9708 VDD VDD pmos W=0.205u L=0.04u
M16729 WX7866 n1279 U2116/net26 VSS nmos W=0.155u L=0.04u
M16730 WX7866 n1484 U2116/net26 VSS nmos W=0.155u L=0.04u
M16731 U2116/net29 n1596 VSS VSS nmos W=0.155u L=0.04u
M16732 U2116/net26 n1595 U2116/net29 VSS nmos W=0.155u L=0.04u
M16733 U2116/net26 n1250 U2116/net29 VSS nmos W=0.155u L=0.04u
M16734 WX7866 n1484 U2116/net43 VDD pmos W=0.205u L=0.04u
M16735 WX7866 n1250 U2116/net49 VDD pmos W=0.205u L=0.04u
M16736 U2116/net49 n1595 VDD VDD pmos W=0.205u L=0.04u
M16737 U2116/net43 n1279 VDD VDD pmos W=0.205u L=0.04u
M16738 WX7866 n1596 VDD VDD pmos W=0.205u L=0.04u
M16739 U2117/net29 n1339 VSS VSS nmos W=0.155u L=0.04u
M16740 n1596 WX8253 U2117/net29 VSS nmos W=0.155u L=0.04u
M16741 n1596 n1308 U2117/net23 VSS nmos W=0.155u L=0.04u
M16742 U2117/net23 CRC_OUT_3_26 VSS VSS nmos W=0.155u L=0.04u
M16743 U2117/net20 CRC_OUT_3_26 n1596 VDD pmos W=0.205u L=0.04u
M16744 U2117/net20 n1308 n1596 VDD pmos W=0.205u L=0.04u
M16745 VDD WX8253 U2117/net20 VDD pmos W=0.205u L=0.04u
M16746 VDD n1339 U2117/net20 VDD pmos W=0.205u L=0.04u
M16747 n1484 n1597 VSS VSS nmos W=0.135u L=0.04u
M16748 n1484 n1597 VDD VDD pmos W=0.205u L=0.04u
M16749 U2119/net28 U2119/net20 U2119/net64 VSS nmos W=0.155u L=0.04u
M16750 U2119/net24 U2119/net30 U2119/net32 VSS nmos W=0.155u L=0.04u
M16751 U2119/net28 U2119/net40 U2119/net24 VSS nmos W=0.155u L=0.04u
M16752 U2119/net40 n1598 U2119/net108 VSS nmos W=0.155u L=0.04u
M16753 U2119/net40 U2119/net106 U2119/net104 VSS nmos W=0.155u L=0.04u
M16754 U2119/net24 WX9834 U2119/net050 VSS nmos W=0.155u L=0.04u
M16755 U2119/net050 U2119/net32 VSS VSS nmos W=0.155u L=0.04u
M16756 U2119/net20 U2119/net40 VSS VSS nmos W=0.155u L=0.04u
M16757 U2119/net106 n1598 VSS VSS nmos W=0.155u L=0.04u
M16758 U2119/net104 WX9898 VSS VSS nmos W=0.155u L=0.04u
M16759 U2119/net30 WX9834 VSS VSS nmos W=0.155u L=0.04u
M16760 U2119/net108 U2119/net104 VSS VSS nmos W=0.155u L=0.04u
M16761 n1597 U2119/net28 VSS VSS nmos W=0.155u L=0.04u
M16762 U2119/net32 WX9770 VSS VSS nmos W=0.155u L=0.04u
M16763 U2119/net64 U2119/net24 VSS VSS nmos W=0.2u L=0.04u
M16764 U2119/net28 U2119/net40 U2119/net64 VDD pmos W=0.205u L=0.04u
M16765 U2119/net24 WX9834 U2119/net32 VDD pmos W=0.205u L=0.04u
M16766 U2119/net28 U2119/net20 U2119/net24 VDD pmos W=0.205u L=0.04u
M16767 U2119/net40 U2119/net106 U2119/net108 VDD pmos W=0.205u L=0.04u
M16768 U2119/net40 n1598 U2119/net104 VDD pmos W=0.205u L=0.04u
M16769 U2119/net20 U2119/net40 VDD VDD pmos W=0.205u L=0.04u
M16770 U2119/net106 n1598 VDD VDD pmos W=0.205u L=0.04u
M16771 U2119/net104 WX9898 VDD VDD pmos W=0.205u L=0.04u
M16772 U2119/net30 WX9834 VDD VDD pmos W=0.205u L=0.04u
M16773 U2119/net108 U2119/net104 VDD VDD pmos W=0.205u L=0.04u
M16774 n1597 U2119/net28 VDD VDD pmos W=0.205u L=0.04u
M16775 U2119/net32 WX9770 VDD VDD pmos W=0.205u L=0.04u
M16776 U2119/net64 U2119/net24 VDD VDD pmos W=0.28u L=0.04u
M16777 U2119/net24 U2119/net30 U2119/net045 VDD pmos W=0.205u L=0.04u
M16778 U2119/net045 U2119/net32 VDD VDD pmos W=0.205u L=0.04u
M16779 U2120/net4 WX9706 U2120/net14 VSS nmos W=0.155u L=0.04u
M16780 U2120/net6 U2120/net10 U2120/net14 VSS nmos W=0.17u L=0.04u
M16781 U2120/net4 n1368 VSS VSS nmos W=0.155u L=0.04u
M16782 U2120/net6 U2120/net4 VSS VSS nmos W=0.17u L=0.04u
M16783 n1598 U2120/net14 VSS VSS nmos W=0.155u L=0.04u
M16784 U2120/net10 WX9706 VSS VSS nmos W=0.155u L=0.04u
M16785 U2120/net4 U2120/net10 U2120/net14 VDD pmos W=0.255u L=0.04u
M16786 U2120/net6 WX9706 U2120/net14 VDD pmos W=0.28u L=0.04u
M16787 U2120/net4 n1368 VDD VDD pmos W=0.205u L=0.04u
M16788 U2120/net6 U2120/net4 VDD VDD pmos W=0.24u L=0.04u
M16789 n1598 U2120/net14 VDD VDD pmos W=0.205u L=0.04u
M16790 U2120/net10 WX9706 VDD VDD pmos W=0.205u L=0.04u
M16791 WX7852 n1279 U2121/net26 VSS nmos W=0.155u L=0.04u
M16792 WX7852 n1487 U2121/net26 VSS nmos W=0.155u L=0.04u
M16793 U2121/net29 n1600 VSS VSS nmos W=0.155u L=0.04u
M16794 U2121/net26 n1599 U2121/net29 VSS nmos W=0.155u L=0.04u
M16795 U2121/net26 n1250 U2121/net29 VSS nmos W=0.155u L=0.04u
M16796 WX7852 n1487 U2121/net43 VDD pmos W=0.205u L=0.04u
M16797 WX7852 n1250 U2121/net49 VDD pmos W=0.205u L=0.04u
M16798 U2121/net49 n1599 VDD VDD pmos W=0.205u L=0.04u
M16799 U2121/net43 n1279 VDD VDD pmos W=0.205u L=0.04u
M16800 WX7852 n1600 VDD VDD pmos W=0.205u L=0.04u
M16801 U2122/net29 n1339 VSS VSS nmos W=0.155u L=0.04u
M16802 n1600 WX8251 U2122/net29 VSS nmos W=0.155u L=0.04u
M16803 n1600 n1308 U2122/net23 VSS nmos W=0.155u L=0.04u
M16804 U2122/net23 CRC_OUT_3_27 VSS VSS nmos W=0.155u L=0.04u
M16805 U2122/net20 CRC_OUT_3_27 n1600 VDD pmos W=0.205u L=0.04u
M16806 U2122/net20 n1308 n1600 VDD pmos W=0.205u L=0.04u
M16807 VDD WX8251 U2122/net20 VDD pmos W=0.205u L=0.04u
M16808 VDD n1339 U2122/net20 VDD pmos W=0.205u L=0.04u
M16809 n1487 n1601 VSS VSS nmos W=0.135u L=0.04u
M16810 n1487 n1601 VDD VDD pmos W=0.205u L=0.04u
M16811 U2124/net28 U2124/net20 U2124/net64 VSS nmos W=0.155u L=0.04u
M16812 U2124/net24 U2124/net30 U2124/net32 VSS nmos W=0.155u L=0.04u
M16813 U2124/net28 U2124/net40 U2124/net24 VSS nmos W=0.155u L=0.04u
M16814 U2124/net40 n1602 U2124/net108 VSS nmos W=0.155u L=0.04u
M16815 U2124/net40 U2124/net106 U2124/net104 VSS nmos W=0.155u L=0.04u
M16816 U2124/net24 WX9832 U2124/net050 VSS nmos W=0.155u L=0.04u
M16817 U2124/net050 U2124/net32 VSS VSS nmos W=0.155u L=0.04u
M16818 U2124/net20 U2124/net40 VSS VSS nmos W=0.155u L=0.04u
M16819 U2124/net106 n1602 VSS VSS nmos W=0.155u L=0.04u
M16820 U2124/net104 WX9896 VSS VSS nmos W=0.155u L=0.04u
M16821 U2124/net30 WX9832 VSS VSS nmos W=0.155u L=0.04u
M16822 U2124/net108 U2124/net104 VSS VSS nmos W=0.155u L=0.04u
M16823 n1601 U2124/net28 VSS VSS nmos W=0.155u L=0.04u
M16824 U2124/net32 WX9768 VSS VSS nmos W=0.155u L=0.04u
M16825 U2124/net64 U2124/net24 VSS VSS nmos W=0.2u L=0.04u
M16826 U2124/net28 U2124/net40 U2124/net64 VDD pmos W=0.205u L=0.04u
M16827 U2124/net24 WX9832 U2124/net32 VDD pmos W=0.205u L=0.04u
M16828 U2124/net28 U2124/net20 U2124/net24 VDD pmos W=0.205u L=0.04u
M16829 U2124/net40 U2124/net106 U2124/net108 VDD pmos W=0.205u L=0.04u
M16830 U2124/net40 n1602 U2124/net104 VDD pmos W=0.205u L=0.04u
M16831 U2124/net20 U2124/net40 VDD VDD pmos W=0.205u L=0.04u
M16832 U2124/net106 n1602 VDD VDD pmos W=0.205u L=0.04u
M16833 U2124/net104 WX9896 VDD VDD pmos W=0.205u L=0.04u
M16834 U2124/net30 WX9832 VDD VDD pmos W=0.205u L=0.04u
M16835 U2124/net108 U2124/net104 VDD VDD pmos W=0.205u L=0.04u
M16836 n1601 U2124/net28 VDD VDD pmos W=0.205u L=0.04u
M16837 U2124/net32 WX9768 VDD VDD pmos W=0.205u L=0.04u
M16838 U2124/net64 U2124/net24 VDD VDD pmos W=0.28u L=0.04u
M16839 U2124/net24 U2124/net30 U2124/net045 VDD pmos W=0.205u L=0.04u
M16840 U2124/net045 U2124/net32 VDD VDD pmos W=0.205u L=0.04u
M16841 U2125/net4 WX9704 U2125/net14 VSS nmos W=0.155u L=0.04u
M16842 U2125/net6 U2125/net10 U2125/net14 VSS nmos W=0.17u L=0.04u
M16843 U2125/net4 n1368 VSS VSS nmos W=0.155u L=0.04u
M16844 U2125/net6 U2125/net4 VSS VSS nmos W=0.17u L=0.04u
M16845 n1602 U2125/net14 VSS VSS nmos W=0.155u L=0.04u
M16846 U2125/net10 WX9704 VSS VSS nmos W=0.155u L=0.04u
M16847 U2125/net4 U2125/net10 U2125/net14 VDD pmos W=0.255u L=0.04u
M16848 U2125/net6 WX9704 U2125/net14 VDD pmos W=0.28u L=0.04u
M16849 U2125/net4 n1368 VDD VDD pmos W=0.205u L=0.04u
M16850 U2125/net6 U2125/net4 VDD VDD pmos W=0.24u L=0.04u
M16851 n1602 U2125/net14 VDD VDD pmos W=0.205u L=0.04u
M16852 U2125/net10 WX9704 VDD VDD pmos W=0.205u L=0.04u
M16853 WX7838 n1279 U2126/net26 VSS nmos W=0.155u L=0.04u
M16854 WX7838 n1490 U2126/net26 VSS nmos W=0.155u L=0.04u
M16855 U2126/net29 n1604 VSS VSS nmos W=0.155u L=0.04u
M16856 U2126/net26 n1603 U2126/net29 VSS nmos W=0.155u L=0.04u
M16857 U2126/net26 n1250 U2126/net29 VSS nmos W=0.155u L=0.04u
M16858 WX7838 n1490 U2126/net43 VDD pmos W=0.205u L=0.04u
M16859 WX7838 n1250 U2126/net49 VDD pmos W=0.205u L=0.04u
M16860 U2126/net49 n1603 VDD VDD pmos W=0.205u L=0.04u
M16861 U2126/net43 n1279 VDD VDD pmos W=0.205u L=0.04u
M16862 WX7838 n1604 VDD VDD pmos W=0.205u L=0.04u
M16863 U2127/net29 n1339 VSS VSS nmos W=0.155u L=0.04u
M16864 n1604 WX8249 U2127/net29 VSS nmos W=0.155u L=0.04u
M16865 n1604 n1308 U2127/net23 VSS nmos W=0.155u L=0.04u
M16866 U2127/net23 CRC_OUT_3_28 VSS VSS nmos W=0.155u L=0.04u
M16867 U2127/net20 CRC_OUT_3_28 n1604 VDD pmos W=0.205u L=0.04u
M16868 U2127/net20 n1308 n1604 VDD pmos W=0.205u L=0.04u
M16869 VDD WX8249 U2127/net20 VDD pmos W=0.205u L=0.04u
M16870 VDD n1339 U2127/net20 VDD pmos W=0.205u L=0.04u
M16871 n1490 n1605 VSS VSS nmos W=0.135u L=0.04u
M16872 n1490 n1605 VDD VDD pmos W=0.205u L=0.04u
M16873 U2129/net28 U2129/net20 U2129/net64 VSS nmos W=0.155u L=0.04u
M16874 U2129/net24 U2129/net30 U2129/net32 VSS nmos W=0.155u L=0.04u
M16875 U2129/net28 U2129/net40 U2129/net24 VSS nmos W=0.155u L=0.04u
M16876 U2129/net40 n1606 U2129/net108 VSS nmos W=0.155u L=0.04u
M16877 U2129/net40 U2129/net106 U2129/net104 VSS nmos W=0.155u L=0.04u
M16878 U2129/net24 WX9830 U2129/net050 VSS nmos W=0.155u L=0.04u
M16879 U2129/net050 U2129/net32 VSS VSS nmos W=0.155u L=0.04u
M16880 U2129/net20 U2129/net40 VSS VSS nmos W=0.155u L=0.04u
M16881 U2129/net106 n1606 VSS VSS nmos W=0.155u L=0.04u
M16882 U2129/net104 WX9894 VSS VSS nmos W=0.155u L=0.04u
M16883 U2129/net30 WX9830 VSS VSS nmos W=0.155u L=0.04u
M16884 U2129/net108 U2129/net104 VSS VSS nmos W=0.155u L=0.04u
M16885 n1605 U2129/net28 VSS VSS nmos W=0.155u L=0.04u
M16886 U2129/net32 WX9766 VSS VSS nmos W=0.155u L=0.04u
M16887 U2129/net64 U2129/net24 VSS VSS nmos W=0.2u L=0.04u
M16888 U2129/net28 U2129/net40 U2129/net64 VDD pmos W=0.205u L=0.04u
M16889 U2129/net24 WX9830 U2129/net32 VDD pmos W=0.205u L=0.04u
M16890 U2129/net28 U2129/net20 U2129/net24 VDD pmos W=0.205u L=0.04u
M16891 U2129/net40 U2129/net106 U2129/net108 VDD pmos W=0.205u L=0.04u
M16892 U2129/net40 n1606 U2129/net104 VDD pmos W=0.205u L=0.04u
M16893 U2129/net20 U2129/net40 VDD VDD pmos W=0.205u L=0.04u
M16894 U2129/net106 n1606 VDD VDD pmos W=0.205u L=0.04u
M16895 U2129/net104 WX9894 VDD VDD pmos W=0.205u L=0.04u
M16896 U2129/net30 WX9830 VDD VDD pmos W=0.205u L=0.04u
M16897 U2129/net108 U2129/net104 VDD VDD pmos W=0.205u L=0.04u
M16898 n1605 U2129/net28 VDD VDD pmos W=0.205u L=0.04u
M16899 U2129/net32 WX9766 VDD VDD pmos W=0.205u L=0.04u
M16900 U2129/net64 U2129/net24 VDD VDD pmos W=0.28u L=0.04u
M16901 U2129/net24 U2129/net30 U2129/net045 VDD pmos W=0.205u L=0.04u
M16902 U2129/net045 U2129/net32 VDD VDD pmos W=0.205u L=0.04u
M16903 U2130/net4 WX9702 U2130/net14 VSS nmos W=0.155u L=0.04u
M16904 U2130/net6 U2130/net10 U2130/net14 VSS nmos W=0.17u L=0.04u
M16905 U2130/net4 n1369 VSS VSS nmos W=0.155u L=0.04u
M16906 U2130/net6 U2130/net4 VSS VSS nmos W=0.17u L=0.04u
M16907 n1606 U2130/net14 VSS VSS nmos W=0.155u L=0.04u
M16908 U2130/net10 WX9702 VSS VSS nmos W=0.155u L=0.04u
M16909 U2130/net4 U2130/net10 U2130/net14 VDD pmos W=0.255u L=0.04u
M16910 U2130/net6 WX9702 U2130/net14 VDD pmos W=0.28u L=0.04u
M16911 U2130/net4 n1369 VDD VDD pmos W=0.205u L=0.04u
M16912 U2130/net6 U2130/net4 VDD VDD pmos W=0.24u L=0.04u
M16913 n1606 U2130/net14 VDD VDD pmos W=0.205u L=0.04u
M16914 U2130/net10 WX9702 VDD VDD pmos W=0.205u L=0.04u
M16915 WX7824 n1278 U2131/net26 VSS nmos W=0.155u L=0.04u
M16916 WX7824 n1493 U2131/net26 VSS nmos W=0.155u L=0.04u
M16917 U2131/net29 n1608 VSS VSS nmos W=0.155u L=0.04u
M16918 U2131/net26 n1607 U2131/net29 VSS nmos W=0.155u L=0.04u
M16919 U2131/net26 n1250 U2131/net29 VSS nmos W=0.155u L=0.04u
M16920 WX7824 n1493 U2131/net43 VDD pmos W=0.205u L=0.04u
M16921 WX7824 n1250 U2131/net49 VDD pmos W=0.205u L=0.04u
M16922 U2131/net49 n1607 VDD VDD pmos W=0.205u L=0.04u
M16923 U2131/net43 n1278 VDD VDD pmos W=0.205u L=0.04u
M16924 WX7824 n1608 VDD VDD pmos W=0.205u L=0.04u
M16925 U2132/net29 n1338 VSS VSS nmos W=0.155u L=0.04u
M16926 n1608 WX8247 U2132/net29 VSS nmos W=0.155u L=0.04u
M16927 n1608 n1308 U2132/net23 VSS nmos W=0.155u L=0.04u
M16928 U2132/net23 CRC_OUT_3_29 VSS VSS nmos W=0.155u L=0.04u
M16929 U2132/net20 CRC_OUT_3_29 n1608 VDD pmos W=0.205u L=0.04u
M16930 U2132/net20 n1308 n1608 VDD pmos W=0.205u L=0.04u
M16931 VDD WX8247 U2132/net20 VDD pmos W=0.205u L=0.04u
M16932 VDD n1338 U2132/net20 VDD pmos W=0.205u L=0.04u
M16933 n1493 n1609 VSS VSS nmos W=0.135u L=0.04u
M16934 n1493 n1609 VDD VDD pmos W=0.205u L=0.04u
M16935 U2134/net28 U2134/net20 U2134/net64 VSS nmos W=0.155u L=0.04u
M16936 U2134/net24 U2134/net30 U2134/net32 VSS nmos W=0.155u L=0.04u
M16937 U2134/net28 U2134/net40 U2134/net24 VSS nmos W=0.155u L=0.04u
M16938 U2134/net40 n1610 U2134/net108 VSS nmos W=0.155u L=0.04u
M16939 U2134/net40 U2134/net106 U2134/net104 VSS nmos W=0.155u L=0.04u
M16940 U2134/net24 WX9828 U2134/net050 VSS nmos W=0.155u L=0.04u
M16941 U2134/net050 U2134/net32 VSS VSS nmos W=0.155u L=0.04u
M16942 U2134/net20 U2134/net40 VSS VSS nmos W=0.155u L=0.04u
M16943 U2134/net106 n1610 VSS VSS nmos W=0.155u L=0.04u
M16944 U2134/net104 WX9892 VSS VSS nmos W=0.155u L=0.04u
M16945 U2134/net30 WX9828 VSS VSS nmos W=0.155u L=0.04u
M16946 U2134/net108 U2134/net104 VSS VSS nmos W=0.155u L=0.04u
M16947 n1609 U2134/net28 VSS VSS nmos W=0.155u L=0.04u
M16948 U2134/net32 WX9764 VSS VSS nmos W=0.155u L=0.04u
M16949 U2134/net64 U2134/net24 VSS VSS nmos W=0.2u L=0.04u
M16950 U2134/net28 U2134/net40 U2134/net64 VDD pmos W=0.205u L=0.04u
M16951 U2134/net24 WX9828 U2134/net32 VDD pmos W=0.205u L=0.04u
M16952 U2134/net28 U2134/net20 U2134/net24 VDD pmos W=0.205u L=0.04u
M16953 U2134/net40 U2134/net106 U2134/net108 VDD pmos W=0.205u L=0.04u
M16954 U2134/net40 n1610 U2134/net104 VDD pmos W=0.205u L=0.04u
M16955 U2134/net20 U2134/net40 VDD VDD pmos W=0.205u L=0.04u
M16956 U2134/net106 n1610 VDD VDD pmos W=0.205u L=0.04u
M16957 U2134/net104 WX9892 VDD VDD pmos W=0.205u L=0.04u
M16958 U2134/net30 WX9828 VDD VDD pmos W=0.205u L=0.04u
M16959 U2134/net108 U2134/net104 VDD VDD pmos W=0.205u L=0.04u
M16960 n1609 U2134/net28 VDD VDD pmos W=0.205u L=0.04u
M16961 U2134/net32 WX9764 VDD VDD pmos W=0.205u L=0.04u
M16962 U2134/net64 U2134/net24 VDD VDD pmos W=0.28u L=0.04u
M16963 U2134/net24 U2134/net30 U2134/net045 VDD pmos W=0.205u L=0.04u
M16964 U2134/net045 U2134/net32 VDD VDD pmos W=0.205u L=0.04u
M16965 U2135/net4 WX9700 U2135/net14 VSS nmos W=0.155u L=0.04u
M16966 U2135/net6 U2135/net10 U2135/net14 VSS nmos W=0.17u L=0.04u
M16967 U2135/net4 n1369 VSS VSS nmos W=0.155u L=0.04u
M16968 U2135/net6 U2135/net4 VSS VSS nmos W=0.17u L=0.04u
M16969 n1610 U2135/net14 VSS VSS nmos W=0.155u L=0.04u
M16970 U2135/net10 WX9700 VSS VSS nmos W=0.155u L=0.04u
M16971 U2135/net4 U2135/net10 U2135/net14 VDD pmos W=0.255u L=0.04u
M16972 U2135/net6 WX9700 U2135/net14 VDD pmos W=0.28u L=0.04u
M16973 U2135/net4 n1369 VDD VDD pmos W=0.205u L=0.04u
M16974 U2135/net6 U2135/net4 VDD VDD pmos W=0.24u L=0.04u
M16975 n1610 U2135/net14 VDD VDD pmos W=0.205u L=0.04u
M16976 U2135/net10 WX9700 VDD VDD pmos W=0.205u L=0.04u
M16977 WX7810 n1278 U2136/net26 VSS nmos W=0.155u L=0.04u
M16978 WX7810 n1496 U2136/net26 VSS nmos W=0.155u L=0.04u
M16979 U2136/net29 n1612 VSS VSS nmos W=0.155u L=0.04u
M16980 U2136/net26 n1611 U2136/net29 VSS nmos W=0.155u L=0.04u
M16981 U2136/net26 n1250 U2136/net29 VSS nmos W=0.155u L=0.04u
M16982 WX7810 n1496 U2136/net43 VDD pmos W=0.205u L=0.04u
M16983 WX7810 n1250 U2136/net49 VDD pmos W=0.205u L=0.04u
M16984 U2136/net49 n1611 VDD VDD pmos W=0.205u L=0.04u
M16985 U2136/net43 n1278 VDD VDD pmos W=0.205u L=0.04u
M16986 WX7810 n1612 VDD VDD pmos W=0.205u L=0.04u
M16987 U2137/net29 n1338 VSS VSS nmos W=0.155u L=0.04u
M16988 n1612 WX8245 U2137/net29 VSS nmos W=0.155u L=0.04u
M16989 n1612 n1308 U2137/net23 VSS nmos W=0.155u L=0.04u
M16990 U2137/net23 CRC_OUT_3_30 VSS VSS nmos W=0.155u L=0.04u
M16991 U2137/net20 CRC_OUT_3_30 n1612 VDD pmos W=0.205u L=0.04u
M16992 U2137/net20 n1308 n1612 VDD pmos W=0.205u L=0.04u
M16993 VDD WX8245 U2137/net20 VDD pmos W=0.205u L=0.04u
M16994 VDD n1338 U2137/net20 VDD pmos W=0.205u L=0.04u
M16995 n1496 n1613 VSS VSS nmos W=0.135u L=0.04u
M16996 n1496 n1613 VDD VDD pmos W=0.205u L=0.04u
M16997 U2139/net28 U2139/net20 U2139/net64 VSS nmos W=0.155u L=0.04u
M16998 U2139/net24 U2139/net30 U2139/net32 VSS nmos W=0.155u L=0.04u
M16999 U2139/net28 U2139/net40 U2139/net24 VSS nmos W=0.155u L=0.04u
M17000 U2139/net40 n1614 U2139/net108 VSS nmos W=0.155u L=0.04u
M17001 U2139/net40 U2139/net106 U2139/net104 VSS nmos W=0.155u L=0.04u
M17002 U2139/net24 WX9826 U2139/net050 VSS nmos W=0.155u L=0.04u
M17003 U2139/net050 U2139/net32 VSS VSS nmos W=0.155u L=0.04u
M17004 U2139/net20 U2139/net40 VSS VSS nmos W=0.155u L=0.04u
M17005 U2139/net106 n1614 VSS VSS nmos W=0.155u L=0.04u
M17006 U2139/net104 WX9890 VSS VSS nmos W=0.155u L=0.04u
M17007 U2139/net30 WX9826 VSS VSS nmos W=0.155u L=0.04u
M17008 U2139/net108 U2139/net104 VSS VSS nmos W=0.155u L=0.04u
M17009 n1613 U2139/net28 VSS VSS nmos W=0.155u L=0.04u
M17010 U2139/net32 WX9762 VSS VSS nmos W=0.155u L=0.04u
M17011 U2139/net64 U2139/net24 VSS VSS nmos W=0.2u L=0.04u
M17012 U2139/net28 U2139/net40 U2139/net64 VDD pmos W=0.205u L=0.04u
M17013 U2139/net24 WX9826 U2139/net32 VDD pmos W=0.205u L=0.04u
M17014 U2139/net28 U2139/net20 U2139/net24 VDD pmos W=0.205u L=0.04u
M17015 U2139/net40 U2139/net106 U2139/net108 VDD pmos W=0.205u L=0.04u
M17016 U2139/net40 n1614 U2139/net104 VDD pmos W=0.205u L=0.04u
M17017 U2139/net20 U2139/net40 VDD VDD pmos W=0.205u L=0.04u
M17018 U2139/net106 n1614 VDD VDD pmos W=0.205u L=0.04u
M17019 U2139/net104 WX9890 VDD VDD pmos W=0.205u L=0.04u
M17020 U2139/net30 WX9826 VDD VDD pmos W=0.205u L=0.04u
M17021 U2139/net108 U2139/net104 VDD VDD pmos W=0.205u L=0.04u
M17022 n1613 U2139/net28 VDD VDD pmos W=0.205u L=0.04u
M17023 U2139/net32 WX9762 VDD VDD pmos W=0.205u L=0.04u
M17024 U2139/net64 U2139/net24 VDD VDD pmos W=0.28u L=0.04u
M17025 U2139/net24 U2139/net30 U2139/net045 VDD pmos W=0.205u L=0.04u
M17026 U2139/net045 U2139/net32 VDD VDD pmos W=0.205u L=0.04u
M17027 U2140/net4 WX9698 U2140/net14 VSS nmos W=0.155u L=0.04u
M17028 U2140/net6 U2140/net10 U2140/net14 VSS nmos W=0.17u L=0.04u
M17029 U2140/net4 n1369 VSS VSS nmos W=0.155u L=0.04u
M17030 U2140/net6 U2140/net4 VSS VSS nmos W=0.17u L=0.04u
M17031 n1614 U2140/net14 VSS VSS nmos W=0.155u L=0.04u
M17032 U2140/net10 WX9698 VSS VSS nmos W=0.155u L=0.04u
M17033 U2140/net4 U2140/net10 U2140/net14 VDD pmos W=0.255u L=0.04u
M17034 U2140/net6 WX9698 U2140/net14 VDD pmos W=0.28u L=0.04u
M17035 U2140/net4 n1369 VDD VDD pmos W=0.205u L=0.04u
M17036 U2140/net6 U2140/net4 VDD VDD pmos W=0.24u L=0.04u
M17037 n1614 U2140/net14 VDD VDD pmos W=0.205u L=0.04u
M17038 U2140/net10 WX9698 VDD VDD pmos W=0.205u L=0.04u
M17039 WX7796 n1615 U2141/net26 VSS nmos W=0.155u L=0.04u
M17040 WX7796 n1386 U2141/net26 VSS nmos W=0.155u L=0.04u
M17041 U2141/net29 n1616 VSS VSS nmos W=0.155u L=0.04u
M17042 U2141/net26 WX8241 U2141/net29 VSS nmos W=0.155u L=0.04u
M17043 U2141/net26 n1500 U2141/net29 VSS nmos W=0.155u L=0.04u
M17044 WX7796 n1386 U2141/net43 VDD pmos W=0.205u L=0.04u
M17045 WX7796 n1500 U2141/net49 VDD pmos W=0.205u L=0.04u
M17046 U2141/net49 WX8241 VDD VDD pmos W=0.205u L=0.04u
M17047 U2141/net43 n1615 VDD VDD pmos W=0.205u L=0.04u
M17048 WX7796 n1616 VDD VDD pmos W=0.205u L=0.04u
M17049 U2142/net29 n1618 VSS VSS nmos W=0.155u L=0.04u
M17050 n1616 n1430 U2142/net29 VSS nmos W=0.155u L=0.04u
M17051 n1616 n1617 U2142/net23 VSS nmos W=0.155u L=0.04u
M17052 U2142/net23 n1502 VSS VSS nmos W=0.155u L=0.04u
M17053 U2142/net20 n1502 n1616 VDD pmos W=0.205u L=0.04u
M17054 U2142/net20 n1617 n1616 VDD pmos W=0.205u L=0.04u
M17055 VDD n1430 U2142/net20 VDD pmos W=0.205u L=0.04u
M17056 VDD n1618 U2142/net20 VDD pmos W=0.205u L=0.04u
M17057 U2143/net28 U2143/net20 U2143/net64 VSS nmos W=0.155u L=0.04u
M17058 U2143/net24 U2143/net30 U2143/net32 VSS nmos W=0.155u L=0.04u
M17059 U2143/net28 U2143/net40 U2143/net24 VSS nmos W=0.155u L=0.04u
M17060 U2143/net40 n1619 U2143/net108 VSS nmos W=0.155u L=0.04u
M17061 U2143/net40 U2143/net106 U2143/net104 VSS nmos W=0.155u L=0.04u
M17062 U2143/net24 WX9824 U2143/net050 VSS nmos W=0.155u L=0.04u
M17063 U2143/net050 U2143/net32 VSS VSS nmos W=0.155u L=0.04u
M17064 U2143/net20 U2143/net40 VSS VSS nmos W=0.155u L=0.04u
M17065 U2143/net106 n1619 VSS VSS nmos W=0.155u L=0.04u
M17066 U2143/net104 WX9888 VSS VSS nmos W=0.155u L=0.04u
M17067 U2143/net30 WX9824 VSS VSS nmos W=0.155u L=0.04u
M17068 U2143/net108 U2143/net104 VSS VSS nmos W=0.155u L=0.04u
M17069 n1502 U2143/net28 VSS VSS nmos W=0.155u L=0.04u
M17070 U2143/net32 WX9760 VSS VSS nmos W=0.155u L=0.04u
M17071 U2143/net64 U2143/net24 VSS VSS nmos W=0.2u L=0.04u
M17072 U2143/net28 U2143/net40 U2143/net64 VDD pmos W=0.205u L=0.04u
M17073 U2143/net24 WX9824 U2143/net32 VDD pmos W=0.205u L=0.04u
M17074 U2143/net28 U2143/net20 U2143/net24 VDD pmos W=0.205u L=0.04u
M17075 U2143/net40 U2143/net106 U2143/net108 VDD pmos W=0.205u L=0.04u
M17076 U2143/net40 n1619 U2143/net104 VDD pmos W=0.205u L=0.04u
M17077 U2143/net20 U2143/net40 VDD VDD pmos W=0.205u L=0.04u
M17078 U2143/net106 n1619 VDD VDD pmos W=0.205u L=0.04u
M17079 U2143/net104 WX9888 VDD VDD pmos W=0.205u L=0.04u
M17080 U2143/net30 WX9824 VDD VDD pmos W=0.205u L=0.04u
M17081 U2143/net108 U2143/net104 VDD VDD pmos W=0.205u L=0.04u
M17082 n1502 U2143/net28 VDD VDD pmos W=0.205u L=0.04u
M17083 U2143/net32 WX9760 VDD VDD pmos W=0.205u L=0.04u
M17084 U2143/net64 U2143/net24 VDD VDD pmos W=0.28u L=0.04u
M17085 U2143/net24 U2143/net30 U2143/net045 VDD pmos W=0.205u L=0.04u
M17086 U2143/net045 U2143/net32 VDD VDD pmos W=0.205u L=0.04u
M17087 U2144/net4 WX9696 U2144/net14 VSS nmos W=0.155u L=0.04u
M17088 U2144/net6 U2144/net10 U2144/net14 VSS nmos W=0.17u L=0.04u
M17089 U2144/net4 n1369 VSS VSS nmos W=0.155u L=0.04u
M17090 U2144/net6 U2144/net4 VSS VSS nmos W=0.17u L=0.04u
M17091 n1619 U2144/net14 VSS VSS nmos W=0.155u L=0.04u
M17092 U2144/net10 WX9696 VSS VSS nmos W=0.155u L=0.04u
M17093 U2144/net4 U2144/net10 U2144/net14 VDD pmos W=0.255u L=0.04u
M17094 U2144/net6 WX9696 U2144/net14 VDD pmos W=0.28u L=0.04u
M17095 U2144/net4 n1369 VDD VDD pmos W=0.205u L=0.04u
M17096 U2144/net6 U2144/net4 VDD VDD pmos W=0.24u L=0.04u
M17097 n1619 U2144/net14 VDD VDD pmos W=0.205u L=0.04u
M17098 U2144/net10 WX9696 VDD VDD pmos W=0.205u L=0.04u
M17099 WX8241 WX8243 VSS VSS nmos W=0.135u L=0.04u
M17100 WX8241 WX8243 VDD VDD pmos W=0.205u L=0.04u
M17101 n1386 CRC_OUT_3_31 VSS VSS nmos W=0.135u L=0.04u
M17102 n1386 CRC_OUT_3_31 VDD VDD pmos W=0.205u L=0.04u
M17103 WX6937 n1278 U2147/net26 VSS nmos W=0.155u L=0.04u
M17104 WX6937 n1503 U2147/net26 VSS nmos W=0.155u L=0.04u
M17105 U2147/net29 n1621 VSS VSS nmos W=0.155u L=0.04u
M17106 U2147/net26 n1620 U2147/net29 VSS nmos W=0.155u L=0.04u
M17107 U2147/net26 n1250 U2147/net29 VSS nmos W=0.155u L=0.04u
M17108 WX6937 n1503 U2147/net43 VDD pmos W=0.205u L=0.04u
M17109 WX6937 n1250 U2147/net49 VDD pmos W=0.205u L=0.04u
M17110 U2147/net49 n1620 VDD VDD pmos W=0.205u L=0.04u
M17111 U2147/net43 n1278 VDD VDD pmos W=0.205u L=0.04u
M17112 WX6937 n1621 VDD VDD pmos W=0.205u L=0.04u
M17113 U2148/net29 n1338 VSS VSS nmos W=0.155u L=0.04u
M17114 n1621 WX7012 U2148/net29 VSS nmos W=0.155u L=0.04u
M17115 n1621 n1307 U2148/net23 VSS nmos W=0.155u L=0.04u
M17116 U2148/net23 CRC_OUT_4_0 VSS VSS nmos W=0.155u L=0.04u
M17117 U2148/net20 CRC_OUT_4_0 n1621 VDD pmos W=0.205u L=0.04u
M17118 U2148/net20 n1307 n1621 VDD pmos W=0.205u L=0.04u
M17119 VDD WX7012 U2148/net20 VDD pmos W=0.205u L=0.04u
M17120 VDD n1338 U2148/net20 VDD pmos W=0.205u L=0.04u
M17121 U2149/net28 U2149/net20 U2149/net64 VSS nmos W=0.155u L=0.04u
M17122 U2149/net24 U2149/net30 U2149/net32 VSS nmos W=0.155u L=0.04u
M17123 U2149/net28 U2149/net40 U2149/net24 VSS nmos W=0.155u L=0.04u
M17124 U2149/net40 WX8593 U2149/net108 VSS nmos W=0.155u L=0.04u
M17125 U2149/net40 U2149/net106 U2149/net104 VSS nmos W=0.155u L=0.04u
M17126 U2149/net24 WX8529 U2149/net050 VSS nmos W=0.155u L=0.04u
M17127 U2149/net050 U2149/net32 VSS VSS nmos W=0.155u L=0.04u
M17128 U2149/net20 U2149/net40 VSS VSS nmos W=0.155u L=0.04u
M17129 U2149/net106 WX8593 VSS VSS nmos W=0.155u L=0.04u
M17130 U2149/net104 n1387 VSS VSS nmos W=0.155u L=0.04u
M17131 U2149/net30 WX8529 VSS VSS nmos W=0.155u L=0.04u
M17132 U2149/net108 U2149/net104 VSS VSS nmos W=0.155u L=0.04u
M17133 n1503 U2149/net28 VSS VSS nmos W=0.155u L=0.04u
M17134 U2149/net32 WX8465 VSS VSS nmos W=0.155u L=0.04u
M17135 U2149/net64 U2149/net24 VSS VSS nmos W=0.2u L=0.04u
M17136 U2149/net28 U2149/net40 U2149/net64 VDD pmos W=0.205u L=0.04u
M17137 U2149/net24 WX8529 U2149/net32 VDD pmos W=0.205u L=0.04u
M17138 U2149/net28 U2149/net20 U2149/net24 VDD pmos W=0.205u L=0.04u
M17139 U2149/net40 U2149/net106 U2149/net108 VDD pmos W=0.205u L=0.04u
M17140 U2149/net40 WX8593 U2149/net104 VDD pmos W=0.205u L=0.04u
M17141 U2149/net20 U2149/net40 VDD VDD pmos W=0.205u L=0.04u
M17142 U2149/net106 WX8593 VDD VDD pmos W=0.205u L=0.04u
M17143 U2149/net104 n1387 VDD VDD pmos W=0.205u L=0.04u
M17144 U2149/net30 WX8529 VDD VDD pmos W=0.205u L=0.04u
M17145 U2149/net108 U2149/net104 VDD VDD pmos W=0.205u L=0.04u
M17146 n1503 U2149/net28 VDD VDD pmos W=0.205u L=0.04u
M17147 U2149/net32 WX8465 VDD VDD pmos W=0.205u L=0.04u
M17148 U2149/net64 U2149/net24 VDD VDD pmos W=0.28u L=0.04u
M17149 U2149/net24 U2149/net30 U2149/net045 VDD pmos W=0.205u L=0.04u
M17150 U2149/net045 U2149/net32 VDD VDD pmos W=0.205u L=0.04u
M17151 n1387 WX8657 VSS VSS nmos W=0.135u L=0.04u
M17152 n1387 WX8657 VDD VDD pmos W=0.205u L=0.04u
M17153 WX6923 n1278 U2151/net26 VSS nmos W=0.155u L=0.04u
M17154 WX6923 n1506 U2151/net26 VSS nmos W=0.155u L=0.04u
M17155 U2151/net29 n1623 VSS VSS nmos W=0.155u L=0.04u
M17156 U2151/net26 n1622 U2151/net29 VSS nmos W=0.155u L=0.04u
M17157 U2151/net26 n1250 U2151/net29 VSS nmos W=0.155u L=0.04u
M17158 WX6923 n1506 U2151/net43 VDD pmos W=0.205u L=0.04u
M17159 WX6923 n1250 U2151/net49 VDD pmos W=0.205u L=0.04u
M17160 U2151/net49 n1622 VDD VDD pmos W=0.205u L=0.04u
M17161 U2151/net43 n1278 VDD VDD pmos W=0.205u L=0.04u
M17162 WX6923 n1623 VDD VDD pmos W=0.205u L=0.04u
M17163 U2152/net29 n1338 VSS VSS nmos W=0.155u L=0.04u
M17164 n1623 WX7010 U2152/net29 VSS nmos W=0.155u L=0.04u
M17165 n1623 n1307 U2152/net23 VSS nmos W=0.155u L=0.04u
M17166 U2152/net23 CRC_OUT_4_1 VSS VSS nmos W=0.155u L=0.04u
M17167 U2152/net20 CRC_OUT_4_1 n1623 VDD pmos W=0.205u L=0.04u
M17168 U2152/net20 n1307 n1623 VDD pmos W=0.205u L=0.04u
M17169 VDD WX7010 U2152/net20 VDD pmos W=0.205u L=0.04u
M17170 VDD n1338 U2152/net20 VDD pmos W=0.205u L=0.04u
M17171 n1506 n1624 VSS VSS nmos W=0.135u L=0.04u
M17172 n1506 n1624 VDD VDD pmos W=0.205u L=0.04u
M17173 U2154/net28 U2154/net20 U2154/net64 VSS nmos W=0.155u L=0.04u
M17174 U2154/net24 U2154/net30 U2154/net32 VSS nmos W=0.155u L=0.04u
M17175 U2154/net28 U2154/net40 U2154/net24 VSS nmos W=0.155u L=0.04u
M17176 U2154/net40 WX8591 U2154/net108 VSS nmos W=0.155u L=0.04u
M17177 U2154/net40 U2154/net106 U2154/net104 VSS nmos W=0.155u L=0.04u
M17178 U2154/net24 WX8527 U2154/net050 VSS nmos W=0.155u L=0.04u
M17179 U2154/net050 U2154/net32 VSS VSS nmos W=0.155u L=0.04u
M17180 U2154/net20 U2154/net40 VSS VSS nmos W=0.155u L=0.04u
M17181 U2154/net106 WX8591 VSS VSS nmos W=0.155u L=0.04u
M17182 U2154/net104 WX8655 VSS VSS nmos W=0.155u L=0.04u
M17183 U2154/net30 WX8527 VSS VSS nmos W=0.155u L=0.04u
M17184 U2154/net108 U2154/net104 VSS VSS nmos W=0.155u L=0.04u
M17185 n1624 U2154/net28 VSS VSS nmos W=0.155u L=0.04u
M17186 U2154/net32 WX8463 VSS VSS nmos W=0.155u L=0.04u
M17187 U2154/net64 U2154/net24 VSS VSS nmos W=0.2u L=0.04u
M17188 U2154/net28 U2154/net40 U2154/net64 VDD pmos W=0.205u L=0.04u
M17189 U2154/net24 WX8527 U2154/net32 VDD pmos W=0.205u L=0.04u
M17190 U2154/net28 U2154/net20 U2154/net24 VDD pmos W=0.205u L=0.04u
M17191 U2154/net40 U2154/net106 U2154/net108 VDD pmos W=0.205u L=0.04u
M17192 U2154/net40 WX8591 U2154/net104 VDD pmos W=0.205u L=0.04u
M17193 U2154/net20 U2154/net40 VDD VDD pmos W=0.205u L=0.04u
M17194 U2154/net106 WX8591 VDD VDD pmos W=0.205u L=0.04u
M17195 U2154/net104 WX8655 VDD VDD pmos W=0.205u L=0.04u
M17196 U2154/net30 WX8527 VDD VDD pmos W=0.205u L=0.04u
M17197 U2154/net108 U2154/net104 VDD VDD pmos W=0.205u L=0.04u
M17198 n1624 U2154/net28 VDD VDD pmos W=0.205u L=0.04u
M17199 U2154/net32 WX8463 VDD VDD pmos W=0.205u L=0.04u
M17200 U2154/net64 U2154/net24 VDD VDD pmos W=0.28u L=0.04u
M17201 U2154/net24 U2154/net30 U2154/net045 VDD pmos W=0.205u L=0.04u
M17202 U2154/net045 U2154/net32 VDD VDD pmos W=0.205u L=0.04u
M17203 WX6909 n1278 U2155/net26 VSS nmos W=0.155u L=0.04u
M17204 WX6909 n1509 U2155/net26 VSS nmos W=0.155u L=0.04u
M17205 U2155/net29 n1626 VSS VSS nmos W=0.155u L=0.04u
M17206 U2155/net26 n1625 U2155/net29 VSS nmos W=0.155u L=0.04u
M17207 U2155/net26 n1250 U2155/net29 VSS nmos W=0.155u L=0.04u
M17208 WX6909 n1509 U2155/net43 VDD pmos W=0.205u L=0.04u
M17209 WX6909 n1250 U2155/net49 VDD pmos W=0.205u L=0.04u
M17210 U2155/net49 n1625 VDD VDD pmos W=0.205u L=0.04u
M17211 U2155/net43 n1278 VDD VDD pmos W=0.205u L=0.04u
M17212 WX6909 n1626 VDD VDD pmos W=0.205u L=0.04u
M17213 U2156/net29 n1338 VSS VSS nmos W=0.155u L=0.04u
M17214 n1626 WX7008 U2156/net29 VSS nmos W=0.155u L=0.04u
M17215 n1626 n1307 U2156/net23 VSS nmos W=0.155u L=0.04u
M17216 U2156/net23 CRC_OUT_4_2 VSS VSS nmos W=0.155u L=0.04u
M17217 U2156/net20 CRC_OUT_4_2 n1626 VDD pmos W=0.205u L=0.04u
M17218 U2156/net20 n1307 n1626 VDD pmos W=0.205u L=0.04u
M17219 VDD WX7008 U2156/net20 VDD pmos W=0.205u L=0.04u
M17220 VDD n1338 U2156/net20 VDD pmos W=0.205u L=0.04u
M17221 n1509 n1627 VSS VSS nmos W=0.135u L=0.04u
M17222 n1509 n1627 VDD VDD pmos W=0.205u L=0.04u
M17223 U2158/net28 U2158/net20 U2158/net64 VSS nmos W=0.155u L=0.04u
M17224 U2158/net24 U2158/net30 U2158/net32 VSS nmos W=0.155u L=0.04u
M17225 U2158/net28 U2158/net40 U2158/net24 VSS nmos W=0.155u L=0.04u
M17226 U2158/net40 WX8589 U2158/net108 VSS nmos W=0.155u L=0.04u
M17227 U2158/net40 U2158/net106 U2158/net104 VSS nmos W=0.155u L=0.04u
M17228 U2158/net24 WX8525 U2158/net050 VSS nmos W=0.155u L=0.04u
M17229 U2158/net050 U2158/net32 VSS VSS nmos W=0.155u L=0.04u
M17230 U2158/net20 U2158/net40 VSS VSS nmos W=0.155u L=0.04u
M17231 U2158/net106 WX8589 VSS VSS nmos W=0.155u L=0.04u
M17232 U2158/net104 WX8653 VSS VSS nmos W=0.155u L=0.04u
M17233 U2158/net30 WX8525 VSS VSS nmos W=0.155u L=0.04u
M17234 U2158/net108 U2158/net104 VSS VSS nmos W=0.155u L=0.04u
M17235 n1627 U2158/net28 VSS VSS nmos W=0.155u L=0.04u
M17236 U2158/net32 WX8461 VSS VSS nmos W=0.155u L=0.04u
M17237 U2158/net64 U2158/net24 VSS VSS nmos W=0.2u L=0.04u
M17238 U2158/net28 U2158/net40 U2158/net64 VDD pmos W=0.205u L=0.04u
M17239 U2158/net24 WX8525 U2158/net32 VDD pmos W=0.205u L=0.04u
M17240 U2158/net28 U2158/net20 U2158/net24 VDD pmos W=0.205u L=0.04u
M17241 U2158/net40 U2158/net106 U2158/net108 VDD pmos W=0.205u L=0.04u
M17242 U2158/net40 WX8589 U2158/net104 VDD pmos W=0.205u L=0.04u
M17243 U2158/net20 U2158/net40 VDD VDD pmos W=0.205u L=0.04u
M17244 U2158/net106 WX8589 VDD VDD pmos W=0.205u L=0.04u
M17245 U2158/net104 WX8653 VDD VDD pmos W=0.205u L=0.04u
M17246 U2158/net30 WX8525 VDD VDD pmos W=0.205u L=0.04u
M17247 U2158/net108 U2158/net104 VDD VDD pmos W=0.205u L=0.04u
M17248 n1627 U2158/net28 VDD VDD pmos W=0.205u L=0.04u
M17249 U2158/net32 WX8461 VDD VDD pmos W=0.205u L=0.04u
M17250 U2158/net64 U2158/net24 VDD VDD pmos W=0.28u L=0.04u
M17251 U2158/net24 U2158/net30 U2158/net045 VDD pmos W=0.205u L=0.04u
M17252 U2158/net045 U2158/net32 VDD VDD pmos W=0.205u L=0.04u
M17253 WX6895 n1278 U2159/net26 VSS nmos W=0.155u L=0.04u
M17254 WX6895 n1512 U2159/net26 VSS nmos W=0.155u L=0.04u
M17255 U2159/net29 n1629 VSS VSS nmos W=0.155u L=0.04u
M17256 U2159/net26 n1628 U2159/net29 VSS nmos W=0.155u L=0.04u
M17257 U2159/net26 n1250 U2159/net29 VSS nmos W=0.155u L=0.04u
M17258 WX6895 n1512 U2159/net43 VDD pmos W=0.205u L=0.04u
M17259 WX6895 n1250 U2159/net49 VDD pmos W=0.205u L=0.04u
M17260 U2159/net49 n1628 VDD VDD pmos W=0.205u L=0.04u
M17261 U2159/net43 n1278 VDD VDD pmos W=0.205u L=0.04u
M17262 WX6895 n1629 VDD VDD pmos W=0.205u L=0.04u
M17263 U2160/net29 n1338 VSS VSS nmos W=0.155u L=0.04u
M17264 n1629 WX7006 U2160/net29 VSS nmos W=0.155u L=0.04u
M17265 n1629 n1307 U2160/net23 VSS nmos W=0.155u L=0.04u
M17266 U2160/net23 CRC_OUT_4_3 VSS VSS nmos W=0.155u L=0.04u
M17267 U2160/net20 CRC_OUT_4_3 n1629 VDD pmos W=0.205u L=0.04u
M17268 U2160/net20 n1307 n1629 VDD pmos W=0.205u L=0.04u
M17269 VDD WX7006 U2160/net20 VDD pmos W=0.205u L=0.04u
M17270 VDD n1338 U2160/net20 VDD pmos W=0.205u L=0.04u
M17271 n1512 n1630 VSS VSS nmos W=0.135u L=0.04u
M17272 n1512 n1630 VDD VDD pmos W=0.205u L=0.04u
M17273 U2162/net28 U2162/net20 U2162/net64 VSS nmos W=0.155u L=0.04u
M17274 U2162/net24 U2162/net30 U2162/net32 VSS nmos W=0.155u L=0.04u
M17275 U2162/net28 U2162/net40 U2162/net24 VSS nmos W=0.155u L=0.04u
M17276 U2162/net40 WX8587 U2162/net108 VSS nmos W=0.155u L=0.04u
M17277 U2162/net40 U2162/net106 U2162/net104 VSS nmos W=0.155u L=0.04u
M17278 U2162/net24 WX8523 U2162/net050 VSS nmos W=0.155u L=0.04u
M17279 U2162/net050 U2162/net32 VSS VSS nmos W=0.155u L=0.04u
M17280 U2162/net20 U2162/net40 VSS VSS nmos W=0.155u L=0.04u
M17281 U2162/net106 WX8587 VSS VSS nmos W=0.155u L=0.04u
M17282 U2162/net104 WX8651 VSS VSS nmos W=0.155u L=0.04u
M17283 U2162/net30 WX8523 VSS VSS nmos W=0.155u L=0.04u
M17284 U2162/net108 U2162/net104 VSS VSS nmos W=0.155u L=0.04u
M17285 n1630 U2162/net28 VSS VSS nmos W=0.155u L=0.04u
M17286 U2162/net32 WX8459 VSS VSS nmos W=0.155u L=0.04u
M17287 U2162/net64 U2162/net24 VSS VSS nmos W=0.2u L=0.04u
M17288 U2162/net28 U2162/net40 U2162/net64 VDD pmos W=0.205u L=0.04u
M17289 U2162/net24 WX8523 U2162/net32 VDD pmos W=0.205u L=0.04u
M17290 U2162/net28 U2162/net20 U2162/net24 VDD pmos W=0.205u L=0.04u
M17291 U2162/net40 U2162/net106 U2162/net108 VDD pmos W=0.205u L=0.04u
M17292 U2162/net40 WX8587 U2162/net104 VDD pmos W=0.205u L=0.04u
M17293 U2162/net20 U2162/net40 VDD VDD pmos W=0.205u L=0.04u
M17294 U2162/net106 WX8587 VDD VDD pmos W=0.205u L=0.04u
M17295 U2162/net104 WX8651 VDD VDD pmos W=0.205u L=0.04u
M17296 U2162/net30 WX8523 VDD VDD pmos W=0.205u L=0.04u
M17297 U2162/net108 U2162/net104 VDD VDD pmos W=0.205u L=0.04u
M17298 n1630 U2162/net28 VDD VDD pmos W=0.205u L=0.04u
M17299 U2162/net32 WX8459 VDD VDD pmos W=0.205u L=0.04u
M17300 U2162/net64 U2162/net24 VDD VDD pmos W=0.28u L=0.04u
M17301 U2162/net24 U2162/net30 U2162/net045 VDD pmos W=0.205u L=0.04u
M17302 U2162/net045 U2162/net32 VDD VDD pmos W=0.205u L=0.04u
M17303 WX6881 n1278 U2163/net26 VSS nmos W=0.155u L=0.04u
M17304 WX6881 n1515 U2163/net26 VSS nmos W=0.155u L=0.04u
M17305 U2163/net29 n1632 VSS VSS nmos W=0.155u L=0.04u
M17306 U2163/net26 n1631 U2163/net29 VSS nmos W=0.155u L=0.04u
M17307 U2163/net26 n1250 U2163/net29 VSS nmos W=0.155u L=0.04u
M17308 WX6881 n1515 U2163/net43 VDD pmos W=0.205u L=0.04u
M17309 WX6881 n1250 U2163/net49 VDD pmos W=0.205u L=0.04u
M17310 U2163/net49 n1631 VDD VDD pmos W=0.205u L=0.04u
M17311 U2163/net43 n1278 VDD VDD pmos W=0.205u L=0.04u
M17312 WX6881 n1632 VDD VDD pmos W=0.205u L=0.04u
M17313 U2164/net29 n1338 VSS VSS nmos W=0.155u L=0.04u
M17314 n1632 WX7004 U2164/net29 VSS nmos W=0.155u L=0.04u
M17315 n1632 n1307 U2164/net23 VSS nmos W=0.155u L=0.04u
M17316 U2164/net23 CRC_OUT_4_4 VSS VSS nmos W=0.155u L=0.04u
M17317 U2164/net20 CRC_OUT_4_4 n1632 VDD pmos W=0.205u L=0.04u
M17318 U2164/net20 n1307 n1632 VDD pmos W=0.205u L=0.04u
M17319 VDD WX7004 U2164/net20 VDD pmos W=0.205u L=0.04u
M17320 VDD n1338 U2164/net20 VDD pmos W=0.205u L=0.04u
M17321 n1515 n1633 VSS VSS nmos W=0.135u L=0.04u
M17322 n1515 n1633 VDD VDD pmos W=0.205u L=0.04u
M17323 U2166/net28 U2166/net20 U2166/net64 VSS nmos W=0.155u L=0.04u
M17324 U2166/net24 U2166/net30 U2166/net32 VSS nmos W=0.155u L=0.04u
M17325 U2166/net28 U2166/net40 U2166/net24 VSS nmos W=0.155u L=0.04u
M17326 U2166/net40 WX8585 U2166/net108 VSS nmos W=0.155u L=0.04u
M17327 U2166/net40 U2166/net106 U2166/net104 VSS nmos W=0.155u L=0.04u
M17328 U2166/net24 WX8521 U2166/net050 VSS nmos W=0.155u L=0.04u
M17329 U2166/net050 U2166/net32 VSS VSS nmos W=0.155u L=0.04u
M17330 U2166/net20 U2166/net40 VSS VSS nmos W=0.155u L=0.04u
M17331 U2166/net106 WX8585 VSS VSS nmos W=0.155u L=0.04u
M17332 U2166/net104 WX8649 VSS VSS nmos W=0.155u L=0.04u
M17333 U2166/net30 WX8521 VSS VSS nmos W=0.155u L=0.04u
M17334 U2166/net108 U2166/net104 VSS VSS nmos W=0.155u L=0.04u
M17335 n1633 U2166/net28 VSS VSS nmos W=0.155u L=0.04u
M17336 U2166/net32 WX8457 VSS VSS nmos W=0.155u L=0.04u
M17337 U2166/net64 U2166/net24 VSS VSS nmos W=0.2u L=0.04u
M17338 U2166/net28 U2166/net40 U2166/net64 VDD pmos W=0.205u L=0.04u
M17339 U2166/net24 WX8521 U2166/net32 VDD pmos W=0.205u L=0.04u
M17340 U2166/net28 U2166/net20 U2166/net24 VDD pmos W=0.205u L=0.04u
M17341 U2166/net40 U2166/net106 U2166/net108 VDD pmos W=0.205u L=0.04u
M17342 U2166/net40 WX8585 U2166/net104 VDD pmos W=0.205u L=0.04u
M17343 U2166/net20 U2166/net40 VDD VDD pmos W=0.205u L=0.04u
M17344 U2166/net106 WX8585 VDD VDD pmos W=0.205u L=0.04u
M17345 U2166/net104 WX8649 VDD VDD pmos W=0.205u L=0.04u
M17346 U2166/net30 WX8521 VDD VDD pmos W=0.205u L=0.04u
M17347 U2166/net108 U2166/net104 VDD VDD pmos W=0.205u L=0.04u
M17348 n1633 U2166/net28 VDD VDD pmos W=0.205u L=0.04u
M17349 U2166/net32 WX8457 VDD VDD pmos W=0.205u L=0.04u
M17350 U2166/net64 U2166/net24 VDD VDD pmos W=0.28u L=0.04u
M17351 U2166/net24 U2166/net30 U2166/net045 VDD pmos W=0.205u L=0.04u
M17352 U2166/net045 U2166/net32 VDD VDD pmos W=0.205u L=0.04u
M17353 WX6867 n1278 U2167/net26 VSS nmos W=0.155u L=0.04u
M17354 WX6867 n1518 U2167/net26 VSS nmos W=0.155u L=0.04u
M17355 U2167/net29 n1635 VSS VSS nmos W=0.155u L=0.04u
M17356 U2167/net26 n1634 U2167/net29 VSS nmos W=0.155u L=0.04u
M17357 U2167/net26 n1250 U2167/net29 VSS nmos W=0.155u L=0.04u
M17358 WX6867 n1518 U2167/net43 VDD pmos W=0.205u L=0.04u
M17359 WX6867 n1250 U2167/net49 VDD pmos W=0.205u L=0.04u
M17360 U2167/net49 n1634 VDD VDD pmos W=0.205u L=0.04u
M17361 U2167/net43 n1278 VDD VDD pmos W=0.205u L=0.04u
M17362 WX6867 n1635 VDD VDD pmos W=0.205u L=0.04u
M17363 U2168/net29 n1338 VSS VSS nmos W=0.155u L=0.04u
M17364 n1635 WX7002 U2168/net29 VSS nmos W=0.155u L=0.04u
M17365 n1635 n1307 U2168/net23 VSS nmos W=0.155u L=0.04u
M17366 U2168/net23 CRC_OUT_4_5 VSS VSS nmos W=0.155u L=0.04u
M17367 U2168/net20 CRC_OUT_4_5 n1635 VDD pmos W=0.205u L=0.04u
M17368 U2168/net20 n1307 n1635 VDD pmos W=0.205u L=0.04u
M17369 VDD WX7002 U2168/net20 VDD pmos W=0.205u L=0.04u
M17370 VDD n1338 U2168/net20 VDD pmos W=0.205u L=0.04u
M17371 n1518 n1636 VSS VSS nmos W=0.135u L=0.04u
M17372 n1518 n1636 VDD VDD pmos W=0.205u L=0.04u
M17373 U2170/net28 U2170/net20 U2170/net64 VSS nmos W=0.155u L=0.04u
M17374 U2170/net24 U2170/net30 U2170/net32 VSS nmos W=0.155u L=0.04u
M17375 U2170/net28 U2170/net40 U2170/net24 VSS nmos W=0.155u L=0.04u
M17376 U2170/net40 WX8583 U2170/net108 VSS nmos W=0.155u L=0.04u
M17377 U2170/net40 U2170/net106 U2170/net104 VSS nmos W=0.155u L=0.04u
M17378 U2170/net24 WX8519 U2170/net050 VSS nmos W=0.155u L=0.04u
M17379 U2170/net050 U2170/net32 VSS VSS nmos W=0.155u L=0.04u
M17380 U2170/net20 U2170/net40 VSS VSS nmos W=0.155u L=0.04u
M17381 U2170/net106 WX8583 VSS VSS nmos W=0.155u L=0.04u
M17382 U2170/net104 WX8647 VSS VSS nmos W=0.155u L=0.04u
M17383 U2170/net30 WX8519 VSS VSS nmos W=0.155u L=0.04u
M17384 U2170/net108 U2170/net104 VSS VSS nmos W=0.155u L=0.04u
M17385 n1636 U2170/net28 VSS VSS nmos W=0.155u L=0.04u
M17386 U2170/net32 WX8455 VSS VSS nmos W=0.155u L=0.04u
M17387 U2170/net64 U2170/net24 VSS VSS nmos W=0.2u L=0.04u
M17388 U2170/net28 U2170/net40 U2170/net64 VDD pmos W=0.205u L=0.04u
M17389 U2170/net24 WX8519 U2170/net32 VDD pmos W=0.205u L=0.04u
M17390 U2170/net28 U2170/net20 U2170/net24 VDD pmos W=0.205u L=0.04u
M17391 U2170/net40 U2170/net106 U2170/net108 VDD pmos W=0.205u L=0.04u
M17392 U2170/net40 WX8583 U2170/net104 VDD pmos W=0.205u L=0.04u
M17393 U2170/net20 U2170/net40 VDD VDD pmos W=0.205u L=0.04u
M17394 U2170/net106 WX8583 VDD VDD pmos W=0.205u L=0.04u
M17395 U2170/net104 WX8647 VDD VDD pmos W=0.205u L=0.04u
M17396 U2170/net30 WX8519 VDD VDD pmos W=0.205u L=0.04u
M17397 U2170/net108 U2170/net104 VDD VDD pmos W=0.205u L=0.04u
M17398 n1636 U2170/net28 VDD VDD pmos W=0.205u L=0.04u
M17399 U2170/net32 WX8455 VDD VDD pmos W=0.205u L=0.04u
M17400 U2170/net64 U2170/net24 VDD VDD pmos W=0.28u L=0.04u
M17401 U2170/net24 U2170/net30 U2170/net045 VDD pmos W=0.205u L=0.04u
M17402 U2170/net045 U2170/net32 VDD VDD pmos W=0.205u L=0.04u
M17403 WX6853 n1278 U2171/net26 VSS nmos W=0.155u L=0.04u
M17404 WX6853 n1521 U2171/net26 VSS nmos W=0.155u L=0.04u
M17405 U2171/net29 n1638 VSS VSS nmos W=0.155u L=0.04u
M17406 U2171/net26 n1637 U2171/net29 VSS nmos W=0.155u L=0.04u
M17407 U2171/net26 n1252 U2171/net29 VSS nmos W=0.155u L=0.04u
M17408 WX6853 n1521 U2171/net43 VDD pmos W=0.205u L=0.04u
M17409 WX6853 n1252 U2171/net49 VDD pmos W=0.205u L=0.04u
M17410 U2171/net49 n1637 VDD VDD pmos W=0.205u L=0.04u
M17411 U2171/net43 n1278 VDD VDD pmos W=0.205u L=0.04u
M17412 WX6853 n1638 VDD VDD pmos W=0.205u L=0.04u
M17413 U2172/net29 n1338 VSS VSS nmos W=0.155u L=0.04u
M17414 n1638 WX7000 U2172/net29 VSS nmos W=0.155u L=0.04u
M17415 n1638 n1307 U2172/net23 VSS nmos W=0.155u L=0.04u
M17416 U2172/net23 CRC_OUT_4_6 VSS VSS nmos W=0.155u L=0.04u
M17417 U2172/net20 CRC_OUT_4_6 n1638 VDD pmos W=0.205u L=0.04u
M17418 U2172/net20 n1307 n1638 VDD pmos W=0.205u L=0.04u
M17419 VDD WX7000 U2172/net20 VDD pmos W=0.205u L=0.04u
M17420 VDD n1338 U2172/net20 VDD pmos W=0.205u L=0.04u
M17421 n1521 n1639 VSS VSS nmos W=0.135u L=0.04u
M17422 n1521 n1639 VDD VDD pmos W=0.205u L=0.04u
M17423 U2174/net28 U2174/net20 U2174/net64 VSS nmos W=0.155u L=0.04u
M17424 U2174/net24 U2174/net30 U2174/net32 VSS nmos W=0.155u L=0.04u
M17425 U2174/net28 U2174/net40 U2174/net24 VSS nmos W=0.155u L=0.04u
M17426 U2174/net40 WX8581 U2174/net108 VSS nmos W=0.155u L=0.04u
M17427 U2174/net40 U2174/net106 U2174/net104 VSS nmos W=0.155u L=0.04u
M17428 U2174/net24 WX8517 U2174/net050 VSS nmos W=0.155u L=0.04u
M17429 U2174/net050 U2174/net32 VSS VSS nmos W=0.155u L=0.04u
M17430 U2174/net20 U2174/net40 VSS VSS nmos W=0.155u L=0.04u
M17431 U2174/net106 WX8581 VSS VSS nmos W=0.155u L=0.04u
M17432 U2174/net104 WX8645 VSS VSS nmos W=0.155u L=0.04u
M17433 U2174/net30 WX8517 VSS VSS nmos W=0.155u L=0.04u
M17434 U2174/net108 U2174/net104 VSS VSS nmos W=0.155u L=0.04u
M17435 n1639 U2174/net28 VSS VSS nmos W=0.155u L=0.04u
M17436 U2174/net32 WX8453 VSS VSS nmos W=0.155u L=0.04u
M17437 U2174/net64 U2174/net24 VSS VSS nmos W=0.2u L=0.04u
M17438 U2174/net28 U2174/net40 U2174/net64 VDD pmos W=0.205u L=0.04u
M17439 U2174/net24 WX8517 U2174/net32 VDD pmos W=0.205u L=0.04u
M17440 U2174/net28 U2174/net20 U2174/net24 VDD pmos W=0.205u L=0.04u
M17441 U2174/net40 U2174/net106 U2174/net108 VDD pmos W=0.205u L=0.04u
M17442 U2174/net40 WX8581 U2174/net104 VDD pmos W=0.205u L=0.04u
M17443 U2174/net20 U2174/net40 VDD VDD pmos W=0.205u L=0.04u
M17444 U2174/net106 WX8581 VDD VDD pmos W=0.205u L=0.04u
M17445 U2174/net104 WX8645 VDD VDD pmos W=0.205u L=0.04u
M17446 U2174/net30 WX8517 VDD VDD pmos W=0.205u L=0.04u
M17447 U2174/net108 U2174/net104 VDD VDD pmos W=0.205u L=0.04u
M17448 n1639 U2174/net28 VDD VDD pmos W=0.205u L=0.04u
M17449 U2174/net32 WX8453 VDD VDD pmos W=0.205u L=0.04u
M17450 U2174/net64 U2174/net24 VDD VDD pmos W=0.28u L=0.04u
M17451 U2174/net24 U2174/net30 U2174/net045 VDD pmos W=0.205u L=0.04u
M17452 U2174/net045 U2174/net32 VDD VDD pmos W=0.205u L=0.04u
M17453 WX6839 n1278 U2175/net26 VSS nmos W=0.155u L=0.04u
M17454 WX6839 n1524 U2175/net26 VSS nmos W=0.155u L=0.04u
M17455 U2175/net29 n1641 VSS VSS nmos W=0.155u L=0.04u
M17456 U2175/net26 n1640 U2175/net29 VSS nmos W=0.155u L=0.04u
M17457 U2175/net26 n1250 U2175/net29 VSS nmos W=0.155u L=0.04u
M17458 WX6839 n1524 U2175/net43 VDD pmos W=0.205u L=0.04u
M17459 WX6839 n1250 U2175/net49 VDD pmos W=0.205u L=0.04u
M17460 U2175/net49 n1640 VDD VDD pmos W=0.205u L=0.04u
M17461 U2175/net43 n1278 VDD VDD pmos W=0.205u L=0.04u
M17462 WX6839 n1641 VDD VDD pmos W=0.205u L=0.04u
M17463 U2176/net29 n1338 VSS VSS nmos W=0.155u L=0.04u
M17464 n1641 WX6998 U2176/net29 VSS nmos W=0.155u L=0.04u
M17465 n1641 n1307 U2176/net23 VSS nmos W=0.155u L=0.04u
M17466 U2176/net23 CRC_OUT_4_7 VSS VSS nmos W=0.155u L=0.04u
M17467 U2176/net20 CRC_OUT_4_7 n1641 VDD pmos W=0.205u L=0.04u
M17468 U2176/net20 n1307 n1641 VDD pmos W=0.205u L=0.04u
M17469 VDD WX6998 U2176/net20 VDD pmos W=0.205u L=0.04u
M17470 VDD n1338 U2176/net20 VDD pmos W=0.205u L=0.04u
M17471 n1524 n1642 VSS VSS nmos W=0.135u L=0.04u
M17472 n1524 n1642 VDD VDD pmos W=0.205u L=0.04u
M17473 U2178/net28 U2178/net20 U2178/net64 VSS nmos W=0.155u L=0.04u
M17474 U2178/net24 U2178/net30 U2178/net32 VSS nmos W=0.155u L=0.04u
M17475 U2178/net28 U2178/net40 U2178/net24 VSS nmos W=0.155u L=0.04u
M17476 U2178/net40 WX8579 U2178/net108 VSS nmos W=0.155u L=0.04u
M17477 U2178/net40 U2178/net106 U2178/net104 VSS nmos W=0.155u L=0.04u
M17478 U2178/net24 WX8515 U2178/net050 VSS nmos W=0.155u L=0.04u
M17479 U2178/net050 U2178/net32 VSS VSS nmos W=0.155u L=0.04u
M17480 U2178/net20 U2178/net40 VSS VSS nmos W=0.155u L=0.04u
M17481 U2178/net106 WX8579 VSS VSS nmos W=0.155u L=0.04u
M17482 U2178/net104 WX8643 VSS VSS nmos W=0.155u L=0.04u
M17483 U2178/net30 WX8515 VSS VSS nmos W=0.155u L=0.04u
M17484 U2178/net108 U2178/net104 VSS VSS nmos W=0.155u L=0.04u
M17485 n1642 U2178/net28 VSS VSS nmos W=0.155u L=0.04u
M17486 U2178/net32 WX8451 VSS VSS nmos W=0.155u L=0.04u
M17487 U2178/net64 U2178/net24 VSS VSS nmos W=0.2u L=0.04u
M17488 U2178/net28 U2178/net40 U2178/net64 VDD pmos W=0.205u L=0.04u
M17489 U2178/net24 WX8515 U2178/net32 VDD pmos W=0.205u L=0.04u
M17490 U2178/net28 U2178/net20 U2178/net24 VDD pmos W=0.205u L=0.04u
M17491 U2178/net40 U2178/net106 U2178/net108 VDD pmos W=0.205u L=0.04u
M17492 U2178/net40 WX8579 U2178/net104 VDD pmos W=0.205u L=0.04u
M17493 U2178/net20 U2178/net40 VDD VDD pmos W=0.205u L=0.04u
M17494 U2178/net106 WX8579 VDD VDD pmos W=0.205u L=0.04u
M17495 U2178/net104 WX8643 VDD VDD pmos W=0.205u L=0.04u
M17496 U2178/net30 WX8515 VDD VDD pmos W=0.205u L=0.04u
M17497 U2178/net108 U2178/net104 VDD VDD pmos W=0.205u L=0.04u
M17498 n1642 U2178/net28 VDD VDD pmos W=0.205u L=0.04u
M17499 U2178/net32 WX8451 VDD VDD pmos W=0.205u L=0.04u
M17500 U2178/net64 U2178/net24 VDD VDD pmos W=0.28u L=0.04u
M17501 U2178/net24 U2178/net30 U2178/net045 VDD pmos W=0.205u L=0.04u
M17502 U2178/net045 U2178/net32 VDD VDD pmos W=0.205u L=0.04u
M17503 WX6825 n1278 U2179/net26 VSS nmos W=0.155u L=0.04u
M17504 WX6825 n1527 U2179/net26 VSS nmos W=0.155u L=0.04u
M17505 U2179/net29 n1644 VSS VSS nmos W=0.155u L=0.04u
M17506 U2179/net26 n1643 U2179/net29 VSS nmos W=0.155u L=0.04u
M17507 U2179/net26 n1249 U2179/net29 VSS nmos W=0.155u L=0.04u
M17508 WX6825 n1527 U2179/net43 VDD pmos W=0.205u L=0.04u
M17509 WX6825 n1249 U2179/net49 VDD pmos W=0.205u L=0.04u
M17510 U2179/net49 n1643 VDD VDD pmos W=0.205u L=0.04u
M17511 U2179/net43 n1278 VDD VDD pmos W=0.205u L=0.04u
M17512 WX6825 n1644 VDD VDD pmos W=0.205u L=0.04u
M17513 U2180/net29 n1338 VSS VSS nmos W=0.155u L=0.04u
M17514 n1644 WX6996 U2180/net29 VSS nmos W=0.155u L=0.04u
M17515 n1644 n1307 U2180/net23 VSS nmos W=0.155u L=0.04u
M17516 U2180/net23 CRC_OUT_4_8 VSS VSS nmos W=0.155u L=0.04u
M17517 U2180/net20 CRC_OUT_4_8 n1644 VDD pmos W=0.205u L=0.04u
M17518 U2180/net20 n1307 n1644 VDD pmos W=0.205u L=0.04u
M17519 VDD WX6996 U2180/net20 VDD pmos W=0.205u L=0.04u
M17520 VDD n1338 U2180/net20 VDD pmos W=0.205u L=0.04u
M17521 n1527 n1645 VSS VSS nmos W=0.135u L=0.04u
M17522 n1527 n1645 VDD VDD pmos W=0.205u L=0.04u
M17523 U2182/net28 U2182/net20 U2182/net64 VSS nmos W=0.155u L=0.04u
M17524 U2182/net24 U2182/net30 U2182/net32 VSS nmos W=0.155u L=0.04u
M17525 U2182/net28 U2182/net40 U2182/net24 VSS nmos W=0.155u L=0.04u
M17526 U2182/net40 WX8577 U2182/net108 VSS nmos W=0.155u L=0.04u
M17527 U2182/net40 U2182/net106 U2182/net104 VSS nmos W=0.155u L=0.04u
M17528 U2182/net24 WX8513 U2182/net050 VSS nmos W=0.155u L=0.04u
M17529 U2182/net050 U2182/net32 VSS VSS nmos W=0.155u L=0.04u
M17530 U2182/net20 U2182/net40 VSS VSS nmos W=0.155u L=0.04u
M17531 U2182/net106 WX8577 VSS VSS nmos W=0.155u L=0.04u
M17532 U2182/net104 WX8641 VSS VSS nmos W=0.155u L=0.04u
M17533 U2182/net30 WX8513 VSS VSS nmos W=0.155u L=0.04u
M17534 U2182/net108 U2182/net104 VSS VSS nmos W=0.155u L=0.04u
M17535 n1645 U2182/net28 VSS VSS nmos W=0.155u L=0.04u
M17536 U2182/net32 WX8449 VSS VSS nmos W=0.155u L=0.04u
M17537 U2182/net64 U2182/net24 VSS VSS nmos W=0.2u L=0.04u
M17538 U2182/net28 U2182/net40 U2182/net64 VDD pmos W=0.205u L=0.04u
M17539 U2182/net24 WX8513 U2182/net32 VDD pmos W=0.205u L=0.04u
M17540 U2182/net28 U2182/net20 U2182/net24 VDD pmos W=0.205u L=0.04u
M17541 U2182/net40 U2182/net106 U2182/net108 VDD pmos W=0.205u L=0.04u
M17542 U2182/net40 WX8577 U2182/net104 VDD pmos W=0.205u L=0.04u
M17543 U2182/net20 U2182/net40 VDD VDD pmos W=0.205u L=0.04u
M17544 U2182/net106 WX8577 VDD VDD pmos W=0.205u L=0.04u
M17545 U2182/net104 WX8641 VDD VDD pmos W=0.205u L=0.04u
M17546 U2182/net30 WX8513 VDD VDD pmos W=0.205u L=0.04u
M17547 U2182/net108 U2182/net104 VDD VDD pmos W=0.205u L=0.04u
M17548 n1645 U2182/net28 VDD VDD pmos W=0.205u L=0.04u
M17549 U2182/net32 WX8449 VDD VDD pmos W=0.205u L=0.04u
M17550 U2182/net64 U2182/net24 VDD VDD pmos W=0.28u L=0.04u
M17551 U2182/net24 U2182/net30 U2182/net045 VDD pmos W=0.205u L=0.04u
M17552 U2182/net045 U2182/net32 VDD VDD pmos W=0.205u L=0.04u
M17553 WX6811 n1278 U2183/net26 VSS nmos W=0.155u L=0.04u
M17554 WX6811 n1530 U2183/net26 VSS nmos W=0.155u L=0.04u
M17555 U2183/net29 n1647 VSS VSS nmos W=0.155u L=0.04u
M17556 U2183/net26 n1646 U2183/net29 VSS nmos W=0.155u L=0.04u
M17557 U2183/net26 n1249 U2183/net29 VSS nmos W=0.155u L=0.04u
M17558 WX6811 n1530 U2183/net43 VDD pmos W=0.205u L=0.04u
M17559 WX6811 n1249 U2183/net49 VDD pmos W=0.205u L=0.04u
M17560 U2183/net49 n1646 VDD VDD pmos W=0.205u L=0.04u
M17561 U2183/net43 n1278 VDD VDD pmos W=0.205u L=0.04u
M17562 WX6811 n1647 VDD VDD pmos W=0.205u L=0.04u
M17563 U2184/net29 n1338 VSS VSS nmos W=0.155u L=0.04u
M17564 n1647 WX6994 U2184/net29 VSS nmos W=0.155u L=0.04u
M17565 n1647 n1307 U2184/net23 VSS nmos W=0.155u L=0.04u
M17566 U2184/net23 CRC_OUT_4_9 VSS VSS nmos W=0.155u L=0.04u
M17567 U2184/net20 CRC_OUT_4_9 n1647 VDD pmos W=0.205u L=0.04u
M17568 U2184/net20 n1307 n1647 VDD pmos W=0.205u L=0.04u
M17569 VDD WX6994 U2184/net20 VDD pmos W=0.205u L=0.04u
M17570 VDD n1338 U2184/net20 VDD pmos W=0.205u L=0.04u
M17571 n1530 n1648 VSS VSS nmos W=0.135u L=0.04u
M17572 n1530 n1648 VDD VDD pmos W=0.205u L=0.04u
M17573 U2186/net28 U2186/net20 U2186/net64 VSS nmos W=0.155u L=0.04u
M17574 U2186/net24 U2186/net30 U2186/net32 VSS nmos W=0.155u L=0.04u
M17575 U2186/net28 U2186/net40 U2186/net24 VSS nmos W=0.155u L=0.04u
M17576 U2186/net40 WX8575 U2186/net108 VSS nmos W=0.155u L=0.04u
M17577 U2186/net40 U2186/net106 U2186/net104 VSS nmos W=0.155u L=0.04u
M17578 U2186/net24 WX8511 U2186/net050 VSS nmos W=0.155u L=0.04u
M17579 U2186/net050 U2186/net32 VSS VSS nmos W=0.155u L=0.04u
M17580 U2186/net20 U2186/net40 VSS VSS nmos W=0.155u L=0.04u
M17581 U2186/net106 WX8575 VSS VSS nmos W=0.155u L=0.04u
M17582 U2186/net104 WX8639 VSS VSS nmos W=0.155u L=0.04u
M17583 U2186/net30 WX8511 VSS VSS nmos W=0.155u L=0.04u
M17584 U2186/net108 U2186/net104 VSS VSS nmos W=0.155u L=0.04u
M17585 n1648 U2186/net28 VSS VSS nmos W=0.155u L=0.04u
M17586 U2186/net32 WX8447 VSS VSS nmos W=0.155u L=0.04u
M17587 U2186/net64 U2186/net24 VSS VSS nmos W=0.2u L=0.04u
M17588 U2186/net28 U2186/net40 U2186/net64 VDD pmos W=0.205u L=0.04u
M17589 U2186/net24 WX8511 U2186/net32 VDD pmos W=0.205u L=0.04u
M17590 U2186/net28 U2186/net20 U2186/net24 VDD pmos W=0.205u L=0.04u
M17591 U2186/net40 U2186/net106 U2186/net108 VDD pmos W=0.205u L=0.04u
M17592 U2186/net40 WX8575 U2186/net104 VDD pmos W=0.205u L=0.04u
M17593 U2186/net20 U2186/net40 VDD VDD pmos W=0.205u L=0.04u
M17594 U2186/net106 WX8575 VDD VDD pmos W=0.205u L=0.04u
M17595 U2186/net104 WX8639 VDD VDD pmos W=0.205u L=0.04u
M17596 U2186/net30 WX8511 VDD VDD pmos W=0.205u L=0.04u
M17597 U2186/net108 U2186/net104 VDD VDD pmos W=0.205u L=0.04u
M17598 n1648 U2186/net28 VDD VDD pmos W=0.205u L=0.04u
M17599 U2186/net32 WX8447 VDD VDD pmos W=0.205u L=0.04u
M17600 U2186/net64 U2186/net24 VDD VDD pmos W=0.28u L=0.04u
M17601 U2186/net24 U2186/net30 U2186/net045 VDD pmos W=0.205u L=0.04u
M17602 U2186/net045 U2186/net32 VDD VDD pmos W=0.205u L=0.04u
M17603 WX6797 n1278 U2187/net26 VSS nmos W=0.155u L=0.04u
M17604 WX6797 n1533 U2187/net26 VSS nmos W=0.155u L=0.04u
M17605 U2187/net29 n1650 VSS VSS nmos W=0.155u L=0.04u
M17606 U2187/net26 n1649 U2187/net29 VSS nmos W=0.155u L=0.04u
M17607 U2187/net26 n1249 U2187/net29 VSS nmos W=0.155u L=0.04u
M17608 WX6797 n1533 U2187/net43 VDD pmos W=0.205u L=0.04u
M17609 WX6797 n1249 U2187/net49 VDD pmos W=0.205u L=0.04u
M17610 U2187/net49 n1649 VDD VDD pmos W=0.205u L=0.04u
M17611 U2187/net43 n1278 VDD VDD pmos W=0.205u L=0.04u
M17612 WX6797 n1650 VDD VDD pmos W=0.205u L=0.04u
M17613 U2188/net29 n1337 VSS VSS nmos W=0.155u L=0.04u
M17614 n1650 WX6992 U2188/net29 VSS nmos W=0.155u L=0.04u
M17615 n1650 n1307 U2188/net23 VSS nmos W=0.155u L=0.04u
M17616 U2188/net23 CRC_OUT_4_10 VSS VSS nmos W=0.155u L=0.04u
M17617 U2188/net20 CRC_OUT_4_10 n1650 VDD pmos W=0.205u L=0.04u
M17618 U2188/net20 n1307 n1650 VDD pmos W=0.205u L=0.04u
M17619 VDD WX6992 U2188/net20 VDD pmos W=0.205u L=0.04u
M17620 VDD n1337 U2188/net20 VDD pmos W=0.205u L=0.04u
M17621 n1533 n1651 VSS VSS nmos W=0.135u L=0.04u
M17622 n1533 n1651 VDD VDD pmos W=0.205u L=0.04u
M17623 U2190/net28 U2190/net20 U2190/net64 VSS nmos W=0.155u L=0.04u
M17624 U2190/net24 U2190/net30 U2190/net32 VSS nmos W=0.155u L=0.04u
M17625 U2190/net28 U2190/net40 U2190/net24 VSS nmos W=0.155u L=0.04u
M17626 U2190/net40 WX8573 U2190/net108 VSS nmos W=0.155u L=0.04u
M17627 U2190/net40 U2190/net106 U2190/net104 VSS nmos W=0.155u L=0.04u
M17628 U2190/net24 WX8509 U2190/net050 VSS nmos W=0.155u L=0.04u
M17629 U2190/net050 U2190/net32 VSS VSS nmos W=0.155u L=0.04u
M17630 U2190/net20 U2190/net40 VSS VSS nmos W=0.155u L=0.04u
M17631 U2190/net106 WX8573 VSS VSS nmos W=0.155u L=0.04u
M17632 U2190/net104 WX8637 VSS VSS nmos W=0.155u L=0.04u
M17633 U2190/net30 WX8509 VSS VSS nmos W=0.155u L=0.04u
M17634 U2190/net108 U2190/net104 VSS VSS nmos W=0.155u L=0.04u
M17635 n1651 U2190/net28 VSS VSS nmos W=0.155u L=0.04u
M17636 U2190/net32 WX8445 VSS VSS nmos W=0.155u L=0.04u
M17637 U2190/net64 U2190/net24 VSS VSS nmos W=0.2u L=0.04u
M17638 U2190/net28 U2190/net40 U2190/net64 VDD pmos W=0.205u L=0.04u
M17639 U2190/net24 WX8509 U2190/net32 VDD pmos W=0.205u L=0.04u
M17640 U2190/net28 U2190/net20 U2190/net24 VDD pmos W=0.205u L=0.04u
M17641 U2190/net40 U2190/net106 U2190/net108 VDD pmos W=0.205u L=0.04u
M17642 U2190/net40 WX8573 U2190/net104 VDD pmos W=0.205u L=0.04u
M17643 U2190/net20 U2190/net40 VDD VDD pmos W=0.205u L=0.04u
M17644 U2190/net106 WX8573 VDD VDD pmos W=0.205u L=0.04u
M17645 U2190/net104 WX8637 VDD VDD pmos W=0.205u L=0.04u
M17646 U2190/net30 WX8509 VDD VDD pmos W=0.205u L=0.04u
M17647 U2190/net108 U2190/net104 VDD VDD pmos W=0.205u L=0.04u
M17648 n1651 U2190/net28 VDD VDD pmos W=0.205u L=0.04u
M17649 U2190/net32 WX8445 VDD VDD pmos W=0.205u L=0.04u
M17650 U2190/net64 U2190/net24 VDD VDD pmos W=0.28u L=0.04u
M17651 U2190/net24 U2190/net30 U2190/net045 VDD pmos W=0.205u L=0.04u
M17652 U2190/net045 U2190/net32 VDD VDD pmos W=0.205u L=0.04u
M17653 WX6783 n1277 U2191/net26 VSS nmos W=0.155u L=0.04u
M17654 WX6783 n1536 U2191/net26 VSS nmos W=0.155u L=0.04u
M17655 U2191/net29 n1653 VSS VSS nmos W=0.155u L=0.04u
M17656 U2191/net26 n1652 U2191/net29 VSS nmos W=0.155u L=0.04u
M17657 U2191/net26 n1249 U2191/net29 VSS nmos W=0.155u L=0.04u
M17658 WX6783 n1536 U2191/net43 VDD pmos W=0.205u L=0.04u
M17659 WX6783 n1249 U2191/net49 VDD pmos W=0.205u L=0.04u
M17660 U2191/net49 n1652 VDD VDD pmos W=0.205u L=0.04u
M17661 U2191/net43 n1277 VDD VDD pmos W=0.205u L=0.04u
M17662 WX6783 n1653 VDD VDD pmos W=0.205u L=0.04u
M17663 U2192/net29 n1337 VSS VSS nmos W=0.155u L=0.04u
M17664 n1653 WX6990 U2192/net29 VSS nmos W=0.155u L=0.04u
M17665 n1653 n1307 U2192/net23 VSS nmos W=0.155u L=0.04u
M17666 U2192/net23 CRC_OUT_4_11 VSS VSS nmos W=0.155u L=0.04u
M17667 U2192/net20 CRC_OUT_4_11 n1653 VDD pmos W=0.205u L=0.04u
M17668 U2192/net20 n1307 n1653 VDD pmos W=0.205u L=0.04u
M17669 VDD WX6990 U2192/net20 VDD pmos W=0.205u L=0.04u
M17670 VDD n1337 U2192/net20 VDD pmos W=0.205u L=0.04u
M17671 n1536 n1654 VSS VSS nmos W=0.135u L=0.04u
M17672 n1536 n1654 VDD VDD pmos W=0.205u L=0.04u
M17673 U2194/net28 U2194/net20 U2194/net64 VSS nmos W=0.155u L=0.04u
M17674 U2194/net24 U2194/net30 U2194/net32 VSS nmos W=0.155u L=0.04u
M17675 U2194/net28 U2194/net40 U2194/net24 VSS nmos W=0.155u L=0.04u
M17676 U2194/net40 WX8571 U2194/net108 VSS nmos W=0.155u L=0.04u
M17677 U2194/net40 U2194/net106 U2194/net104 VSS nmos W=0.155u L=0.04u
M17678 U2194/net24 WX8507 U2194/net050 VSS nmos W=0.155u L=0.04u
M17679 U2194/net050 U2194/net32 VSS VSS nmos W=0.155u L=0.04u
M17680 U2194/net20 U2194/net40 VSS VSS nmos W=0.155u L=0.04u
M17681 U2194/net106 WX8571 VSS VSS nmos W=0.155u L=0.04u
M17682 U2194/net104 WX8635 VSS VSS nmos W=0.155u L=0.04u
M17683 U2194/net30 WX8507 VSS VSS nmos W=0.155u L=0.04u
M17684 U2194/net108 U2194/net104 VSS VSS nmos W=0.155u L=0.04u
M17685 n1654 U2194/net28 VSS VSS nmos W=0.155u L=0.04u
M17686 U2194/net32 WX8443 VSS VSS nmos W=0.155u L=0.04u
M17687 U2194/net64 U2194/net24 VSS VSS nmos W=0.2u L=0.04u
M17688 U2194/net28 U2194/net40 U2194/net64 VDD pmos W=0.205u L=0.04u
M17689 U2194/net24 WX8507 U2194/net32 VDD pmos W=0.205u L=0.04u
M17690 U2194/net28 U2194/net20 U2194/net24 VDD pmos W=0.205u L=0.04u
M17691 U2194/net40 U2194/net106 U2194/net108 VDD pmos W=0.205u L=0.04u
M17692 U2194/net40 WX8571 U2194/net104 VDD pmos W=0.205u L=0.04u
M17693 U2194/net20 U2194/net40 VDD VDD pmos W=0.205u L=0.04u
M17694 U2194/net106 WX8571 VDD VDD pmos W=0.205u L=0.04u
M17695 U2194/net104 WX8635 VDD VDD pmos W=0.205u L=0.04u
M17696 U2194/net30 WX8507 VDD VDD pmos W=0.205u L=0.04u
M17697 U2194/net108 U2194/net104 VDD VDD pmos W=0.205u L=0.04u
M17698 n1654 U2194/net28 VDD VDD pmos W=0.205u L=0.04u
M17699 U2194/net32 WX8443 VDD VDD pmos W=0.205u L=0.04u
M17700 U2194/net64 U2194/net24 VDD VDD pmos W=0.28u L=0.04u
M17701 U2194/net24 U2194/net30 U2194/net045 VDD pmos W=0.205u L=0.04u
M17702 U2194/net045 U2194/net32 VDD VDD pmos W=0.205u L=0.04u
M17703 WX6769 n1277 U2195/net26 VSS nmos W=0.155u L=0.04u
M17704 WX6769 n1539 U2195/net26 VSS nmos W=0.155u L=0.04u
M17705 U2195/net29 n1656 VSS VSS nmos W=0.155u L=0.04u
M17706 U2195/net26 n1655 U2195/net29 VSS nmos W=0.155u L=0.04u
M17707 U2195/net26 n1249 U2195/net29 VSS nmos W=0.155u L=0.04u
M17708 WX6769 n1539 U2195/net43 VDD pmos W=0.205u L=0.04u
M17709 WX6769 n1249 U2195/net49 VDD pmos W=0.205u L=0.04u
M17710 U2195/net49 n1655 VDD VDD pmos W=0.205u L=0.04u
M17711 U2195/net43 n1277 VDD VDD pmos W=0.205u L=0.04u
M17712 WX6769 n1656 VDD VDD pmos W=0.205u L=0.04u
M17713 U2196/net29 n1337 VSS VSS nmos W=0.155u L=0.04u
M17714 n1656 WX6988 U2196/net29 VSS nmos W=0.155u L=0.04u
M17715 n1656 n1306 U2196/net23 VSS nmos W=0.155u L=0.04u
M17716 U2196/net23 CRC_OUT_4_12 VSS VSS nmos W=0.155u L=0.04u
M17717 U2196/net20 CRC_OUT_4_12 n1656 VDD pmos W=0.205u L=0.04u
M17718 U2196/net20 n1306 n1656 VDD pmos W=0.205u L=0.04u
M17719 VDD WX6988 U2196/net20 VDD pmos W=0.205u L=0.04u
M17720 VDD n1337 U2196/net20 VDD pmos W=0.205u L=0.04u
M17721 n1539 n1657 VSS VSS nmos W=0.135u L=0.04u
M17722 n1539 n1657 VDD VDD pmos W=0.205u L=0.04u
M17723 U2198/net28 U2198/net20 U2198/net64 VSS nmos W=0.155u L=0.04u
M17724 U2198/net24 U2198/net30 U2198/net32 VSS nmos W=0.155u L=0.04u
M17725 U2198/net28 U2198/net40 U2198/net24 VSS nmos W=0.155u L=0.04u
M17726 U2198/net40 WX8569 U2198/net108 VSS nmos W=0.155u L=0.04u
M17727 U2198/net40 U2198/net106 U2198/net104 VSS nmos W=0.155u L=0.04u
M17728 U2198/net24 WX8505 U2198/net050 VSS nmos W=0.155u L=0.04u
M17729 U2198/net050 U2198/net32 VSS VSS nmos W=0.155u L=0.04u
M17730 U2198/net20 U2198/net40 VSS VSS nmos W=0.155u L=0.04u
M17731 U2198/net106 WX8569 VSS VSS nmos W=0.155u L=0.04u
M17732 U2198/net104 WX8633 VSS VSS nmos W=0.155u L=0.04u
M17733 U2198/net30 WX8505 VSS VSS nmos W=0.155u L=0.04u
M17734 U2198/net108 U2198/net104 VSS VSS nmos W=0.155u L=0.04u
M17735 n1657 U2198/net28 VSS VSS nmos W=0.155u L=0.04u
M17736 U2198/net32 WX8441 VSS VSS nmos W=0.155u L=0.04u
M17737 U2198/net64 U2198/net24 VSS VSS nmos W=0.2u L=0.04u
M17738 U2198/net28 U2198/net40 U2198/net64 VDD pmos W=0.205u L=0.04u
M17739 U2198/net24 WX8505 U2198/net32 VDD pmos W=0.205u L=0.04u
M17740 U2198/net28 U2198/net20 U2198/net24 VDD pmos W=0.205u L=0.04u
M17741 U2198/net40 U2198/net106 U2198/net108 VDD pmos W=0.205u L=0.04u
M17742 U2198/net40 WX8569 U2198/net104 VDD pmos W=0.205u L=0.04u
M17743 U2198/net20 U2198/net40 VDD VDD pmos W=0.205u L=0.04u
M17744 U2198/net106 WX8569 VDD VDD pmos W=0.205u L=0.04u
M17745 U2198/net104 WX8633 VDD VDD pmos W=0.205u L=0.04u
M17746 U2198/net30 WX8505 VDD VDD pmos W=0.205u L=0.04u
M17747 U2198/net108 U2198/net104 VDD VDD pmos W=0.205u L=0.04u
M17748 n1657 U2198/net28 VDD VDD pmos W=0.205u L=0.04u
M17749 U2198/net32 WX8441 VDD VDD pmos W=0.205u L=0.04u
M17750 U2198/net64 U2198/net24 VDD VDD pmos W=0.28u L=0.04u
M17751 U2198/net24 U2198/net30 U2198/net045 VDD pmos W=0.205u L=0.04u
M17752 U2198/net045 U2198/net32 VDD VDD pmos W=0.205u L=0.04u
M17753 WX6755 n1277 U2199/net26 VSS nmos W=0.155u L=0.04u
M17754 WX6755 n1542 U2199/net26 VSS nmos W=0.155u L=0.04u
M17755 U2199/net29 n1659 VSS VSS nmos W=0.155u L=0.04u
M17756 U2199/net26 n1658 U2199/net29 VSS nmos W=0.155u L=0.04u
M17757 U2199/net26 n1249 U2199/net29 VSS nmos W=0.155u L=0.04u
M17758 WX6755 n1542 U2199/net43 VDD pmos W=0.205u L=0.04u
M17759 WX6755 n1249 U2199/net49 VDD pmos W=0.205u L=0.04u
M17760 U2199/net49 n1658 VDD VDD pmos W=0.205u L=0.04u
M17761 U2199/net43 n1277 VDD VDD pmos W=0.205u L=0.04u
M17762 WX6755 n1659 VDD VDD pmos W=0.205u L=0.04u
M17763 U2200/net29 n1337 VSS VSS nmos W=0.155u L=0.04u
M17764 n1659 WX6986 U2200/net29 VSS nmos W=0.155u L=0.04u
M17765 n1659 n1306 U2200/net23 VSS nmos W=0.155u L=0.04u
M17766 U2200/net23 CRC_OUT_4_13 VSS VSS nmos W=0.155u L=0.04u
M17767 U2200/net20 CRC_OUT_4_13 n1659 VDD pmos W=0.205u L=0.04u
M17768 U2200/net20 n1306 n1659 VDD pmos W=0.205u L=0.04u
M17769 VDD WX6986 U2200/net20 VDD pmos W=0.205u L=0.04u
M17770 VDD n1337 U2200/net20 VDD pmos W=0.205u L=0.04u
M17771 n1542 n1660 VSS VSS nmos W=0.135u L=0.04u
M17772 n1542 n1660 VDD VDD pmos W=0.205u L=0.04u
M17773 U2202/net28 U2202/net20 U2202/net64 VSS nmos W=0.155u L=0.04u
M17774 U2202/net24 U2202/net30 U2202/net32 VSS nmos W=0.155u L=0.04u
M17775 U2202/net28 U2202/net40 U2202/net24 VSS nmos W=0.155u L=0.04u
M17776 U2202/net40 WX8567 U2202/net108 VSS nmos W=0.155u L=0.04u
M17777 U2202/net40 U2202/net106 U2202/net104 VSS nmos W=0.155u L=0.04u
M17778 U2202/net24 WX8503 U2202/net050 VSS nmos W=0.155u L=0.04u
M17779 U2202/net050 U2202/net32 VSS VSS nmos W=0.155u L=0.04u
M17780 U2202/net20 U2202/net40 VSS VSS nmos W=0.155u L=0.04u
M17781 U2202/net106 WX8567 VSS VSS nmos W=0.155u L=0.04u
M17782 U2202/net104 WX8631 VSS VSS nmos W=0.155u L=0.04u
M17783 U2202/net30 WX8503 VSS VSS nmos W=0.155u L=0.04u
M17784 U2202/net108 U2202/net104 VSS VSS nmos W=0.155u L=0.04u
M17785 n1660 U2202/net28 VSS VSS nmos W=0.155u L=0.04u
M17786 U2202/net32 WX8439 VSS VSS nmos W=0.155u L=0.04u
M17787 U2202/net64 U2202/net24 VSS VSS nmos W=0.2u L=0.04u
M17788 U2202/net28 U2202/net40 U2202/net64 VDD pmos W=0.205u L=0.04u
M17789 U2202/net24 WX8503 U2202/net32 VDD pmos W=0.205u L=0.04u
M17790 U2202/net28 U2202/net20 U2202/net24 VDD pmos W=0.205u L=0.04u
M17791 U2202/net40 U2202/net106 U2202/net108 VDD pmos W=0.205u L=0.04u
M17792 U2202/net40 WX8567 U2202/net104 VDD pmos W=0.205u L=0.04u
M17793 U2202/net20 U2202/net40 VDD VDD pmos W=0.205u L=0.04u
M17794 U2202/net106 WX8567 VDD VDD pmos W=0.205u L=0.04u
M17795 U2202/net104 WX8631 VDD VDD pmos W=0.205u L=0.04u
M17796 U2202/net30 WX8503 VDD VDD pmos W=0.205u L=0.04u
M17797 U2202/net108 U2202/net104 VDD VDD pmos W=0.205u L=0.04u
M17798 n1660 U2202/net28 VDD VDD pmos W=0.205u L=0.04u
M17799 U2202/net32 WX8439 VDD VDD pmos W=0.205u L=0.04u
M17800 U2202/net64 U2202/net24 VDD VDD pmos W=0.28u L=0.04u
M17801 U2202/net24 U2202/net30 U2202/net045 VDD pmos W=0.205u L=0.04u
M17802 U2202/net045 U2202/net32 VDD VDD pmos W=0.205u L=0.04u
M17803 WX6741 n1277 U2203/net26 VSS nmos W=0.155u L=0.04u
M17804 WX6741 n1545 U2203/net26 VSS nmos W=0.155u L=0.04u
M17805 U2203/net29 n1662 VSS VSS nmos W=0.155u L=0.04u
M17806 U2203/net26 n1661 U2203/net29 VSS nmos W=0.155u L=0.04u
M17807 U2203/net26 n1249 U2203/net29 VSS nmos W=0.155u L=0.04u
M17808 WX6741 n1545 U2203/net43 VDD pmos W=0.205u L=0.04u
M17809 WX6741 n1249 U2203/net49 VDD pmos W=0.205u L=0.04u
M17810 U2203/net49 n1661 VDD VDD pmos W=0.205u L=0.04u
M17811 U2203/net43 n1277 VDD VDD pmos W=0.205u L=0.04u
M17812 WX6741 n1662 VDD VDD pmos W=0.205u L=0.04u
M17813 U2204/net29 n1337 VSS VSS nmos W=0.155u L=0.04u
M17814 n1662 WX6984 U2204/net29 VSS nmos W=0.155u L=0.04u
M17815 n1662 n1306 U2204/net23 VSS nmos W=0.155u L=0.04u
M17816 U2204/net23 CRC_OUT_4_14 VSS VSS nmos W=0.155u L=0.04u
M17817 U2204/net20 CRC_OUT_4_14 n1662 VDD pmos W=0.205u L=0.04u
M17818 U2204/net20 n1306 n1662 VDD pmos W=0.205u L=0.04u
M17819 VDD WX6984 U2204/net20 VDD pmos W=0.205u L=0.04u
M17820 VDD n1337 U2204/net20 VDD pmos W=0.205u L=0.04u
M17821 n1545 n1663 VSS VSS nmos W=0.135u L=0.04u
M17822 n1545 n1663 VDD VDD pmos W=0.205u L=0.04u
M17823 U2206/net28 U2206/net20 U2206/net64 VSS nmos W=0.155u L=0.04u
M17824 U2206/net24 U2206/net30 U2206/net32 VSS nmos W=0.155u L=0.04u
M17825 U2206/net28 U2206/net40 U2206/net24 VSS nmos W=0.155u L=0.04u
M17826 U2206/net40 WX8565 U2206/net108 VSS nmos W=0.155u L=0.04u
M17827 U2206/net40 U2206/net106 U2206/net104 VSS nmos W=0.155u L=0.04u
M17828 U2206/net24 WX8501 U2206/net050 VSS nmos W=0.155u L=0.04u
M17829 U2206/net050 U2206/net32 VSS VSS nmos W=0.155u L=0.04u
M17830 U2206/net20 U2206/net40 VSS VSS nmos W=0.155u L=0.04u
M17831 U2206/net106 WX8565 VSS VSS nmos W=0.155u L=0.04u
M17832 U2206/net104 WX8629 VSS VSS nmos W=0.155u L=0.04u
M17833 U2206/net30 WX8501 VSS VSS nmos W=0.155u L=0.04u
M17834 U2206/net108 U2206/net104 VSS VSS nmos W=0.155u L=0.04u
M17835 n1663 U2206/net28 VSS VSS nmos W=0.155u L=0.04u
M17836 U2206/net32 WX8437 VSS VSS nmos W=0.155u L=0.04u
M17837 U2206/net64 U2206/net24 VSS VSS nmos W=0.2u L=0.04u
M17838 U2206/net28 U2206/net40 U2206/net64 VDD pmos W=0.205u L=0.04u
M17839 U2206/net24 WX8501 U2206/net32 VDD pmos W=0.205u L=0.04u
M17840 U2206/net28 U2206/net20 U2206/net24 VDD pmos W=0.205u L=0.04u
M17841 U2206/net40 U2206/net106 U2206/net108 VDD pmos W=0.205u L=0.04u
M17842 U2206/net40 WX8565 U2206/net104 VDD pmos W=0.205u L=0.04u
M17843 U2206/net20 U2206/net40 VDD VDD pmos W=0.205u L=0.04u
M17844 U2206/net106 WX8565 VDD VDD pmos W=0.205u L=0.04u
M17845 U2206/net104 WX8629 VDD VDD pmos W=0.205u L=0.04u
M17846 U2206/net30 WX8501 VDD VDD pmos W=0.205u L=0.04u
M17847 U2206/net108 U2206/net104 VDD VDD pmos W=0.205u L=0.04u
M17848 n1663 U2206/net28 VDD VDD pmos W=0.205u L=0.04u
M17849 U2206/net32 WX8437 VDD VDD pmos W=0.205u L=0.04u
M17850 U2206/net64 U2206/net24 VDD VDD pmos W=0.28u L=0.04u
M17851 U2206/net24 U2206/net30 U2206/net045 VDD pmos W=0.205u L=0.04u
M17852 U2206/net045 U2206/net32 VDD VDD pmos W=0.205u L=0.04u
M17853 WX6727 n1277 U2207/net26 VSS nmos W=0.155u L=0.04u
M17854 WX6727 n1548 U2207/net26 VSS nmos W=0.155u L=0.04u
M17855 U2207/net29 n1665 VSS VSS nmos W=0.155u L=0.04u
M17856 U2207/net26 n1664 U2207/net29 VSS nmos W=0.155u L=0.04u
M17857 U2207/net26 n1249 U2207/net29 VSS nmos W=0.155u L=0.04u
M17858 WX6727 n1548 U2207/net43 VDD pmos W=0.205u L=0.04u
M17859 WX6727 n1249 U2207/net49 VDD pmos W=0.205u L=0.04u
M17860 U2207/net49 n1664 VDD VDD pmos W=0.205u L=0.04u
M17861 U2207/net43 n1277 VDD VDD pmos W=0.205u L=0.04u
M17862 WX6727 n1665 VDD VDD pmos W=0.205u L=0.04u
M17863 U2208/net29 n1337 VSS VSS nmos W=0.155u L=0.04u
M17864 n1665 WX6982 U2208/net29 VSS nmos W=0.155u L=0.04u
M17865 n1665 n1306 U2208/net23 VSS nmos W=0.155u L=0.04u
M17866 U2208/net23 CRC_OUT_4_15 VSS VSS nmos W=0.155u L=0.04u
M17867 U2208/net20 CRC_OUT_4_15 n1665 VDD pmos W=0.205u L=0.04u
M17868 U2208/net20 n1306 n1665 VDD pmos W=0.205u L=0.04u
M17869 VDD WX6982 U2208/net20 VDD pmos W=0.205u L=0.04u
M17870 VDD n1337 U2208/net20 VDD pmos W=0.205u L=0.04u
M17871 n1548 n1666 VSS VSS nmos W=0.135u L=0.04u
M17872 n1548 n1666 VDD VDD pmos W=0.205u L=0.04u
M17873 U2210/net28 U2210/net20 U2210/net64 VSS nmos W=0.155u L=0.04u
M17874 U2210/net24 U2210/net30 U2210/net32 VSS nmos W=0.155u L=0.04u
M17875 U2210/net28 U2210/net40 U2210/net24 VSS nmos W=0.155u L=0.04u
M17876 U2210/net40 WX8563 U2210/net108 VSS nmos W=0.155u L=0.04u
M17877 U2210/net40 U2210/net106 U2210/net104 VSS nmos W=0.155u L=0.04u
M17878 U2210/net24 WX8499 U2210/net050 VSS nmos W=0.155u L=0.04u
M17879 U2210/net050 U2210/net32 VSS VSS nmos W=0.155u L=0.04u
M17880 U2210/net20 U2210/net40 VSS VSS nmos W=0.155u L=0.04u
M17881 U2210/net106 WX8563 VSS VSS nmos W=0.155u L=0.04u
M17882 U2210/net104 WX8627 VSS VSS nmos W=0.155u L=0.04u
M17883 U2210/net30 WX8499 VSS VSS nmos W=0.155u L=0.04u
M17884 U2210/net108 U2210/net104 VSS VSS nmos W=0.155u L=0.04u
M17885 n1666 U2210/net28 VSS VSS nmos W=0.155u L=0.04u
M17886 U2210/net32 WX8435 VSS VSS nmos W=0.155u L=0.04u
M17887 U2210/net64 U2210/net24 VSS VSS nmos W=0.2u L=0.04u
M17888 U2210/net28 U2210/net40 U2210/net64 VDD pmos W=0.205u L=0.04u
M17889 U2210/net24 WX8499 U2210/net32 VDD pmos W=0.205u L=0.04u
M17890 U2210/net28 U2210/net20 U2210/net24 VDD pmos W=0.205u L=0.04u
M17891 U2210/net40 U2210/net106 U2210/net108 VDD pmos W=0.205u L=0.04u
M17892 U2210/net40 WX8563 U2210/net104 VDD pmos W=0.205u L=0.04u
M17893 U2210/net20 U2210/net40 VDD VDD pmos W=0.205u L=0.04u
M17894 U2210/net106 WX8563 VDD VDD pmos W=0.205u L=0.04u
M17895 U2210/net104 WX8627 VDD VDD pmos W=0.205u L=0.04u
M17896 U2210/net30 WX8499 VDD VDD pmos W=0.205u L=0.04u
M17897 U2210/net108 U2210/net104 VDD VDD pmos W=0.205u L=0.04u
M17898 n1666 U2210/net28 VDD VDD pmos W=0.205u L=0.04u
M17899 U2210/net32 WX8435 VDD VDD pmos W=0.205u L=0.04u
M17900 U2210/net64 U2210/net24 VDD VDD pmos W=0.28u L=0.04u
M17901 U2210/net24 U2210/net30 U2210/net045 VDD pmos W=0.205u L=0.04u
M17902 U2210/net045 U2210/net32 VDD VDD pmos W=0.205u L=0.04u
M17903 WX6713 n1277 U2211/net26 VSS nmos W=0.155u L=0.04u
M17904 WX6713 n1551 U2211/net26 VSS nmos W=0.155u L=0.04u
M17905 U2211/net29 n1668 VSS VSS nmos W=0.155u L=0.04u
M17906 U2211/net26 n1667 U2211/net29 VSS nmos W=0.155u L=0.04u
M17907 U2211/net26 n1249 U2211/net29 VSS nmos W=0.155u L=0.04u
M17908 WX6713 n1551 U2211/net43 VDD pmos W=0.205u L=0.04u
M17909 WX6713 n1249 U2211/net49 VDD pmos W=0.205u L=0.04u
M17910 U2211/net49 n1667 VDD VDD pmos W=0.205u L=0.04u
M17911 U2211/net43 n1277 VDD VDD pmos W=0.205u L=0.04u
M17912 WX6713 n1668 VDD VDD pmos W=0.205u L=0.04u
M17913 U2212/net29 n1337 VSS VSS nmos W=0.155u L=0.04u
M17914 n1668 WX6980 U2212/net29 VSS nmos W=0.155u L=0.04u
M17915 n1668 n1306 U2212/net23 VSS nmos W=0.155u L=0.04u
M17916 U2212/net23 CRC_OUT_4_16 VSS VSS nmos W=0.155u L=0.04u
M17917 U2212/net20 CRC_OUT_4_16 n1668 VDD pmos W=0.205u L=0.04u
M17918 U2212/net20 n1306 n1668 VDD pmos W=0.205u L=0.04u
M17919 VDD WX6980 U2212/net20 VDD pmos W=0.205u L=0.04u
M17920 VDD n1337 U2212/net20 VDD pmos W=0.205u L=0.04u
M17921 n1551 n1669 VSS VSS nmos W=0.135u L=0.04u
M17922 n1551 n1669 VDD VDD pmos W=0.205u L=0.04u
M17923 U2214/net28 U2214/net20 U2214/net64 VSS nmos W=0.155u L=0.04u
M17924 U2214/net24 U2214/net30 U2214/net32 VSS nmos W=0.155u L=0.04u
M17925 U2214/net28 U2214/net40 U2214/net24 VSS nmos W=0.155u L=0.04u
M17926 U2214/net40 n1670 U2214/net108 VSS nmos W=0.155u L=0.04u
M17927 U2214/net40 U2214/net106 U2214/net104 VSS nmos W=0.155u L=0.04u
M17928 U2214/net24 WX8561 U2214/net050 VSS nmos W=0.155u L=0.04u
M17929 U2214/net050 U2214/net32 VSS VSS nmos W=0.155u L=0.04u
M17930 U2214/net20 U2214/net40 VSS VSS nmos W=0.155u L=0.04u
M17931 U2214/net106 n1670 VSS VSS nmos W=0.155u L=0.04u
M17932 U2214/net104 WX8625 VSS VSS nmos W=0.155u L=0.04u
M17933 U2214/net30 WX8561 VSS VSS nmos W=0.155u L=0.04u
M17934 U2214/net108 U2214/net104 VSS VSS nmos W=0.155u L=0.04u
M17935 n1669 U2214/net28 VSS VSS nmos W=0.155u L=0.04u
M17936 U2214/net32 WX8497 VSS VSS nmos W=0.155u L=0.04u
M17937 U2214/net64 U2214/net24 VSS VSS nmos W=0.2u L=0.04u
M17938 U2214/net28 U2214/net40 U2214/net64 VDD pmos W=0.205u L=0.04u
M17939 U2214/net24 WX8561 U2214/net32 VDD pmos W=0.205u L=0.04u
M17940 U2214/net28 U2214/net20 U2214/net24 VDD pmos W=0.205u L=0.04u
M17941 U2214/net40 U2214/net106 U2214/net108 VDD pmos W=0.205u L=0.04u
M17942 U2214/net40 n1670 U2214/net104 VDD pmos W=0.205u L=0.04u
M17943 U2214/net20 U2214/net40 VDD VDD pmos W=0.205u L=0.04u
M17944 U2214/net106 n1670 VDD VDD pmos W=0.205u L=0.04u
M17945 U2214/net104 WX8625 VDD VDD pmos W=0.205u L=0.04u
M17946 U2214/net30 WX8561 VDD VDD pmos W=0.205u L=0.04u
M17947 U2214/net108 U2214/net104 VDD VDD pmos W=0.205u L=0.04u
M17948 n1669 U2214/net28 VDD VDD pmos W=0.205u L=0.04u
M17949 U2214/net32 WX8497 VDD VDD pmos W=0.205u L=0.04u
M17950 U2214/net64 U2214/net24 VDD VDD pmos W=0.28u L=0.04u
M17951 U2214/net24 U2214/net30 U2214/net045 VDD pmos W=0.205u L=0.04u
M17952 U2214/net045 U2214/net32 VDD VDD pmos W=0.205u L=0.04u
M17953 U2215/net4 WX8433 U2215/net14 VSS nmos W=0.155u L=0.04u
M17954 U2215/net6 U2215/net10 U2215/net14 VSS nmos W=0.17u L=0.04u
M17955 U2215/net4 n1369 VSS VSS nmos W=0.155u L=0.04u
M17956 U2215/net6 U2215/net4 VSS VSS nmos W=0.17u L=0.04u
M17957 n1670 U2215/net14 VSS VSS nmos W=0.155u L=0.04u
M17958 U2215/net10 WX8433 VSS VSS nmos W=0.155u L=0.04u
M17959 U2215/net4 U2215/net10 U2215/net14 VDD pmos W=0.255u L=0.04u
M17960 U2215/net6 WX8433 U2215/net14 VDD pmos W=0.28u L=0.04u
M17961 U2215/net4 n1369 VDD VDD pmos W=0.205u L=0.04u
M17962 U2215/net6 U2215/net4 VDD VDD pmos W=0.24u L=0.04u
M17963 n1670 U2215/net14 VDD VDD pmos W=0.205u L=0.04u
M17964 U2215/net10 WX8433 VDD VDD pmos W=0.205u L=0.04u
M17965 WX6699 n1277 U2216/net26 VSS nmos W=0.155u L=0.04u
M17966 WX6699 n1559 U2216/net26 VSS nmos W=0.155u L=0.04u
M17967 U2216/net29 n1672 VSS VSS nmos W=0.155u L=0.04u
M17968 U2216/net26 n1671 U2216/net29 VSS nmos W=0.155u L=0.04u
M17969 U2216/net26 n1249 U2216/net29 VSS nmos W=0.155u L=0.04u
M17970 WX6699 n1559 U2216/net43 VDD pmos W=0.205u L=0.04u
M17971 WX6699 n1249 U2216/net49 VDD pmos W=0.205u L=0.04u
M17972 U2216/net49 n1671 VDD VDD pmos W=0.205u L=0.04u
M17973 U2216/net43 n1277 VDD VDD pmos W=0.205u L=0.04u
M17974 WX6699 n1672 VDD VDD pmos W=0.205u L=0.04u
M17975 U2217/net29 n1337 VSS VSS nmos W=0.155u L=0.04u
M17976 n1672 WX6978 U2217/net29 VSS nmos W=0.155u L=0.04u
M17977 n1672 n1306 U2217/net23 VSS nmos W=0.155u L=0.04u
M17978 U2217/net23 CRC_OUT_4_17 VSS VSS nmos W=0.155u L=0.04u
M17979 U2217/net20 CRC_OUT_4_17 n1672 VDD pmos W=0.205u L=0.04u
M17980 U2217/net20 n1306 n1672 VDD pmos W=0.205u L=0.04u
M17981 VDD WX6978 U2217/net20 VDD pmos W=0.205u L=0.04u
M17982 VDD n1337 U2217/net20 VDD pmos W=0.205u L=0.04u
M17983 n1559 n1673 VSS VSS nmos W=0.135u L=0.04u
M17984 n1559 n1673 VDD VDD pmos W=0.205u L=0.04u
M17985 U2219/net28 U2219/net20 U2219/net64 VSS nmos W=0.155u L=0.04u
M17986 U2219/net24 U2219/net30 U2219/net32 VSS nmos W=0.155u L=0.04u
M17987 U2219/net28 U2219/net40 U2219/net24 VSS nmos W=0.155u L=0.04u
M17988 U2219/net40 n1674 U2219/net108 VSS nmos W=0.155u L=0.04u
M17989 U2219/net40 U2219/net106 U2219/net104 VSS nmos W=0.155u L=0.04u
M17990 U2219/net24 WX8559 U2219/net050 VSS nmos W=0.155u L=0.04u
M17991 U2219/net050 U2219/net32 VSS VSS nmos W=0.155u L=0.04u
M17992 U2219/net20 U2219/net40 VSS VSS nmos W=0.155u L=0.04u
M17993 U2219/net106 n1674 VSS VSS nmos W=0.155u L=0.04u
M17994 U2219/net104 WX8623 VSS VSS nmos W=0.155u L=0.04u
M17995 U2219/net30 WX8559 VSS VSS nmos W=0.155u L=0.04u
M17996 U2219/net108 U2219/net104 VSS VSS nmos W=0.155u L=0.04u
M17997 n1673 U2219/net28 VSS VSS nmos W=0.155u L=0.04u
M17998 U2219/net32 WX8495 VSS VSS nmos W=0.155u L=0.04u
M17999 U2219/net64 U2219/net24 VSS VSS nmos W=0.2u L=0.04u
M18000 U2219/net28 U2219/net40 U2219/net64 VDD pmos W=0.205u L=0.04u
M18001 U2219/net24 WX8559 U2219/net32 VDD pmos W=0.205u L=0.04u
M18002 U2219/net28 U2219/net20 U2219/net24 VDD pmos W=0.205u L=0.04u
M18003 U2219/net40 U2219/net106 U2219/net108 VDD pmos W=0.205u L=0.04u
M18004 U2219/net40 n1674 U2219/net104 VDD pmos W=0.205u L=0.04u
M18005 U2219/net20 U2219/net40 VDD VDD pmos W=0.205u L=0.04u
M18006 U2219/net106 n1674 VDD VDD pmos W=0.205u L=0.04u
M18007 U2219/net104 WX8623 VDD VDD pmos W=0.205u L=0.04u
M18008 U2219/net30 WX8559 VDD VDD pmos W=0.205u L=0.04u
M18009 U2219/net108 U2219/net104 VDD VDD pmos W=0.205u L=0.04u
M18010 n1673 U2219/net28 VDD VDD pmos W=0.205u L=0.04u
M18011 U2219/net32 WX8495 VDD VDD pmos W=0.205u L=0.04u
M18012 U2219/net64 U2219/net24 VDD VDD pmos W=0.28u L=0.04u
M18013 U2219/net24 U2219/net30 U2219/net045 VDD pmos W=0.205u L=0.04u
M18014 U2219/net045 U2219/net32 VDD VDD pmos W=0.205u L=0.04u
M18015 U2220/net4 WX8431 U2220/net14 VSS nmos W=0.155u L=0.04u
M18016 U2220/net6 U2220/net10 U2220/net14 VSS nmos W=0.17u L=0.04u
M18017 U2220/net4 n1369 VSS VSS nmos W=0.155u L=0.04u
M18018 U2220/net6 U2220/net4 VSS VSS nmos W=0.17u L=0.04u
M18019 n1674 U2220/net14 VSS VSS nmos W=0.155u L=0.04u
M18020 U2220/net10 WX8431 VSS VSS nmos W=0.155u L=0.04u
M18021 U2220/net4 U2220/net10 U2220/net14 VDD pmos W=0.255u L=0.04u
M18022 U2220/net6 WX8431 U2220/net14 VDD pmos W=0.28u L=0.04u
M18023 U2220/net4 n1369 VDD VDD pmos W=0.205u L=0.04u
M18024 U2220/net6 U2220/net4 VDD VDD pmos W=0.24u L=0.04u
M18025 n1674 U2220/net14 VDD VDD pmos W=0.205u L=0.04u
M18026 U2220/net10 WX8431 VDD VDD pmos W=0.205u L=0.04u
M18027 WX6685 n1277 U2221/net26 VSS nmos W=0.155u L=0.04u
M18028 WX6685 n1563 U2221/net26 VSS nmos W=0.155u L=0.04u
M18029 U2221/net29 n1676 VSS VSS nmos W=0.155u L=0.04u
M18030 U2221/net26 n1675 U2221/net29 VSS nmos W=0.155u L=0.04u
M18031 U2221/net26 n1249 U2221/net29 VSS nmos W=0.155u L=0.04u
M18032 WX6685 n1563 U2221/net43 VDD pmos W=0.205u L=0.04u
M18033 WX6685 n1249 U2221/net49 VDD pmos W=0.205u L=0.04u
M18034 U2221/net49 n1675 VDD VDD pmos W=0.205u L=0.04u
M18035 U2221/net43 n1277 VDD VDD pmos W=0.205u L=0.04u
M18036 WX6685 n1676 VDD VDD pmos W=0.205u L=0.04u
M18037 U2222/net29 n1337 VSS VSS nmos W=0.155u L=0.04u
M18038 n1676 WX6976 U2222/net29 VSS nmos W=0.155u L=0.04u
M18039 n1676 n1306 U2222/net23 VSS nmos W=0.155u L=0.04u
M18040 U2222/net23 CRC_OUT_4_18 VSS VSS nmos W=0.155u L=0.04u
M18041 U2222/net20 CRC_OUT_4_18 n1676 VDD pmos W=0.205u L=0.04u
M18042 U2222/net20 n1306 n1676 VDD pmos W=0.205u L=0.04u
M18043 VDD WX6976 U2222/net20 VDD pmos W=0.205u L=0.04u
M18044 VDD n1337 U2222/net20 VDD pmos W=0.205u L=0.04u
M18045 n1563 n1677 VSS VSS nmos W=0.135u L=0.04u
M18046 n1563 n1677 VDD VDD pmos W=0.205u L=0.04u
M18047 U2224/net28 U2224/net20 U2224/net64 VSS nmos W=0.155u L=0.04u
M18048 U2224/net24 U2224/net30 U2224/net32 VSS nmos W=0.155u L=0.04u
M18049 U2224/net28 U2224/net40 U2224/net24 VSS nmos W=0.155u L=0.04u
M18050 U2224/net40 n1678 U2224/net108 VSS nmos W=0.155u L=0.04u
M18051 U2224/net40 U2224/net106 U2224/net104 VSS nmos W=0.155u L=0.04u
M18052 U2224/net24 WX8557 U2224/net050 VSS nmos W=0.155u L=0.04u
M18053 U2224/net050 U2224/net32 VSS VSS nmos W=0.155u L=0.04u
M18054 U2224/net20 U2224/net40 VSS VSS nmos W=0.155u L=0.04u
M18055 U2224/net106 n1678 VSS VSS nmos W=0.155u L=0.04u
M18056 U2224/net104 WX8621 VSS VSS nmos W=0.155u L=0.04u
M18057 U2224/net30 WX8557 VSS VSS nmos W=0.155u L=0.04u
M18058 U2224/net108 U2224/net104 VSS VSS nmos W=0.155u L=0.04u
M18059 n1677 U2224/net28 VSS VSS nmos W=0.155u L=0.04u
M18060 U2224/net32 WX8493 VSS VSS nmos W=0.155u L=0.04u
M18061 U2224/net64 U2224/net24 VSS VSS nmos W=0.2u L=0.04u
M18062 U2224/net28 U2224/net40 U2224/net64 VDD pmos W=0.205u L=0.04u
M18063 U2224/net24 WX8557 U2224/net32 VDD pmos W=0.205u L=0.04u
M18064 U2224/net28 U2224/net20 U2224/net24 VDD pmos W=0.205u L=0.04u
M18065 U2224/net40 U2224/net106 U2224/net108 VDD pmos W=0.205u L=0.04u
M18066 U2224/net40 n1678 U2224/net104 VDD pmos W=0.205u L=0.04u
M18067 U2224/net20 U2224/net40 VDD VDD pmos W=0.205u L=0.04u
M18068 U2224/net106 n1678 VDD VDD pmos W=0.205u L=0.04u
M18069 U2224/net104 WX8621 VDD VDD pmos W=0.205u L=0.04u
M18070 U2224/net30 WX8557 VDD VDD pmos W=0.205u L=0.04u
M18071 U2224/net108 U2224/net104 VDD VDD pmos W=0.205u L=0.04u
M18072 n1677 U2224/net28 VDD VDD pmos W=0.205u L=0.04u
M18073 U2224/net32 WX8493 VDD VDD pmos W=0.205u L=0.04u
M18074 U2224/net64 U2224/net24 VDD VDD pmos W=0.28u L=0.04u
M18075 U2224/net24 U2224/net30 U2224/net045 VDD pmos W=0.205u L=0.04u
M18076 U2224/net045 U2224/net32 VDD VDD pmos W=0.205u L=0.04u
M18077 U2225/net4 WX8429 U2225/net14 VSS nmos W=0.155u L=0.04u
M18078 U2225/net6 U2225/net10 U2225/net14 VSS nmos W=0.17u L=0.04u
M18079 U2225/net4 n1369 VSS VSS nmos W=0.155u L=0.04u
M18080 U2225/net6 U2225/net4 VSS VSS nmos W=0.17u L=0.04u
M18081 n1678 U2225/net14 VSS VSS nmos W=0.155u L=0.04u
M18082 U2225/net10 WX8429 VSS VSS nmos W=0.155u L=0.04u
M18083 U2225/net4 U2225/net10 U2225/net14 VDD pmos W=0.255u L=0.04u
M18084 U2225/net6 WX8429 U2225/net14 VDD pmos W=0.28u L=0.04u
M18085 U2225/net4 n1369 VDD VDD pmos W=0.205u L=0.04u
M18086 U2225/net6 U2225/net4 VDD VDD pmos W=0.24u L=0.04u
M18087 n1678 U2225/net14 VDD VDD pmos W=0.205u L=0.04u
M18088 U2225/net10 WX8429 VDD VDD pmos W=0.205u L=0.04u
M18089 WX6671 n1277 U2226/net26 VSS nmos W=0.155u L=0.04u
M18090 WX6671 n1567 U2226/net26 VSS nmos W=0.155u L=0.04u
M18091 U2226/net29 n1680 VSS VSS nmos W=0.155u L=0.04u
M18092 U2226/net26 n1679 U2226/net29 VSS nmos W=0.155u L=0.04u
M18093 U2226/net26 n1249 U2226/net29 VSS nmos W=0.155u L=0.04u
M18094 WX6671 n1567 U2226/net43 VDD pmos W=0.205u L=0.04u
M18095 WX6671 n1249 U2226/net49 VDD pmos W=0.205u L=0.04u
M18096 U2226/net49 n1679 VDD VDD pmos W=0.205u L=0.04u
M18097 U2226/net43 n1277 VDD VDD pmos W=0.205u L=0.04u
M18098 WX6671 n1680 VDD VDD pmos W=0.205u L=0.04u
M18099 U2227/net29 n1337 VSS VSS nmos W=0.155u L=0.04u
M18100 n1680 WX6974 U2227/net29 VSS nmos W=0.155u L=0.04u
M18101 n1680 n1306 U2227/net23 VSS nmos W=0.155u L=0.04u
M18102 U2227/net23 CRC_OUT_4_19 VSS VSS nmos W=0.155u L=0.04u
M18103 U2227/net20 CRC_OUT_4_19 n1680 VDD pmos W=0.205u L=0.04u
M18104 U2227/net20 n1306 n1680 VDD pmos W=0.205u L=0.04u
M18105 VDD WX6974 U2227/net20 VDD pmos W=0.205u L=0.04u
M18106 VDD n1337 U2227/net20 VDD pmos W=0.205u L=0.04u
M18107 n1567 n1681 VSS VSS nmos W=0.135u L=0.04u
M18108 n1567 n1681 VDD VDD pmos W=0.205u L=0.04u
M18109 U2229/net28 U2229/net20 U2229/net64 VSS nmos W=0.155u L=0.04u
M18110 U2229/net24 U2229/net30 U2229/net32 VSS nmos W=0.155u L=0.04u
M18111 U2229/net28 U2229/net40 U2229/net24 VSS nmos W=0.155u L=0.04u
M18112 U2229/net40 n1682 U2229/net108 VSS nmos W=0.155u L=0.04u
M18113 U2229/net40 U2229/net106 U2229/net104 VSS nmos W=0.155u L=0.04u
M18114 U2229/net24 WX8555 U2229/net050 VSS nmos W=0.155u L=0.04u
M18115 U2229/net050 U2229/net32 VSS VSS nmos W=0.155u L=0.04u
M18116 U2229/net20 U2229/net40 VSS VSS nmos W=0.155u L=0.04u
M18117 U2229/net106 n1682 VSS VSS nmos W=0.155u L=0.04u
M18118 U2229/net104 WX8619 VSS VSS nmos W=0.155u L=0.04u
M18119 U2229/net30 WX8555 VSS VSS nmos W=0.155u L=0.04u
M18120 U2229/net108 U2229/net104 VSS VSS nmos W=0.155u L=0.04u
M18121 n1681 U2229/net28 VSS VSS nmos W=0.155u L=0.04u
M18122 U2229/net32 WX8491 VSS VSS nmos W=0.155u L=0.04u
M18123 U2229/net64 U2229/net24 VSS VSS nmos W=0.2u L=0.04u
M18124 U2229/net28 U2229/net40 U2229/net64 VDD pmos W=0.205u L=0.04u
M18125 U2229/net24 WX8555 U2229/net32 VDD pmos W=0.205u L=0.04u
M18126 U2229/net28 U2229/net20 U2229/net24 VDD pmos W=0.205u L=0.04u
M18127 U2229/net40 U2229/net106 U2229/net108 VDD pmos W=0.205u L=0.04u
M18128 U2229/net40 n1682 U2229/net104 VDD pmos W=0.205u L=0.04u
M18129 U2229/net20 U2229/net40 VDD VDD pmos W=0.205u L=0.04u
M18130 U2229/net106 n1682 VDD VDD pmos W=0.205u L=0.04u
M18131 U2229/net104 WX8619 VDD VDD pmos W=0.205u L=0.04u
M18132 U2229/net30 WX8555 VDD VDD pmos W=0.205u L=0.04u
M18133 U2229/net108 U2229/net104 VDD VDD pmos W=0.205u L=0.04u
M18134 n1681 U2229/net28 VDD VDD pmos W=0.205u L=0.04u
M18135 U2229/net32 WX8491 VDD VDD pmos W=0.205u L=0.04u
M18136 U2229/net64 U2229/net24 VDD VDD pmos W=0.28u L=0.04u
M18137 U2229/net24 U2229/net30 U2229/net045 VDD pmos W=0.205u L=0.04u
M18138 U2229/net045 U2229/net32 VDD VDD pmos W=0.205u L=0.04u
M18139 U2230/net4 WX8427 U2230/net14 VSS nmos W=0.155u L=0.04u
M18140 U2230/net6 U2230/net10 U2230/net14 VSS nmos W=0.17u L=0.04u
M18141 U2230/net4 n1369 VSS VSS nmos W=0.155u L=0.04u
M18142 U2230/net6 U2230/net4 VSS VSS nmos W=0.17u L=0.04u
M18143 n1682 U2230/net14 VSS VSS nmos W=0.155u L=0.04u
M18144 U2230/net10 WX8427 VSS VSS nmos W=0.155u L=0.04u
M18145 U2230/net4 U2230/net10 U2230/net14 VDD pmos W=0.255u L=0.04u
M18146 U2230/net6 WX8427 U2230/net14 VDD pmos W=0.28u L=0.04u
M18147 U2230/net4 n1369 VDD VDD pmos W=0.205u L=0.04u
M18148 U2230/net6 U2230/net4 VDD VDD pmos W=0.24u L=0.04u
M18149 n1682 U2230/net14 VDD VDD pmos W=0.205u L=0.04u
M18150 U2230/net10 WX8427 VDD VDD pmos W=0.205u L=0.04u
M18151 WX6657 n1277 U2231/net26 VSS nmos W=0.155u L=0.04u
M18152 WX6657 n1571 U2231/net26 VSS nmos W=0.155u L=0.04u
M18153 U2231/net29 n1684 VSS VSS nmos W=0.155u L=0.04u
M18154 U2231/net26 n1683 U2231/net29 VSS nmos W=0.155u L=0.04u
M18155 U2231/net26 n1248 U2231/net29 VSS nmos W=0.155u L=0.04u
M18156 WX6657 n1571 U2231/net43 VDD pmos W=0.205u L=0.04u
M18157 WX6657 n1248 U2231/net49 VDD pmos W=0.205u L=0.04u
M18158 U2231/net49 n1683 VDD VDD pmos W=0.205u L=0.04u
M18159 U2231/net43 n1277 VDD VDD pmos W=0.205u L=0.04u
M18160 WX6657 n1684 VDD VDD pmos W=0.205u L=0.04u
M18161 U2232/net29 n1337 VSS VSS nmos W=0.155u L=0.04u
M18162 n1684 WX6972 U2232/net29 VSS nmos W=0.155u L=0.04u
M18163 n1684 n1306 U2232/net23 VSS nmos W=0.155u L=0.04u
M18164 U2232/net23 CRC_OUT_4_20 VSS VSS nmos W=0.155u L=0.04u
M18165 U2232/net20 CRC_OUT_4_20 n1684 VDD pmos W=0.205u L=0.04u
M18166 U2232/net20 n1306 n1684 VDD pmos W=0.205u L=0.04u
M18167 VDD WX6972 U2232/net20 VDD pmos W=0.205u L=0.04u
M18168 VDD n1337 U2232/net20 VDD pmos W=0.205u L=0.04u
M18169 n1571 n1685 VSS VSS nmos W=0.135u L=0.04u
M18170 n1571 n1685 VDD VDD pmos W=0.205u L=0.04u
M18171 U2234/net28 U2234/net20 U2234/net64 VSS nmos W=0.155u L=0.04u
M18172 U2234/net24 U2234/net30 U2234/net32 VSS nmos W=0.155u L=0.04u
M18173 U2234/net28 U2234/net40 U2234/net24 VSS nmos W=0.155u L=0.04u
M18174 U2234/net40 n1686 U2234/net108 VSS nmos W=0.155u L=0.04u
M18175 U2234/net40 U2234/net106 U2234/net104 VSS nmos W=0.155u L=0.04u
M18176 U2234/net24 WX8553 U2234/net050 VSS nmos W=0.155u L=0.04u
M18177 U2234/net050 U2234/net32 VSS VSS nmos W=0.155u L=0.04u
M18178 U2234/net20 U2234/net40 VSS VSS nmos W=0.155u L=0.04u
M18179 U2234/net106 n1686 VSS VSS nmos W=0.155u L=0.04u
M18180 U2234/net104 WX8617 VSS VSS nmos W=0.155u L=0.04u
M18181 U2234/net30 WX8553 VSS VSS nmos W=0.155u L=0.04u
M18182 U2234/net108 U2234/net104 VSS VSS nmos W=0.155u L=0.04u
M18183 n1685 U2234/net28 VSS VSS nmos W=0.155u L=0.04u
M18184 U2234/net32 WX8489 VSS VSS nmos W=0.155u L=0.04u
M18185 U2234/net64 U2234/net24 VSS VSS nmos W=0.2u L=0.04u
M18186 U2234/net28 U2234/net40 U2234/net64 VDD pmos W=0.205u L=0.04u
M18187 U2234/net24 WX8553 U2234/net32 VDD pmos W=0.205u L=0.04u
M18188 U2234/net28 U2234/net20 U2234/net24 VDD pmos W=0.205u L=0.04u
M18189 U2234/net40 U2234/net106 U2234/net108 VDD pmos W=0.205u L=0.04u
M18190 U2234/net40 n1686 U2234/net104 VDD pmos W=0.205u L=0.04u
M18191 U2234/net20 U2234/net40 VDD VDD pmos W=0.205u L=0.04u
M18192 U2234/net106 n1686 VDD VDD pmos W=0.205u L=0.04u
M18193 U2234/net104 WX8617 VDD VDD pmos W=0.205u L=0.04u
M18194 U2234/net30 WX8553 VDD VDD pmos W=0.205u L=0.04u
M18195 U2234/net108 U2234/net104 VDD VDD pmos W=0.205u L=0.04u
M18196 n1685 U2234/net28 VDD VDD pmos W=0.205u L=0.04u
M18197 U2234/net32 WX8489 VDD VDD pmos W=0.205u L=0.04u
M18198 U2234/net64 U2234/net24 VDD VDD pmos W=0.28u L=0.04u
M18199 U2234/net24 U2234/net30 U2234/net045 VDD pmos W=0.205u L=0.04u
M18200 U2234/net045 U2234/net32 VDD VDD pmos W=0.205u L=0.04u
M18201 U2235/net4 WX8425 U2235/net14 VSS nmos W=0.155u L=0.04u
M18202 U2235/net6 U2235/net10 U2235/net14 VSS nmos W=0.17u L=0.04u
M18203 U2235/net4 n1369 VSS VSS nmos W=0.155u L=0.04u
M18204 U2235/net6 U2235/net4 VSS VSS nmos W=0.17u L=0.04u
M18205 n1686 U2235/net14 VSS VSS nmos W=0.155u L=0.04u
M18206 U2235/net10 WX8425 VSS VSS nmos W=0.155u L=0.04u
M18207 U2235/net4 U2235/net10 U2235/net14 VDD pmos W=0.255u L=0.04u
M18208 U2235/net6 WX8425 U2235/net14 VDD pmos W=0.28u L=0.04u
M18209 U2235/net4 n1369 VDD VDD pmos W=0.205u L=0.04u
M18210 U2235/net6 U2235/net4 VDD VDD pmos W=0.24u L=0.04u
M18211 n1686 U2235/net14 VDD VDD pmos W=0.205u L=0.04u
M18212 U2235/net10 WX8425 VDD VDD pmos W=0.205u L=0.04u
M18213 WX6643 n1277 U2236/net26 VSS nmos W=0.155u L=0.04u
M18214 WX6643 n1575 U2236/net26 VSS nmos W=0.155u L=0.04u
M18215 U2236/net29 n1688 VSS VSS nmos W=0.155u L=0.04u
M18216 U2236/net26 n1687 U2236/net29 VSS nmos W=0.155u L=0.04u
M18217 U2236/net26 n1248 U2236/net29 VSS nmos W=0.155u L=0.04u
M18218 WX6643 n1575 U2236/net43 VDD pmos W=0.205u L=0.04u
M18219 WX6643 n1248 U2236/net49 VDD pmos W=0.205u L=0.04u
M18220 U2236/net49 n1687 VDD VDD pmos W=0.205u L=0.04u
M18221 U2236/net43 n1277 VDD VDD pmos W=0.205u L=0.04u
M18222 WX6643 n1688 VDD VDD pmos W=0.205u L=0.04u
M18223 U2237/net29 n1337 VSS VSS nmos W=0.155u L=0.04u
M18224 n1688 WX6970 U2237/net29 VSS nmos W=0.155u L=0.04u
M18225 n1688 n1306 U2237/net23 VSS nmos W=0.155u L=0.04u
M18226 U2237/net23 CRC_OUT_4_21 VSS VSS nmos W=0.155u L=0.04u
M18227 U2237/net20 CRC_OUT_4_21 n1688 VDD pmos W=0.205u L=0.04u
M18228 U2237/net20 n1306 n1688 VDD pmos W=0.205u L=0.04u
M18229 VDD WX6970 U2237/net20 VDD pmos W=0.205u L=0.04u
M18230 VDD n1337 U2237/net20 VDD pmos W=0.205u L=0.04u
M18231 n1575 n1689 VSS VSS nmos W=0.135u L=0.04u
M18232 n1575 n1689 VDD VDD pmos W=0.205u L=0.04u
M18233 U2239/net28 U2239/net20 U2239/net64 VSS nmos W=0.155u L=0.04u
M18234 U2239/net24 U2239/net30 U2239/net32 VSS nmos W=0.155u L=0.04u
M18235 U2239/net28 U2239/net40 U2239/net24 VSS nmos W=0.155u L=0.04u
M18236 U2239/net40 n1690 U2239/net108 VSS nmos W=0.155u L=0.04u
M18237 U2239/net40 U2239/net106 U2239/net104 VSS nmos W=0.155u L=0.04u
M18238 U2239/net24 WX8551 U2239/net050 VSS nmos W=0.155u L=0.04u
M18239 U2239/net050 U2239/net32 VSS VSS nmos W=0.155u L=0.04u
M18240 U2239/net20 U2239/net40 VSS VSS nmos W=0.155u L=0.04u
M18241 U2239/net106 n1690 VSS VSS nmos W=0.155u L=0.04u
M18242 U2239/net104 WX8615 VSS VSS nmos W=0.155u L=0.04u
M18243 U2239/net30 WX8551 VSS VSS nmos W=0.155u L=0.04u
M18244 U2239/net108 U2239/net104 VSS VSS nmos W=0.155u L=0.04u
M18245 n1689 U2239/net28 VSS VSS nmos W=0.155u L=0.04u
M18246 U2239/net32 WX8487 VSS VSS nmos W=0.155u L=0.04u
M18247 U2239/net64 U2239/net24 VSS VSS nmos W=0.2u L=0.04u
M18248 U2239/net28 U2239/net40 U2239/net64 VDD pmos W=0.205u L=0.04u
M18249 U2239/net24 WX8551 U2239/net32 VDD pmos W=0.205u L=0.04u
M18250 U2239/net28 U2239/net20 U2239/net24 VDD pmos W=0.205u L=0.04u
M18251 U2239/net40 U2239/net106 U2239/net108 VDD pmos W=0.205u L=0.04u
M18252 U2239/net40 n1690 U2239/net104 VDD pmos W=0.205u L=0.04u
M18253 U2239/net20 U2239/net40 VDD VDD pmos W=0.205u L=0.04u
M18254 U2239/net106 n1690 VDD VDD pmos W=0.205u L=0.04u
M18255 U2239/net104 WX8615 VDD VDD pmos W=0.205u L=0.04u
M18256 U2239/net30 WX8551 VDD VDD pmos W=0.205u L=0.04u
M18257 U2239/net108 U2239/net104 VDD VDD pmos W=0.205u L=0.04u
M18258 n1689 U2239/net28 VDD VDD pmos W=0.205u L=0.04u
M18259 U2239/net32 WX8487 VDD VDD pmos W=0.205u L=0.04u
M18260 U2239/net64 U2239/net24 VDD VDD pmos W=0.28u L=0.04u
M18261 U2239/net24 U2239/net30 U2239/net045 VDD pmos W=0.205u L=0.04u
M18262 U2239/net045 U2239/net32 VDD VDD pmos W=0.205u L=0.04u
M18263 U2240/net4 WX8423 U2240/net14 VSS nmos W=0.155u L=0.04u
M18264 U2240/net6 U2240/net10 U2240/net14 VSS nmos W=0.17u L=0.04u
M18265 U2240/net4 n1369 VSS VSS nmos W=0.155u L=0.04u
M18266 U2240/net6 U2240/net4 VSS VSS nmos W=0.17u L=0.04u
M18267 n1690 U2240/net14 VSS VSS nmos W=0.155u L=0.04u
M18268 U2240/net10 WX8423 VSS VSS nmos W=0.155u L=0.04u
M18269 U2240/net4 U2240/net10 U2240/net14 VDD pmos W=0.255u L=0.04u
M18270 U2240/net6 WX8423 U2240/net14 VDD pmos W=0.28u L=0.04u
M18271 U2240/net4 n1369 VDD VDD pmos W=0.205u L=0.04u
M18272 U2240/net6 U2240/net4 VDD VDD pmos W=0.24u L=0.04u
M18273 n1690 U2240/net14 VDD VDD pmos W=0.205u L=0.04u
M18274 U2240/net10 WX8423 VDD VDD pmos W=0.205u L=0.04u
M18275 WX6629 n1277 U2241/net26 VSS nmos W=0.155u L=0.04u
M18276 WX6629 n1579 U2241/net26 VSS nmos W=0.155u L=0.04u
M18277 U2241/net29 n1692 VSS VSS nmos W=0.155u L=0.04u
M18278 U2241/net26 n1691 U2241/net29 VSS nmos W=0.155u L=0.04u
M18279 U2241/net26 n1248 U2241/net29 VSS nmos W=0.155u L=0.04u
M18280 WX6629 n1579 U2241/net43 VDD pmos W=0.205u L=0.04u
M18281 WX6629 n1248 U2241/net49 VDD pmos W=0.205u L=0.04u
M18282 U2241/net49 n1691 VDD VDD pmos W=0.205u L=0.04u
M18283 U2241/net43 n1277 VDD VDD pmos W=0.205u L=0.04u
M18284 WX6629 n1692 VDD VDD pmos W=0.205u L=0.04u
M18285 U2242/net29 n1337 VSS VSS nmos W=0.155u L=0.04u
M18286 n1692 WX6968 U2242/net29 VSS nmos W=0.155u L=0.04u
M18287 n1692 n1306 U2242/net23 VSS nmos W=0.155u L=0.04u
M18288 U2242/net23 CRC_OUT_4_22 VSS VSS nmos W=0.155u L=0.04u
M18289 U2242/net20 CRC_OUT_4_22 n1692 VDD pmos W=0.205u L=0.04u
M18290 U2242/net20 n1306 n1692 VDD pmos W=0.205u L=0.04u
M18291 VDD WX6968 U2242/net20 VDD pmos W=0.205u L=0.04u
M18292 VDD n1337 U2242/net20 VDD pmos W=0.205u L=0.04u
M18293 n1579 n1693 VSS VSS nmos W=0.135u L=0.04u
M18294 n1579 n1693 VDD VDD pmos W=0.205u L=0.04u
M18295 U2244/net28 U2244/net20 U2244/net64 VSS nmos W=0.155u L=0.04u
M18296 U2244/net24 U2244/net30 U2244/net32 VSS nmos W=0.155u L=0.04u
M18297 U2244/net28 U2244/net40 U2244/net24 VSS nmos W=0.155u L=0.04u
M18298 U2244/net40 n1694 U2244/net108 VSS nmos W=0.155u L=0.04u
M18299 U2244/net40 U2244/net106 U2244/net104 VSS nmos W=0.155u L=0.04u
M18300 U2244/net24 WX8549 U2244/net050 VSS nmos W=0.155u L=0.04u
M18301 U2244/net050 U2244/net32 VSS VSS nmos W=0.155u L=0.04u
M18302 U2244/net20 U2244/net40 VSS VSS nmos W=0.155u L=0.04u
M18303 U2244/net106 n1694 VSS VSS nmos W=0.155u L=0.04u
M18304 U2244/net104 WX8613 VSS VSS nmos W=0.155u L=0.04u
M18305 U2244/net30 WX8549 VSS VSS nmos W=0.155u L=0.04u
M18306 U2244/net108 U2244/net104 VSS VSS nmos W=0.155u L=0.04u
M18307 n1693 U2244/net28 VSS VSS nmos W=0.155u L=0.04u
M18308 U2244/net32 WX8485 VSS VSS nmos W=0.155u L=0.04u
M18309 U2244/net64 U2244/net24 VSS VSS nmos W=0.2u L=0.04u
M18310 U2244/net28 U2244/net40 U2244/net64 VDD pmos W=0.205u L=0.04u
M18311 U2244/net24 WX8549 U2244/net32 VDD pmos W=0.205u L=0.04u
M18312 U2244/net28 U2244/net20 U2244/net24 VDD pmos W=0.205u L=0.04u
M18313 U2244/net40 U2244/net106 U2244/net108 VDD pmos W=0.205u L=0.04u
M18314 U2244/net40 n1694 U2244/net104 VDD pmos W=0.205u L=0.04u
M18315 U2244/net20 U2244/net40 VDD VDD pmos W=0.205u L=0.04u
M18316 U2244/net106 n1694 VDD VDD pmos W=0.205u L=0.04u
M18317 U2244/net104 WX8613 VDD VDD pmos W=0.205u L=0.04u
M18318 U2244/net30 WX8549 VDD VDD pmos W=0.205u L=0.04u
M18319 U2244/net108 U2244/net104 VDD VDD pmos W=0.205u L=0.04u
M18320 n1693 U2244/net28 VDD VDD pmos W=0.205u L=0.04u
M18321 U2244/net32 WX8485 VDD VDD pmos W=0.205u L=0.04u
M18322 U2244/net64 U2244/net24 VDD VDD pmos W=0.28u L=0.04u
M18323 U2244/net24 U2244/net30 U2244/net045 VDD pmos W=0.205u L=0.04u
M18324 U2244/net045 U2244/net32 VDD VDD pmos W=0.205u L=0.04u
M18325 U2245/net4 WX8421 U2245/net14 VSS nmos W=0.155u L=0.04u
M18326 U2245/net6 U2245/net10 U2245/net14 VSS nmos W=0.17u L=0.04u
M18327 U2245/net4 n1369 VSS VSS nmos W=0.155u L=0.04u
M18328 U2245/net6 U2245/net4 VSS VSS nmos W=0.17u L=0.04u
M18329 n1694 U2245/net14 VSS VSS nmos W=0.155u L=0.04u
M18330 U2245/net10 WX8421 VSS VSS nmos W=0.155u L=0.04u
M18331 U2245/net4 U2245/net10 U2245/net14 VDD pmos W=0.255u L=0.04u
M18332 U2245/net6 WX8421 U2245/net14 VDD pmos W=0.28u L=0.04u
M18333 U2245/net4 n1369 VDD VDD pmos W=0.205u L=0.04u
M18334 U2245/net6 U2245/net4 VDD VDD pmos W=0.24u L=0.04u
M18335 n1694 U2245/net14 VDD VDD pmos W=0.205u L=0.04u
M18336 U2245/net10 WX8421 VDD VDD pmos W=0.205u L=0.04u
M18337 WX6615 n1276 U2246/net26 VSS nmos W=0.155u L=0.04u
M18338 WX6615 n1583 U2246/net26 VSS nmos W=0.155u L=0.04u
M18339 U2246/net29 n1696 VSS VSS nmos W=0.155u L=0.04u
M18340 U2246/net26 n1695 U2246/net29 VSS nmos W=0.155u L=0.04u
M18341 U2246/net26 n1248 U2246/net29 VSS nmos W=0.155u L=0.04u
M18342 WX6615 n1583 U2246/net43 VDD pmos W=0.205u L=0.04u
M18343 WX6615 n1248 U2246/net49 VDD pmos W=0.205u L=0.04u
M18344 U2246/net49 n1695 VDD VDD pmos W=0.205u L=0.04u
M18345 U2246/net43 n1276 VDD VDD pmos W=0.205u L=0.04u
M18346 WX6615 n1696 VDD VDD pmos W=0.205u L=0.04u
M18347 U2247/net29 n1336 VSS VSS nmos W=0.155u L=0.04u
M18348 n1696 WX6966 U2247/net29 VSS nmos W=0.155u L=0.04u
M18349 n1696 n1306 U2247/net23 VSS nmos W=0.155u L=0.04u
M18350 U2247/net23 CRC_OUT_4_23 VSS VSS nmos W=0.155u L=0.04u
M18351 U2247/net20 CRC_OUT_4_23 n1696 VDD pmos W=0.205u L=0.04u
M18352 U2247/net20 n1306 n1696 VDD pmos W=0.205u L=0.04u
M18353 VDD WX6966 U2247/net20 VDD pmos W=0.205u L=0.04u
M18354 VDD n1336 U2247/net20 VDD pmos W=0.205u L=0.04u
M18355 n1583 n1697 VSS VSS nmos W=0.135u L=0.04u
M18356 n1583 n1697 VDD VDD pmos W=0.205u L=0.04u
M18357 U2249/net28 U2249/net20 U2249/net64 VSS nmos W=0.155u L=0.04u
M18358 U2249/net24 U2249/net30 U2249/net32 VSS nmos W=0.155u L=0.04u
M18359 U2249/net28 U2249/net40 U2249/net24 VSS nmos W=0.155u L=0.04u
M18360 U2249/net40 n1698 U2249/net108 VSS nmos W=0.155u L=0.04u
M18361 U2249/net40 U2249/net106 U2249/net104 VSS nmos W=0.155u L=0.04u
M18362 U2249/net24 WX8547 U2249/net050 VSS nmos W=0.155u L=0.04u
M18363 U2249/net050 U2249/net32 VSS VSS nmos W=0.155u L=0.04u
M18364 U2249/net20 U2249/net40 VSS VSS nmos W=0.155u L=0.04u
M18365 U2249/net106 n1698 VSS VSS nmos W=0.155u L=0.04u
M18366 U2249/net104 WX8611 VSS VSS nmos W=0.155u L=0.04u
M18367 U2249/net30 WX8547 VSS VSS nmos W=0.155u L=0.04u
M18368 U2249/net108 U2249/net104 VSS VSS nmos W=0.155u L=0.04u
M18369 n1697 U2249/net28 VSS VSS nmos W=0.155u L=0.04u
M18370 U2249/net32 WX8483 VSS VSS nmos W=0.155u L=0.04u
M18371 U2249/net64 U2249/net24 VSS VSS nmos W=0.2u L=0.04u
M18372 U2249/net28 U2249/net40 U2249/net64 VDD pmos W=0.205u L=0.04u
M18373 U2249/net24 WX8547 U2249/net32 VDD pmos W=0.205u L=0.04u
M18374 U2249/net28 U2249/net20 U2249/net24 VDD pmos W=0.205u L=0.04u
M18375 U2249/net40 U2249/net106 U2249/net108 VDD pmos W=0.205u L=0.04u
M18376 U2249/net40 n1698 U2249/net104 VDD pmos W=0.205u L=0.04u
M18377 U2249/net20 U2249/net40 VDD VDD pmos W=0.205u L=0.04u
M18378 U2249/net106 n1698 VDD VDD pmos W=0.205u L=0.04u
M18379 U2249/net104 WX8611 VDD VDD pmos W=0.205u L=0.04u
M18380 U2249/net30 WX8547 VDD VDD pmos W=0.205u L=0.04u
M18381 U2249/net108 U2249/net104 VDD VDD pmos W=0.205u L=0.04u
M18382 n1697 U2249/net28 VDD VDD pmos W=0.205u L=0.04u
M18383 U2249/net32 WX8483 VDD VDD pmos W=0.205u L=0.04u
M18384 U2249/net64 U2249/net24 VDD VDD pmos W=0.28u L=0.04u
M18385 U2249/net24 U2249/net30 U2249/net045 VDD pmos W=0.205u L=0.04u
M18386 U2249/net045 U2249/net32 VDD VDD pmos W=0.205u L=0.04u
M18387 U2250/net4 WX8419 U2250/net14 VSS nmos W=0.155u L=0.04u
M18388 U2250/net6 U2250/net10 U2250/net14 VSS nmos W=0.17u L=0.04u
M18389 U2250/net4 n1369 VSS VSS nmos W=0.155u L=0.04u
M18390 U2250/net6 U2250/net4 VSS VSS nmos W=0.17u L=0.04u
M18391 n1698 U2250/net14 VSS VSS nmos W=0.155u L=0.04u
M18392 U2250/net10 WX8419 VSS VSS nmos W=0.155u L=0.04u
M18393 U2250/net4 U2250/net10 U2250/net14 VDD pmos W=0.255u L=0.04u
M18394 U2250/net6 WX8419 U2250/net14 VDD pmos W=0.28u L=0.04u
M18395 U2250/net4 n1369 VDD VDD pmos W=0.205u L=0.04u
M18396 U2250/net6 U2250/net4 VDD VDD pmos W=0.24u L=0.04u
M18397 n1698 U2250/net14 VDD VDD pmos W=0.205u L=0.04u
M18398 U2250/net10 WX8419 VDD VDD pmos W=0.205u L=0.04u
M18399 WX6601 n1276 U2251/net26 VSS nmos W=0.155u L=0.04u
M18400 WX6601 n1587 U2251/net26 VSS nmos W=0.155u L=0.04u
M18401 U2251/net29 n1700 VSS VSS nmos W=0.155u L=0.04u
M18402 U2251/net26 n1699 U2251/net29 VSS nmos W=0.155u L=0.04u
M18403 U2251/net26 n1248 U2251/net29 VSS nmos W=0.155u L=0.04u
M18404 WX6601 n1587 U2251/net43 VDD pmos W=0.205u L=0.04u
M18405 WX6601 n1248 U2251/net49 VDD pmos W=0.205u L=0.04u
M18406 U2251/net49 n1699 VDD VDD pmos W=0.205u L=0.04u
M18407 U2251/net43 n1276 VDD VDD pmos W=0.205u L=0.04u
M18408 WX6601 n1700 VDD VDD pmos W=0.205u L=0.04u
M18409 U2252/net29 n1336 VSS VSS nmos W=0.155u L=0.04u
M18410 n1700 WX6964 U2252/net29 VSS nmos W=0.155u L=0.04u
M18411 n1700 n1306 U2252/net23 VSS nmos W=0.155u L=0.04u
M18412 U2252/net23 CRC_OUT_4_24 VSS VSS nmos W=0.155u L=0.04u
M18413 U2252/net20 CRC_OUT_4_24 n1700 VDD pmos W=0.205u L=0.04u
M18414 U2252/net20 n1306 n1700 VDD pmos W=0.205u L=0.04u
M18415 VDD WX6964 U2252/net20 VDD pmos W=0.205u L=0.04u
M18416 VDD n1336 U2252/net20 VDD pmos W=0.205u L=0.04u
M18417 n1587 n1701 VSS VSS nmos W=0.135u L=0.04u
M18418 n1587 n1701 VDD VDD pmos W=0.205u L=0.04u
M18419 U2254/net28 U2254/net20 U2254/net64 VSS nmos W=0.155u L=0.04u
M18420 U2254/net24 U2254/net30 U2254/net32 VSS nmos W=0.155u L=0.04u
M18421 U2254/net28 U2254/net40 U2254/net24 VSS nmos W=0.155u L=0.04u
M18422 U2254/net40 n1702 U2254/net108 VSS nmos W=0.155u L=0.04u
M18423 U2254/net40 U2254/net106 U2254/net104 VSS nmos W=0.155u L=0.04u
M18424 U2254/net24 WX8545 U2254/net050 VSS nmos W=0.155u L=0.04u
M18425 U2254/net050 U2254/net32 VSS VSS nmos W=0.155u L=0.04u
M18426 U2254/net20 U2254/net40 VSS VSS nmos W=0.155u L=0.04u
M18427 U2254/net106 n1702 VSS VSS nmos W=0.155u L=0.04u
M18428 U2254/net104 WX8609 VSS VSS nmos W=0.155u L=0.04u
M18429 U2254/net30 WX8545 VSS VSS nmos W=0.155u L=0.04u
M18430 U2254/net108 U2254/net104 VSS VSS nmos W=0.155u L=0.04u
M18431 n1701 U2254/net28 VSS VSS nmos W=0.155u L=0.04u
M18432 U2254/net32 WX8481 VSS VSS nmos W=0.155u L=0.04u
M18433 U2254/net64 U2254/net24 VSS VSS nmos W=0.2u L=0.04u
M18434 U2254/net28 U2254/net40 U2254/net64 VDD pmos W=0.205u L=0.04u
M18435 U2254/net24 WX8545 U2254/net32 VDD pmos W=0.205u L=0.04u
M18436 U2254/net28 U2254/net20 U2254/net24 VDD pmos W=0.205u L=0.04u
M18437 U2254/net40 U2254/net106 U2254/net108 VDD pmos W=0.205u L=0.04u
M18438 U2254/net40 n1702 U2254/net104 VDD pmos W=0.205u L=0.04u
M18439 U2254/net20 U2254/net40 VDD VDD pmos W=0.205u L=0.04u
M18440 U2254/net106 n1702 VDD VDD pmos W=0.205u L=0.04u
M18441 U2254/net104 WX8609 VDD VDD pmos W=0.205u L=0.04u
M18442 U2254/net30 WX8545 VDD VDD pmos W=0.205u L=0.04u
M18443 U2254/net108 U2254/net104 VDD VDD pmos W=0.205u L=0.04u
M18444 n1701 U2254/net28 VDD VDD pmos W=0.205u L=0.04u
M18445 U2254/net32 WX8481 VDD VDD pmos W=0.205u L=0.04u
M18446 U2254/net64 U2254/net24 VDD VDD pmos W=0.28u L=0.04u
M18447 U2254/net24 U2254/net30 U2254/net045 VDD pmos W=0.205u L=0.04u
M18448 U2254/net045 U2254/net32 VDD VDD pmos W=0.205u L=0.04u
M18449 U2255/net4 WX8417 U2255/net14 VSS nmos W=0.155u L=0.04u
M18450 U2255/net6 U2255/net10 U2255/net14 VSS nmos W=0.17u L=0.04u
M18451 U2255/net4 n1370 VSS VSS nmos W=0.155u L=0.04u
M18452 U2255/net6 U2255/net4 VSS VSS nmos W=0.17u L=0.04u
M18453 n1702 U2255/net14 VSS VSS nmos W=0.155u L=0.04u
M18454 U2255/net10 WX8417 VSS VSS nmos W=0.155u L=0.04u
M18455 U2255/net4 U2255/net10 U2255/net14 VDD pmos W=0.255u L=0.04u
M18456 U2255/net6 WX8417 U2255/net14 VDD pmos W=0.28u L=0.04u
M18457 U2255/net4 n1370 VDD VDD pmos W=0.205u L=0.04u
M18458 U2255/net6 U2255/net4 VDD VDD pmos W=0.24u L=0.04u
M18459 n1702 U2255/net14 VDD VDD pmos W=0.205u L=0.04u
M18460 U2255/net10 WX8417 VDD VDD pmos W=0.205u L=0.04u
M18461 WX66 U2256/net31 VDD VDD pmos W=0.205u L=0.04u
M18462 U2256/net30 n1354 U2256/net31 VDD pmos W=0.205u L=0.04u
M18463 U2256/net30 WX489 U2256/net31 VDD pmos W=0.205u L=0.04u
M18464 VDD n1704 U2256/net36 VDD pmos W=0.205u L=0.04u
M18465 U2256/net36 n1430 U2256/net30 VDD pmos W=0.205u L=0.04u
M18466 U2256/net36 n1703 U2256/net30 VDD pmos W=0.205u L=0.04u
M18467 U2256/net31 n1704 VSS VSS nmos W=0.155u L=0.04u
M18468 WX66 U2256/net31 VSS VSS nmos W=0.155u L=0.04u
M18469 U2256/net31 n1703 U2256/XI17-net17 VSS nmos W=0.155u L=0.04u
M18470 U2256/XI17-net17 n1430 VSS VSS nmos W=0.155u L=0.04u
M18471 U2256/net31 n1354 U2256/XI1-net17 VSS nmos W=0.155u L=0.04u
M18472 U2256/XI1-net17 WX489 VSS VSS nmos W=0.155u L=0.04u
M18473 U2257/net8 n1303 U2257/net26 VSS nmos W=0.155u L=0.04u
M18474 U2257/net26 CRC_OUT_9_29 VSS VSS nmos W=0.155u L=0.04u
M18475 U2257/net29 U2257/net8 VSS VSS nmos W=0.155u L=0.04u
M18476 U2257/net29 n1292 n1704 VSS nmos W=0.155u L=0.04u
M18477 U2257/net29 n1705 n1704 VSS nmos W=0.155u L=0.04u
M18478 U2257/net8 CRC_OUT_9_29 VDD VDD pmos W=0.205u L=0.04u
M18479 U2257/net8 n1303 VDD VDD pmos W=0.205u L=0.04u
M18480 n1704 U2257/net8 VDD VDD pmos W=0.205u L=0.04u
M18481 n1704 n1292 U2257/net20 VDD pmos W=0.205u L=0.04u
M18482 U2257/net20 n1705 VDD VDD pmos W=0.205u L=0.04u
M18483 WX6587 n1276 U2258/net26 VSS nmos W=0.155u L=0.04u
M18484 WX6587 n1591 U2258/net26 VSS nmos W=0.155u L=0.04u
M18485 U2258/net29 n1707 VSS VSS nmos W=0.155u L=0.04u
M18486 U2258/net26 n1706 U2258/net29 VSS nmos W=0.155u L=0.04u
M18487 U2258/net26 n1248 U2258/net29 VSS nmos W=0.155u L=0.04u
M18488 WX6587 n1591 U2258/net43 VDD pmos W=0.205u L=0.04u
M18489 WX6587 n1248 U2258/net49 VDD pmos W=0.205u L=0.04u
M18490 U2258/net49 n1706 VDD VDD pmos W=0.205u L=0.04u
M18491 U2258/net43 n1276 VDD VDD pmos W=0.205u L=0.04u
M18492 WX6587 n1707 VDD VDD pmos W=0.205u L=0.04u
M18493 U2259/net29 n1336 VSS VSS nmos W=0.155u L=0.04u
M18494 n1707 WX6962 U2259/net29 VSS nmos W=0.155u L=0.04u
M18495 n1707 n1305 U2259/net23 VSS nmos W=0.155u L=0.04u
M18496 U2259/net23 CRC_OUT_4_25 VSS VSS nmos W=0.155u L=0.04u
M18497 U2259/net20 CRC_OUT_4_25 n1707 VDD pmos W=0.205u L=0.04u
M18498 U2259/net20 n1305 n1707 VDD pmos W=0.205u L=0.04u
M18499 VDD WX6962 U2259/net20 VDD pmos W=0.205u L=0.04u
M18500 VDD n1336 U2259/net20 VDD pmos W=0.205u L=0.04u
M18501 n1591 n1708 VSS VSS nmos W=0.135u L=0.04u
M18502 n1591 n1708 VDD VDD pmos W=0.205u L=0.04u
M18503 U2261/net28 U2261/net20 U2261/net64 VSS nmos W=0.155u L=0.04u
M18504 U2261/net24 U2261/net30 U2261/net32 VSS nmos W=0.155u L=0.04u
M18505 U2261/net28 U2261/net40 U2261/net24 VSS nmos W=0.155u L=0.04u
M18506 U2261/net40 n1709 U2261/net108 VSS nmos W=0.155u L=0.04u
M18507 U2261/net40 U2261/net106 U2261/net104 VSS nmos W=0.155u L=0.04u
M18508 U2261/net24 WX8543 U2261/net050 VSS nmos W=0.155u L=0.04u
M18509 U2261/net050 U2261/net32 VSS VSS nmos W=0.155u L=0.04u
M18510 U2261/net20 U2261/net40 VSS VSS nmos W=0.155u L=0.04u
M18511 U2261/net106 n1709 VSS VSS nmos W=0.155u L=0.04u
M18512 U2261/net104 WX8607 VSS VSS nmos W=0.155u L=0.04u
M18513 U2261/net30 WX8543 VSS VSS nmos W=0.155u L=0.04u
M18514 U2261/net108 U2261/net104 VSS VSS nmos W=0.155u L=0.04u
M18515 n1708 U2261/net28 VSS VSS nmos W=0.155u L=0.04u
M18516 U2261/net32 WX8479 VSS VSS nmos W=0.155u L=0.04u
M18517 U2261/net64 U2261/net24 VSS VSS nmos W=0.2u L=0.04u
M18518 U2261/net28 U2261/net40 U2261/net64 VDD pmos W=0.205u L=0.04u
M18519 U2261/net24 WX8543 U2261/net32 VDD pmos W=0.205u L=0.04u
M18520 U2261/net28 U2261/net20 U2261/net24 VDD pmos W=0.205u L=0.04u
M18521 U2261/net40 U2261/net106 U2261/net108 VDD pmos W=0.205u L=0.04u
M18522 U2261/net40 n1709 U2261/net104 VDD pmos W=0.205u L=0.04u
M18523 U2261/net20 U2261/net40 VDD VDD pmos W=0.205u L=0.04u
M18524 U2261/net106 n1709 VDD VDD pmos W=0.205u L=0.04u
M18525 U2261/net104 WX8607 VDD VDD pmos W=0.205u L=0.04u
M18526 U2261/net30 WX8543 VDD VDD pmos W=0.205u L=0.04u
M18527 U2261/net108 U2261/net104 VDD VDD pmos W=0.205u L=0.04u
M18528 n1708 U2261/net28 VDD VDD pmos W=0.205u L=0.04u
M18529 U2261/net32 WX8479 VDD VDD pmos W=0.205u L=0.04u
M18530 U2261/net64 U2261/net24 VDD VDD pmos W=0.28u L=0.04u
M18531 U2261/net24 U2261/net30 U2261/net045 VDD pmos W=0.205u L=0.04u
M18532 U2261/net045 U2261/net32 VDD VDD pmos W=0.205u L=0.04u
M18533 U2262/net4 WX8415 U2262/net14 VSS nmos W=0.155u L=0.04u
M18534 U2262/net6 U2262/net10 U2262/net14 VSS nmos W=0.17u L=0.04u
M18535 U2262/net4 n1370 VSS VSS nmos W=0.155u L=0.04u
M18536 U2262/net6 U2262/net4 VSS VSS nmos W=0.17u L=0.04u
M18537 n1709 U2262/net14 VSS VSS nmos W=0.155u L=0.04u
M18538 U2262/net10 WX8415 VSS VSS nmos W=0.155u L=0.04u
M18539 U2262/net4 U2262/net10 U2262/net14 VDD pmos W=0.255u L=0.04u
M18540 U2262/net6 WX8415 U2262/net14 VDD pmos W=0.28u L=0.04u
M18541 U2262/net4 n1370 VDD VDD pmos W=0.205u L=0.04u
M18542 U2262/net6 U2262/net4 VDD VDD pmos W=0.24u L=0.04u
M18543 n1709 U2262/net14 VDD VDD pmos W=0.205u L=0.04u
M18544 U2262/net10 WX8415 VDD VDD pmos W=0.205u L=0.04u
M18545 WX6573 n1276 U2263/net26 VSS nmos W=0.155u L=0.04u
M18546 WX6573 n1595 U2263/net26 VSS nmos W=0.155u L=0.04u
M18547 U2263/net29 n1711 VSS VSS nmos W=0.155u L=0.04u
M18548 U2263/net26 n1710 U2263/net29 VSS nmos W=0.155u L=0.04u
M18549 U2263/net26 n1248 U2263/net29 VSS nmos W=0.155u L=0.04u
M18550 WX6573 n1595 U2263/net43 VDD pmos W=0.205u L=0.04u
M18551 WX6573 n1248 U2263/net49 VDD pmos W=0.205u L=0.04u
M18552 U2263/net49 n1710 VDD VDD pmos W=0.205u L=0.04u
M18553 U2263/net43 n1276 VDD VDD pmos W=0.205u L=0.04u
M18554 WX6573 n1711 VDD VDD pmos W=0.205u L=0.04u
M18555 U2264/net29 n1336 VSS VSS nmos W=0.155u L=0.04u
M18556 n1711 WX6960 U2264/net29 VSS nmos W=0.155u L=0.04u
M18557 n1711 n1305 U2264/net23 VSS nmos W=0.155u L=0.04u
M18558 U2264/net23 CRC_OUT_4_26 VSS VSS nmos W=0.155u L=0.04u
M18559 U2264/net20 CRC_OUT_4_26 n1711 VDD pmos W=0.205u L=0.04u
M18560 U2264/net20 n1305 n1711 VDD pmos W=0.205u L=0.04u
M18561 VDD WX6960 U2264/net20 VDD pmos W=0.205u L=0.04u
M18562 VDD n1336 U2264/net20 VDD pmos W=0.205u L=0.04u
M18563 n1595 n1712 VSS VSS nmos W=0.135u L=0.04u
M18564 n1595 n1712 VDD VDD pmos W=0.205u L=0.04u
M18565 U2266/net28 U2266/net20 U2266/net64 VSS nmos W=0.155u L=0.04u
M18566 U2266/net24 U2266/net30 U2266/net32 VSS nmos W=0.155u L=0.04u
M18567 U2266/net28 U2266/net40 U2266/net24 VSS nmos W=0.155u L=0.04u
M18568 U2266/net40 n1713 U2266/net108 VSS nmos W=0.155u L=0.04u
M18569 U2266/net40 U2266/net106 U2266/net104 VSS nmos W=0.155u L=0.04u
M18570 U2266/net24 WX8541 U2266/net050 VSS nmos W=0.155u L=0.04u
M18571 U2266/net050 U2266/net32 VSS VSS nmos W=0.155u L=0.04u
M18572 U2266/net20 U2266/net40 VSS VSS nmos W=0.155u L=0.04u
M18573 U2266/net106 n1713 VSS VSS nmos W=0.155u L=0.04u
M18574 U2266/net104 WX8605 VSS VSS nmos W=0.155u L=0.04u
M18575 U2266/net30 WX8541 VSS VSS nmos W=0.155u L=0.04u
M18576 U2266/net108 U2266/net104 VSS VSS nmos W=0.155u L=0.04u
M18577 n1712 U2266/net28 VSS VSS nmos W=0.155u L=0.04u
M18578 U2266/net32 WX8477 VSS VSS nmos W=0.155u L=0.04u
M18579 U2266/net64 U2266/net24 VSS VSS nmos W=0.2u L=0.04u
M18580 U2266/net28 U2266/net40 U2266/net64 VDD pmos W=0.205u L=0.04u
M18581 U2266/net24 WX8541 U2266/net32 VDD pmos W=0.205u L=0.04u
M18582 U2266/net28 U2266/net20 U2266/net24 VDD pmos W=0.205u L=0.04u
M18583 U2266/net40 U2266/net106 U2266/net108 VDD pmos W=0.205u L=0.04u
M18584 U2266/net40 n1713 U2266/net104 VDD pmos W=0.205u L=0.04u
M18585 U2266/net20 U2266/net40 VDD VDD pmos W=0.205u L=0.04u
M18586 U2266/net106 n1713 VDD VDD pmos W=0.205u L=0.04u
M18587 U2266/net104 WX8605 VDD VDD pmos W=0.205u L=0.04u
M18588 U2266/net30 WX8541 VDD VDD pmos W=0.205u L=0.04u
M18589 U2266/net108 U2266/net104 VDD VDD pmos W=0.205u L=0.04u
M18590 n1712 U2266/net28 VDD VDD pmos W=0.205u L=0.04u
M18591 U2266/net32 WX8477 VDD VDD pmos W=0.205u L=0.04u
M18592 U2266/net64 U2266/net24 VDD VDD pmos W=0.28u L=0.04u
M18593 U2266/net24 U2266/net30 U2266/net045 VDD pmos W=0.205u L=0.04u
M18594 U2266/net045 U2266/net32 VDD VDD pmos W=0.205u L=0.04u
M18595 U2267/net4 WX8413 U2267/net14 VSS nmos W=0.155u L=0.04u
M18596 U2267/net6 U2267/net10 U2267/net14 VSS nmos W=0.17u L=0.04u
M18597 U2267/net4 n1370 VSS VSS nmos W=0.155u L=0.04u
M18598 U2267/net6 U2267/net4 VSS VSS nmos W=0.17u L=0.04u
M18599 n1713 U2267/net14 VSS VSS nmos W=0.155u L=0.04u
M18600 U2267/net10 WX8413 VSS VSS nmos W=0.155u L=0.04u
M18601 U2267/net4 U2267/net10 U2267/net14 VDD pmos W=0.255u L=0.04u
M18602 U2267/net6 WX8413 U2267/net14 VDD pmos W=0.28u L=0.04u
M18603 U2267/net4 n1370 VDD VDD pmos W=0.205u L=0.04u
M18604 U2267/net6 U2267/net4 VDD VDD pmos W=0.24u L=0.04u
M18605 n1713 U2267/net14 VDD VDD pmos W=0.205u L=0.04u
M18606 U2267/net10 WX8413 VDD VDD pmos W=0.205u L=0.04u
M18607 WX6559 n1276 U2268/net26 VSS nmos W=0.155u L=0.04u
M18608 WX6559 n1599 U2268/net26 VSS nmos W=0.155u L=0.04u
M18609 U2268/net29 n1715 VSS VSS nmos W=0.155u L=0.04u
M18610 U2268/net26 n1714 U2268/net29 VSS nmos W=0.155u L=0.04u
M18611 U2268/net26 n1248 U2268/net29 VSS nmos W=0.155u L=0.04u
M18612 WX6559 n1599 U2268/net43 VDD pmos W=0.205u L=0.04u
M18613 WX6559 n1248 U2268/net49 VDD pmos W=0.205u L=0.04u
M18614 U2268/net49 n1714 VDD VDD pmos W=0.205u L=0.04u
M18615 U2268/net43 n1276 VDD VDD pmos W=0.205u L=0.04u
M18616 WX6559 n1715 VDD VDD pmos W=0.205u L=0.04u
M18617 U2269/net29 n1336 VSS VSS nmos W=0.155u L=0.04u
M18618 n1715 WX6958 U2269/net29 VSS nmos W=0.155u L=0.04u
M18619 n1715 n1305 U2269/net23 VSS nmos W=0.155u L=0.04u
M18620 U2269/net23 CRC_OUT_4_27 VSS VSS nmos W=0.155u L=0.04u
M18621 U2269/net20 CRC_OUT_4_27 n1715 VDD pmos W=0.205u L=0.04u
M18622 U2269/net20 n1305 n1715 VDD pmos W=0.205u L=0.04u
M18623 VDD WX6958 U2269/net20 VDD pmos W=0.205u L=0.04u
M18624 VDD n1336 U2269/net20 VDD pmos W=0.205u L=0.04u
M18625 n1599 n1716 VSS VSS nmos W=0.135u L=0.04u
M18626 n1599 n1716 VDD VDD pmos W=0.205u L=0.04u
M18627 U2271/net28 U2271/net20 U2271/net64 VSS nmos W=0.155u L=0.04u
M18628 U2271/net24 U2271/net30 U2271/net32 VSS nmos W=0.155u L=0.04u
M18629 U2271/net28 U2271/net40 U2271/net24 VSS nmos W=0.155u L=0.04u
M18630 U2271/net40 n1717 U2271/net108 VSS nmos W=0.155u L=0.04u
M18631 U2271/net40 U2271/net106 U2271/net104 VSS nmos W=0.155u L=0.04u
M18632 U2271/net24 WX8539 U2271/net050 VSS nmos W=0.155u L=0.04u
M18633 U2271/net050 U2271/net32 VSS VSS nmos W=0.155u L=0.04u
M18634 U2271/net20 U2271/net40 VSS VSS nmos W=0.155u L=0.04u
M18635 U2271/net106 n1717 VSS VSS nmos W=0.155u L=0.04u
M18636 U2271/net104 WX8603 VSS VSS nmos W=0.155u L=0.04u
M18637 U2271/net30 WX8539 VSS VSS nmos W=0.155u L=0.04u
M18638 U2271/net108 U2271/net104 VSS VSS nmos W=0.155u L=0.04u
M18639 n1716 U2271/net28 VSS VSS nmos W=0.155u L=0.04u
M18640 U2271/net32 WX8475 VSS VSS nmos W=0.155u L=0.04u
M18641 U2271/net64 U2271/net24 VSS VSS nmos W=0.2u L=0.04u
M18642 U2271/net28 U2271/net40 U2271/net64 VDD pmos W=0.205u L=0.04u
M18643 U2271/net24 WX8539 U2271/net32 VDD pmos W=0.205u L=0.04u
M18644 U2271/net28 U2271/net20 U2271/net24 VDD pmos W=0.205u L=0.04u
M18645 U2271/net40 U2271/net106 U2271/net108 VDD pmos W=0.205u L=0.04u
M18646 U2271/net40 n1717 U2271/net104 VDD pmos W=0.205u L=0.04u
M18647 U2271/net20 U2271/net40 VDD VDD pmos W=0.205u L=0.04u
M18648 U2271/net106 n1717 VDD VDD pmos W=0.205u L=0.04u
M18649 U2271/net104 WX8603 VDD VDD pmos W=0.205u L=0.04u
M18650 U2271/net30 WX8539 VDD VDD pmos W=0.205u L=0.04u
M18651 U2271/net108 U2271/net104 VDD VDD pmos W=0.205u L=0.04u
M18652 n1716 U2271/net28 VDD VDD pmos W=0.205u L=0.04u
M18653 U2271/net32 WX8475 VDD VDD pmos W=0.205u L=0.04u
M18654 U2271/net64 U2271/net24 VDD VDD pmos W=0.28u L=0.04u
M18655 U2271/net24 U2271/net30 U2271/net045 VDD pmos W=0.205u L=0.04u
M18656 U2271/net045 U2271/net32 VDD VDD pmos W=0.205u L=0.04u
M18657 U2272/net4 WX8411 U2272/net14 VSS nmos W=0.155u L=0.04u
M18658 U2272/net6 U2272/net10 U2272/net14 VSS nmos W=0.17u L=0.04u
M18659 U2272/net4 n1370 VSS VSS nmos W=0.155u L=0.04u
M18660 U2272/net6 U2272/net4 VSS VSS nmos W=0.17u L=0.04u
M18661 n1717 U2272/net14 VSS VSS nmos W=0.155u L=0.04u
M18662 U2272/net10 WX8411 VSS VSS nmos W=0.155u L=0.04u
M18663 U2272/net4 U2272/net10 U2272/net14 VDD pmos W=0.255u L=0.04u
M18664 U2272/net6 WX8411 U2272/net14 VDD pmos W=0.28u L=0.04u
M18665 U2272/net4 n1370 VDD VDD pmos W=0.205u L=0.04u
M18666 U2272/net6 U2272/net4 VDD VDD pmos W=0.24u L=0.04u
M18667 n1717 U2272/net14 VDD VDD pmos W=0.205u L=0.04u
M18668 U2272/net10 WX8411 VDD VDD pmos W=0.205u L=0.04u
M18669 WX6545 n1276 U2273/net26 VSS nmos W=0.155u L=0.04u
M18670 WX6545 n1603 U2273/net26 VSS nmos W=0.155u L=0.04u
M18671 U2273/net29 n1719 VSS VSS nmos W=0.155u L=0.04u
M18672 U2273/net26 n1718 U2273/net29 VSS nmos W=0.155u L=0.04u
M18673 U2273/net26 n1248 U2273/net29 VSS nmos W=0.155u L=0.04u
M18674 WX6545 n1603 U2273/net43 VDD pmos W=0.205u L=0.04u
M18675 WX6545 n1248 U2273/net49 VDD pmos W=0.205u L=0.04u
M18676 U2273/net49 n1718 VDD VDD pmos W=0.205u L=0.04u
M18677 U2273/net43 n1276 VDD VDD pmos W=0.205u L=0.04u
M18678 WX6545 n1719 VDD VDD pmos W=0.205u L=0.04u
M18679 U2274/net29 n1336 VSS VSS nmos W=0.155u L=0.04u
M18680 n1719 WX6956 U2274/net29 VSS nmos W=0.155u L=0.04u
M18681 n1719 n1305 U2274/net23 VSS nmos W=0.155u L=0.04u
M18682 U2274/net23 CRC_OUT_4_28 VSS VSS nmos W=0.155u L=0.04u
M18683 U2274/net20 CRC_OUT_4_28 n1719 VDD pmos W=0.205u L=0.04u
M18684 U2274/net20 n1305 n1719 VDD pmos W=0.205u L=0.04u
M18685 VDD WX6956 U2274/net20 VDD pmos W=0.205u L=0.04u
M18686 VDD n1336 U2274/net20 VDD pmos W=0.205u L=0.04u
M18687 n1603 n1720 VSS VSS nmos W=0.135u L=0.04u
M18688 n1603 n1720 VDD VDD pmos W=0.205u L=0.04u
M18689 U2276/net28 U2276/net20 U2276/net64 VSS nmos W=0.155u L=0.04u
M18690 U2276/net24 U2276/net30 U2276/net32 VSS nmos W=0.155u L=0.04u
M18691 U2276/net28 U2276/net40 U2276/net24 VSS nmos W=0.155u L=0.04u
M18692 U2276/net40 n1721 U2276/net108 VSS nmos W=0.155u L=0.04u
M18693 U2276/net40 U2276/net106 U2276/net104 VSS nmos W=0.155u L=0.04u
M18694 U2276/net24 WX8537 U2276/net050 VSS nmos W=0.155u L=0.04u
M18695 U2276/net050 U2276/net32 VSS VSS nmos W=0.155u L=0.04u
M18696 U2276/net20 U2276/net40 VSS VSS nmos W=0.155u L=0.04u
M18697 U2276/net106 n1721 VSS VSS nmos W=0.155u L=0.04u
M18698 U2276/net104 WX8601 VSS VSS nmos W=0.155u L=0.04u
M18699 U2276/net30 WX8537 VSS VSS nmos W=0.155u L=0.04u
M18700 U2276/net108 U2276/net104 VSS VSS nmos W=0.155u L=0.04u
M18701 n1720 U2276/net28 VSS VSS nmos W=0.155u L=0.04u
M18702 U2276/net32 WX8473 VSS VSS nmos W=0.155u L=0.04u
M18703 U2276/net64 U2276/net24 VSS VSS nmos W=0.2u L=0.04u
M18704 U2276/net28 U2276/net40 U2276/net64 VDD pmos W=0.205u L=0.04u
M18705 U2276/net24 WX8537 U2276/net32 VDD pmos W=0.205u L=0.04u
M18706 U2276/net28 U2276/net20 U2276/net24 VDD pmos W=0.205u L=0.04u
M18707 U2276/net40 U2276/net106 U2276/net108 VDD pmos W=0.205u L=0.04u
M18708 U2276/net40 n1721 U2276/net104 VDD pmos W=0.205u L=0.04u
M18709 U2276/net20 U2276/net40 VDD VDD pmos W=0.205u L=0.04u
M18710 U2276/net106 n1721 VDD VDD pmos W=0.205u L=0.04u
M18711 U2276/net104 WX8601 VDD VDD pmos W=0.205u L=0.04u
M18712 U2276/net30 WX8537 VDD VDD pmos W=0.205u L=0.04u
M18713 U2276/net108 U2276/net104 VDD VDD pmos W=0.205u L=0.04u
M18714 n1720 U2276/net28 VDD VDD pmos W=0.205u L=0.04u
M18715 U2276/net32 WX8473 VDD VDD pmos W=0.205u L=0.04u
M18716 U2276/net64 U2276/net24 VDD VDD pmos W=0.28u L=0.04u
M18717 U2276/net24 U2276/net30 U2276/net045 VDD pmos W=0.205u L=0.04u
M18718 U2276/net045 U2276/net32 VDD VDD pmos W=0.205u L=0.04u
M18719 U2277/net4 WX8409 U2277/net14 VSS nmos W=0.155u L=0.04u
M18720 U2277/net6 U2277/net10 U2277/net14 VSS nmos W=0.17u L=0.04u
M18721 U2277/net4 n1370 VSS VSS nmos W=0.155u L=0.04u
M18722 U2277/net6 U2277/net4 VSS VSS nmos W=0.17u L=0.04u
M18723 n1721 U2277/net14 VSS VSS nmos W=0.155u L=0.04u
M18724 U2277/net10 WX8409 VSS VSS nmos W=0.155u L=0.04u
M18725 U2277/net4 U2277/net10 U2277/net14 VDD pmos W=0.255u L=0.04u
M18726 U2277/net6 WX8409 U2277/net14 VDD pmos W=0.28u L=0.04u
M18727 U2277/net4 n1370 VDD VDD pmos W=0.205u L=0.04u
M18728 U2277/net6 U2277/net4 VDD VDD pmos W=0.24u L=0.04u
M18729 n1721 U2277/net14 VDD VDD pmos W=0.205u L=0.04u
M18730 U2277/net10 WX8409 VDD VDD pmos W=0.205u L=0.04u
M18731 WX6531 n1276 U2278/net26 VSS nmos W=0.155u L=0.04u
M18732 WX6531 n1607 U2278/net26 VSS nmos W=0.155u L=0.04u
M18733 U2278/net29 n1723 VSS VSS nmos W=0.155u L=0.04u
M18734 U2278/net26 n1722 U2278/net29 VSS nmos W=0.155u L=0.04u
M18735 U2278/net26 n1248 U2278/net29 VSS nmos W=0.155u L=0.04u
M18736 WX6531 n1607 U2278/net43 VDD pmos W=0.205u L=0.04u
M18737 WX6531 n1248 U2278/net49 VDD pmos W=0.205u L=0.04u
M18738 U2278/net49 n1722 VDD VDD pmos W=0.205u L=0.04u
M18739 U2278/net43 n1276 VDD VDD pmos W=0.205u L=0.04u
M18740 WX6531 n1723 VDD VDD pmos W=0.205u L=0.04u
M18741 U2279/net29 n1336 VSS VSS nmos W=0.155u L=0.04u
M18742 n1723 WX6954 U2279/net29 VSS nmos W=0.155u L=0.04u
M18743 n1723 n1305 U2279/net23 VSS nmos W=0.155u L=0.04u
M18744 U2279/net23 CRC_OUT_4_29 VSS VSS nmos W=0.155u L=0.04u
M18745 U2279/net20 CRC_OUT_4_29 n1723 VDD pmos W=0.205u L=0.04u
M18746 U2279/net20 n1305 n1723 VDD pmos W=0.205u L=0.04u
M18747 VDD WX6954 U2279/net20 VDD pmos W=0.205u L=0.04u
M18748 VDD n1336 U2279/net20 VDD pmos W=0.205u L=0.04u
M18749 n1607 n1724 VSS VSS nmos W=0.135u L=0.04u
M18750 n1607 n1724 VDD VDD pmos W=0.205u L=0.04u
M18751 U2281/net28 U2281/net20 U2281/net64 VSS nmos W=0.155u L=0.04u
M18752 U2281/net24 U2281/net30 U2281/net32 VSS nmos W=0.155u L=0.04u
M18753 U2281/net28 U2281/net40 U2281/net24 VSS nmos W=0.155u L=0.04u
M18754 U2281/net40 n1725 U2281/net108 VSS nmos W=0.155u L=0.04u
M18755 U2281/net40 U2281/net106 U2281/net104 VSS nmos W=0.155u L=0.04u
M18756 U2281/net24 WX8535 U2281/net050 VSS nmos W=0.155u L=0.04u
M18757 U2281/net050 U2281/net32 VSS VSS nmos W=0.155u L=0.04u
M18758 U2281/net20 U2281/net40 VSS VSS nmos W=0.155u L=0.04u
M18759 U2281/net106 n1725 VSS VSS nmos W=0.155u L=0.04u
M18760 U2281/net104 WX8599 VSS VSS nmos W=0.155u L=0.04u
M18761 U2281/net30 WX8535 VSS VSS nmos W=0.155u L=0.04u
M18762 U2281/net108 U2281/net104 VSS VSS nmos W=0.155u L=0.04u
M18763 n1724 U2281/net28 VSS VSS nmos W=0.155u L=0.04u
M18764 U2281/net32 WX8471 VSS VSS nmos W=0.155u L=0.04u
M18765 U2281/net64 U2281/net24 VSS VSS nmos W=0.2u L=0.04u
M18766 U2281/net28 U2281/net40 U2281/net64 VDD pmos W=0.205u L=0.04u
M18767 U2281/net24 WX8535 U2281/net32 VDD pmos W=0.205u L=0.04u
M18768 U2281/net28 U2281/net20 U2281/net24 VDD pmos W=0.205u L=0.04u
M18769 U2281/net40 U2281/net106 U2281/net108 VDD pmos W=0.205u L=0.04u
M18770 U2281/net40 n1725 U2281/net104 VDD pmos W=0.205u L=0.04u
M18771 U2281/net20 U2281/net40 VDD VDD pmos W=0.205u L=0.04u
M18772 U2281/net106 n1725 VDD VDD pmos W=0.205u L=0.04u
M18773 U2281/net104 WX8599 VDD VDD pmos W=0.205u L=0.04u
M18774 U2281/net30 WX8535 VDD VDD pmos W=0.205u L=0.04u
M18775 U2281/net108 U2281/net104 VDD VDD pmos W=0.205u L=0.04u
M18776 n1724 U2281/net28 VDD VDD pmos W=0.205u L=0.04u
M18777 U2281/net32 WX8471 VDD VDD pmos W=0.205u L=0.04u
M18778 U2281/net64 U2281/net24 VDD VDD pmos W=0.28u L=0.04u
M18779 U2281/net24 U2281/net30 U2281/net045 VDD pmos W=0.205u L=0.04u
M18780 U2281/net045 U2281/net32 VDD VDD pmos W=0.205u L=0.04u
M18781 U2282/net4 WX8407 U2282/net14 VSS nmos W=0.155u L=0.04u
M18782 U2282/net6 U2282/net10 U2282/net14 VSS nmos W=0.17u L=0.04u
M18783 U2282/net4 n1370 VSS VSS nmos W=0.155u L=0.04u
M18784 U2282/net6 U2282/net4 VSS VSS nmos W=0.17u L=0.04u
M18785 n1725 U2282/net14 VSS VSS nmos W=0.155u L=0.04u
M18786 U2282/net10 WX8407 VSS VSS nmos W=0.155u L=0.04u
M18787 U2282/net4 U2282/net10 U2282/net14 VDD pmos W=0.255u L=0.04u
M18788 U2282/net6 WX8407 U2282/net14 VDD pmos W=0.28u L=0.04u
M18789 U2282/net4 n1370 VDD VDD pmos W=0.205u L=0.04u
M18790 U2282/net6 U2282/net4 VDD VDD pmos W=0.24u L=0.04u
M18791 n1725 U2282/net14 VDD VDD pmos W=0.205u L=0.04u
M18792 U2282/net10 WX8407 VDD VDD pmos W=0.205u L=0.04u
M18793 WX6517 n1276 U2283/net26 VSS nmos W=0.155u L=0.04u
M18794 WX6517 n1611 U2283/net26 VSS nmos W=0.155u L=0.04u
M18795 U2283/net29 n1727 VSS VSS nmos W=0.155u L=0.04u
M18796 U2283/net26 n1726 U2283/net29 VSS nmos W=0.155u L=0.04u
M18797 U2283/net26 n1248 U2283/net29 VSS nmos W=0.155u L=0.04u
M18798 WX6517 n1611 U2283/net43 VDD pmos W=0.205u L=0.04u
M18799 WX6517 n1248 U2283/net49 VDD pmos W=0.205u L=0.04u
M18800 U2283/net49 n1726 VDD VDD pmos W=0.205u L=0.04u
M18801 U2283/net43 n1276 VDD VDD pmos W=0.205u L=0.04u
M18802 WX6517 n1727 VDD VDD pmos W=0.205u L=0.04u
M18803 U2284/net29 n1336 VSS VSS nmos W=0.155u L=0.04u
M18804 n1727 WX6952 U2284/net29 VSS nmos W=0.155u L=0.04u
M18805 n1727 n1305 U2284/net23 VSS nmos W=0.155u L=0.04u
M18806 U2284/net23 CRC_OUT_4_30 VSS VSS nmos W=0.155u L=0.04u
M18807 U2284/net20 CRC_OUT_4_30 n1727 VDD pmos W=0.205u L=0.04u
M18808 U2284/net20 n1305 n1727 VDD pmos W=0.205u L=0.04u
M18809 VDD WX6952 U2284/net20 VDD pmos W=0.205u L=0.04u
M18810 VDD n1336 U2284/net20 VDD pmos W=0.205u L=0.04u
M18811 n1611 n1728 VSS VSS nmos W=0.135u L=0.04u
M18812 n1611 n1728 VDD VDD pmos W=0.205u L=0.04u
M18813 U2286/net28 U2286/net20 U2286/net64 VSS nmos W=0.155u L=0.04u
M18814 U2286/net24 U2286/net30 U2286/net32 VSS nmos W=0.155u L=0.04u
M18815 U2286/net28 U2286/net40 U2286/net24 VSS nmos W=0.155u L=0.04u
M18816 U2286/net40 n1729 U2286/net108 VSS nmos W=0.155u L=0.04u
M18817 U2286/net40 U2286/net106 U2286/net104 VSS nmos W=0.155u L=0.04u
M18818 U2286/net24 WX8533 U2286/net050 VSS nmos W=0.155u L=0.04u
M18819 U2286/net050 U2286/net32 VSS VSS nmos W=0.155u L=0.04u
M18820 U2286/net20 U2286/net40 VSS VSS nmos W=0.155u L=0.04u
M18821 U2286/net106 n1729 VSS VSS nmos W=0.155u L=0.04u
M18822 U2286/net104 WX8597 VSS VSS nmos W=0.155u L=0.04u
M18823 U2286/net30 WX8533 VSS VSS nmos W=0.155u L=0.04u
M18824 U2286/net108 U2286/net104 VSS VSS nmos W=0.155u L=0.04u
M18825 n1728 U2286/net28 VSS VSS nmos W=0.155u L=0.04u
M18826 U2286/net32 WX8469 VSS VSS nmos W=0.155u L=0.04u
M18827 U2286/net64 U2286/net24 VSS VSS nmos W=0.2u L=0.04u
M18828 U2286/net28 U2286/net40 U2286/net64 VDD pmos W=0.205u L=0.04u
M18829 U2286/net24 WX8533 U2286/net32 VDD pmos W=0.205u L=0.04u
M18830 U2286/net28 U2286/net20 U2286/net24 VDD pmos W=0.205u L=0.04u
M18831 U2286/net40 U2286/net106 U2286/net108 VDD pmos W=0.205u L=0.04u
M18832 U2286/net40 n1729 U2286/net104 VDD pmos W=0.205u L=0.04u
M18833 U2286/net20 U2286/net40 VDD VDD pmos W=0.205u L=0.04u
M18834 U2286/net106 n1729 VDD VDD pmos W=0.205u L=0.04u
M18835 U2286/net104 WX8597 VDD VDD pmos W=0.205u L=0.04u
M18836 U2286/net30 WX8533 VDD VDD pmos W=0.205u L=0.04u
M18837 U2286/net108 U2286/net104 VDD VDD pmos W=0.205u L=0.04u
M18838 n1728 U2286/net28 VDD VDD pmos W=0.205u L=0.04u
M18839 U2286/net32 WX8469 VDD VDD pmos W=0.205u L=0.04u
M18840 U2286/net64 U2286/net24 VDD VDD pmos W=0.28u L=0.04u
M18841 U2286/net24 U2286/net30 U2286/net045 VDD pmos W=0.205u L=0.04u
M18842 U2286/net045 U2286/net32 VDD VDD pmos W=0.205u L=0.04u
M18843 U2287/net4 WX8405 U2287/net14 VSS nmos W=0.155u L=0.04u
M18844 U2287/net6 U2287/net10 U2287/net14 VSS nmos W=0.17u L=0.04u
M18845 U2287/net4 n1370 VSS VSS nmos W=0.155u L=0.04u
M18846 U2287/net6 U2287/net4 VSS VSS nmos W=0.17u L=0.04u
M18847 n1729 U2287/net14 VSS VSS nmos W=0.155u L=0.04u
M18848 U2287/net10 WX8405 VSS VSS nmos W=0.155u L=0.04u
M18849 U2287/net4 U2287/net10 U2287/net14 VDD pmos W=0.255u L=0.04u
M18850 U2287/net6 WX8405 U2287/net14 VDD pmos W=0.28u L=0.04u
M18851 U2287/net4 n1370 VDD VDD pmos W=0.205u L=0.04u
M18852 U2287/net6 U2287/net4 VDD VDD pmos W=0.24u L=0.04u
M18853 n1729 U2287/net14 VDD VDD pmos W=0.205u L=0.04u
M18854 U2287/net10 WX8405 VDD VDD pmos W=0.205u L=0.04u
M18855 WX6503 n1615 U2288/net26 VSS nmos W=0.155u L=0.04u
M18856 WX6503 n1388 U2288/net26 VSS nmos W=0.155u L=0.04u
M18857 U2288/net29 n1730 VSS VSS nmos W=0.155u L=0.04u
M18858 U2288/net26 WX6948 U2288/net29 VSS nmos W=0.155u L=0.04u
M18859 U2288/net26 n1500 U2288/net29 VSS nmos W=0.155u L=0.04u
M18860 WX6503 n1388 U2288/net43 VDD pmos W=0.205u L=0.04u
M18861 WX6503 n1500 U2288/net49 VDD pmos W=0.205u L=0.04u
M18862 U2288/net49 WX6948 VDD VDD pmos W=0.205u L=0.04u
M18863 U2288/net43 n1615 VDD VDD pmos W=0.205u L=0.04u
M18864 WX6503 n1730 VDD VDD pmos W=0.205u L=0.04u
M18865 U2289/net29 n1731 VSS VSS nmos W=0.155u L=0.04u
M18866 n1730 n1430 U2289/net29 VSS nmos W=0.155u L=0.04u
M18867 n1730 n1617 U2289/net23 VSS nmos W=0.155u L=0.04u
M18868 U2289/net23 n1618 VSS VSS nmos W=0.155u L=0.04u
M18869 U2289/net20 n1618 n1730 VDD pmos W=0.205u L=0.04u
M18870 U2289/net20 n1617 n1730 VDD pmos W=0.205u L=0.04u
M18871 VDD n1430 U2289/net20 VDD pmos W=0.205u L=0.04u
M18872 VDD n1731 U2289/net20 VDD pmos W=0.205u L=0.04u
M18873 U2290/net28 U2290/net20 U2290/net64 VSS nmos W=0.155u L=0.04u
M18874 U2290/net24 U2290/net30 U2290/net32 VSS nmos W=0.155u L=0.04u
M18875 U2290/net28 U2290/net40 U2290/net24 VSS nmos W=0.155u L=0.04u
M18876 U2290/net40 n1732 U2290/net108 VSS nmos W=0.155u L=0.04u
M18877 U2290/net40 U2290/net106 U2290/net104 VSS nmos W=0.155u L=0.04u
M18878 U2290/net24 WX8531 U2290/net050 VSS nmos W=0.155u L=0.04u
M18879 U2290/net050 U2290/net32 VSS VSS nmos W=0.155u L=0.04u
M18880 U2290/net20 U2290/net40 VSS VSS nmos W=0.155u L=0.04u
M18881 U2290/net106 n1732 VSS VSS nmos W=0.155u L=0.04u
M18882 U2290/net104 WX8595 VSS VSS nmos W=0.155u L=0.04u
M18883 U2290/net30 WX8531 VSS VSS nmos W=0.155u L=0.04u
M18884 U2290/net108 U2290/net104 VSS VSS nmos W=0.155u L=0.04u
M18885 n1618 U2290/net28 VSS VSS nmos W=0.155u L=0.04u
M18886 U2290/net32 WX8467 VSS VSS nmos W=0.155u L=0.04u
M18887 U2290/net64 U2290/net24 VSS VSS nmos W=0.2u L=0.04u
M18888 U2290/net28 U2290/net40 U2290/net64 VDD pmos W=0.205u L=0.04u
M18889 U2290/net24 WX8531 U2290/net32 VDD pmos W=0.205u L=0.04u
M18890 U2290/net28 U2290/net20 U2290/net24 VDD pmos W=0.205u L=0.04u
M18891 U2290/net40 U2290/net106 U2290/net108 VDD pmos W=0.205u L=0.04u
M18892 U2290/net40 n1732 U2290/net104 VDD pmos W=0.205u L=0.04u
M18893 U2290/net20 U2290/net40 VDD VDD pmos W=0.205u L=0.04u
M18894 U2290/net106 n1732 VDD VDD pmos W=0.205u L=0.04u
M18895 U2290/net104 WX8595 VDD VDD pmos W=0.205u L=0.04u
M18896 U2290/net30 WX8531 VDD VDD pmos W=0.205u L=0.04u
M18897 U2290/net108 U2290/net104 VDD VDD pmos W=0.205u L=0.04u
M18898 n1618 U2290/net28 VDD VDD pmos W=0.205u L=0.04u
M18899 U2290/net32 WX8467 VDD VDD pmos W=0.205u L=0.04u
M18900 U2290/net64 U2290/net24 VDD VDD pmos W=0.28u L=0.04u
M18901 U2290/net24 U2290/net30 U2290/net045 VDD pmos W=0.205u L=0.04u
M18902 U2290/net045 U2290/net32 VDD VDD pmos W=0.205u L=0.04u
M18903 U2291/net4 WX8403 U2291/net14 VSS nmos W=0.155u L=0.04u
M18904 U2291/net6 U2291/net10 U2291/net14 VSS nmos W=0.17u L=0.04u
M18905 U2291/net4 n1370 VSS VSS nmos W=0.155u L=0.04u
M18906 U2291/net6 U2291/net4 VSS VSS nmos W=0.17u L=0.04u
M18907 n1732 U2291/net14 VSS VSS nmos W=0.155u L=0.04u
M18908 U2291/net10 WX8403 VSS VSS nmos W=0.155u L=0.04u
M18909 U2291/net4 U2291/net10 U2291/net14 VDD pmos W=0.255u L=0.04u
M18910 U2291/net6 WX8403 U2291/net14 VDD pmos W=0.28u L=0.04u
M18911 U2291/net4 n1370 VDD VDD pmos W=0.205u L=0.04u
M18912 U2291/net6 U2291/net4 VDD VDD pmos W=0.24u L=0.04u
M18913 n1732 U2291/net14 VDD VDD pmos W=0.205u L=0.04u
M18914 U2291/net10 WX8403 VDD VDD pmos W=0.205u L=0.04u
M18915 WX6948 WX6950 VSS VSS nmos W=0.135u L=0.04u
M18916 WX6948 WX6950 VDD VDD pmos W=0.205u L=0.04u
M18917 n1388 CRC_OUT_4_31 VSS VSS nmos W=0.135u L=0.04u
M18918 n1388 CRC_OUT_4_31 VDD VDD pmos W=0.205u L=0.04u
M18919 WX5644 n1276 U2294/net26 VSS nmos W=0.155u L=0.04u
M18920 WX5644 n1620 U2294/net26 VSS nmos W=0.155u L=0.04u
M18921 U2294/net29 n1734 VSS VSS nmos W=0.155u L=0.04u
M18922 U2294/net26 n1733 U2294/net29 VSS nmos W=0.155u L=0.04u
M18923 U2294/net26 n1248 U2294/net29 VSS nmos W=0.155u L=0.04u
M18924 WX5644 n1620 U2294/net43 VDD pmos W=0.205u L=0.04u
M18925 WX5644 n1248 U2294/net49 VDD pmos W=0.205u L=0.04u
M18926 U2294/net49 n1733 VDD VDD pmos W=0.205u L=0.04u
M18927 U2294/net43 n1276 VDD VDD pmos W=0.205u L=0.04u
M18928 WX5644 n1734 VDD VDD pmos W=0.205u L=0.04u
M18929 U2295/net29 n1336 VSS VSS nmos W=0.155u L=0.04u
M18930 n1734 WX5719 U2295/net29 VSS nmos W=0.155u L=0.04u
M18931 n1734 n1305 U2295/net23 VSS nmos W=0.155u L=0.04u
M18932 U2295/net23 CRC_OUT_5_0 VSS VSS nmos W=0.155u L=0.04u
M18933 U2295/net20 CRC_OUT_5_0 n1734 VDD pmos W=0.205u L=0.04u
M18934 U2295/net20 n1305 n1734 VDD pmos W=0.205u L=0.04u
M18935 VDD WX5719 U2295/net20 VDD pmos W=0.205u L=0.04u
M18936 VDD n1336 U2295/net20 VDD pmos W=0.205u L=0.04u
M18937 U2296/net28 U2296/net20 U2296/net64 VSS nmos W=0.155u L=0.04u
M18938 U2296/net24 U2296/net30 U2296/net32 VSS nmos W=0.155u L=0.04u
M18939 U2296/net28 U2296/net40 U2296/net24 VSS nmos W=0.155u L=0.04u
M18940 U2296/net40 WX7300 U2296/net108 VSS nmos W=0.155u L=0.04u
M18941 U2296/net40 U2296/net106 U2296/net104 VSS nmos W=0.155u L=0.04u
M18942 U2296/net24 WX7236 U2296/net050 VSS nmos W=0.155u L=0.04u
M18943 U2296/net050 U2296/net32 VSS VSS nmos W=0.155u L=0.04u
M18944 U2296/net20 U2296/net40 VSS VSS nmos W=0.155u L=0.04u
M18945 U2296/net106 WX7300 VSS VSS nmos W=0.155u L=0.04u
M18946 U2296/net104 n1389 VSS VSS nmos W=0.155u L=0.04u
M18947 U2296/net30 WX7236 VSS VSS nmos W=0.155u L=0.04u
M18948 U2296/net108 U2296/net104 VSS VSS nmos W=0.155u L=0.04u
M18949 n1620 U2296/net28 VSS VSS nmos W=0.155u L=0.04u
M18950 U2296/net32 WX7172 VSS VSS nmos W=0.155u L=0.04u
M18951 U2296/net64 U2296/net24 VSS VSS nmos W=0.2u L=0.04u
M18952 U2296/net28 U2296/net40 U2296/net64 VDD pmos W=0.205u L=0.04u
M18953 U2296/net24 WX7236 U2296/net32 VDD pmos W=0.205u L=0.04u
M18954 U2296/net28 U2296/net20 U2296/net24 VDD pmos W=0.205u L=0.04u
M18955 U2296/net40 U2296/net106 U2296/net108 VDD pmos W=0.205u L=0.04u
M18956 U2296/net40 WX7300 U2296/net104 VDD pmos W=0.205u L=0.04u
M18957 U2296/net20 U2296/net40 VDD VDD pmos W=0.205u L=0.04u
M18958 U2296/net106 WX7300 VDD VDD pmos W=0.205u L=0.04u
M18959 U2296/net104 n1389 VDD VDD pmos W=0.205u L=0.04u
M18960 U2296/net30 WX7236 VDD VDD pmos W=0.205u L=0.04u
M18961 U2296/net108 U2296/net104 VDD VDD pmos W=0.205u L=0.04u
M18962 n1620 U2296/net28 VDD VDD pmos W=0.205u L=0.04u
M18963 U2296/net32 WX7172 VDD VDD pmos W=0.205u L=0.04u
M18964 U2296/net64 U2296/net24 VDD VDD pmos W=0.28u L=0.04u
M18965 U2296/net24 U2296/net30 U2296/net045 VDD pmos W=0.205u L=0.04u
M18966 U2296/net045 U2296/net32 VDD VDD pmos W=0.205u L=0.04u
M18967 n1389 WX7364 VSS VSS nmos W=0.135u L=0.04u
M18968 n1389 WX7364 VDD VDD pmos W=0.205u L=0.04u
M18969 WX5630 n1276 U2298/net26 VSS nmos W=0.155u L=0.04u
M18970 WX5630 n1622 U2298/net26 VSS nmos W=0.155u L=0.04u
M18971 U2298/net29 n1736 VSS VSS nmos W=0.155u L=0.04u
M18972 U2298/net26 n1735 U2298/net29 VSS nmos W=0.155u L=0.04u
M18973 U2298/net26 n1248 U2298/net29 VSS nmos W=0.155u L=0.04u
M18974 WX5630 n1622 U2298/net43 VDD pmos W=0.205u L=0.04u
M18975 WX5630 n1248 U2298/net49 VDD pmos W=0.205u L=0.04u
M18976 U2298/net49 n1735 VDD VDD pmos W=0.205u L=0.04u
M18977 U2298/net43 n1276 VDD VDD pmos W=0.205u L=0.04u
M18978 WX5630 n1736 VDD VDD pmos W=0.205u L=0.04u
M18979 U2299/net29 n1336 VSS VSS nmos W=0.155u L=0.04u
M18980 n1736 WX5717 U2299/net29 VSS nmos W=0.155u L=0.04u
M18981 n1736 n1305 U2299/net23 VSS nmos W=0.155u L=0.04u
M18982 U2299/net23 CRC_OUT_5_1 VSS VSS nmos W=0.155u L=0.04u
M18983 U2299/net20 CRC_OUT_5_1 n1736 VDD pmos W=0.205u L=0.04u
M18984 U2299/net20 n1305 n1736 VDD pmos W=0.205u L=0.04u
M18985 VDD WX5717 U2299/net20 VDD pmos W=0.205u L=0.04u
M18986 VDD n1336 U2299/net20 VDD pmos W=0.205u L=0.04u
M18987 n1622 n1737 VSS VSS nmos W=0.135u L=0.04u
M18988 n1622 n1737 VDD VDD pmos W=0.205u L=0.04u
M18989 U2301/net28 U2301/net20 U2301/net64 VSS nmos W=0.155u L=0.04u
M18990 U2301/net24 U2301/net30 U2301/net32 VSS nmos W=0.155u L=0.04u
M18991 U2301/net28 U2301/net40 U2301/net24 VSS nmos W=0.155u L=0.04u
M18992 U2301/net40 WX7298 U2301/net108 VSS nmos W=0.155u L=0.04u
M18993 U2301/net40 U2301/net106 U2301/net104 VSS nmos W=0.155u L=0.04u
M18994 U2301/net24 WX7234 U2301/net050 VSS nmos W=0.155u L=0.04u
M18995 U2301/net050 U2301/net32 VSS VSS nmos W=0.155u L=0.04u
M18996 U2301/net20 U2301/net40 VSS VSS nmos W=0.155u L=0.04u
M18997 U2301/net106 WX7298 VSS VSS nmos W=0.155u L=0.04u
M18998 U2301/net104 WX7362 VSS VSS nmos W=0.155u L=0.04u
M18999 U2301/net30 WX7234 VSS VSS nmos W=0.155u L=0.04u
M19000 U2301/net108 U2301/net104 VSS VSS nmos W=0.155u L=0.04u
M19001 n1737 U2301/net28 VSS VSS nmos W=0.155u L=0.04u
M19002 U2301/net32 WX7170 VSS VSS nmos W=0.155u L=0.04u
M19003 U2301/net64 U2301/net24 VSS VSS nmos W=0.2u L=0.04u
M19004 U2301/net28 U2301/net40 U2301/net64 VDD pmos W=0.205u L=0.04u
M19005 U2301/net24 WX7234 U2301/net32 VDD pmos W=0.205u L=0.04u
M19006 U2301/net28 U2301/net20 U2301/net24 VDD pmos W=0.205u L=0.04u
M19007 U2301/net40 U2301/net106 U2301/net108 VDD pmos W=0.205u L=0.04u
M19008 U2301/net40 WX7298 U2301/net104 VDD pmos W=0.205u L=0.04u
M19009 U2301/net20 U2301/net40 VDD VDD pmos W=0.205u L=0.04u
M19010 U2301/net106 WX7298 VDD VDD pmos W=0.205u L=0.04u
M19011 U2301/net104 WX7362 VDD VDD pmos W=0.205u L=0.04u
M19012 U2301/net30 WX7234 VDD VDD pmos W=0.205u L=0.04u
M19013 U2301/net108 U2301/net104 VDD VDD pmos W=0.205u L=0.04u
M19014 n1737 U2301/net28 VDD VDD pmos W=0.205u L=0.04u
M19015 U2301/net32 WX7170 VDD VDD pmos W=0.205u L=0.04u
M19016 U2301/net64 U2301/net24 VDD VDD pmos W=0.28u L=0.04u
M19017 U2301/net24 U2301/net30 U2301/net045 VDD pmos W=0.205u L=0.04u
M19018 U2301/net045 U2301/net32 VDD VDD pmos W=0.205u L=0.04u
M19019 WX5616 n1276 U2302/net26 VSS nmos W=0.155u L=0.04u
M19020 WX5616 n1625 U2302/net26 VSS nmos W=0.155u L=0.04u
M19021 U2302/net29 n1739 VSS VSS nmos W=0.155u L=0.04u
M19022 U2302/net26 n1738 U2302/net29 VSS nmos W=0.155u L=0.04u
M19023 U2302/net26 n1247 U2302/net29 VSS nmos W=0.155u L=0.04u
M19024 WX5616 n1625 U2302/net43 VDD pmos W=0.205u L=0.04u
M19025 WX5616 n1247 U2302/net49 VDD pmos W=0.205u L=0.04u
M19026 U2302/net49 n1738 VDD VDD pmos W=0.205u L=0.04u
M19027 U2302/net43 n1276 VDD VDD pmos W=0.205u L=0.04u
M19028 WX5616 n1739 VDD VDD pmos W=0.205u L=0.04u
M19029 U2303/net29 n1336 VSS VSS nmos W=0.155u L=0.04u
M19030 n1739 WX5715 U2303/net29 VSS nmos W=0.155u L=0.04u
M19031 n1739 n1305 U2303/net23 VSS nmos W=0.155u L=0.04u
M19032 U2303/net23 CRC_OUT_5_2 VSS VSS nmos W=0.155u L=0.04u
M19033 U2303/net20 CRC_OUT_5_2 n1739 VDD pmos W=0.205u L=0.04u
M19034 U2303/net20 n1305 n1739 VDD pmos W=0.205u L=0.04u
M19035 VDD WX5715 U2303/net20 VDD pmos W=0.205u L=0.04u
M19036 VDD n1336 U2303/net20 VDD pmos W=0.205u L=0.04u
M19037 n1625 n1740 VSS VSS nmos W=0.135u L=0.04u
M19038 n1625 n1740 VDD VDD pmos W=0.205u L=0.04u
M19039 U2305/net28 U2305/net20 U2305/net64 VSS nmos W=0.155u L=0.04u
M19040 U2305/net24 U2305/net30 U2305/net32 VSS nmos W=0.155u L=0.04u
M19041 U2305/net28 U2305/net40 U2305/net24 VSS nmos W=0.155u L=0.04u
M19042 U2305/net40 WX7296 U2305/net108 VSS nmos W=0.155u L=0.04u
M19043 U2305/net40 U2305/net106 U2305/net104 VSS nmos W=0.155u L=0.04u
M19044 U2305/net24 WX7232 U2305/net050 VSS nmos W=0.155u L=0.04u
M19045 U2305/net050 U2305/net32 VSS VSS nmos W=0.155u L=0.04u
M19046 U2305/net20 U2305/net40 VSS VSS nmos W=0.155u L=0.04u
M19047 U2305/net106 WX7296 VSS VSS nmos W=0.155u L=0.04u
M19048 U2305/net104 WX7360 VSS VSS nmos W=0.155u L=0.04u
M19049 U2305/net30 WX7232 VSS VSS nmos W=0.155u L=0.04u
M19050 U2305/net108 U2305/net104 VSS VSS nmos W=0.155u L=0.04u
M19051 n1740 U2305/net28 VSS VSS nmos W=0.155u L=0.04u
M19052 U2305/net32 WX7168 VSS VSS nmos W=0.155u L=0.04u
M19053 U2305/net64 U2305/net24 VSS VSS nmos W=0.2u L=0.04u
M19054 U2305/net28 U2305/net40 U2305/net64 VDD pmos W=0.205u L=0.04u
M19055 U2305/net24 WX7232 U2305/net32 VDD pmos W=0.205u L=0.04u
M19056 U2305/net28 U2305/net20 U2305/net24 VDD pmos W=0.205u L=0.04u
M19057 U2305/net40 U2305/net106 U2305/net108 VDD pmos W=0.205u L=0.04u
M19058 U2305/net40 WX7296 U2305/net104 VDD pmos W=0.205u L=0.04u
M19059 U2305/net20 U2305/net40 VDD VDD pmos W=0.205u L=0.04u
M19060 U2305/net106 WX7296 VDD VDD pmos W=0.205u L=0.04u
M19061 U2305/net104 WX7360 VDD VDD pmos W=0.205u L=0.04u
M19062 U2305/net30 WX7232 VDD VDD pmos W=0.205u L=0.04u
M19063 U2305/net108 U2305/net104 VDD VDD pmos W=0.205u L=0.04u
M19064 n1740 U2305/net28 VDD VDD pmos W=0.205u L=0.04u
M19065 U2305/net32 WX7168 VDD VDD pmos W=0.205u L=0.04u
M19066 U2305/net64 U2305/net24 VDD VDD pmos W=0.28u L=0.04u
M19067 U2305/net24 U2305/net30 U2305/net045 VDD pmos W=0.205u L=0.04u
M19068 U2305/net045 U2305/net32 VDD VDD pmos W=0.205u L=0.04u
M19069 WX5602 n1276 U2306/net26 VSS nmos W=0.155u L=0.04u
M19070 WX5602 n1628 U2306/net26 VSS nmos W=0.155u L=0.04u
M19071 U2306/net29 n1742 VSS VSS nmos W=0.155u L=0.04u
M19072 U2306/net26 n1741 U2306/net29 VSS nmos W=0.155u L=0.04u
M19073 U2306/net26 n1247 U2306/net29 VSS nmos W=0.155u L=0.04u
M19074 WX5602 n1628 U2306/net43 VDD pmos W=0.205u L=0.04u
M19075 WX5602 n1247 U2306/net49 VDD pmos W=0.205u L=0.04u
M19076 U2306/net49 n1741 VDD VDD pmos W=0.205u L=0.04u
M19077 U2306/net43 n1276 VDD VDD pmos W=0.205u L=0.04u
M19078 WX5602 n1742 VDD VDD pmos W=0.205u L=0.04u
M19079 U2307/net29 n1336 VSS VSS nmos W=0.155u L=0.04u
M19080 n1742 WX5713 U2307/net29 VSS nmos W=0.155u L=0.04u
M19081 n1742 n1305 U2307/net23 VSS nmos W=0.155u L=0.04u
M19082 U2307/net23 CRC_OUT_5_3 VSS VSS nmos W=0.155u L=0.04u
M19083 U2307/net20 CRC_OUT_5_3 n1742 VDD pmos W=0.205u L=0.04u
M19084 U2307/net20 n1305 n1742 VDD pmos W=0.205u L=0.04u
M19085 VDD WX5713 U2307/net20 VDD pmos W=0.205u L=0.04u
M19086 VDD n1336 U2307/net20 VDD pmos W=0.205u L=0.04u
M19087 n1628 n1743 VSS VSS nmos W=0.135u L=0.04u
M19088 n1628 n1743 VDD VDD pmos W=0.205u L=0.04u
M19089 U2309/net28 U2309/net20 U2309/net64 VSS nmos W=0.155u L=0.04u
M19090 U2309/net24 U2309/net30 U2309/net32 VSS nmos W=0.155u L=0.04u
M19091 U2309/net28 U2309/net40 U2309/net24 VSS nmos W=0.155u L=0.04u
M19092 U2309/net40 WX7294 U2309/net108 VSS nmos W=0.155u L=0.04u
M19093 U2309/net40 U2309/net106 U2309/net104 VSS nmos W=0.155u L=0.04u
M19094 U2309/net24 WX7230 U2309/net050 VSS nmos W=0.155u L=0.04u
M19095 U2309/net050 U2309/net32 VSS VSS nmos W=0.155u L=0.04u
M19096 U2309/net20 U2309/net40 VSS VSS nmos W=0.155u L=0.04u
M19097 U2309/net106 WX7294 VSS VSS nmos W=0.155u L=0.04u
M19098 U2309/net104 WX7358 VSS VSS nmos W=0.155u L=0.04u
M19099 U2309/net30 WX7230 VSS VSS nmos W=0.155u L=0.04u
M19100 U2309/net108 U2309/net104 VSS VSS nmos W=0.155u L=0.04u
M19101 n1743 U2309/net28 VSS VSS nmos W=0.155u L=0.04u
M19102 U2309/net32 WX7166 VSS VSS nmos W=0.155u L=0.04u
M19103 U2309/net64 U2309/net24 VSS VSS nmos W=0.2u L=0.04u
M19104 U2309/net28 U2309/net40 U2309/net64 VDD pmos W=0.205u L=0.04u
M19105 U2309/net24 WX7230 U2309/net32 VDD pmos W=0.205u L=0.04u
M19106 U2309/net28 U2309/net20 U2309/net24 VDD pmos W=0.205u L=0.04u
M19107 U2309/net40 U2309/net106 U2309/net108 VDD pmos W=0.205u L=0.04u
M19108 U2309/net40 WX7294 U2309/net104 VDD pmos W=0.205u L=0.04u
M19109 U2309/net20 U2309/net40 VDD VDD pmos W=0.205u L=0.04u
M19110 U2309/net106 WX7294 VDD VDD pmos W=0.205u L=0.04u
M19111 U2309/net104 WX7358 VDD VDD pmos W=0.205u L=0.04u
M19112 U2309/net30 WX7230 VDD VDD pmos W=0.205u L=0.04u
M19113 U2309/net108 U2309/net104 VDD VDD pmos W=0.205u L=0.04u
M19114 n1743 U2309/net28 VDD VDD pmos W=0.205u L=0.04u
M19115 U2309/net32 WX7166 VDD VDD pmos W=0.205u L=0.04u
M19116 U2309/net64 U2309/net24 VDD VDD pmos W=0.28u L=0.04u
M19117 U2309/net24 U2309/net30 U2309/net045 VDD pmos W=0.205u L=0.04u
M19118 U2309/net045 U2309/net32 VDD VDD pmos W=0.205u L=0.04u
M19119 WX5588 n1276 U2310/net26 VSS nmos W=0.155u L=0.04u
M19120 WX5588 n1631 U2310/net26 VSS nmos W=0.155u L=0.04u
M19121 U2310/net29 n1745 VSS VSS nmos W=0.155u L=0.04u
M19122 U2310/net26 n1744 U2310/net29 VSS nmos W=0.155u L=0.04u
M19123 U2310/net26 n1247 U2310/net29 VSS nmos W=0.155u L=0.04u
M19124 WX5588 n1631 U2310/net43 VDD pmos W=0.205u L=0.04u
M19125 WX5588 n1247 U2310/net49 VDD pmos W=0.205u L=0.04u
M19126 U2310/net49 n1744 VDD VDD pmos W=0.205u L=0.04u
M19127 U2310/net43 n1276 VDD VDD pmos W=0.205u L=0.04u
M19128 WX5588 n1745 VDD VDD pmos W=0.205u L=0.04u
M19129 U2311/net29 n1336 VSS VSS nmos W=0.155u L=0.04u
M19130 n1745 WX5711 U2311/net29 VSS nmos W=0.155u L=0.04u
M19131 n1745 n1305 U2311/net23 VSS nmos W=0.155u L=0.04u
M19132 U2311/net23 CRC_OUT_5_4 VSS VSS nmos W=0.155u L=0.04u
M19133 U2311/net20 CRC_OUT_5_4 n1745 VDD pmos W=0.205u L=0.04u
M19134 U2311/net20 n1305 n1745 VDD pmos W=0.205u L=0.04u
M19135 VDD WX5711 U2311/net20 VDD pmos W=0.205u L=0.04u
M19136 VDD n1336 U2311/net20 VDD pmos W=0.205u L=0.04u
M19137 n1631 n1746 VSS VSS nmos W=0.135u L=0.04u
M19138 n1631 n1746 VDD VDD pmos W=0.205u L=0.04u
M19139 U2313/net28 U2313/net20 U2313/net64 VSS nmos W=0.155u L=0.04u
M19140 U2313/net24 U2313/net30 U2313/net32 VSS nmos W=0.155u L=0.04u
M19141 U2313/net28 U2313/net40 U2313/net24 VSS nmos W=0.155u L=0.04u
M19142 U2313/net40 WX7292 U2313/net108 VSS nmos W=0.155u L=0.04u
M19143 U2313/net40 U2313/net106 U2313/net104 VSS nmos W=0.155u L=0.04u
M19144 U2313/net24 WX7228 U2313/net050 VSS nmos W=0.155u L=0.04u
M19145 U2313/net050 U2313/net32 VSS VSS nmos W=0.155u L=0.04u
M19146 U2313/net20 U2313/net40 VSS VSS nmos W=0.155u L=0.04u
M19147 U2313/net106 WX7292 VSS VSS nmos W=0.155u L=0.04u
M19148 U2313/net104 WX7356 VSS VSS nmos W=0.155u L=0.04u
M19149 U2313/net30 WX7228 VSS VSS nmos W=0.155u L=0.04u
M19150 U2313/net108 U2313/net104 VSS VSS nmos W=0.155u L=0.04u
M19151 n1746 U2313/net28 VSS VSS nmos W=0.155u L=0.04u
M19152 U2313/net32 WX7164 VSS VSS nmos W=0.155u L=0.04u
M19153 U2313/net64 U2313/net24 VSS VSS nmos W=0.2u L=0.04u
M19154 U2313/net28 U2313/net40 U2313/net64 VDD pmos W=0.205u L=0.04u
M19155 U2313/net24 WX7228 U2313/net32 VDD pmos W=0.205u L=0.04u
M19156 U2313/net28 U2313/net20 U2313/net24 VDD pmos W=0.205u L=0.04u
M19157 U2313/net40 U2313/net106 U2313/net108 VDD pmos W=0.205u L=0.04u
M19158 U2313/net40 WX7292 U2313/net104 VDD pmos W=0.205u L=0.04u
M19159 U2313/net20 U2313/net40 VDD VDD pmos W=0.205u L=0.04u
M19160 U2313/net106 WX7292 VDD VDD pmos W=0.205u L=0.04u
M19161 U2313/net104 WX7356 VDD VDD pmos W=0.205u L=0.04u
M19162 U2313/net30 WX7228 VDD VDD pmos W=0.205u L=0.04u
M19163 U2313/net108 U2313/net104 VDD VDD pmos W=0.205u L=0.04u
M19164 n1746 U2313/net28 VDD VDD pmos W=0.205u L=0.04u
M19165 U2313/net32 WX7164 VDD VDD pmos W=0.205u L=0.04u
M19166 U2313/net64 U2313/net24 VDD VDD pmos W=0.28u L=0.04u
M19167 U2313/net24 U2313/net30 U2313/net045 VDD pmos W=0.205u L=0.04u
M19168 U2313/net045 U2313/net32 VDD VDD pmos W=0.205u L=0.04u
M19169 WX5574 n1275 U2314/net26 VSS nmos W=0.155u L=0.04u
M19170 WX5574 n1634 U2314/net26 VSS nmos W=0.155u L=0.04u
M19171 U2314/net29 n1748 VSS VSS nmos W=0.155u L=0.04u
M19172 U2314/net26 n1747 U2314/net29 VSS nmos W=0.155u L=0.04u
M19173 U2314/net26 n1247 U2314/net29 VSS nmos W=0.155u L=0.04u
M19174 WX5574 n1634 U2314/net43 VDD pmos W=0.205u L=0.04u
M19175 WX5574 n1247 U2314/net49 VDD pmos W=0.205u L=0.04u
M19176 U2314/net49 n1747 VDD VDD pmos W=0.205u L=0.04u
M19177 U2314/net43 n1275 VDD VDD pmos W=0.205u L=0.04u
M19178 WX5574 n1748 VDD VDD pmos W=0.205u L=0.04u
M19179 U2315/net29 n1335 VSS VSS nmos W=0.155u L=0.04u
M19180 n1748 WX5709 U2315/net29 VSS nmos W=0.155u L=0.04u
M19181 n1748 n1305 U2315/net23 VSS nmos W=0.155u L=0.04u
M19182 U2315/net23 CRC_OUT_5_5 VSS VSS nmos W=0.155u L=0.04u
M19183 U2315/net20 CRC_OUT_5_5 n1748 VDD pmos W=0.205u L=0.04u
M19184 U2315/net20 n1305 n1748 VDD pmos W=0.205u L=0.04u
M19185 VDD WX5709 U2315/net20 VDD pmos W=0.205u L=0.04u
M19186 VDD n1335 U2315/net20 VDD pmos W=0.205u L=0.04u
M19187 n1634 n1749 VSS VSS nmos W=0.135u L=0.04u
M19188 n1634 n1749 VDD VDD pmos W=0.205u L=0.04u
M19189 U2317/net28 U2317/net20 U2317/net64 VSS nmos W=0.155u L=0.04u
M19190 U2317/net24 U2317/net30 U2317/net32 VSS nmos W=0.155u L=0.04u
M19191 U2317/net28 U2317/net40 U2317/net24 VSS nmos W=0.155u L=0.04u
M19192 U2317/net40 WX7290 U2317/net108 VSS nmos W=0.155u L=0.04u
M19193 U2317/net40 U2317/net106 U2317/net104 VSS nmos W=0.155u L=0.04u
M19194 U2317/net24 WX7226 U2317/net050 VSS nmos W=0.155u L=0.04u
M19195 U2317/net050 U2317/net32 VSS VSS nmos W=0.155u L=0.04u
M19196 U2317/net20 U2317/net40 VSS VSS nmos W=0.155u L=0.04u
M19197 U2317/net106 WX7290 VSS VSS nmos W=0.155u L=0.04u
M19198 U2317/net104 WX7354 VSS VSS nmos W=0.155u L=0.04u
M19199 U2317/net30 WX7226 VSS VSS nmos W=0.155u L=0.04u
M19200 U2317/net108 U2317/net104 VSS VSS nmos W=0.155u L=0.04u
M19201 n1749 U2317/net28 VSS VSS nmos W=0.155u L=0.04u
M19202 U2317/net32 WX7162 VSS VSS nmos W=0.155u L=0.04u
M19203 U2317/net64 U2317/net24 VSS VSS nmos W=0.2u L=0.04u
M19204 U2317/net28 U2317/net40 U2317/net64 VDD pmos W=0.205u L=0.04u
M19205 U2317/net24 WX7226 U2317/net32 VDD pmos W=0.205u L=0.04u
M19206 U2317/net28 U2317/net20 U2317/net24 VDD pmos W=0.205u L=0.04u
M19207 U2317/net40 U2317/net106 U2317/net108 VDD pmos W=0.205u L=0.04u
M19208 U2317/net40 WX7290 U2317/net104 VDD pmos W=0.205u L=0.04u
M19209 U2317/net20 U2317/net40 VDD VDD pmos W=0.205u L=0.04u
M19210 U2317/net106 WX7290 VDD VDD pmos W=0.205u L=0.04u
M19211 U2317/net104 WX7354 VDD VDD pmos W=0.205u L=0.04u
M19212 U2317/net30 WX7226 VDD VDD pmos W=0.205u L=0.04u
M19213 U2317/net108 U2317/net104 VDD VDD pmos W=0.205u L=0.04u
M19214 n1749 U2317/net28 VDD VDD pmos W=0.205u L=0.04u
M19215 U2317/net32 WX7162 VDD VDD pmos W=0.205u L=0.04u
M19216 U2317/net64 U2317/net24 VDD VDD pmos W=0.28u L=0.04u
M19217 U2317/net24 U2317/net30 U2317/net045 VDD pmos W=0.205u L=0.04u
M19218 U2317/net045 U2317/net32 VDD VDD pmos W=0.205u L=0.04u
M19219 WX5560 n1275 U2318/net26 VSS nmos W=0.155u L=0.04u
M19220 WX5560 n1637 U2318/net26 VSS nmos W=0.155u L=0.04u
M19221 U2318/net29 n1751 VSS VSS nmos W=0.155u L=0.04u
M19222 U2318/net26 n1750 U2318/net29 VSS nmos W=0.155u L=0.04u
M19223 U2318/net26 n1247 U2318/net29 VSS nmos W=0.155u L=0.04u
M19224 WX5560 n1637 U2318/net43 VDD pmos W=0.205u L=0.04u
M19225 WX5560 n1247 U2318/net49 VDD pmos W=0.205u L=0.04u
M19226 U2318/net49 n1750 VDD VDD pmos W=0.205u L=0.04u
M19227 U2318/net43 n1275 VDD VDD pmos W=0.205u L=0.04u
M19228 WX5560 n1751 VDD VDD pmos W=0.205u L=0.04u
M19229 U2319/net29 n1335 VSS VSS nmos W=0.155u L=0.04u
M19230 n1751 WX5707 U2319/net29 VSS nmos W=0.155u L=0.04u
M19231 n1751 n1305 U2319/net23 VSS nmos W=0.155u L=0.04u
M19232 U2319/net23 CRC_OUT_5_6 VSS VSS nmos W=0.155u L=0.04u
M19233 U2319/net20 CRC_OUT_5_6 n1751 VDD pmos W=0.205u L=0.04u
M19234 U2319/net20 n1305 n1751 VDD pmos W=0.205u L=0.04u
M19235 VDD WX5707 U2319/net20 VDD pmos W=0.205u L=0.04u
M19236 VDD n1335 U2319/net20 VDD pmos W=0.205u L=0.04u
M19237 n1637 n1752 VSS VSS nmos W=0.135u L=0.04u
M19238 n1637 n1752 VDD VDD pmos W=0.205u L=0.04u
M19239 U2321/net28 U2321/net20 U2321/net64 VSS nmos W=0.155u L=0.04u
M19240 U2321/net24 U2321/net30 U2321/net32 VSS nmos W=0.155u L=0.04u
M19241 U2321/net28 U2321/net40 U2321/net24 VSS nmos W=0.155u L=0.04u
M19242 U2321/net40 WX7288 U2321/net108 VSS nmos W=0.155u L=0.04u
M19243 U2321/net40 U2321/net106 U2321/net104 VSS nmos W=0.155u L=0.04u
M19244 U2321/net24 WX7224 U2321/net050 VSS nmos W=0.155u L=0.04u
M19245 U2321/net050 U2321/net32 VSS VSS nmos W=0.155u L=0.04u
M19246 U2321/net20 U2321/net40 VSS VSS nmos W=0.155u L=0.04u
M19247 U2321/net106 WX7288 VSS VSS nmos W=0.155u L=0.04u
M19248 U2321/net104 WX7352 VSS VSS nmos W=0.155u L=0.04u
M19249 U2321/net30 WX7224 VSS VSS nmos W=0.155u L=0.04u
M19250 U2321/net108 U2321/net104 VSS VSS nmos W=0.155u L=0.04u
M19251 n1752 U2321/net28 VSS VSS nmos W=0.155u L=0.04u
M19252 U2321/net32 WX7160 VSS VSS nmos W=0.155u L=0.04u
M19253 U2321/net64 U2321/net24 VSS VSS nmos W=0.2u L=0.04u
M19254 U2321/net28 U2321/net40 U2321/net64 VDD pmos W=0.205u L=0.04u
M19255 U2321/net24 WX7224 U2321/net32 VDD pmos W=0.205u L=0.04u
M19256 U2321/net28 U2321/net20 U2321/net24 VDD pmos W=0.205u L=0.04u
M19257 U2321/net40 U2321/net106 U2321/net108 VDD pmos W=0.205u L=0.04u
M19258 U2321/net40 WX7288 U2321/net104 VDD pmos W=0.205u L=0.04u
M19259 U2321/net20 U2321/net40 VDD VDD pmos W=0.205u L=0.04u
M19260 U2321/net106 WX7288 VDD VDD pmos W=0.205u L=0.04u
M19261 U2321/net104 WX7352 VDD VDD pmos W=0.205u L=0.04u
M19262 U2321/net30 WX7224 VDD VDD pmos W=0.205u L=0.04u
M19263 U2321/net108 U2321/net104 VDD VDD pmos W=0.205u L=0.04u
M19264 n1752 U2321/net28 VDD VDD pmos W=0.205u L=0.04u
M19265 U2321/net32 WX7160 VDD VDD pmos W=0.205u L=0.04u
M19266 U2321/net64 U2321/net24 VDD VDD pmos W=0.28u L=0.04u
M19267 U2321/net24 U2321/net30 U2321/net045 VDD pmos W=0.205u L=0.04u
M19268 U2321/net045 U2321/net32 VDD VDD pmos W=0.205u L=0.04u
M19269 WX5546 n1275 U2322/net26 VSS nmos W=0.155u L=0.04u
M19270 WX5546 n1640 U2322/net26 VSS nmos W=0.155u L=0.04u
M19271 U2322/net29 n1754 VSS VSS nmos W=0.155u L=0.04u
M19272 U2322/net26 n1753 U2322/net29 VSS nmos W=0.155u L=0.04u
M19273 U2322/net26 n1247 U2322/net29 VSS nmos W=0.155u L=0.04u
M19274 WX5546 n1640 U2322/net43 VDD pmos W=0.205u L=0.04u
M19275 WX5546 n1247 U2322/net49 VDD pmos W=0.205u L=0.04u
M19276 U2322/net49 n1753 VDD VDD pmos W=0.205u L=0.04u
M19277 U2322/net43 n1275 VDD VDD pmos W=0.205u L=0.04u
M19278 WX5546 n1754 VDD VDD pmos W=0.205u L=0.04u
M19279 U2323/net29 n1335 VSS VSS nmos W=0.155u L=0.04u
M19280 n1754 WX5705 U2323/net29 VSS nmos W=0.155u L=0.04u
M19281 n1754 n1304 U2323/net23 VSS nmos W=0.155u L=0.04u
M19282 U2323/net23 CRC_OUT_5_7 VSS VSS nmos W=0.155u L=0.04u
M19283 U2323/net20 CRC_OUT_5_7 n1754 VDD pmos W=0.205u L=0.04u
M19284 U2323/net20 n1304 n1754 VDD pmos W=0.205u L=0.04u
M19285 VDD WX5705 U2323/net20 VDD pmos W=0.205u L=0.04u
M19286 VDD n1335 U2323/net20 VDD pmos W=0.205u L=0.04u
M19287 n1640 n1755 VSS VSS nmos W=0.135u L=0.04u
M19288 n1640 n1755 VDD VDD pmos W=0.205u L=0.04u
M19289 U2325/net28 U2325/net20 U2325/net64 VSS nmos W=0.155u L=0.04u
M19290 U2325/net24 U2325/net30 U2325/net32 VSS nmos W=0.155u L=0.04u
M19291 U2325/net28 U2325/net40 U2325/net24 VSS nmos W=0.155u L=0.04u
M19292 U2325/net40 WX7286 U2325/net108 VSS nmos W=0.155u L=0.04u
M19293 U2325/net40 U2325/net106 U2325/net104 VSS nmos W=0.155u L=0.04u
M19294 U2325/net24 WX7222 U2325/net050 VSS nmos W=0.155u L=0.04u
M19295 U2325/net050 U2325/net32 VSS VSS nmos W=0.155u L=0.04u
M19296 U2325/net20 U2325/net40 VSS VSS nmos W=0.155u L=0.04u
M19297 U2325/net106 WX7286 VSS VSS nmos W=0.155u L=0.04u
M19298 U2325/net104 WX7350 VSS VSS nmos W=0.155u L=0.04u
M19299 U2325/net30 WX7222 VSS VSS nmos W=0.155u L=0.04u
M19300 U2325/net108 U2325/net104 VSS VSS nmos W=0.155u L=0.04u
M19301 n1755 U2325/net28 VSS VSS nmos W=0.155u L=0.04u
M19302 U2325/net32 WX7158 VSS VSS nmos W=0.155u L=0.04u
M19303 U2325/net64 U2325/net24 VSS VSS nmos W=0.2u L=0.04u
M19304 U2325/net28 U2325/net40 U2325/net64 VDD pmos W=0.205u L=0.04u
M19305 U2325/net24 WX7222 U2325/net32 VDD pmos W=0.205u L=0.04u
M19306 U2325/net28 U2325/net20 U2325/net24 VDD pmos W=0.205u L=0.04u
M19307 U2325/net40 U2325/net106 U2325/net108 VDD pmos W=0.205u L=0.04u
M19308 U2325/net40 WX7286 U2325/net104 VDD pmos W=0.205u L=0.04u
M19309 U2325/net20 U2325/net40 VDD VDD pmos W=0.205u L=0.04u
M19310 U2325/net106 WX7286 VDD VDD pmos W=0.205u L=0.04u
M19311 U2325/net104 WX7350 VDD VDD pmos W=0.205u L=0.04u
M19312 U2325/net30 WX7222 VDD VDD pmos W=0.205u L=0.04u
M19313 U2325/net108 U2325/net104 VDD VDD pmos W=0.205u L=0.04u
M19314 n1755 U2325/net28 VDD VDD pmos W=0.205u L=0.04u
M19315 U2325/net32 WX7158 VDD VDD pmos W=0.205u L=0.04u
M19316 U2325/net64 U2325/net24 VDD VDD pmos W=0.28u L=0.04u
M19317 U2325/net24 U2325/net30 U2325/net045 VDD pmos W=0.205u L=0.04u
M19318 U2325/net045 U2325/net32 VDD VDD pmos W=0.205u L=0.04u
M19319 WX5532 n1275 U2326/net26 VSS nmos W=0.155u L=0.04u
M19320 WX5532 n1643 U2326/net26 VSS nmos W=0.155u L=0.04u
M19321 U2326/net29 n1757 VSS VSS nmos W=0.155u L=0.04u
M19322 U2326/net26 n1756 U2326/net29 VSS nmos W=0.155u L=0.04u
M19323 U2326/net26 n1247 U2326/net29 VSS nmos W=0.155u L=0.04u
M19324 WX5532 n1643 U2326/net43 VDD pmos W=0.205u L=0.04u
M19325 WX5532 n1247 U2326/net49 VDD pmos W=0.205u L=0.04u
M19326 U2326/net49 n1756 VDD VDD pmos W=0.205u L=0.04u
M19327 U2326/net43 n1275 VDD VDD pmos W=0.205u L=0.04u
M19328 WX5532 n1757 VDD VDD pmos W=0.205u L=0.04u
M19329 U2327/net29 n1335 VSS VSS nmos W=0.155u L=0.04u
M19330 n1757 WX5703 U2327/net29 VSS nmos W=0.155u L=0.04u
M19331 n1757 n1304 U2327/net23 VSS nmos W=0.155u L=0.04u
M19332 U2327/net23 CRC_OUT_5_8 VSS VSS nmos W=0.155u L=0.04u
M19333 U2327/net20 CRC_OUT_5_8 n1757 VDD pmos W=0.205u L=0.04u
M19334 U2327/net20 n1304 n1757 VDD pmos W=0.205u L=0.04u
M19335 VDD WX5703 U2327/net20 VDD pmos W=0.205u L=0.04u
M19336 VDD n1335 U2327/net20 VDD pmos W=0.205u L=0.04u
M19337 n1643 n1758 VSS VSS nmos W=0.135u L=0.04u
M19338 n1643 n1758 VDD VDD pmos W=0.205u L=0.04u
M19339 U2329/net28 U2329/net20 U2329/net64 VSS nmos W=0.155u L=0.04u
M19340 U2329/net24 U2329/net30 U2329/net32 VSS nmos W=0.155u L=0.04u
M19341 U2329/net28 U2329/net40 U2329/net24 VSS nmos W=0.155u L=0.04u
M19342 U2329/net40 WX7284 U2329/net108 VSS nmos W=0.155u L=0.04u
M19343 U2329/net40 U2329/net106 U2329/net104 VSS nmos W=0.155u L=0.04u
M19344 U2329/net24 WX7220 U2329/net050 VSS nmos W=0.155u L=0.04u
M19345 U2329/net050 U2329/net32 VSS VSS nmos W=0.155u L=0.04u
M19346 U2329/net20 U2329/net40 VSS VSS nmos W=0.155u L=0.04u
M19347 U2329/net106 WX7284 VSS VSS nmos W=0.155u L=0.04u
M19348 U2329/net104 WX7348 VSS VSS nmos W=0.155u L=0.04u
M19349 U2329/net30 WX7220 VSS VSS nmos W=0.155u L=0.04u
M19350 U2329/net108 U2329/net104 VSS VSS nmos W=0.155u L=0.04u
M19351 n1758 U2329/net28 VSS VSS nmos W=0.155u L=0.04u
M19352 U2329/net32 WX7156 VSS VSS nmos W=0.155u L=0.04u
M19353 U2329/net64 U2329/net24 VSS VSS nmos W=0.2u L=0.04u
M19354 U2329/net28 U2329/net40 U2329/net64 VDD pmos W=0.205u L=0.04u
M19355 U2329/net24 WX7220 U2329/net32 VDD pmos W=0.205u L=0.04u
M19356 U2329/net28 U2329/net20 U2329/net24 VDD pmos W=0.205u L=0.04u
M19357 U2329/net40 U2329/net106 U2329/net108 VDD pmos W=0.205u L=0.04u
M19358 U2329/net40 WX7284 U2329/net104 VDD pmos W=0.205u L=0.04u
M19359 U2329/net20 U2329/net40 VDD VDD pmos W=0.205u L=0.04u
M19360 U2329/net106 WX7284 VDD VDD pmos W=0.205u L=0.04u
M19361 U2329/net104 WX7348 VDD VDD pmos W=0.205u L=0.04u
M19362 U2329/net30 WX7220 VDD VDD pmos W=0.205u L=0.04u
M19363 U2329/net108 U2329/net104 VDD VDD pmos W=0.205u L=0.04u
M19364 n1758 U2329/net28 VDD VDD pmos W=0.205u L=0.04u
M19365 U2329/net32 WX7156 VDD VDD pmos W=0.205u L=0.04u
M19366 U2329/net64 U2329/net24 VDD VDD pmos W=0.28u L=0.04u
M19367 U2329/net24 U2329/net30 U2329/net045 VDD pmos W=0.205u L=0.04u
M19368 U2329/net045 U2329/net32 VDD VDD pmos W=0.205u L=0.04u
M19369 WX5518 n1275 U2330/net26 VSS nmos W=0.155u L=0.04u
M19370 WX5518 n1646 U2330/net26 VSS nmos W=0.155u L=0.04u
M19371 U2330/net29 n1760 VSS VSS nmos W=0.155u L=0.04u
M19372 U2330/net26 n1759 U2330/net29 VSS nmos W=0.155u L=0.04u
M19373 U2330/net26 n1247 U2330/net29 VSS nmos W=0.155u L=0.04u
M19374 WX5518 n1646 U2330/net43 VDD pmos W=0.205u L=0.04u
M19375 WX5518 n1247 U2330/net49 VDD pmos W=0.205u L=0.04u
M19376 U2330/net49 n1759 VDD VDD pmos W=0.205u L=0.04u
M19377 U2330/net43 n1275 VDD VDD pmos W=0.205u L=0.04u
M19378 WX5518 n1760 VDD VDD pmos W=0.205u L=0.04u
M19379 U2331/net29 n1335 VSS VSS nmos W=0.155u L=0.04u
M19380 n1760 WX5701 U2331/net29 VSS nmos W=0.155u L=0.04u
M19381 n1760 n1304 U2331/net23 VSS nmos W=0.155u L=0.04u
M19382 U2331/net23 CRC_OUT_5_9 VSS VSS nmos W=0.155u L=0.04u
M19383 U2331/net20 CRC_OUT_5_9 n1760 VDD pmos W=0.205u L=0.04u
M19384 U2331/net20 n1304 n1760 VDD pmos W=0.205u L=0.04u
M19385 VDD WX5701 U2331/net20 VDD pmos W=0.205u L=0.04u
M19386 VDD n1335 U2331/net20 VDD pmos W=0.205u L=0.04u
M19387 n1646 n1761 VSS VSS nmos W=0.135u L=0.04u
M19388 n1646 n1761 VDD VDD pmos W=0.205u L=0.04u
M19389 U2333/net28 U2333/net20 U2333/net64 VSS nmos W=0.155u L=0.04u
M19390 U2333/net24 U2333/net30 U2333/net32 VSS nmos W=0.155u L=0.04u
M19391 U2333/net28 U2333/net40 U2333/net24 VSS nmos W=0.155u L=0.04u
M19392 U2333/net40 WX7282 U2333/net108 VSS nmos W=0.155u L=0.04u
M19393 U2333/net40 U2333/net106 U2333/net104 VSS nmos W=0.155u L=0.04u
M19394 U2333/net24 WX7218 U2333/net050 VSS nmos W=0.155u L=0.04u
M19395 U2333/net050 U2333/net32 VSS VSS nmos W=0.155u L=0.04u
M19396 U2333/net20 U2333/net40 VSS VSS nmos W=0.155u L=0.04u
M19397 U2333/net106 WX7282 VSS VSS nmos W=0.155u L=0.04u
M19398 U2333/net104 WX7346 VSS VSS nmos W=0.155u L=0.04u
M19399 U2333/net30 WX7218 VSS VSS nmos W=0.155u L=0.04u
M19400 U2333/net108 U2333/net104 VSS VSS nmos W=0.155u L=0.04u
M19401 n1761 U2333/net28 VSS VSS nmos W=0.155u L=0.04u
M19402 U2333/net32 WX7154 VSS VSS nmos W=0.155u L=0.04u
M19403 U2333/net64 U2333/net24 VSS VSS nmos W=0.2u L=0.04u
M19404 U2333/net28 U2333/net40 U2333/net64 VDD pmos W=0.205u L=0.04u
M19405 U2333/net24 WX7218 U2333/net32 VDD pmos W=0.205u L=0.04u
M19406 U2333/net28 U2333/net20 U2333/net24 VDD pmos W=0.205u L=0.04u
M19407 U2333/net40 U2333/net106 U2333/net108 VDD pmos W=0.205u L=0.04u
M19408 U2333/net40 WX7282 U2333/net104 VDD pmos W=0.205u L=0.04u
M19409 U2333/net20 U2333/net40 VDD VDD pmos W=0.205u L=0.04u
M19410 U2333/net106 WX7282 VDD VDD pmos W=0.205u L=0.04u
M19411 U2333/net104 WX7346 VDD VDD pmos W=0.205u L=0.04u
M19412 U2333/net30 WX7218 VDD VDD pmos W=0.205u L=0.04u
M19413 U2333/net108 U2333/net104 VDD VDD pmos W=0.205u L=0.04u
M19414 n1761 U2333/net28 VDD VDD pmos W=0.205u L=0.04u
M19415 U2333/net32 WX7154 VDD VDD pmos W=0.205u L=0.04u
M19416 U2333/net64 U2333/net24 VDD VDD pmos W=0.28u L=0.04u
M19417 U2333/net24 U2333/net30 U2333/net045 VDD pmos W=0.205u L=0.04u
M19418 U2333/net045 U2333/net32 VDD VDD pmos W=0.205u L=0.04u
M19419 WX5504 n1275 U2334/net26 VSS nmos W=0.155u L=0.04u
M19420 WX5504 n1649 U2334/net26 VSS nmos W=0.155u L=0.04u
M19421 U2334/net29 n1763 VSS VSS nmos W=0.155u L=0.04u
M19422 U2334/net26 n1762 U2334/net29 VSS nmos W=0.155u L=0.04u
M19423 U2334/net26 n1247 U2334/net29 VSS nmos W=0.155u L=0.04u
M19424 WX5504 n1649 U2334/net43 VDD pmos W=0.205u L=0.04u
M19425 WX5504 n1247 U2334/net49 VDD pmos W=0.205u L=0.04u
M19426 U2334/net49 n1762 VDD VDD pmos W=0.205u L=0.04u
M19427 U2334/net43 n1275 VDD VDD pmos W=0.205u L=0.04u
M19428 WX5504 n1763 VDD VDD pmos W=0.205u L=0.04u
M19429 U2335/net29 n1335 VSS VSS nmos W=0.155u L=0.04u
M19430 n1763 WX5699 U2335/net29 VSS nmos W=0.155u L=0.04u
M19431 n1763 n1304 U2335/net23 VSS nmos W=0.155u L=0.04u
M19432 U2335/net23 CRC_OUT_5_10 VSS VSS nmos W=0.155u L=0.04u
M19433 U2335/net20 CRC_OUT_5_10 n1763 VDD pmos W=0.205u L=0.04u
M19434 U2335/net20 n1304 n1763 VDD pmos W=0.205u L=0.04u
M19435 VDD WX5699 U2335/net20 VDD pmos W=0.205u L=0.04u
M19436 VDD n1335 U2335/net20 VDD pmos W=0.205u L=0.04u
M19437 n1649 n1764 VSS VSS nmos W=0.135u L=0.04u
M19438 n1649 n1764 VDD VDD pmos W=0.205u L=0.04u
M19439 U2337/net28 U2337/net20 U2337/net64 VSS nmos W=0.155u L=0.04u
M19440 U2337/net24 U2337/net30 U2337/net32 VSS nmos W=0.155u L=0.04u
M19441 U2337/net28 U2337/net40 U2337/net24 VSS nmos W=0.155u L=0.04u
M19442 U2337/net40 WX7280 U2337/net108 VSS nmos W=0.155u L=0.04u
M19443 U2337/net40 U2337/net106 U2337/net104 VSS nmos W=0.155u L=0.04u
M19444 U2337/net24 WX7216 U2337/net050 VSS nmos W=0.155u L=0.04u
M19445 U2337/net050 U2337/net32 VSS VSS nmos W=0.155u L=0.04u
M19446 U2337/net20 U2337/net40 VSS VSS nmos W=0.155u L=0.04u
M19447 U2337/net106 WX7280 VSS VSS nmos W=0.155u L=0.04u
M19448 U2337/net104 WX7344 VSS VSS nmos W=0.155u L=0.04u
M19449 U2337/net30 WX7216 VSS VSS nmos W=0.155u L=0.04u
M19450 U2337/net108 U2337/net104 VSS VSS nmos W=0.155u L=0.04u
M19451 n1764 U2337/net28 VSS VSS nmos W=0.155u L=0.04u
M19452 U2337/net32 WX7152 VSS VSS nmos W=0.155u L=0.04u
M19453 U2337/net64 U2337/net24 VSS VSS nmos W=0.2u L=0.04u
M19454 U2337/net28 U2337/net40 U2337/net64 VDD pmos W=0.205u L=0.04u
M19455 U2337/net24 WX7216 U2337/net32 VDD pmos W=0.205u L=0.04u
M19456 U2337/net28 U2337/net20 U2337/net24 VDD pmos W=0.205u L=0.04u
M19457 U2337/net40 U2337/net106 U2337/net108 VDD pmos W=0.205u L=0.04u
M19458 U2337/net40 WX7280 U2337/net104 VDD pmos W=0.205u L=0.04u
M19459 U2337/net20 U2337/net40 VDD VDD pmos W=0.205u L=0.04u
M19460 U2337/net106 WX7280 VDD VDD pmos W=0.205u L=0.04u
M19461 U2337/net104 WX7344 VDD VDD pmos W=0.205u L=0.04u
M19462 U2337/net30 WX7216 VDD VDD pmos W=0.205u L=0.04u
M19463 U2337/net108 U2337/net104 VDD VDD pmos W=0.205u L=0.04u
M19464 n1764 U2337/net28 VDD VDD pmos W=0.205u L=0.04u
M19465 U2337/net32 WX7152 VDD VDD pmos W=0.205u L=0.04u
M19466 U2337/net64 U2337/net24 VDD VDD pmos W=0.28u L=0.04u
M19467 U2337/net24 U2337/net30 U2337/net045 VDD pmos W=0.205u L=0.04u
M19468 U2337/net045 U2337/net32 VDD VDD pmos W=0.205u L=0.04u
M19469 WX5490 n1275 U2338/net26 VSS nmos W=0.155u L=0.04u
M19470 WX5490 n1652 U2338/net26 VSS nmos W=0.155u L=0.04u
M19471 U2338/net29 n1766 VSS VSS nmos W=0.155u L=0.04u
M19472 U2338/net26 n1765 U2338/net29 VSS nmos W=0.155u L=0.04u
M19473 U2338/net26 n1247 U2338/net29 VSS nmos W=0.155u L=0.04u
M19474 WX5490 n1652 U2338/net43 VDD pmos W=0.205u L=0.04u
M19475 WX5490 n1247 U2338/net49 VDD pmos W=0.205u L=0.04u
M19476 U2338/net49 n1765 VDD VDD pmos W=0.205u L=0.04u
M19477 U2338/net43 n1275 VDD VDD pmos W=0.205u L=0.04u
M19478 WX5490 n1766 VDD VDD pmos W=0.205u L=0.04u
M19479 U2339/net29 n1335 VSS VSS nmos W=0.155u L=0.04u
M19480 n1766 WX5697 U2339/net29 VSS nmos W=0.155u L=0.04u
M19481 n1766 n1304 U2339/net23 VSS nmos W=0.155u L=0.04u
M19482 U2339/net23 CRC_OUT_5_11 VSS VSS nmos W=0.155u L=0.04u
M19483 U2339/net20 CRC_OUT_5_11 n1766 VDD pmos W=0.205u L=0.04u
M19484 U2339/net20 n1304 n1766 VDD pmos W=0.205u L=0.04u
M19485 VDD WX5697 U2339/net20 VDD pmos W=0.205u L=0.04u
M19486 VDD n1335 U2339/net20 VDD pmos W=0.205u L=0.04u
M19487 n1652 n1767 VSS VSS nmos W=0.135u L=0.04u
M19488 n1652 n1767 VDD VDD pmos W=0.205u L=0.04u
M19489 U2341/net28 U2341/net20 U2341/net64 VSS nmos W=0.155u L=0.04u
M19490 U2341/net24 U2341/net30 U2341/net32 VSS nmos W=0.155u L=0.04u
M19491 U2341/net28 U2341/net40 U2341/net24 VSS nmos W=0.155u L=0.04u
M19492 U2341/net40 WX7278 U2341/net108 VSS nmos W=0.155u L=0.04u
M19493 U2341/net40 U2341/net106 U2341/net104 VSS nmos W=0.155u L=0.04u
M19494 U2341/net24 WX7214 U2341/net050 VSS nmos W=0.155u L=0.04u
M19495 U2341/net050 U2341/net32 VSS VSS nmos W=0.155u L=0.04u
M19496 U2341/net20 U2341/net40 VSS VSS nmos W=0.155u L=0.04u
M19497 U2341/net106 WX7278 VSS VSS nmos W=0.155u L=0.04u
M19498 U2341/net104 WX7342 VSS VSS nmos W=0.155u L=0.04u
M19499 U2341/net30 WX7214 VSS VSS nmos W=0.155u L=0.04u
M19500 U2341/net108 U2341/net104 VSS VSS nmos W=0.155u L=0.04u
M19501 n1767 U2341/net28 VSS VSS nmos W=0.155u L=0.04u
M19502 U2341/net32 WX7150 VSS VSS nmos W=0.155u L=0.04u
M19503 U2341/net64 U2341/net24 VSS VSS nmos W=0.2u L=0.04u
M19504 U2341/net28 U2341/net40 U2341/net64 VDD pmos W=0.205u L=0.04u
M19505 U2341/net24 WX7214 U2341/net32 VDD pmos W=0.205u L=0.04u
M19506 U2341/net28 U2341/net20 U2341/net24 VDD pmos W=0.205u L=0.04u
M19507 U2341/net40 U2341/net106 U2341/net108 VDD pmos W=0.205u L=0.04u
M19508 U2341/net40 WX7278 U2341/net104 VDD pmos W=0.205u L=0.04u
M19509 U2341/net20 U2341/net40 VDD VDD pmos W=0.205u L=0.04u
M19510 U2341/net106 WX7278 VDD VDD pmos W=0.205u L=0.04u
M19511 U2341/net104 WX7342 VDD VDD pmos W=0.205u L=0.04u
M19512 U2341/net30 WX7214 VDD VDD pmos W=0.205u L=0.04u
M19513 U2341/net108 U2341/net104 VDD VDD pmos W=0.205u L=0.04u
M19514 n1767 U2341/net28 VDD VDD pmos W=0.205u L=0.04u
M19515 U2341/net32 WX7150 VDD VDD pmos W=0.205u L=0.04u
M19516 U2341/net64 U2341/net24 VDD VDD pmos W=0.28u L=0.04u
M19517 U2341/net24 U2341/net30 U2341/net045 VDD pmos W=0.205u L=0.04u
M19518 U2341/net045 U2341/net32 VDD VDD pmos W=0.205u L=0.04u
M19519 WX5476 n1275 U2342/net26 VSS nmos W=0.155u L=0.04u
M19520 WX5476 n1655 U2342/net26 VSS nmos W=0.155u L=0.04u
M19521 U2342/net29 n1769 VSS VSS nmos W=0.155u L=0.04u
M19522 U2342/net26 n1768 U2342/net29 VSS nmos W=0.155u L=0.04u
M19523 U2342/net26 n1247 U2342/net29 VSS nmos W=0.155u L=0.04u
M19524 WX5476 n1655 U2342/net43 VDD pmos W=0.205u L=0.04u
M19525 WX5476 n1247 U2342/net49 VDD pmos W=0.205u L=0.04u
M19526 U2342/net49 n1768 VDD VDD pmos W=0.205u L=0.04u
M19527 U2342/net43 n1275 VDD VDD pmos W=0.205u L=0.04u
M19528 WX5476 n1769 VDD VDD pmos W=0.205u L=0.04u
M19529 U2343/net29 n1335 VSS VSS nmos W=0.155u L=0.04u
M19530 n1769 WX5695 U2343/net29 VSS nmos W=0.155u L=0.04u
M19531 n1769 n1304 U2343/net23 VSS nmos W=0.155u L=0.04u
M19532 U2343/net23 CRC_OUT_5_12 VSS VSS nmos W=0.155u L=0.04u
M19533 U2343/net20 CRC_OUT_5_12 n1769 VDD pmos W=0.205u L=0.04u
M19534 U2343/net20 n1304 n1769 VDD pmos W=0.205u L=0.04u
M19535 VDD WX5695 U2343/net20 VDD pmos W=0.205u L=0.04u
M19536 VDD n1335 U2343/net20 VDD pmos W=0.205u L=0.04u
M19537 n1655 n1770 VSS VSS nmos W=0.135u L=0.04u
M19538 n1655 n1770 VDD VDD pmos W=0.205u L=0.04u
M19539 U2345/net28 U2345/net20 U2345/net64 VSS nmos W=0.155u L=0.04u
M19540 U2345/net24 U2345/net30 U2345/net32 VSS nmos W=0.155u L=0.04u
M19541 U2345/net28 U2345/net40 U2345/net24 VSS nmos W=0.155u L=0.04u
M19542 U2345/net40 WX7276 U2345/net108 VSS nmos W=0.155u L=0.04u
M19543 U2345/net40 U2345/net106 U2345/net104 VSS nmos W=0.155u L=0.04u
M19544 U2345/net24 WX7212 U2345/net050 VSS nmos W=0.155u L=0.04u
M19545 U2345/net050 U2345/net32 VSS VSS nmos W=0.155u L=0.04u
M19546 U2345/net20 U2345/net40 VSS VSS nmos W=0.155u L=0.04u
M19547 U2345/net106 WX7276 VSS VSS nmos W=0.155u L=0.04u
M19548 U2345/net104 WX7340 VSS VSS nmos W=0.155u L=0.04u
M19549 U2345/net30 WX7212 VSS VSS nmos W=0.155u L=0.04u
M19550 U2345/net108 U2345/net104 VSS VSS nmos W=0.155u L=0.04u
M19551 n1770 U2345/net28 VSS VSS nmos W=0.155u L=0.04u
M19552 U2345/net32 WX7148 VSS VSS nmos W=0.155u L=0.04u
M19553 U2345/net64 U2345/net24 VSS VSS nmos W=0.2u L=0.04u
M19554 U2345/net28 U2345/net40 U2345/net64 VDD pmos W=0.205u L=0.04u
M19555 U2345/net24 WX7212 U2345/net32 VDD pmos W=0.205u L=0.04u
M19556 U2345/net28 U2345/net20 U2345/net24 VDD pmos W=0.205u L=0.04u
M19557 U2345/net40 U2345/net106 U2345/net108 VDD pmos W=0.205u L=0.04u
M19558 U2345/net40 WX7276 U2345/net104 VDD pmos W=0.205u L=0.04u
M19559 U2345/net20 U2345/net40 VDD VDD pmos W=0.205u L=0.04u
M19560 U2345/net106 WX7276 VDD VDD pmos W=0.205u L=0.04u
M19561 U2345/net104 WX7340 VDD VDD pmos W=0.205u L=0.04u
M19562 U2345/net30 WX7212 VDD VDD pmos W=0.205u L=0.04u
M19563 U2345/net108 U2345/net104 VDD VDD pmos W=0.205u L=0.04u
M19564 n1770 U2345/net28 VDD VDD pmos W=0.205u L=0.04u
M19565 U2345/net32 WX7148 VDD VDD pmos W=0.205u L=0.04u
M19566 U2345/net64 U2345/net24 VDD VDD pmos W=0.28u L=0.04u
M19567 U2345/net24 U2345/net30 U2345/net045 VDD pmos W=0.205u L=0.04u
M19568 U2345/net045 U2345/net32 VDD VDD pmos W=0.205u L=0.04u
M19569 WX5462 n1275 U2346/net26 VSS nmos W=0.155u L=0.04u
M19570 WX5462 n1658 U2346/net26 VSS nmos W=0.155u L=0.04u
M19571 U2346/net29 n1772 VSS VSS nmos W=0.155u L=0.04u
M19572 U2346/net26 n1771 U2346/net29 VSS nmos W=0.155u L=0.04u
M19573 U2346/net26 n1247 U2346/net29 VSS nmos W=0.155u L=0.04u
M19574 WX5462 n1658 U2346/net43 VDD pmos W=0.205u L=0.04u
M19575 WX5462 n1247 U2346/net49 VDD pmos W=0.205u L=0.04u
M19576 U2346/net49 n1771 VDD VDD pmos W=0.205u L=0.04u
M19577 U2346/net43 n1275 VDD VDD pmos W=0.205u L=0.04u
M19578 WX5462 n1772 VDD VDD pmos W=0.205u L=0.04u
M19579 U2347/net29 n1335 VSS VSS nmos W=0.155u L=0.04u
M19580 n1772 WX5693 U2347/net29 VSS nmos W=0.155u L=0.04u
M19581 n1772 n1304 U2347/net23 VSS nmos W=0.155u L=0.04u
M19582 U2347/net23 CRC_OUT_5_13 VSS VSS nmos W=0.155u L=0.04u
M19583 U2347/net20 CRC_OUT_5_13 n1772 VDD pmos W=0.205u L=0.04u
M19584 U2347/net20 n1304 n1772 VDD pmos W=0.205u L=0.04u
M19585 VDD WX5693 U2347/net20 VDD pmos W=0.205u L=0.04u
M19586 VDD n1335 U2347/net20 VDD pmos W=0.205u L=0.04u
M19587 n1658 n1773 VSS VSS nmos W=0.135u L=0.04u
M19588 n1658 n1773 VDD VDD pmos W=0.205u L=0.04u
M19589 U2349/net28 U2349/net20 U2349/net64 VSS nmos W=0.155u L=0.04u
M19590 U2349/net24 U2349/net30 U2349/net32 VSS nmos W=0.155u L=0.04u
M19591 U2349/net28 U2349/net40 U2349/net24 VSS nmos W=0.155u L=0.04u
M19592 U2349/net40 WX7274 U2349/net108 VSS nmos W=0.155u L=0.04u
M19593 U2349/net40 U2349/net106 U2349/net104 VSS nmos W=0.155u L=0.04u
M19594 U2349/net24 WX7210 U2349/net050 VSS nmos W=0.155u L=0.04u
M19595 U2349/net050 U2349/net32 VSS VSS nmos W=0.155u L=0.04u
M19596 U2349/net20 U2349/net40 VSS VSS nmos W=0.155u L=0.04u
M19597 U2349/net106 WX7274 VSS VSS nmos W=0.155u L=0.04u
M19598 U2349/net104 WX7338 VSS VSS nmos W=0.155u L=0.04u
M19599 U2349/net30 WX7210 VSS VSS nmos W=0.155u L=0.04u
M19600 U2349/net108 U2349/net104 VSS VSS nmos W=0.155u L=0.04u
M19601 n1773 U2349/net28 VSS VSS nmos W=0.155u L=0.04u
M19602 U2349/net32 WX7146 VSS VSS nmos W=0.155u L=0.04u
M19603 U2349/net64 U2349/net24 VSS VSS nmos W=0.2u L=0.04u
M19604 U2349/net28 U2349/net40 U2349/net64 VDD pmos W=0.205u L=0.04u
M19605 U2349/net24 WX7210 U2349/net32 VDD pmos W=0.205u L=0.04u
M19606 U2349/net28 U2349/net20 U2349/net24 VDD pmos W=0.205u L=0.04u
M19607 U2349/net40 U2349/net106 U2349/net108 VDD pmos W=0.205u L=0.04u
M19608 U2349/net40 WX7274 U2349/net104 VDD pmos W=0.205u L=0.04u
M19609 U2349/net20 U2349/net40 VDD VDD pmos W=0.205u L=0.04u
M19610 U2349/net106 WX7274 VDD VDD pmos W=0.205u L=0.04u
M19611 U2349/net104 WX7338 VDD VDD pmos W=0.205u L=0.04u
M19612 U2349/net30 WX7210 VDD VDD pmos W=0.205u L=0.04u
M19613 U2349/net108 U2349/net104 VDD VDD pmos W=0.205u L=0.04u
M19614 n1773 U2349/net28 VDD VDD pmos W=0.205u L=0.04u
M19615 U2349/net32 WX7146 VDD VDD pmos W=0.205u L=0.04u
M19616 U2349/net64 U2349/net24 VDD VDD pmos W=0.28u L=0.04u
M19617 U2349/net24 U2349/net30 U2349/net045 VDD pmos W=0.205u L=0.04u
M19618 U2349/net045 U2349/net32 VDD VDD pmos W=0.205u L=0.04u
M19619 WX5448 n1275 U2350/net26 VSS nmos W=0.155u L=0.04u
M19620 WX5448 n1661 U2350/net26 VSS nmos W=0.155u L=0.04u
M19621 U2350/net29 n1775 VSS VSS nmos W=0.155u L=0.04u
M19622 U2350/net26 n1774 U2350/net29 VSS nmos W=0.155u L=0.04u
M19623 U2350/net26 n1247 U2350/net29 VSS nmos W=0.155u L=0.04u
M19624 WX5448 n1661 U2350/net43 VDD pmos W=0.205u L=0.04u
M19625 WX5448 n1247 U2350/net49 VDD pmos W=0.205u L=0.04u
M19626 U2350/net49 n1774 VDD VDD pmos W=0.205u L=0.04u
M19627 U2350/net43 n1275 VDD VDD pmos W=0.205u L=0.04u
M19628 WX5448 n1775 VDD VDD pmos W=0.205u L=0.04u
M19629 U2351/net29 n1335 VSS VSS nmos W=0.155u L=0.04u
M19630 n1775 WX5691 U2351/net29 VSS nmos W=0.155u L=0.04u
M19631 n1775 n1304 U2351/net23 VSS nmos W=0.155u L=0.04u
M19632 U2351/net23 CRC_OUT_5_14 VSS VSS nmos W=0.155u L=0.04u
M19633 U2351/net20 CRC_OUT_5_14 n1775 VDD pmos W=0.205u L=0.04u
M19634 U2351/net20 n1304 n1775 VDD pmos W=0.205u L=0.04u
M19635 VDD WX5691 U2351/net20 VDD pmos W=0.205u L=0.04u
M19636 VDD n1335 U2351/net20 VDD pmos W=0.205u L=0.04u
M19637 n1661 n1776 VSS VSS nmos W=0.135u L=0.04u
M19638 n1661 n1776 VDD VDD pmos W=0.205u L=0.04u
M19639 U2353/net28 U2353/net20 U2353/net64 VSS nmos W=0.155u L=0.04u
M19640 U2353/net24 U2353/net30 U2353/net32 VSS nmos W=0.155u L=0.04u
M19641 U2353/net28 U2353/net40 U2353/net24 VSS nmos W=0.155u L=0.04u
M19642 U2353/net40 WX7272 U2353/net108 VSS nmos W=0.155u L=0.04u
M19643 U2353/net40 U2353/net106 U2353/net104 VSS nmos W=0.155u L=0.04u
M19644 U2353/net24 WX7208 U2353/net050 VSS nmos W=0.155u L=0.04u
M19645 U2353/net050 U2353/net32 VSS VSS nmos W=0.155u L=0.04u
M19646 U2353/net20 U2353/net40 VSS VSS nmos W=0.155u L=0.04u
M19647 U2353/net106 WX7272 VSS VSS nmos W=0.155u L=0.04u
M19648 U2353/net104 WX7336 VSS VSS nmos W=0.155u L=0.04u
M19649 U2353/net30 WX7208 VSS VSS nmos W=0.155u L=0.04u
M19650 U2353/net108 U2353/net104 VSS VSS nmos W=0.155u L=0.04u
M19651 n1776 U2353/net28 VSS VSS nmos W=0.155u L=0.04u
M19652 U2353/net32 WX7144 VSS VSS nmos W=0.155u L=0.04u
M19653 U2353/net64 U2353/net24 VSS VSS nmos W=0.2u L=0.04u
M19654 U2353/net28 U2353/net40 U2353/net64 VDD pmos W=0.205u L=0.04u
M19655 U2353/net24 WX7208 U2353/net32 VDD pmos W=0.205u L=0.04u
M19656 U2353/net28 U2353/net20 U2353/net24 VDD pmos W=0.205u L=0.04u
M19657 U2353/net40 U2353/net106 U2353/net108 VDD pmos W=0.205u L=0.04u
M19658 U2353/net40 WX7272 U2353/net104 VDD pmos W=0.205u L=0.04u
M19659 U2353/net20 U2353/net40 VDD VDD pmos W=0.205u L=0.04u
M19660 U2353/net106 WX7272 VDD VDD pmos W=0.205u L=0.04u
M19661 U2353/net104 WX7336 VDD VDD pmos W=0.205u L=0.04u
M19662 U2353/net30 WX7208 VDD VDD pmos W=0.205u L=0.04u
M19663 U2353/net108 U2353/net104 VDD VDD pmos W=0.205u L=0.04u
M19664 n1776 U2353/net28 VDD VDD pmos W=0.205u L=0.04u
M19665 U2353/net32 WX7144 VDD VDD pmos W=0.205u L=0.04u
M19666 U2353/net64 U2353/net24 VDD VDD pmos W=0.28u L=0.04u
M19667 U2353/net24 U2353/net30 U2353/net045 VDD pmos W=0.205u L=0.04u
M19668 U2353/net045 U2353/net32 VDD VDD pmos W=0.205u L=0.04u
M19669 WX5434 n1275 U2354/net26 VSS nmos W=0.155u L=0.04u
M19670 WX5434 n1664 U2354/net26 VSS nmos W=0.155u L=0.04u
M19671 U2354/net29 n1778 VSS VSS nmos W=0.155u L=0.04u
M19672 U2354/net26 n1777 U2354/net29 VSS nmos W=0.155u L=0.04u
M19673 U2354/net26 n1246 U2354/net29 VSS nmos W=0.155u L=0.04u
M19674 WX5434 n1664 U2354/net43 VDD pmos W=0.205u L=0.04u
M19675 WX5434 n1246 U2354/net49 VDD pmos W=0.205u L=0.04u
M19676 U2354/net49 n1777 VDD VDD pmos W=0.205u L=0.04u
M19677 U2354/net43 n1275 VDD VDD pmos W=0.205u L=0.04u
M19678 WX5434 n1778 VDD VDD pmos W=0.205u L=0.04u
M19679 U2355/net29 n1335 VSS VSS nmos W=0.155u L=0.04u
M19680 n1778 WX5689 U2355/net29 VSS nmos W=0.155u L=0.04u
M19681 n1778 n1304 U2355/net23 VSS nmos W=0.155u L=0.04u
M19682 U2355/net23 CRC_OUT_5_15 VSS VSS nmos W=0.155u L=0.04u
M19683 U2355/net20 CRC_OUT_5_15 n1778 VDD pmos W=0.205u L=0.04u
M19684 U2355/net20 n1304 n1778 VDD pmos W=0.205u L=0.04u
M19685 VDD WX5689 U2355/net20 VDD pmos W=0.205u L=0.04u
M19686 VDD n1335 U2355/net20 VDD pmos W=0.205u L=0.04u
M19687 n1664 n1779 VSS VSS nmos W=0.135u L=0.04u
M19688 n1664 n1779 VDD VDD pmos W=0.205u L=0.04u
M19689 U2357/net28 U2357/net20 U2357/net64 VSS nmos W=0.155u L=0.04u
M19690 U2357/net24 U2357/net30 U2357/net32 VSS nmos W=0.155u L=0.04u
M19691 U2357/net28 U2357/net40 U2357/net24 VSS nmos W=0.155u L=0.04u
M19692 U2357/net40 WX7270 U2357/net108 VSS nmos W=0.155u L=0.04u
M19693 U2357/net40 U2357/net106 U2357/net104 VSS nmos W=0.155u L=0.04u
M19694 U2357/net24 WX7206 U2357/net050 VSS nmos W=0.155u L=0.04u
M19695 U2357/net050 U2357/net32 VSS VSS nmos W=0.155u L=0.04u
M19696 U2357/net20 U2357/net40 VSS VSS nmos W=0.155u L=0.04u
M19697 U2357/net106 WX7270 VSS VSS nmos W=0.155u L=0.04u
M19698 U2357/net104 WX7334 VSS VSS nmos W=0.155u L=0.04u
M19699 U2357/net30 WX7206 VSS VSS nmos W=0.155u L=0.04u
M19700 U2357/net108 U2357/net104 VSS VSS nmos W=0.155u L=0.04u
M19701 n1779 U2357/net28 VSS VSS nmos W=0.155u L=0.04u
M19702 U2357/net32 WX7142 VSS VSS nmos W=0.155u L=0.04u
M19703 U2357/net64 U2357/net24 VSS VSS nmos W=0.2u L=0.04u
M19704 U2357/net28 U2357/net40 U2357/net64 VDD pmos W=0.205u L=0.04u
M19705 U2357/net24 WX7206 U2357/net32 VDD pmos W=0.205u L=0.04u
M19706 U2357/net28 U2357/net20 U2357/net24 VDD pmos W=0.205u L=0.04u
M19707 U2357/net40 U2357/net106 U2357/net108 VDD pmos W=0.205u L=0.04u
M19708 U2357/net40 WX7270 U2357/net104 VDD pmos W=0.205u L=0.04u
M19709 U2357/net20 U2357/net40 VDD VDD pmos W=0.205u L=0.04u
M19710 U2357/net106 WX7270 VDD VDD pmos W=0.205u L=0.04u
M19711 U2357/net104 WX7334 VDD VDD pmos W=0.205u L=0.04u
M19712 U2357/net30 WX7206 VDD VDD pmos W=0.205u L=0.04u
M19713 U2357/net108 U2357/net104 VDD VDD pmos W=0.205u L=0.04u
M19714 n1779 U2357/net28 VDD VDD pmos W=0.205u L=0.04u
M19715 U2357/net32 WX7142 VDD VDD pmos W=0.205u L=0.04u
M19716 U2357/net64 U2357/net24 VDD VDD pmos W=0.28u L=0.04u
M19717 U2357/net24 U2357/net30 U2357/net045 VDD pmos W=0.205u L=0.04u
M19718 U2357/net045 U2357/net32 VDD VDD pmos W=0.205u L=0.04u
M19719 WX5420 n1275 U2358/net26 VSS nmos W=0.155u L=0.04u
M19720 WX5420 n1667 U2358/net26 VSS nmos W=0.155u L=0.04u
M19721 U2358/net29 n1781 VSS VSS nmos W=0.155u L=0.04u
M19722 U2358/net26 n1780 U2358/net29 VSS nmos W=0.155u L=0.04u
M19723 U2358/net26 n1261 U2358/net29 VSS nmos W=0.155u L=0.04u
M19724 WX5420 n1667 U2358/net43 VDD pmos W=0.205u L=0.04u
M19725 WX5420 n1261 U2358/net49 VDD pmos W=0.205u L=0.04u
M19726 U2358/net49 n1780 VDD VDD pmos W=0.205u L=0.04u
M19727 U2358/net43 n1275 VDD VDD pmos W=0.205u L=0.04u
M19728 WX5420 n1781 VDD VDD pmos W=0.205u L=0.04u
M19729 U2359/net29 n1335 VSS VSS nmos W=0.155u L=0.04u
M19730 n1781 WX5687 U2359/net29 VSS nmos W=0.155u L=0.04u
M19731 n1781 n1304 U2359/net23 VSS nmos W=0.155u L=0.04u
M19732 U2359/net23 CRC_OUT_5_16 VSS VSS nmos W=0.155u L=0.04u
M19733 U2359/net20 CRC_OUT_5_16 n1781 VDD pmos W=0.205u L=0.04u
M19734 U2359/net20 n1304 n1781 VDD pmos W=0.205u L=0.04u
M19735 VDD WX5687 U2359/net20 VDD pmos W=0.205u L=0.04u
M19736 VDD n1335 U2359/net20 VDD pmos W=0.205u L=0.04u
M19737 n1667 n1782 VSS VSS nmos W=0.135u L=0.04u
M19738 n1667 n1782 VDD VDD pmos W=0.205u L=0.04u
M19739 U2361/net28 U2361/net20 U2361/net64 VSS nmos W=0.155u L=0.04u
M19740 U2361/net24 U2361/net30 U2361/net32 VSS nmos W=0.155u L=0.04u
M19741 U2361/net28 U2361/net40 U2361/net24 VSS nmos W=0.155u L=0.04u
M19742 U2361/net40 n1783 U2361/net108 VSS nmos W=0.155u L=0.04u
M19743 U2361/net40 U2361/net106 U2361/net104 VSS nmos W=0.155u L=0.04u
M19744 U2361/net24 WX7268 U2361/net050 VSS nmos W=0.155u L=0.04u
M19745 U2361/net050 U2361/net32 VSS VSS nmos W=0.155u L=0.04u
M19746 U2361/net20 U2361/net40 VSS VSS nmos W=0.155u L=0.04u
M19747 U2361/net106 n1783 VSS VSS nmos W=0.155u L=0.04u
M19748 U2361/net104 WX7332 VSS VSS nmos W=0.155u L=0.04u
M19749 U2361/net30 WX7268 VSS VSS nmos W=0.155u L=0.04u
M19750 U2361/net108 U2361/net104 VSS VSS nmos W=0.155u L=0.04u
M19751 n1782 U2361/net28 VSS VSS nmos W=0.155u L=0.04u
M19752 U2361/net32 WX7204 VSS VSS nmos W=0.155u L=0.04u
M19753 U2361/net64 U2361/net24 VSS VSS nmos W=0.2u L=0.04u
M19754 U2361/net28 U2361/net40 U2361/net64 VDD pmos W=0.205u L=0.04u
M19755 U2361/net24 WX7268 U2361/net32 VDD pmos W=0.205u L=0.04u
M19756 U2361/net28 U2361/net20 U2361/net24 VDD pmos W=0.205u L=0.04u
M19757 U2361/net40 U2361/net106 U2361/net108 VDD pmos W=0.205u L=0.04u
M19758 U2361/net40 n1783 U2361/net104 VDD pmos W=0.205u L=0.04u
M19759 U2361/net20 U2361/net40 VDD VDD pmos W=0.205u L=0.04u
M19760 U2361/net106 n1783 VDD VDD pmos W=0.205u L=0.04u
M19761 U2361/net104 WX7332 VDD VDD pmos W=0.205u L=0.04u
M19762 U2361/net30 WX7268 VDD VDD pmos W=0.205u L=0.04u
M19763 U2361/net108 U2361/net104 VDD VDD pmos W=0.205u L=0.04u
M19764 n1782 U2361/net28 VDD VDD pmos W=0.205u L=0.04u
M19765 U2361/net32 WX7204 VDD VDD pmos W=0.205u L=0.04u
M19766 U2361/net64 U2361/net24 VDD VDD pmos W=0.28u L=0.04u
M19767 U2361/net24 U2361/net30 U2361/net045 VDD pmos W=0.205u L=0.04u
M19768 U2361/net045 U2361/net32 VDD VDD pmos W=0.205u L=0.04u
M19769 U2362/net4 WX7140 U2362/net14 VSS nmos W=0.155u L=0.04u
M19770 U2362/net6 U2362/net10 U2362/net14 VSS nmos W=0.17u L=0.04u
M19771 U2362/net4 n1370 VSS VSS nmos W=0.155u L=0.04u
M19772 U2362/net6 U2362/net4 VSS VSS nmos W=0.17u L=0.04u
M19773 n1783 U2362/net14 VSS VSS nmos W=0.155u L=0.04u
M19774 U2362/net10 WX7140 VSS VSS nmos W=0.155u L=0.04u
M19775 U2362/net4 U2362/net10 U2362/net14 VDD pmos W=0.255u L=0.04u
M19776 U2362/net6 WX7140 U2362/net14 VDD pmos W=0.28u L=0.04u
M19777 U2362/net4 n1370 VDD VDD pmos W=0.205u L=0.04u
M19778 U2362/net6 U2362/net4 VDD VDD pmos W=0.24u L=0.04u
M19779 n1783 U2362/net14 VDD VDD pmos W=0.205u L=0.04u
M19780 U2362/net10 WX7140 VDD VDD pmos W=0.205u L=0.04u
M19781 WX5406 n1275 U2363/net26 VSS nmos W=0.155u L=0.04u
M19782 WX5406 n1671 U2363/net26 VSS nmos W=0.155u L=0.04u
M19783 U2363/net29 n1785 VSS VSS nmos W=0.155u L=0.04u
M19784 U2363/net26 n1784 U2363/net29 VSS nmos W=0.155u L=0.04u
M19785 U2363/net26 n1261 U2363/net29 VSS nmos W=0.155u L=0.04u
M19786 WX5406 n1671 U2363/net43 VDD pmos W=0.205u L=0.04u
M19787 WX5406 n1261 U2363/net49 VDD pmos W=0.205u L=0.04u
M19788 U2363/net49 n1784 VDD VDD pmos W=0.205u L=0.04u
M19789 U2363/net43 n1275 VDD VDD pmos W=0.205u L=0.04u
M19790 WX5406 n1785 VDD VDD pmos W=0.205u L=0.04u
M19791 U2364/net29 n1335 VSS VSS nmos W=0.155u L=0.04u
M19792 n1785 WX5685 U2364/net29 VSS nmos W=0.155u L=0.04u
M19793 n1785 n1304 U2364/net23 VSS nmos W=0.155u L=0.04u
M19794 U2364/net23 CRC_OUT_5_17 VSS VSS nmos W=0.155u L=0.04u
M19795 U2364/net20 CRC_OUT_5_17 n1785 VDD pmos W=0.205u L=0.04u
M19796 U2364/net20 n1304 n1785 VDD pmos W=0.205u L=0.04u
M19797 VDD WX5685 U2364/net20 VDD pmos W=0.205u L=0.04u
M19798 VDD n1335 U2364/net20 VDD pmos W=0.205u L=0.04u
M19799 n1671 n1786 VSS VSS nmos W=0.135u L=0.04u
M19800 n1671 n1786 VDD VDD pmos W=0.205u L=0.04u
M19801 U2366/net28 U2366/net20 U2366/net64 VSS nmos W=0.155u L=0.04u
M19802 U2366/net24 U2366/net30 U2366/net32 VSS nmos W=0.155u L=0.04u
M19803 U2366/net28 U2366/net40 U2366/net24 VSS nmos W=0.155u L=0.04u
M19804 U2366/net40 n1787 U2366/net108 VSS nmos W=0.155u L=0.04u
M19805 U2366/net40 U2366/net106 U2366/net104 VSS nmos W=0.155u L=0.04u
M19806 U2366/net24 WX7266 U2366/net050 VSS nmos W=0.155u L=0.04u
M19807 U2366/net050 U2366/net32 VSS VSS nmos W=0.155u L=0.04u
M19808 U2366/net20 U2366/net40 VSS VSS nmos W=0.155u L=0.04u
M19809 U2366/net106 n1787 VSS VSS nmos W=0.155u L=0.04u
M19810 U2366/net104 WX7330 VSS VSS nmos W=0.155u L=0.04u
M19811 U2366/net30 WX7266 VSS VSS nmos W=0.155u L=0.04u
M19812 U2366/net108 U2366/net104 VSS VSS nmos W=0.155u L=0.04u
M19813 n1786 U2366/net28 VSS VSS nmos W=0.155u L=0.04u
M19814 U2366/net32 WX7202 VSS VSS nmos W=0.155u L=0.04u
M19815 U2366/net64 U2366/net24 VSS VSS nmos W=0.2u L=0.04u
M19816 U2366/net28 U2366/net40 U2366/net64 VDD pmos W=0.205u L=0.04u
M19817 U2366/net24 WX7266 U2366/net32 VDD pmos W=0.205u L=0.04u
M19818 U2366/net28 U2366/net20 U2366/net24 VDD pmos W=0.205u L=0.04u
M19819 U2366/net40 U2366/net106 U2366/net108 VDD pmos W=0.205u L=0.04u
M19820 U2366/net40 n1787 U2366/net104 VDD pmos W=0.205u L=0.04u
M19821 U2366/net20 U2366/net40 VDD VDD pmos W=0.205u L=0.04u
M19822 U2366/net106 n1787 VDD VDD pmos W=0.205u L=0.04u
M19823 U2366/net104 WX7330 VDD VDD pmos W=0.205u L=0.04u
M19824 U2366/net30 WX7266 VDD VDD pmos W=0.205u L=0.04u
M19825 U2366/net108 U2366/net104 VDD VDD pmos W=0.205u L=0.04u
M19826 n1786 U2366/net28 VDD VDD pmos W=0.205u L=0.04u
M19827 U2366/net32 WX7202 VDD VDD pmos W=0.205u L=0.04u
M19828 U2366/net64 U2366/net24 VDD VDD pmos W=0.28u L=0.04u
M19829 U2366/net24 U2366/net30 U2366/net045 VDD pmos W=0.205u L=0.04u
M19830 U2366/net045 U2366/net32 VDD VDD pmos W=0.205u L=0.04u
M19831 U2367/net4 WX7138 U2367/net14 VSS nmos W=0.155u L=0.04u
M19832 U2367/net6 U2367/net10 U2367/net14 VSS nmos W=0.17u L=0.04u
M19833 U2367/net4 n1370 VSS VSS nmos W=0.155u L=0.04u
M19834 U2367/net6 U2367/net4 VSS VSS nmos W=0.17u L=0.04u
M19835 n1787 U2367/net14 VSS VSS nmos W=0.155u L=0.04u
M19836 U2367/net10 WX7138 VSS VSS nmos W=0.155u L=0.04u
M19837 U2367/net4 U2367/net10 U2367/net14 VDD pmos W=0.255u L=0.04u
M19838 U2367/net6 WX7138 U2367/net14 VDD pmos W=0.28u L=0.04u
M19839 U2367/net4 n1370 VDD VDD pmos W=0.205u L=0.04u
M19840 U2367/net6 U2367/net4 VDD VDD pmos W=0.24u L=0.04u
M19841 n1787 U2367/net14 VDD VDD pmos W=0.205u L=0.04u
M19842 U2367/net10 WX7138 VDD VDD pmos W=0.205u L=0.04u
M19843 WX5392 n1274 U2368/net26 VSS nmos W=0.155u L=0.04u
M19844 WX5392 n1675 U2368/net26 VSS nmos W=0.155u L=0.04u
M19845 U2368/net29 n1789 VSS VSS nmos W=0.155u L=0.04u
M19846 U2368/net26 n1788 U2368/net29 VSS nmos W=0.155u L=0.04u
M19847 U2368/net26 n1261 U2368/net29 VSS nmos W=0.155u L=0.04u
M19848 WX5392 n1675 U2368/net43 VDD pmos W=0.205u L=0.04u
M19849 WX5392 n1261 U2368/net49 VDD pmos W=0.205u L=0.04u
M19850 U2368/net49 n1788 VDD VDD pmos W=0.205u L=0.04u
M19851 U2368/net43 n1274 VDD VDD pmos W=0.205u L=0.04u
M19852 WX5392 n1789 VDD VDD pmos W=0.205u L=0.04u
M19853 U2369/net29 n1334 VSS VSS nmos W=0.155u L=0.04u
M19854 n1789 WX5683 U2369/net29 VSS nmos W=0.155u L=0.04u
M19855 n1789 n1304 U2369/net23 VSS nmos W=0.155u L=0.04u
M19856 U2369/net23 CRC_OUT_5_18 VSS VSS nmos W=0.155u L=0.04u
M19857 U2369/net20 CRC_OUT_5_18 n1789 VDD pmos W=0.205u L=0.04u
M19858 U2369/net20 n1304 n1789 VDD pmos W=0.205u L=0.04u
M19859 VDD WX5683 U2369/net20 VDD pmos W=0.205u L=0.04u
M19860 VDD n1334 U2369/net20 VDD pmos W=0.205u L=0.04u
M19861 n1675 n1790 VSS VSS nmos W=0.135u L=0.04u
M19862 n1675 n1790 VDD VDD pmos W=0.205u L=0.04u
M19863 U2371/net28 U2371/net20 U2371/net64 VSS nmos W=0.155u L=0.04u
M19864 U2371/net24 U2371/net30 U2371/net32 VSS nmos W=0.155u L=0.04u
M19865 U2371/net28 U2371/net40 U2371/net24 VSS nmos W=0.155u L=0.04u
M19866 U2371/net40 n1791 U2371/net108 VSS nmos W=0.155u L=0.04u
M19867 U2371/net40 U2371/net106 U2371/net104 VSS nmos W=0.155u L=0.04u
M19868 U2371/net24 WX7264 U2371/net050 VSS nmos W=0.155u L=0.04u
M19869 U2371/net050 U2371/net32 VSS VSS nmos W=0.155u L=0.04u
M19870 U2371/net20 U2371/net40 VSS VSS nmos W=0.155u L=0.04u
M19871 U2371/net106 n1791 VSS VSS nmos W=0.155u L=0.04u
M19872 U2371/net104 WX7328 VSS VSS nmos W=0.155u L=0.04u
M19873 U2371/net30 WX7264 VSS VSS nmos W=0.155u L=0.04u
M19874 U2371/net108 U2371/net104 VSS VSS nmos W=0.155u L=0.04u
M19875 n1790 U2371/net28 VSS VSS nmos W=0.155u L=0.04u
M19876 U2371/net32 WX7200 VSS VSS nmos W=0.155u L=0.04u
M19877 U2371/net64 U2371/net24 VSS VSS nmos W=0.2u L=0.04u
M19878 U2371/net28 U2371/net40 U2371/net64 VDD pmos W=0.205u L=0.04u
M19879 U2371/net24 WX7264 U2371/net32 VDD pmos W=0.205u L=0.04u
M19880 U2371/net28 U2371/net20 U2371/net24 VDD pmos W=0.205u L=0.04u
M19881 U2371/net40 U2371/net106 U2371/net108 VDD pmos W=0.205u L=0.04u
M19882 U2371/net40 n1791 U2371/net104 VDD pmos W=0.205u L=0.04u
M19883 U2371/net20 U2371/net40 VDD VDD pmos W=0.205u L=0.04u
M19884 U2371/net106 n1791 VDD VDD pmos W=0.205u L=0.04u
M19885 U2371/net104 WX7328 VDD VDD pmos W=0.205u L=0.04u
M19886 U2371/net30 WX7264 VDD VDD pmos W=0.205u L=0.04u
M19887 U2371/net108 U2371/net104 VDD VDD pmos W=0.205u L=0.04u
M19888 n1790 U2371/net28 VDD VDD pmos W=0.205u L=0.04u
M19889 U2371/net32 WX7200 VDD VDD pmos W=0.205u L=0.04u
M19890 U2371/net64 U2371/net24 VDD VDD pmos W=0.28u L=0.04u
M19891 U2371/net24 U2371/net30 U2371/net045 VDD pmos W=0.205u L=0.04u
M19892 U2371/net045 U2371/net32 VDD VDD pmos W=0.205u L=0.04u
M19893 U2372/net4 WX7136 U2372/net14 VSS nmos W=0.155u L=0.04u
M19894 U2372/net6 U2372/net10 U2372/net14 VSS nmos W=0.17u L=0.04u
M19895 U2372/net4 n1370 VSS VSS nmos W=0.155u L=0.04u
M19896 U2372/net6 U2372/net4 VSS VSS nmos W=0.17u L=0.04u
M19897 n1791 U2372/net14 VSS VSS nmos W=0.155u L=0.04u
M19898 U2372/net10 WX7136 VSS VSS nmos W=0.155u L=0.04u
M19899 U2372/net4 U2372/net10 U2372/net14 VDD pmos W=0.255u L=0.04u
M19900 U2372/net6 WX7136 U2372/net14 VDD pmos W=0.28u L=0.04u
M19901 U2372/net4 n1370 VDD VDD pmos W=0.205u L=0.04u
M19902 U2372/net6 U2372/net4 VDD VDD pmos W=0.24u L=0.04u
M19903 n1791 U2372/net14 VDD VDD pmos W=0.205u L=0.04u
M19904 U2372/net10 WX7136 VDD VDD pmos W=0.205u L=0.04u
M19905 WX5378 n1274 U2373/net26 VSS nmos W=0.155u L=0.04u
M19906 WX5378 n1679 U2373/net26 VSS nmos W=0.155u L=0.04u
M19907 U2373/net29 n1793 VSS VSS nmos W=0.155u L=0.04u
M19908 U2373/net26 n1792 U2373/net29 VSS nmos W=0.155u L=0.04u
M19909 U2373/net26 n1261 U2373/net29 VSS nmos W=0.155u L=0.04u
M19910 WX5378 n1679 U2373/net43 VDD pmos W=0.205u L=0.04u
M19911 WX5378 n1261 U2373/net49 VDD pmos W=0.205u L=0.04u
M19912 U2373/net49 n1792 VDD VDD pmos W=0.205u L=0.04u
M19913 U2373/net43 n1274 VDD VDD pmos W=0.205u L=0.04u
M19914 WX5378 n1793 VDD VDD pmos W=0.205u L=0.04u
M19915 U2374/net29 n1334 VSS VSS nmos W=0.155u L=0.04u
M19916 n1793 WX5681 U2374/net29 VSS nmos W=0.155u L=0.04u
M19917 n1793 n1303 U2374/net23 VSS nmos W=0.155u L=0.04u
M19918 U2374/net23 CRC_OUT_5_19 VSS VSS nmos W=0.155u L=0.04u
M19919 U2374/net20 CRC_OUT_5_19 n1793 VDD pmos W=0.205u L=0.04u
M19920 U2374/net20 n1303 n1793 VDD pmos W=0.205u L=0.04u
M19921 VDD WX5681 U2374/net20 VDD pmos W=0.205u L=0.04u
M19922 VDD n1334 U2374/net20 VDD pmos W=0.205u L=0.04u
M19923 n1679 n1794 VSS VSS nmos W=0.135u L=0.04u
M19924 n1679 n1794 VDD VDD pmos W=0.205u L=0.04u
M19925 U2376/net28 U2376/net20 U2376/net64 VSS nmos W=0.155u L=0.04u
M19926 U2376/net24 U2376/net30 U2376/net32 VSS nmos W=0.155u L=0.04u
M19927 U2376/net28 U2376/net40 U2376/net24 VSS nmos W=0.155u L=0.04u
M19928 U2376/net40 n1795 U2376/net108 VSS nmos W=0.155u L=0.04u
M19929 U2376/net40 U2376/net106 U2376/net104 VSS nmos W=0.155u L=0.04u
M19930 U2376/net24 WX7262 U2376/net050 VSS nmos W=0.155u L=0.04u
M19931 U2376/net050 U2376/net32 VSS VSS nmos W=0.155u L=0.04u
M19932 U2376/net20 U2376/net40 VSS VSS nmos W=0.155u L=0.04u
M19933 U2376/net106 n1795 VSS VSS nmos W=0.155u L=0.04u
M19934 U2376/net104 WX7326 VSS VSS nmos W=0.155u L=0.04u
M19935 U2376/net30 WX7262 VSS VSS nmos W=0.155u L=0.04u
M19936 U2376/net108 U2376/net104 VSS VSS nmos W=0.155u L=0.04u
M19937 n1794 U2376/net28 VSS VSS nmos W=0.155u L=0.04u
M19938 U2376/net32 WX7198 VSS VSS nmos W=0.155u L=0.04u
M19939 U2376/net64 U2376/net24 VSS VSS nmos W=0.2u L=0.04u
M19940 U2376/net28 U2376/net40 U2376/net64 VDD pmos W=0.205u L=0.04u
M19941 U2376/net24 WX7262 U2376/net32 VDD pmos W=0.205u L=0.04u
M19942 U2376/net28 U2376/net20 U2376/net24 VDD pmos W=0.205u L=0.04u
M19943 U2376/net40 U2376/net106 U2376/net108 VDD pmos W=0.205u L=0.04u
M19944 U2376/net40 n1795 U2376/net104 VDD pmos W=0.205u L=0.04u
M19945 U2376/net20 U2376/net40 VDD VDD pmos W=0.205u L=0.04u
M19946 U2376/net106 n1795 VDD VDD pmos W=0.205u L=0.04u
M19947 U2376/net104 WX7326 VDD VDD pmos W=0.205u L=0.04u
M19948 U2376/net30 WX7262 VDD VDD pmos W=0.205u L=0.04u
M19949 U2376/net108 U2376/net104 VDD VDD pmos W=0.205u L=0.04u
M19950 n1794 U2376/net28 VDD VDD pmos W=0.205u L=0.04u
M19951 U2376/net32 WX7198 VDD VDD pmos W=0.205u L=0.04u
M19952 U2376/net64 U2376/net24 VDD VDD pmos W=0.28u L=0.04u
M19953 U2376/net24 U2376/net30 U2376/net045 VDD pmos W=0.205u L=0.04u
M19954 U2376/net045 U2376/net32 VDD VDD pmos W=0.205u L=0.04u
M19955 U2377/net4 WX7134 U2377/net14 VSS nmos W=0.155u L=0.04u
M19956 U2377/net6 U2377/net10 U2377/net14 VSS nmos W=0.17u L=0.04u
M19957 U2377/net4 n1370 VSS VSS nmos W=0.155u L=0.04u
M19958 U2377/net6 U2377/net4 VSS VSS nmos W=0.17u L=0.04u
M19959 n1795 U2377/net14 VSS VSS nmos W=0.155u L=0.04u
M19960 U2377/net10 WX7134 VSS VSS nmos W=0.155u L=0.04u
M19961 U2377/net4 U2377/net10 U2377/net14 VDD pmos W=0.255u L=0.04u
M19962 U2377/net6 WX7134 U2377/net14 VDD pmos W=0.28u L=0.04u
M19963 U2377/net4 n1370 VDD VDD pmos W=0.205u L=0.04u
M19964 U2377/net6 U2377/net4 VDD VDD pmos W=0.24u L=0.04u
M19965 n1795 U2377/net14 VDD VDD pmos W=0.205u L=0.04u
M19966 U2377/net10 WX7134 VDD VDD pmos W=0.205u L=0.04u
M19967 WX5364 n1274 U2378/net26 VSS nmos W=0.155u L=0.04u
M19968 WX5364 n1683 U2378/net26 VSS nmos W=0.155u L=0.04u
M19969 U2378/net29 n1797 VSS VSS nmos W=0.155u L=0.04u
M19970 U2378/net26 n1796 U2378/net29 VSS nmos W=0.155u L=0.04u
M19971 U2378/net26 n1260 U2378/net29 VSS nmos W=0.155u L=0.04u
M19972 WX5364 n1683 U2378/net43 VDD pmos W=0.205u L=0.04u
M19973 WX5364 n1260 U2378/net49 VDD pmos W=0.205u L=0.04u
M19974 U2378/net49 n1796 VDD VDD pmos W=0.205u L=0.04u
M19975 U2378/net43 n1274 VDD VDD pmos W=0.205u L=0.04u
M19976 WX5364 n1797 VDD VDD pmos W=0.205u L=0.04u
M19977 U2379/net29 n1334 VSS VSS nmos W=0.155u L=0.04u
M19978 n1797 WX5679 U2379/net29 VSS nmos W=0.155u L=0.04u
M19979 n1797 n1304 U2379/net23 VSS nmos W=0.155u L=0.04u
M19980 U2379/net23 CRC_OUT_5_20 VSS VSS nmos W=0.155u L=0.04u
M19981 U2379/net20 CRC_OUT_5_20 n1797 VDD pmos W=0.205u L=0.04u
M19982 U2379/net20 n1304 n1797 VDD pmos W=0.205u L=0.04u
M19983 VDD WX5679 U2379/net20 VDD pmos W=0.205u L=0.04u
M19984 VDD n1334 U2379/net20 VDD pmos W=0.205u L=0.04u
M19985 n1683 n1798 VSS VSS nmos W=0.135u L=0.04u
M19986 n1683 n1798 VDD VDD pmos W=0.205u L=0.04u
M19987 U2381/net28 U2381/net20 U2381/net64 VSS nmos W=0.155u L=0.04u
M19988 U2381/net24 U2381/net30 U2381/net32 VSS nmos W=0.155u L=0.04u
M19989 U2381/net28 U2381/net40 U2381/net24 VSS nmos W=0.155u L=0.04u
M19990 U2381/net40 n1799 U2381/net108 VSS nmos W=0.155u L=0.04u
M19991 U2381/net40 U2381/net106 U2381/net104 VSS nmos W=0.155u L=0.04u
M19992 U2381/net24 WX7260 U2381/net050 VSS nmos W=0.155u L=0.04u
M19993 U2381/net050 U2381/net32 VSS VSS nmos W=0.155u L=0.04u
M19994 U2381/net20 U2381/net40 VSS VSS nmos W=0.155u L=0.04u
M19995 U2381/net106 n1799 VSS VSS nmos W=0.155u L=0.04u
M19996 U2381/net104 WX7324 VSS VSS nmos W=0.155u L=0.04u
M19997 U2381/net30 WX7260 VSS VSS nmos W=0.155u L=0.04u
M19998 U2381/net108 U2381/net104 VSS VSS nmos W=0.155u L=0.04u
M19999 n1798 U2381/net28 VSS VSS nmos W=0.155u L=0.04u
M20000 U2381/net32 WX7196 VSS VSS nmos W=0.155u L=0.04u
M20001 U2381/net64 U2381/net24 VSS VSS nmos W=0.2u L=0.04u
M20002 U2381/net28 U2381/net40 U2381/net64 VDD pmos W=0.205u L=0.04u
M20003 U2381/net24 WX7260 U2381/net32 VDD pmos W=0.205u L=0.04u
M20004 U2381/net28 U2381/net20 U2381/net24 VDD pmos W=0.205u L=0.04u
M20005 U2381/net40 U2381/net106 U2381/net108 VDD pmos W=0.205u L=0.04u
M20006 U2381/net40 n1799 U2381/net104 VDD pmos W=0.205u L=0.04u
M20007 U2381/net20 U2381/net40 VDD VDD pmos W=0.205u L=0.04u
M20008 U2381/net106 n1799 VDD VDD pmos W=0.205u L=0.04u
M20009 U2381/net104 WX7324 VDD VDD pmos W=0.205u L=0.04u
M20010 U2381/net30 WX7260 VDD VDD pmos W=0.205u L=0.04u
M20011 U2381/net108 U2381/net104 VDD VDD pmos W=0.205u L=0.04u
M20012 n1798 U2381/net28 VDD VDD pmos W=0.205u L=0.04u
M20013 U2381/net32 WX7196 VDD VDD pmos W=0.205u L=0.04u
M20014 U2381/net64 U2381/net24 VDD VDD pmos W=0.28u L=0.04u
M20015 U2381/net24 U2381/net30 U2381/net045 VDD pmos W=0.205u L=0.04u
M20016 U2381/net045 U2381/net32 VDD VDD pmos W=0.205u L=0.04u
M20017 U2382/net4 WX7132 U2382/net14 VSS nmos W=0.155u L=0.04u
M20018 U2382/net6 U2382/net10 U2382/net14 VSS nmos W=0.17u L=0.04u
M20019 U2382/net4 n1371 VSS VSS nmos W=0.155u L=0.04u
M20020 U2382/net6 U2382/net4 VSS VSS nmos W=0.17u L=0.04u
M20021 n1799 U2382/net14 VSS VSS nmos W=0.155u L=0.04u
M20022 U2382/net10 WX7132 VSS VSS nmos W=0.155u L=0.04u
M20023 U2382/net4 U2382/net10 U2382/net14 VDD pmos W=0.255u L=0.04u
M20024 U2382/net6 WX7132 U2382/net14 VDD pmos W=0.28u L=0.04u
M20025 U2382/net4 n1371 VDD VDD pmos W=0.205u L=0.04u
M20026 U2382/net6 U2382/net4 VDD VDD pmos W=0.24u L=0.04u
M20027 n1799 U2382/net14 VDD VDD pmos W=0.205u L=0.04u
M20028 U2382/net10 WX7132 VDD VDD pmos W=0.205u L=0.04u
M20029 WX5350 n1274 U2383/net26 VSS nmos W=0.155u L=0.04u
M20030 WX5350 n1687 U2383/net26 VSS nmos W=0.155u L=0.04u
M20031 U2383/net29 n1801 VSS VSS nmos W=0.155u L=0.04u
M20032 U2383/net26 n1800 U2383/net29 VSS nmos W=0.155u L=0.04u
M20033 U2383/net26 n1260 U2383/net29 VSS nmos W=0.155u L=0.04u
M20034 WX5350 n1687 U2383/net43 VDD pmos W=0.205u L=0.04u
M20035 WX5350 n1260 U2383/net49 VDD pmos W=0.205u L=0.04u
M20036 U2383/net49 n1800 VDD VDD pmos W=0.205u L=0.04u
M20037 U2383/net43 n1274 VDD VDD pmos W=0.205u L=0.04u
M20038 WX5350 n1801 VDD VDD pmos W=0.205u L=0.04u
M20039 U2384/net29 n1334 VSS VSS nmos W=0.155u L=0.04u
M20040 n1801 WX5677 U2384/net29 VSS nmos W=0.155u L=0.04u
M20041 n1801 n1303 U2384/net23 VSS nmos W=0.155u L=0.04u
M20042 U2384/net23 CRC_OUT_5_21 VSS VSS nmos W=0.155u L=0.04u
M20043 U2384/net20 CRC_OUT_5_21 n1801 VDD pmos W=0.205u L=0.04u
M20044 U2384/net20 n1303 n1801 VDD pmos W=0.205u L=0.04u
M20045 VDD WX5677 U2384/net20 VDD pmos W=0.205u L=0.04u
M20046 VDD n1334 U2384/net20 VDD pmos W=0.205u L=0.04u
M20047 n1687 n1802 VSS VSS nmos W=0.135u L=0.04u
M20048 n1687 n1802 VDD VDD pmos W=0.205u L=0.04u
M20049 U2386/net28 U2386/net20 U2386/net64 VSS nmos W=0.155u L=0.04u
M20050 U2386/net24 U2386/net30 U2386/net32 VSS nmos W=0.155u L=0.04u
M20051 U2386/net28 U2386/net40 U2386/net24 VSS nmos W=0.155u L=0.04u
M20052 U2386/net40 n1803 U2386/net108 VSS nmos W=0.155u L=0.04u
M20053 U2386/net40 U2386/net106 U2386/net104 VSS nmos W=0.155u L=0.04u
M20054 U2386/net24 WX7258 U2386/net050 VSS nmos W=0.155u L=0.04u
M20055 U2386/net050 U2386/net32 VSS VSS nmos W=0.155u L=0.04u
M20056 U2386/net20 U2386/net40 VSS VSS nmos W=0.155u L=0.04u
M20057 U2386/net106 n1803 VSS VSS nmos W=0.155u L=0.04u
M20058 U2386/net104 WX7322 VSS VSS nmos W=0.155u L=0.04u
M20059 U2386/net30 WX7258 VSS VSS nmos W=0.155u L=0.04u
M20060 U2386/net108 U2386/net104 VSS VSS nmos W=0.155u L=0.04u
M20061 n1802 U2386/net28 VSS VSS nmos W=0.155u L=0.04u
M20062 U2386/net32 WX7194 VSS VSS nmos W=0.155u L=0.04u
M20063 U2386/net64 U2386/net24 VSS VSS nmos W=0.2u L=0.04u
M20064 U2386/net28 U2386/net40 U2386/net64 VDD pmos W=0.205u L=0.04u
M20065 U2386/net24 WX7258 U2386/net32 VDD pmos W=0.205u L=0.04u
M20066 U2386/net28 U2386/net20 U2386/net24 VDD pmos W=0.205u L=0.04u
M20067 U2386/net40 U2386/net106 U2386/net108 VDD pmos W=0.205u L=0.04u
M20068 U2386/net40 n1803 U2386/net104 VDD pmos W=0.205u L=0.04u
M20069 U2386/net20 U2386/net40 VDD VDD pmos W=0.205u L=0.04u
M20070 U2386/net106 n1803 VDD VDD pmos W=0.205u L=0.04u
M20071 U2386/net104 WX7322 VDD VDD pmos W=0.205u L=0.04u
M20072 U2386/net30 WX7258 VDD VDD pmos W=0.205u L=0.04u
M20073 U2386/net108 U2386/net104 VDD VDD pmos W=0.205u L=0.04u
M20074 n1802 U2386/net28 VDD VDD pmos W=0.205u L=0.04u
M20075 U2386/net32 WX7194 VDD VDD pmos W=0.205u L=0.04u
M20076 U2386/net64 U2386/net24 VDD VDD pmos W=0.28u L=0.04u
M20077 U2386/net24 U2386/net30 U2386/net045 VDD pmos W=0.205u L=0.04u
M20078 U2386/net045 U2386/net32 VDD VDD pmos W=0.205u L=0.04u
M20079 U2387/net4 WX7130 U2387/net14 VSS nmos W=0.155u L=0.04u
M20080 U2387/net6 U2387/net10 U2387/net14 VSS nmos W=0.17u L=0.04u
M20081 U2387/net4 n1371 VSS VSS nmos W=0.155u L=0.04u
M20082 U2387/net6 U2387/net4 VSS VSS nmos W=0.17u L=0.04u
M20083 n1803 U2387/net14 VSS VSS nmos W=0.155u L=0.04u
M20084 U2387/net10 WX7130 VSS VSS nmos W=0.155u L=0.04u
M20085 U2387/net4 U2387/net10 U2387/net14 VDD pmos W=0.255u L=0.04u
M20086 U2387/net6 WX7130 U2387/net14 VDD pmos W=0.28u L=0.04u
M20087 U2387/net4 n1371 VDD VDD pmos W=0.205u L=0.04u
M20088 U2387/net6 U2387/net4 VDD VDD pmos W=0.24u L=0.04u
M20089 n1803 U2387/net14 VDD VDD pmos W=0.205u L=0.04u
M20090 U2387/net10 WX7130 VDD VDD pmos W=0.205u L=0.04u
M20091 WX5336 n1274 U2388/net26 VSS nmos W=0.155u L=0.04u
M20092 WX5336 n1691 U2388/net26 VSS nmos W=0.155u L=0.04u
M20093 U2388/net29 n1805 VSS VSS nmos W=0.155u L=0.04u
M20094 U2388/net26 n1804 U2388/net29 VSS nmos W=0.155u L=0.04u
M20095 U2388/net26 n1260 U2388/net29 VSS nmos W=0.155u L=0.04u
M20096 WX5336 n1691 U2388/net43 VDD pmos W=0.205u L=0.04u
M20097 WX5336 n1260 U2388/net49 VDD pmos W=0.205u L=0.04u
M20098 U2388/net49 n1804 VDD VDD pmos W=0.205u L=0.04u
M20099 U2388/net43 n1274 VDD VDD pmos W=0.205u L=0.04u
M20100 WX5336 n1805 VDD VDD pmos W=0.205u L=0.04u
M20101 U2389/net29 n1334 VSS VSS nmos W=0.155u L=0.04u
M20102 n1805 WX5675 U2389/net29 VSS nmos W=0.155u L=0.04u
M20103 n1805 n1303 U2389/net23 VSS nmos W=0.155u L=0.04u
M20104 U2389/net23 CRC_OUT_5_22 VSS VSS nmos W=0.155u L=0.04u
M20105 U2389/net20 CRC_OUT_5_22 n1805 VDD pmos W=0.205u L=0.04u
M20106 U2389/net20 n1303 n1805 VDD pmos W=0.205u L=0.04u
M20107 VDD WX5675 U2389/net20 VDD pmos W=0.205u L=0.04u
M20108 VDD n1334 U2389/net20 VDD pmos W=0.205u L=0.04u
M20109 n1691 n1806 VSS VSS nmos W=0.135u L=0.04u
M20110 n1691 n1806 VDD VDD pmos W=0.205u L=0.04u
M20111 U2391/net28 U2391/net20 U2391/net64 VSS nmos W=0.155u L=0.04u
M20112 U2391/net24 U2391/net30 U2391/net32 VSS nmos W=0.155u L=0.04u
M20113 U2391/net28 U2391/net40 U2391/net24 VSS nmos W=0.155u L=0.04u
M20114 U2391/net40 n1807 U2391/net108 VSS nmos W=0.155u L=0.04u
M20115 U2391/net40 U2391/net106 U2391/net104 VSS nmos W=0.155u L=0.04u
M20116 U2391/net24 WX7256 U2391/net050 VSS nmos W=0.155u L=0.04u
M20117 U2391/net050 U2391/net32 VSS VSS nmos W=0.155u L=0.04u
M20118 U2391/net20 U2391/net40 VSS VSS nmos W=0.155u L=0.04u
M20119 U2391/net106 n1807 VSS VSS nmos W=0.155u L=0.04u
M20120 U2391/net104 WX7320 VSS VSS nmos W=0.155u L=0.04u
M20121 U2391/net30 WX7256 VSS VSS nmos W=0.155u L=0.04u
M20122 U2391/net108 U2391/net104 VSS VSS nmos W=0.155u L=0.04u
M20123 n1806 U2391/net28 VSS VSS nmos W=0.155u L=0.04u
M20124 U2391/net32 WX7192 VSS VSS nmos W=0.155u L=0.04u
M20125 U2391/net64 U2391/net24 VSS VSS nmos W=0.2u L=0.04u
M20126 U2391/net28 U2391/net40 U2391/net64 VDD pmos W=0.205u L=0.04u
M20127 U2391/net24 WX7256 U2391/net32 VDD pmos W=0.205u L=0.04u
M20128 U2391/net28 U2391/net20 U2391/net24 VDD pmos W=0.205u L=0.04u
M20129 U2391/net40 U2391/net106 U2391/net108 VDD pmos W=0.205u L=0.04u
M20130 U2391/net40 n1807 U2391/net104 VDD pmos W=0.205u L=0.04u
M20131 U2391/net20 U2391/net40 VDD VDD pmos W=0.205u L=0.04u
M20132 U2391/net106 n1807 VDD VDD pmos W=0.205u L=0.04u
M20133 U2391/net104 WX7320 VDD VDD pmos W=0.205u L=0.04u
M20134 U2391/net30 WX7256 VDD VDD pmos W=0.205u L=0.04u
M20135 U2391/net108 U2391/net104 VDD VDD pmos W=0.205u L=0.04u
M20136 n1806 U2391/net28 VDD VDD pmos W=0.205u L=0.04u
M20137 U2391/net32 WX7192 VDD VDD pmos W=0.205u L=0.04u
M20138 U2391/net64 U2391/net24 VDD VDD pmos W=0.28u L=0.04u
M20139 U2391/net24 U2391/net30 U2391/net045 VDD pmos W=0.205u L=0.04u
M20140 U2391/net045 U2391/net32 VDD VDD pmos W=0.205u L=0.04u
M20141 U2392/net4 WX7128 U2392/net14 VSS nmos W=0.155u L=0.04u
M20142 U2392/net6 U2392/net10 U2392/net14 VSS nmos W=0.17u L=0.04u
M20143 U2392/net4 n1371 VSS VSS nmos W=0.155u L=0.04u
M20144 U2392/net6 U2392/net4 VSS VSS nmos W=0.17u L=0.04u
M20145 n1807 U2392/net14 VSS VSS nmos W=0.155u L=0.04u
M20146 U2392/net10 WX7128 VSS VSS nmos W=0.155u L=0.04u
M20147 U2392/net4 U2392/net10 U2392/net14 VDD pmos W=0.255u L=0.04u
M20148 U2392/net6 WX7128 U2392/net14 VDD pmos W=0.28u L=0.04u
M20149 U2392/net4 n1371 VDD VDD pmos W=0.205u L=0.04u
M20150 U2392/net6 U2392/net4 VDD VDD pmos W=0.24u L=0.04u
M20151 n1807 U2392/net14 VDD VDD pmos W=0.205u L=0.04u
M20152 U2392/net10 WX7128 VDD VDD pmos W=0.205u L=0.04u
M20153 WX5322 n1274 U2393/net26 VSS nmos W=0.155u L=0.04u
M20154 WX5322 n1695 U2393/net26 VSS nmos W=0.155u L=0.04u
M20155 U2393/net29 n1809 VSS VSS nmos W=0.155u L=0.04u
M20156 U2393/net26 n1808 U2393/net29 VSS nmos W=0.155u L=0.04u
M20157 U2393/net26 n1260 U2393/net29 VSS nmos W=0.155u L=0.04u
M20158 WX5322 n1695 U2393/net43 VDD pmos W=0.205u L=0.04u
M20159 WX5322 n1260 U2393/net49 VDD pmos W=0.205u L=0.04u
M20160 U2393/net49 n1808 VDD VDD pmos W=0.205u L=0.04u
M20161 U2393/net43 n1274 VDD VDD pmos W=0.205u L=0.04u
M20162 WX5322 n1809 VDD VDD pmos W=0.205u L=0.04u
M20163 U2394/net29 n1334 VSS VSS nmos W=0.155u L=0.04u
M20164 n1809 WX5673 U2394/net29 VSS nmos W=0.155u L=0.04u
M20165 n1809 n1303 U2394/net23 VSS nmos W=0.155u L=0.04u
M20166 U2394/net23 CRC_OUT_5_23 VSS VSS nmos W=0.155u L=0.04u
M20167 U2394/net20 CRC_OUT_5_23 n1809 VDD pmos W=0.205u L=0.04u
M20168 U2394/net20 n1303 n1809 VDD pmos W=0.205u L=0.04u
M20169 VDD WX5673 U2394/net20 VDD pmos W=0.205u L=0.04u
M20170 VDD n1334 U2394/net20 VDD pmos W=0.205u L=0.04u
M20171 n1695 n1810 VSS VSS nmos W=0.135u L=0.04u
M20172 n1695 n1810 VDD VDD pmos W=0.205u L=0.04u
M20173 U2396/net28 U2396/net20 U2396/net64 VSS nmos W=0.155u L=0.04u
M20174 U2396/net24 U2396/net30 U2396/net32 VSS nmos W=0.155u L=0.04u
M20175 U2396/net28 U2396/net40 U2396/net24 VSS nmos W=0.155u L=0.04u
M20176 U2396/net40 n1811 U2396/net108 VSS nmos W=0.155u L=0.04u
M20177 U2396/net40 U2396/net106 U2396/net104 VSS nmos W=0.155u L=0.04u
M20178 U2396/net24 WX7254 U2396/net050 VSS nmos W=0.155u L=0.04u
M20179 U2396/net050 U2396/net32 VSS VSS nmos W=0.155u L=0.04u
M20180 U2396/net20 U2396/net40 VSS VSS nmos W=0.155u L=0.04u
M20181 U2396/net106 n1811 VSS VSS nmos W=0.155u L=0.04u
M20182 U2396/net104 WX7318 VSS VSS nmos W=0.155u L=0.04u
M20183 U2396/net30 WX7254 VSS VSS nmos W=0.155u L=0.04u
M20184 U2396/net108 U2396/net104 VSS VSS nmos W=0.155u L=0.04u
M20185 n1810 U2396/net28 VSS VSS nmos W=0.155u L=0.04u
M20186 U2396/net32 WX7190 VSS VSS nmos W=0.155u L=0.04u
M20187 U2396/net64 U2396/net24 VSS VSS nmos W=0.2u L=0.04u
M20188 U2396/net28 U2396/net40 U2396/net64 VDD pmos W=0.205u L=0.04u
M20189 U2396/net24 WX7254 U2396/net32 VDD pmos W=0.205u L=0.04u
M20190 U2396/net28 U2396/net20 U2396/net24 VDD pmos W=0.205u L=0.04u
M20191 U2396/net40 U2396/net106 U2396/net108 VDD pmos W=0.205u L=0.04u
M20192 U2396/net40 n1811 U2396/net104 VDD pmos W=0.205u L=0.04u
M20193 U2396/net20 U2396/net40 VDD VDD pmos W=0.205u L=0.04u
M20194 U2396/net106 n1811 VDD VDD pmos W=0.205u L=0.04u
M20195 U2396/net104 WX7318 VDD VDD pmos W=0.205u L=0.04u
M20196 U2396/net30 WX7254 VDD VDD pmos W=0.205u L=0.04u
M20197 U2396/net108 U2396/net104 VDD VDD pmos W=0.205u L=0.04u
M20198 n1810 U2396/net28 VDD VDD pmos W=0.205u L=0.04u
M20199 U2396/net32 WX7190 VDD VDD pmos W=0.205u L=0.04u
M20200 U2396/net64 U2396/net24 VDD VDD pmos W=0.28u L=0.04u
M20201 U2396/net24 U2396/net30 U2396/net045 VDD pmos W=0.205u L=0.04u
M20202 U2396/net045 U2396/net32 VDD VDD pmos W=0.205u L=0.04u
M20203 U2397/net4 WX7126 U2397/net14 VSS nmos W=0.155u L=0.04u
M20204 U2397/net6 U2397/net10 U2397/net14 VSS nmos W=0.17u L=0.04u
M20205 U2397/net4 n1371 VSS VSS nmos W=0.155u L=0.04u
M20206 U2397/net6 U2397/net4 VSS VSS nmos W=0.17u L=0.04u
M20207 n1811 U2397/net14 VSS VSS nmos W=0.155u L=0.04u
M20208 U2397/net10 WX7126 VSS VSS nmos W=0.155u L=0.04u
M20209 U2397/net4 U2397/net10 U2397/net14 VDD pmos W=0.255u L=0.04u
M20210 U2397/net6 WX7126 U2397/net14 VDD pmos W=0.28u L=0.04u
M20211 U2397/net4 n1371 VDD VDD pmos W=0.205u L=0.04u
M20212 U2397/net6 U2397/net4 VDD VDD pmos W=0.24u L=0.04u
M20213 n1811 U2397/net14 VDD VDD pmos W=0.205u L=0.04u
M20214 U2397/net10 WX7126 VDD VDD pmos W=0.205u L=0.04u
M20215 WX5308 n1274 U2398/net26 VSS nmos W=0.155u L=0.04u
M20216 WX5308 n1699 U2398/net26 VSS nmos W=0.155u L=0.04u
M20217 U2398/net29 n1813 VSS VSS nmos W=0.155u L=0.04u
M20218 U2398/net26 n1812 U2398/net29 VSS nmos W=0.155u L=0.04u
M20219 U2398/net26 n1260 U2398/net29 VSS nmos W=0.155u L=0.04u
M20220 WX5308 n1699 U2398/net43 VDD pmos W=0.205u L=0.04u
M20221 WX5308 n1260 U2398/net49 VDD pmos W=0.205u L=0.04u
M20222 U2398/net49 n1812 VDD VDD pmos W=0.205u L=0.04u
M20223 U2398/net43 n1274 VDD VDD pmos W=0.205u L=0.04u
M20224 WX5308 n1813 VDD VDD pmos W=0.205u L=0.04u
M20225 U2399/net29 n1334 VSS VSS nmos W=0.155u L=0.04u
M20226 n1813 WX5671 U2399/net29 VSS nmos W=0.155u L=0.04u
M20227 n1813 n1303 U2399/net23 VSS nmos W=0.155u L=0.04u
M20228 U2399/net23 CRC_OUT_5_24 VSS VSS nmos W=0.155u L=0.04u
M20229 U2399/net20 CRC_OUT_5_24 n1813 VDD pmos W=0.205u L=0.04u
M20230 U2399/net20 n1303 n1813 VDD pmos W=0.205u L=0.04u
M20231 VDD WX5671 U2399/net20 VDD pmos W=0.205u L=0.04u
M20232 VDD n1334 U2399/net20 VDD pmos W=0.205u L=0.04u
M20233 n1699 n1814 VSS VSS nmos W=0.135u L=0.04u
M20234 n1699 n1814 VDD VDD pmos W=0.205u L=0.04u
M20235 U2401/net28 U2401/net20 U2401/net64 VSS nmos W=0.155u L=0.04u
M20236 U2401/net24 U2401/net30 U2401/net32 VSS nmos W=0.155u L=0.04u
M20237 U2401/net28 U2401/net40 U2401/net24 VSS nmos W=0.155u L=0.04u
M20238 U2401/net40 n1815 U2401/net108 VSS nmos W=0.155u L=0.04u
M20239 U2401/net40 U2401/net106 U2401/net104 VSS nmos W=0.155u L=0.04u
M20240 U2401/net24 WX7252 U2401/net050 VSS nmos W=0.155u L=0.04u
M20241 U2401/net050 U2401/net32 VSS VSS nmos W=0.155u L=0.04u
M20242 U2401/net20 U2401/net40 VSS VSS nmos W=0.155u L=0.04u
M20243 U2401/net106 n1815 VSS VSS nmos W=0.155u L=0.04u
M20244 U2401/net104 WX7316 VSS VSS nmos W=0.155u L=0.04u
M20245 U2401/net30 WX7252 VSS VSS nmos W=0.155u L=0.04u
M20246 U2401/net108 U2401/net104 VSS VSS nmos W=0.155u L=0.04u
M20247 n1814 U2401/net28 VSS VSS nmos W=0.155u L=0.04u
M20248 U2401/net32 WX7188 VSS VSS nmos W=0.155u L=0.04u
M20249 U2401/net64 U2401/net24 VSS VSS nmos W=0.2u L=0.04u
M20250 U2401/net28 U2401/net40 U2401/net64 VDD pmos W=0.205u L=0.04u
M20251 U2401/net24 WX7252 U2401/net32 VDD pmos W=0.205u L=0.04u
M20252 U2401/net28 U2401/net20 U2401/net24 VDD pmos W=0.205u L=0.04u
M20253 U2401/net40 U2401/net106 U2401/net108 VDD pmos W=0.205u L=0.04u
M20254 U2401/net40 n1815 U2401/net104 VDD pmos W=0.205u L=0.04u
M20255 U2401/net20 U2401/net40 VDD VDD pmos W=0.205u L=0.04u
M20256 U2401/net106 n1815 VDD VDD pmos W=0.205u L=0.04u
M20257 U2401/net104 WX7316 VDD VDD pmos W=0.205u L=0.04u
M20258 U2401/net30 WX7252 VDD VDD pmos W=0.205u L=0.04u
M20259 U2401/net108 U2401/net104 VDD VDD pmos W=0.205u L=0.04u
M20260 n1814 U2401/net28 VDD VDD pmos W=0.205u L=0.04u
M20261 U2401/net32 WX7188 VDD VDD pmos W=0.205u L=0.04u
M20262 U2401/net64 U2401/net24 VDD VDD pmos W=0.28u L=0.04u
M20263 U2401/net24 U2401/net30 U2401/net045 VDD pmos W=0.205u L=0.04u
M20264 U2401/net045 U2401/net32 VDD VDD pmos W=0.205u L=0.04u
M20265 U2402/net4 WX7124 U2402/net14 VSS nmos W=0.155u L=0.04u
M20266 U2402/net6 U2402/net10 U2402/net14 VSS nmos W=0.17u L=0.04u
M20267 U2402/net4 n1371 VSS VSS nmos W=0.155u L=0.04u
M20268 U2402/net6 U2402/net4 VSS VSS nmos W=0.17u L=0.04u
M20269 n1815 U2402/net14 VSS VSS nmos W=0.155u L=0.04u
M20270 U2402/net10 WX7124 VSS VSS nmos W=0.155u L=0.04u
M20271 U2402/net4 U2402/net10 U2402/net14 VDD pmos W=0.255u L=0.04u
M20272 U2402/net6 WX7124 U2402/net14 VDD pmos W=0.28u L=0.04u
M20273 U2402/net4 n1371 VDD VDD pmos W=0.205u L=0.04u
M20274 U2402/net6 U2402/net4 VDD VDD pmos W=0.24u L=0.04u
M20275 n1815 U2402/net14 VDD VDD pmos W=0.205u L=0.04u
M20276 U2402/net10 WX7124 VDD VDD pmos W=0.205u L=0.04u
M20277 WX5294 n1274 U2403/net26 VSS nmos W=0.155u L=0.04u
M20278 WX5294 n1706 U2403/net26 VSS nmos W=0.155u L=0.04u
M20279 U2403/net29 n1817 VSS VSS nmos W=0.155u L=0.04u
M20280 U2403/net26 n1816 U2403/net29 VSS nmos W=0.155u L=0.04u
M20281 U2403/net26 n1260 U2403/net29 VSS nmos W=0.155u L=0.04u
M20282 WX5294 n1706 U2403/net43 VDD pmos W=0.205u L=0.04u
M20283 WX5294 n1260 U2403/net49 VDD pmos W=0.205u L=0.04u
M20284 U2403/net49 n1816 VDD VDD pmos W=0.205u L=0.04u
M20285 U2403/net43 n1274 VDD VDD pmos W=0.205u L=0.04u
M20286 WX5294 n1817 VDD VDD pmos W=0.205u L=0.04u
M20287 U2404/net29 n1334 VSS VSS nmos W=0.155u L=0.04u
M20288 n1817 WX5669 U2404/net29 VSS nmos W=0.155u L=0.04u
M20289 n1817 n1303 U2404/net23 VSS nmos W=0.155u L=0.04u
M20290 U2404/net23 CRC_OUT_5_25 VSS VSS nmos W=0.155u L=0.04u
M20291 U2404/net20 CRC_OUT_5_25 n1817 VDD pmos W=0.205u L=0.04u
M20292 U2404/net20 n1303 n1817 VDD pmos W=0.205u L=0.04u
M20293 VDD WX5669 U2404/net20 VDD pmos W=0.205u L=0.04u
M20294 VDD n1334 U2404/net20 VDD pmos W=0.205u L=0.04u
M20295 n1706 n1818 VSS VSS nmos W=0.135u L=0.04u
M20296 n1706 n1818 VDD VDD pmos W=0.205u L=0.04u
M20297 U2406/net28 U2406/net20 U2406/net64 VSS nmos W=0.155u L=0.04u
M20298 U2406/net24 U2406/net30 U2406/net32 VSS nmos W=0.155u L=0.04u
M20299 U2406/net28 U2406/net40 U2406/net24 VSS nmos W=0.155u L=0.04u
M20300 U2406/net40 n1819 U2406/net108 VSS nmos W=0.155u L=0.04u
M20301 U2406/net40 U2406/net106 U2406/net104 VSS nmos W=0.155u L=0.04u
M20302 U2406/net24 WX7250 U2406/net050 VSS nmos W=0.155u L=0.04u
M20303 U2406/net050 U2406/net32 VSS VSS nmos W=0.155u L=0.04u
M20304 U2406/net20 U2406/net40 VSS VSS nmos W=0.155u L=0.04u
M20305 U2406/net106 n1819 VSS VSS nmos W=0.155u L=0.04u
M20306 U2406/net104 WX7314 VSS VSS nmos W=0.155u L=0.04u
M20307 U2406/net30 WX7250 VSS VSS nmos W=0.155u L=0.04u
M20308 U2406/net108 U2406/net104 VSS VSS nmos W=0.155u L=0.04u
M20309 n1818 U2406/net28 VSS VSS nmos W=0.155u L=0.04u
M20310 U2406/net32 WX7186 VSS VSS nmos W=0.155u L=0.04u
M20311 U2406/net64 U2406/net24 VSS VSS nmos W=0.2u L=0.04u
M20312 U2406/net28 U2406/net40 U2406/net64 VDD pmos W=0.205u L=0.04u
M20313 U2406/net24 WX7250 U2406/net32 VDD pmos W=0.205u L=0.04u
M20314 U2406/net28 U2406/net20 U2406/net24 VDD pmos W=0.205u L=0.04u
M20315 U2406/net40 U2406/net106 U2406/net108 VDD pmos W=0.205u L=0.04u
M20316 U2406/net40 n1819 U2406/net104 VDD pmos W=0.205u L=0.04u
M20317 U2406/net20 U2406/net40 VDD VDD pmos W=0.205u L=0.04u
M20318 U2406/net106 n1819 VDD VDD pmos W=0.205u L=0.04u
M20319 U2406/net104 WX7314 VDD VDD pmos W=0.205u L=0.04u
M20320 U2406/net30 WX7250 VDD VDD pmos W=0.205u L=0.04u
M20321 U2406/net108 U2406/net104 VDD VDD pmos W=0.205u L=0.04u
M20322 n1818 U2406/net28 VDD VDD pmos W=0.205u L=0.04u
M20323 U2406/net32 WX7186 VDD VDD pmos W=0.205u L=0.04u
M20324 U2406/net64 U2406/net24 VDD VDD pmos W=0.28u L=0.04u
M20325 U2406/net24 U2406/net30 U2406/net045 VDD pmos W=0.205u L=0.04u
M20326 U2406/net045 U2406/net32 VDD VDD pmos W=0.205u L=0.04u
M20327 U2407/net4 WX7122 U2407/net14 VSS nmos W=0.155u L=0.04u
M20328 U2407/net6 U2407/net10 U2407/net14 VSS nmos W=0.17u L=0.04u
M20329 U2407/net4 n1371 VSS VSS nmos W=0.155u L=0.04u
M20330 U2407/net6 U2407/net4 VSS VSS nmos W=0.17u L=0.04u
M20331 n1819 U2407/net14 VSS VSS nmos W=0.155u L=0.04u
M20332 U2407/net10 WX7122 VSS VSS nmos W=0.155u L=0.04u
M20333 U2407/net4 U2407/net10 U2407/net14 VDD pmos W=0.255u L=0.04u
M20334 U2407/net6 WX7122 U2407/net14 VDD pmos W=0.28u L=0.04u
M20335 U2407/net4 n1371 VDD VDD pmos W=0.205u L=0.04u
M20336 U2407/net6 U2407/net4 VDD VDD pmos W=0.24u L=0.04u
M20337 n1819 U2407/net14 VDD VDD pmos W=0.205u L=0.04u
M20338 U2407/net10 WX7122 VDD VDD pmos W=0.205u L=0.04u
M20339 WX5280 n1274 U2408/net26 VSS nmos W=0.155u L=0.04u
M20340 WX5280 n1710 U2408/net26 VSS nmos W=0.155u L=0.04u
M20341 U2408/net29 n1821 VSS VSS nmos W=0.155u L=0.04u
M20342 U2408/net26 n1820 U2408/net29 VSS nmos W=0.155u L=0.04u
M20343 U2408/net26 n1260 U2408/net29 VSS nmos W=0.155u L=0.04u
M20344 WX5280 n1710 U2408/net43 VDD pmos W=0.205u L=0.04u
M20345 WX5280 n1260 U2408/net49 VDD pmos W=0.205u L=0.04u
M20346 U2408/net49 n1820 VDD VDD pmos W=0.205u L=0.04u
M20347 U2408/net43 n1274 VDD VDD pmos W=0.205u L=0.04u
M20348 WX5280 n1821 VDD VDD pmos W=0.205u L=0.04u
M20349 U2409/net29 n1334 VSS VSS nmos W=0.155u L=0.04u
M20350 n1821 WX5667 U2409/net29 VSS nmos W=0.155u L=0.04u
M20351 n1821 n1307 U2409/net23 VSS nmos W=0.155u L=0.04u
M20352 U2409/net23 CRC_OUT_5_26 VSS VSS nmos W=0.155u L=0.04u
M20353 U2409/net20 CRC_OUT_5_26 n1821 VDD pmos W=0.205u L=0.04u
M20354 U2409/net20 n1307 n1821 VDD pmos W=0.205u L=0.04u
M20355 VDD WX5667 U2409/net20 VDD pmos W=0.205u L=0.04u
M20356 VDD n1334 U2409/net20 VDD pmos W=0.205u L=0.04u
M20357 n1710 n1822 VSS VSS nmos W=0.135u L=0.04u
M20358 n1710 n1822 VDD VDD pmos W=0.205u L=0.04u
M20359 U2411/net28 U2411/net20 U2411/net64 VSS nmos W=0.155u L=0.04u
M20360 U2411/net24 U2411/net30 U2411/net32 VSS nmos W=0.155u L=0.04u
M20361 U2411/net28 U2411/net40 U2411/net24 VSS nmos W=0.155u L=0.04u
M20362 U2411/net40 n1823 U2411/net108 VSS nmos W=0.155u L=0.04u
M20363 U2411/net40 U2411/net106 U2411/net104 VSS nmos W=0.155u L=0.04u
M20364 U2411/net24 WX7248 U2411/net050 VSS nmos W=0.155u L=0.04u
M20365 U2411/net050 U2411/net32 VSS VSS nmos W=0.155u L=0.04u
M20366 U2411/net20 U2411/net40 VSS VSS nmos W=0.155u L=0.04u
M20367 U2411/net106 n1823 VSS VSS nmos W=0.155u L=0.04u
M20368 U2411/net104 WX7312 VSS VSS nmos W=0.155u L=0.04u
M20369 U2411/net30 WX7248 VSS VSS nmos W=0.155u L=0.04u
M20370 U2411/net108 U2411/net104 VSS VSS nmos W=0.155u L=0.04u
M20371 n1822 U2411/net28 VSS VSS nmos W=0.155u L=0.04u
M20372 U2411/net32 WX7184 VSS VSS nmos W=0.155u L=0.04u
M20373 U2411/net64 U2411/net24 VSS VSS nmos W=0.2u L=0.04u
M20374 U2411/net28 U2411/net40 U2411/net64 VDD pmos W=0.205u L=0.04u
M20375 U2411/net24 WX7248 U2411/net32 VDD pmos W=0.205u L=0.04u
M20376 U2411/net28 U2411/net20 U2411/net24 VDD pmos W=0.205u L=0.04u
M20377 U2411/net40 U2411/net106 U2411/net108 VDD pmos W=0.205u L=0.04u
M20378 U2411/net40 n1823 U2411/net104 VDD pmos W=0.205u L=0.04u
M20379 U2411/net20 U2411/net40 VDD VDD pmos W=0.205u L=0.04u
M20380 U2411/net106 n1823 VDD VDD pmos W=0.205u L=0.04u
M20381 U2411/net104 WX7312 VDD VDD pmos W=0.205u L=0.04u
M20382 U2411/net30 WX7248 VDD VDD pmos W=0.205u L=0.04u
M20383 U2411/net108 U2411/net104 VDD VDD pmos W=0.205u L=0.04u
M20384 n1822 U2411/net28 VDD VDD pmos W=0.205u L=0.04u
M20385 U2411/net32 WX7184 VDD VDD pmos W=0.205u L=0.04u
M20386 U2411/net64 U2411/net24 VDD VDD pmos W=0.28u L=0.04u
M20387 U2411/net24 U2411/net30 U2411/net045 VDD pmos W=0.205u L=0.04u
M20388 U2411/net045 U2411/net32 VDD VDD pmos W=0.205u L=0.04u
M20389 U2412/net4 WX7120 U2412/net14 VSS nmos W=0.155u L=0.04u
M20390 U2412/net6 U2412/net10 U2412/net14 VSS nmos W=0.17u L=0.04u
M20391 U2412/net4 n1371 VSS VSS nmos W=0.155u L=0.04u
M20392 U2412/net6 U2412/net4 VSS VSS nmos W=0.17u L=0.04u
M20393 n1823 U2412/net14 VSS VSS nmos W=0.155u L=0.04u
M20394 U2412/net10 WX7120 VSS VSS nmos W=0.155u L=0.04u
M20395 U2412/net4 U2412/net10 U2412/net14 VDD pmos W=0.255u L=0.04u
M20396 U2412/net6 WX7120 U2412/net14 VDD pmos W=0.28u L=0.04u
M20397 U2412/net4 n1371 VDD VDD pmos W=0.205u L=0.04u
M20398 U2412/net6 U2412/net4 VDD VDD pmos W=0.24u L=0.04u
M20399 n1823 U2412/net14 VDD VDD pmos W=0.205u L=0.04u
M20400 U2412/net10 WX7120 VDD VDD pmos W=0.205u L=0.04u
M20401 WX5266 n1274 U2413/net26 VSS nmos W=0.155u L=0.04u
M20402 WX5266 n1714 U2413/net26 VSS nmos W=0.155u L=0.04u
M20403 U2413/net29 n1825 VSS VSS nmos W=0.155u L=0.04u
M20404 U2413/net26 n1824 U2413/net29 VSS nmos W=0.155u L=0.04u
M20405 U2413/net26 n1260 U2413/net29 VSS nmos W=0.155u L=0.04u
M20406 WX5266 n1714 U2413/net43 VDD pmos W=0.205u L=0.04u
M20407 WX5266 n1260 U2413/net49 VDD pmos W=0.205u L=0.04u
M20408 U2413/net49 n1824 VDD VDD pmos W=0.205u L=0.04u
M20409 U2413/net43 n1274 VDD VDD pmos W=0.205u L=0.04u
M20410 WX5266 n1825 VDD VDD pmos W=0.205u L=0.04u
M20411 U2414/net29 n1334 VSS VSS nmos W=0.155u L=0.04u
M20412 n1825 WX5665 U2414/net29 VSS nmos W=0.155u L=0.04u
M20413 n1825 n1322 U2414/net23 VSS nmos W=0.155u L=0.04u
M20414 U2414/net23 CRC_OUT_5_27 VSS VSS nmos W=0.155u L=0.04u
M20415 U2414/net20 CRC_OUT_5_27 n1825 VDD pmos W=0.205u L=0.04u
M20416 U2414/net20 n1322 n1825 VDD pmos W=0.205u L=0.04u
M20417 VDD WX5665 U2414/net20 VDD pmos W=0.205u L=0.04u
M20418 VDD n1334 U2414/net20 VDD pmos W=0.205u L=0.04u
M20419 n1714 n1826 VSS VSS nmos W=0.135u L=0.04u
M20420 n1714 n1826 VDD VDD pmos W=0.205u L=0.04u
M20421 U2416/net28 U2416/net20 U2416/net64 VSS nmos W=0.155u L=0.04u
M20422 U2416/net24 U2416/net30 U2416/net32 VSS nmos W=0.155u L=0.04u
M20423 U2416/net28 U2416/net40 U2416/net24 VSS nmos W=0.155u L=0.04u
M20424 U2416/net40 n1827 U2416/net108 VSS nmos W=0.155u L=0.04u
M20425 U2416/net40 U2416/net106 U2416/net104 VSS nmos W=0.155u L=0.04u
M20426 U2416/net24 WX7246 U2416/net050 VSS nmos W=0.155u L=0.04u
M20427 U2416/net050 U2416/net32 VSS VSS nmos W=0.155u L=0.04u
M20428 U2416/net20 U2416/net40 VSS VSS nmos W=0.155u L=0.04u
M20429 U2416/net106 n1827 VSS VSS nmos W=0.155u L=0.04u
M20430 U2416/net104 WX7310 VSS VSS nmos W=0.155u L=0.04u
M20431 U2416/net30 WX7246 VSS VSS nmos W=0.155u L=0.04u
M20432 U2416/net108 U2416/net104 VSS VSS nmos W=0.155u L=0.04u
M20433 n1826 U2416/net28 VSS VSS nmos W=0.155u L=0.04u
M20434 U2416/net32 WX7182 VSS VSS nmos W=0.155u L=0.04u
M20435 U2416/net64 U2416/net24 VSS VSS nmos W=0.2u L=0.04u
M20436 U2416/net28 U2416/net40 U2416/net64 VDD pmos W=0.205u L=0.04u
M20437 U2416/net24 WX7246 U2416/net32 VDD pmos W=0.205u L=0.04u
M20438 U2416/net28 U2416/net20 U2416/net24 VDD pmos W=0.205u L=0.04u
M20439 U2416/net40 U2416/net106 U2416/net108 VDD pmos W=0.205u L=0.04u
M20440 U2416/net40 n1827 U2416/net104 VDD pmos W=0.205u L=0.04u
M20441 U2416/net20 U2416/net40 VDD VDD pmos W=0.205u L=0.04u
M20442 U2416/net106 n1827 VDD VDD pmos W=0.205u L=0.04u
M20443 U2416/net104 WX7310 VDD VDD pmos W=0.205u L=0.04u
M20444 U2416/net30 WX7246 VDD VDD pmos W=0.205u L=0.04u
M20445 U2416/net108 U2416/net104 VDD VDD pmos W=0.205u L=0.04u
M20446 n1826 U2416/net28 VDD VDD pmos W=0.205u L=0.04u
M20447 U2416/net32 WX7182 VDD VDD pmos W=0.205u L=0.04u
M20448 U2416/net64 U2416/net24 VDD VDD pmos W=0.28u L=0.04u
M20449 U2416/net24 U2416/net30 U2416/net045 VDD pmos W=0.205u L=0.04u
M20450 U2416/net045 U2416/net32 VDD VDD pmos W=0.205u L=0.04u
M20451 U2417/net4 WX7118 U2417/net14 VSS nmos W=0.155u L=0.04u
M20452 U2417/net6 U2417/net10 U2417/net14 VSS nmos W=0.17u L=0.04u
M20453 U2417/net4 n1371 VSS VSS nmos W=0.155u L=0.04u
M20454 U2417/net6 U2417/net4 VSS VSS nmos W=0.17u L=0.04u
M20455 n1827 U2417/net14 VSS VSS nmos W=0.155u L=0.04u
M20456 U2417/net10 WX7118 VSS VSS nmos W=0.155u L=0.04u
M20457 U2417/net4 U2417/net10 U2417/net14 VDD pmos W=0.255u L=0.04u
M20458 U2417/net6 WX7118 U2417/net14 VDD pmos W=0.28u L=0.04u
M20459 U2417/net4 n1371 VDD VDD pmos W=0.205u L=0.04u
M20460 U2417/net6 U2417/net4 VDD VDD pmos W=0.24u L=0.04u
M20461 n1827 U2417/net14 VDD VDD pmos W=0.205u L=0.04u
M20462 U2417/net10 WX7118 VDD VDD pmos W=0.205u L=0.04u
M20463 WX5252 n1274 U2418/net26 VSS nmos W=0.155u L=0.04u
M20464 WX5252 n1718 U2418/net26 VSS nmos W=0.155u L=0.04u
M20465 U2418/net29 n1829 VSS VSS nmos W=0.155u L=0.04u
M20466 U2418/net26 n1828 U2418/net29 VSS nmos W=0.155u L=0.04u
M20467 U2418/net26 n1260 U2418/net29 VSS nmos W=0.155u L=0.04u
M20468 WX5252 n1718 U2418/net43 VDD pmos W=0.205u L=0.04u
M20469 WX5252 n1260 U2418/net49 VDD pmos W=0.205u L=0.04u
M20470 U2418/net49 n1828 VDD VDD pmos W=0.205u L=0.04u
M20471 U2418/net43 n1274 VDD VDD pmos W=0.205u L=0.04u
M20472 WX5252 n1829 VDD VDD pmos W=0.205u L=0.04u
M20473 U2419/net29 n1334 VSS VSS nmos W=0.155u L=0.04u
M20474 n1829 WX5663 U2419/net29 VSS nmos W=0.155u L=0.04u
M20475 n1829 n1322 U2419/net23 VSS nmos W=0.155u L=0.04u
M20476 U2419/net23 CRC_OUT_5_28 VSS VSS nmos W=0.155u L=0.04u
M20477 U2419/net20 CRC_OUT_5_28 n1829 VDD pmos W=0.205u L=0.04u
M20478 U2419/net20 n1322 n1829 VDD pmos W=0.205u L=0.04u
M20479 VDD WX5663 U2419/net20 VDD pmos W=0.205u L=0.04u
M20480 VDD n1334 U2419/net20 VDD pmos W=0.205u L=0.04u
M20481 n1718 n1830 VSS VSS nmos W=0.135u L=0.04u
M20482 n1718 n1830 VDD VDD pmos W=0.205u L=0.04u
M20483 U2421/net28 U2421/net20 U2421/net64 VSS nmos W=0.155u L=0.04u
M20484 U2421/net24 U2421/net30 U2421/net32 VSS nmos W=0.155u L=0.04u
M20485 U2421/net28 U2421/net40 U2421/net24 VSS nmos W=0.155u L=0.04u
M20486 U2421/net40 n1831 U2421/net108 VSS nmos W=0.155u L=0.04u
M20487 U2421/net40 U2421/net106 U2421/net104 VSS nmos W=0.155u L=0.04u
M20488 U2421/net24 WX7244 U2421/net050 VSS nmos W=0.155u L=0.04u
M20489 U2421/net050 U2421/net32 VSS VSS nmos W=0.155u L=0.04u
M20490 U2421/net20 U2421/net40 VSS VSS nmos W=0.155u L=0.04u
M20491 U2421/net106 n1831 VSS VSS nmos W=0.155u L=0.04u
M20492 U2421/net104 WX7308 VSS VSS nmos W=0.155u L=0.04u
M20493 U2421/net30 WX7244 VSS VSS nmos W=0.155u L=0.04u
M20494 U2421/net108 U2421/net104 VSS VSS nmos W=0.155u L=0.04u
M20495 n1830 U2421/net28 VSS VSS nmos W=0.155u L=0.04u
M20496 U2421/net32 WX7180 VSS VSS nmos W=0.155u L=0.04u
M20497 U2421/net64 U2421/net24 VSS VSS nmos W=0.2u L=0.04u
M20498 U2421/net28 U2421/net40 U2421/net64 VDD pmos W=0.205u L=0.04u
M20499 U2421/net24 WX7244 U2421/net32 VDD pmos W=0.205u L=0.04u
M20500 U2421/net28 U2421/net20 U2421/net24 VDD pmos W=0.205u L=0.04u
M20501 U2421/net40 U2421/net106 U2421/net108 VDD pmos W=0.205u L=0.04u
M20502 U2421/net40 n1831 U2421/net104 VDD pmos W=0.205u L=0.04u
M20503 U2421/net20 U2421/net40 VDD VDD pmos W=0.205u L=0.04u
M20504 U2421/net106 n1831 VDD VDD pmos W=0.205u L=0.04u
M20505 U2421/net104 WX7308 VDD VDD pmos W=0.205u L=0.04u
M20506 U2421/net30 WX7244 VDD VDD pmos W=0.205u L=0.04u
M20507 U2421/net108 U2421/net104 VDD VDD pmos W=0.205u L=0.04u
M20508 n1830 U2421/net28 VDD VDD pmos W=0.205u L=0.04u
M20509 U2421/net32 WX7180 VDD VDD pmos W=0.205u L=0.04u
M20510 U2421/net64 U2421/net24 VDD VDD pmos W=0.28u L=0.04u
M20511 U2421/net24 U2421/net30 U2421/net045 VDD pmos W=0.205u L=0.04u
M20512 U2421/net045 U2421/net32 VDD VDD pmos W=0.205u L=0.04u
M20513 U2422/net4 WX7116 U2422/net14 VSS nmos W=0.155u L=0.04u
M20514 U2422/net6 U2422/net10 U2422/net14 VSS nmos W=0.17u L=0.04u
M20515 U2422/net4 n1371 VSS VSS nmos W=0.155u L=0.04u
M20516 U2422/net6 U2422/net4 VSS VSS nmos W=0.17u L=0.04u
M20517 n1831 U2422/net14 VSS VSS nmos W=0.155u L=0.04u
M20518 U2422/net10 WX7116 VSS VSS nmos W=0.155u L=0.04u
M20519 U2422/net4 U2422/net10 U2422/net14 VDD pmos W=0.255u L=0.04u
M20520 U2422/net6 WX7116 U2422/net14 VDD pmos W=0.28u L=0.04u
M20521 U2422/net4 n1371 VDD VDD pmos W=0.205u L=0.04u
M20522 U2422/net6 U2422/net4 VDD VDD pmos W=0.24u L=0.04u
M20523 n1831 U2422/net14 VDD VDD pmos W=0.205u L=0.04u
M20524 U2422/net10 WX7116 VDD VDD pmos W=0.205u L=0.04u
M20525 WX5238 n1274 U2423/net26 VSS nmos W=0.155u L=0.04u
M20526 WX5238 n1722 U2423/net26 VSS nmos W=0.155u L=0.04u
M20527 U2423/net29 n1833 VSS VSS nmos W=0.155u L=0.04u
M20528 U2423/net26 n1832 U2423/net29 VSS nmos W=0.155u L=0.04u
M20529 U2423/net26 n1260 U2423/net29 VSS nmos W=0.155u L=0.04u
M20530 WX5238 n1722 U2423/net43 VDD pmos W=0.205u L=0.04u
M20531 WX5238 n1260 U2423/net49 VDD pmos W=0.205u L=0.04u
M20532 U2423/net49 n1832 VDD VDD pmos W=0.205u L=0.04u
M20533 U2423/net43 n1274 VDD VDD pmos W=0.205u L=0.04u
M20534 WX5238 n1833 VDD VDD pmos W=0.205u L=0.04u
M20535 U2424/net29 n1334 VSS VSS nmos W=0.155u L=0.04u
M20536 n1833 WX5661 U2424/net29 VSS nmos W=0.155u L=0.04u
M20537 n1833 n1322 U2424/net23 VSS nmos W=0.155u L=0.04u
M20538 U2424/net23 CRC_OUT_5_29 VSS VSS nmos W=0.155u L=0.04u
M20539 U2424/net20 CRC_OUT_5_29 n1833 VDD pmos W=0.205u L=0.04u
M20540 U2424/net20 n1322 n1833 VDD pmos W=0.205u L=0.04u
M20541 VDD WX5661 U2424/net20 VDD pmos W=0.205u L=0.04u
M20542 VDD n1334 U2424/net20 VDD pmos W=0.205u L=0.04u
M20543 n1722 n1834 VSS VSS nmos W=0.135u L=0.04u
M20544 n1722 n1834 VDD VDD pmos W=0.205u L=0.04u
M20545 U2426/net28 U2426/net20 U2426/net64 VSS nmos W=0.155u L=0.04u
M20546 U2426/net24 U2426/net30 U2426/net32 VSS nmos W=0.155u L=0.04u
M20547 U2426/net28 U2426/net40 U2426/net24 VSS nmos W=0.155u L=0.04u
M20548 U2426/net40 n1835 U2426/net108 VSS nmos W=0.155u L=0.04u
M20549 U2426/net40 U2426/net106 U2426/net104 VSS nmos W=0.155u L=0.04u
M20550 U2426/net24 WX7242 U2426/net050 VSS nmos W=0.155u L=0.04u
M20551 U2426/net050 U2426/net32 VSS VSS nmos W=0.155u L=0.04u
M20552 U2426/net20 U2426/net40 VSS VSS nmos W=0.155u L=0.04u
M20553 U2426/net106 n1835 VSS VSS nmos W=0.155u L=0.04u
M20554 U2426/net104 WX7306 VSS VSS nmos W=0.155u L=0.04u
M20555 U2426/net30 WX7242 VSS VSS nmos W=0.155u L=0.04u
M20556 U2426/net108 U2426/net104 VSS VSS nmos W=0.155u L=0.04u
M20557 n1834 U2426/net28 VSS VSS nmos W=0.155u L=0.04u
M20558 U2426/net32 WX7178 VSS VSS nmos W=0.155u L=0.04u
M20559 U2426/net64 U2426/net24 VSS VSS nmos W=0.2u L=0.04u
M20560 U2426/net28 U2426/net40 U2426/net64 VDD pmos W=0.205u L=0.04u
M20561 U2426/net24 WX7242 U2426/net32 VDD pmos W=0.205u L=0.04u
M20562 U2426/net28 U2426/net20 U2426/net24 VDD pmos W=0.205u L=0.04u
M20563 U2426/net40 U2426/net106 U2426/net108 VDD pmos W=0.205u L=0.04u
M20564 U2426/net40 n1835 U2426/net104 VDD pmos W=0.205u L=0.04u
M20565 U2426/net20 U2426/net40 VDD VDD pmos W=0.205u L=0.04u
M20566 U2426/net106 n1835 VDD VDD pmos W=0.205u L=0.04u
M20567 U2426/net104 WX7306 VDD VDD pmos W=0.205u L=0.04u
M20568 U2426/net30 WX7242 VDD VDD pmos W=0.205u L=0.04u
M20569 U2426/net108 U2426/net104 VDD VDD pmos W=0.205u L=0.04u
M20570 n1834 U2426/net28 VDD VDD pmos W=0.205u L=0.04u
M20571 U2426/net32 WX7178 VDD VDD pmos W=0.205u L=0.04u
M20572 U2426/net64 U2426/net24 VDD VDD pmos W=0.28u L=0.04u
M20573 U2426/net24 U2426/net30 U2426/net045 VDD pmos W=0.205u L=0.04u
M20574 U2426/net045 U2426/net32 VDD VDD pmos W=0.205u L=0.04u
M20575 U2427/net4 WX7114 U2427/net14 VSS nmos W=0.155u L=0.04u
M20576 U2427/net6 U2427/net10 U2427/net14 VSS nmos W=0.17u L=0.04u
M20577 U2427/net4 n1371 VSS VSS nmos W=0.155u L=0.04u
M20578 U2427/net6 U2427/net4 VSS VSS nmos W=0.17u L=0.04u
M20579 n1835 U2427/net14 VSS VSS nmos W=0.155u L=0.04u
M20580 U2427/net10 WX7114 VSS VSS nmos W=0.155u L=0.04u
M20581 U2427/net4 U2427/net10 U2427/net14 VDD pmos W=0.255u L=0.04u
M20582 U2427/net6 WX7114 U2427/net14 VDD pmos W=0.28u L=0.04u
M20583 U2427/net4 n1371 VDD VDD pmos W=0.205u L=0.04u
M20584 U2427/net6 U2427/net4 VDD VDD pmos W=0.24u L=0.04u
M20585 n1835 U2427/net14 VDD VDD pmos W=0.205u L=0.04u
M20586 U2427/net10 WX7114 VDD VDD pmos W=0.205u L=0.04u
M20587 WX5224 n1274 U2428/net26 VSS nmos W=0.155u L=0.04u
M20588 WX5224 n1726 U2428/net26 VSS nmos W=0.155u L=0.04u
M20589 U2428/net29 n1837 VSS VSS nmos W=0.155u L=0.04u
M20590 U2428/net26 n1836 U2428/net29 VSS nmos W=0.155u L=0.04u
M20591 U2428/net26 n1260 U2428/net29 VSS nmos W=0.155u L=0.04u
M20592 WX5224 n1726 U2428/net43 VDD pmos W=0.205u L=0.04u
M20593 WX5224 n1260 U2428/net49 VDD pmos W=0.205u L=0.04u
M20594 U2428/net49 n1836 VDD VDD pmos W=0.205u L=0.04u
M20595 U2428/net43 n1274 VDD VDD pmos W=0.205u L=0.04u
M20596 WX5224 n1837 VDD VDD pmos W=0.205u L=0.04u
M20597 U2429/net29 n1334 VSS VSS nmos W=0.155u L=0.04u
M20598 n1837 WX5659 U2429/net29 VSS nmos W=0.155u L=0.04u
M20599 n1837 n1322 U2429/net23 VSS nmos W=0.155u L=0.04u
M20600 U2429/net23 CRC_OUT_5_30 VSS VSS nmos W=0.155u L=0.04u
M20601 U2429/net20 CRC_OUT_5_30 n1837 VDD pmos W=0.205u L=0.04u
M20602 U2429/net20 n1322 n1837 VDD pmos W=0.205u L=0.04u
M20603 VDD WX5659 U2429/net20 VDD pmos W=0.205u L=0.04u
M20604 VDD n1334 U2429/net20 VDD pmos W=0.205u L=0.04u
M20605 n1726 n1838 VSS VSS nmos W=0.135u L=0.04u
M20606 n1726 n1838 VDD VDD pmos W=0.205u L=0.04u
M20607 U2431/net28 U2431/net20 U2431/net64 VSS nmos W=0.155u L=0.04u
M20608 U2431/net24 U2431/net30 U2431/net32 VSS nmos W=0.155u L=0.04u
M20609 U2431/net28 U2431/net40 U2431/net24 VSS nmos W=0.155u L=0.04u
M20610 U2431/net40 n1839 U2431/net108 VSS nmos W=0.155u L=0.04u
M20611 U2431/net40 U2431/net106 U2431/net104 VSS nmos W=0.155u L=0.04u
M20612 U2431/net24 WX7240 U2431/net050 VSS nmos W=0.155u L=0.04u
M20613 U2431/net050 U2431/net32 VSS VSS nmos W=0.155u L=0.04u
M20614 U2431/net20 U2431/net40 VSS VSS nmos W=0.155u L=0.04u
M20615 U2431/net106 n1839 VSS VSS nmos W=0.155u L=0.04u
M20616 U2431/net104 WX7304 VSS VSS nmos W=0.155u L=0.04u
M20617 U2431/net30 WX7240 VSS VSS nmos W=0.155u L=0.04u
M20618 U2431/net108 U2431/net104 VSS VSS nmos W=0.155u L=0.04u
M20619 n1838 U2431/net28 VSS VSS nmos W=0.155u L=0.04u
M20620 U2431/net32 WX7176 VSS VSS nmos W=0.155u L=0.04u
M20621 U2431/net64 U2431/net24 VSS VSS nmos W=0.2u L=0.04u
M20622 U2431/net28 U2431/net40 U2431/net64 VDD pmos W=0.205u L=0.04u
M20623 U2431/net24 WX7240 U2431/net32 VDD pmos W=0.205u L=0.04u
M20624 U2431/net28 U2431/net20 U2431/net24 VDD pmos W=0.205u L=0.04u
M20625 U2431/net40 U2431/net106 U2431/net108 VDD pmos W=0.205u L=0.04u
M20626 U2431/net40 n1839 U2431/net104 VDD pmos W=0.205u L=0.04u
M20627 U2431/net20 U2431/net40 VDD VDD pmos W=0.205u L=0.04u
M20628 U2431/net106 n1839 VDD VDD pmos W=0.205u L=0.04u
M20629 U2431/net104 WX7304 VDD VDD pmos W=0.205u L=0.04u
M20630 U2431/net30 WX7240 VDD VDD pmos W=0.205u L=0.04u
M20631 U2431/net108 U2431/net104 VDD VDD pmos W=0.205u L=0.04u
M20632 n1838 U2431/net28 VDD VDD pmos W=0.205u L=0.04u
M20633 U2431/net32 WX7176 VDD VDD pmos W=0.205u L=0.04u
M20634 U2431/net64 U2431/net24 VDD VDD pmos W=0.28u L=0.04u
M20635 U2431/net24 U2431/net30 U2431/net045 VDD pmos W=0.205u L=0.04u
M20636 U2431/net045 U2431/net32 VDD VDD pmos W=0.205u L=0.04u
M20637 U2432/net4 WX7112 U2432/net14 VSS nmos W=0.155u L=0.04u
M20638 U2432/net6 U2432/net10 U2432/net14 VSS nmos W=0.17u L=0.04u
M20639 U2432/net4 n1371 VSS VSS nmos W=0.155u L=0.04u
M20640 U2432/net6 U2432/net4 VSS VSS nmos W=0.17u L=0.04u
M20641 n1839 U2432/net14 VSS VSS nmos W=0.155u L=0.04u
M20642 U2432/net10 WX7112 VSS VSS nmos W=0.155u L=0.04u
M20643 U2432/net4 U2432/net10 U2432/net14 VDD pmos W=0.255u L=0.04u
M20644 U2432/net6 WX7112 U2432/net14 VDD pmos W=0.28u L=0.04u
M20645 U2432/net4 n1371 VDD VDD pmos W=0.205u L=0.04u
M20646 U2432/net6 U2432/net4 VDD VDD pmos W=0.24u L=0.04u
M20647 n1839 U2432/net14 VDD VDD pmos W=0.205u L=0.04u
M20648 U2432/net10 WX7112 VDD VDD pmos W=0.205u L=0.04u
M20649 WX5210 n1615 U2433/net26 VSS nmos W=0.155u L=0.04u
M20650 WX5210 n1390 U2433/net26 VSS nmos W=0.155u L=0.04u
M20651 U2433/net29 n1840 VSS VSS nmos W=0.155u L=0.04u
M20652 U2433/net26 WX5655 U2433/net29 VSS nmos W=0.155u L=0.04u
M20653 U2433/net26 n1500 U2433/net29 VSS nmos W=0.155u L=0.04u
M20654 WX5210 n1390 U2433/net43 VDD pmos W=0.205u L=0.04u
M20655 WX5210 n1500 U2433/net49 VDD pmos W=0.205u L=0.04u
M20656 U2433/net49 WX5655 VDD VDD pmos W=0.205u L=0.04u
M20657 U2433/net43 n1615 VDD VDD pmos W=0.205u L=0.04u
M20658 WX5210 n1840 VDD VDD pmos W=0.205u L=0.04u
M20659 U2434/net29 n1841 VSS VSS nmos W=0.155u L=0.04u
M20660 n1840 n1430 U2434/net29 VSS nmos W=0.155u L=0.04u
M20661 n1840 n1617 U2434/net23 VSS nmos W=0.155u L=0.04u
M20662 U2434/net23 n1731 VSS VSS nmos W=0.155u L=0.04u
M20663 U2434/net20 n1731 n1840 VDD pmos W=0.205u L=0.04u
M20664 U2434/net20 n1617 n1840 VDD pmos W=0.205u L=0.04u
M20665 VDD n1430 U2434/net20 VDD pmos W=0.205u L=0.04u
M20666 VDD n1841 U2434/net20 VDD pmos W=0.205u L=0.04u
M20667 U2435/net28 U2435/net20 U2435/net64 VSS nmos W=0.155u L=0.04u
M20668 U2435/net24 U2435/net30 U2435/net32 VSS nmos W=0.155u L=0.04u
M20669 U2435/net28 U2435/net40 U2435/net24 VSS nmos W=0.155u L=0.04u
M20670 U2435/net40 n1842 U2435/net108 VSS nmos W=0.155u L=0.04u
M20671 U2435/net40 U2435/net106 U2435/net104 VSS nmos W=0.155u L=0.04u
M20672 U2435/net24 WX7238 U2435/net050 VSS nmos W=0.155u L=0.04u
M20673 U2435/net050 U2435/net32 VSS VSS nmos W=0.155u L=0.04u
M20674 U2435/net20 U2435/net40 VSS VSS nmos W=0.155u L=0.04u
M20675 U2435/net106 n1842 VSS VSS nmos W=0.155u L=0.04u
M20676 U2435/net104 WX7302 VSS VSS nmos W=0.155u L=0.04u
M20677 U2435/net30 WX7238 VSS VSS nmos W=0.155u L=0.04u
M20678 U2435/net108 U2435/net104 VSS VSS nmos W=0.155u L=0.04u
M20679 n1731 U2435/net28 VSS VSS nmos W=0.155u L=0.04u
M20680 U2435/net32 WX7174 VSS VSS nmos W=0.155u L=0.04u
M20681 U2435/net64 U2435/net24 VSS VSS nmos W=0.2u L=0.04u
M20682 U2435/net28 U2435/net40 U2435/net64 VDD pmos W=0.205u L=0.04u
M20683 U2435/net24 WX7238 U2435/net32 VDD pmos W=0.205u L=0.04u
M20684 U2435/net28 U2435/net20 U2435/net24 VDD pmos W=0.205u L=0.04u
M20685 U2435/net40 U2435/net106 U2435/net108 VDD pmos W=0.205u L=0.04u
M20686 U2435/net40 n1842 U2435/net104 VDD pmos W=0.205u L=0.04u
M20687 U2435/net20 U2435/net40 VDD VDD pmos W=0.205u L=0.04u
M20688 U2435/net106 n1842 VDD VDD pmos W=0.205u L=0.04u
M20689 U2435/net104 WX7302 VDD VDD pmos W=0.205u L=0.04u
M20690 U2435/net30 WX7238 VDD VDD pmos W=0.205u L=0.04u
M20691 U2435/net108 U2435/net104 VDD VDD pmos W=0.205u L=0.04u
M20692 n1731 U2435/net28 VDD VDD pmos W=0.205u L=0.04u
M20693 U2435/net32 WX7174 VDD VDD pmos W=0.205u L=0.04u
M20694 U2435/net64 U2435/net24 VDD VDD pmos W=0.28u L=0.04u
M20695 U2435/net24 U2435/net30 U2435/net045 VDD pmos W=0.205u L=0.04u
M20696 U2435/net045 U2435/net32 VDD VDD pmos W=0.205u L=0.04u
M20697 U2436/net4 WX7110 U2436/net14 VSS nmos W=0.155u L=0.04u
M20698 U2436/net6 U2436/net10 U2436/net14 VSS nmos W=0.17u L=0.04u
M20699 U2436/net4 n1371 VSS VSS nmos W=0.155u L=0.04u
M20700 U2436/net6 U2436/net4 VSS VSS nmos W=0.17u L=0.04u
M20701 n1842 U2436/net14 VSS VSS nmos W=0.155u L=0.04u
M20702 U2436/net10 WX7110 VSS VSS nmos W=0.155u L=0.04u
M20703 U2436/net4 U2436/net10 U2436/net14 VDD pmos W=0.255u L=0.04u
M20704 U2436/net6 WX7110 U2436/net14 VDD pmos W=0.28u L=0.04u
M20705 U2436/net4 n1371 VDD VDD pmos W=0.205u L=0.04u
M20706 U2436/net6 U2436/net4 VDD VDD pmos W=0.24u L=0.04u
M20707 n1842 U2436/net14 VDD VDD pmos W=0.205u L=0.04u
M20708 U2436/net10 WX7110 VDD VDD pmos W=0.205u L=0.04u
M20709 WX5655 WX5657 VSS VSS nmos W=0.135u L=0.04u
M20710 WX5655 WX5657 VDD VDD pmos W=0.205u L=0.04u
M20711 n1390 CRC_OUT_5_31 VSS VSS nmos W=0.135u L=0.04u
M20712 n1390 CRC_OUT_5_31 VDD VDD pmos W=0.205u L=0.04u
M20713 WX52 U2439/net31 VDD VDD pmos W=0.205u L=0.04u
M20714 U2439/net30 n1354 U2439/net31 VDD pmos W=0.205u L=0.04u
M20715 U2439/net30 WX487 U2439/net31 VDD pmos W=0.205u L=0.04u
M20716 VDD n1844 U2439/net36 VDD pmos W=0.205u L=0.04u
M20717 U2439/net36 n1430 U2439/net30 VDD pmos W=0.205u L=0.04u
M20718 U2439/net36 n1843 U2439/net30 VDD pmos W=0.205u L=0.04u
M20719 U2439/net31 n1844 VSS VSS nmos W=0.155u L=0.04u
M20720 WX52 U2439/net31 VSS VSS nmos W=0.155u L=0.04u
M20721 U2439/net31 n1843 U2439/XI17-net17 VSS nmos W=0.155u L=0.04u
M20722 U2439/XI17-net17 n1430 VSS VSS nmos W=0.155u L=0.04u
M20723 U2439/net31 n1354 U2439/XI1-net17 VSS nmos W=0.155u L=0.04u
M20724 U2439/XI1-net17 WX487 VSS VSS nmos W=0.155u L=0.04u
M20725 U2440/net8 n1303 U2440/net26 VSS nmos W=0.155u L=0.04u
M20726 U2440/net26 CRC_OUT_9_30 VSS VSS nmos W=0.155u L=0.04u
M20727 U2440/net29 U2440/net8 VSS VSS nmos W=0.155u L=0.04u
M20728 U2440/net29 n1292 n1844 VSS nmos W=0.155u L=0.04u
M20729 U2440/net29 n1845 n1844 VSS nmos W=0.155u L=0.04u
M20730 U2440/net8 CRC_OUT_9_30 VDD VDD pmos W=0.205u L=0.04u
M20731 U2440/net8 n1303 VDD VDD pmos W=0.205u L=0.04u
M20732 n1844 U2440/net8 VDD VDD pmos W=0.205u L=0.04u
M20733 n1844 n1292 U2440/net20 VDD pmos W=0.205u L=0.04u
M20734 U2440/net20 n1845 VDD VDD pmos W=0.205u L=0.04u
M20735 WX472 n1273 U2441/net26 VSS nmos W=0.155u L=0.04u
M20736 WX472 n1846 U2441/net26 VSS nmos W=0.155u L=0.04u
M20737 U2441/net29 n1848 VSS VSS nmos W=0.155u L=0.04u
M20738 U2441/net26 n1847 U2441/net29 VSS nmos W=0.155u L=0.04u
M20739 U2441/net26 n1260 U2441/net29 VSS nmos W=0.155u L=0.04u
M20740 WX472 n1846 U2441/net43 VDD pmos W=0.205u L=0.04u
M20741 WX472 n1260 U2441/net49 VDD pmos W=0.205u L=0.04u
M20742 U2441/net49 n1847 VDD VDD pmos W=0.205u L=0.04u
M20743 U2441/net43 n1273 VDD VDD pmos W=0.205u L=0.04u
M20744 WX472 n1848 VDD VDD pmos W=0.205u L=0.04u
M20745 U2442/net29 n1333 VSS VSS nmos W=0.155u L=0.04u
M20746 n1848 WX547 U2442/net29 VSS nmos W=0.155u L=0.04u
M20747 n1848 n1321 U2442/net23 VSS nmos W=0.155u L=0.04u
M20748 U2442/net23 CRC_OUT_9_0 VSS VSS nmos W=0.155u L=0.04u
M20749 U2442/net20 CRC_OUT_9_0 n1848 VDD pmos W=0.205u L=0.04u
M20750 U2442/net20 n1321 n1848 VDD pmos W=0.205u L=0.04u
M20751 VDD WX547 U2442/net20 VDD pmos W=0.205u L=0.04u
M20752 VDD n1333 U2442/net20 VDD pmos W=0.205u L=0.04u
M20753 WX458 n1273 U2443/net26 VSS nmos W=0.155u L=0.04u
M20754 WX458 n1849 U2443/net26 VSS nmos W=0.155u L=0.04u
M20755 U2443/net29 n1851 VSS VSS nmos W=0.155u L=0.04u
M20756 U2443/net26 n1850 U2443/net29 VSS nmos W=0.155u L=0.04u
M20757 U2443/net26 n1260 U2443/net29 VSS nmos W=0.155u L=0.04u
M20758 WX458 n1849 U2443/net43 VDD pmos W=0.205u L=0.04u
M20759 WX458 n1260 U2443/net49 VDD pmos W=0.205u L=0.04u
M20760 U2443/net49 n1850 VDD VDD pmos W=0.205u L=0.04u
M20761 U2443/net43 n1273 VDD VDD pmos W=0.205u L=0.04u
M20762 WX458 n1851 VDD VDD pmos W=0.205u L=0.04u
M20763 U2444/net29 n1333 VSS VSS nmos W=0.155u L=0.04u
M20764 n1851 WX545 U2444/net29 VSS nmos W=0.155u L=0.04u
M20765 n1851 n1321 U2444/net23 VSS nmos W=0.155u L=0.04u
M20766 U2444/net23 CRC_OUT_9_1 VSS VSS nmos W=0.155u L=0.04u
M20767 U2444/net20 CRC_OUT_9_1 n1851 VDD pmos W=0.205u L=0.04u
M20768 U2444/net20 n1321 n1851 VDD pmos W=0.205u L=0.04u
M20769 VDD WX545 U2444/net20 VDD pmos W=0.205u L=0.04u
M20770 VDD n1333 U2444/net20 VDD pmos W=0.205u L=0.04u
M20771 WX444 n1273 U2445/net26 VSS nmos W=0.155u L=0.04u
M20772 WX444 n1852 U2445/net26 VSS nmos W=0.155u L=0.04u
M20773 U2445/net29 n1854 VSS VSS nmos W=0.155u L=0.04u
M20774 U2445/net26 n1853 U2445/net29 VSS nmos W=0.155u L=0.04u
M20775 U2445/net26 n1259 U2445/net29 VSS nmos W=0.155u L=0.04u
M20776 WX444 n1852 U2445/net43 VDD pmos W=0.205u L=0.04u
M20777 WX444 n1259 U2445/net49 VDD pmos W=0.205u L=0.04u
M20778 U2445/net49 n1853 VDD VDD pmos W=0.205u L=0.04u
M20779 U2445/net43 n1273 VDD VDD pmos W=0.205u L=0.04u
M20780 WX444 n1854 VDD VDD pmos W=0.205u L=0.04u
M20781 U2446/net29 n1333 VSS VSS nmos W=0.155u L=0.04u
M20782 n1854 WX543 U2446/net29 VSS nmos W=0.155u L=0.04u
M20783 n1854 n1321 U2446/net23 VSS nmos W=0.155u L=0.04u
M20784 U2446/net23 CRC_OUT_9_2 VSS VSS nmos W=0.155u L=0.04u
M20785 U2446/net20 CRC_OUT_9_2 n1854 VDD pmos W=0.205u L=0.04u
M20786 U2446/net20 n1321 n1854 VDD pmos W=0.205u L=0.04u
M20787 VDD WX543 U2446/net20 VDD pmos W=0.205u L=0.04u
M20788 VDD n1333 U2446/net20 VDD pmos W=0.205u L=0.04u
M20789 WX4351 n1273 U2447/net26 VSS nmos W=0.155u L=0.04u
M20790 WX4351 n1733 U2447/net26 VSS nmos W=0.155u L=0.04u
M20791 U2447/net29 n1856 VSS VSS nmos W=0.155u L=0.04u
M20792 U2447/net26 n1855 U2447/net29 VSS nmos W=0.155u L=0.04u
M20793 U2447/net26 n1259 U2447/net29 VSS nmos W=0.155u L=0.04u
M20794 WX4351 n1733 U2447/net43 VDD pmos W=0.205u L=0.04u
M20795 WX4351 n1259 U2447/net49 VDD pmos W=0.205u L=0.04u
M20796 U2447/net49 n1855 VDD VDD pmos W=0.205u L=0.04u
M20797 U2447/net43 n1273 VDD VDD pmos W=0.205u L=0.04u
M20798 WX4351 n1856 VDD VDD pmos W=0.205u L=0.04u
M20799 U2448/net29 n1333 VSS VSS nmos W=0.155u L=0.04u
M20800 n1856 WX4426 U2448/net29 VSS nmos W=0.155u L=0.04u
M20801 n1856 n1321 U2448/net23 VSS nmos W=0.155u L=0.04u
M20802 U2448/net23 CRC_OUT_6_0 VSS VSS nmos W=0.155u L=0.04u
M20803 U2448/net20 CRC_OUT_6_0 n1856 VDD pmos W=0.205u L=0.04u
M20804 U2448/net20 n1321 n1856 VDD pmos W=0.205u L=0.04u
M20805 VDD WX4426 U2448/net20 VDD pmos W=0.205u L=0.04u
M20806 VDD n1333 U2448/net20 VDD pmos W=0.205u L=0.04u
M20807 U2449/net28 U2449/net20 U2449/net64 VSS nmos W=0.155u L=0.04u
M20808 U2449/net24 U2449/net30 U2449/net32 VSS nmos W=0.155u L=0.04u
M20809 U2449/net28 U2449/net40 U2449/net24 VSS nmos W=0.155u L=0.04u
M20810 U2449/net40 WX6007 U2449/net108 VSS nmos W=0.155u L=0.04u
M20811 U2449/net40 U2449/net106 U2449/net104 VSS nmos W=0.155u L=0.04u
M20812 U2449/net24 WX5943 U2449/net050 VSS nmos W=0.155u L=0.04u
M20813 U2449/net050 U2449/net32 VSS VSS nmos W=0.155u L=0.04u
M20814 U2449/net20 U2449/net40 VSS VSS nmos W=0.155u L=0.04u
M20815 U2449/net106 WX6007 VSS VSS nmos W=0.155u L=0.04u
M20816 U2449/net104 n1391 VSS VSS nmos W=0.155u L=0.04u
M20817 U2449/net30 WX5943 VSS VSS nmos W=0.155u L=0.04u
M20818 U2449/net108 U2449/net104 VSS VSS nmos W=0.155u L=0.04u
M20819 n1733 U2449/net28 VSS VSS nmos W=0.155u L=0.04u
M20820 U2449/net32 WX5879 VSS VSS nmos W=0.155u L=0.04u
M20821 U2449/net64 U2449/net24 VSS VSS nmos W=0.2u L=0.04u
M20822 U2449/net28 U2449/net40 U2449/net64 VDD pmos W=0.205u L=0.04u
M20823 U2449/net24 WX5943 U2449/net32 VDD pmos W=0.205u L=0.04u
M20824 U2449/net28 U2449/net20 U2449/net24 VDD pmos W=0.205u L=0.04u
M20825 U2449/net40 U2449/net106 U2449/net108 VDD pmos W=0.205u L=0.04u
M20826 U2449/net40 WX6007 U2449/net104 VDD pmos W=0.205u L=0.04u
M20827 U2449/net20 U2449/net40 VDD VDD pmos W=0.205u L=0.04u
M20828 U2449/net106 WX6007 VDD VDD pmos W=0.205u L=0.04u
M20829 U2449/net104 n1391 VDD VDD pmos W=0.205u L=0.04u
M20830 U2449/net30 WX5943 VDD VDD pmos W=0.205u L=0.04u
M20831 U2449/net108 U2449/net104 VDD VDD pmos W=0.205u L=0.04u
M20832 n1733 U2449/net28 VDD VDD pmos W=0.205u L=0.04u
M20833 U2449/net32 WX5879 VDD VDD pmos W=0.205u L=0.04u
M20834 U2449/net64 U2449/net24 VDD VDD pmos W=0.28u L=0.04u
M20835 U2449/net24 U2449/net30 U2449/net045 VDD pmos W=0.205u L=0.04u
M20836 U2449/net045 U2449/net32 VDD VDD pmos W=0.205u L=0.04u
M20837 n1391 WX6071 VSS VSS nmos W=0.135u L=0.04u
M20838 n1391 WX6071 VDD VDD pmos W=0.205u L=0.04u
M20839 WX4337 n1273 U2451/net26 VSS nmos W=0.155u L=0.04u
M20840 WX4337 n1735 U2451/net26 VSS nmos W=0.155u L=0.04u
M20841 U2451/net29 n1858 VSS VSS nmos W=0.155u L=0.04u
M20842 U2451/net26 n1857 U2451/net29 VSS nmos W=0.155u L=0.04u
M20843 U2451/net26 n1259 U2451/net29 VSS nmos W=0.155u L=0.04u
M20844 WX4337 n1735 U2451/net43 VDD pmos W=0.205u L=0.04u
M20845 WX4337 n1259 U2451/net49 VDD pmos W=0.205u L=0.04u
M20846 U2451/net49 n1857 VDD VDD pmos W=0.205u L=0.04u
M20847 U2451/net43 n1273 VDD VDD pmos W=0.205u L=0.04u
M20848 WX4337 n1858 VDD VDD pmos W=0.205u L=0.04u
M20849 U2452/net29 n1333 VSS VSS nmos W=0.155u L=0.04u
M20850 n1858 WX4424 U2452/net29 VSS nmos W=0.155u L=0.04u
M20851 n1858 n1321 U2452/net23 VSS nmos W=0.155u L=0.04u
M20852 U2452/net23 CRC_OUT_6_1 VSS VSS nmos W=0.155u L=0.04u
M20853 U2452/net20 CRC_OUT_6_1 n1858 VDD pmos W=0.205u L=0.04u
M20854 U2452/net20 n1321 n1858 VDD pmos W=0.205u L=0.04u
M20855 VDD WX4424 U2452/net20 VDD pmos W=0.205u L=0.04u
M20856 VDD n1333 U2452/net20 VDD pmos W=0.205u L=0.04u
M20857 n1735 n1859 VSS VSS nmos W=0.135u L=0.04u
M20858 n1735 n1859 VDD VDD pmos W=0.205u L=0.04u
M20859 U2454/net28 U2454/net20 U2454/net64 VSS nmos W=0.155u L=0.04u
M20860 U2454/net24 U2454/net30 U2454/net32 VSS nmos W=0.155u L=0.04u
M20861 U2454/net28 U2454/net40 U2454/net24 VSS nmos W=0.155u L=0.04u
M20862 U2454/net40 WX6005 U2454/net108 VSS nmos W=0.155u L=0.04u
M20863 U2454/net40 U2454/net106 U2454/net104 VSS nmos W=0.155u L=0.04u
M20864 U2454/net24 WX5941 U2454/net050 VSS nmos W=0.155u L=0.04u
M20865 U2454/net050 U2454/net32 VSS VSS nmos W=0.155u L=0.04u
M20866 U2454/net20 U2454/net40 VSS VSS nmos W=0.155u L=0.04u
M20867 U2454/net106 WX6005 VSS VSS nmos W=0.155u L=0.04u
M20868 U2454/net104 WX6069 VSS VSS nmos W=0.155u L=0.04u
M20869 U2454/net30 WX5941 VSS VSS nmos W=0.155u L=0.04u
M20870 U2454/net108 U2454/net104 VSS VSS nmos W=0.155u L=0.04u
M20871 n1859 U2454/net28 VSS VSS nmos W=0.155u L=0.04u
M20872 U2454/net32 WX5877 VSS VSS nmos W=0.155u L=0.04u
M20873 U2454/net64 U2454/net24 VSS VSS nmos W=0.2u L=0.04u
M20874 U2454/net28 U2454/net40 U2454/net64 VDD pmos W=0.205u L=0.04u
M20875 U2454/net24 WX5941 U2454/net32 VDD pmos W=0.205u L=0.04u
M20876 U2454/net28 U2454/net20 U2454/net24 VDD pmos W=0.205u L=0.04u
M20877 U2454/net40 U2454/net106 U2454/net108 VDD pmos W=0.205u L=0.04u
M20878 U2454/net40 WX6005 U2454/net104 VDD pmos W=0.205u L=0.04u
M20879 U2454/net20 U2454/net40 VDD VDD pmos W=0.205u L=0.04u
M20880 U2454/net106 WX6005 VDD VDD pmos W=0.205u L=0.04u
M20881 U2454/net104 WX6069 VDD VDD pmos W=0.205u L=0.04u
M20882 U2454/net30 WX5941 VDD VDD pmos W=0.205u L=0.04u
M20883 U2454/net108 U2454/net104 VDD VDD pmos W=0.205u L=0.04u
M20884 n1859 U2454/net28 VDD VDD pmos W=0.205u L=0.04u
M20885 U2454/net32 WX5877 VDD VDD pmos W=0.205u L=0.04u
M20886 U2454/net64 U2454/net24 VDD VDD pmos W=0.28u L=0.04u
M20887 U2454/net24 U2454/net30 U2454/net045 VDD pmos W=0.205u L=0.04u
M20888 U2454/net045 U2454/net32 VDD VDD pmos W=0.205u L=0.04u
M20889 WX4323 n1273 U2455/net26 VSS nmos W=0.155u L=0.04u
M20890 WX4323 n1738 U2455/net26 VSS nmos W=0.155u L=0.04u
M20891 U2455/net29 n1861 VSS VSS nmos W=0.155u L=0.04u
M20892 U2455/net26 n1860 U2455/net29 VSS nmos W=0.155u L=0.04u
M20893 U2455/net26 n1259 U2455/net29 VSS nmos W=0.155u L=0.04u
M20894 WX4323 n1738 U2455/net43 VDD pmos W=0.205u L=0.04u
M20895 WX4323 n1259 U2455/net49 VDD pmos W=0.205u L=0.04u
M20896 U2455/net49 n1860 VDD VDD pmos W=0.205u L=0.04u
M20897 U2455/net43 n1273 VDD VDD pmos W=0.205u L=0.04u
M20898 WX4323 n1861 VDD VDD pmos W=0.205u L=0.04u
M20899 U2456/net29 n1333 VSS VSS nmos W=0.155u L=0.04u
M20900 n1861 WX4422 U2456/net29 VSS nmos W=0.155u L=0.04u
M20901 n1861 n1321 U2456/net23 VSS nmos W=0.155u L=0.04u
M20902 U2456/net23 CRC_OUT_6_2 VSS VSS nmos W=0.155u L=0.04u
M20903 U2456/net20 CRC_OUT_6_2 n1861 VDD pmos W=0.205u L=0.04u
M20904 U2456/net20 n1321 n1861 VDD pmos W=0.205u L=0.04u
M20905 VDD WX4422 U2456/net20 VDD pmos W=0.205u L=0.04u
M20906 VDD n1333 U2456/net20 VDD pmos W=0.205u L=0.04u
M20907 n1738 n1862 VSS VSS nmos W=0.135u L=0.04u
M20908 n1738 n1862 VDD VDD pmos W=0.205u L=0.04u
M20909 U2458/net28 U2458/net20 U2458/net64 VSS nmos W=0.155u L=0.04u
M20910 U2458/net24 U2458/net30 U2458/net32 VSS nmos W=0.155u L=0.04u
M20911 U2458/net28 U2458/net40 U2458/net24 VSS nmos W=0.155u L=0.04u
M20912 U2458/net40 WX6003 U2458/net108 VSS nmos W=0.155u L=0.04u
M20913 U2458/net40 U2458/net106 U2458/net104 VSS nmos W=0.155u L=0.04u
M20914 U2458/net24 WX5939 U2458/net050 VSS nmos W=0.155u L=0.04u
M20915 U2458/net050 U2458/net32 VSS VSS nmos W=0.155u L=0.04u
M20916 U2458/net20 U2458/net40 VSS VSS nmos W=0.155u L=0.04u
M20917 U2458/net106 WX6003 VSS VSS nmos W=0.155u L=0.04u
M20918 U2458/net104 WX6067 VSS VSS nmos W=0.155u L=0.04u
M20919 U2458/net30 WX5939 VSS VSS nmos W=0.155u L=0.04u
M20920 U2458/net108 U2458/net104 VSS VSS nmos W=0.155u L=0.04u
M20921 n1862 U2458/net28 VSS VSS nmos W=0.155u L=0.04u
M20922 U2458/net32 WX5875 VSS VSS nmos W=0.155u L=0.04u
M20923 U2458/net64 U2458/net24 VSS VSS nmos W=0.2u L=0.04u
M20924 U2458/net28 U2458/net40 U2458/net64 VDD pmos W=0.205u L=0.04u
M20925 U2458/net24 WX5939 U2458/net32 VDD pmos W=0.205u L=0.04u
M20926 U2458/net28 U2458/net20 U2458/net24 VDD pmos W=0.205u L=0.04u
M20927 U2458/net40 U2458/net106 U2458/net108 VDD pmos W=0.205u L=0.04u
M20928 U2458/net40 WX6003 U2458/net104 VDD pmos W=0.205u L=0.04u
M20929 U2458/net20 U2458/net40 VDD VDD pmos W=0.205u L=0.04u
M20930 U2458/net106 WX6003 VDD VDD pmos W=0.205u L=0.04u
M20931 U2458/net104 WX6067 VDD VDD pmos W=0.205u L=0.04u
M20932 U2458/net30 WX5939 VDD VDD pmos W=0.205u L=0.04u
M20933 U2458/net108 U2458/net104 VDD VDD pmos W=0.205u L=0.04u
M20934 n1862 U2458/net28 VDD VDD pmos W=0.205u L=0.04u
M20935 U2458/net32 WX5875 VDD VDD pmos W=0.205u L=0.04u
M20936 U2458/net64 U2458/net24 VDD VDD pmos W=0.28u L=0.04u
M20937 U2458/net24 U2458/net30 U2458/net045 VDD pmos W=0.205u L=0.04u
M20938 U2458/net045 U2458/net32 VDD VDD pmos W=0.205u L=0.04u
M20939 WX4309 n1273 U2459/net26 VSS nmos W=0.155u L=0.04u
M20940 WX4309 n1741 U2459/net26 VSS nmos W=0.155u L=0.04u
M20941 U2459/net29 n1864 VSS VSS nmos W=0.155u L=0.04u
M20942 U2459/net26 n1863 U2459/net29 VSS nmos W=0.155u L=0.04u
M20943 U2459/net26 n1259 U2459/net29 VSS nmos W=0.155u L=0.04u
M20944 WX4309 n1741 U2459/net43 VDD pmos W=0.205u L=0.04u
M20945 WX4309 n1259 U2459/net49 VDD pmos W=0.205u L=0.04u
M20946 U2459/net49 n1863 VDD VDD pmos W=0.205u L=0.04u
M20947 U2459/net43 n1273 VDD VDD pmos W=0.205u L=0.04u
M20948 WX4309 n1864 VDD VDD pmos W=0.205u L=0.04u
M20949 U2460/net29 n1333 VSS VSS nmos W=0.155u L=0.04u
M20950 n1864 WX4420 U2460/net29 VSS nmos W=0.155u L=0.04u
M20951 n1864 n1321 U2460/net23 VSS nmos W=0.155u L=0.04u
M20952 U2460/net23 CRC_OUT_6_3 VSS VSS nmos W=0.155u L=0.04u
M20953 U2460/net20 CRC_OUT_6_3 n1864 VDD pmos W=0.205u L=0.04u
M20954 U2460/net20 n1321 n1864 VDD pmos W=0.205u L=0.04u
M20955 VDD WX4420 U2460/net20 VDD pmos W=0.205u L=0.04u
M20956 VDD n1333 U2460/net20 VDD pmos W=0.205u L=0.04u
M20957 n1741 n1865 VSS VSS nmos W=0.135u L=0.04u
M20958 n1741 n1865 VDD VDD pmos W=0.205u L=0.04u
M20959 U2462/net28 U2462/net20 U2462/net64 VSS nmos W=0.155u L=0.04u
M20960 U2462/net24 U2462/net30 U2462/net32 VSS nmos W=0.155u L=0.04u
M20961 U2462/net28 U2462/net40 U2462/net24 VSS nmos W=0.155u L=0.04u
M20962 U2462/net40 WX6001 U2462/net108 VSS nmos W=0.155u L=0.04u
M20963 U2462/net40 U2462/net106 U2462/net104 VSS nmos W=0.155u L=0.04u
M20964 U2462/net24 WX5937 U2462/net050 VSS nmos W=0.155u L=0.04u
M20965 U2462/net050 U2462/net32 VSS VSS nmos W=0.155u L=0.04u
M20966 U2462/net20 U2462/net40 VSS VSS nmos W=0.155u L=0.04u
M20967 U2462/net106 WX6001 VSS VSS nmos W=0.155u L=0.04u
M20968 U2462/net104 WX6065 VSS VSS nmos W=0.155u L=0.04u
M20969 U2462/net30 WX5937 VSS VSS nmos W=0.155u L=0.04u
M20970 U2462/net108 U2462/net104 VSS VSS nmos W=0.155u L=0.04u
M20971 n1865 U2462/net28 VSS VSS nmos W=0.155u L=0.04u
M20972 U2462/net32 WX5873 VSS VSS nmos W=0.155u L=0.04u
M20973 U2462/net64 U2462/net24 VSS VSS nmos W=0.2u L=0.04u
M20974 U2462/net28 U2462/net40 U2462/net64 VDD pmos W=0.205u L=0.04u
M20975 U2462/net24 WX5937 U2462/net32 VDD pmos W=0.205u L=0.04u
M20976 U2462/net28 U2462/net20 U2462/net24 VDD pmos W=0.205u L=0.04u
M20977 U2462/net40 U2462/net106 U2462/net108 VDD pmos W=0.205u L=0.04u
M20978 U2462/net40 WX6001 U2462/net104 VDD pmos W=0.205u L=0.04u
M20979 U2462/net20 U2462/net40 VDD VDD pmos W=0.205u L=0.04u
M20980 U2462/net106 WX6001 VDD VDD pmos W=0.205u L=0.04u
M20981 U2462/net104 WX6065 VDD VDD pmos W=0.205u L=0.04u
M20982 U2462/net30 WX5937 VDD VDD pmos W=0.205u L=0.04u
M20983 U2462/net108 U2462/net104 VDD VDD pmos W=0.205u L=0.04u
M20984 n1865 U2462/net28 VDD VDD pmos W=0.205u L=0.04u
M20985 U2462/net32 WX5873 VDD VDD pmos W=0.205u L=0.04u
M20986 U2462/net64 U2462/net24 VDD VDD pmos W=0.28u L=0.04u
M20987 U2462/net24 U2462/net30 U2462/net045 VDD pmos W=0.205u L=0.04u
M20988 U2462/net045 U2462/net32 VDD VDD pmos W=0.205u L=0.04u
M20989 WX430 n1273 U2463/net26 VSS nmos W=0.155u L=0.04u
M20990 WX430 n1866 U2463/net26 VSS nmos W=0.155u L=0.04u
M20991 U2463/net29 n1868 VSS VSS nmos W=0.155u L=0.04u
M20992 U2463/net26 n1867 U2463/net29 VSS nmos W=0.155u L=0.04u
M20993 U2463/net26 n1259 U2463/net29 VSS nmos W=0.155u L=0.04u
M20994 WX430 n1866 U2463/net43 VDD pmos W=0.205u L=0.04u
M20995 WX430 n1259 U2463/net49 VDD pmos W=0.205u L=0.04u
M20996 U2463/net49 n1867 VDD VDD pmos W=0.205u L=0.04u
M20997 U2463/net43 n1273 VDD VDD pmos W=0.205u L=0.04u
M20998 WX430 n1868 VDD VDD pmos W=0.205u L=0.04u
M20999 U2464/net29 n1333 VSS VSS nmos W=0.155u L=0.04u
M21000 n1868 WX541 U2464/net29 VSS nmos W=0.155u L=0.04u
M21001 n1868 n1321 U2464/net23 VSS nmos W=0.155u L=0.04u
M21002 U2464/net23 CRC_OUT_9_3 VSS VSS nmos W=0.155u L=0.04u
M21003 U2464/net20 CRC_OUT_9_3 n1868 VDD pmos W=0.205u L=0.04u
M21004 U2464/net20 n1321 n1868 VDD pmos W=0.205u L=0.04u
M21005 VDD WX541 U2464/net20 VDD pmos W=0.205u L=0.04u
M21006 VDD n1333 U2464/net20 VDD pmos W=0.205u L=0.04u
M21007 WX4295 n1273 U2465/net26 VSS nmos W=0.155u L=0.04u
M21008 WX4295 n1744 U2465/net26 VSS nmos W=0.155u L=0.04u
M21009 U2465/net29 n1870 VSS VSS nmos W=0.155u L=0.04u
M21010 U2465/net26 n1869 U2465/net29 VSS nmos W=0.155u L=0.04u
M21011 U2465/net26 n1259 U2465/net29 VSS nmos W=0.155u L=0.04u
M21012 WX4295 n1744 U2465/net43 VDD pmos W=0.205u L=0.04u
M21013 WX4295 n1259 U2465/net49 VDD pmos W=0.205u L=0.04u
M21014 U2465/net49 n1869 VDD VDD pmos W=0.205u L=0.04u
M21015 U2465/net43 n1273 VDD VDD pmos W=0.205u L=0.04u
M21016 WX4295 n1870 VDD VDD pmos W=0.205u L=0.04u
M21017 U2466/net29 n1333 VSS VSS nmos W=0.155u L=0.04u
M21018 n1870 WX4418 U2466/net29 VSS nmos W=0.155u L=0.04u
M21019 n1870 n1321 U2466/net23 VSS nmos W=0.155u L=0.04u
M21020 U2466/net23 CRC_OUT_6_4 VSS VSS nmos W=0.155u L=0.04u
M21021 U2466/net20 CRC_OUT_6_4 n1870 VDD pmos W=0.205u L=0.04u
M21022 U2466/net20 n1321 n1870 VDD pmos W=0.205u L=0.04u
M21023 VDD WX4418 U2466/net20 VDD pmos W=0.205u L=0.04u
M21024 VDD n1333 U2466/net20 VDD pmos W=0.205u L=0.04u
M21025 n1744 n1871 VSS VSS nmos W=0.135u L=0.04u
M21026 n1744 n1871 VDD VDD pmos W=0.205u L=0.04u
M21027 U2468/net28 U2468/net20 U2468/net64 VSS nmos W=0.155u L=0.04u
M21028 U2468/net24 U2468/net30 U2468/net32 VSS nmos W=0.155u L=0.04u
M21029 U2468/net28 U2468/net40 U2468/net24 VSS nmos W=0.155u L=0.04u
M21030 U2468/net40 WX5999 U2468/net108 VSS nmos W=0.155u L=0.04u
M21031 U2468/net40 U2468/net106 U2468/net104 VSS nmos W=0.155u L=0.04u
M21032 U2468/net24 WX5935 U2468/net050 VSS nmos W=0.155u L=0.04u
M21033 U2468/net050 U2468/net32 VSS VSS nmos W=0.155u L=0.04u
M21034 U2468/net20 U2468/net40 VSS VSS nmos W=0.155u L=0.04u
M21035 U2468/net106 WX5999 VSS VSS nmos W=0.155u L=0.04u
M21036 U2468/net104 WX6063 VSS VSS nmos W=0.155u L=0.04u
M21037 U2468/net30 WX5935 VSS VSS nmos W=0.155u L=0.04u
M21038 U2468/net108 U2468/net104 VSS VSS nmos W=0.155u L=0.04u
M21039 n1871 U2468/net28 VSS VSS nmos W=0.155u L=0.04u
M21040 U2468/net32 WX5871 VSS VSS nmos W=0.155u L=0.04u
M21041 U2468/net64 U2468/net24 VSS VSS nmos W=0.2u L=0.04u
M21042 U2468/net28 U2468/net40 U2468/net64 VDD pmos W=0.205u L=0.04u
M21043 U2468/net24 WX5935 U2468/net32 VDD pmos W=0.205u L=0.04u
M21044 U2468/net28 U2468/net20 U2468/net24 VDD pmos W=0.205u L=0.04u
M21045 U2468/net40 U2468/net106 U2468/net108 VDD pmos W=0.205u L=0.04u
M21046 U2468/net40 WX5999 U2468/net104 VDD pmos W=0.205u L=0.04u
M21047 U2468/net20 U2468/net40 VDD VDD pmos W=0.205u L=0.04u
M21048 U2468/net106 WX5999 VDD VDD pmos W=0.205u L=0.04u
M21049 U2468/net104 WX6063 VDD VDD pmos W=0.205u L=0.04u
M21050 U2468/net30 WX5935 VDD VDD pmos W=0.205u L=0.04u
M21051 U2468/net108 U2468/net104 VDD VDD pmos W=0.205u L=0.04u
M21052 n1871 U2468/net28 VDD VDD pmos W=0.205u L=0.04u
M21053 U2468/net32 WX5871 VDD VDD pmos W=0.205u L=0.04u
M21054 U2468/net64 U2468/net24 VDD VDD pmos W=0.28u L=0.04u
M21055 U2468/net24 U2468/net30 U2468/net045 VDD pmos W=0.205u L=0.04u
M21056 U2468/net045 U2468/net32 VDD VDD pmos W=0.205u L=0.04u
M21057 WX4281 n1273 U2469/net26 VSS nmos W=0.155u L=0.04u
M21058 WX4281 n1747 U2469/net26 VSS nmos W=0.155u L=0.04u
M21059 U2469/net29 n1873 VSS VSS nmos W=0.155u L=0.04u
M21060 U2469/net26 n1872 U2469/net29 VSS nmos W=0.155u L=0.04u
M21061 U2469/net26 n1259 U2469/net29 VSS nmos W=0.155u L=0.04u
M21062 WX4281 n1747 U2469/net43 VDD pmos W=0.205u L=0.04u
M21063 WX4281 n1259 U2469/net49 VDD pmos W=0.205u L=0.04u
M21064 U2469/net49 n1872 VDD VDD pmos W=0.205u L=0.04u
M21065 U2469/net43 n1273 VDD VDD pmos W=0.205u L=0.04u
M21066 WX4281 n1873 VDD VDD pmos W=0.205u L=0.04u
M21067 U2470/net29 n1333 VSS VSS nmos W=0.155u L=0.04u
M21068 n1873 WX4416 U2470/net29 VSS nmos W=0.155u L=0.04u
M21069 n1873 n1321 U2470/net23 VSS nmos W=0.155u L=0.04u
M21070 U2470/net23 CRC_OUT_6_5 VSS VSS nmos W=0.155u L=0.04u
M21071 U2470/net20 CRC_OUT_6_5 n1873 VDD pmos W=0.205u L=0.04u
M21072 U2470/net20 n1321 n1873 VDD pmos W=0.205u L=0.04u
M21073 VDD WX4416 U2470/net20 VDD pmos W=0.205u L=0.04u
M21074 VDD n1333 U2470/net20 VDD pmos W=0.205u L=0.04u
M21075 n1747 n1874 VSS VSS nmos W=0.135u L=0.04u
M21076 n1747 n1874 VDD VDD pmos W=0.205u L=0.04u
M21077 U2472/net28 U2472/net20 U2472/net64 VSS nmos W=0.155u L=0.04u
M21078 U2472/net24 U2472/net30 U2472/net32 VSS nmos W=0.155u L=0.04u
M21079 U2472/net28 U2472/net40 U2472/net24 VSS nmos W=0.155u L=0.04u
M21080 U2472/net40 WX5997 U2472/net108 VSS nmos W=0.155u L=0.04u
M21081 U2472/net40 U2472/net106 U2472/net104 VSS nmos W=0.155u L=0.04u
M21082 U2472/net24 WX5933 U2472/net050 VSS nmos W=0.155u L=0.04u
M21083 U2472/net050 U2472/net32 VSS VSS nmos W=0.155u L=0.04u
M21084 U2472/net20 U2472/net40 VSS VSS nmos W=0.155u L=0.04u
M21085 U2472/net106 WX5997 VSS VSS nmos W=0.155u L=0.04u
M21086 U2472/net104 WX6061 VSS VSS nmos W=0.155u L=0.04u
M21087 U2472/net30 WX5933 VSS VSS nmos W=0.155u L=0.04u
M21088 U2472/net108 U2472/net104 VSS VSS nmos W=0.155u L=0.04u
M21089 n1874 U2472/net28 VSS VSS nmos W=0.155u L=0.04u
M21090 U2472/net32 WX5869 VSS VSS nmos W=0.155u L=0.04u
M21091 U2472/net64 U2472/net24 VSS VSS nmos W=0.2u L=0.04u
M21092 U2472/net28 U2472/net40 U2472/net64 VDD pmos W=0.205u L=0.04u
M21093 U2472/net24 WX5933 U2472/net32 VDD pmos W=0.205u L=0.04u
M21094 U2472/net28 U2472/net20 U2472/net24 VDD pmos W=0.205u L=0.04u
M21095 U2472/net40 U2472/net106 U2472/net108 VDD pmos W=0.205u L=0.04u
M21096 U2472/net40 WX5997 U2472/net104 VDD pmos W=0.205u L=0.04u
M21097 U2472/net20 U2472/net40 VDD VDD pmos W=0.205u L=0.04u
M21098 U2472/net106 WX5997 VDD VDD pmos W=0.205u L=0.04u
M21099 U2472/net104 WX6061 VDD VDD pmos W=0.205u L=0.04u
M21100 U2472/net30 WX5933 VDD VDD pmos W=0.205u L=0.04u
M21101 U2472/net108 U2472/net104 VDD VDD pmos W=0.205u L=0.04u
M21102 n1874 U2472/net28 VDD VDD pmos W=0.205u L=0.04u
M21103 U2472/net32 WX5869 VDD VDD pmos W=0.205u L=0.04u
M21104 U2472/net64 U2472/net24 VDD VDD pmos W=0.28u L=0.04u
M21105 U2472/net24 U2472/net30 U2472/net045 VDD pmos W=0.205u L=0.04u
M21106 U2472/net045 U2472/net32 VDD VDD pmos W=0.205u L=0.04u
M21107 WX4267 n1273 U2473/net26 VSS nmos W=0.155u L=0.04u
M21108 WX4267 n1750 U2473/net26 VSS nmos W=0.155u L=0.04u
M21109 U2473/net29 n1876 VSS VSS nmos W=0.155u L=0.04u
M21110 U2473/net26 n1875 U2473/net29 VSS nmos W=0.155u L=0.04u
M21111 U2473/net26 n1259 U2473/net29 VSS nmos W=0.155u L=0.04u
M21112 WX4267 n1750 U2473/net43 VDD pmos W=0.205u L=0.04u
M21113 WX4267 n1259 U2473/net49 VDD pmos W=0.205u L=0.04u
M21114 U2473/net49 n1875 VDD VDD pmos W=0.205u L=0.04u
M21115 U2473/net43 n1273 VDD VDD pmos W=0.205u L=0.04u
M21116 WX4267 n1876 VDD VDD pmos W=0.205u L=0.04u
M21117 U2474/net29 n1333 VSS VSS nmos W=0.155u L=0.04u
M21118 n1876 WX4414 U2474/net29 VSS nmos W=0.155u L=0.04u
M21119 n1876 n1321 U2474/net23 VSS nmos W=0.155u L=0.04u
M21120 U2474/net23 CRC_OUT_6_6 VSS VSS nmos W=0.155u L=0.04u
M21121 U2474/net20 CRC_OUT_6_6 n1876 VDD pmos W=0.205u L=0.04u
M21122 U2474/net20 n1321 n1876 VDD pmos W=0.205u L=0.04u
M21123 VDD WX4414 U2474/net20 VDD pmos W=0.205u L=0.04u
M21124 VDD n1333 U2474/net20 VDD pmos W=0.205u L=0.04u
M21125 n1750 n1877 VSS VSS nmos W=0.135u L=0.04u
M21126 n1750 n1877 VDD VDD pmos W=0.205u L=0.04u
M21127 U2476/net28 U2476/net20 U2476/net64 VSS nmos W=0.155u L=0.04u
M21128 U2476/net24 U2476/net30 U2476/net32 VSS nmos W=0.155u L=0.04u
M21129 U2476/net28 U2476/net40 U2476/net24 VSS nmos W=0.155u L=0.04u
M21130 U2476/net40 WX5995 U2476/net108 VSS nmos W=0.155u L=0.04u
M21131 U2476/net40 U2476/net106 U2476/net104 VSS nmos W=0.155u L=0.04u
M21132 U2476/net24 WX5931 U2476/net050 VSS nmos W=0.155u L=0.04u
M21133 U2476/net050 U2476/net32 VSS VSS nmos W=0.155u L=0.04u
M21134 U2476/net20 U2476/net40 VSS VSS nmos W=0.155u L=0.04u
M21135 U2476/net106 WX5995 VSS VSS nmos W=0.155u L=0.04u
M21136 U2476/net104 WX6059 VSS VSS nmos W=0.155u L=0.04u
M21137 U2476/net30 WX5931 VSS VSS nmos W=0.155u L=0.04u
M21138 U2476/net108 U2476/net104 VSS VSS nmos W=0.155u L=0.04u
M21139 n1877 U2476/net28 VSS VSS nmos W=0.155u L=0.04u
M21140 U2476/net32 WX5867 VSS VSS nmos W=0.155u L=0.04u
M21141 U2476/net64 U2476/net24 VSS VSS nmos W=0.2u L=0.04u
M21142 U2476/net28 U2476/net40 U2476/net64 VDD pmos W=0.205u L=0.04u
M21143 U2476/net24 WX5931 U2476/net32 VDD pmos W=0.205u L=0.04u
M21144 U2476/net28 U2476/net20 U2476/net24 VDD pmos W=0.205u L=0.04u
M21145 U2476/net40 U2476/net106 U2476/net108 VDD pmos W=0.205u L=0.04u
M21146 U2476/net40 WX5995 U2476/net104 VDD pmos W=0.205u L=0.04u
M21147 U2476/net20 U2476/net40 VDD VDD pmos W=0.205u L=0.04u
M21148 U2476/net106 WX5995 VDD VDD pmos W=0.205u L=0.04u
M21149 U2476/net104 WX6059 VDD VDD pmos W=0.205u L=0.04u
M21150 U2476/net30 WX5931 VDD VDD pmos W=0.205u L=0.04u
M21151 U2476/net108 U2476/net104 VDD VDD pmos W=0.205u L=0.04u
M21152 n1877 U2476/net28 VDD VDD pmos W=0.205u L=0.04u
M21153 U2476/net32 WX5867 VDD VDD pmos W=0.205u L=0.04u
M21154 U2476/net64 U2476/net24 VDD VDD pmos W=0.28u L=0.04u
M21155 U2476/net24 U2476/net30 U2476/net045 VDD pmos W=0.205u L=0.04u
M21156 U2476/net045 U2476/net32 VDD VDD pmos W=0.205u L=0.04u
M21157 WX4253 n1273 U2477/net26 VSS nmos W=0.155u L=0.04u
M21158 WX4253 n1753 U2477/net26 VSS nmos W=0.155u L=0.04u
M21159 U2477/net29 n1879 VSS VSS nmos W=0.155u L=0.04u
M21160 U2477/net26 n1878 U2477/net29 VSS nmos W=0.155u L=0.04u
M21161 U2477/net26 n1259 U2477/net29 VSS nmos W=0.155u L=0.04u
M21162 WX4253 n1753 U2477/net43 VDD pmos W=0.205u L=0.04u
M21163 WX4253 n1259 U2477/net49 VDD pmos W=0.205u L=0.04u
M21164 U2477/net49 n1878 VDD VDD pmos W=0.205u L=0.04u
M21165 U2477/net43 n1273 VDD VDD pmos W=0.205u L=0.04u
M21166 WX4253 n1879 VDD VDD pmos W=0.205u L=0.04u
M21167 U2478/net29 n1333 VSS VSS nmos W=0.155u L=0.04u
M21168 n1879 WX4412 U2478/net29 VSS nmos W=0.155u L=0.04u
M21169 n1879 n1321 U2478/net23 VSS nmos W=0.155u L=0.04u
M21170 U2478/net23 CRC_OUT_6_7 VSS VSS nmos W=0.155u L=0.04u
M21171 U2478/net20 CRC_OUT_6_7 n1879 VDD pmos W=0.205u L=0.04u
M21172 U2478/net20 n1321 n1879 VDD pmos W=0.205u L=0.04u
M21173 VDD WX4412 U2478/net20 VDD pmos W=0.205u L=0.04u
M21174 VDD n1333 U2478/net20 VDD pmos W=0.205u L=0.04u
M21175 n1753 n1880 VSS VSS nmos W=0.135u L=0.04u
M21176 n1753 n1880 VDD VDD pmos W=0.205u L=0.04u
M21177 U2480/net28 U2480/net20 U2480/net64 VSS nmos W=0.155u L=0.04u
M21178 U2480/net24 U2480/net30 U2480/net32 VSS nmos W=0.155u L=0.04u
M21179 U2480/net28 U2480/net40 U2480/net24 VSS nmos W=0.155u L=0.04u
M21180 U2480/net40 WX5993 U2480/net108 VSS nmos W=0.155u L=0.04u
M21181 U2480/net40 U2480/net106 U2480/net104 VSS nmos W=0.155u L=0.04u
M21182 U2480/net24 WX5929 U2480/net050 VSS nmos W=0.155u L=0.04u
M21183 U2480/net050 U2480/net32 VSS VSS nmos W=0.155u L=0.04u
M21184 U2480/net20 U2480/net40 VSS VSS nmos W=0.155u L=0.04u
M21185 U2480/net106 WX5993 VSS VSS nmos W=0.155u L=0.04u
M21186 U2480/net104 WX6057 VSS VSS nmos W=0.155u L=0.04u
M21187 U2480/net30 WX5929 VSS VSS nmos W=0.155u L=0.04u
M21188 U2480/net108 U2480/net104 VSS VSS nmos W=0.155u L=0.04u
M21189 n1880 U2480/net28 VSS VSS nmos W=0.155u L=0.04u
M21190 U2480/net32 WX5865 VSS VSS nmos W=0.155u L=0.04u
M21191 U2480/net64 U2480/net24 VSS VSS nmos W=0.2u L=0.04u
M21192 U2480/net28 U2480/net40 U2480/net64 VDD pmos W=0.205u L=0.04u
M21193 U2480/net24 WX5929 U2480/net32 VDD pmos W=0.205u L=0.04u
M21194 U2480/net28 U2480/net20 U2480/net24 VDD pmos W=0.205u L=0.04u
M21195 U2480/net40 U2480/net106 U2480/net108 VDD pmos W=0.205u L=0.04u
M21196 U2480/net40 WX5993 U2480/net104 VDD pmos W=0.205u L=0.04u
M21197 U2480/net20 U2480/net40 VDD VDD pmos W=0.205u L=0.04u
M21198 U2480/net106 WX5993 VDD VDD pmos W=0.205u L=0.04u
M21199 U2480/net104 WX6057 VDD VDD pmos W=0.205u L=0.04u
M21200 U2480/net30 WX5929 VDD VDD pmos W=0.205u L=0.04u
M21201 U2480/net108 U2480/net104 VDD VDD pmos W=0.205u L=0.04u
M21202 n1880 U2480/net28 VDD VDD pmos W=0.205u L=0.04u
M21203 U2480/net32 WX5865 VDD VDD pmos W=0.205u L=0.04u
M21204 U2480/net64 U2480/net24 VDD VDD pmos W=0.28u L=0.04u
M21205 U2480/net24 U2480/net30 U2480/net045 VDD pmos W=0.205u L=0.04u
M21206 U2480/net045 U2480/net32 VDD VDD pmos W=0.205u L=0.04u
M21207 WX4239 n1277 U2481/net26 VSS nmos W=0.155u L=0.04u
M21208 WX4239 n1756 U2481/net26 VSS nmos W=0.155u L=0.04u
M21209 U2481/net29 n1882 VSS VSS nmos W=0.155u L=0.04u
M21210 U2481/net26 n1881 U2481/net29 VSS nmos W=0.155u L=0.04u
M21211 U2481/net26 n1259 U2481/net29 VSS nmos W=0.155u L=0.04u
M21212 WX4239 n1756 U2481/net43 VDD pmos W=0.205u L=0.04u
M21213 WX4239 n1259 U2481/net49 VDD pmos W=0.205u L=0.04u
M21214 U2481/net49 n1881 VDD VDD pmos W=0.205u L=0.04u
M21215 U2481/net43 n1277 VDD VDD pmos W=0.205u L=0.04u
M21216 WX4239 n1882 VDD VDD pmos W=0.205u L=0.04u
M21217 U2482/net29 n1338 VSS VSS nmos W=0.155u L=0.04u
M21218 n1882 WX4410 U2482/net29 VSS nmos W=0.155u L=0.04u
M21219 n1882 n1321 U2482/net23 VSS nmos W=0.155u L=0.04u
M21220 U2482/net23 CRC_OUT_6_8 VSS VSS nmos W=0.155u L=0.04u
M21221 U2482/net20 CRC_OUT_6_8 n1882 VDD pmos W=0.205u L=0.04u
M21222 U2482/net20 n1321 n1882 VDD pmos W=0.205u L=0.04u
M21223 VDD WX4410 U2482/net20 VDD pmos W=0.205u L=0.04u
M21224 VDD n1338 U2482/net20 VDD pmos W=0.205u L=0.04u
M21225 n1756 n1883 VSS VSS nmos W=0.135u L=0.04u
M21226 n1756 n1883 VDD VDD pmos W=0.205u L=0.04u
M21227 U2484/net28 U2484/net20 U2484/net64 VSS nmos W=0.155u L=0.04u
M21228 U2484/net24 U2484/net30 U2484/net32 VSS nmos W=0.155u L=0.04u
M21229 U2484/net28 U2484/net40 U2484/net24 VSS nmos W=0.155u L=0.04u
M21230 U2484/net40 WX5991 U2484/net108 VSS nmos W=0.155u L=0.04u
M21231 U2484/net40 U2484/net106 U2484/net104 VSS nmos W=0.155u L=0.04u
M21232 U2484/net24 WX5927 U2484/net050 VSS nmos W=0.155u L=0.04u
M21233 U2484/net050 U2484/net32 VSS VSS nmos W=0.155u L=0.04u
M21234 U2484/net20 U2484/net40 VSS VSS nmos W=0.155u L=0.04u
M21235 U2484/net106 WX5991 VSS VSS nmos W=0.155u L=0.04u
M21236 U2484/net104 WX6055 VSS VSS nmos W=0.155u L=0.04u
M21237 U2484/net30 WX5927 VSS VSS nmos W=0.155u L=0.04u
M21238 U2484/net108 U2484/net104 VSS VSS nmos W=0.155u L=0.04u
M21239 n1883 U2484/net28 VSS VSS nmos W=0.155u L=0.04u
M21240 U2484/net32 WX5863 VSS VSS nmos W=0.155u L=0.04u
M21241 U2484/net64 U2484/net24 VSS VSS nmos W=0.2u L=0.04u
M21242 U2484/net28 U2484/net40 U2484/net64 VDD pmos W=0.205u L=0.04u
M21243 U2484/net24 WX5927 U2484/net32 VDD pmos W=0.205u L=0.04u
M21244 U2484/net28 U2484/net20 U2484/net24 VDD pmos W=0.205u L=0.04u
M21245 U2484/net40 U2484/net106 U2484/net108 VDD pmos W=0.205u L=0.04u
M21246 U2484/net40 WX5991 U2484/net104 VDD pmos W=0.205u L=0.04u
M21247 U2484/net20 U2484/net40 VDD VDD pmos W=0.205u L=0.04u
M21248 U2484/net106 WX5991 VDD VDD pmos W=0.205u L=0.04u
M21249 U2484/net104 WX6055 VDD VDD pmos W=0.205u L=0.04u
M21250 U2484/net30 WX5927 VDD VDD pmos W=0.205u L=0.04u
M21251 U2484/net108 U2484/net104 VDD VDD pmos W=0.205u L=0.04u
M21252 n1883 U2484/net28 VDD VDD pmos W=0.205u L=0.04u
M21253 U2484/net32 WX5863 VDD VDD pmos W=0.205u L=0.04u
M21254 U2484/net64 U2484/net24 VDD VDD pmos W=0.28u L=0.04u
M21255 U2484/net24 U2484/net30 U2484/net045 VDD pmos W=0.205u L=0.04u
M21256 U2484/net045 U2484/net32 VDD VDD pmos W=0.205u L=0.04u
M21257 WX4225 n1286 U2485/net26 VSS nmos W=0.155u L=0.04u
M21258 WX4225 n1759 U2485/net26 VSS nmos W=0.155u L=0.04u
M21259 U2485/net29 n1885 VSS VSS nmos W=0.155u L=0.04u
M21260 U2485/net26 n1884 U2485/net29 VSS nmos W=0.155u L=0.04u
M21261 U2485/net26 n1259 U2485/net29 VSS nmos W=0.155u L=0.04u
M21262 WX4225 n1759 U2485/net43 VDD pmos W=0.205u L=0.04u
M21263 WX4225 n1259 U2485/net49 VDD pmos W=0.205u L=0.04u
M21264 U2485/net49 n1884 VDD VDD pmos W=0.205u L=0.04u
M21265 U2485/net43 n1286 VDD VDD pmos W=0.205u L=0.04u
M21266 WX4225 n1885 VDD VDD pmos W=0.205u L=0.04u
M21267 U2486/net29 n1353 VSS VSS nmos W=0.155u L=0.04u
M21268 n1885 WX4408 U2486/net29 VSS nmos W=0.155u L=0.04u
M21269 n1885 n1320 U2486/net23 VSS nmos W=0.155u L=0.04u
M21270 U2486/net23 CRC_OUT_6_9 VSS VSS nmos W=0.155u L=0.04u
M21271 U2486/net20 CRC_OUT_6_9 n1885 VDD pmos W=0.205u L=0.04u
M21272 U2486/net20 n1320 n1885 VDD pmos W=0.205u L=0.04u
M21273 VDD WX4408 U2486/net20 VDD pmos W=0.205u L=0.04u
M21274 VDD n1353 U2486/net20 VDD pmos W=0.205u L=0.04u
M21275 n1759 n1886 VSS VSS nmos W=0.135u L=0.04u
M21276 n1759 n1886 VDD VDD pmos W=0.205u L=0.04u
M21277 U2488/net28 U2488/net20 U2488/net64 VSS nmos W=0.155u L=0.04u
M21278 U2488/net24 U2488/net30 U2488/net32 VSS nmos W=0.155u L=0.04u
M21279 U2488/net28 U2488/net40 U2488/net24 VSS nmos W=0.155u L=0.04u
M21280 U2488/net40 WX5989 U2488/net108 VSS nmos W=0.155u L=0.04u
M21281 U2488/net40 U2488/net106 U2488/net104 VSS nmos W=0.155u L=0.04u
M21282 U2488/net24 WX5925 U2488/net050 VSS nmos W=0.155u L=0.04u
M21283 U2488/net050 U2488/net32 VSS VSS nmos W=0.155u L=0.04u
M21284 U2488/net20 U2488/net40 VSS VSS nmos W=0.155u L=0.04u
M21285 U2488/net106 WX5989 VSS VSS nmos W=0.155u L=0.04u
M21286 U2488/net104 WX6053 VSS VSS nmos W=0.155u L=0.04u
M21287 U2488/net30 WX5925 VSS VSS nmos W=0.155u L=0.04u
M21288 U2488/net108 U2488/net104 VSS VSS nmos W=0.155u L=0.04u
M21289 n1886 U2488/net28 VSS VSS nmos W=0.155u L=0.04u
M21290 U2488/net32 WX5861 VSS VSS nmos W=0.155u L=0.04u
M21291 U2488/net64 U2488/net24 VSS VSS nmos W=0.2u L=0.04u
M21292 U2488/net28 U2488/net40 U2488/net64 VDD pmos W=0.205u L=0.04u
M21293 U2488/net24 WX5925 U2488/net32 VDD pmos W=0.205u L=0.04u
M21294 U2488/net28 U2488/net20 U2488/net24 VDD pmos W=0.205u L=0.04u
M21295 U2488/net40 U2488/net106 U2488/net108 VDD pmos W=0.205u L=0.04u
M21296 U2488/net40 WX5989 U2488/net104 VDD pmos W=0.205u L=0.04u
M21297 U2488/net20 U2488/net40 VDD VDD pmos W=0.205u L=0.04u
M21298 U2488/net106 WX5989 VDD VDD pmos W=0.205u L=0.04u
M21299 U2488/net104 WX6053 VDD VDD pmos W=0.205u L=0.04u
M21300 U2488/net30 WX5925 VDD VDD pmos W=0.205u L=0.04u
M21301 U2488/net108 U2488/net104 VDD VDD pmos W=0.205u L=0.04u
M21302 n1886 U2488/net28 VDD VDD pmos W=0.205u L=0.04u
M21303 U2488/net32 WX5861 VDD VDD pmos W=0.205u L=0.04u
M21304 U2488/net64 U2488/net24 VDD VDD pmos W=0.28u L=0.04u
M21305 U2488/net24 U2488/net30 U2488/net045 VDD pmos W=0.205u L=0.04u
M21306 U2488/net045 U2488/net32 VDD VDD pmos W=0.205u L=0.04u
M21307 WX4211 n1287 U2489/net26 VSS nmos W=0.155u L=0.04u
M21308 WX4211 n1762 U2489/net26 VSS nmos W=0.155u L=0.04u
M21309 U2489/net29 n1888 VSS VSS nmos W=0.155u L=0.04u
M21310 U2489/net26 n1887 U2489/net29 VSS nmos W=0.155u L=0.04u
M21311 U2489/net26 n1259 U2489/net29 VSS nmos W=0.155u L=0.04u
M21312 WX4211 n1762 U2489/net43 VDD pmos W=0.205u L=0.04u
M21313 WX4211 n1259 U2489/net49 VDD pmos W=0.205u L=0.04u
M21314 U2489/net49 n1887 VDD VDD pmos W=0.205u L=0.04u
M21315 U2489/net43 n1287 VDD VDD pmos W=0.205u L=0.04u
M21316 WX4211 n1888 VDD VDD pmos W=0.205u L=0.04u
M21317 U2490/net29 n1354 VSS VSS nmos W=0.155u L=0.04u
M21318 n1888 WX4406 U2490/net29 VSS nmos W=0.155u L=0.04u
M21319 n1888 n1320 U2490/net23 VSS nmos W=0.155u L=0.04u
M21320 U2490/net23 CRC_OUT_6_10 VSS VSS nmos W=0.155u L=0.04u
M21321 U2490/net20 CRC_OUT_6_10 n1888 VDD pmos W=0.205u L=0.04u
M21322 U2490/net20 n1320 n1888 VDD pmos W=0.205u L=0.04u
M21323 VDD WX4406 U2490/net20 VDD pmos W=0.205u L=0.04u
M21324 VDD n1354 U2490/net20 VDD pmos W=0.205u L=0.04u
M21325 n1762 n1889 VSS VSS nmos W=0.135u L=0.04u
M21326 n1762 n1889 VDD VDD pmos W=0.205u L=0.04u
M21327 U2492/net28 U2492/net20 U2492/net64 VSS nmos W=0.155u L=0.04u
M21328 U2492/net24 U2492/net30 U2492/net32 VSS nmos W=0.155u L=0.04u
M21329 U2492/net28 U2492/net40 U2492/net24 VSS nmos W=0.155u L=0.04u
M21330 U2492/net40 WX5987 U2492/net108 VSS nmos W=0.155u L=0.04u
M21331 U2492/net40 U2492/net106 U2492/net104 VSS nmos W=0.155u L=0.04u
M21332 U2492/net24 WX5923 U2492/net050 VSS nmos W=0.155u L=0.04u
M21333 U2492/net050 U2492/net32 VSS VSS nmos W=0.155u L=0.04u
M21334 U2492/net20 U2492/net40 VSS VSS nmos W=0.155u L=0.04u
M21335 U2492/net106 WX5987 VSS VSS nmos W=0.155u L=0.04u
M21336 U2492/net104 WX6051 VSS VSS nmos W=0.155u L=0.04u
M21337 U2492/net30 WX5923 VSS VSS nmos W=0.155u L=0.04u
M21338 U2492/net108 U2492/net104 VSS VSS nmos W=0.155u L=0.04u
M21339 n1889 U2492/net28 VSS VSS nmos W=0.155u L=0.04u
M21340 U2492/net32 WX5859 VSS VSS nmos W=0.155u L=0.04u
M21341 U2492/net64 U2492/net24 VSS VSS nmos W=0.2u L=0.04u
M21342 U2492/net28 U2492/net40 U2492/net64 VDD pmos W=0.205u L=0.04u
M21343 U2492/net24 WX5923 U2492/net32 VDD pmos W=0.205u L=0.04u
M21344 U2492/net28 U2492/net20 U2492/net24 VDD pmos W=0.205u L=0.04u
M21345 U2492/net40 U2492/net106 U2492/net108 VDD pmos W=0.205u L=0.04u
M21346 U2492/net40 WX5987 U2492/net104 VDD pmos W=0.205u L=0.04u
M21347 U2492/net20 U2492/net40 VDD VDD pmos W=0.205u L=0.04u
M21348 U2492/net106 WX5987 VDD VDD pmos W=0.205u L=0.04u
M21349 U2492/net104 WX6051 VDD VDD pmos W=0.205u L=0.04u
M21350 U2492/net30 WX5923 VDD VDD pmos W=0.205u L=0.04u
M21351 U2492/net108 U2492/net104 VDD VDD pmos W=0.205u L=0.04u
M21352 n1889 U2492/net28 VDD VDD pmos W=0.205u L=0.04u
M21353 U2492/net32 WX5859 VDD VDD pmos W=0.205u L=0.04u
M21354 U2492/net64 U2492/net24 VDD VDD pmos W=0.28u L=0.04u
M21355 U2492/net24 U2492/net30 U2492/net045 VDD pmos W=0.205u L=0.04u
M21356 U2492/net045 U2492/net32 VDD VDD pmos W=0.205u L=0.04u
M21357 WX4197 n1287 U2493/net26 VSS nmos W=0.155u L=0.04u
M21358 WX4197 n1765 U2493/net26 VSS nmos W=0.155u L=0.04u
M21359 U2493/net29 n1891 VSS VSS nmos W=0.155u L=0.04u
M21360 U2493/net26 n1890 U2493/net29 VSS nmos W=0.155u L=0.04u
M21361 U2493/net26 n1258 U2493/net29 VSS nmos W=0.155u L=0.04u
M21362 WX4197 n1765 U2493/net43 VDD pmos W=0.205u L=0.04u
M21363 WX4197 n1258 U2493/net49 VDD pmos W=0.205u L=0.04u
M21364 U2493/net49 n1890 VDD VDD pmos W=0.205u L=0.04u
M21365 U2493/net43 n1287 VDD VDD pmos W=0.205u L=0.04u
M21366 WX4197 n1891 VDD VDD pmos W=0.205u L=0.04u
M21367 U2494/net29 n1354 VSS VSS nmos W=0.155u L=0.04u
M21368 n1891 WX4404 U2494/net29 VSS nmos W=0.155u L=0.04u
M21369 n1891 n1320 U2494/net23 VSS nmos W=0.155u L=0.04u
M21370 U2494/net23 CRC_OUT_6_11 VSS VSS nmos W=0.155u L=0.04u
M21371 U2494/net20 CRC_OUT_6_11 n1891 VDD pmos W=0.205u L=0.04u
M21372 U2494/net20 n1320 n1891 VDD pmos W=0.205u L=0.04u
M21373 VDD WX4404 U2494/net20 VDD pmos W=0.205u L=0.04u
M21374 VDD n1354 U2494/net20 VDD pmos W=0.205u L=0.04u
M21375 n1765 n1892 VSS VSS nmos W=0.135u L=0.04u
M21376 n1765 n1892 VDD VDD pmos W=0.205u L=0.04u
M21377 U2496/net28 U2496/net20 U2496/net64 VSS nmos W=0.155u L=0.04u
M21378 U2496/net24 U2496/net30 U2496/net32 VSS nmos W=0.155u L=0.04u
M21379 U2496/net28 U2496/net40 U2496/net24 VSS nmos W=0.155u L=0.04u
M21380 U2496/net40 WX5985 U2496/net108 VSS nmos W=0.155u L=0.04u
M21381 U2496/net40 U2496/net106 U2496/net104 VSS nmos W=0.155u L=0.04u
M21382 U2496/net24 WX5921 U2496/net050 VSS nmos W=0.155u L=0.04u
M21383 U2496/net050 U2496/net32 VSS VSS nmos W=0.155u L=0.04u
M21384 U2496/net20 U2496/net40 VSS VSS nmos W=0.155u L=0.04u
M21385 U2496/net106 WX5985 VSS VSS nmos W=0.155u L=0.04u
M21386 U2496/net104 WX6049 VSS VSS nmos W=0.155u L=0.04u
M21387 U2496/net30 WX5921 VSS VSS nmos W=0.155u L=0.04u
M21388 U2496/net108 U2496/net104 VSS VSS nmos W=0.155u L=0.04u
M21389 n1892 U2496/net28 VSS VSS nmos W=0.155u L=0.04u
M21390 U2496/net32 WX5857 VSS VSS nmos W=0.155u L=0.04u
M21391 U2496/net64 U2496/net24 VSS VSS nmos W=0.2u L=0.04u
M21392 U2496/net28 U2496/net40 U2496/net64 VDD pmos W=0.205u L=0.04u
M21393 U2496/net24 WX5921 U2496/net32 VDD pmos W=0.205u L=0.04u
M21394 U2496/net28 U2496/net20 U2496/net24 VDD pmos W=0.205u L=0.04u
M21395 U2496/net40 U2496/net106 U2496/net108 VDD pmos W=0.205u L=0.04u
M21396 U2496/net40 WX5985 U2496/net104 VDD pmos W=0.205u L=0.04u
M21397 U2496/net20 U2496/net40 VDD VDD pmos W=0.205u L=0.04u
M21398 U2496/net106 WX5985 VDD VDD pmos W=0.205u L=0.04u
M21399 U2496/net104 WX6049 VDD VDD pmos W=0.205u L=0.04u
M21400 U2496/net30 WX5921 VDD VDD pmos W=0.205u L=0.04u
M21401 U2496/net108 U2496/net104 VDD VDD pmos W=0.205u L=0.04u
M21402 n1892 U2496/net28 VDD VDD pmos W=0.205u L=0.04u
M21403 U2496/net32 WX5857 VDD VDD pmos W=0.205u L=0.04u
M21404 U2496/net64 U2496/net24 VDD VDD pmos W=0.28u L=0.04u
M21405 U2496/net24 U2496/net30 U2496/net045 VDD pmos W=0.205u L=0.04u
M21406 U2496/net045 U2496/net32 VDD VDD pmos W=0.205u L=0.04u
M21407 WX4183 n1287 U2497/net26 VSS nmos W=0.155u L=0.04u
M21408 WX4183 n1768 U2497/net26 VSS nmos W=0.155u L=0.04u
M21409 U2497/net29 n1894 VSS VSS nmos W=0.155u L=0.04u
M21410 U2497/net26 n1893 U2497/net29 VSS nmos W=0.155u L=0.04u
M21411 U2497/net26 n1258 U2497/net29 VSS nmos W=0.155u L=0.04u
M21412 WX4183 n1768 U2497/net43 VDD pmos W=0.205u L=0.04u
M21413 WX4183 n1258 U2497/net49 VDD pmos W=0.205u L=0.04u
M21414 U2497/net49 n1893 VDD VDD pmos W=0.205u L=0.04u
M21415 U2497/net43 n1287 VDD VDD pmos W=0.205u L=0.04u
M21416 WX4183 n1894 VDD VDD pmos W=0.205u L=0.04u
M21417 U2498/net29 n1353 VSS VSS nmos W=0.155u L=0.04u
M21418 n1894 WX4402 U2498/net29 VSS nmos W=0.155u L=0.04u
M21419 n1894 n1320 U2498/net23 VSS nmos W=0.155u L=0.04u
M21420 U2498/net23 CRC_OUT_6_12 VSS VSS nmos W=0.155u L=0.04u
M21421 U2498/net20 CRC_OUT_6_12 n1894 VDD pmos W=0.205u L=0.04u
M21422 U2498/net20 n1320 n1894 VDD pmos W=0.205u L=0.04u
M21423 VDD WX4402 U2498/net20 VDD pmos W=0.205u L=0.04u
M21424 VDD n1353 U2498/net20 VDD pmos W=0.205u L=0.04u
M21425 n1768 n1895 VSS VSS nmos W=0.135u L=0.04u
M21426 n1768 n1895 VDD VDD pmos W=0.205u L=0.04u
M21427 U2500/net28 U2500/net20 U2500/net64 VSS nmos W=0.155u L=0.04u
M21428 U2500/net24 U2500/net30 U2500/net32 VSS nmos W=0.155u L=0.04u
M21429 U2500/net28 U2500/net40 U2500/net24 VSS nmos W=0.155u L=0.04u
M21430 U2500/net40 WX5983 U2500/net108 VSS nmos W=0.155u L=0.04u
M21431 U2500/net40 U2500/net106 U2500/net104 VSS nmos W=0.155u L=0.04u
M21432 U2500/net24 WX5919 U2500/net050 VSS nmos W=0.155u L=0.04u
M21433 U2500/net050 U2500/net32 VSS VSS nmos W=0.155u L=0.04u
M21434 U2500/net20 U2500/net40 VSS VSS nmos W=0.155u L=0.04u
M21435 U2500/net106 WX5983 VSS VSS nmos W=0.155u L=0.04u
M21436 U2500/net104 WX6047 VSS VSS nmos W=0.155u L=0.04u
M21437 U2500/net30 WX5919 VSS VSS nmos W=0.155u L=0.04u
M21438 U2500/net108 U2500/net104 VSS VSS nmos W=0.155u L=0.04u
M21439 n1895 U2500/net28 VSS VSS nmos W=0.155u L=0.04u
M21440 U2500/net32 WX5855 VSS VSS nmos W=0.155u L=0.04u
M21441 U2500/net64 U2500/net24 VSS VSS nmos W=0.2u L=0.04u
M21442 U2500/net28 U2500/net40 U2500/net64 VDD pmos W=0.205u L=0.04u
M21443 U2500/net24 WX5919 U2500/net32 VDD pmos W=0.205u L=0.04u
M21444 U2500/net28 U2500/net20 U2500/net24 VDD pmos W=0.205u L=0.04u
M21445 U2500/net40 U2500/net106 U2500/net108 VDD pmos W=0.205u L=0.04u
M21446 U2500/net40 WX5983 U2500/net104 VDD pmos W=0.205u L=0.04u
M21447 U2500/net20 U2500/net40 VDD VDD pmos W=0.205u L=0.04u
M21448 U2500/net106 WX5983 VDD VDD pmos W=0.205u L=0.04u
M21449 U2500/net104 WX6047 VDD VDD pmos W=0.205u L=0.04u
M21450 U2500/net30 WX5919 VDD VDD pmos W=0.205u L=0.04u
M21451 U2500/net108 U2500/net104 VDD VDD pmos W=0.205u L=0.04u
M21452 n1895 U2500/net28 VDD VDD pmos W=0.205u L=0.04u
M21453 U2500/net32 WX5855 VDD VDD pmos W=0.205u L=0.04u
M21454 U2500/net64 U2500/net24 VDD VDD pmos W=0.28u L=0.04u
M21455 U2500/net24 U2500/net30 U2500/net045 VDD pmos W=0.205u L=0.04u
M21456 U2500/net045 U2500/net32 VDD VDD pmos W=0.205u L=0.04u
M21457 WX4169 n1287 U2501/net26 VSS nmos W=0.155u L=0.04u
M21458 WX4169 n1771 U2501/net26 VSS nmos W=0.155u L=0.04u
M21459 U2501/net29 n1897 VSS VSS nmos W=0.155u L=0.04u
M21460 U2501/net26 n1896 U2501/net29 VSS nmos W=0.155u L=0.04u
M21461 U2501/net26 n1258 U2501/net29 VSS nmos W=0.155u L=0.04u
M21462 WX4169 n1771 U2501/net43 VDD pmos W=0.205u L=0.04u
M21463 WX4169 n1258 U2501/net49 VDD pmos W=0.205u L=0.04u
M21464 U2501/net49 n1896 VDD VDD pmos W=0.205u L=0.04u
M21465 U2501/net43 n1287 VDD VDD pmos W=0.205u L=0.04u
M21466 WX4169 n1897 VDD VDD pmos W=0.205u L=0.04u
M21467 U2502/net29 n1353 VSS VSS nmos W=0.155u L=0.04u
M21468 n1897 WX4400 U2502/net29 VSS nmos W=0.155u L=0.04u
M21469 n1897 n1320 U2502/net23 VSS nmos W=0.155u L=0.04u
M21470 U2502/net23 CRC_OUT_6_13 VSS VSS nmos W=0.155u L=0.04u
M21471 U2502/net20 CRC_OUT_6_13 n1897 VDD pmos W=0.205u L=0.04u
M21472 U2502/net20 n1320 n1897 VDD pmos W=0.205u L=0.04u
M21473 VDD WX4400 U2502/net20 VDD pmos W=0.205u L=0.04u
M21474 VDD n1353 U2502/net20 VDD pmos W=0.205u L=0.04u
M21475 n1771 n1898 VSS VSS nmos W=0.135u L=0.04u
M21476 n1771 n1898 VDD VDD pmos W=0.205u L=0.04u
M21477 U2504/net28 U2504/net20 U2504/net64 VSS nmos W=0.155u L=0.04u
M21478 U2504/net24 U2504/net30 U2504/net32 VSS nmos W=0.155u L=0.04u
M21479 U2504/net28 U2504/net40 U2504/net24 VSS nmos W=0.155u L=0.04u
M21480 U2504/net40 WX5981 U2504/net108 VSS nmos W=0.155u L=0.04u
M21481 U2504/net40 U2504/net106 U2504/net104 VSS nmos W=0.155u L=0.04u
M21482 U2504/net24 WX5917 U2504/net050 VSS nmos W=0.155u L=0.04u
M21483 U2504/net050 U2504/net32 VSS VSS nmos W=0.155u L=0.04u
M21484 U2504/net20 U2504/net40 VSS VSS nmos W=0.155u L=0.04u
M21485 U2504/net106 WX5981 VSS VSS nmos W=0.155u L=0.04u
M21486 U2504/net104 WX6045 VSS VSS nmos W=0.155u L=0.04u
M21487 U2504/net30 WX5917 VSS VSS nmos W=0.155u L=0.04u
M21488 U2504/net108 U2504/net104 VSS VSS nmos W=0.155u L=0.04u
M21489 n1898 U2504/net28 VSS VSS nmos W=0.155u L=0.04u
M21490 U2504/net32 WX5853 VSS VSS nmos W=0.155u L=0.04u
M21491 U2504/net64 U2504/net24 VSS VSS nmos W=0.2u L=0.04u
M21492 U2504/net28 U2504/net40 U2504/net64 VDD pmos W=0.205u L=0.04u
M21493 U2504/net24 WX5917 U2504/net32 VDD pmos W=0.205u L=0.04u
M21494 U2504/net28 U2504/net20 U2504/net24 VDD pmos W=0.205u L=0.04u
M21495 U2504/net40 U2504/net106 U2504/net108 VDD pmos W=0.205u L=0.04u
M21496 U2504/net40 WX5981 U2504/net104 VDD pmos W=0.205u L=0.04u
M21497 U2504/net20 U2504/net40 VDD VDD pmos W=0.205u L=0.04u
M21498 U2504/net106 WX5981 VDD VDD pmos W=0.205u L=0.04u
M21499 U2504/net104 WX6045 VDD VDD pmos W=0.205u L=0.04u
M21500 U2504/net30 WX5917 VDD VDD pmos W=0.205u L=0.04u
M21501 U2504/net108 U2504/net104 VDD VDD pmos W=0.205u L=0.04u
M21502 n1898 U2504/net28 VDD VDD pmos W=0.205u L=0.04u
M21503 U2504/net32 WX5853 VDD VDD pmos W=0.205u L=0.04u
M21504 U2504/net64 U2504/net24 VDD VDD pmos W=0.28u L=0.04u
M21505 U2504/net24 U2504/net30 U2504/net045 VDD pmos W=0.205u L=0.04u
M21506 U2504/net045 U2504/net32 VDD VDD pmos W=0.205u L=0.04u
M21507 WX416 n1286 U2505/net26 VSS nmos W=0.155u L=0.04u
M21508 WX416 n1899 U2505/net26 VSS nmos W=0.155u L=0.04u
M21509 U2505/net29 n1901 VSS VSS nmos W=0.155u L=0.04u
M21510 U2505/net26 n1900 U2505/net29 VSS nmos W=0.155u L=0.04u
M21511 U2505/net26 n1258 U2505/net29 VSS nmos W=0.155u L=0.04u
M21512 WX416 n1899 U2505/net43 VDD pmos W=0.205u L=0.04u
M21513 WX416 n1258 U2505/net49 VDD pmos W=0.205u L=0.04u
M21514 U2505/net49 n1900 VDD VDD pmos W=0.205u L=0.04u
M21515 U2505/net43 n1286 VDD VDD pmos W=0.205u L=0.04u
M21516 WX416 n1901 VDD VDD pmos W=0.205u L=0.04u
M21517 U2506/net29 n1353 VSS VSS nmos W=0.155u L=0.04u
M21518 n1901 WX539 U2506/net29 VSS nmos W=0.155u L=0.04u
M21519 n1901 n1320 U2506/net23 VSS nmos W=0.155u L=0.04u
M21520 U2506/net23 CRC_OUT_9_4 VSS VSS nmos W=0.155u L=0.04u
M21521 U2506/net20 CRC_OUT_9_4 n1901 VDD pmos W=0.205u L=0.04u
M21522 U2506/net20 n1320 n1901 VDD pmos W=0.205u L=0.04u
M21523 VDD WX539 U2506/net20 VDD pmos W=0.205u L=0.04u
M21524 VDD n1353 U2506/net20 VDD pmos W=0.205u L=0.04u
M21525 WX4155 n1286 U2507/net26 VSS nmos W=0.155u L=0.04u
M21526 WX4155 n1774 U2507/net26 VSS nmos W=0.155u L=0.04u
M21527 U2507/net29 n1903 VSS VSS nmos W=0.155u L=0.04u
M21528 U2507/net26 n1902 U2507/net29 VSS nmos W=0.155u L=0.04u
M21529 U2507/net26 n1258 U2507/net29 VSS nmos W=0.155u L=0.04u
M21530 WX4155 n1774 U2507/net43 VDD pmos W=0.205u L=0.04u
M21531 WX4155 n1258 U2507/net49 VDD pmos W=0.205u L=0.04u
M21532 U2507/net49 n1902 VDD VDD pmos W=0.205u L=0.04u
M21533 U2507/net43 n1286 VDD VDD pmos W=0.205u L=0.04u
M21534 WX4155 n1903 VDD VDD pmos W=0.205u L=0.04u
M21535 U2508/net29 n1353 VSS VSS nmos W=0.155u L=0.04u
M21536 n1903 WX4398 U2508/net29 VSS nmos W=0.155u L=0.04u
M21537 n1903 n1320 U2508/net23 VSS nmos W=0.155u L=0.04u
M21538 U2508/net23 CRC_OUT_6_14 VSS VSS nmos W=0.155u L=0.04u
M21539 U2508/net20 CRC_OUT_6_14 n1903 VDD pmos W=0.205u L=0.04u
M21540 U2508/net20 n1320 n1903 VDD pmos W=0.205u L=0.04u
M21541 VDD WX4398 U2508/net20 VDD pmos W=0.205u L=0.04u
M21542 VDD n1353 U2508/net20 VDD pmos W=0.205u L=0.04u
M21543 n1774 n1904 VSS VSS nmos W=0.135u L=0.04u
M21544 n1774 n1904 VDD VDD pmos W=0.205u L=0.04u
M21545 U2510/net28 U2510/net20 U2510/net64 VSS nmos W=0.155u L=0.04u
M21546 U2510/net24 U2510/net30 U2510/net32 VSS nmos W=0.155u L=0.04u
M21547 U2510/net28 U2510/net40 U2510/net24 VSS nmos W=0.155u L=0.04u
M21548 U2510/net40 WX5979 U2510/net108 VSS nmos W=0.155u L=0.04u
M21549 U2510/net40 U2510/net106 U2510/net104 VSS nmos W=0.155u L=0.04u
M21550 U2510/net24 WX5915 U2510/net050 VSS nmos W=0.155u L=0.04u
M21551 U2510/net050 U2510/net32 VSS VSS nmos W=0.155u L=0.04u
M21552 U2510/net20 U2510/net40 VSS VSS nmos W=0.155u L=0.04u
M21553 U2510/net106 WX5979 VSS VSS nmos W=0.155u L=0.04u
M21554 U2510/net104 WX6043 VSS VSS nmos W=0.155u L=0.04u
M21555 U2510/net30 WX5915 VSS VSS nmos W=0.155u L=0.04u
M21556 U2510/net108 U2510/net104 VSS VSS nmos W=0.155u L=0.04u
M21557 n1904 U2510/net28 VSS VSS nmos W=0.155u L=0.04u
M21558 U2510/net32 WX5851 VSS VSS nmos W=0.155u L=0.04u
M21559 U2510/net64 U2510/net24 VSS VSS nmos W=0.2u L=0.04u
M21560 U2510/net28 U2510/net40 U2510/net64 VDD pmos W=0.205u L=0.04u
M21561 U2510/net24 WX5915 U2510/net32 VDD pmos W=0.205u L=0.04u
M21562 U2510/net28 U2510/net20 U2510/net24 VDD pmos W=0.205u L=0.04u
M21563 U2510/net40 U2510/net106 U2510/net108 VDD pmos W=0.205u L=0.04u
M21564 U2510/net40 WX5979 U2510/net104 VDD pmos W=0.205u L=0.04u
M21565 U2510/net20 U2510/net40 VDD VDD pmos W=0.205u L=0.04u
M21566 U2510/net106 WX5979 VDD VDD pmos W=0.205u L=0.04u
M21567 U2510/net104 WX6043 VDD VDD pmos W=0.205u L=0.04u
M21568 U2510/net30 WX5915 VDD VDD pmos W=0.205u L=0.04u
M21569 U2510/net108 U2510/net104 VDD VDD pmos W=0.205u L=0.04u
M21570 n1904 U2510/net28 VDD VDD pmos W=0.205u L=0.04u
M21571 U2510/net32 WX5851 VDD VDD pmos W=0.205u L=0.04u
M21572 U2510/net64 U2510/net24 VDD VDD pmos W=0.28u L=0.04u
M21573 U2510/net24 U2510/net30 U2510/net045 VDD pmos W=0.205u L=0.04u
M21574 U2510/net045 U2510/net32 VDD VDD pmos W=0.205u L=0.04u
M21575 WX4141 n1286 U2511/net26 VSS nmos W=0.155u L=0.04u
M21576 WX4141 n1777 U2511/net26 VSS nmos W=0.155u L=0.04u
M21577 U2511/net29 n1906 VSS VSS nmos W=0.155u L=0.04u
M21578 U2511/net26 n1905 U2511/net29 VSS nmos W=0.155u L=0.04u
M21579 U2511/net26 n1258 U2511/net29 VSS nmos W=0.155u L=0.04u
M21580 WX4141 n1777 U2511/net43 VDD pmos W=0.205u L=0.04u
M21581 WX4141 n1258 U2511/net49 VDD pmos W=0.205u L=0.04u
M21582 U2511/net49 n1905 VDD VDD pmos W=0.205u L=0.04u
M21583 U2511/net43 n1286 VDD VDD pmos W=0.205u L=0.04u
M21584 WX4141 n1906 VDD VDD pmos W=0.205u L=0.04u
M21585 U2512/net29 n1353 VSS VSS nmos W=0.155u L=0.04u
M21586 n1906 WX4396 U2512/net29 VSS nmos W=0.155u L=0.04u
M21587 n1906 n1320 U2512/net23 VSS nmos W=0.155u L=0.04u
M21588 U2512/net23 CRC_OUT_6_15 VSS VSS nmos W=0.155u L=0.04u
M21589 U2512/net20 CRC_OUT_6_15 n1906 VDD pmos W=0.205u L=0.04u
M21590 U2512/net20 n1320 n1906 VDD pmos W=0.205u L=0.04u
M21591 VDD WX4396 U2512/net20 VDD pmos W=0.205u L=0.04u
M21592 VDD n1353 U2512/net20 VDD pmos W=0.205u L=0.04u
M21593 n1777 n1907 VSS VSS nmos W=0.135u L=0.04u
M21594 n1777 n1907 VDD VDD pmos W=0.205u L=0.04u
M21595 U2514/net28 U2514/net20 U2514/net64 VSS nmos W=0.155u L=0.04u
M21596 U2514/net24 U2514/net30 U2514/net32 VSS nmos W=0.155u L=0.04u
M21597 U2514/net28 U2514/net40 U2514/net24 VSS nmos W=0.155u L=0.04u
M21598 U2514/net40 WX5977 U2514/net108 VSS nmos W=0.155u L=0.04u
M21599 U2514/net40 U2514/net106 U2514/net104 VSS nmos W=0.155u L=0.04u
M21600 U2514/net24 WX5913 U2514/net050 VSS nmos W=0.155u L=0.04u
M21601 U2514/net050 U2514/net32 VSS VSS nmos W=0.155u L=0.04u
M21602 U2514/net20 U2514/net40 VSS VSS nmos W=0.155u L=0.04u
M21603 U2514/net106 WX5977 VSS VSS nmos W=0.155u L=0.04u
M21604 U2514/net104 WX6041 VSS VSS nmos W=0.155u L=0.04u
M21605 U2514/net30 WX5913 VSS VSS nmos W=0.155u L=0.04u
M21606 U2514/net108 U2514/net104 VSS VSS nmos W=0.155u L=0.04u
M21607 n1907 U2514/net28 VSS VSS nmos W=0.155u L=0.04u
M21608 U2514/net32 WX5849 VSS VSS nmos W=0.155u L=0.04u
M21609 U2514/net64 U2514/net24 VSS VSS nmos W=0.2u L=0.04u
M21610 U2514/net28 U2514/net40 U2514/net64 VDD pmos W=0.205u L=0.04u
M21611 U2514/net24 WX5913 U2514/net32 VDD pmos W=0.205u L=0.04u
M21612 U2514/net28 U2514/net20 U2514/net24 VDD pmos W=0.205u L=0.04u
M21613 U2514/net40 U2514/net106 U2514/net108 VDD pmos W=0.205u L=0.04u
M21614 U2514/net40 WX5977 U2514/net104 VDD pmos W=0.205u L=0.04u
M21615 U2514/net20 U2514/net40 VDD VDD pmos W=0.205u L=0.04u
M21616 U2514/net106 WX5977 VDD VDD pmos W=0.205u L=0.04u
M21617 U2514/net104 WX6041 VDD VDD pmos W=0.205u L=0.04u
M21618 U2514/net30 WX5913 VDD VDD pmos W=0.205u L=0.04u
M21619 U2514/net108 U2514/net104 VDD VDD pmos W=0.205u L=0.04u
M21620 n1907 U2514/net28 VDD VDD pmos W=0.205u L=0.04u
M21621 U2514/net32 WX5849 VDD VDD pmos W=0.205u L=0.04u
M21622 U2514/net64 U2514/net24 VDD VDD pmos W=0.28u L=0.04u
M21623 U2514/net24 U2514/net30 U2514/net045 VDD pmos W=0.205u L=0.04u
M21624 U2514/net045 U2514/net32 VDD VDD pmos W=0.205u L=0.04u
M21625 WX4127 n1286 U2515/net26 VSS nmos W=0.155u L=0.04u
M21626 WX4127 n1780 U2515/net26 VSS nmos W=0.155u L=0.04u
M21627 U2515/net29 n1909 VSS VSS nmos W=0.155u L=0.04u
M21628 U2515/net26 n1908 U2515/net29 VSS nmos W=0.155u L=0.04u
M21629 U2515/net26 n1258 U2515/net29 VSS nmos W=0.155u L=0.04u
M21630 WX4127 n1780 U2515/net43 VDD pmos W=0.205u L=0.04u
M21631 WX4127 n1258 U2515/net49 VDD pmos W=0.205u L=0.04u
M21632 U2515/net49 n1908 VDD VDD pmos W=0.205u L=0.04u
M21633 U2515/net43 n1286 VDD VDD pmos W=0.205u L=0.04u
M21634 WX4127 n1909 VDD VDD pmos W=0.205u L=0.04u
M21635 U2516/net29 n1353 VSS VSS nmos W=0.155u L=0.04u
M21636 n1909 WX4394 U2516/net29 VSS nmos W=0.155u L=0.04u
M21637 n1909 n1320 U2516/net23 VSS nmos W=0.155u L=0.04u
M21638 U2516/net23 CRC_OUT_6_16 VSS VSS nmos W=0.155u L=0.04u
M21639 U2516/net20 CRC_OUT_6_16 n1909 VDD pmos W=0.205u L=0.04u
M21640 U2516/net20 n1320 n1909 VDD pmos W=0.205u L=0.04u
M21641 VDD WX4394 U2516/net20 VDD pmos W=0.205u L=0.04u
M21642 VDD n1353 U2516/net20 VDD pmos W=0.205u L=0.04u
M21643 n1780 n1910 VSS VSS nmos W=0.135u L=0.04u
M21644 n1780 n1910 VDD VDD pmos W=0.205u L=0.04u
M21645 U2518/net28 U2518/net20 U2518/net64 VSS nmos W=0.155u L=0.04u
M21646 U2518/net24 U2518/net30 U2518/net32 VSS nmos W=0.155u L=0.04u
M21647 U2518/net28 U2518/net40 U2518/net24 VSS nmos W=0.155u L=0.04u
M21648 U2518/net40 n1911 U2518/net108 VSS nmos W=0.155u L=0.04u
M21649 U2518/net40 U2518/net106 U2518/net104 VSS nmos W=0.155u L=0.04u
M21650 U2518/net24 WX5975 U2518/net050 VSS nmos W=0.155u L=0.04u
M21651 U2518/net050 U2518/net32 VSS VSS nmos W=0.155u L=0.04u
M21652 U2518/net20 U2518/net40 VSS VSS nmos W=0.155u L=0.04u
M21653 U2518/net106 n1911 VSS VSS nmos W=0.155u L=0.04u
M21654 U2518/net104 WX6039 VSS VSS nmos W=0.155u L=0.04u
M21655 U2518/net30 WX5975 VSS VSS nmos W=0.155u L=0.04u
M21656 U2518/net108 U2518/net104 VSS VSS nmos W=0.155u L=0.04u
M21657 n1910 U2518/net28 VSS VSS nmos W=0.155u L=0.04u
M21658 U2518/net32 WX5911 VSS VSS nmos W=0.155u L=0.04u
M21659 U2518/net64 U2518/net24 VSS VSS nmos W=0.2u L=0.04u
M21660 U2518/net28 U2518/net40 U2518/net64 VDD pmos W=0.205u L=0.04u
M21661 U2518/net24 WX5975 U2518/net32 VDD pmos W=0.205u L=0.04u
M21662 U2518/net28 U2518/net20 U2518/net24 VDD pmos W=0.205u L=0.04u
M21663 U2518/net40 U2518/net106 U2518/net108 VDD pmos W=0.205u L=0.04u
M21664 U2518/net40 n1911 U2518/net104 VDD pmos W=0.205u L=0.04u
M21665 U2518/net20 U2518/net40 VDD VDD pmos W=0.205u L=0.04u
M21666 U2518/net106 n1911 VDD VDD pmos W=0.205u L=0.04u
M21667 U2518/net104 WX6039 VDD VDD pmos W=0.205u L=0.04u
M21668 U2518/net30 WX5975 VDD VDD pmos W=0.205u L=0.04u
M21669 U2518/net108 U2518/net104 VDD VDD pmos W=0.205u L=0.04u
M21670 n1910 U2518/net28 VDD VDD pmos W=0.205u L=0.04u
M21671 U2518/net32 WX5911 VDD VDD pmos W=0.205u L=0.04u
M21672 U2518/net64 U2518/net24 VDD VDD pmos W=0.28u L=0.04u
M21673 U2518/net24 U2518/net30 U2518/net045 VDD pmos W=0.205u L=0.04u
M21674 U2518/net045 U2518/net32 VDD VDD pmos W=0.205u L=0.04u
M21675 U2519/net4 WX5847 U2519/net14 VSS nmos W=0.155u L=0.04u
M21676 U2519/net6 U2519/net10 U2519/net14 VSS nmos W=0.17u L=0.04u
M21677 U2519/net4 n1372 VSS VSS nmos W=0.155u L=0.04u
M21678 U2519/net6 U2519/net4 VSS VSS nmos W=0.17u L=0.04u
M21679 n1911 U2519/net14 VSS VSS nmos W=0.155u L=0.04u
M21680 U2519/net10 WX5847 VSS VSS nmos W=0.155u L=0.04u
M21681 U2519/net4 U2519/net10 U2519/net14 VDD pmos W=0.255u L=0.04u
M21682 U2519/net6 WX5847 U2519/net14 VDD pmos W=0.28u L=0.04u
M21683 U2519/net4 n1372 VDD VDD pmos W=0.205u L=0.04u
M21684 U2519/net6 U2519/net4 VDD VDD pmos W=0.24u L=0.04u
M21685 n1911 U2519/net14 VDD VDD pmos W=0.205u L=0.04u
M21686 U2519/net10 WX5847 VDD VDD pmos W=0.205u L=0.04u
M21687 WX4113 n1286 U2520/net26 VSS nmos W=0.155u L=0.04u
M21688 WX4113 n1784 U2520/net26 VSS nmos W=0.155u L=0.04u
M21689 U2520/net29 n1913 VSS VSS nmos W=0.155u L=0.04u
M21690 U2520/net26 n1912 U2520/net29 VSS nmos W=0.155u L=0.04u
M21691 U2520/net26 n1258 U2520/net29 VSS nmos W=0.155u L=0.04u
M21692 WX4113 n1784 U2520/net43 VDD pmos W=0.205u L=0.04u
M21693 WX4113 n1258 U2520/net49 VDD pmos W=0.205u L=0.04u
M21694 U2520/net49 n1912 VDD VDD pmos W=0.205u L=0.04u
M21695 U2520/net43 n1286 VDD VDD pmos W=0.205u L=0.04u
M21696 WX4113 n1913 VDD VDD pmos W=0.205u L=0.04u
M21697 U2521/net29 n1353 VSS VSS nmos W=0.155u L=0.04u
M21698 n1913 WX4392 U2521/net29 VSS nmos W=0.155u L=0.04u
M21699 n1913 n1320 U2521/net23 VSS nmos W=0.155u L=0.04u
M21700 U2521/net23 CRC_OUT_6_17 VSS VSS nmos W=0.155u L=0.04u
M21701 U2521/net20 CRC_OUT_6_17 n1913 VDD pmos W=0.205u L=0.04u
M21702 U2521/net20 n1320 n1913 VDD pmos W=0.205u L=0.04u
M21703 VDD WX4392 U2521/net20 VDD pmos W=0.205u L=0.04u
M21704 VDD n1353 U2521/net20 VDD pmos W=0.205u L=0.04u
M21705 n1784 n1914 VSS VSS nmos W=0.135u L=0.04u
M21706 n1784 n1914 VDD VDD pmos W=0.205u L=0.04u
M21707 U2523/net28 U2523/net20 U2523/net64 VSS nmos W=0.155u L=0.04u
M21708 U2523/net24 U2523/net30 U2523/net32 VSS nmos W=0.155u L=0.04u
M21709 U2523/net28 U2523/net40 U2523/net24 VSS nmos W=0.155u L=0.04u
M21710 U2523/net40 n1915 U2523/net108 VSS nmos W=0.155u L=0.04u
M21711 U2523/net40 U2523/net106 U2523/net104 VSS nmos W=0.155u L=0.04u
M21712 U2523/net24 WX5973 U2523/net050 VSS nmos W=0.155u L=0.04u
M21713 U2523/net050 U2523/net32 VSS VSS nmos W=0.155u L=0.04u
M21714 U2523/net20 U2523/net40 VSS VSS nmos W=0.155u L=0.04u
M21715 U2523/net106 n1915 VSS VSS nmos W=0.155u L=0.04u
M21716 U2523/net104 WX6037 VSS VSS nmos W=0.155u L=0.04u
M21717 U2523/net30 WX5973 VSS VSS nmos W=0.155u L=0.04u
M21718 U2523/net108 U2523/net104 VSS VSS nmos W=0.155u L=0.04u
M21719 n1914 U2523/net28 VSS VSS nmos W=0.155u L=0.04u
M21720 U2523/net32 WX5909 VSS VSS nmos W=0.155u L=0.04u
M21721 U2523/net64 U2523/net24 VSS VSS nmos W=0.2u L=0.04u
M21722 U2523/net28 U2523/net40 U2523/net64 VDD pmos W=0.205u L=0.04u
M21723 U2523/net24 WX5973 U2523/net32 VDD pmos W=0.205u L=0.04u
M21724 U2523/net28 U2523/net20 U2523/net24 VDD pmos W=0.205u L=0.04u
M21725 U2523/net40 U2523/net106 U2523/net108 VDD pmos W=0.205u L=0.04u
M21726 U2523/net40 n1915 U2523/net104 VDD pmos W=0.205u L=0.04u
M21727 U2523/net20 U2523/net40 VDD VDD pmos W=0.205u L=0.04u
M21728 U2523/net106 n1915 VDD VDD pmos W=0.205u L=0.04u
M21729 U2523/net104 WX6037 VDD VDD pmos W=0.205u L=0.04u
M21730 U2523/net30 WX5973 VDD VDD pmos W=0.205u L=0.04u
M21731 U2523/net108 U2523/net104 VDD VDD pmos W=0.205u L=0.04u
M21732 n1914 U2523/net28 VDD VDD pmos W=0.205u L=0.04u
M21733 U2523/net32 WX5909 VDD VDD pmos W=0.205u L=0.04u
M21734 U2523/net64 U2523/net24 VDD VDD pmos W=0.28u L=0.04u
M21735 U2523/net24 U2523/net30 U2523/net045 VDD pmos W=0.205u L=0.04u
M21736 U2523/net045 U2523/net32 VDD VDD pmos W=0.205u L=0.04u
M21737 U2524/net4 WX5845 U2524/net14 VSS nmos W=0.155u L=0.04u
M21738 U2524/net6 U2524/net10 U2524/net14 VSS nmos W=0.17u L=0.04u
M21739 U2524/net4 n1372 VSS VSS nmos W=0.155u L=0.04u
M21740 U2524/net6 U2524/net4 VSS VSS nmos W=0.17u L=0.04u
M21741 n1915 U2524/net14 VSS VSS nmos W=0.155u L=0.04u
M21742 U2524/net10 WX5845 VSS VSS nmos W=0.155u L=0.04u
M21743 U2524/net4 U2524/net10 U2524/net14 VDD pmos W=0.255u L=0.04u
M21744 U2524/net6 WX5845 U2524/net14 VDD pmos W=0.28u L=0.04u
M21745 U2524/net4 n1372 VDD VDD pmos W=0.205u L=0.04u
M21746 U2524/net6 U2524/net4 VDD VDD pmos W=0.24u L=0.04u
M21747 n1915 U2524/net14 VDD VDD pmos W=0.205u L=0.04u
M21748 U2524/net10 WX5845 VDD VDD pmos W=0.205u L=0.04u
M21749 WX4099 n1286 U2525/net26 VSS nmos W=0.155u L=0.04u
M21750 WX4099 n1788 U2525/net26 VSS nmos W=0.155u L=0.04u
M21751 U2525/net29 n1917 VSS VSS nmos W=0.155u L=0.04u
M21752 U2525/net26 n1916 U2525/net29 VSS nmos W=0.155u L=0.04u
M21753 U2525/net26 n1258 U2525/net29 VSS nmos W=0.155u L=0.04u
M21754 WX4099 n1788 U2525/net43 VDD pmos W=0.205u L=0.04u
M21755 WX4099 n1258 U2525/net49 VDD pmos W=0.205u L=0.04u
M21756 U2525/net49 n1916 VDD VDD pmos W=0.205u L=0.04u
M21757 U2525/net43 n1286 VDD VDD pmos W=0.205u L=0.04u
M21758 WX4099 n1917 VDD VDD pmos W=0.205u L=0.04u
M21759 U2526/net29 n1353 VSS VSS nmos W=0.155u L=0.04u
M21760 n1917 WX4390 U2526/net29 VSS nmos W=0.155u L=0.04u
M21761 n1917 n1320 U2526/net23 VSS nmos W=0.155u L=0.04u
M21762 U2526/net23 CRC_OUT_6_18 VSS VSS nmos W=0.155u L=0.04u
M21763 U2526/net20 CRC_OUT_6_18 n1917 VDD pmos W=0.205u L=0.04u
M21764 U2526/net20 n1320 n1917 VDD pmos W=0.205u L=0.04u
M21765 VDD WX4390 U2526/net20 VDD pmos W=0.205u L=0.04u
M21766 VDD n1353 U2526/net20 VDD pmos W=0.205u L=0.04u
M21767 n1788 n1918 VSS VSS nmos W=0.135u L=0.04u
M21768 n1788 n1918 VDD VDD pmos W=0.205u L=0.04u
M21769 U2528/net28 U2528/net20 U2528/net64 VSS nmos W=0.155u L=0.04u
M21770 U2528/net24 U2528/net30 U2528/net32 VSS nmos W=0.155u L=0.04u
M21771 U2528/net28 U2528/net40 U2528/net24 VSS nmos W=0.155u L=0.04u
M21772 U2528/net40 n1919 U2528/net108 VSS nmos W=0.155u L=0.04u
M21773 U2528/net40 U2528/net106 U2528/net104 VSS nmos W=0.155u L=0.04u
M21774 U2528/net24 WX5971 U2528/net050 VSS nmos W=0.155u L=0.04u
M21775 U2528/net050 U2528/net32 VSS VSS nmos W=0.155u L=0.04u
M21776 U2528/net20 U2528/net40 VSS VSS nmos W=0.155u L=0.04u
M21777 U2528/net106 n1919 VSS VSS nmos W=0.155u L=0.04u
M21778 U2528/net104 WX6035 VSS VSS nmos W=0.155u L=0.04u
M21779 U2528/net30 WX5971 VSS VSS nmos W=0.155u L=0.04u
M21780 U2528/net108 U2528/net104 VSS VSS nmos W=0.155u L=0.04u
M21781 n1918 U2528/net28 VSS VSS nmos W=0.155u L=0.04u
M21782 U2528/net32 WX5907 VSS VSS nmos W=0.155u L=0.04u
M21783 U2528/net64 U2528/net24 VSS VSS nmos W=0.2u L=0.04u
M21784 U2528/net28 U2528/net40 U2528/net64 VDD pmos W=0.205u L=0.04u
M21785 U2528/net24 WX5971 U2528/net32 VDD pmos W=0.205u L=0.04u
M21786 U2528/net28 U2528/net20 U2528/net24 VDD pmos W=0.205u L=0.04u
M21787 U2528/net40 U2528/net106 U2528/net108 VDD pmos W=0.205u L=0.04u
M21788 U2528/net40 n1919 U2528/net104 VDD pmos W=0.205u L=0.04u
M21789 U2528/net20 U2528/net40 VDD VDD pmos W=0.205u L=0.04u
M21790 U2528/net106 n1919 VDD VDD pmos W=0.205u L=0.04u
M21791 U2528/net104 WX6035 VDD VDD pmos W=0.205u L=0.04u
M21792 U2528/net30 WX5971 VDD VDD pmos W=0.205u L=0.04u
M21793 U2528/net108 U2528/net104 VDD VDD pmos W=0.205u L=0.04u
M21794 n1918 U2528/net28 VDD VDD pmos W=0.205u L=0.04u
M21795 U2528/net32 WX5907 VDD VDD pmos W=0.205u L=0.04u
M21796 U2528/net64 U2528/net24 VDD VDD pmos W=0.28u L=0.04u
M21797 U2528/net24 U2528/net30 U2528/net045 VDD pmos W=0.205u L=0.04u
M21798 U2528/net045 U2528/net32 VDD VDD pmos W=0.205u L=0.04u
M21799 U2529/net4 WX5843 U2529/net14 VSS nmos W=0.155u L=0.04u
M21800 U2529/net6 U2529/net10 U2529/net14 VSS nmos W=0.17u L=0.04u
M21801 U2529/net4 n1372 VSS VSS nmos W=0.155u L=0.04u
M21802 U2529/net6 U2529/net4 VSS VSS nmos W=0.17u L=0.04u
M21803 n1919 U2529/net14 VSS VSS nmos W=0.155u L=0.04u
M21804 U2529/net10 WX5843 VSS VSS nmos W=0.155u L=0.04u
M21805 U2529/net4 U2529/net10 U2529/net14 VDD pmos W=0.255u L=0.04u
M21806 U2529/net6 WX5843 U2529/net14 VDD pmos W=0.28u L=0.04u
M21807 U2529/net4 n1372 VDD VDD pmos W=0.205u L=0.04u
M21808 U2529/net6 U2529/net4 VDD VDD pmos W=0.24u L=0.04u
M21809 n1919 U2529/net14 VDD VDD pmos W=0.205u L=0.04u
M21810 U2529/net10 WX5843 VDD VDD pmos W=0.205u L=0.04u
M21811 WX4085 n1286 U2530/net26 VSS nmos W=0.155u L=0.04u
M21812 WX4085 n1792 U2530/net26 VSS nmos W=0.155u L=0.04u
M21813 U2530/net29 n1921 VSS VSS nmos W=0.155u L=0.04u
M21814 U2530/net26 n1920 U2530/net29 VSS nmos W=0.155u L=0.04u
M21815 U2530/net26 n1258 U2530/net29 VSS nmos W=0.155u L=0.04u
M21816 WX4085 n1792 U2530/net43 VDD pmos W=0.205u L=0.04u
M21817 WX4085 n1258 U2530/net49 VDD pmos W=0.205u L=0.04u
M21818 U2530/net49 n1920 VDD VDD pmos W=0.205u L=0.04u
M21819 U2530/net43 n1286 VDD VDD pmos W=0.205u L=0.04u
M21820 WX4085 n1921 VDD VDD pmos W=0.205u L=0.04u
M21821 U2531/net29 n1353 VSS VSS nmos W=0.155u L=0.04u
M21822 n1921 WX4388 U2531/net29 VSS nmos W=0.155u L=0.04u
M21823 n1921 n1320 U2531/net23 VSS nmos W=0.155u L=0.04u
M21824 U2531/net23 CRC_OUT_6_19 VSS VSS nmos W=0.155u L=0.04u
M21825 U2531/net20 CRC_OUT_6_19 n1921 VDD pmos W=0.205u L=0.04u
M21826 U2531/net20 n1320 n1921 VDD pmos W=0.205u L=0.04u
M21827 VDD WX4388 U2531/net20 VDD pmos W=0.205u L=0.04u
M21828 VDD n1353 U2531/net20 VDD pmos W=0.205u L=0.04u
M21829 n1792 n1922 VSS VSS nmos W=0.135u L=0.04u
M21830 n1792 n1922 VDD VDD pmos W=0.205u L=0.04u
M21831 U2533/net28 U2533/net20 U2533/net64 VSS nmos W=0.155u L=0.04u
M21832 U2533/net24 U2533/net30 U2533/net32 VSS nmos W=0.155u L=0.04u
M21833 U2533/net28 U2533/net40 U2533/net24 VSS nmos W=0.155u L=0.04u
M21834 U2533/net40 n1923 U2533/net108 VSS nmos W=0.155u L=0.04u
M21835 U2533/net40 U2533/net106 U2533/net104 VSS nmos W=0.155u L=0.04u
M21836 U2533/net24 WX5969 U2533/net050 VSS nmos W=0.155u L=0.04u
M21837 U2533/net050 U2533/net32 VSS VSS nmos W=0.155u L=0.04u
M21838 U2533/net20 U2533/net40 VSS VSS nmos W=0.155u L=0.04u
M21839 U2533/net106 n1923 VSS VSS nmos W=0.155u L=0.04u
M21840 U2533/net104 WX6033 VSS VSS nmos W=0.155u L=0.04u
M21841 U2533/net30 WX5969 VSS VSS nmos W=0.155u L=0.04u
M21842 U2533/net108 U2533/net104 VSS VSS nmos W=0.155u L=0.04u
M21843 n1922 U2533/net28 VSS VSS nmos W=0.155u L=0.04u
M21844 U2533/net32 WX5905 VSS VSS nmos W=0.155u L=0.04u
M21845 U2533/net64 U2533/net24 VSS VSS nmos W=0.2u L=0.04u
M21846 U2533/net28 U2533/net40 U2533/net64 VDD pmos W=0.205u L=0.04u
M21847 U2533/net24 WX5969 U2533/net32 VDD pmos W=0.205u L=0.04u
M21848 U2533/net28 U2533/net20 U2533/net24 VDD pmos W=0.205u L=0.04u
M21849 U2533/net40 U2533/net106 U2533/net108 VDD pmos W=0.205u L=0.04u
M21850 U2533/net40 n1923 U2533/net104 VDD pmos W=0.205u L=0.04u
M21851 U2533/net20 U2533/net40 VDD VDD pmos W=0.205u L=0.04u
M21852 U2533/net106 n1923 VDD VDD pmos W=0.205u L=0.04u
M21853 U2533/net104 WX6033 VDD VDD pmos W=0.205u L=0.04u
M21854 U2533/net30 WX5969 VDD VDD pmos W=0.205u L=0.04u
M21855 U2533/net108 U2533/net104 VDD VDD pmos W=0.205u L=0.04u
M21856 n1922 U2533/net28 VDD VDD pmos W=0.205u L=0.04u
M21857 U2533/net32 WX5905 VDD VDD pmos W=0.205u L=0.04u
M21858 U2533/net64 U2533/net24 VDD VDD pmos W=0.28u L=0.04u
M21859 U2533/net24 U2533/net30 U2533/net045 VDD pmos W=0.205u L=0.04u
M21860 U2533/net045 U2533/net32 VDD VDD pmos W=0.205u L=0.04u
M21861 U2534/net4 WX5841 U2534/net14 VSS nmos W=0.155u L=0.04u
M21862 U2534/net6 U2534/net10 U2534/net14 VSS nmos W=0.17u L=0.04u
M21863 U2534/net4 n1372 VSS VSS nmos W=0.155u L=0.04u
M21864 U2534/net6 U2534/net4 VSS VSS nmos W=0.17u L=0.04u
M21865 n1923 U2534/net14 VSS VSS nmos W=0.155u L=0.04u
M21866 U2534/net10 WX5841 VSS VSS nmos W=0.155u L=0.04u
M21867 U2534/net4 U2534/net10 U2534/net14 VDD pmos W=0.255u L=0.04u
M21868 U2534/net6 WX5841 U2534/net14 VDD pmos W=0.28u L=0.04u
M21869 U2534/net4 n1372 VDD VDD pmos W=0.205u L=0.04u
M21870 U2534/net6 U2534/net4 VDD VDD pmos W=0.24u L=0.04u
M21871 n1923 U2534/net14 VDD VDD pmos W=0.205u L=0.04u
M21872 U2534/net10 WX5841 VDD VDD pmos W=0.205u L=0.04u
M21873 WX4071 n1286 U2535/net26 VSS nmos W=0.155u L=0.04u
M21874 WX4071 n1796 U2535/net26 VSS nmos W=0.155u L=0.04u
M21875 U2535/net29 n1925 VSS VSS nmos W=0.155u L=0.04u
M21876 U2535/net26 n1924 U2535/net29 VSS nmos W=0.155u L=0.04u
M21877 U2535/net26 n1258 U2535/net29 VSS nmos W=0.155u L=0.04u
M21878 WX4071 n1796 U2535/net43 VDD pmos W=0.205u L=0.04u
M21879 WX4071 n1258 U2535/net49 VDD pmos W=0.205u L=0.04u
M21880 U2535/net49 n1924 VDD VDD pmos W=0.205u L=0.04u
M21881 U2535/net43 n1286 VDD VDD pmos W=0.205u L=0.04u
M21882 WX4071 n1925 VDD VDD pmos W=0.205u L=0.04u
M21883 U2536/net29 n1353 VSS VSS nmos W=0.155u L=0.04u
M21884 n1925 WX4386 U2536/net29 VSS nmos W=0.155u L=0.04u
M21885 n1925 n1320 U2536/net23 VSS nmos W=0.155u L=0.04u
M21886 U2536/net23 CRC_OUT_6_20 VSS VSS nmos W=0.155u L=0.04u
M21887 U2536/net20 CRC_OUT_6_20 n1925 VDD pmos W=0.205u L=0.04u
M21888 U2536/net20 n1320 n1925 VDD pmos W=0.205u L=0.04u
M21889 VDD WX4386 U2536/net20 VDD pmos W=0.205u L=0.04u
M21890 VDD n1353 U2536/net20 VDD pmos W=0.205u L=0.04u
M21891 n1796 n1926 VSS VSS nmos W=0.135u L=0.04u
M21892 n1796 n1926 VDD VDD pmos W=0.205u L=0.04u
M21893 U2538/net28 U2538/net20 U2538/net64 VSS nmos W=0.155u L=0.04u
M21894 U2538/net24 U2538/net30 U2538/net32 VSS nmos W=0.155u L=0.04u
M21895 U2538/net28 U2538/net40 U2538/net24 VSS nmos W=0.155u L=0.04u
M21896 U2538/net40 n1927 U2538/net108 VSS nmos W=0.155u L=0.04u
M21897 U2538/net40 U2538/net106 U2538/net104 VSS nmos W=0.155u L=0.04u
M21898 U2538/net24 WX5967 U2538/net050 VSS nmos W=0.155u L=0.04u
M21899 U2538/net050 U2538/net32 VSS VSS nmos W=0.155u L=0.04u
M21900 U2538/net20 U2538/net40 VSS VSS nmos W=0.155u L=0.04u
M21901 U2538/net106 n1927 VSS VSS nmos W=0.155u L=0.04u
M21902 U2538/net104 WX6031 VSS VSS nmos W=0.155u L=0.04u
M21903 U2538/net30 WX5967 VSS VSS nmos W=0.155u L=0.04u
M21904 U2538/net108 U2538/net104 VSS VSS nmos W=0.155u L=0.04u
M21905 n1926 U2538/net28 VSS VSS nmos W=0.155u L=0.04u
M21906 U2538/net32 WX5903 VSS VSS nmos W=0.155u L=0.04u
M21907 U2538/net64 U2538/net24 VSS VSS nmos W=0.2u L=0.04u
M21908 U2538/net28 U2538/net40 U2538/net64 VDD pmos W=0.205u L=0.04u
M21909 U2538/net24 WX5967 U2538/net32 VDD pmos W=0.205u L=0.04u
M21910 U2538/net28 U2538/net20 U2538/net24 VDD pmos W=0.205u L=0.04u
M21911 U2538/net40 U2538/net106 U2538/net108 VDD pmos W=0.205u L=0.04u
M21912 U2538/net40 n1927 U2538/net104 VDD pmos W=0.205u L=0.04u
M21913 U2538/net20 U2538/net40 VDD VDD pmos W=0.205u L=0.04u
M21914 U2538/net106 n1927 VDD VDD pmos W=0.205u L=0.04u
M21915 U2538/net104 WX6031 VDD VDD pmos W=0.205u L=0.04u
M21916 U2538/net30 WX5967 VDD VDD pmos W=0.205u L=0.04u
M21917 U2538/net108 U2538/net104 VDD VDD pmos W=0.205u L=0.04u
M21918 n1926 U2538/net28 VDD VDD pmos W=0.205u L=0.04u
M21919 U2538/net32 WX5903 VDD VDD pmos W=0.205u L=0.04u
M21920 U2538/net64 U2538/net24 VDD VDD pmos W=0.28u L=0.04u
M21921 U2538/net24 U2538/net30 U2538/net045 VDD pmos W=0.205u L=0.04u
M21922 U2538/net045 U2538/net32 VDD VDD pmos W=0.205u L=0.04u
M21923 U2539/net4 WX5839 U2539/net14 VSS nmos W=0.155u L=0.04u
M21924 U2539/net6 U2539/net10 U2539/net14 VSS nmos W=0.17u L=0.04u
M21925 U2539/net4 n1372 VSS VSS nmos W=0.155u L=0.04u
M21926 U2539/net6 U2539/net4 VSS VSS nmos W=0.17u L=0.04u
M21927 n1927 U2539/net14 VSS VSS nmos W=0.155u L=0.04u
M21928 U2539/net10 WX5839 VSS VSS nmos W=0.155u L=0.04u
M21929 U2539/net4 U2539/net10 U2539/net14 VDD pmos W=0.255u L=0.04u
M21930 U2539/net6 WX5839 U2539/net14 VDD pmos W=0.28u L=0.04u
M21931 U2539/net4 n1372 VDD VDD pmos W=0.205u L=0.04u
M21932 U2539/net6 U2539/net4 VDD VDD pmos W=0.24u L=0.04u
M21933 n1927 U2539/net14 VDD VDD pmos W=0.205u L=0.04u
M21934 U2539/net10 WX5839 VDD VDD pmos W=0.205u L=0.04u
M21935 WX4057 n1286 U2540/net26 VSS nmos W=0.155u L=0.04u
M21936 WX4057 n1800 U2540/net26 VSS nmos W=0.155u L=0.04u
M21937 U2540/net29 n1929 VSS VSS nmos W=0.155u L=0.04u
M21938 U2540/net26 n1928 U2540/net29 VSS nmos W=0.155u L=0.04u
M21939 U2540/net26 n1258 U2540/net29 VSS nmos W=0.155u L=0.04u
M21940 WX4057 n1800 U2540/net43 VDD pmos W=0.205u L=0.04u
M21941 WX4057 n1258 U2540/net49 VDD pmos W=0.205u L=0.04u
M21942 U2540/net49 n1928 VDD VDD pmos W=0.205u L=0.04u
M21943 U2540/net43 n1286 VDD VDD pmos W=0.205u L=0.04u
M21944 WX4057 n1929 VDD VDD pmos W=0.205u L=0.04u
M21945 U2541/net29 n1353 VSS VSS nmos W=0.155u L=0.04u
M21946 n1929 WX4384 U2541/net29 VSS nmos W=0.155u L=0.04u
M21947 n1929 n1319 U2541/net23 VSS nmos W=0.155u L=0.04u
M21948 U2541/net23 CRC_OUT_6_21 VSS VSS nmos W=0.155u L=0.04u
M21949 U2541/net20 CRC_OUT_6_21 n1929 VDD pmos W=0.205u L=0.04u
M21950 U2541/net20 n1319 n1929 VDD pmos W=0.205u L=0.04u
M21951 VDD WX4384 U2541/net20 VDD pmos W=0.205u L=0.04u
M21952 VDD n1353 U2541/net20 VDD pmos W=0.205u L=0.04u
M21953 n1800 n1930 VSS VSS nmos W=0.135u L=0.04u
M21954 n1800 n1930 VDD VDD pmos W=0.205u L=0.04u
M21955 U2543/net28 U2543/net20 U2543/net64 VSS nmos W=0.155u L=0.04u
M21956 U2543/net24 U2543/net30 U2543/net32 VSS nmos W=0.155u L=0.04u
M21957 U2543/net28 U2543/net40 U2543/net24 VSS nmos W=0.155u L=0.04u
M21958 U2543/net40 n1931 U2543/net108 VSS nmos W=0.155u L=0.04u
M21959 U2543/net40 U2543/net106 U2543/net104 VSS nmos W=0.155u L=0.04u
M21960 U2543/net24 WX5965 U2543/net050 VSS nmos W=0.155u L=0.04u
M21961 U2543/net050 U2543/net32 VSS VSS nmos W=0.155u L=0.04u
M21962 U2543/net20 U2543/net40 VSS VSS nmos W=0.155u L=0.04u
M21963 U2543/net106 n1931 VSS VSS nmos W=0.155u L=0.04u
M21964 U2543/net104 WX6029 VSS VSS nmos W=0.155u L=0.04u
M21965 U2543/net30 WX5965 VSS VSS nmos W=0.155u L=0.04u
M21966 U2543/net108 U2543/net104 VSS VSS nmos W=0.155u L=0.04u
M21967 n1930 U2543/net28 VSS VSS nmos W=0.155u L=0.04u
M21968 U2543/net32 WX5901 VSS VSS nmos W=0.155u L=0.04u
M21969 U2543/net64 U2543/net24 VSS VSS nmos W=0.2u L=0.04u
M21970 U2543/net28 U2543/net40 U2543/net64 VDD pmos W=0.205u L=0.04u
M21971 U2543/net24 WX5965 U2543/net32 VDD pmos W=0.205u L=0.04u
M21972 U2543/net28 U2543/net20 U2543/net24 VDD pmos W=0.205u L=0.04u
M21973 U2543/net40 U2543/net106 U2543/net108 VDD pmos W=0.205u L=0.04u
M21974 U2543/net40 n1931 U2543/net104 VDD pmos W=0.205u L=0.04u
M21975 U2543/net20 U2543/net40 VDD VDD pmos W=0.205u L=0.04u
M21976 U2543/net106 n1931 VDD VDD pmos W=0.205u L=0.04u
M21977 U2543/net104 WX6029 VDD VDD pmos W=0.205u L=0.04u
M21978 U2543/net30 WX5965 VDD VDD pmos W=0.205u L=0.04u
M21979 U2543/net108 U2543/net104 VDD VDD pmos W=0.205u L=0.04u
M21980 n1930 U2543/net28 VDD VDD pmos W=0.205u L=0.04u
M21981 U2543/net32 WX5901 VDD VDD pmos W=0.205u L=0.04u
M21982 U2543/net64 U2543/net24 VDD VDD pmos W=0.28u L=0.04u
M21983 U2543/net24 U2543/net30 U2543/net045 VDD pmos W=0.205u L=0.04u
M21984 U2543/net045 U2543/net32 VDD VDD pmos W=0.205u L=0.04u
M21985 U2544/net4 WX5837 U2544/net14 VSS nmos W=0.155u L=0.04u
M21986 U2544/net6 U2544/net10 U2544/net14 VSS nmos W=0.17u L=0.04u
M21987 U2544/net4 n1372 VSS VSS nmos W=0.155u L=0.04u
M21988 U2544/net6 U2544/net4 VSS VSS nmos W=0.17u L=0.04u
M21989 n1931 U2544/net14 VSS VSS nmos W=0.155u L=0.04u
M21990 U2544/net10 WX5837 VSS VSS nmos W=0.155u L=0.04u
M21991 U2544/net4 U2544/net10 U2544/net14 VDD pmos W=0.255u L=0.04u
M21992 U2544/net6 WX5837 U2544/net14 VDD pmos W=0.28u L=0.04u
M21993 U2544/net4 n1372 VDD VDD pmos W=0.205u L=0.04u
M21994 U2544/net6 U2544/net4 VDD VDD pmos W=0.24u L=0.04u
M21995 n1931 U2544/net14 VDD VDD pmos W=0.205u L=0.04u
M21996 U2544/net10 WX5837 VDD VDD pmos W=0.205u L=0.04u
M21997 WX4043 n1286 U2545/net26 VSS nmos W=0.155u L=0.04u
M21998 WX4043 n1804 U2545/net26 VSS nmos W=0.155u L=0.04u
M21999 U2545/net29 n1933 VSS VSS nmos W=0.155u L=0.04u
M22000 U2545/net26 n1932 U2545/net29 VSS nmos W=0.155u L=0.04u
M22001 U2545/net26 n1258 U2545/net29 VSS nmos W=0.155u L=0.04u
M22002 WX4043 n1804 U2545/net43 VDD pmos W=0.205u L=0.04u
M22003 WX4043 n1258 U2545/net49 VDD pmos W=0.205u L=0.04u
M22004 U2545/net49 n1932 VDD VDD pmos W=0.205u L=0.04u
M22005 U2545/net43 n1286 VDD VDD pmos W=0.205u L=0.04u
M22006 WX4043 n1933 VDD VDD pmos W=0.205u L=0.04u
M22007 U2546/net29 n1353 VSS VSS nmos W=0.155u L=0.04u
M22008 n1933 WX4382 U2546/net29 VSS nmos W=0.155u L=0.04u
M22009 n1933 n1319 U2546/net23 VSS nmos W=0.155u L=0.04u
M22010 U2546/net23 CRC_OUT_6_22 VSS VSS nmos W=0.155u L=0.04u
M22011 U2546/net20 CRC_OUT_6_22 n1933 VDD pmos W=0.205u L=0.04u
M22012 U2546/net20 n1319 n1933 VDD pmos W=0.205u L=0.04u
M22013 VDD WX4382 U2546/net20 VDD pmos W=0.205u L=0.04u
M22014 VDD n1353 U2546/net20 VDD pmos W=0.205u L=0.04u
M22015 n1804 n1934 VSS VSS nmos W=0.135u L=0.04u
M22016 n1804 n1934 VDD VDD pmos W=0.205u L=0.04u
M22017 U2548/net28 U2548/net20 U2548/net64 VSS nmos W=0.155u L=0.04u
M22018 U2548/net24 U2548/net30 U2548/net32 VSS nmos W=0.155u L=0.04u
M22019 U2548/net28 U2548/net40 U2548/net24 VSS nmos W=0.155u L=0.04u
M22020 U2548/net40 n1935 U2548/net108 VSS nmos W=0.155u L=0.04u
M22021 U2548/net40 U2548/net106 U2548/net104 VSS nmos W=0.155u L=0.04u
M22022 U2548/net24 WX5963 U2548/net050 VSS nmos W=0.155u L=0.04u
M22023 U2548/net050 U2548/net32 VSS VSS nmos W=0.155u L=0.04u
M22024 U2548/net20 U2548/net40 VSS VSS nmos W=0.155u L=0.04u
M22025 U2548/net106 n1935 VSS VSS nmos W=0.155u L=0.04u
M22026 U2548/net104 WX6027 VSS VSS nmos W=0.155u L=0.04u
M22027 U2548/net30 WX5963 VSS VSS nmos W=0.155u L=0.04u
M22028 U2548/net108 U2548/net104 VSS VSS nmos W=0.155u L=0.04u
M22029 n1934 U2548/net28 VSS VSS nmos W=0.155u L=0.04u
M22030 U2548/net32 WX5899 VSS VSS nmos W=0.155u L=0.04u
M22031 U2548/net64 U2548/net24 VSS VSS nmos W=0.2u L=0.04u
M22032 U2548/net28 U2548/net40 U2548/net64 VDD pmos W=0.205u L=0.04u
M22033 U2548/net24 WX5963 U2548/net32 VDD pmos W=0.205u L=0.04u
M22034 U2548/net28 U2548/net20 U2548/net24 VDD pmos W=0.205u L=0.04u
M22035 U2548/net40 U2548/net106 U2548/net108 VDD pmos W=0.205u L=0.04u
M22036 U2548/net40 n1935 U2548/net104 VDD pmos W=0.205u L=0.04u
M22037 U2548/net20 U2548/net40 VDD VDD pmos W=0.205u L=0.04u
M22038 U2548/net106 n1935 VDD VDD pmos W=0.205u L=0.04u
M22039 U2548/net104 WX6027 VDD VDD pmos W=0.205u L=0.04u
M22040 U2548/net30 WX5963 VDD VDD pmos W=0.205u L=0.04u
M22041 U2548/net108 U2548/net104 VDD VDD pmos W=0.205u L=0.04u
M22042 n1934 U2548/net28 VDD VDD pmos W=0.205u L=0.04u
M22043 U2548/net32 WX5899 VDD VDD pmos W=0.205u L=0.04u
M22044 U2548/net64 U2548/net24 VDD VDD pmos W=0.28u L=0.04u
M22045 U2548/net24 U2548/net30 U2548/net045 VDD pmos W=0.205u L=0.04u
M22046 U2548/net045 U2548/net32 VDD VDD pmos W=0.205u L=0.04u
M22047 U2549/net4 WX5835 U2549/net14 VSS nmos W=0.155u L=0.04u
M22048 U2549/net6 U2549/net10 U2549/net14 VSS nmos W=0.17u L=0.04u
M22049 U2549/net4 n1372 VSS VSS nmos W=0.155u L=0.04u
M22050 U2549/net6 U2549/net4 VSS VSS nmos W=0.17u L=0.04u
M22051 n1935 U2549/net14 VSS VSS nmos W=0.155u L=0.04u
M22052 U2549/net10 WX5835 VSS VSS nmos W=0.155u L=0.04u
M22053 U2549/net4 U2549/net10 U2549/net14 VDD pmos W=0.255u L=0.04u
M22054 U2549/net6 WX5835 U2549/net14 VDD pmos W=0.28u L=0.04u
M22055 U2549/net4 n1372 VDD VDD pmos W=0.205u L=0.04u
M22056 U2549/net6 U2549/net4 VDD VDD pmos W=0.24u L=0.04u
M22057 n1935 U2549/net14 VDD VDD pmos W=0.205u L=0.04u
M22058 U2549/net10 WX5835 VDD VDD pmos W=0.205u L=0.04u
M22059 WX4029 n1286 U2550/net26 VSS nmos W=0.155u L=0.04u
M22060 WX4029 n1808 U2550/net26 VSS nmos W=0.155u L=0.04u
M22061 U2550/net29 n1937 VSS VSS nmos W=0.155u L=0.04u
M22062 U2550/net26 n1936 U2550/net29 VSS nmos W=0.155u L=0.04u
M22063 U2550/net26 n1257 U2550/net29 VSS nmos W=0.155u L=0.04u
M22064 WX4029 n1808 U2550/net43 VDD pmos W=0.205u L=0.04u
M22065 WX4029 n1257 U2550/net49 VDD pmos W=0.205u L=0.04u
M22066 U2550/net49 n1936 VDD VDD pmos W=0.205u L=0.04u
M22067 U2550/net43 n1286 VDD VDD pmos W=0.205u L=0.04u
M22068 WX4029 n1937 VDD VDD pmos W=0.205u L=0.04u
M22069 U2551/net29 n1352 VSS VSS nmos W=0.155u L=0.04u
M22070 n1937 WX4380 U2551/net29 VSS nmos W=0.155u L=0.04u
M22071 n1937 n1319 U2551/net23 VSS nmos W=0.155u L=0.04u
M22072 U2551/net23 CRC_OUT_6_23 VSS VSS nmos W=0.155u L=0.04u
M22073 U2551/net20 CRC_OUT_6_23 n1937 VDD pmos W=0.205u L=0.04u
M22074 U2551/net20 n1319 n1937 VDD pmos W=0.205u L=0.04u
M22075 VDD WX4380 U2551/net20 VDD pmos W=0.205u L=0.04u
M22076 VDD n1352 U2551/net20 VDD pmos W=0.205u L=0.04u
M22077 n1808 n1938 VSS VSS nmos W=0.135u L=0.04u
M22078 n1808 n1938 VDD VDD pmos W=0.205u L=0.04u
M22079 U2553/net28 U2553/net20 U2553/net64 VSS nmos W=0.155u L=0.04u
M22080 U2553/net24 U2553/net30 U2553/net32 VSS nmos W=0.155u L=0.04u
M22081 U2553/net28 U2553/net40 U2553/net24 VSS nmos W=0.155u L=0.04u
M22082 U2553/net40 n1939 U2553/net108 VSS nmos W=0.155u L=0.04u
M22083 U2553/net40 U2553/net106 U2553/net104 VSS nmos W=0.155u L=0.04u
M22084 U2553/net24 WX5961 U2553/net050 VSS nmos W=0.155u L=0.04u
M22085 U2553/net050 U2553/net32 VSS VSS nmos W=0.155u L=0.04u
M22086 U2553/net20 U2553/net40 VSS VSS nmos W=0.155u L=0.04u
M22087 U2553/net106 n1939 VSS VSS nmos W=0.155u L=0.04u
M22088 U2553/net104 WX6025 VSS VSS nmos W=0.155u L=0.04u
M22089 U2553/net30 WX5961 VSS VSS nmos W=0.155u L=0.04u
M22090 U2553/net108 U2553/net104 VSS VSS nmos W=0.155u L=0.04u
M22091 n1938 U2553/net28 VSS VSS nmos W=0.155u L=0.04u
M22092 U2553/net32 WX5897 VSS VSS nmos W=0.155u L=0.04u
M22093 U2553/net64 U2553/net24 VSS VSS nmos W=0.2u L=0.04u
M22094 U2553/net28 U2553/net40 U2553/net64 VDD pmos W=0.205u L=0.04u
M22095 U2553/net24 WX5961 U2553/net32 VDD pmos W=0.205u L=0.04u
M22096 U2553/net28 U2553/net20 U2553/net24 VDD pmos W=0.205u L=0.04u
M22097 U2553/net40 U2553/net106 U2553/net108 VDD pmos W=0.205u L=0.04u
M22098 U2553/net40 n1939 U2553/net104 VDD pmos W=0.205u L=0.04u
M22099 U2553/net20 U2553/net40 VDD VDD pmos W=0.205u L=0.04u
M22100 U2553/net106 n1939 VDD VDD pmos W=0.205u L=0.04u
M22101 U2553/net104 WX6025 VDD VDD pmos W=0.205u L=0.04u
M22102 U2553/net30 WX5961 VDD VDD pmos W=0.205u L=0.04u
M22103 U2553/net108 U2553/net104 VDD VDD pmos W=0.205u L=0.04u
M22104 n1938 U2553/net28 VDD VDD pmos W=0.205u L=0.04u
M22105 U2553/net32 WX5897 VDD VDD pmos W=0.205u L=0.04u
M22106 U2553/net64 U2553/net24 VDD VDD pmos W=0.28u L=0.04u
M22107 U2553/net24 U2553/net30 U2553/net045 VDD pmos W=0.205u L=0.04u
M22108 U2553/net045 U2553/net32 VDD VDD pmos W=0.205u L=0.04u
M22109 U2554/net4 WX5833 U2554/net14 VSS nmos W=0.155u L=0.04u
M22110 U2554/net6 U2554/net10 U2554/net14 VSS nmos W=0.17u L=0.04u
M22111 U2554/net4 n1372 VSS VSS nmos W=0.155u L=0.04u
M22112 U2554/net6 U2554/net4 VSS VSS nmos W=0.17u L=0.04u
M22113 n1939 U2554/net14 VSS VSS nmos W=0.155u L=0.04u
M22114 U2554/net10 WX5833 VSS VSS nmos W=0.155u L=0.04u
M22115 U2554/net4 U2554/net10 U2554/net14 VDD pmos W=0.255u L=0.04u
M22116 U2554/net6 WX5833 U2554/net14 VDD pmos W=0.28u L=0.04u
M22117 U2554/net4 n1372 VDD VDD pmos W=0.205u L=0.04u
M22118 U2554/net6 U2554/net4 VDD VDD pmos W=0.24u L=0.04u
M22119 n1939 U2554/net14 VDD VDD pmos W=0.205u L=0.04u
M22120 U2554/net10 WX5833 VDD VDD pmos W=0.205u L=0.04u
M22121 WX402 n1286 U2555/net26 VSS nmos W=0.155u L=0.04u
M22122 WX402 n1940 U2555/net26 VSS nmos W=0.155u L=0.04u
M22123 U2555/net29 n1942 VSS VSS nmos W=0.155u L=0.04u
M22124 U2555/net26 n1941 U2555/net29 VSS nmos W=0.155u L=0.04u
M22125 U2555/net26 n1257 U2555/net29 VSS nmos W=0.155u L=0.04u
M22126 WX402 n1940 U2555/net43 VDD pmos W=0.205u L=0.04u
M22127 WX402 n1257 U2555/net49 VDD pmos W=0.205u L=0.04u
M22128 U2555/net49 n1941 VDD VDD pmos W=0.205u L=0.04u
M22129 U2555/net43 n1286 VDD VDD pmos W=0.205u L=0.04u
M22130 WX402 n1942 VDD VDD pmos W=0.205u L=0.04u
M22131 U2556/net29 n1352 VSS VSS nmos W=0.155u L=0.04u
M22132 n1942 WX537 U2556/net29 VSS nmos W=0.155u L=0.04u
M22133 n1942 n1319 U2556/net23 VSS nmos W=0.155u L=0.04u
M22134 U2556/net23 CRC_OUT_9_5 VSS VSS nmos W=0.155u L=0.04u
M22135 U2556/net20 CRC_OUT_9_5 n1942 VDD pmos W=0.205u L=0.04u
M22136 U2556/net20 n1319 n1942 VDD pmos W=0.205u L=0.04u
M22137 VDD WX537 U2556/net20 VDD pmos W=0.205u L=0.04u
M22138 VDD n1352 U2556/net20 VDD pmos W=0.205u L=0.04u
M22139 WX4015 n1285 U2557/net26 VSS nmos W=0.155u L=0.04u
M22140 WX4015 n1812 U2557/net26 VSS nmos W=0.155u L=0.04u
M22141 U2557/net29 n1944 VSS VSS nmos W=0.155u L=0.04u
M22142 U2557/net26 n1943 U2557/net29 VSS nmos W=0.155u L=0.04u
M22143 U2557/net26 n1257 U2557/net29 VSS nmos W=0.155u L=0.04u
M22144 WX4015 n1812 U2557/net43 VDD pmos W=0.205u L=0.04u
M22145 WX4015 n1257 U2557/net49 VDD pmos W=0.205u L=0.04u
M22146 U2557/net49 n1943 VDD VDD pmos W=0.205u L=0.04u
M22147 U2557/net43 n1285 VDD VDD pmos W=0.205u L=0.04u
M22148 WX4015 n1944 VDD VDD pmos W=0.205u L=0.04u
M22149 U2558/net29 n1352 VSS VSS nmos W=0.155u L=0.04u
M22150 n1944 WX4378 U2558/net29 VSS nmos W=0.155u L=0.04u
M22151 n1944 n1319 U2558/net23 VSS nmos W=0.155u L=0.04u
M22152 U2558/net23 CRC_OUT_6_24 VSS VSS nmos W=0.155u L=0.04u
M22153 U2558/net20 CRC_OUT_6_24 n1944 VDD pmos W=0.205u L=0.04u
M22154 U2558/net20 n1319 n1944 VDD pmos W=0.205u L=0.04u
M22155 VDD WX4378 U2558/net20 VDD pmos W=0.205u L=0.04u
M22156 VDD n1352 U2558/net20 VDD pmos W=0.205u L=0.04u
M22157 n1812 n1945 VSS VSS nmos W=0.135u L=0.04u
M22158 n1812 n1945 VDD VDD pmos W=0.205u L=0.04u
M22159 U2560/net28 U2560/net20 U2560/net64 VSS nmos W=0.155u L=0.04u
M22160 U2560/net24 U2560/net30 U2560/net32 VSS nmos W=0.155u L=0.04u
M22161 U2560/net28 U2560/net40 U2560/net24 VSS nmos W=0.155u L=0.04u
M22162 U2560/net40 n1946 U2560/net108 VSS nmos W=0.155u L=0.04u
M22163 U2560/net40 U2560/net106 U2560/net104 VSS nmos W=0.155u L=0.04u
M22164 U2560/net24 WX5959 U2560/net050 VSS nmos W=0.155u L=0.04u
M22165 U2560/net050 U2560/net32 VSS VSS nmos W=0.155u L=0.04u
M22166 U2560/net20 U2560/net40 VSS VSS nmos W=0.155u L=0.04u
M22167 U2560/net106 n1946 VSS VSS nmos W=0.155u L=0.04u
M22168 U2560/net104 WX6023 VSS VSS nmos W=0.155u L=0.04u
M22169 U2560/net30 WX5959 VSS VSS nmos W=0.155u L=0.04u
M22170 U2560/net108 U2560/net104 VSS VSS nmos W=0.155u L=0.04u
M22171 n1945 U2560/net28 VSS VSS nmos W=0.155u L=0.04u
M22172 U2560/net32 WX5895 VSS VSS nmos W=0.155u L=0.04u
M22173 U2560/net64 U2560/net24 VSS VSS nmos W=0.2u L=0.04u
M22174 U2560/net28 U2560/net40 U2560/net64 VDD pmos W=0.205u L=0.04u
M22175 U2560/net24 WX5959 U2560/net32 VDD pmos W=0.205u L=0.04u
M22176 U2560/net28 U2560/net20 U2560/net24 VDD pmos W=0.205u L=0.04u
M22177 U2560/net40 U2560/net106 U2560/net108 VDD pmos W=0.205u L=0.04u
M22178 U2560/net40 n1946 U2560/net104 VDD pmos W=0.205u L=0.04u
M22179 U2560/net20 U2560/net40 VDD VDD pmos W=0.205u L=0.04u
M22180 U2560/net106 n1946 VDD VDD pmos W=0.205u L=0.04u
M22181 U2560/net104 WX6023 VDD VDD pmos W=0.205u L=0.04u
M22182 U2560/net30 WX5959 VDD VDD pmos W=0.205u L=0.04u
M22183 U2560/net108 U2560/net104 VDD VDD pmos W=0.205u L=0.04u
M22184 n1945 U2560/net28 VDD VDD pmos W=0.205u L=0.04u
M22185 U2560/net32 WX5895 VDD VDD pmos W=0.205u L=0.04u
M22186 U2560/net64 U2560/net24 VDD VDD pmos W=0.28u L=0.04u
M22187 U2560/net24 U2560/net30 U2560/net045 VDD pmos W=0.205u L=0.04u
M22188 U2560/net045 U2560/net32 VDD VDD pmos W=0.205u L=0.04u
M22189 U2561/net4 WX5831 U2561/net14 VSS nmos W=0.155u L=0.04u
M22190 U2561/net6 U2561/net10 U2561/net14 VSS nmos W=0.17u L=0.04u
M22191 U2561/net4 n1372 VSS VSS nmos W=0.155u L=0.04u
M22192 U2561/net6 U2561/net4 VSS VSS nmos W=0.17u L=0.04u
M22193 n1946 U2561/net14 VSS VSS nmos W=0.155u L=0.04u
M22194 U2561/net10 WX5831 VSS VSS nmos W=0.155u L=0.04u
M22195 U2561/net4 U2561/net10 U2561/net14 VDD pmos W=0.255u L=0.04u
M22196 U2561/net6 WX5831 U2561/net14 VDD pmos W=0.28u L=0.04u
M22197 U2561/net4 n1372 VDD VDD pmos W=0.205u L=0.04u
M22198 U2561/net6 U2561/net4 VDD VDD pmos W=0.24u L=0.04u
M22199 n1946 U2561/net14 VDD VDD pmos W=0.205u L=0.04u
M22200 U2561/net10 WX5831 VDD VDD pmos W=0.205u L=0.04u
M22201 WX4001 n1285 U2562/net26 VSS nmos W=0.155u L=0.04u
M22202 WX4001 n1816 U2562/net26 VSS nmos W=0.155u L=0.04u
M22203 U2562/net29 n1948 VSS VSS nmos W=0.155u L=0.04u
M22204 U2562/net26 n1947 U2562/net29 VSS nmos W=0.155u L=0.04u
M22205 U2562/net26 n1257 U2562/net29 VSS nmos W=0.155u L=0.04u
M22206 WX4001 n1816 U2562/net43 VDD pmos W=0.205u L=0.04u
M22207 WX4001 n1257 U2562/net49 VDD pmos W=0.205u L=0.04u
M22208 U2562/net49 n1947 VDD VDD pmos W=0.205u L=0.04u
M22209 U2562/net43 n1285 VDD VDD pmos W=0.205u L=0.04u
M22210 WX4001 n1948 VDD VDD pmos W=0.205u L=0.04u
M22211 U2563/net29 n1352 VSS VSS nmos W=0.155u L=0.04u
M22212 n1948 WX4376 U2563/net29 VSS nmos W=0.155u L=0.04u
M22213 n1948 n1319 U2563/net23 VSS nmos W=0.155u L=0.04u
M22214 U2563/net23 CRC_OUT_6_25 VSS VSS nmos W=0.155u L=0.04u
M22215 U2563/net20 CRC_OUT_6_25 n1948 VDD pmos W=0.205u L=0.04u
M22216 U2563/net20 n1319 n1948 VDD pmos W=0.205u L=0.04u
M22217 VDD WX4376 U2563/net20 VDD pmos W=0.205u L=0.04u
M22218 VDD n1352 U2563/net20 VDD pmos W=0.205u L=0.04u
M22219 n1816 n1949 VSS VSS nmos W=0.135u L=0.04u
M22220 n1816 n1949 VDD VDD pmos W=0.205u L=0.04u
M22221 U2565/net28 U2565/net20 U2565/net64 VSS nmos W=0.155u L=0.04u
M22222 U2565/net24 U2565/net30 U2565/net32 VSS nmos W=0.155u L=0.04u
M22223 U2565/net28 U2565/net40 U2565/net24 VSS nmos W=0.155u L=0.04u
M22224 U2565/net40 n1950 U2565/net108 VSS nmos W=0.155u L=0.04u
M22225 U2565/net40 U2565/net106 U2565/net104 VSS nmos W=0.155u L=0.04u
M22226 U2565/net24 WX5957 U2565/net050 VSS nmos W=0.155u L=0.04u
M22227 U2565/net050 U2565/net32 VSS VSS nmos W=0.155u L=0.04u
M22228 U2565/net20 U2565/net40 VSS VSS nmos W=0.155u L=0.04u
M22229 U2565/net106 n1950 VSS VSS nmos W=0.155u L=0.04u
M22230 U2565/net104 WX6021 VSS VSS nmos W=0.155u L=0.04u
M22231 U2565/net30 WX5957 VSS VSS nmos W=0.155u L=0.04u
M22232 U2565/net108 U2565/net104 VSS VSS nmos W=0.155u L=0.04u
M22233 n1949 U2565/net28 VSS VSS nmos W=0.155u L=0.04u
M22234 U2565/net32 WX5893 VSS VSS nmos W=0.155u L=0.04u
M22235 U2565/net64 U2565/net24 VSS VSS nmos W=0.2u L=0.04u
M22236 U2565/net28 U2565/net40 U2565/net64 VDD pmos W=0.205u L=0.04u
M22237 U2565/net24 WX5957 U2565/net32 VDD pmos W=0.205u L=0.04u
M22238 U2565/net28 U2565/net20 U2565/net24 VDD pmos W=0.205u L=0.04u
M22239 U2565/net40 U2565/net106 U2565/net108 VDD pmos W=0.205u L=0.04u
M22240 U2565/net40 n1950 U2565/net104 VDD pmos W=0.205u L=0.04u
M22241 U2565/net20 U2565/net40 VDD VDD pmos W=0.205u L=0.04u
M22242 U2565/net106 n1950 VDD VDD pmos W=0.205u L=0.04u
M22243 U2565/net104 WX6021 VDD VDD pmos W=0.205u L=0.04u
M22244 U2565/net30 WX5957 VDD VDD pmos W=0.205u L=0.04u
M22245 U2565/net108 U2565/net104 VDD VDD pmos W=0.205u L=0.04u
M22246 n1949 U2565/net28 VDD VDD pmos W=0.205u L=0.04u
M22247 U2565/net32 WX5893 VDD VDD pmos W=0.205u L=0.04u
M22248 U2565/net64 U2565/net24 VDD VDD pmos W=0.28u L=0.04u
M22249 U2565/net24 U2565/net30 U2565/net045 VDD pmos W=0.205u L=0.04u
M22250 U2565/net045 U2565/net32 VDD VDD pmos W=0.205u L=0.04u
M22251 U2566/net4 WX5829 U2566/net14 VSS nmos W=0.155u L=0.04u
M22252 U2566/net6 U2566/net10 U2566/net14 VSS nmos W=0.17u L=0.04u
M22253 U2566/net4 n1372 VSS VSS nmos W=0.155u L=0.04u
M22254 U2566/net6 U2566/net4 VSS VSS nmos W=0.17u L=0.04u
M22255 n1950 U2566/net14 VSS VSS nmos W=0.155u L=0.04u
M22256 U2566/net10 WX5829 VSS VSS nmos W=0.155u L=0.04u
M22257 U2566/net4 U2566/net10 U2566/net14 VDD pmos W=0.255u L=0.04u
M22258 U2566/net6 WX5829 U2566/net14 VDD pmos W=0.28u L=0.04u
M22259 U2566/net4 n1372 VDD VDD pmos W=0.205u L=0.04u
M22260 U2566/net6 U2566/net4 VDD VDD pmos W=0.24u L=0.04u
M22261 n1950 U2566/net14 VDD VDD pmos W=0.205u L=0.04u
M22262 U2566/net10 WX5829 VDD VDD pmos W=0.205u L=0.04u
M22263 WX3987 n1285 U2567/net26 VSS nmos W=0.155u L=0.04u
M22264 WX3987 n1820 U2567/net26 VSS nmos W=0.155u L=0.04u
M22265 U2567/net29 n1952 VSS VSS nmos W=0.155u L=0.04u
M22266 U2567/net26 n1951 U2567/net29 VSS nmos W=0.155u L=0.04u
M22267 U2567/net26 n1257 U2567/net29 VSS nmos W=0.155u L=0.04u
M22268 WX3987 n1820 U2567/net43 VDD pmos W=0.205u L=0.04u
M22269 WX3987 n1257 U2567/net49 VDD pmos W=0.205u L=0.04u
M22270 U2567/net49 n1951 VDD VDD pmos W=0.205u L=0.04u
M22271 U2567/net43 n1285 VDD VDD pmos W=0.205u L=0.04u
M22272 WX3987 n1952 VDD VDD pmos W=0.205u L=0.04u
M22273 U2568/net29 n1352 VSS VSS nmos W=0.155u L=0.04u
M22274 n1952 WX4374 U2568/net29 VSS nmos W=0.155u L=0.04u
M22275 n1952 n1319 U2568/net23 VSS nmos W=0.155u L=0.04u
M22276 U2568/net23 CRC_OUT_6_26 VSS VSS nmos W=0.155u L=0.04u
M22277 U2568/net20 CRC_OUT_6_26 n1952 VDD pmos W=0.205u L=0.04u
M22278 U2568/net20 n1319 n1952 VDD pmos W=0.205u L=0.04u
M22279 VDD WX4374 U2568/net20 VDD pmos W=0.205u L=0.04u
M22280 VDD n1352 U2568/net20 VDD pmos W=0.205u L=0.04u
M22281 n1820 n1953 VSS VSS nmos W=0.135u L=0.04u
M22282 n1820 n1953 VDD VDD pmos W=0.205u L=0.04u
M22283 U2570/net28 U2570/net20 U2570/net64 VSS nmos W=0.155u L=0.04u
M22284 U2570/net24 U2570/net30 U2570/net32 VSS nmos W=0.155u L=0.04u
M22285 U2570/net28 U2570/net40 U2570/net24 VSS nmos W=0.155u L=0.04u
M22286 U2570/net40 n1954 U2570/net108 VSS nmos W=0.155u L=0.04u
M22287 U2570/net40 U2570/net106 U2570/net104 VSS nmos W=0.155u L=0.04u
M22288 U2570/net24 WX5955 U2570/net050 VSS nmos W=0.155u L=0.04u
M22289 U2570/net050 U2570/net32 VSS VSS nmos W=0.155u L=0.04u
M22290 U2570/net20 U2570/net40 VSS VSS nmos W=0.155u L=0.04u
M22291 U2570/net106 n1954 VSS VSS nmos W=0.155u L=0.04u
M22292 U2570/net104 WX6019 VSS VSS nmos W=0.155u L=0.04u
M22293 U2570/net30 WX5955 VSS VSS nmos W=0.155u L=0.04u
M22294 U2570/net108 U2570/net104 VSS VSS nmos W=0.155u L=0.04u
M22295 n1953 U2570/net28 VSS VSS nmos W=0.155u L=0.04u
M22296 U2570/net32 WX5891 VSS VSS nmos W=0.155u L=0.04u
M22297 U2570/net64 U2570/net24 VSS VSS nmos W=0.2u L=0.04u
M22298 U2570/net28 U2570/net40 U2570/net64 VDD pmos W=0.205u L=0.04u
M22299 U2570/net24 WX5955 U2570/net32 VDD pmos W=0.205u L=0.04u
M22300 U2570/net28 U2570/net20 U2570/net24 VDD pmos W=0.205u L=0.04u
M22301 U2570/net40 U2570/net106 U2570/net108 VDD pmos W=0.205u L=0.04u
M22302 U2570/net40 n1954 U2570/net104 VDD pmos W=0.205u L=0.04u
M22303 U2570/net20 U2570/net40 VDD VDD pmos W=0.205u L=0.04u
M22304 U2570/net106 n1954 VDD VDD pmos W=0.205u L=0.04u
M22305 U2570/net104 WX6019 VDD VDD pmos W=0.205u L=0.04u
M22306 U2570/net30 WX5955 VDD VDD pmos W=0.205u L=0.04u
M22307 U2570/net108 U2570/net104 VDD VDD pmos W=0.205u L=0.04u
M22308 n1953 U2570/net28 VDD VDD pmos W=0.205u L=0.04u
M22309 U2570/net32 WX5891 VDD VDD pmos W=0.205u L=0.04u
M22310 U2570/net64 U2570/net24 VDD VDD pmos W=0.28u L=0.04u
M22311 U2570/net24 U2570/net30 U2570/net045 VDD pmos W=0.205u L=0.04u
M22312 U2570/net045 U2570/net32 VDD VDD pmos W=0.205u L=0.04u
M22313 U2571/net4 WX5827 U2571/net14 VSS nmos W=0.155u L=0.04u
M22314 U2571/net6 U2571/net10 U2571/net14 VSS nmos W=0.17u L=0.04u
M22315 U2571/net4 n1372 VSS VSS nmos W=0.155u L=0.04u
M22316 U2571/net6 U2571/net4 VSS VSS nmos W=0.17u L=0.04u
M22317 n1954 U2571/net14 VSS VSS nmos W=0.155u L=0.04u
M22318 U2571/net10 WX5827 VSS VSS nmos W=0.155u L=0.04u
M22319 U2571/net4 U2571/net10 U2571/net14 VDD pmos W=0.255u L=0.04u
M22320 U2571/net6 WX5827 U2571/net14 VDD pmos W=0.28u L=0.04u
M22321 U2571/net4 n1372 VDD VDD pmos W=0.205u L=0.04u
M22322 U2571/net6 U2571/net4 VDD VDD pmos W=0.24u L=0.04u
M22323 n1954 U2571/net14 VDD VDD pmos W=0.205u L=0.04u
M22324 U2571/net10 WX5827 VDD VDD pmos W=0.205u L=0.04u
M22325 WX3973 n1285 U2572/net26 VSS nmos W=0.155u L=0.04u
M22326 WX3973 n1824 U2572/net26 VSS nmos W=0.155u L=0.04u
M22327 U2572/net29 n1956 VSS VSS nmos W=0.155u L=0.04u
M22328 U2572/net26 n1955 U2572/net29 VSS nmos W=0.155u L=0.04u
M22329 U2572/net26 n1257 U2572/net29 VSS nmos W=0.155u L=0.04u
M22330 WX3973 n1824 U2572/net43 VDD pmos W=0.205u L=0.04u
M22331 WX3973 n1257 U2572/net49 VDD pmos W=0.205u L=0.04u
M22332 U2572/net49 n1955 VDD VDD pmos W=0.205u L=0.04u
M22333 U2572/net43 n1285 VDD VDD pmos W=0.205u L=0.04u
M22334 WX3973 n1956 VDD VDD pmos W=0.205u L=0.04u
M22335 U2573/net29 n1352 VSS VSS nmos W=0.155u L=0.04u
M22336 n1956 WX4372 U2573/net29 VSS nmos W=0.155u L=0.04u
M22337 n1956 n1319 U2573/net23 VSS nmos W=0.155u L=0.04u
M22338 U2573/net23 CRC_OUT_6_27 VSS VSS nmos W=0.155u L=0.04u
M22339 U2573/net20 CRC_OUT_6_27 n1956 VDD pmos W=0.205u L=0.04u
M22340 U2573/net20 n1319 n1956 VDD pmos W=0.205u L=0.04u
M22341 VDD WX4372 U2573/net20 VDD pmos W=0.205u L=0.04u
M22342 VDD n1352 U2573/net20 VDD pmos W=0.205u L=0.04u
M22343 n1824 n1957 VSS VSS nmos W=0.135u L=0.04u
M22344 n1824 n1957 VDD VDD pmos W=0.205u L=0.04u
M22345 U2575/net28 U2575/net20 U2575/net64 VSS nmos W=0.155u L=0.04u
M22346 U2575/net24 U2575/net30 U2575/net32 VSS nmos W=0.155u L=0.04u
M22347 U2575/net28 U2575/net40 U2575/net24 VSS nmos W=0.155u L=0.04u
M22348 U2575/net40 n1958 U2575/net108 VSS nmos W=0.155u L=0.04u
M22349 U2575/net40 U2575/net106 U2575/net104 VSS nmos W=0.155u L=0.04u
M22350 U2575/net24 WX5953 U2575/net050 VSS nmos W=0.155u L=0.04u
M22351 U2575/net050 U2575/net32 VSS VSS nmos W=0.155u L=0.04u
M22352 U2575/net20 U2575/net40 VSS VSS nmos W=0.155u L=0.04u
M22353 U2575/net106 n1958 VSS VSS nmos W=0.155u L=0.04u
M22354 U2575/net104 WX6017 VSS VSS nmos W=0.155u L=0.04u
M22355 U2575/net30 WX5953 VSS VSS nmos W=0.155u L=0.04u
M22356 U2575/net108 U2575/net104 VSS VSS nmos W=0.155u L=0.04u
M22357 n1957 U2575/net28 VSS VSS nmos W=0.155u L=0.04u
M22358 U2575/net32 WX5889 VSS VSS nmos W=0.155u L=0.04u
M22359 U2575/net64 U2575/net24 VSS VSS nmos W=0.2u L=0.04u
M22360 U2575/net28 U2575/net40 U2575/net64 VDD pmos W=0.205u L=0.04u
M22361 U2575/net24 WX5953 U2575/net32 VDD pmos W=0.205u L=0.04u
M22362 U2575/net28 U2575/net20 U2575/net24 VDD pmos W=0.205u L=0.04u
M22363 U2575/net40 U2575/net106 U2575/net108 VDD pmos W=0.205u L=0.04u
M22364 U2575/net40 n1958 U2575/net104 VDD pmos W=0.205u L=0.04u
M22365 U2575/net20 U2575/net40 VDD VDD pmos W=0.205u L=0.04u
M22366 U2575/net106 n1958 VDD VDD pmos W=0.205u L=0.04u
M22367 U2575/net104 WX6017 VDD VDD pmos W=0.205u L=0.04u
M22368 U2575/net30 WX5953 VDD VDD pmos W=0.205u L=0.04u
M22369 U2575/net108 U2575/net104 VDD VDD pmos W=0.205u L=0.04u
M22370 n1957 U2575/net28 VDD VDD pmos W=0.205u L=0.04u
M22371 U2575/net32 WX5889 VDD VDD pmos W=0.205u L=0.04u
M22372 U2575/net64 U2575/net24 VDD VDD pmos W=0.28u L=0.04u
M22373 U2575/net24 U2575/net30 U2575/net045 VDD pmos W=0.205u L=0.04u
M22374 U2575/net045 U2575/net32 VDD VDD pmos W=0.205u L=0.04u
M22375 U2576/net4 WX5825 U2576/net14 VSS nmos W=0.155u L=0.04u
M22376 U2576/net6 U2576/net10 U2576/net14 VSS nmos W=0.17u L=0.04u
M22377 U2576/net4 n1372 VSS VSS nmos W=0.155u L=0.04u
M22378 U2576/net6 U2576/net4 VSS VSS nmos W=0.17u L=0.04u
M22379 n1958 U2576/net14 VSS VSS nmos W=0.155u L=0.04u
M22380 U2576/net10 WX5825 VSS VSS nmos W=0.155u L=0.04u
M22381 U2576/net4 U2576/net10 U2576/net14 VDD pmos W=0.255u L=0.04u
M22382 U2576/net6 WX5825 U2576/net14 VDD pmos W=0.28u L=0.04u
M22383 U2576/net4 n1372 VDD VDD pmos W=0.205u L=0.04u
M22384 U2576/net6 U2576/net4 VDD VDD pmos W=0.24u L=0.04u
M22385 n1958 U2576/net14 VDD VDD pmos W=0.205u L=0.04u
M22386 U2576/net10 WX5825 VDD VDD pmos W=0.205u L=0.04u
M22387 WX3959 n1285 U2577/net26 VSS nmos W=0.155u L=0.04u
M22388 WX3959 n1828 U2577/net26 VSS nmos W=0.155u L=0.04u
M22389 U2577/net29 n1960 VSS VSS nmos W=0.155u L=0.04u
M22390 U2577/net26 n1959 U2577/net29 VSS nmos W=0.155u L=0.04u
M22391 U2577/net26 n1257 U2577/net29 VSS nmos W=0.155u L=0.04u
M22392 WX3959 n1828 U2577/net43 VDD pmos W=0.205u L=0.04u
M22393 WX3959 n1257 U2577/net49 VDD pmos W=0.205u L=0.04u
M22394 U2577/net49 n1959 VDD VDD pmos W=0.205u L=0.04u
M22395 U2577/net43 n1285 VDD VDD pmos W=0.205u L=0.04u
M22396 WX3959 n1960 VDD VDD pmos W=0.205u L=0.04u
M22397 U2578/net29 n1352 VSS VSS nmos W=0.155u L=0.04u
M22398 n1960 WX4370 U2578/net29 VSS nmos W=0.155u L=0.04u
M22399 n1960 n1319 U2578/net23 VSS nmos W=0.155u L=0.04u
M22400 U2578/net23 CRC_OUT_6_28 VSS VSS nmos W=0.155u L=0.04u
M22401 U2578/net20 CRC_OUT_6_28 n1960 VDD pmos W=0.205u L=0.04u
M22402 U2578/net20 n1319 n1960 VDD pmos W=0.205u L=0.04u
M22403 VDD WX4370 U2578/net20 VDD pmos W=0.205u L=0.04u
M22404 VDD n1352 U2578/net20 VDD pmos W=0.205u L=0.04u
M22405 n1828 n1961 VSS VSS nmos W=0.135u L=0.04u
M22406 n1828 n1961 VDD VDD pmos W=0.205u L=0.04u
M22407 U2580/net28 U2580/net20 U2580/net64 VSS nmos W=0.155u L=0.04u
M22408 U2580/net24 U2580/net30 U2580/net32 VSS nmos W=0.155u L=0.04u
M22409 U2580/net28 U2580/net40 U2580/net24 VSS nmos W=0.155u L=0.04u
M22410 U2580/net40 n1962 U2580/net108 VSS nmos W=0.155u L=0.04u
M22411 U2580/net40 U2580/net106 U2580/net104 VSS nmos W=0.155u L=0.04u
M22412 U2580/net24 WX5951 U2580/net050 VSS nmos W=0.155u L=0.04u
M22413 U2580/net050 U2580/net32 VSS VSS nmos W=0.155u L=0.04u
M22414 U2580/net20 U2580/net40 VSS VSS nmos W=0.155u L=0.04u
M22415 U2580/net106 n1962 VSS VSS nmos W=0.155u L=0.04u
M22416 U2580/net104 WX6015 VSS VSS nmos W=0.155u L=0.04u
M22417 U2580/net30 WX5951 VSS VSS nmos W=0.155u L=0.04u
M22418 U2580/net108 U2580/net104 VSS VSS nmos W=0.155u L=0.04u
M22419 n1961 U2580/net28 VSS VSS nmos W=0.155u L=0.04u
M22420 U2580/net32 WX5887 VSS VSS nmos W=0.155u L=0.04u
M22421 U2580/net64 U2580/net24 VSS VSS nmos W=0.2u L=0.04u
M22422 U2580/net28 U2580/net40 U2580/net64 VDD pmos W=0.205u L=0.04u
M22423 U2580/net24 WX5951 U2580/net32 VDD pmos W=0.205u L=0.04u
M22424 U2580/net28 U2580/net20 U2580/net24 VDD pmos W=0.205u L=0.04u
M22425 U2580/net40 U2580/net106 U2580/net108 VDD pmos W=0.205u L=0.04u
M22426 U2580/net40 n1962 U2580/net104 VDD pmos W=0.205u L=0.04u
M22427 U2580/net20 U2580/net40 VDD VDD pmos W=0.205u L=0.04u
M22428 U2580/net106 n1962 VDD VDD pmos W=0.205u L=0.04u
M22429 U2580/net104 WX6015 VDD VDD pmos W=0.205u L=0.04u
M22430 U2580/net30 WX5951 VDD VDD pmos W=0.205u L=0.04u
M22431 U2580/net108 U2580/net104 VDD VDD pmos W=0.205u L=0.04u
M22432 n1961 U2580/net28 VDD VDD pmos W=0.205u L=0.04u
M22433 U2580/net32 WX5887 VDD VDD pmos W=0.205u L=0.04u
M22434 U2580/net64 U2580/net24 VDD VDD pmos W=0.28u L=0.04u
M22435 U2580/net24 U2580/net30 U2580/net045 VDD pmos W=0.205u L=0.04u
M22436 U2580/net045 U2580/net32 VDD VDD pmos W=0.205u L=0.04u
M22437 U2581/net4 WX5823 U2581/net14 VSS nmos W=0.155u L=0.04u
M22438 U2581/net6 U2581/net10 U2581/net14 VSS nmos W=0.17u L=0.04u
M22439 U2581/net4 n1373 VSS VSS nmos W=0.155u L=0.04u
M22440 U2581/net6 U2581/net4 VSS VSS nmos W=0.17u L=0.04u
M22441 n1962 U2581/net14 VSS VSS nmos W=0.155u L=0.04u
M22442 U2581/net10 WX5823 VSS VSS nmos W=0.155u L=0.04u
M22443 U2581/net4 U2581/net10 U2581/net14 VDD pmos W=0.255u L=0.04u
M22444 U2581/net6 WX5823 U2581/net14 VDD pmos W=0.28u L=0.04u
M22445 U2581/net4 n1373 VDD VDD pmos W=0.205u L=0.04u
M22446 U2581/net6 U2581/net4 VDD VDD pmos W=0.24u L=0.04u
M22447 n1962 U2581/net14 VDD VDD pmos W=0.205u L=0.04u
M22448 U2581/net10 WX5823 VDD VDD pmos W=0.205u L=0.04u
M22449 WX3945 n1285 U2582/net26 VSS nmos W=0.155u L=0.04u
M22450 WX3945 n1832 U2582/net26 VSS nmos W=0.155u L=0.04u
M22451 U2582/net29 n1964 VSS VSS nmos W=0.155u L=0.04u
M22452 U2582/net26 n1963 U2582/net29 VSS nmos W=0.155u L=0.04u
M22453 U2582/net26 n1257 U2582/net29 VSS nmos W=0.155u L=0.04u
M22454 WX3945 n1832 U2582/net43 VDD pmos W=0.205u L=0.04u
M22455 WX3945 n1257 U2582/net49 VDD pmos W=0.205u L=0.04u
M22456 U2582/net49 n1963 VDD VDD pmos W=0.205u L=0.04u
M22457 U2582/net43 n1285 VDD VDD pmos W=0.205u L=0.04u
M22458 WX3945 n1964 VDD VDD pmos W=0.205u L=0.04u
M22459 U2583/net29 n1352 VSS VSS nmos W=0.155u L=0.04u
M22460 n1964 WX4368 U2583/net29 VSS nmos W=0.155u L=0.04u
M22461 n1964 n1319 U2583/net23 VSS nmos W=0.155u L=0.04u
M22462 U2583/net23 CRC_OUT_6_29 VSS VSS nmos W=0.155u L=0.04u
M22463 U2583/net20 CRC_OUT_6_29 n1964 VDD pmos W=0.205u L=0.04u
M22464 U2583/net20 n1319 n1964 VDD pmos W=0.205u L=0.04u
M22465 VDD WX4368 U2583/net20 VDD pmos W=0.205u L=0.04u
M22466 VDD n1352 U2583/net20 VDD pmos W=0.205u L=0.04u
M22467 n1832 n1965 VSS VSS nmos W=0.135u L=0.04u
M22468 n1832 n1965 VDD VDD pmos W=0.205u L=0.04u
M22469 U2585/net28 U2585/net20 U2585/net64 VSS nmos W=0.155u L=0.04u
M22470 U2585/net24 U2585/net30 U2585/net32 VSS nmos W=0.155u L=0.04u
M22471 U2585/net28 U2585/net40 U2585/net24 VSS nmos W=0.155u L=0.04u
M22472 U2585/net40 n1966 U2585/net108 VSS nmos W=0.155u L=0.04u
M22473 U2585/net40 U2585/net106 U2585/net104 VSS nmos W=0.155u L=0.04u
M22474 U2585/net24 WX5949 U2585/net050 VSS nmos W=0.155u L=0.04u
M22475 U2585/net050 U2585/net32 VSS VSS nmos W=0.155u L=0.04u
M22476 U2585/net20 U2585/net40 VSS VSS nmos W=0.155u L=0.04u
M22477 U2585/net106 n1966 VSS VSS nmos W=0.155u L=0.04u
M22478 U2585/net104 WX6013 VSS VSS nmos W=0.155u L=0.04u
M22479 U2585/net30 WX5949 VSS VSS nmos W=0.155u L=0.04u
M22480 U2585/net108 U2585/net104 VSS VSS nmos W=0.155u L=0.04u
M22481 n1965 U2585/net28 VSS VSS nmos W=0.155u L=0.04u
M22482 U2585/net32 WX5885 VSS VSS nmos W=0.155u L=0.04u
M22483 U2585/net64 U2585/net24 VSS VSS nmos W=0.2u L=0.04u
M22484 U2585/net28 U2585/net40 U2585/net64 VDD pmos W=0.205u L=0.04u
M22485 U2585/net24 WX5949 U2585/net32 VDD pmos W=0.205u L=0.04u
M22486 U2585/net28 U2585/net20 U2585/net24 VDD pmos W=0.205u L=0.04u
M22487 U2585/net40 U2585/net106 U2585/net108 VDD pmos W=0.205u L=0.04u
M22488 U2585/net40 n1966 U2585/net104 VDD pmos W=0.205u L=0.04u
M22489 U2585/net20 U2585/net40 VDD VDD pmos W=0.205u L=0.04u
M22490 U2585/net106 n1966 VDD VDD pmos W=0.205u L=0.04u
M22491 U2585/net104 WX6013 VDD VDD pmos W=0.205u L=0.04u
M22492 U2585/net30 WX5949 VDD VDD pmos W=0.205u L=0.04u
M22493 U2585/net108 U2585/net104 VDD VDD pmos W=0.205u L=0.04u
M22494 n1965 U2585/net28 VDD VDD pmos W=0.205u L=0.04u
M22495 U2585/net32 WX5885 VDD VDD pmos W=0.205u L=0.04u
M22496 U2585/net64 U2585/net24 VDD VDD pmos W=0.28u L=0.04u
M22497 U2585/net24 U2585/net30 U2585/net045 VDD pmos W=0.205u L=0.04u
M22498 U2585/net045 U2585/net32 VDD VDD pmos W=0.205u L=0.04u
M22499 U2586/net4 WX5821 U2586/net14 VSS nmos W=0.155u L=0.04u
M22500 U2586/net6 U2586/net10 U2586/net14 VSS nmos W=0.17u L=0.04u
M22501 U2586/net4 n1373 VSS VSS nmos W=0.155u L=0.04u
M22502 U2586/net6 U2586/net4 VSS VSS nmos W=0.17u L=0.04u
M22503 n1966 U2586/net14 VSS VSS nmos W=0.155u L=0.04u
M22504 U2586/net10 WX5821 VSS VSS nmos W=0.155u L=0.04u
M22505 U2586/net4 U2586/net10 U2586/net14 VDD pmos W=0.255u L=0.04u
M22506 U2586/net6 WX5821 U2586/net14 VDD pmos W=0.28u L=0.04u
M22507 U2586/net4 n1373 VDD VDD pmos W=0.205u L=0.04u
M22508 U2586/net6 U2586/net4 VDD VDD pmos W=0.24u L=0.04u
M22509 n1966 U2586/net14 VDD VDD pmos W=0.205u L=0.04u
M22510 U2586/net10 WX5821 VDD VDD pmos W=0.205u L=0.04u
M22511 WX3931 n1285 U2587/net26 VSS nmos W=0.155u L=0.04u
M22512 WX3931 n1836 U2587/net26 VSS nmos W=0.155u L=0.04u
M22513 U2587/net29 n1968 VSS VSS nmos W=0.155u L=0.04u
M22514 U2587/net26 n1967 U2587/net29 VSS nmos W=0.155u L=0.04u
M22515 U2587/net26 n1257 U2587/net29 VSS nmos W=0.155u L=0.04u
M22516 WX3931 n1836 U2587/net43 VDD pmos W=0.205u L=0.04u
M22517 WX3931 n1257 U2587/net49 VDD pmos W=0.205u L=0.04u
M22518 U2587/net49 n1967 VDD VDD pmos W=0.205u L=0.04u
M22519 U2587/net43 n1285 VDD VDD pmos W=0.205u L=0.04u
M22520 WX3931 n1968 VDD VDD pmos W=0.205u L=0.04u
M22521 U2588/net29 n1352 VSS VSS nmos W=0.155u L=0.04u
M22522 n1968 WX4366 U2588/net29 VSS nmos W=0.155u L=0.04u
M22523 n1968 n1319 U2588/net23 VSS nmos W=0.155u L=0.04u
M22524 U2588/net23 CRC_OUT_6_30 VSS VSS nmos W=0.155u L=0.04u
M22525 U2588/net20 CRC_OUT_6_30 n1968 VDD pmos W=0.205u L=0.04u
M22526 U2588/net20 n1319 n1968 VDD pmos W=0.205u L=0.04u
M22527 VDD WX4366 U2588/net20 VDD pmos W=0.205u L=0.04u
M22528 VDD n1352 U2588/net20 VDD pmos W=0.205u L=0.04u
M22529 n1836 n1969 VSS VSS nmos W=0.135u L=0.04u
M22530 n1836 n1969 VDD VDD pmos W=0.205u L=0.04u
M22531 U2590/net28 U2590/net20 U2590/net64 VSS nmos W=0.155u L=0.04u
M22532 U2590/net24 U2590/net30 U2590/net32 VSS nmos W=0.155u L=0.04u
M22533 U2590/net28 U2590/net40 U2590/net24 VSS nmos W=0.155u L=0.04u
M22534 U2590/net40 n1970 U2590/net108 VSS nmos W=0.155u L=0.04u
M22535 U2590/net40 U2590/net106 U2590/net104 VSS nmos W=0.155u L=0.04u
M22536 U2590/net24 WX5947 U2590/net050 VSS nmos W=0.155u L=0.04u
M22537 U2590/net050 U2590/net32 VSS VSS nmos W=0.155u L=0.04u
M22538 U2590/net20 U2590/net40 VSS VSS nmos W=0.155u L=0.04u
M22539 U2590/net106 n1970 VSS VSS nmos W=0.155u L=0.04u
M22540 U2590/net104 WX6011 VSS VSS nmos W=0.155u L=0.04u
M22541 U2590/net30 WX5947 VSS VSS nmos W=0.155u L=0.04u
M22542 U2590/net108 U2590/net104 VSS VSS nmos W=0.155u L=0.04u
M22543 n1969 U2590/net28 VSS VSS nmos W=0.155u L=0.04u
M22544 U2590/net32 WX5883 VSS VSS nmos W=0.155u L=0.04u
M22545 U2590/net64 U2590/net24 VSS VSS nmos W=0.2u L=0.04u
M22546 U2590/net28 U2590/net40 U2590/net64 VDD pmos W=0.205u L=0.04u
M22547 U2590/net24 WX5947 U2590/net32 VDD pmos W=0.205u L=0.04u
M22548 U2590/net28 U2590/net20 U2590/net24 VDD pmos W=0.205u L=0.04u
M22549 U2590/net40 U2590/net106 U2590/net108 VDD pmos W=0.205u L=0.04u
M22550 U2590/net40 n1970 U2590/net104 VDD pmos W=0.205u L=0.04u
M22551 U2590/net20 U2590/net40 VDD VDD pmos W=0.205u L=0.04u
M22552 U2590/net106 n1970 VDD VDD pmos W=0.205u L=0.04u
M22553 U2590/net104 WX6011 VDD VDD pmos W=0.205u L=0.04u
M22554 U2590/net30 WX5947 VDD VDD pmos W=0.205u L=0.04u
M22555 U2590/net108 U2590/net104 VDD VDD pmos W=0.205u L=0.04u
M22556 n1969 U2590/net28 VDD VDD pmos W=0.205u L=0.04u
M22557 U2590/net32 WX5883 VDD VDD pmos W=0.205u L=0.04u
M22558 U2590/net64 U2590/net24 VDD VDD pmos W=0.28u L=0.04u
M22559 U2590/net24 U2590/net30 U2590/net045 VDD pmos W=0.205u L=0.04u
M22560 U2590/net045 U2590/net32 VDD VDD pmos W=0.205u L=0.04u
M22561 U2591/net4 WX5819 U2591/net14 VSS nmos W=0.155u L=0.04u
M22562 U2591/net6 U2591/net10 U2591/net14 VSS nmos W=0.17u L=0.04u
M22563 U2591/net4 n1373 VSS VSS nmos W=0.155u L=0.04u
M22564 U2591/net6 U2591/net4 VSS VSS nmos W=0.17u L=0.04u
M22565 n1970 U2591/net14 VSS VSS nmos W=0.155u L=0.04u
M22566 U2591/net10 WX5819 VSS VSS nmos W=0.155u L=0.04u
M22567 U2591/net4 U2591/net10 U2591/net14 VDD pmos W=0.255u L=0.04u
M22568 U2591/net6 WX5819 U2591/net14 VDD pmos W=0.28u L=0.04u
M22569 U2591/net4 n1373 VDD VDD pmos W=0.205u L=0.04u
M22570 U2591/net6 U2591/net4 VDD VDD pmos W=0.24u L=0.04u
M22571 n1970 U2591/net14 VDD VDD pmos W=0.205u L=0.04u
M22572 U2591/net10 WX5819 VDD VDD pmos W=0.205u L=0.04u
M22573 WX3917 n1615 U2592/net26 VSS nmos W=0.155u L=0.04u
M22574 WX3917 n1392 U2592/net26 VSS nmos W=0.155u L=0.04u
M22575 U2592/net29 n1971 VSS VSS nmos W=0.155u L=0.04u
M22576 U2592/net26 WX4362 U2592/net29 VSS nmos W=0.155u L=0.04u
M22577 U2592/net26 n1500 U2592/net29 VSS nmos W=0.155u L=0.04u
M22578 WX3917 n1392 U2592/net43 VDD pmos W=0.205u L=0.04u
M22579 WX3917 n1500 U2592/net49 VDD pmos W=0.205u L=0.04u
M22580 U2592/net49 WX4362 VDD VDD pmos W=0.205u L=0.04u
M22581 U2592/net43 n1615 VDD VDD pmos W=0.205u L=0.04u
M22582 WX3917 n1971 VDD VDD pmos W=0.205u L=0.04u
M22583 U2593/net29 n1972 VSS VSS nmos W=0.155u L=0.04u
M22584 n1971 n1430 U2593/net29 VSS nmos W=0.155u L=0.04u
M22585 n1971 n1617 U2593/net23 VSS nmos W=0.155u L=0.04u
M22586 U2593/net23 n1841 VSS VSS nmos W=0.155u L=0.04u
M22587 U2593/net20 n1841 n1971 VDD pmos W=0.205u L=0.04u
M22588 U2593/net20 n1617 n1971 VDD pmos W=0.205u L=0.04u
M22589 VDD n1430 U2593/net20 VDD pmos W=0.205u L=0.04u
M22590 VDD n1972 U2593/net20 VDD pmos W=0.205u L=0.04u
M22591 U2594/net28 U2594/net20 U2594/net64 VSS nmos W=0.155u L=0.04u
M22592 U2594/net24 U2594/net30 U2594/net32 VSS nmos W=0.155u L=0.04u
M22593 U2594/net28 U2594/net40 U2594/net24 VSS nmos W=0.155u L=0.04u
M22594 U2594/net40 n1973 U2594/net108 VSS nmos W=0.155u L=0.04u
M22595 U2594/net40 U2594/net106 U2594/net104 VSS nmos W=0.155u L=0.04u
M22596 U2594/net24 WX5945 U2594/net050 VSS nmos W=0.155u L=0.04u
M22597 U2594/net050 U2594/net32 VSS VSS nmos W=0.155u L=0.04u
M22598 U2594/net20 U2594/net40 VSS VSS nmos W=0.155u L=0.04u
M22599 U2594/net106 n1973 VSS VSS nmos W=0.155u L=0.04u
M22600 U2594/net104 WX6009 VSS VSS nmos W=0.155u L=0.04u
M22601 U2594/net30 WX5945 VSS VSS nmos W=0.155u L=0.04u
M22602 U2594/net108 U2594/net104 VSS VSS nmos W=0.155u L=0.04u
M22603 n1841 U2594/net28 VSS VSS nmos W=0.155u L=0.04u
M22604 U2594/net32 WX5881 VSS VSS nmos W=0.155u L=0.04u
M22605 U2594/net64 U2594/net24 VSS VSS nmos W=0.2u L=0.04u
M22606 U2594/net28 U2594/net40 U2594/net64 VDD pmos W=0.205u L=0.04u
M22607 U2594/net24 WX5945 U2594/net32 VDD pmos W=0.205u L=0.04u
M22608 U2594/net28 U2594/net20 U2594/net24 VDD pmos W=0.205u L=0.04u
M22609 U2594/net40 U2594/net106 U2594/net108 VDD pmos W=0.205u L=0.04u
M22610 U2594/net40 n1973 U2594/net104 VDD pmos W=0.205u L=0.04u
M22611 U2594/net20 U2594/net40 VDD VDD pmos W=0.205u L=0.04u
M22612 U2594/net106 n1973 VDD VDD pmos W=0.205u L=0.04u
M22613 U2594/net104 WX6009 VDD VDD pmos W=0.205u L=0.04u
M22614 U2594/net30 WX5945 VDD VDD pmos W=0.205u L=0.04u
M22615 U2594/net108 U2594/net104 VDD VDD pmos W=0.205u L=0.04u
M22616 n1841 U2594/net28 VDD VDD pmos W=0.205u L=0.04u
M22617 U2594/net32 WX5881 VDD VDD pmos W=0.205u L=0.04u
M22618 U2594/net64 U2594/net24 VDD VDD pmos W=0.28u L=0.04u
M22619 U2594/net24 U2594/net30 U2594/net045 VDD pmos W=0.205u L=0.04u
M22620 U2594/net045 U2594/net32 VDD VDD pmos W=0.205u L=0.04u
M22621 U2595/net4 WX5817 U2595/net14 VSS nmos W=0.155u L=0.04u
M22622 U2595/net6 U2595/net10 U2595/net14 VSS nmos W=0.17u L=0.04u
M22623 U2595/net4 n1373 VSS VSS nmos W=0.155u L=0.04u
M22624 U2595/net6 U2595/net4 VSS VSS nmos W=0.17u L=0.04u
M22625 n1973 U2595/net14 VSS VSS nmos W=0.155u L=0.04u
M22626 U2595/net10 WX5817 VSS VSS nmos W=0.155u L=0.04u
M22627 U2595/net4 U2595/net10 U2595/net14 VDD pmos W=0.255u L=0.04u
M22628 U2595/net6 WX5817 U2595/net14 VDD pmos W=0.28u L=0.04u
M22629 U2595/net4 n1373 VDD VDD pmos W=0.205u L=0.04u
M22630 U2595/net6 U2595/net4 VDD VDD pmos W=0.24u L=0.04u
M22631 n1973 U2595/net14 VDD VDD pmos W=0.205u L=0.04u
M22632 U2595/net10 WX5817 VDD VDD pmos W=0.205u L=0.04u
M22633 WX4362 WX4364 VSS VSS nmos W=0.135u L=0.04u
M22634 WX4362 WX4364 VDD VDD pmos W=0.205u L=0.04u
M22635 n1392 CRC_OUT_6_31 VSS VSS nmos W=0.135u L=0.04u
M22636 n1392 CRC_OUT_6_31 VDD VDD pmos W=0.205u L=0.04u
M22637 WX388 n1285 U2598/net26 VSS nmos W=0.155u L=0.04u
M22638 WX388 n1974 U2598/net26 VSS nmos W=0.155u L=0.04u
M22639 U2598/net29 n1976 VSS VSS nmos W=0.155u L=0.04u
M22640 U2598/net26 n1975 U2598/net29 VSS nmos W=0.155u L=0.04u
M22641 U2598/net26 n1257 U2598/net29 VSS nmos W=0.155u L=0.04u
M22642 WX388 n1974 U2598/net43 VDD pmos W=0.205u L=0.04u
M22643 WX388 n1257 U2598/net49 VDD pmos W=0.205u L=0.04u
M22644 U2598/net49 n1975 VDD VDD pmos W=0.205u L=0.04u
M22645 U2598/net43 n1285 VDD VDD pmos W=0.205u L=0.04u
M22646 WX388 n1976 VDD VDD pmos W=0.205u L=0.04u
M22647 U2599/net29 n1352 VSS VSS nmos W=0.155u L=0.04u
M22648 n1976 WX535 U2599/net29 VSS nmos W=0.155u L=0.04u
M22649 n1976 n1319 U2599/net23 VSS nmos W=0.155u L=0.04u
M22650 U2599/net23 CRC_OUT_9_6 VSS VSS nmos W=0.155u L=0.04u
M22651 U2599/net20 CRC_OUT_9_6 n1976 VDD pmos W=0.205u L=0.04u
M22652 U2599/net20 n1319 n1976 VDD pmos W=0.205u L=0.04u
M22653 VDD WX535 U2599/net20 VDD pmos W=0.205u L=0.04u
M22654 VDD n1352 U2599/net20 VDD pmos W=0.205u L=0.04u
M22655 WX38 n1500 U2600/net26 VSS nmos W=0.155u L=0.04u
M22656 WX38 WX483 U2600/net26 VSS nmos W=0.155u L=0.04u
M22657 U2600/net29 n1978 VSS VSS nmos W=0.155u L=0.04u
M22658 U2600/net26 n1977 U2600/net29 VSS nmos W=0.155u L=0.04u
M22659 U2600/net26 n1257 U2600/net29 VSS nmos W=0.155u L=0.04u
M22660 WX38 WX483 U2600/net43 VDD pmos W=0.205u L=0.04u
M22661 WX38 n1257 U2600/net49 VDD pmos W=0.205u L=0.04u
M22662 U2600/net49 n1977 VDD VDD pmos W=0.205u L=0.04u
M22663 U2600/net43 n1500 VDD VDD pmos W=0.205u L=0.04u
M22664 WX38 n1978 VDD VDD pmos W=0.205u L=0.04u
M22665 U2601/net29 CRC_OUT_9_31 VSS VSS nmos W=0.155u L=0.04u
M22666 n1978 n1303 U2601/net29 VSS nmos W=0.155u L=0.04u
M22667 n1978 n1617 U2601/net23 VSS nmos W=0.155u L=0.04u
M22668 U2601/net23 n1979 VSS VSS nmos W=0.155u L=0.04u
M22669 U2601/net20 n1979 n1978 VDD pmos W=0.205u L=0.04u
M22670 U2601/net20 n1617 n1978 VDD pmos W=0.205u L=0.04u
M22671 VDD n1303 U2601/net20 VDD pmos W=0.205u L=0.04u
M22672 VDD CRC_OUT_9_31 U2601/net20 VDD pmos W=0.205u L=0.04u
M22673 WX483 WX485 VSS VSS nmos W=0.135u L=0.04u
M22674 WX483 WX485 VDD VDD pmos W=0.205u L=0.04u
M22675 WX374 n1285 U2603/net26 VSS nmos W=0.155u L=0.04u
M22676 WX374 n1980 U2603/net26 VSS nmos W=0.155u L=0.04u
M22677 U2603/net29 n1982 VSS VSS nmos W=0.155u L=0.04u
M22678 U2603/net26 n1981 U2603/net29 VSS nmos W=0.155u L=0.04u
M22679 U2603/net26 n1257 U2603/net29 VSS nmos W=0.155u L=0.04u
M22680 WX374 n1980 U2603/net43 VDD pmos W=0.205u L=0.04u
M22681 WX374 n1257 U2603/net49 VDD pmos W=0.205u L=0.04u
M22682 U2603/net49 n1981 VDD VDD pmos W=0.205u L=0.04u
M22683 U2603/net43 n1285 VDD VDD pmos W=0.205u L=0.04u
M22684 WX374 n1982 VDD VDD pmos W=0.205u L=0.04u
M22685 U2604/net29 n1352 VSS VSS nmos W=0.155u L=0.04u
M22686 n1982 WX533 U2604/net29 VSS nmos W=0.155u L=0.04u
M22687 n1982 n1319 U2604/net23 VSS nmos W=0.155u L=0.04u
M22688 U2604/net23 CRC_OUT_9_7 VSS VSS nmos W=0.155u L=0.04u
M22689 U2604/net20 CRC_OUT_9_7 n1982 VDD pmos W=0.205u L=0.04u
M22690 U2604/net20 n1319 n1982 VDD pmos W=0.205u L=0.04u
M22691 VDD WX533 U2604/net20 VDD pmos W=0.205u L=0.04u
M22692 VDD n1352 U2604/net20 VDD pmos W=0.205u L=0.04u
M22693 WX360 n1285 U2605/net26 VSS nmos W=0.155u L=0.04u
M22694 WX360 n1983 U2605/net26 VSS nmos W=0.155u L=0.04u
M22695 U2605/net29 n1985 VSS VSS nmos W=0.155u L=0.04u
M22696 U2605/net26 n1984 U2605/net29 VSS nmos W=0.155u L=0.04u
M22697 U2605/net26 n1256 U2605/net29 VSS nmos W=0.155u L=0.04u
M22698 WX360 n1983 U2605/net43 VDD pmos W=0.205u L=0.04u
M22699 WX360 n1256 U2605/net49 VDD pmos W=0.205u L=0.04u
M22700 U2605/net49 n1984 VDD VDD pmos W=0.205u L=0.04u
M22701 U2605/net43 n1285 VDD VDD pmos W=0.205u L=0.04u
M22702 WX360 n1985 VDD VDD pmos W=0.205u L=0.04u
M22703 U2606/net29 n1352 VSS VSS nmos W=0.155u L=0.04u
M22704 n1985 WX531 U2606/net29 VSS nmos W=0.155u L=0.04u
M22705 n1985 n1318 U2606/net23 VSS nmos W=0.155u L=0.04u
M22706 U2606/net23 CRC_OUT_9_8 VSS VSS nmos W=0.155u L=0.04u
M22707 U2606/net20 CRC_OUT_9_8 n1985 VDD pmos W=0.205u L=0.04u
M22708 U2606/net20 n1318 n1985 VDD pmos W=0.205u L=0.04u
M22709 VDD WX531 U2606/net20 VDD pmos W=0.205u L=0.04u
M22710 VDD n1352 U2606/net20 VDD pmos W=0.205u L=0.04u
M22711 WX346 n1285 U2607/net26 VSS nmos W=0.155u L=0.04u
M22712 WX346 n1986 U2607/net26 VSS nmos W=0.155u L=0.04u
M22713 U2607/net29 n1988 VSS VSS nmos W=0.155u L=0.04u
M22714 U2607/net26 n1987 U2607/net29 VSS nmos W=0.155u L=0.04u
M22715 U2607/net26 n1256 U2607/net29 VSS nmos W=0.155u L=0.04u
M22716 WX346 n1986 U2607/net43 VDD pmos W=0.205u L=0.04u
M22717 WX346 n1256 U2607/net49 VDD pmos W=0.205u L=0.04u
M22718 U2607/net49 n1987 VDD VDD pmos W=0.205u L=0.04u
M22719 U2607/net43 n1285 VDD VDD pmos W=0.205u L=0.04u
M22720 WX346 n1988 VDD VDD pmos W=0.205u L=0.04u
M22721 U2608/net29 n1352 VSS VSS nmos W=0.155u L=0.04u
M22722 n1988 WX529 U2608/net29 VSS nmos W=0.155u L=0.04u
M22723 n1988 n1318 U2608/net23 VSS nmos W=0.155u L=0.04u
M22724 U2608/net23 CRC_OUT_9_9 VSS VSS nmos W=0.155u L=0.04u
M22725 U2608/net20 CRC_OUT_9_9 n1988 VDD pmos W=0.205u L=0.04u
M22726 U2608/net20 n1318 n1988 VDD pmos W=0.205u L=0.04u
M22727 VDD WX529 U2608/net20 VDD pmos W=0.205u L=0.04u
M22728 VDD n1352 U2608/net20 VDD pmos W=0.205u L=0.04u
M22729 WX332 n1285 U2609/net26 VSS nmos W=0.155u L=0.04u
M22730 WX332 n1989 U2609/net26 VSS nmos W=0.155u L=0.04u
M22731 U2609/net29 n1991 VSS VSS nmos W=0.155u L=0.04u
M22732 U2609/net26 n1990 U2609/net29 VSS nmos W=0.155u L=0.04u
M22733 U2609/net26 n1256 U2609/net29 VSS nmos W=0.155u L=0.04u
M22734 WX332 n1989 U2609/net43 VDD pmos W=0.205u L=0.04u
M22735 WX332 n1256 U2609/net49 VDD pmos W=0.205u L=0.04u
M22736 U2609/net49 n1990 VDD VDD pmos W=0.205u L=0.04u
M22737 U2609/net43 n1285 VDD VDD pmos W=0.205u L=0.04u
M22738 WX332 n1991 VDD VDD pmos W=0.205u L=0.04u
M22739 U2610/net29 n1351 VSS VSS nmos W=0.155u L=0.04u
M22740 n1991 WX527 U2610/net29 VSS nmos W=0.155u L=0.04u
M22741 n1991 n1318 U2610/net23 VSS nmos W=0.155u L=0.04u
M22742 U2610/net23 CRC_OUT_9_10 VSS VSS nmos W=0.155u L=0.04u
M22743 U2610/net20 CRC_OUT_9_10 n1991 VDD pmos W=0.205u L=0.04u
M22744 U2610/net20 n1318 n1991 VDD pmos W=0.205u L=0.04u
M22745 VDD WX527 U2610/net20 VDD pmos W=0.205u L=0.04u
M22746 VDD n1351 U2610/net20 VDD pmos W=0.205u L=0.04u
M22747 WX318 n1285 U2611/net26 VSS nmos W=0.155u L=0.04u
M22748 WX318 n1992 U2611/net26 VSS nmos W=0.155u L=0.04u
M22749 U2611/net29 n1994 VSS VSS nmos W=0.155u L=0.04u
M22750 U2611/net26 n1993 U2611/net29 VSS nmos W=0.155u L=0.04u
M22751 U2611/net26 n1256 U2611/net29 VSS nmos W=0.155u L=0.04u
M22752 WX318 n1992 U2611/net43 VDD pmos W=0.205u L=0.04u
M22753 WX318 n1256 U2611/net49 VDD pmos W=0.205u L=0.04u
M22754 U2611/net49 n1993 VDD VDD pmos W=0.205u L=0.04u
M22755 U2611/net43 n1285 VDD VDD pmos W=0.205u L=0.04u
M22756 WX318 n1994 VDD VDD pmos W=0.205u L=0.04u
M22757 U2612/net29 n1351 VSS VSS nmos W=0.155u L=0.04u
M22758 n1994 WX525 U2612/net29 VSS nmos W=0.155u L=0.04u
M22759 n1994 n1318 U2612/net23 VSS nmos W=0.155u L=0.04u
M22760 U2612/net23 CRC_OUT_9_11 VSS VSS nmos W=0.155u L=0.04u
M22761 U2612/net20 CRC_OUT_9_11 n1994 VDD pmos W=0.205u L=0.04u
M22762 U2612/net20 n1318 n1994 VDD pmos W=0.205u L=0.04u
M22763 VDD WX525 U2612/net20 VDD pmos W=0.205u L=0.04u
M22764 VDD n1351 U2612/net20 VDD pmos W=0.205u L=0.04u
M22765 WX3058 n1284 U2613/net26 VSS nmos W=0.155u L=0.04u
M22766 WX3058 n1855 U2613/net26 VSS nmos W=0.155u L=0.04u
M22767 U2613/net29 n1996 VSS VSS nmos W=0.155u L=0.04u
M22768 U2613/net26 n1995 U2613/net29 VSS nmos W=0.155u L=0.04u
M22769 U2613/net26 n1256 U2613/net29 VSS nmos W=0.155u L=0.04u
M22770 WX3058 n1855 U2613/net43 VDD pmos W=0.205u L=0.04u
M22771 WX3058 n1256 U2613/net49 VDD pmos W=0.205u L=0.04u
M22772 U2613/net49 n1995 VDD VDD pmos W=0.205u L=0.04u
M22773 U2613/net43 n1284 VDD VDD pmos W=0.205u L=0.04u
M22774 WX3058 n1996 VDD VDD pmos W=0.205u L=0.04u
M22775 U2614/net29 n1351 VSS VSS nmos W=0.155u L=0.04u
M22776 n1996 WX3133 U2614/net29 VSS nmos W=0.155u L=0.04u
M22777 n1996 n1318 U2614/net23 VSS nmos W=0.155u L=0.04u
M22778 U2614/net23 CRC_OUT_7_0 VSS VSS nmos W=0.155u L=0.04u
M22779 U2614/net20 CRC_OUT_7_0 n1996 VDD pmos W=0.205u L=0.04u
M22780 U2614/net20 n1318 n1996 VDD pmos W=0.205u L=0.04u
M22781 VDD WX3133 U2614/net20 VDD pmos W=0.205u L=0.04u
M22782 VDD n1351 U2614/net20 VDD pmos W=0.205u L=0.04u
M22783 U2615/net28 U2615/net20 U2615/net64 VSS nmos W=0.155u L=0.04u
M22784 U2615/net24 U2615/net30 U2615/net32 VSS nmos W=0.155u L=0.04u
M22785 U2615/net28 U2615/net40 U2615/net24 VSS nmos W=0.155u L=0.04u
M22786 U2615/net40 WX4714 U2615/net108 VSS nmos W=0.155u L=0.04u
M22787 U2615/net40 U2615/net106 U2615/net104 VSS nmos W=0.155u L=0.04u
M22788 U2615/net24 WX4650 U2615/net050 VSS nmos W=0.155u L=0.04u
M22789 U2615/net050 U2615/net32 VSS VSS nmos W=0.155u L=0.04u
M22790 U2615/net20 U2615/net40 VSS VSS nmos W=0.155u L=0.04u
M22791 U2615/net106 WX4714 VSS VSS nmos W=0.155u L=0.04u
M22792 U2615/net104 n1393 VSS VSS nmos W=0.155u L=0.04u
M22793 U2615/net30 WX4650 VSS VSS nmos W=0.155u L=0.04u
M22794 U2615/net108 U2615/net104 VSS VSS nmos W=0.155u L=0.04u
M22795 n1855 U2615/net28 VSS VSS nmos W=0.155u L=0.04u
M22796 U2615/net32 WX4586 VSS VSS nmos W=0.155u L=0.04u
M22797 U2615/net64 U2615/net24 VSS VSS nmos W=0.2u L=0.04u
M22798 U2615/net28 U2615/net40 U2615/net64 VDD pmos W=0.205u L=0.04u
M22799 U2615/net24 WX4650 U2615/net32 VDD pmos W=0.205u L=0.04u
M22800 U2615/net28 U2615/net20 U2615/net24 VDD pmos W=0.205u L=0.04u
M22801 U2615/net40 U2615/net106 U2615/net108 VDD pmos W=0.205u L=0.04u
M22802 U2615/net40 WX4714 U2615/net104 VDD pmos W=0.205u L=0.04u
M22803 U2615/net20 U2615/net40 VDD VDD pmos W=0.205u L=0.04u
M22804 U2615/net106 WX4714 VDD VDD pmos W=0.205u L=0.04u
M22805 U2615/net104 n1393 VDD VDD pmos W=0.205u L=0.04u
M22806 U2615/net30 WX4650 VDD VDD pmos W=0.205u L=0.04u
M22807 U2615/net108 U2615/net104 VDD VDD pmos W=0.205u L=0.04u
M22808 n1855 U2615/net28 VDD VDD pmos W=0.205u L=0.04u
M22809 U2615/net32 WX4586 VDD VDD pmos W=0.205u L=0.04u
M22810 U2615/net64 U2615/net24 VDD VDD pmos W=0.28u L=0.04u
M22811 U2615/net24 U2615/net30 U2615/net045 VDD pmos W=0.205u L=0.04u
M22812 U2615/net045 U2615/net32 VDD VDD pmos W=0.205u L=0.04u
M22813 n1393 WX4778 VSS VSS nmos W=0.135u L=0.04u
M22814 n1393 WX4778 VDD VDD pmos W=0.205u L=0.04u
M22815 WX3044 n1284 U2617/net26 VSS nmos W=0.155u L=0.04u
M22816 WX3044 n1857 U2617/net26 VSS nmos W=0.155u L=0.04u
M22817 U2617/net29 n1998 VSS VSS nmos W=0.155u L=0.04u
M22818 U2617/net26 n1997 U2617/net29 VSS nmos W=0.155u L=0.04u
M22819 U2617/net26 n1256 U2617/net29 VSS nmos W=0.155u L=0.04u
M22820 WX3044 n1857 U2617/net43 VDD pmos W=0.205u L=0.04u
M22821 WX3044 n1256 U2617/net49 VDD pmos W=0.205u L=0.04u
M22822 U2617/net49 n1997 VDD VDD pmos W=0.205u L=0.04u
M22823 U2617/net43 n1284 VDD VDD pmos W=0.205u L=0.04u
M22824 WX3044 n1998 VDD VDD pmos W=0.205u L=0.04u
M22825 U2618/net29 n1351 VSS VSS nmos W=0.155u L=0.04u
M22826 n1998 WX3131 U2618/net29 VSS nmos W=0.155u L=0.04u
M22827 n1998 n1318 U2618/net23 VSS nmos W=0.155u L=0.04u
M22828 U2618/net23 CRC_OUT_7_1 VSS VSS nmos W=0.155u L=0.04u
M22829 U2618/net20 CRC_OUT_7_1 n1998 VDD pmos W=0.205u L=0.04u
M22830 U2618/net20 n1318 n1998 VDD pmos W=0.205u L=0.04u
M22831 VDD WX3131 U2618/net20 VDD pmos W=0.205u L=0.04u
M22832 VDD n1351 U2618/net20 VDD pmos W=0.205u L=0.04u
M22833 n1857 n1999 VSS VSS nmos W=0.135u L=0.04u
M22834 n1857 n1999 VDD VDD pmos W=0.205u L=0.04u
M22835 U2620/net28 U2620/net20 U2620/net64 VSS nmos W=0.155u L=0.04u
M22836 U2620/net24 U2620/net30 U2620/net32 VSS nmos W=0.155u L=0.04u
M22837 U2620/net28 U2620/net40 U2620/net24 VSS nmos W=0.155u L=0.04u
M22838 U2620/net40 WX4712 U2620/net108 VSS nmos W=0.155u L=0.04u
M22839 U2620/net40 U2620/net106 U2620/net104 VSS nmos W=0.155u L=0.04u
M22840 U2620/net24 WX4648 U2620/net050 VSS nmos W=0.155u L=0.04u
M22841 U2620/net050 U2620/net32 VSS VSS nmos W=0.155u L=0.04u
M22842 U2620/net20 U2620/net40 VSS VSS nmos W=0.155u L=0.04u
M22843 U2620/net106 WX4712 VSS VSS nmos W=0.155u L=0.04u
M22844 U2620/net104 WX4776 VSS VSS nmos W=0.155u L=0.04u
M22845 U2620/net30 WX4648 VSS VSS nmos W=0.155u L=0.04u
M22846 U2620/net108 U2620/net104 VSS VSS nmos W=0.155u L=0.04u
M22847 n1999 U2620/net28 VSS VSS nmos W=0.155u L=0.04u
M22848 U2620/net32 WX4584 VSS VSS nmos W=0.155u L=0.04u
M22849 U2620/net64 U2620/net24 VSS VSS nmos W=0.2u L=0.04u
M22850 U2620/net28 U2620/net40 U2620/net64 VDD pmos W=0.205u L=0.04u
M22851 U2620/net24 WX4648 U2620/net32 VDD pmos W=0.205u L=0.04u
M22852 U2620/net28 U2620/net20 U2620/net24 VDD pmos W=0.205u L=0.04u
M22853 U2620/net40 U2620/net106 U2620/net108 VDD pmos W=0.205u L=0.04u
M22854 U2620/net40 WX4712 U2620/net104 VDD pmos W=0.205u L=0.04u
M22855 U2620/net20 U2620/net40 VDD VDD pmos W=0.205u L=0.04u
M22856 U2620/net106 WX4712 VDD VDD pmos W=0.205u L=0.04u
M22857 U2620/net104 WX4776 VDD VDD pmos W=0.205u L=0.04u
M22858 U2620/net30 WX4648 VDD VDD pmos W=0.205u L=0.04u
M22859 U2620/net108 U2620/net104 VDD VDD pmos W=0.205u L=0.04u
M22860 n1999 U2620/net28 VDD VDD pmos W=0.205u L=0.04u
M22861 U2620/net32 WX4584 VDD VDD pmos W=0.205u L=0.04u
M22862 U2620/net64 U2620/net24 VDD VDD pmos W=0.28u L=0.04u
M22863 U2620/net24 U2620/net30 U2620/net045 VDD pmos W=0.205u L=0.04u
M22864 U2620/net045 U2620/net32 VDD VDD pmos W=0.205u L=0.04u
M22865 WX304 n1284 U2621/net26 VSS nmos W=0.155u L=0.04u
M22866 WX304 n2000 U2621/net26 VSS nmos W=0.155u L=0.04u
M22867 U2621/net29 n2002 VSS VSS nmos W=0.155u L=0.04u
M22868 U2621/net26 n2001 U2621/net29 VSS nmos W=0.155u L=0.04u
M22869 U2621/net26 n1256 U2621/net29 VSS nmos W=0.155u L=0.04u
M22870 WX304 n2000 U2621/net43 VDD pmos W=0.205u L=0.04u
M22871 WX304 n1256 U2621/net49 VDD pmos W=0.205u L=0.04u
M22872 U2621/net49 n2001 VDD VDD pmos W=0.205u L=0.04u
M22873 U2621/net43 n1284 VDD VDD pmos W=0.205u L=0.04u
M22874 WX304 n2002 VDD VDD pmos W=0.205u L=0.04u
M22875 U2622/net29 n1351 VSS VSS nmos W=0.155u L=0.04u
M22876 n2002 WX523 U2622/net29 VSS nmos W=0.155u L=0.04u
M22877 n2002 n1318 U2622/net23 VSS nmos W=0.155u L=0.04u
M22878 U2622/net23 CRC_OUT_9_12 VSS VSS nmos W=0.155u L=0.04u
M22879 U2622/net20 CRC_OUT_9_12 n2002 VDD pmos W=0.205u L=0.04u
M22880 U2622/net20 n1318 n2002 VDD pmos W=0.205u L=0.04u
M22881 VDD WX523 U2622/net20 VDD pmos W=0.205u L=0.04u
M22882 VDD n1351 U2622/net20 VDD pmos W=0.205u L=0.04u
M22883 WX3030 n1284 U2623/net26 VSS nmos W=0.155u L=0.04u
M22884 WX3030 n1860 U2623/net26 VSS nmos W=0.155u L=0.04u
M22885 U2623/net29 n2004 VSS VSS nmos W=0.155u L=0.04u
M22886 U2623/net26 n2003 U2623/net29 VSS nmos W=0.155u L=0.04u
M22887 U2623/net26 n1256 U2623/net29 VSS nmos W=0.155u L=0.04u
M22888 WX3030 n1860 U2623/net43 VDD pmos W=0.205u L=0.04u
M22889 WX3030 n1256 U2623/net49 VDD pmos W=0.205u L=0.04u
M22890 U2623/net49 n2003 VDD VDD pmos W=0.205u L=0.04u
M22891 U2623/net43 n1284 VDD VDD pmos W=0.205u L=0.04u
M22892 WX3030 n2004 VDD VDD pmos W=0.205u L=0.04u
M22893 U2624/net29 n1351 VSS VSS nmos W=0.155u L=0.04u
M22894 n2004 WX3129 U2624/net29 VSS nmos W=0.155u L=0.04u
M22895 n2004 n1318 U2624/net23 VSS nmos W=0.155u L=0.04u
M22896 U2624/net23 CRC_OUT_7_2 VSS VSS nmos W=0.155u L=0.04u
M22897 U2624/net20 CRC_OUT_7_2 n2004 VDD pmos W=0.205u L=0.04u
M22898 U2624/net20 n1318 n2004 VDD pmos W=0.205u L=0.04u
M22899 VDD WX3129 U2624/net20 VDD pmos W=0.205u L=0.04u
M22900 VDD n1351 U2624/net20 VDD pmos W=0.205u L=0.04u
M22901 n1860 n2005 VSS VSS nmos W=0.135u L=0.04u
M22902 n1860 n2005 VDD VDD pmos W=0.205u L=0.04u
M22903 U2626/net28 U2626/net20 U2626/net64 VSS nmos W=0.155u L=0.04u
M22904 U2626/net24 U2626/net30 U2626/net32 VSS nmos W=0.155u L=0.04u
M22905 U2626/net28 U2626/net40 U2626/net24 VSS nmos W=0.155u L=0.04u
M22906 U2626/net40 WX4710 U2626/net108 VSS nmos W=0.155u L=0.04u
M22907 U2626/net40 U2626/net106 U2626/net104 VSS nmos W=0.155u L=0.04u
M22908 U2626/net24 WX4646 U2626/net050 VSS nmos W=0.155u L=0.04u
M22909 U2626/net050 U2626/net32 VSS VSS nmos W=0.155u L=0.04u
M22910 U2626/net20 U2626/net40 VSS VSS nmos W=0.155u L=0.04u
M22911 U2626/net106 WX4710 VSS VSS nmos W=0.155u L=0.04u
M22912 U2626/net104 WX4774 VSS VSS nmos W=0.155u L=0.04u
M22913 U2626/net30 WX4646 VSS VSS nmos W=0.155u L=0.04u
M22914 U2626/net108 U2626/net104 VSS VSS nmos W=0.155u L=0.04u
M22915 n2005 U2626/net28 VSS VSS nmos W=0.155u L=0.04u
M22916 U2626/net32 WX4582 VSS VSS nmos W=0.155u L=0.04u
M22917 U2626/net64 U2626/net24 VSS VSS nmos W=0.2u L=0.04u
M22918 U2626/net28 U2626/net40 U2626/net64 VDD pmos W=0.205u L=0.04u
M22919 U2626/net24 WX4646 U2626/net32 VDD pmos W=0.205u L=0.04u
M22920 U2626/net28 U2626/net20 U2626/net24 VDD pmos W=0.205u L=0.04u
M22921 U2626/net40 U2626/net106 U2626/net108 VDD pmos W=0.205u L=0.04u
M22922 U2626/net40 WX4710 U2626/net104 VDD pmos W=0.205u L=0.04u
M22923 U2626/net20 U2626/net40 VDD VDD pmos W=0.205u L=0.04u
M22924 U2626/net106 WX4710 VDD VDD pmos W=0.205u L=0.04u
M22925 U2626/net104 WX4774 VDD VDD pmos W=0.205u L=0.04u
M22926 U2626/net30 WX4646 VDD VDD pmos W=0.205u L=0.04u
M22927 U2626/net108 U2626/net104 VDD VDD pmos W=0.205u L=0.04u
M22928 n2005 U2626/net28 VDD VDD pmos W=0.205u L=0.04u
M22929 U2626/net32 WX4582 VDD VDD pmos W=0.205u L=0.04u
M22930 U2626/net64 U2626/net24 VDD VDD pmos W=0.28u L=0.04u
M22931 U2626/net24 U2626/net30 U2626/net045 VDD pmos W=0.205u L=0.04u
M22932 U2626/net045 U2626/net32 VDD VDD pmos W=0.205u L=0.04u
M22933 WX3016 n1284 U2627/net26 VSS nmos W=0.155u L=0.04u
M22934 WX3016 n1863 U2627/net26 VSS nmos W=0.155u L=0.04u
M22935 U2627/net29 n2007 VSS VSS nmos W=0.155u L=0.04u
M22936 U2627/net26 n2006 U2627/net29 VSS nmos W=0.155u L=0.04u
M22937 U2627/net26 n1256 U2627/net29 VSS nmos W=0.155u L=0.04u
M22938 WX3016 n1863 U2627/net43 VDD pmos W=0.205u L=0.04u
M22939 WX3016 n1256 U2627/net49 VDD pmos W=0.205u L=0.04u
M22940 U2627/net49 n2006 VDD VDD pmos W=0.205u L=0.04u
M22941 U2627/net43 n1284 VDD VDD pmos W=0.205u L=0.04u
M22942 WX3016 n2007 VDD VDD pmos W=0.205u L=0.04u
M22943 U2628/net29 n1351 VSS VSS nmos W=0.155u L=0.04u
M22944 n2007 WX3127 U2628/net29 VSS nmos W=0.155u L=0.04u
M22945 n2007 n1318 U2628/net23 VSS nmos W=0.155u L=0.04u
M22946 U2628/net23 CRC_OUT_7_3 VSS VSS nmos W=0.155u L=0.04u
M22947 U2628/net20 CRC_OUT_7_3 n2007 VDD pmos W=0.205u L=0.04u
M22948 U2628/net20 n1318 n2007 VDD pmos W=0.205u L=0.04u
M22949 VDD WX3127 U2628/net20 VDD pmos W=0.205u L=0.04u
M22950 VDD n1351 U2628/net20 VDD pmos W=0.205u L=0.04u
M22951 n1863 n2008 VSS VSS nmos W=0.135u L=0.04u
M22952 n1863 n2008 VDD VDD pmos W=0.205u L=0.04u
M22953 U2630/net28 U2630/net20 U2630/net64 VSS nmos W=0.155u L=0.04u
M22954 U2630/net24 U2630/net30 U2630/net32 VSS nmos W=0.155u L=0.04u
M22955 U2630/net28 U2630/net40 U2630/net24 VSS nmos W=0.155u L=0.04u
M22956 U2630/net40 WX4708 U2630/net108 VSS nmos W=0.155u L=0.04u
M22957 U2630/net40 U2630/net106 U2630/net104 VSS nmos W=0.155u L=0.04u
M22958 U2630/net24 WX4644 U2630/net050 VSS nmos W=0.155u L=0.04u
M22959 U2630/net050 U2630/net32 VSS VSS nmos W=0.155u L=0.04u
M22960 U2630/net20 U2630/net40 VSS VSS nmos W=0.155u L=0.04u
M22961 U2630/net106 WX4708 VSS VSS nmos W=0.155u L=0.04u
M22962 U2630/net104 WX4772 VSS VSS nmos W=0.155u L=0.04u
M22963 U2630/net30 WX4644 VSS VSS nmos W=0.155u L=0.04u
M22964 U2630/net108 U2630/net104 VSS VSS nmos W=0.155u L=0.04u
M22965 n2008 U2630/net28 VSS VSS nmos W=0.155u L=0.04u
M22966 U2630/net32 WX4580 VSS VSS nmos W=0.155u L=0.04u
M22967 U2630/net64 U2630/net24 VSS VSS nmos W=0.2u L=0.04u
M22968 U2630/net28 U2630/net40 U2630/net64 VDD pmos W=0.205u L=0.04u
M22969 U2630/net24 WX4644 U2630/net32 VDD pmos W=0.205u L=0.04u
M22970 U2630/net28 U2630/net20 U2630/net24 VDD pmos W=0.205u L=0.04u
M22971 U2630/net40 U2630/net106 U2630/net108 VDD pmos W=0.205u L=0.04u
M22972 U2630/net40 WX4708 U2630/net104 VDD pmos W=0.205u L=0.04u
M22973 U2630/net20 U2630/net40 VDD VDD pmos W=0.205u L=0.04u
M22974 U2630/net106 WX4708 VDD VDD pmos W=0.205u L=0.04u
M22975 U2630/net104 WX4772 VDD VDD pmos W=0.205u L=0.04u
M22976 U2630/net30 WX4644 VDD VDD pmos W=0.205u L=0.04u
M22977 U2630/net108 U2630/net104 VDD VDD pmos W=0.205u L=0.04u
M22978 n2008 U2630/net28 VDD VDD pmos W=0.205u L=0.04u
M22979 U2630/net32 WX4580 VDD VDD pmos W=0.205u L=0.04u
M22980 U2630/net64 U2630/net24 VDD VDD pmos W=0.28u L=0.04u
M22981 U2630/net24 U2630/net30 U2630/net045 VDD pmos W=0.205u L=0.04u
M22982 U2630/net045 U2630/net32 VDD VDD pmos W=0.205u L=0.04u
M22983 WX3002 n1284 U2631/net26 VSS nmos W=0.155u L=0.04u
M22984 WX3002 n1869 U2631/net26 VSS nmos W=0.155u L=0.04u
M22985 U2631/net29 n2010 VSS VSS nmos W=0.155u L=0.04u
M22986 U2631/net26 n2009 U2631/net29 VSS nmos W=0.155u L=0.04u
M22987 U2631/net26 n1256 U2631/net29 VSS nmos W=0.155u L=0.04u
M22988 WX3002 n1869 U2631/net43 VDD pmos W=0.205u L=0.04u
M22989 WX3002 n1256 U2631/net49 VDD pmos W=0.205u L=0.04u
M22990 U2631/net49 n2009 VDD VDD pmos W=0.205u L=0.04u
M22991 U2631/net43 n1284 VDD VDD pmos W=0.205u L=0.04u
M22992 WX3002 n2010 VDD VDD pmos W=0.205u L=0.04u
M22993 U2632/net29 n1351 VSS VSS nmos W=0.155u L=0.04u
M22994 n2010 WX3125 U2632/net29 VSS nmos W=0.155u L=0.04u
M22995 n2010 n1318 U2632/net23 VSS nmos W=0.155u L=0.04u
M22996 U2632/net23 CRC_OUT_7_4 VSS VSS nmos W=0.155u L=0.04u
M22997 U2632/net20 CRC_OUT_7_4 n2010 VDD pmos W=0.205u L=0.04u
M22998 U2632/net20 n1318 n2010 VDD pmos W=0.205u L=0.04u
M22999 VDD WX3125 U2632/net20 VDD pmos W=0.205u L=0.04u
M23000 VDD n1351 U2632/net20 VDD pmos W=0.205u L=0.04u
M23001 n1869 n2011 VSS VSS nmos W=0.135u L=0.04u
M23002 n1869 n2011 VDD VDD pmos W=0.205u L=0.04u
M23003 U2634/net28 U2634/net20 U2634/net64 VSS nmos W=0.155u L=0.04u
M23004 U2634/net24 U2634/net30 U2634/net32 VSS nmos W=0.155u L=0.04u
M23005 U2634/net28 U2634/net40 U2634/net24 VSS nmos W=0.155u L=0.04u
M23006 U2634/net40 WX4706 U2634/net108 VSS nmos W=0.155u L=0.04u
M23007 U2634/net40 U2634/net106 U2634/net104 VSS nmos W=0.155u L=0.04u
M23008 U2634/net24 WX4642 U2634/net050 VSS nmos W=0.155u L=0.04u
M23009 U2634/net050 U2634/net32 VSS VSS nmos W=0.155u L=0.04u
M23010 U2634/net20 U2634/net40 VSS VSS nmos W=0.155u L=0.04u
M23011 U2634/net106 WX4706 VSS VSS nmos W=0.155u L=0.04u
M23012 U2634/net104 WX4770 VSS VSS nmos W=0.155u L=0.04u
M23013 U2634/net30 WX4642 VSS VSS nmos W=0.155u L=0.04u
M23014 U2634/net108 U2634/net104 VSS VSS nmos W=0.155u L=0.04u
M23015 n2011 U2634/net28 VSS VSS nmos W=0.155u L=0.04u
M23016 U2634/net32 WX4578 VSS VSS nmos W=0.155u L=0.04u
M23017 U2634/net64 U2634/net24 VSS VSS nmos W=0.2u L=0.04u
M23018 U2634/net28 U2634/net40 U2634/net64 VDD pmos W=0.205u L=0.04u
M23019 U2634/net24 WX4642 U2634/net32 VDD pmos W=0.205u L=0.04u
M23020 U2634/net28 U2634/net20 U2634/net24 VDD pmos W=0.205u L=0.04u
M23021 U2634/net40 U2634/net106 U2634/net108 VDD pmos W=0.205u L=0.04u
M23022 U2634/net40 WX4706 U2634/net104 VDD pmos W=0.205u L=0.04u
M23023 U2634/net20 U2634/net40 VDD VDD pmos W=0.205u L=0.04u
M23024 U2634/net106 WX4706 VDD VDD pmos W=0.205u L=0.04u
M23025 U2634/net104 WX4770 VDD VDD pmos W=0.205u L=0.04u
M23026 U2634/net30 WX4642 VDD VDD pmos W=0.205u L=0.04u
M23027 U2634/net108 U2634/net104 VDD VDD pmos W=0.205u L=0.04u
M23028 n2011 U2634/net28 VDD VDD pmos W=0.205u L=0.04u
M23029 U2634/net32 WX4578 VDD VDD pmos W=0.205u L=0.04u
M23030 U2634/net64 U2634/net24 VDD VDD pmos W=0.28u L=0.04u
M23031 U2634/net24 U2634/net30 U2634/net045 VDD pmos W=0.205u L=0.04u
M23032 U2634/net045 U2634/net32 VDD VDD pmos W=0.205u L=0.04u
M23033 WX2988 n1284 U2635/net26 VSS nmos W=0.155u L=0.04u
M23034 WX2988 n1872 U2635/net26 VSS nmos W=0.155u L=0.04u
M23035 U2635/net29 n2013 VSS VSS nmos W=0.155u L=0.04u
M23036 U2635/net26 n2012 U2635/net29 VSS nmos W=0.155u L=0.04u
M23037 U2635/net26 n1256 U2635/net29 VSS nmos W=0.155u L=0.04u
M23038 WX2988 n1872 U2635/net43 VDD pmos W=0.205u L=0.04u
M23039 WX2988 n1256 U2635/net49 VDD pmos W=0.205u L=0.04u
M23040 U2635/net49 n2012 VDD VDD pmos W=0.205u L=0.04u
M23041 U2635/net43 n1284 VDD VDD pmos W=0.205u L=0.04u
M23042 WX2988 n2013 VDD VDD pmos W=0.205u L=0.04u
M23043 U2636/net29 n1351 VSS VSS nmos W=0.155u L=0.04u
M23044 n2013 WX3123 U2636/net29 VSS nmos W=0.155u L=0.04u
M23045 n2013 n1318 U2636/net23 VSS nmos W=0.155u L=0.04u
M23046 U2636/net23 CRC_OUT_7_5 VSS VSS nmos W=0.155u L=0.04u
M23047 U2636/net20 CRC_OUT_7_5 n2013 VDD pmos W=0.205u L=0.04u
M23048 U2636/net20 n1318 n2013 VDD pmos W=0.205u L=0.04u
M23049 VDD WX3123 U2636/net20 VDD pmos W=0.205u L=0.04u
M23050 VDD n1351 U2636/net20 VDD pmos W=0.205u L=0.04u
M23051 n1872 n2014 VSS VSS nmos W=0.135u L=0.04u
M23052 n1872 n2014 VDD VDD pmos W=0.205u L=0.04u
M23053 U2638/net28 U2638/net20 U2638/net64 VSS nmos W=0.155u L=0.04u
M23054 U2638/net24 U2638/net30 U2638/net32 VSS nmos W=0.155u L=0.04u
M23055 U2638/net28 U2638/net40 U2638/net24 VSS nmos W=0.155u L=0.04u
M23056 U2638/net40 WX4704 U2638/net108 VSS nmos W=0.155u L=0.04u
M23057 U2638/net40 U2638/net106 U2638/net104 VSS nmos W=0.155u L=0.04u
M23058 U2638/net24 WX4640 U2638/net050 VSS nmos W=0.155u L=0.04u
M23059 U2638/net050 U2638/net32 VSS VSS nmos W=0.155u L=0.04u
M23060 U2638/net20 U2638/net40 VSS VSS nmos W=0.155u L=0.04u
M23061 U2638/net106 WX4704 VSS VSS nmos W=0.155u L=0.04u
M23062 U2638/net104 WX4768 VSS VSS nmos W=0.155u L=0.04u
M23063 U2638/net30 WX4640 VSS VSS nmos W=0.155u L=0.04u
M23064 U2638/net108 U2638/net104 VSS VSS nmos W=0.155u L=0.04u
M23065 n2014 U2638/net28 VSS VSS nmos W=0.155u L=0.04u
M23066 U2638/net32 WX4576 VSS VSS nmos W=0.155u L=0.04u
M23067 U2638/net64 U2638/net24 VSS VSS nmos W=0.2u L=0.04u
M23068 U2638/net28 U2638/net40 U2638/net64 VDD pmos W=0.205u L=0.04u
M23069 U2638/net24 WX4640 U2638/net32 VDD pmos W=0.205u L=0.04u
M23070 U2638/net28 U2638/net20 U2638/net24 VDD pmos W=0.205u L=0.04u
M23071 U2638/net40 U2638/net106 U2638/net108 VDD pmos W=0.205u L=0.04u
M23072 U2638/net40 WX4704 U2638/net104 VDD pmos W=0.205u L=0.04u
M23073 U2638/net20 U2638/net40 VDD VDD pmos W=0.205u L=0.04u
M23074 U2638/net106 WX4704 VDD VDD pmos W=0.205u L=0.04u
M23075 U2638/net104 WX4768 VDD VDD pmos W=0.205u L=0.04u
M23076 U2638/net30 WX4640 VDD VDD pmos W=0.205u L=0.04u
M23077 U2638/net108 U2638/net104 VDD VDD pmos W=0.205u L=0.04u
M23078 n2014 U2638/net28 VDD VDD pmos W=0.205u L=0.04u
M23079 U2638/net32 WX4576 VDD VDD pmos W=0.205u L=0.04u
M23080 U2638/net64 U2638/net24 VDD VDD pmos W=0.28u L=0.04u
M23081 U2638/net24 U2638/net30 U2638/net045 VDD pmos W=0.205u L=0.04u
M23082 U2638/net045 U2638/net32 VDD VDD pmos W=0.205u L=0.04u
M23083 WX2974 n1284 U2639/net26 VSS nmos W=0.155u L=0.04u
M23084 WX2974 n1875 U2639/net26 VSS nmos W=0.155u L=0.04u
M23085 U2639/net29 n2016 VSS VSS nmos W=0.155u L=0.04u
M23086 U2639/net26 n2015 U2639/net29 VSS nmos W=0.155u L=0.04u
M23087 U2639/net26 n1256 U2639/net29 VSS nmos W=0.155u L=0.04u
M23088 WX2974 n1875 U2639/net43 VDD pmos W=0.205u L=0.04u
M23089 WX2974 n1256 U2639/net49 VDD pmos W=0.205u L=0.04u
M23090 U2639/net49 n2015 VDD VDD pmos W=0.205u L=0.04u
M23091 U2639/net43 n1284 VDD VDD pmos W=0.205u L=0.04u
M23092 WX2974 n2016 VDD VDD pmos W=0.205u L=0.04u
M23093 U2640/net29 n1351 VSS VSS nmos W=0.155u L=0.04u
M23094 n2016 WX3121 U2640/net29 VSS nmos W=0.155u L=0.04u
M23095 n2016 n1318 U2640/net23 VSS nmos W=0.155u L=0.04u
M23096 U2640/net23 CRC_OUT_7_6 VSS VSS nmos W=0.155u L=0.04u
M23097 U2640/net20 CRC_OUT_7_6 n2016 VDD pmos W=0.205u L=0.04u
M23098 U2640/net20 n1318 n2016 VDD pmos W=0.205u L=0.04u
M23099 VDD WX3121 U2640/net20 VDD pmos W=0.205u L=0.04u
M23100 VDD n1351 U2640/net20 VDD pmos W=0.205u L=0.04u
M23101 n1875 n2017 VSS VSS nmos W=0.135u L=0.04u
M23102 n1875 n2017 VDD VDD pmos W=0.205u L=0.04u
M23103 U2642/net28 U2642/net20 U2642/net64 VSS nmos W=0.155u L=0.04u
M23104 U2642/net24 U2642/net30 U2642/net32 VSS nmos W=0.155u L=0.04u
M23105 U2642/net28 U2642/net40 U2642/net24 VSS nmos W=0.155u L=0.04u
M23106 U2642/net40 WX4702 U2642/net108 VSS nmos W=0.155u L=0.04u
M23107 U2642/net40 U2642/net106 U2642/net104 VSS nmos W=0.155u L=0.04u
M23108 U2642/net24 WX4638 U2642/net050 VSS nmos W=0.155u L=0.04u
M23109 U2642/net050 U2642/net32 VSS VSS nmos W=0.155u L=0.04u
M23110 U2642/net20 U2642/net40 VSS VSS nmos W=0.155u L=0.04u
M23111 U2642/net106 WX4702 VSS VSS nmos W=0.155u L=0.04u
M23112 U2642/net104 WX4766 VSS VSS nmos W=0.155u L=0.04u
M23113 U2642/net30 WX4638 VSS VSS nmos W=0.155u L=0.04u
M23114 U2642/net108 U2642/net104 VSS VSS nmos W=0.155u L=0.04u
M23115 n2017 U2642/net28 VSS VSS nmos W=0.155u L=0.04u
M23116 U2642/net32 WX4574 VSS VSS nmos W=0.155u L=0.04u
M23117 U2642/net64 U2642/net24 VSS VSS nmos W=0.2u L=0.04u
M23118 U2642/net28 U2642/net40 U2642/net64 VDD pmos W=0.205u L=0.04u
M23119 U2642/net24 WX4638 U2642/net32 VDD pmos W=0.205u L=0.04u
M23120 U2642/net28 U2642/net20 U2642/net24 VDD pmos W=0.205u L=0.04u
M23121 U2642/net40 U2642/net106 U2642/net108 VDD pmos W=0.205u L=0.04u
M23122 U2642/net40 WX4702 U2642/net104 VDD pmos W=0.205u L=0.04u
M23123 U2642/net20 U2642/net40 VDD VDD pmos W=0.205u L=0.04u
M23124 U2642/net106 WX4702 VDD VDD pmos W=0.205u L=0.04u
M23125 U2642/net104 WX4766 VDD VDD pmos W=0.205u L=0.04u
M23126 U2642/net30 WX4638 VDD VDD pmos W=0.205u L=0.04u
M23127 U2642/net108 U2642/net104 VDD VDD pmos W=0.205u L=0.04u
M23128 n2017 U2642/net28 VDD VDD pmos W=0.205u L=0.04u
M23129 U2642/net32 WX4574 VDD VDD pmos W=0.205u L=0.04u
M23130 U2642/net64 U2642/net24 VDD VDD pmos W=0.28u L=0.04u
M23131 U2642/net24 U2642/net30 U2642/net045 VDD pmos W=0.205u L=0.04u
M23132 U2642/net045 U2642/net32 VDD VDD pmos W=0.205u L=0.04u
M23133 WX2960 n1284 U2643/net26 VSS nmos W=0.155u L=0.04u
M23134 WX2960 n1878 U2643/net26 VSS nmos W=0.155u L=0.04u
M23135 U2643/net29 n2019 VSS VSS nmos W=0.155u L=0.04u
M23136 U2643/net26 n2018 U2643/net29 VSS nmos W=0.155u L=0.04u
M23137 U2643/net26 n1256 U2643/net29 VSS nmos W=0.155u L=0.04u
M23138 WX2960 n1878 U2643/net43 VDD pmos W=0.205u L=0.04u
M23139 WX2960 n1256 U2643/net49 VDD pmos W=0.205u L=0.04u
M23140 U2643/net49 n2018 VDD VDD pmos W=0.205u L=0.04u
M23141 U2643/net43 n1284 VDD VDD pmos W=0.205u L=0.04u
M23142 WX2960 n2019 VDD VDD pmos W=0.205u L=0.04u
M23143 U2644/net29 n1351 VSS VSS nmos W=0.155u L=0.04u
M23144 n2019 WX3119 U2644/net29 VSS nmos W=0.155u L=0.04u
M23145 n2019 n1318 U2644/net23 VSS nmos W=0.155u L=0.04u
M23146 U2644/net23 CRC_OUT_7_7 VSS VSS nmos W=0.155u L=0.04u
M23147 U2644/net20 CRC_OUT_7_7 n2019 VDD pmos W=0.205u L=0.04u
M23148 U2644/net20 n1318 n2019 VDD pmos W=0.205u L=0.04u
M23149 VDD WX3119 U2644/net20 VDD pmos W=0.205u L=0.04u
M23150 VDD n1351 U2644/net20 VDD pmos W=0.205u L=0.04u
M23151 n1878 n2020 VSS VSS nmos W=0.135u L=0.04u
M23152 n1878 n2020 VDD VDD pmos W=0.205u L=0.04u
M23153 U2646/net28 U2646/net20 U2646/net64 VSS nmos W=0.155u L=0.04u
M23154 U2646/net24 U2646/net30 U2646/net32 VSS nmos W=0.155u L=0.04u
M23155 U2646/net28 U2646/net40 U2646/net24 VSS nmos W=0.155u L=0.04u
M23156 U2646/net40 WX4700 U2646/net108 VSS nmos W=0.155u L=0.04u
M23157 U2646/net40 U2646/net106 U2646/net104 VSS nmos W=0.155u L=0.04u
M23158 U2646/net24 WX4636 U2646/net050 VSS nmos W=0.155u L=0.04u
M23159 U2646/net050 U2646/net32 VSS VSS nmos W=0.155u L=0.04u
M23160 U2646/net20 U2646/net40 VSS VSS nmos W=0.155u L=0.04u
M23161 U2646/net106 WX4700 VSS VSS nmos W=0.155u L=0.04u
M23162 U2646/net104 WX4764 VSS VSS nmos W=0.155u L=0.04u
M23163 U2646/net30 WX4636 VSS VSS nmos W=0.155u L=0.04u
M23164 U2646/net108 U2646/net104 VSS VSS nmos W=0.155u L=0.04u
M23165 n2020 U2646/net28 VSS VSS nmos W=0.155u L=0.04u
M23166 U2646/net32 WX4572 VSS VSS nmos W=0.155u L=0.04u
M23167 U2646/net64 U2646/net24 VSS VSS nmos W=0.2u L=0.04u
M23168 U2646/net28 U2646/net40 U2646/net64 VDD pmos W=0.205u L=0.04u
M23169 U2646/net24 WX4636 U2646/net32 VDD pmos W=0.205u L=0.04u
M23170 U2646/net28 U2646/net20 U2646/net24 VDD pmos W=0.205u L=0.04u
M23171 U2646/net40 U2646/net106 U2646/net108 VDD pmos W=0.205u L=0.04u
M23172 U2646/net40 WX4700 U2646/net104 VDD pmos W=0.205u L=0.04u
M23173 U2646/net20 U2646/net40 VDD VDD pmos W=0.205u L=0.04u
M23174 U2646/net106 WX4700 VDD VDD pmos W=0.205u L=0.04u
M23175 U2646/net104 WX4764 VDD VDD pmos W=0.205u L=0.04u
M23176 U2646/net30 WX4636 VDD VDD pmos W=0.205u L=0.04u
M23177 U2646/net108 U2646/net104 VDD VDD pmos W=0.205u L=0.04u
M23178 n2020 U2646/net28 VDD VDD pmos W=0.205u L=0.04u
M23179 U2646/net32 WX4572 VDD VDD pmos W=0.205u L=0.04u
M23180 U2646/net64 U2646/net24 VDD VDD pmos W=0.28u L=0.04u
M23181 U2646/net24 U2646/net30 U2646/net045 VDD pmos W=0.205u L=0.04u
M23182 U2646/net045 U2646/net32 VDD VDD pmos W=0.205u L=0.04u
M23183 WX2946 n1284 U2647/net26 VSS nmos W=0.155u L=0.04u
M23184 WX2946 n1881 U2647/net26 VSS nmos W=0.155u L=0.04u
M23185 U2647/net29 n2022 VSS VSS nmos W=0.155u L=0.04u
M23186 U2647/net26 n2021 U2647/net29 VSS nmos W=0.155u L=0.04u
M23187 U2647/net26 n1255 U2647/net29 VSS nmos W=0.155u L=0.04u
M23188 WX2946 n1881 U2647/net43 VDD pmos W=0.205u L=0.04u
M23189 WX2946 n1255 U2647/net49 VDD pmos W=0.205u L=0.04u
M23190 U2647/net49 n2021 VDD VDD pmos W=0.205u L=0.04u
M23191 U2647/net43 n1284 VDD VDD pmos W=0.205u L=0.04u
M23192 WX2946 n2022 VDD VDD pmos W=0.205u L=0.04u
M23193 U2648/net29 n1351 VSS VSS nmos W=0.155u L=0.04u
M23194 n2022 WX3117 U2648/net29 VSS nmos W=0.155u L=0.04u
M23195 n2022 n1317 U2648/net23 VSS nmos W=0.155u L=0.04u
M23196 U2648/net23 CRC_OUT_7_8 VSS VSS nmos W=0.155u L=0.04u
M23197 U2648/net20 CRC_OUT_7_8 n2022 VDD pmos W=0.205u L=0.04u
M23198 U2648/net20 n1317 n2022 VDD pmos W=0.205u L=0.04u
M23199 VDD WX3117 U2648/net20 VDD pmos W=0.205u L=0.04u
M23200 VDD n1351 U2648/net20 VDD pmos W=0.205u L=0.04u
M23201 n1881 n2023 VSS VSS nmos W=0.135u L=0.04u
M23202 n1881 n2023 VDD VDD pmos W=0.205u L=0.04u
M23203 U2650/net28 U2650/net20 U2650/net64 VSS nmos W=0.155u L=0.04u
M23204 U2650/net24 U2650/net30 U2650/net32 VSS nmos W=0.155u L=0.04u
M23205 U2650/net28 U2650/net40 U2650/net24 VSS nmos W=0.155u L=0.04u
M23206 U2650/net40 WX4698 U2650/net108 VSS nmos W=0.155u L=0.04u
M23207 U2650/net40 U2650/net106 U2650/net104 VSS nmos W=0.155u L=0.04u
M23208 U2650/net24 WX4634 U2650/net050 VSS nmos W=0.155u L=0.04u
M23209 U2650/net050 U2650/net32 VSS VSS nmos W=0.155u L=0.04u
M23210 U2650/net20 U2650/net40 VSS VSS nmos W=0.155u L=0.04u
M23211 U2650/net106 WX4698 VSS VSS nmos W=0.155u L=0.04u
M23212 U2650/net104 WX4762 VSS VSS nmos W=0.155u L=0.04u
M23213 U2650/net30 WX4634 VSS VSS nmos W=0.155u L=0.04u
M23214 U2650/net108 U2650/net104 VSS VSS nmos W=0.155u L=0.04u
M23215 n2023 U2650/net28 VSS VSS nmos W=0.155u L=0.04u
M23216 U2650/net32 WX4570 VSS VSS nmos W=0.155u L=0.04u
M23217 U2650/net64 U2650/net24 VSS VSS nmos W=0.2u L=0.04u
M23218 U2650/net28 U2650/net40 U2650/net64 VDD pmos W=0.205u L=0.04u
M23219 U2650/net24 WX4634 U2650/net32 VDD pmos W=0.205u L=0.04u
M23220 U2650/net28 U2650/net20 U2650/net24 VDD pmos W=0.205u L=0.04u
M23221 U2650/net40 U2650/net106 U2650/net108 VDD pmos W=0.205u L=0.04u
M23222 U2650/net40 WX4698 U2650/net104 VDD pmos W=0.205u L=0.04u
M23223 U2650/net20 U2650/net40 VDD VDD pmos W=0.205u L=0.04u
M23224 U2650/net106 WX4698 VDD VDD pmos W=0.205u L=0.04u
M23225 U2650/net104 WX4762 VDD VDD pmos W=0.205u L=0.04u
M23226 U2650/net30 WX4634 VDD VDD pmos W=0.205u L=0.04u
M23227 U2650/net108 U2650/net104 VDD VDD pmos W=0.205u L=0.04u
M23228 n2023 U2650/net28 VDD VDD pmos W=0.205u L=0.04u
M23229 U2650/net32 WX4570 VDD VDD pmos W=0.205u L=0.04u
M23230 U2650/net64 U2650/net24 VDD VDD pmos W=0.28u L=0.04u
M23231 U2650/net24 U2650/net30 U2650/net045 VDD pmos W=0.205u L=0.04u
M23232 U2650/net045 U2650/net32 VDD VDD pmos W=0.205u L=0.04u
M23233 WX2932 n1284 U2651/net26 VSS nmos W=0.155u L=0.04u
M23234 WX2932 n1884 U2651/net26 VSS nmos W=0.155u L=0.04u
M23235 U2651/net29 n2025 VSS VSS nmos W=0.155u L=0.04u
M23236 U2651/net26 n2024 U2651/net29 VSS nmos W=0.155u L=0.04u
M23237 U2651/net26 n1255 U2651/net29 VSS nmos W=0.155u L=0.04u
M23238 WX2932 n1884 U2651/net43 VDD pmos W=0.205u L=0.04u
M23239 WX2932 n1255 U2651/net49 VDD pmos W=0.205u L=0.04u
M23240 U2651/net49 n2024 VDD VDD pmos W=0.205u L=0.04u
M23241 U2651/net43 n1284 VDD VDD pmos W=0.205u L=0.04u
M23242 WX2932 n2025 VDD VDD pmos W=0.205u L=0.04u
M23243 U2652/net29 n1351 VSS VSS nmos W=0.155u L=0.04u
M23244 n2025 WX3115 U2652/net29 VSS nmos W=0.155u L=0.04u
M23245 n2025 n1317 U2652/net23 VSS nmos W=0.155u L=0.04u
M23246 U2652/net23 CRC_OUT_7_9 VSS VSS nmos W=0.155u L=0.04u
M23247 U2652/net20 CRC_OUT_7_9 n2025 VDD pmos W=0.205u L=0.04u
M23248 U2652/net20 n1317 n2025 VDD pmos W=0.205u L=0.04u
M23249 VDD WX3115 U2652/net20 VDD pmos W=0.205u L=0.04u
M23250 VDD n1351 U2652/net20 VDD pmos W=0.205u L=0.04u
M23251 n1884 n2026 VSS VSS nmos W=0.135u L=0.04u
M23252 n1884 n2026 VDD VDD pmos W=0.205u L=0.04u
M23253 U2654/net28 U2654/net20 U2654/net64 VSS nmos W=0.155u L=0.04u
M23254 U2654/net24 U2654/net30 U2654/net32 VSS nmos W=0.155u L=0.04u
M23255 U2654/net28 U2654/net40 U2654/net24 VSS nmos W=0.155u L=0.04u
M23256 U2654/net40 WX4696 U2654/net108 VSS nmos W=0.155u L=0.04u
M23257 U2654/net40 U2654/net106 U2654/net104 VSS nmos W=0.155u L=0.04u
M23258 U2654/net24 WX4632 U2654/net050 VSS nmos W=0.155u L=0.04u
M23259 U2654/net050 U2654/net32 VSS VSS nmos W=0.155u L=0.04u
M23260 U2654/net20 U2654/net40 VSS VSS nmos W=0.155u L=0.04u
M23261 U2654/net106 WX4696 VSS VSS nmos W=0.155u L=0.04u
M23262 U2654/net104 WX4760 VSS VSS nmos W=0.155u L=0.04u
M23263 U2654/net30 WX4632 VSS VSS nmos W=0.155u L=0.04u
M23264 U2654/net108 U2654/net104 VSS VSS nmos W=0.155u L=0.04u
M23265 n2026 U2654/net28 VSS VSS nmos W=0.155u L=0.04u
M23266 U2654/net32 WX4568 VSS VSS nmos W=0.155u L=0.04u
M23267 U2654/net64 U2654/net24 VSS VSS nmos W=0.2u L=0.04u
M23268 U2654/net28 U2654/net40 U2654/net64 VDD pmos W=0.205u L=0.04u
M23269 U2654/net24 WX4632 U2654/net32 VDD pmos W=0.205u L=0.04u
M23270 U2654/net28 U2654/net20 U2654/net24 VDD pmos W=0.205u L=0.04u
M23271 U2654/net40 U2654/net106 U2654/net108 VDD pmos W=0.205u L=0.04u
M23272 U2654/net40 WX4696 U2654/net104 VDD pmos W=0.205u L=0.04u
M23273 U2654/net20 U2654/net40 VDD VDD pmos W=0.205u L=0.04u
M23274 U2654/net106 WX4696 VDD VDD pmos W=0.205u L=0.04u
M23275 U2654/net104 WX4760 VDD VDD pmos W=0.205u L=0.04u
M23276 U2654/net30 WX4632 VDD VDD pmos W=0.205u L=0.04u
M23277 U2654/net108 U2654/net104 VDD VDD pmos W=0.205u L=0.04u
M23278 n2026 U2654/net28 VDD VDD pmos W=0.205u L=0.04u
M23279 U2654/net32 WX4568 VDD VDD pmos W=0.205u L=0.04u
M23280 U2654/net64 U2654/net24 VDD VDD pmos W=0.28u L=0.04u
M23281 U2654/net24 U2654/net30 U2654/net045 VDD pmos W=0.205u L=0.04u
M23282 U2654/net045 U2654/net32 VDD VDD pmos W=0.205u L=0.04u
M23283 WX2918 n1284 U2655/net26 VSS nmos W=0.155u L=0.04u
M23284 WX2918 n1887 U2655/net26 VSS nmos W=0.155u L=0.04u
M23285 U2655/net29 n2028 VSS VSS nmos W=0.155u L=0.04u
M23286 U2655/net26 n2027 U2655/net29 VSS nmos W=0.155u L=0.04u
M23287 U2655/net26 n1255 U2655/net29 VSS nmos W=0.155u L=0.04u
M23288 WX2918 n1887 U2655/net43 VDD pmos W=0.205u L=0.04u
M23289 WX2918 n1255 U2655/net49 VDD pmos W=0.205u L=0.04u
M23290 U2655/net49 n2027 VDD VDD pmos W=0.205u L=0.04u
M23291 U2655/net43 n1284 VDD VDD pmos W=0.205u L=0.04u
M23292 WX2918 n2028 VDD VDD pmos W=0.205u L=0.04u
M23293 U2656/net29 n1350 VSS VSS nmos W=0.155u L=0.04u
M23294 n2028 WX3113 U2656/net29 VSS nmos W=0.155u L=0.04u
M23295 n2028 n1317 U2656/net23 VSS nmos W=0.155u L=0.04u
M23296 U2656/net23 CRC_OUT_7_10 VSS VSS nmos W=0.155u L=0.04u
M23297 U2656/net20 CRC_OUT_7_10 n2028 VDD pmos W=0.205u L=0.04u
M23298 U2656/net20 n1317 n2028 VDD pmos W=0.205u L=0.04u
M23299 VDD WX3113 U2656/net20 VDD pmos W=0.205u L=0.04u
M23300 VDD n1350 U2656/net20 VDD pmos W=0.205u L=0.04u
M23301 n1887 n2029 VSS VSS nmos W=0.135u L=0.04u
M23302 n1887 n2029 VDD VDD pmos W=0.205u L=0.04u
M23303 U2658/net28 U2658/net20 U2658/net64 VSS nmos W=0.155u L=0.04u
M23304 U2658/net24 U2658/net30 U2658/net32 VSS nmos W=0.155u L=0.04u
M23305 U2658/net28 U2658/net40 U2658/net24 VSS nmos W=0.155u L=0.04u
M23306 U2658/net40 WX4694 U2658/net108 VSS nmos W=0.155u L=0.04u
M23307 U2658/net40 U2658/net106 U2658/net104 VSS nmos W=0.155u L=0.04u
M23308 U2658/net24 WX4630 U2658/net050 VSS nmos W=0.155u L=0.04u
M23309 U2658/net050 U2658/net32 VSS VSS nmos W=0.155u L=0.04u
M23310 U2658/net20 U2658/net40 VSS VSS nmos W=0.155u L=0.04u
M23311 U2658/net106 WX4694 VSS VSS nmos W=0.155u L=0.04u
M23312 U2658/net104 WX4758 VSS VSS nmos W=0.155u L=0.04u
M23313 U2658/net30 WX4630 VSS VSS nmos W=0.155u L=0.04u
M23314 U2658/net108 U2658/net104 VSS VSS nmos W=0.155u L=0.04u
M23315 n2029 U2658/net28 VSS VSS nmos W=0.155u L=0.04u
M23316 U2658/net32 WX4566 VSS VSS nmos W=0.155u L=0.04u
M23317 U2658/net64 U2658/net24 VSS VSS nmos W=0.2u L=0.04u
M23318 U2658/net28 U2658/net40 U2658/net64 VDD pmos W=0.205u L=0.04u
M23319 U2658/net24 WX4630 U2658/net32 VDD pmos W=0.205u L=0.04u
M23320 U2658/net28 U2658/net20 U2658/net24 VDD pmos W=0.205u L=0.04u
M23321 U2658/net40 U2658/net106 U2658/net108 VDD pmos W=0.205u L=0.04u
M23322 U2658/net40 WX4694 U2658/net104 VDD pmos W=0.205u L=0.04u
M23323 U2658/net20 U2658/net40 VDD VDD pmos W=0.205u L=0.04u
M23324 U2658/net106 WX4694 VDD VDD pmos W=0.205u L=0.04u
M23325 U2658/net104 WX4758 VDD VDD pmos W=0.205u L=0.04u
M23326 U2658/net30 WX4630 VDD VDD pmos W=0.205u L=0.04u
M23327 U2658/net108 U2658/net104 VDD VDD pmos W=0.205u L=0.04u
M23328 n2029 U2658/net28 VDD VDD pmos W=0.205u L=0.04u
M23329 U2658/net32 WX4566 VDD VDD pmos W=0.205u L=0.04u
M23330 U2658/net64 U2658/net24 VDD VDD pmos W=0.28u L=0.04u
M23331 U2658/net24 U2658/net30 U2658/net045 VDD pmos W=0.205u L=0.04u
M23332 U2658/net045 U2658/net32 VDD VDD pmos W=0.205u L=0.04u
M23333 WX2904 n1283 U2659/net26 VSS nmos W=0.155u L=0.04u
M23334 WX2904 n1890 U2659/net26 VSS nmos W=0.155u L=0.04u
M23335 U2659/net29 n2031 VSS VSS nmos W=0.155u L=0.04u
M23336 U2659/net26 n2030 U2659/net29 VSS nmos W=0.155u L=0.04u
M23337 U2659/net26 n1255 U2659/net29 VSS nmos W=0.155u L=0.04u
M23338 WX2904 n1890 U2659/net43 VDD pmos W=0.205u L=0.04u
M23339 WX2904 n1255 U2659/net49 VDD pmos W=0.205u L=0.04u
M23340 U2659/net49 n2030 VDD VDD pmos W=0.205u L=0.04u
M23341 U2659/net43 n1283 VDD VDD pmos W=0.205u L=0.04u
M23342 WX2904 n2031 VDD VDD pmos W=0.205u L=0.04u
M23343 U2660/net29 n1350 VSS VSS nmos W=0.155u L=0.04u
M23344 n2031 WX3111 U2660/net29 VSS nmos W=0.155u L=0.04u
M23345 n2031 n1317 U2660/net23 VSS nmos W=0.155u L=0.04u
M23346 U2660/net23 CRC_OUT_7_11 VSS VSS nmos W=0.155u L=0.04u
M23347 U2660/net20 CRC_OUT_7_11 n2031 VDD pmos W=0.205u L=0.04u
M23348 U2660/net20 n1317 n2031 VDD pmos W=0.205u L=0.04u
M23349 VDD WX3111 U2660/net20 VDD pmos W=0.205u L=0.04u
M23350 VDD n1350 U2660/net20 VDD pmos W=0.205u L=0.04u
M23351 n1890 n2032 VSS VSS nmos W=0.135u L=0.04u
M23352 n1890 n2032 VDD VDD pmos W=0.205u L=0.04u
M23353 U2662/net28 U2662/net20 U2662/net64 VSS nmos W=0.155u L=0.04u
M23354 U2662/net24 U2662/net30 U2662/net32 VSS nmos W=0.155u L=0.04u
M23355 U2662/net28 U2662/net40 U2662/net24 VSS nmos W=0.155u L=0.04u
M23356 U2662/net40 WX4692 U2662/net108 VSS nmos W=0.155u L=0.04u
M23357 U2662/net40 U2662/net106 U2662/net104 VSS nmos W=0.155u L=0.04u
M23358 U2662/net24 WX4628 U2662/net050 VSS nmos W=0.155u L=0.04u
M23359 U2662/net050 U2662/net32 VSS VSS nmos W=0.155u L=0.04u
M23360 U2662/net20 U2662/net40 VSS VSS nmos W=0.155u L=0.04u
M23361 U2662/net106 WX4692 VSS VSS nmos W=0.155u L=0.04u
M23362 U2662/net104 WX4756 VSS VSS nmos W=0.155u L=0.04u
M23363 U2662/net30 WX4628 VSS VSS nmos W=0.155u L=0.04u
M23364 U2662/net108 U2662/net104 VSS VSS nmos W=0.155u L=0.04u
M23365 n2032 U2662/net28 VSS VSS nmos W=0.155u L=0.04u
M23366 U2662/net32 WX4564 VSS VSS nmos W=0.155u L=0.04u
M23367 U2662/net64 U2662/net24 VSS VSS nmos W=0.2u L=0.04u
M23368 U2662/net28 U2662/net40 U2662/net64 VDD pmos W=0.205u L=0.04u
M23369 U2662/net24 WX4628 U2662/net32 VDD pmos W=0.205u L=0.04u
M23370 U2662/net28 U2662/net20 U2662/net24 VDD pmos W=0.205u L=0.04u
M23371 U2662/net40 U2662/net106 U2662/net108 VDD pmos W=0.205u L=0.04u
M23372 U2662/net40 WX4692 U2662/net104 VDD pmos W=0.205u L=0.04u
M23373 U2662/net20 U2662/net40 VDD VDD pmos W=0.205u L=0.04u
M23374 U2662/net106 WX4692 VDD VDD pmos W=0.205u L=0.04u
M23375 U2662/net104 WX4756 VDD VDD pmos W=0.205u L=0.04u
M23376 U2662/net30 WX4628 VDD VDD pmos W=0.205u L=0.04u
M23377 U2662/net108 U2662/net104 VDD VDD pmos W=0.205u L=0.04u
M23378 n2032 U2662/net28 VDD VDD pmos W=0.205u L=0.04u
M23379 U2662/net32 WX4564 VDD VDD pmos W=0.205u L=0.04u
M23380 U2662/net64 U2662/net24 VDD VDD pmos W=0.28u L=0.04u
M23381 U2662/net24 U2662/net30 U2662/net045 VDD pmos W=0.205u L=0.04u
M23382 U2662/net045 U2662/net32 VDD VDD pmos W=0.205u L=0.04u
M23383 WX290 n1283 U2663/net26 VSS nmos W=0.155u L=0.04u
M23384 WX290 n2033 U2663/net26 VSS nmos W=0.155u L=0.04u
M23385 U2663/net29 n2035 VSS VSS nmos W=0.155u L=0.04u
M23386 U2663/net26 n2034 U2663/net29 VSS nmos W=0.155u L=0.04u
M23387 U2663/net26 n1255 U2663/net29 VSS nmos W=0.155u L=0.04u
M23388 WX290 n2033 U2663/net43 VDD pmos W=0.205u L=0.04u
M23389 WX290 n1255 U2663/net49 VDD pmos W=0.205u L=0.04u
M23390 U2663/net49 n2034 VDD VDD pmos W=0.205u L=0.04u
M23391 U2663/net43 n1283 VDD VDD pmos W=0.205u L=0.04u
M23392 WX290 n2035 VDD VDD pmos W=0.205u L=0.04u
M23393 U2664/net29 n1350 VSS VSS nmos W=0.155u L=0.04u
M23394 n2035 WX521 U2664/net29 VSS nmos W=0.155u L=0.04u
M23395 n2035 n1317 U2664/net23 VSS nmos W=0.155u L=0.04u
M23396 U2664/net23 CRC_OUT_9_13 VSS VSS nmos W=0.155u L=0.04u
M23397 U2664/net20 CRC_OUT_9_13 n2035 VDD pmos W=0.205u L=0.04u
M23398 U2664/net20 n1317 n2035 VDD pmos W=0.205u L=0.04u
M23399 VDD WX521 U2664/net20 VDD pmos W=0.205u L=0.04u
M23400 VDD n1350 U2664/net20 VDD pmos W=0.205u L=0.04u
M23401 WX2890 n1283 U2665/net26 VSS nmos W=0.155u L=0.04u
M23402 WX2890 n1893 U2665/net26 VSS nmos W=0.155u L=0.04u
M23403 U2665/net29 n2037 VSS VSS nmos W=0.155u L=0.04u
M23404 U2665/net26 n2036 U2665/net29 VSS nmos W=0.155u L=0.04u
M23405 U2665/net26 n1255 U2665/net29 VSS nmos W=0.155u L=0.04u
M23406 WX2890 n1893 U2665/net43 VDD pmos W=0.205u L=0.04u
M23407 WX2890 n1255 U2665/net49 VDD pmos W=0.205u L=0.04u
M23408 U2665/net49 n2036 VDD VDD pmos W=0.205u L=0.04u
M23409 U2665/net43 n1283 VDD VDD pmos W=0.205u L=0.04u
M23410 WX2890 n2037 VDD VDD pmos W=0.205u L=0.04u
M23411 U2666/net29 n1350 VSS VSS nmos W=0.155u L=0.04u
M23412 n2037 WX3109 U2666/net29 VSS nmos W=0.155u L=0.04u
M23413 n2037 n1317 U2666/net23 VSS nmos W=0.155u L=0.04u
M23414 U2666/net23 CRC_OUT_7_12 VSS VSS nmos W=0.155u L=0.04u
M23415 U2666/net20 CRC_OUT_7_12 n2037 VDD pmos W=0.205u L=0.04u
M23416 U2666/net20 n1317 n2037 VDD pmos W=0.205u L=0.04u
M23417 VDD WX3109 U2666/net20 VDD pmos W=0.205u L=0.04u
M23418 VDD n1350 U2666/net20 VDD pmos W=0.205u L=0.04u
M23419 n1893 n2038 VSS VSS nmos W=0.135u L=0.04u
M23420 n1893 n2038 VDD VDD pmos W=0.205u L=0.04u
M23421 U2668/net28 U2668/net20 U2668/net64 VSS nmos W=0.155u L=0.04u
M23422 U2668/net24 U2668/net30 U2668/net32 VSS nmos W=0.155u L=0.04u
M23423 U2668/net28 U2668/net40 U2668/net24 VSS nmos W=0.155u L=0.04u
M23424 U2668/net40 WX4690 U2668/net108 VSS nmos W=0.155u L=0.04u
M23425 U2668/net40 U2668/net106 U2668/net104 VSS nmos W=0.155u L=0.04u
M23426 U2668/net24 WX4626 U2668/net050 VSS nmos W=0.155u L=0.04u
M23427 U2668/net050 U2668/net32 VSS VSS nmos W=0.155u L=0.04u
M23428 U2668/net20 U2668/net40 VSS VSS nmos W=0.155u L=0.04u
M23429 U2668/net106 WX4690 VSS VSS nmos W=0.155u L=0.04u
M23430 U2668/net104 WX4754 VSS VSS nmos W=0.155u L=0.04u
M23431 U2668/net30 WX4626 VSS VSS nmos W=0.155u L=0.04u
M23432 U2668/net108 U2668/net104 VSS VSS nmos W=0.155u L=0.04u
M23433 n2038 U2668/net28 VSS VSS nmos W=0.155u L=0.04u
M23434 U2668/net32 WX4562 VSS VSS nmos W=0.155u L=0.04u
M23435 U2668/net64 U2668/net24 VSS VSS nmos W=0.2u L=0.04u
M23436 U2668/net28 U2668/net40 U2668/net64 VDD pmos W=0.205u L=0.04u
M23437 U2668/net24 WX4626 U2668/net32 VDD pmos W=0.205u L=0.04u
M23438 U2668/net28 U2668/net20 U2668/net24 VDD pmos W=0.205u L=0.04u
M23439 U2668/net40 U2668/net106 U2668/net108 VDD pmos W=0.205u L=0.04u
M23440 U2668/net40 WX4690 U2668/net104 VDD pmos W=0.205u L=0.04u
M23441 U2668/net20 U2668/net40 VDD VDD pmos W=0.205u L=0.04u
M23442 U2668/net106 WX4690 VDD VDD pmos W=0.205u L=0.04u
M23443 U2668/net104 WX4754 VDD VDD pmos W=0.205u L=0.04u
M23444 U2668/net30 WX4626 VDD VDD pmos W=0.205u L=0.04u
M23445 U2668/net108 U2668/net104 VDD VDD pmos W=0.205u L=0.04u
M23446 n2038 U2668/net28 VDD VDD pmos W=0.205u L=0.04u
M23447 U2668/net32 WX4562 VDD VDD pmos W=0.205u L=0.04u
M23448 U2668/net64 U2668/net24 VDD VDD pmos W=0.28u L=0.04u
M23449 U2668/net24 U2668/net30 U2668/net045 VDD pmos W=0.205u L=0.04u
M23450 U2668/net045 U2668/net32 VDD VDD pmos W=0.205u L=0.04u
M23451 WX2876 n1283 U2669/net26 VSS nmos W=0.155u L=0.04u
M23452 WX2876 n1896 U2669/net26 VSS nmos W=0.155u L=0.04u
M23453 U2669/net29 n2040 VSS VSS nmos W=0.155u L=0.04u
M23454 U2669/net26 n2039 U2669/net29 VSS nmos W=0.155u L=0.04u
M23455 U2669/net26 n1255 U2669/net29 VSS nmos W=0.155u L=0.04u
M23456 WX2876 n1896 U2669/net43 VDD pmos W=0.205u L=0.04u
M23457 WX2876 n1255 U2669/net49 VDD pmos W=0.205u L=0.04u
M23458 U2669/net49 n2039 VDD VDD pmos W=0.205u L=0.04u
M23459 U2669/net43 n1283 VDD VDD pmos W=0.205u L=0.04u
M23460 WX2876 n2040 VDD VDD pmos W=0.205u L=0.04u
M23461 U2670/net29 n1350 VSS VSS nmos W=0.155u L=0.04u
M23462 n2040 WX3107 U2670/net29 VSS nmos W=0.155u L=0.04u
M23463 n2040 n1317 U2670/net23 VSS nmos W=0.155u L=0.04u
M23464 U2670/net23 CRC_OUT_7_13 VSS VSS nmos W=0.155u L=0.04u
M23465 U2670/net20 CRC_OUT_7_13 n2040 VDD pmos W=0.205u L=0.04u
M23466 U2670/net20 n1317 n2040 VDD pmos W=0.205u L=0.04u
M23467 VDD WX3107 U2670/net20 VDD pmos W=0.205u L=0.04u
M23468 VDD n1350 U2670/net20 VDD pmos W=0.205u L=0.04u
M23469 n1896 n2041 VSS VSS nmos W=0.135u L=0.04u
M23470 n1896 n2041 VDD VDD pmos W=0.205u L=0.04u
M23471 U2672/net28 U2672/net20 U2672/net64 VSS nmos W=0.155u L=0.04u
M23472 U2672/net24 U2672/net30 U2672/net32 VSS nmos W=0.155u L=0.04u
M23473 U2672/net28 U2672/net40 U2672/net24 VSS nmos W=0.155u L=0.04u
M23474 U2672/net40 WX4688 U2672/net108 VSS nmos W=0.155u L=0.04u
M23475 U2672/net40 U2672/net106 U2672/net104 VSS nmos W=0.155u L=0.04u
M23476 U2672/net24 WX4624 U2672/net050 VSS nmos W=0.155u L=0.04u
M23477 U2672/net050 U2672/net32 VSS VSS nmos W=0.155u L=0.04u
M23478 U2672/net20 U2672/net40 VSS VSS nmos W=0.155u L=0.04u
M23479 U2672/net106 WX4688 VSS VSS nmos W=0.155u L=0.04u
M23480 U2672/net104 WX4752 VSS VSS nmos W=0.155u L=0.04u
M23481 U2672/net30 WX4624 VSS VSS nmos W=0.155u L=0.04u
M23482 U2672/net108 U2672/net104 VSS VSS nmos W=0.155u L=0.04u
M23483 n2041 U2672/net28 VSS VSS nmos W=0.155u L=0.04u
M23484 U2672/net32 WX4560 VSS VSS nmos W=0.155u L=0.04u
M23485 U2672/net64 U2672/net24 VSS VSS nmos W=0.2u L=0.04u
M23486 U2672/net28 U2672/net40 U2672/net64 VDD pmos W=0.205u L=0.04u
M23487 U2672/net24 WX4624 U2672/net32 VDD pmos W=0.205u L=0.04u
M23488 U2672/net28 U2672/net20 U2672/net24 VDD pmos W=0.205u L=0.04u
M23489 U2672/net40 U2672/net106 U2672/net108 VDD pmos W=0.205u L=0.04u
M23490 U2672/net40 WX4688 U2672/net104 VDD pmos W=0.205u L=0.04u
M23491 U2672/net20 U2672/net40 VDD VDD pmos W=0.205u L=0.04u
M23492 U2672/net106 WX4688 VDD VDD pmos W=0.205u L=0.04u
M23493 U2672/net104 WX4752 VDD VDD pmos W=0.205u L=0.04u
M23494 U2672/net30 WX4624 VDD VDD pmos W=0.205u L=0.04u
M23495 U2672/net108 U2672/net104 VDD VDD pmos W=0.205u L=0.04u
M23496 n2041 U2672/net28 VDD VDD pmos W=0.205u L=0.04u
M23497 U2672/net32 WX4560 VDD VDD pmos W=0.205u L=0.04u
M23498 U2672/net64 U2672/net24 VDD VDD pmos W=0.28u L=0.04u
M23499 U2672/net24 U2672/net30 U2672/net045 VDD pmos W=0.205u L=0.04u
M23500 U2672/net045 U2672/net32 VDD VDD pmos W=0.205u L=0.04u
M23501 WX2862 n1283 U2673/net26 VSS nmos W=0.155u L=0.04u
M23502 WX2862 n1902 U2673/net26 VSS nmos W=0.155u L=0.04u
M23503 U2673/net29 n2043 VSS VSS nmos W=0.155u L=0.04u
M23504 U2673/net26 n2042 U2673/net29 VSS nmos W=0.155u L=0.04u
M23505 U2673/net26 n1255 U2673/net29 VSS nmos W=0.155u L=0.04u
M23506 WX2862 n1902 U2673/net43 VDD pmos W=0.205u L=0.04u
M23507 WX2862 n1255 U2673/net49 VDD pmos W=0.205u L=0.04u
M23508 U2673/net49 n2042 VDD VDD pmos W=0.205u L=0.04u
M23509 U2673/net43 n1283 VDD VDD pmos W=0.205u L=0.04u
M23510 WX2862 n2043 VDD VDD pmos W=0.205u L=0.04u
M23511 U2674/net29 n1350 VSS VSS nmos W=0.155u L=0.04u
M23512 n2043 WX3105 U2674/net29 VSS nmos W=0.155u L=0.04u
M23513 n2043 n1317 U2674/net23 VSS nmos W=0.155u L=0.04u
M23514 U2674/net23 CRC_OUT_7_14 VSS VSS nmos W=0.155u L=0.04u
M23515 U2674/net20 CRC_OUT_7_14 n2043 VDD pmos W=0.205u L=0.04u
M23516 U2674/net20 n1317 n2043 VDD pmos W=0.205u L=0.04u
M23517 VDD WX3105 U2674/net20 VDD pmos W=0.205u L=0.04u
M23518 VDD n1350 U2674/net20 VDD pmos W=0.205u L=0.04u
M23519 n1902 n2044 VSS VSS nmos W=0.135u L=0.04u
M23520 n1902 n2044 VDD VDD pmos W=0.205u L=0.04u
M23521 U2676/net28 U2676/net20 U2676/net64 VSS nmos W=0.155u L=0.04u
M23522 U2676/net24 U2676/net30 U2676/net32 VSS nmos W=0.155u L=0.04u
M23523 U2676/net28 U2676/net40 U2676/net24 VSS nmos W=0.155u L=0.04u
M23524 U2676/net40 WX4686 U2676/net108 VSS nmos W=0.155u L=0.04u
M23525 U2676/net40 U2676/net106 U2676/net104 VSS nmos W=0.155u L=0.04u
M23526 U2676/net24 WX4622 U2676/net050 VSS nmos W=0.155u L=0.04u
M23527 U2676/net050 U2676/net32 VSS VSS nmos W=0.155u L=0.04u
M23528 U2676/net20 U2676/net40 VSS VSS nmos W=0.155u L=0.04u
M23529 U2676/net106 WX4686 VSS VSS nmos W=0.155u L=0.04u
M23530 U2676/net104 WX4750 VSS VSS nmos W=0.155u L=0.04u
M23531 U2676/net30 WX4622 VSS VSS nmos W=0.155u L=0.04u
M23532 U2676/net108 U2676/net104 VSS VSS nmos W=0.155u L=0.04u
M23533 n2044 U2676/net28 VSS VSS nmos W=0.155u L=0.04u
M23534 U2676/net32 WX4558 VSS VSS nmos W=0.155u L=0.04u
M23535 U2676/net64 U2676/net24 VSS VSS nmos W=0.2u L=0.04u
M23536 U2676/net28 U2676/net40 U2676/net64 VDD pmos W=0.205u L=0.04u
M23537 U2676/net24 WX4622 U2676/net32 VDD pmos W=0.205u L=0.04u
M23538 U2676/net28 U2676/net20 U2676/net24 VDD pmos W=0.205u L=0.04u
M23539 U2676/net40 U2676/net106 U2676/net108 VDD pmos W=0.205u L=0.04u
M23540 U2676/net40 WX4686 U2676/net104 VDD pmos W=0.205u L=0.04u
M23541 U2676/net20 U2676/net40 VDD VDD pmos W=0.205u L=0.04u
M23542 U2676/net106 WX4686 VDD VDD pmos W=0.205u L=0.04u
M23543 U2676/net104 WX4750 VDD VDD pmos W=0.205u L=0.04u
M23544 U2676/net30 WX4622 VDD VDD pmos W=0.205u L=0.04u
M23545 U2676/net108 U2676/net104 VDD VDD pmos W=0.205u L=0.04u
M23546 n2044 U2676/net28 VDD VDD pmos W=0.205u L=0.04u
M23547 U2676/net32 WX4558 VDD VDD pmos W=0.205u L=0.04u
M23548 U2676/net64 U2676/net24 VDD VDD pmos W=0.28u L=0.04u
M23549 U2676/net24 U2676/net30 U2676/net045 VDD pmos W=0.205u L=0.04u
M23550 U2676/net045 U2676/net32 VDD VDD pmos W=0.205u L=0.04u
M23551 WX2848 n1283 U2677/net26 VSS nmos W=0.155u L=0.04u
M23552 WX2848 n1905 U2677/net26 VSS nmos W=0.155u L=0.04u
M23553 U2677/net29 n2046 VSS VSS nmos W=0.155u L=0.04u
M23554 U2677/net26 n2045 U2677/net29 VSS nmos W=0.155u L=0.04u
M23555 U2677/net26 n1255 U2677/net29 VSS nmos W=0.155u L=0.04u
M23556 WX2848 n1905 U2677/net43 VDD pmos W=0.205u L=0.04u
M23557 WX2848 n1255 U2677/net49 VDD pmos W=0.205u L=0.04u
M23558 U2677/net49 n2045 VDD VDD pmos W=0.205u L=0.04u
M23559 U2677/net43 n1283 VDD VDD pmos W=0.205u L=0.04u
M23560 WX2848 n2046 VDD VDD pmos W=0.205u L=0.04u
M23561 U2678/net29 n1350 VSS VSS nmos W=0.155u L=0.04u
M23562 n2046 WX3103 U2678/net29 VSS nmos W=0.155u L=0.04u
M23563 n2046 n1317 U2678/net23 VSS nmos W=0.155u L=0.04u
M23564 U2678/net23 CRC_OUT_7_15 VSS VSS nmos W=0.155u L=0.04u
M23565 U2678/net20 CRC_OUT_7_15 n2046 VDD pmos W=0.205u L=0.04u
M23566 U2678/net20 n1317 n2046 VDD pmos W=0.205u L=0.04u
M23567 VDD WX3103 U2678/net20 VDD pmos W=0.205u L=0.04u
M23568 VDD n1350 U2678/net20 VDD pmos W=0.205u L=0.04u
M23569 n1905 n2047 VSS VSS nmos W=0.135u L=0.04u
M23570 n1905 n2047 VDD VDD pmos W=0.205u L=0.04u
M23571 U2680/net28 U2680/net20 U2680/net64 VSS nmos W=0.155u L=0.04u
M23572 U2680/net24 U2680/net30 U2680/net32 VSS nmos W=0.155u L=0.04u
M23573 U2680/net28 U2680/net40 U2680/net24 VSS nmos W=0.155u L=0.04u
M23574 U2680/net40 WX4684 U2680/net108 VSS nmos W=0.155u L=0.04u
M23575 U2680/net40 U2680/net106 U2680/net104 VSS nmos W=0.155u L=0.04u
M23576 U2680/net24 WX4620 U2680/net050 VSS nmos W=0.155u L=0.04u
M23577 U2680/net050 U2680/net32 VSS VSS nmos W=0.155u L=0.04u
M23578 U2680/net20 U2680/net40 VSS VSS nmos W=0.155u L=0.04u
M23579 U2680/net106 WX4684 VSS VSS nmos W=0.155u L=0.04u
M23580 U2680/net104 WX4748 VSS VSS nmos W=0.155u L=0.04u
M23581 U2680/net30 WX4620 VSS VSS nmos W=0.155u L=0.04u
M23582 U2680/net108 U2680/net104 VSS VSS nmos W=0.155u L=0.04u
M23583 n2047 U2680/net28 VSS VSS nmos W=0.155u L=0.04u
M23584 U2680/net32 WX4556 VSS VSS nmos W=0.155u L=0.04u
M23585 U2680/net64 U2680/net24 VSS VSS nmos W=0.2u L=0.04u
M23586 U2680/net28 U2680/net40 U2680/net64 VDD pmos W=0.205u L=0.04u
M23587 U2680/net24 WX4620 U2680/net32 VDD pmos W=0.205u L=0.04u
M23588 U2680/net28 U2680/net20 U2680/net24 VDD pmos W=0.205u L=0.04u
M23589 U2680/net40 U2680/net106 U2680/net108 VDD pmos W=0.205u L=0.04u
M23590 U2680/net40 WX4684 U2680/net104 VDD pmos W=0.205u L=0.04u
M23591 U2680/net20 U2680/net40 VDD VDD pmos W=0.205u L=0.04u
M23592 U2680/net106 WX4684 VDD VDD pmos W=0.205u L=0.04u
M23593 U2680/net104 WX4748 VDD VDD pmos W=0.205u L=0.04u
M23594 U2680/net30 WX4620 VDD VDD pmos W=0.205u L=0.04u
M23595 U2680/net108 U2680/net104 VDD VDD pmos W=0.205u L=0.04u
M23596 n2047 U2680/net28 VDD VDD pmos W=0.205u L=0.04u
M23597 U2680/net32 WX4556 VDD VDD pmos W=0.205u L=0.04u
M23598 U2680/net64 U2680/net24 VDD VDD pmos W=0.28u L=0.04u
M23599 U2680/net24 U2680/net30 U2680/net045 VDD pmos W=0.205u L=0.04u
M23600 U2680/net045 U2680/net32 VDD VDD pmos W=0.205u L=0.04u
M23601 WX2834 n1283 U2681/net26 VSS nmos W=0.155u L=0.04u
M23602 WX2834 n1908 U2681/net26 VSS nmos W=0.155u L=0.04u
M23603 U2681/net29 n2049 VSS VSS nmos W=0.155u L=0.04u
M23604 U2681/net26 n2048 U2681/net29 VSS nmos W=0.155u L=0.04u
M23605 U2681/net26 n1255 U2681/net29 VSS nmos W=0.155u L=0.04u
M23606 WX2834 n1908 U2681/net43 VDD pmos W=0.205u L=0.04u
M23607 WX2834 n1255 U2681/net49 VDD pmos W=0.205u L=0.04u
M23608 U2681/net49 n2048 VDD VDD pmos W=0.205u L=0.04u
M23609 U2681/net43 n1283 VDD VDD pmos W=0.205u L=0.04u
M23610 WX2834 n2049 VDD VDD pmos W=0.205u L=0.04u
M23611 U2682/net29 n1350 VSS VSS nmos W=0.155u L=0.04u
M23612 n2049 WX3101 U2682/net29 VSS nmos W=0.155u L=0.04u
M23613 n2049 n1317 U2682/net23 VSS nmos W=0.155u L=0.04u
M23614 U2682/net23 CRC_OUT_7_16 VSS VSS nmos W=0.155u L=0.04u
M23615 U2682/net20 CRC_OUT_7_16 n2049 VDD pmos W=0.205u L=0.04u
M23616 U2682/net20 n1317 n2049 VDD pmos W=0.205u L=0.04u
M23617 VDD WX3101 U2682/net20 VDD pmos W=0.205u L=0.04u
M23618 VDD n1350 U2682/net20 VDD pmos W=0.205u L=0.04u
M23619 n1908 n2050 VSS VSS nmos W=0.135u L=0.04u
M23620 n1908 n2050 VDD VDD pmos W=0.205u L=0.04u
M23621 U2684/net28 U2684/net20 U2684/net64 VSS nmos W=0.155u L=0.04u
M23622 U2684/net24 U2684/net30 U2684/net32 VSS nmos W=0.155u L=0.04u
M23623 U2684/net28 U2684/net40 U2684/net24 VSS nmos W=0.155u L=0.04u
M23624 U2684/net40 n2051 U2684/net108 VSS nmos W=0.155u L=0.04u
M23625 U2684/net40 U2684/net106 U2684/net104 VSS nmos W=0.155u L=0.04u
M23626 U2684/net24 WX4682 U2684/net050 VSS nmos W=0.155u L=0.04u
M23627 U2684/net050 U2684/net32 VSS VSS nmos W=0.155u L=0.04u
M23628 U2684/net20 U2684/net40 VSS VSS nmos W=0.155u L=0.04u
M23629 U2684/net106 n2051 VSS VSS nmos W=0.155u L=0.04u
M23630 U2684/net104 WX4746 VSS VSS nmos W=0.155u L=0.04u
M23631 U2684/net30 WX4682 VSS VSS nmos W=0.155u L=0.04u
M23632 U2684/net108 U2684/net104 VSS VSS nmos W=0.155u L=0.04u
M23633 n2050 U2684/net28 VSS VSS nmos W=0.155u L=0.04u
M23634 U2684/net32 WX4618 VSS VSS nmos W=0.155u L=0.04u
M23635 U2684/net64 U2684/net24 VSS VSS nmos W=0.2u L=0.04u
M23636 U2684/net28 U2684/net40 U2684/net64 VDD pmos W=0.205u L=0.04u
M23637 U2684/net24 WX4682 U2684/net32 VDD pmos W=0.205u L=0.04u
M23638 U2684/net28 U2684/net20 U2684/net24 VDD pmos W=0.205u L=0.04u
M23639 U2684/net40 U2684/net106 U2684/net108 VDD pmos W=0.205u L=0.04u
M23640 U2684/net40 n2051 U2684/net104 VDD pmos W=0.205u L=0.04u
M23641 U2684/net20 U2684/net40 VDD VDD pmos W=0.205u L=0.04u
M23642 U2684/net106 n2051 VDD VDD pmos W=0.205u L=0.04u
M23643 U2684/net104 WX4746 VDD VDD pmos W=0.205u L=0.04u
M23644 U2684/net30 WX4682 VDD VDD pmos W=0.205u L=0.04u
M23645 U2684/net108 U2684/net104 VDD VDD pmos W=0.205u L=0.04u
M23646 n2050 U2684/net28 VDD VDD pmos W=0.205u L=0.04u
M23647 U2684/net32 WX4618 VDD VDD pmos W=0.205u L=0.04u
M23648 U2684/net64 U2684/net24 VDD VDD pmos W=0.28u L=0.04u
M23649 U2684/net24 U2684/net30 U2684/net045 VDD pmos W=0.205u L=0.04u
M23650 U2684/net045 U2684/net32 VDD VDD pmos W=0.205u L=0.04u
M23651 U2685/net4 WX4554 U2685/net14 VSS nmos W=0.155u L=0.04u
M23652 U2685/net6 U2685/net10 U2685/net14 VSS nmos W=0.17u L=0.04u
M23653 U2685/net4 n1373 VSS VSS nmos W=0.155u L=0.04u
M23654 U2685/net6 U2685/net4 VSS VSS nmos W=0.17u L=0.04u
M23655 n2051 U2685/net14 VSS VSS nmos W=0.155u L=0.04u
M23656 U2685/net10 WX4554 VSS VSS nmos W=0.155u L=0.04u
M23657 U2685/net4 U2685/net10 U2685/net14 VDD pmos W=0.255u L=0.04u
M23658 U2685/net6 WX4554 U2685/net14 VDD pmos W=0.28u L=0.04u
M23659 U2685/net4 n1373 VDD VDD pmos W=0.205u L=0.04u
M23660 U2685/net6 U2685/net4 VDD VDD pmos W=0.24u L=0.04u
M23661 n2051 U2685/net14 VDD VDD pmos W=0.205u L=0.04u
M23662 U2685/net10 WX4554 VDD VDD pmos W=0.205u L=0.04u
M23663 WX2820 n1283 U2686/net26 VSS nmos W=0.155u L=0.04u
M23664 WX2820 n1912 U2686/net26 VSS nmos W=0.155u L=0.04u
M23665 U2686/net29 n2053 VSS VSS nmos W=0.155u L=0.04u
M23666 U2686/net26 n2052 U2686/net29 VSS nmos W=0.155u L=0.04u
M23667 U2686/net26 n1255 U2686/net29 VSS nmos W=0.155u L=0.04u
M23668 WX2820 n1912 U2686/net43 VDD pmos W=0.205u L=0.04u
M23669 WX2820 n1255 U2686/net49 VDD pmos W=0.205u L=0.04u
M23670 U2686/net49 n2052 VDD VDD pmos W=0.205u L=0.04u
M23671 U2686/net43 n1283 VDD VDD pmos W=0.205u L=0.04u
M23672 WX2820 n2053 VDD VDD pmos W=0.205u L=0.04u
M23673 U2687/net29 n1350 VSS VSS nmos W=0.155u L=0.04u
M23674 n2053 WX3099 U2687/net29 VSS nmos W=0.155u L=0.04u
M23675 n2053 n1317 U2687/net23 VSS nmos W=0.155u L=0.04u
M23676 U2687/net23 CRC_OUT_7_17 VSS VSS nmos W=0.155u L=0.04u
M23677 U2687/net20 CRC_OUT_7_17 n2053 VDD pmos W=0.205u L=0.04u
M23678 U2687/net20 n1317 n2053 VDD pmos W=0.205u L=0.04u
M23679 VDD WX3099 U2687/net20 VDD pmos W=0.205u L=0.04u
M23680 VDD n1350 U2687/net20 VDD pmos W=0.205u L=0.04u
M23681 n1912 n2054 VSS VSS nmos W=0.135u L=0.04u
M23682 n1912 n2054 VDD VDD pmos W=0.205u L=0.04u
M23683 U2689/net28 U2689/net20 U2689/net64 VSS nmos W=0.155u L=0.04u
M23684 U2689/net24 U2689/net30 U2689/net32 VSS nmos W=0.155u L=0.04u
M23685 U2689/net28 U2689/net40 U2689/net24 VSS nmos W=0.155u L=0.04u
M23686 U2689/net40 n2055 U2689/net108 VSS nmos W=0.155u L=0.04u
M23687 U2689/net40 U2689/net106 U2689/net104 VSS nmos W=0.155u L=0.04u
M23688 U2689/net24 WX4680 U2689/net050 VSS nmos W=0.155u L=0.04u
M23689 U2689/net050 U2689/net32 VSS VSS nmos W=0.155u L=0.04u
M23690 U2689/net20 U2689/net40 VSS VSS nmos W=0.155u L=0.04u
M23691 U2689/net106 n2055 VSS VSS nmos W=0.155u L=0.04u
M23692 U2689/net104 WX4744 VSS VSS nmos W=0.155u L=0.04u
M23693 U2689/net30 WX4680 VSS VSS nmos W=0.155u L=0.04u
M23694 U2689/net108 U2689/net104 VSS VSS nmos W=0.155u L=0.04u
M23695 n2054 U2689/net28 VSS VSS nmos W=0.155u L=0.04u
M23696 U2689/net32 WX4616 VSS VSS nmos W=0.155u L=0.04u
M23697 U2689/net64 U2689/net24 VSS VSS nmos W=0.2u L=0.04u
M23698 U2689/net28 U2689/net40 U2689/net64 VDD pmos W=0.205u L=0.04u
M23699 U2689/net24 WX4680 U2689/net32 VDD pmos W=0.205u L=0.04u
M23700 U2689/net28 U2689/net20 U2689/net24 VDD pmos W=0.205u L=0.04u
M23701 U2689/net40 U2689/net106 U2689/net108 VDD pmos W=0.205u L=0.04u
M23702 U2689/net40 n2055 U2689/net104 VDD pmos W=0.205u L=0.04u
M23703 U2689/net20 U2689/net40 VDD VDD pmos W=0.205u L=0.04u
M23704 U2689/net106 n2055 VDD VDD pmos W=0.205u L=0.04u
M23705 U2689/net104 WX4744 VDD VDD pmos W=0.205u L=0.04u
M23706 U2689/net30 WX4680 VDD VDD pmos W=0.205u L=0.04u
M23707 U2689/net108 U2689/net104 VDD VDD pmos W=0.205u L=0.04u
M23708 n2054 U2689/net28 VDD VDD pmos W=0.205u L=0.04u
M23709 U2689/net32 WX4616 VDD VDD pmos W=0.205u L=0.04u
M23710 U2689/net64 U2689/net24 VDD VDD pmos W=0.28u L=0.04u
M23711 U2689/net24 U2689/net30 U2689/net045 VDD pmos W=0.205u L=0.04u
M23712 U2689/net045 U2689/net32 VDD VDD pmos W=0.205u L=0.04u
M23713 U2690/net4 WX4552 U2690/net14 VSS nmos W=0.155u L=0.04u
M23714 U2690/net6 U2690/net10 U2690/net14 VSS nmos W=0.17u L=0.04u
M23715 U2690/net4 n1373 VSS VSS nmos W=0.155u L=0.04u
M23716 U2690/net6 U2690/net4 VSS VSS nmos W=0.17u L=0.04u
M23717 n2055 U2690/net14 VSS VSS nmos W=0.155u L=0.04u
M23718 U2690/net10 WX4552 VSS VSS nmos W=0.155u L=0.04u
M23719 U2690/net4 U2690/net10 U2690/net14 VDD pmos W=0.255u L=0.04u
M23720 U2690/net6 WX4552 U2690/net14 VDD pmos W=0.28u L=0.04u
M23721 U2690/net4 n1373 VDD VDD pmos W=0.205u L=0.04u
M23722 U2690/net6 U2690/net4 VDD VDD pmos W=0.24u L=0.04u
M23723 n2055 U2690/net14 VDD VDD pmos W=0.205u L=0.04u
M23724 U2690/net10 WX4552 VDD VDD pmos W=0.205u L=0.04u
M23725 WX2806 n1283 U2691/net26 VSS nmos W=0.155u L=0.04u
M23726 WX2806 n1916 U2691/net26 VSS nmos W=0.155u L=0.04u
M23727 U2691/net29 n2057 VSS VSS nmos W=0.155u L=0.04u
M23728 U2691/net26 n2056 U2691/net29 VSS nmos W=0.155u L=0.04u
M23729 U2691/net26 n1255 U2691/net29 VSS nmos W=0.155u L=0.04u
M23730 WX2806 n1916 U2691/net43 VDD pmos W=0.205u L=0.04u
M23731 WX2806 n1255 U2691/net49 VDD pmos W=0.205u L=0.04u
M23732 U2691/net49 n2056 VDD VDD pmos W=0.205u L=0.04u
M23733 U2691/net43 n1283 VDD VDD pmos W=0.205u L=0.04u
M23734 WX2806 n2057 VDD VDD pmos W=0.205u L=0.04u
M23735 U2692/net29 n1350 VSS VSS nmos W=0.155u L=0.04u
M23736 n2057 WX3097 U2692/net29 VSS nmos W=0.155u L=0.04u
M23737 n2057 n1317 U2692/net23 VSS nmos W=0.155u L=0.04u
M23738 U2692/net23 CRC_OUT_7_18 VSS VSS nmos W=0.155u L=0.04u
M23739 U2692/net20 CRC_OUT_7_18 n2057 VDD pmos W=0.205u L=0.04u
M23740 U2692/net20 n1317 n2057 VDD pmos W=0.205u L=0.04u
M23741 VDD WX3097 U2692/net20 VDD pmos W=0.205u L=0.04u
M23742 VDD n1350 U2692/net20 VDD pmos W=0.205u L=0.04u
M23743 n1916 n2058 VSS VSS nmos W=0.135u L=0.04u
M23744 n1916 n2058 VDD VDD pmos W=0.205u L=0.04u
M23745 U2694/net28 U2694/net20 U2694/net64 VSS nmos W=0.155u L=0.04u
M23746 U2694/net24 U2694/net30 U2694/net32 VSS nmos W=0.155u L=0.04u
M23747 U2694/net28 U2694/net40 U2694/net24 VSS nmos W=0.155u L=0.04u
M23748 U2694/net40 n2059 U2694/net108 VSS nmos W=0.155u L=0.04u
M23749 U2694/net40 U2694/net106 U2694/net104 VSS nmos W=0.155u L=0.04u
M23750 U2694/net24 WX4678 U2694/net050 VSS nmos W=0.155u L=0.04u
M23751 U2694/net050 U2694/net32 VSS VSS nmos W=0.155u L=0.04u
M23752 U2694/net20 U2694/net40 VSS VSS nmos W=0.155u L=0.04u
M23753 U2694/net106 n2059 VSS VSS nmos W=0.155u L=0.04u
M23754 U2694/net104 WX4742 VSS VSS nmos W=0.155u L=0.04u
M23755 U2694/net30 WX4678 VSS VSS nmos W=0.155u L=0.04u
M23756 U2694/net108 U2694/net104 VSS VSS nmos W=0.155u L=0.04u
M23757 n2058 U2694/net28 VSS VSS nmos W=0.155u L=0.04u
M23758 U2694/net32 WX4614 VSS VSS nmos W=0.155u L=0.04u
M23759 U2694/net64 U2694/net24 VSS VSS nmos W=0.2u L=0.04u
M23760 U2694/net28 U2694/net40 U2694/net64 VDD pmos W=0.205u L=0.04u
M23761 U2694/net24 WX4678 U2694/net32 VDD pmos W=0.205u L=0.04u
M23762 U2694/net28 U2694/net20 U2694/net24 VDD pmos W=0.205u L=0.04u
M23763 U2694/net40 U2694/net106 U2694/net108 VDD pmos W=0.205u L=0.04u
M23764 U2694/net40 n2059 U2694/net104 VDD pmos W=0.205u L=0.04u
M23765 U2694/net20 U2694/net40 VDD VDD pmos W=0.205u L=0.04u
M23766 U2694/net106 n2059 VDD VDD pmos W=0.205u L=0.04u
M23767 U2694/net104 WX4742 VDD VDD pmos W=0.205u L=0.04u
M23768 U2694/net30 WX4678 VDD VDD pmos W=0.205u L=0.04u
M23769 U2694/net108 U2694/net104 VDD VDD pmos W=0.205u L=0.04u
M23770 n2058 U2694/net28 VDD VDD pmos W=0.205u L=0.04u
M23771 U2694/net32 WX4614 VDD VDD pmos W=0.205u L=0.04u
M23772 U2694/net64 U2694/net24 VDD VDD pmos W=0.28u L=0.04u
M23773 U2694/net24 U2694/net30 U2694/net045 VDD pmos W=0.205u L=0.04u
M23774 U2694/net045 U2694/net32 VDD VDD pmos W=0.205u L=0.04u
M23775 U2695/net4 WX4550 U2695/net14 VSS nmos W=0.155u L=0.04u
M23776 U2695/net6 U2695/net10 U2695/net14 VSS nmos W=0.17u L=0.04u
M23777 U2695/net4 n1373 VSS VSS nmos W=0.155u L=0.04u
M23778 U2695/net6 U2695/net4 VSS VSS nmos W=0.17u L=0.04u
M23779 n2059 U2695/net14 VSS VSS nmos W=0.155u L=0.04u
M23780 U2695/net10 WX4550 VSS VSS nmos W=0.155u L=0.04u
M23781 U2695/net4 U2695/net10 U2695/net14 VDD pmos W=0.255u L=0.04u
M23782 U2695/net6 WX4550 U2695/net14 VDD pmos W=0.28u L=0.04u
M23783 U2695/net4 n1373 VDD VDD pmos W=0.205u L=0.04u
M23784 U2695/net6 U2695/net4 VDD VDD pmos W=0.24u L=0.04u
M23785 n2059 U2695/net14 VDD VDD pmos W=0.205u L=0.04u
M23786 U2695/net10 WX4550 VDD VDD pmos W=0.205u L=0.04u
M23787 WX2792 n1283 U2696/net26 VSS nmos W=0.155u L=0.04u
M23788 WX2792 n1920 U2696/net26 VSS nmos W=0.155u L=0.04u
M23789 U2696/net29 n2061 VSS VSS nmos W=0.155u L=0.04u
M23790 U2696/net26 n2060 U2696/net29 VSS nmos W=0.155u L=0.04u
M23791 U2696/net26 n1255 U2696/net29 VSS nmos W=0.155u L=0.04u
M23792 WX2792 n1920 U2696/net43 VDD pmos W=0.205u L=0.04u
M23793 WX2792 n1255 U2696/net49 VDD pmos W=0.205u L=0.04u
M23794 U2696/net49 n2060 VDD VDD pmos W=0.205u L=0.04u
M23795 U2696/net43 n1283 VDD VDD pmos W=0.205u L=0.04u
M23796 WX2792 n2061 VDD VDD pmos W=0.205u L=0.04u
M23797 U2697/net29 n1350 VSS VSS nmos W=0.155u L=0.04u
M23798 n2061 WX3095 U2697/net29 VSS nmos W=0.155u L=0.04u
M23799 n2061 n1316 U2697/net23 VSS nmos W=0.155u L=0.04u
M23800 U2697/net23 CRC_OUT_7_19 VSS VSS nmos W=0.155u L=0.04u
M23801 U2697/net20 CRC_OUT_7_19 n2061 VDD pmos W=0.205u L=0.04u
M23802 U2697/net20 n1316 n2061 VDD pmos W=0.205u L=0.04u
M23803 VDD WX3095 U2697/net20 VDD pmos W=0.205u L=0.04u
M23804 VDD n1350 U2697/net20 VDD pmos W=0.205u L=0.04u
M23805 n1920 n2062 VSS VSS nmos W=0.135u L=0.04u
M23806 n1920 n2062 VDD VDD pmos W=0.205u L=0.04u
M23807 U2699/net28 U2699/net20 U2699/net64 VSS nmos W=0.155u L=0.04u
M23808 U2699/net24 U2699/net30 U2699/net32 VSS nmos W=0.155u L=0.04u
M23809 U2699/net28 U2699/net40 U2699/net24 VSS nmos W=0.155u L=0.04u
M23810 U2699/net40 n2063 U2699/net108 VSS nmos W=0.155u L=0.04u
M23811 U2699/net40 U2699/net106 U2699/net104 VSS nmos W=0.155u L=0.04u
M23812 U2699/net24 WX4676 U2699/net050 VSS nmos W=0.155u L=0.04u
M23813 U2699/net050 U2699/net32 VSS VSS nmos W=0.155u L=0.04u
M23814 U2699/net20 U2699/net40 VSS VSS nmos W=0.155u L=0.04u
M23815 U2699/net106 n2063 VSS VSS nmos W=0.155u L=0.04u
M23816 U2699/net104 WX4740 VSS VSS nmos W=0.155u L=0.04u
M23817 U2699/net30 WX4676 VSS VSS nmos W=0.155u L=0.04u
M23818 U2699/net108 U2699/net104 VSS VSS nmos W=0.155u L=0.04u
M23819 n2062 U2699/net28 VSS VSS nmos W=0.155u L=0.04u
M23820 U2699/net32 WX4612 VSS VSS nmos W=0.155u L=0.04u
M23821 U2699/net64 U2699/net24 VSS VSS nmos W=0.2u L=0.04u
M23822 U2699/net28 U2699/net40 U2699/net64 VDD pmos W=0.205u L=0.04u
M23823 U2699/net24 WX4676 U2699/net32 VDD pmos W=0.205u L=0.04u
M23824 U2699/net28 U2699/net20 U2699/net24 VDD pmos W=0.205u L=0.04u
M23825 U2699/net40 U2699/net106 U2699/net108 VDD pmos W=0.205u L=0.04u
M23826 U2699/net40 n2063 U2699/net104 VDD pmos W=0.205u L=0.04u
M23827 U2699/net20 U2699/net40 VDD VDD pmos W=0.205u L=0.04u
M23828 U2699/net106 n2063 VDD VDD pmos W=0.205u L=0.04u
M23829 U2699/net104 WX4740 VDD VDD pmos W=0.205u L=0.04u
M23830 U2699/net30 WX4676 VDD VDD pmos W=0.205u L=0.04u
M23831 U2699/net108 U2699/net104 VDD VDD pmos W=0.205u L=0.04u
M23832 n2062 U2699/net28 VDD VDD pmos W=0.205u L=0.04u
M23833 U2699/net32 WX4612 VDD VDD pmos W=0.205u L=0.04u
M23834 U2699/net64 U2699/net24 VDD VDD pmos W=0.28u L=0.04u
M23835 U2699/net24 U2699/net30 U2699/net045 VDD pmos W=0.205u L=0.04u
M23836 U2699/net045 U2699/net32 VDD VDD pmos W=0.205u L=0.04u
M23837 U2700/net4 WX4548 U2700/net14 VSS nmos W=0.155u L=0.04u
M23838 U2700/net6 U2700/net10 U2700/net14 VSS nmos W=0.17u L=0.04u
M23839 U2700/net4 n1373 VSS VSS nmos W=0.155u L=0.04u
M23840 U2700/net6 U2700/net4 VSS VSS nmos W=0.17u L=0.04u
M23841 n2063 U2700/net14 VSS VSS nmos W=0.155u L=0.04u
M23842 U2700/net10 WX4548 VSS VSS nmos W=0.155u L=0.04u
M23843 U2700/net4 U2700/net10 U2700/net14 VDD pmos W=0.255u L=0.04u
M23844 U2700/net6 WX4548 U2700/net14 VDD pmos W=0.28u L=0.04u
M23845 U2700/net4 n1373 VDD VDD pmos W=0.205u L=0.04u
M23846 U2700/net6 U2700/net4 VDD VDD pmos W=0.24u L=0.04u
M23847 n2063 U2700/net14 VDD VDD pmos W=0.205u L=0.04u
M23848 U2700/net10 WX4548 VDD VDD pmos W=0.205u L=0.04u
M23849 WX2778 n1283 U2701/net26 VSS nmos W=0.155u L=0.04u
M23850 WX2778 n1924 U2701/net26 VSS nmos W=0.155u L=0.04u
M23851 U2701/net29 n2065 VSS VSS nmos W=0.155u L=0.04u
M23852 U2701/net26 n2064 U2701/net29 VSS nmos W=0.155u L=0.04u
M23853 U2701/net26 n1254 U2701/net29 VSS nmos W=0.155u L=0.04u
M23854 WX2778 n1924 U2701/net43 VDD pmos W=0.205u L=0.04u
M23855 WX2778 n1254 U2701/net49 VDD pmos W=0.205u L=0.04u
M23856 U2701/net49 n2064 VDD VDD pmos W=0.205u L=0.04u
M23857 U2701/net43 n1283 VDD VDD pmos W=0.205u L=0.04u
M23858 WX2778 n2065 VDD VDD pmos W=0.205u L=0.04u
M23859 U2702/net29 n1350 VSS VSS nmos W=0.155u L=0.04u
M23860 n2065 WX3093 U2702/net29 VSS nmos W=0.155u L=0.04u
M23861 n2065 n1316 U2702/net23 VSS nmos W=0.155u L=0.04u
M23862 U2702/net23 CRC_OUT_7_20 VSS VSS nmos W=0.155u L=0.04u
M23863 U2702/net20 CRC_OUT_7_20 n2065 VDD pmos W=0.205u L=0.04u
M23864 U2702/net20 n1316 n2065 VDD pmos W=0.205u L=0.04u
M23865 VDD WX3093 U2702/net20 VDD pmos W=0.205u L=0.04u
M23866 VDD n1350 U2702/net20 VDD pmos W=0.205u L=0.04u
M23867 n1924 n2066 VSS VSS nmos W=0.135u L=0.04u
M23868 n1924 n2066 VDD VDD pmos W=0.205u L=0.04u
M23869 U2704/net28 U2704/net20 U2704/net64 VSS nmos W=0.155u L=0.04u
M23870 U2704/net24 U2704/net30 U2704/net32 VSS nmos W=0.155u L=0.04u
M23871 U2704/net28 U2704/net40 U2704/net24 VSS nmos W=0.155u L=0.04u
M23872 U2704/net40 n2067 U2704/net108 VSS nmos W=0.155u L=0.04u
M23873 U2704/net40 U2704/net106 U2704/net104 VSS nmos W=0.155u L=0.04u
M23874 U2704/net24 WX4674 U2704/net050 VSS nmos W=0.155u L=0.04u
M23875 U2704/net050 U2704/net32 VSS VSS nmos W=0.155u L=0.04u
M23876 U2704/net20 U2704/net40 VSS VSS nmos W=0.155u L=0.04u
M23877 U2704/net106 n2067 VSS VSS nmos W=0.155u L=0.04u
M23878 U2704/net104 WX4738 VSS VSS nmos W=0.155u L=0.04u
M23879 U2704/net30 WX4674 VSS VSS nmos W=0.155u L=0.04u
M23880 U2704/net108 U2704/net104 VSS VSS nmos W=0.155u L=0.04u
M23881 n2066 U2704/net28 VSS VSS nmos W=0.155u L=0.04u
M23882 U2704/net32 WX4610 VSS VSS nmos W=0.155u L=0.04u
M23883 U2704/net64 U2704/net24 VSS VSS nmos W=0.2u L=0.04u
M23884 U2704/net28 U2704/net40 U2704/net64 VDD pmos W=0.205u L=0.04u
M23885 U2704/net24 WX4674 U2704/net32 VDD pmos W=0.205u L=0.04u
M23886 U2704/net28 U2704/net20 U2704/net24 VDD pmos W=0.205u L=0.04u
M23887 U2704/net40 U2704/net106 U2704/net108 VDD pmos W=0.205u L=0.04u
M23888 U2704/net40 n2067 U2704/net104 VDD pmos W=0.205u L=0.04u
M23889 U2704/net20 U2704/net40 VDD VDD pmos W=0.205u L=0.04u
M23890 U2704/net106 n2067 VDD VDD pmos W=0.205u L=0.04u
M23891 U2704/net104 WX4738 VDD VDD pmos W=0.205u L=0.04u
M23892 U2704/net30 WX4674 VDD VDD pmos W=0.205u L=0.04u
M23893 U2704/net108 U2704/net104 VDD VDD pmos W=0.205u L=0.04u
M23894 n2066 U2704/net28 VDD VDD pmos W=0.205u L=0.04u
M23895 U2704/net32 WX4610 VDD VDD pmos W=0.205u L=0.04u
M23896 U2704/net64 U2704/net24 VDD VDD pmos W=0.28u L=0.04u
M23897 U2704/net24 U2704/net30 U2704/net045 VDD pmos W=0.205u L=0.04u
M23898 U2704/net045 U2704/net32 VDD VDD pmos W=0.205u L=0.04u
M23899 U2705/net4 WX4546 U2705/net14 VSS nmos W=0.155u L=0.04u
M23900 U2705/net6 U2705/net10 U2705/net14 VSS nmos W=0.17u L=0.04u
M23901 U2705/net4 n1373 VSS VSS nmos W=0.155u L=0.04u
M23902 U2705/net6 U2705/net4 VSS VSS nmos W=0.17u L=0.04u
M23903 n2067 U2705/net14 VSS VSS nmos W=0.155u L=0.04u
M23904 U2705/net10 WX4546 VSS VSS nmos W=0.155u L=0.04u
M23905 U2705/net4 U2705/net10 U2705/net14 VDD pmos W=0.255u L=0.04u
M23906 U2705/net6 WX4546 U2705/net14 VDD pmos W=0.28u L=0.04u
M23907 U2705/net4 n1373 VDD VDD pmos W=0.205u L=0.04u
M23908 U2705/net6 U2705/net4 VDD VDD pmos W=0.24u L=0.04u
M23909 n2067 U2705/net14 VDD VDD pmos W=0.205u L=0.04u
M23910 U2705/net10 WX4546 VDD VDD pmos W=0.205u L=0.04u
M23911 WX2764 n1283 U2706/net26 VSS nmos W=0.155u L=0.04u
M23912 WX2764 n1928 U2706/net26 VSS nmos W=0.155u L=0.04u
M23913 U2706/net29 n2069 VSS VSS nmos W=0.155u L=0.04u
M23914 U2706/net26 n2068 U2706/net29 VSS nmos W=0.155u L=0.04u
M23915 U2706/net26 n1254 U2706/net29 VSS nmos W=0.155u L=0.04u
M23916 WX2764 n1928 U2706/net43 VDD pmos W=0.205u L=0.04u
M23917 WX2764 n1254 U2706/net49 VDD pmos W=0.205u L=0.04u
M23918 U2706/net49 n2068 VDD VDD pmos W=0.205u L=0.04u
M23919 U2706/net43 n1283 VDD VDD pmos W=0.205u L=0.04u
M23920 WX2764 n2069 VDD VDD pmos W=0.205u L=0.04u
M23921 U2707/net29 n1350 VSS VSS nmos W=0.155u L=0.04u
M23922 n2069 WX3091 U2707/net29 VSS nmos W=0.155u L=0.04u
M23923 n2069 n1316 U2707/net23 VSS nmos W=0.155u L=0.04u
M23924 U2707/net23 CRC_OUT_7_21 VSS VSS nmos W=0.155u L=0.04u
M23925 U2707/net20 CRC_OUT_7_21 n2069 VDD pmos W=0.205u L=0.04u
M23926 U2707/net20 n1316 n2069 VDD pmos W=0.205u L=0.04u
M23927 VDD WX3091 U2707/net20 VDD pmos W=0.205u L=0.04u
M23928 VDD n1350 U2707/net20 VDD pmos W=0.205u L=0.04u
M23929 n1928 n2070 VSS VSS nmos W=0.135u L=0.04u
M23930 n1928 n2070 VDD VDD pmos W=0.205u L=0.04u
M23931 U2709/net28 U2709/net20 U2709/net64 VSS nmos W=0.155u L=0.04u
M23932 U2709/net24 U2709/net30 U2709/net32 VSS nmos W=0.155u L=0.04u
M23933 U2709/net28 U2709/net40 U2709/net24 VSS nmos W=0.155u L=0.04u
M23934 U2709/net40 n2071 U2709/net108 VSS nmos W=0.155u L=0.04u
M23935 U2709/net40 U2709/net106 U2709/net104 VSS nmos W=0.155u L=0.04u
M23936 U2709/net24 WX4672 U2709/net050 VSS nmos W=0.155u L=0.04u
M23937 U2709/net050 U2709/net32 VSS VSS nmos W=0.155u L=0.04u
M23938 U2709/net20 U2709/net40 VSS VSS nmos W=0.155u L=0.04u
M23939 U2709/net106 n2071 VSS VSS nmos W=0.155u L=0.04u
M23940 U2709/net104 WX4736 VSS VSS nmos W=0.155u L=0.04u
M23941 U2709/net30 WX4672 VSS VSS nmos W=0.155u L=0.04u
M23942 U2709/net108 U2709/net104 VSS VSS nmos W=0.155u L=0.04u
M23943 n2070 U2709/net28 VSS VSS nmos W=0.155u L=0.04u
M23944 U2709/net32 WX4608 VSS VSS nmos W=0.155u L=0.04u
M23945 U2709/net64 U2709/net24 VSS VSS nmos W=0.2u L=0.04u
M23946 U2709/net28 U2709/net40 U2709/net64 VDD pmos W=0.205u L=0.04u
M23947 U2709/net24 WX4672 U2709/net32 VDD pmos W=0.205u L=0.04u
M23948 U2709/net28 U2709/net20 U2709/net24 VDD pmos W=0.205u L=0.04u
M23949 U2709/net40 U2709/net106 U2709/net108 VDD pmos W=0.205u L=0.04u
M23950 U2709/net40 n2071 U2709/net104 VDD pmos W=0.205u L=0.04u
M23951 U2709/net20 U2709/net40 VDD VDD pmos W=0.205u L=0.04u
M23952 U2709/net106 n2071 VDD VDD pmos W=0.205u L=0.04u
M23953 U2709/net104 WX4736 VDD VDD pmos W=0.205u L=0.04u
M23954 U2709/net30 WX4672 VDD VDD pmos W=0.205u L=0.04u
M23955 U2709/net108 U2709/net104 VDD VDD pmos W=0.205u L=0.04u
M23956 n2070 U2709/net28 VDD VDD pmos W=0.205u L=0.04u
M23957 U2709/net32 WX4608 VDD VDD pmos W=0.205u L=0.04u
M23958 U2709/net64 U2709/net24 VDD VDD pmos W=0.28u L=0.04u
M23959 U2709/net24 U2709/net30 U2709/net045 VDD pmos W=0.205u L=0.04u
M23960 U2709/net045 U2709/net32 VDD VDD pmos W=0.205u L=0.04u
M23961 U2710/net4 WX4544 U2710/net14 VSS nmos W=0.155u L=0.04u
M23962 U2710/net6 U2710/net10 U2710/net14 VSS nmos W=0.17u L=0.04u
M23963 U2710/net4 n1373 VSS VSS nmos W=0.155u L=0.04u
M23964 U2710/net6 U2710/net4 VSS VSS nmos W=0.17u L=0.04u
M23965 n2071 U2710/net14 VSS VSS nmos W=0.155u L=0.04u
M23966 U2710/net10 WX4544 VSS VSS nmos W=0.155u L=0.04u
M23967 U2710/net4 U2710/net10 U2710/net14 VDD pmos W=0.255u L=0.04u
M23968 U2710/net6 WX4544 U2710/net14 VDD pmos W=0.28u L=0.04u
M23969 U2710/net4 n1373 VDD VDD pmos W=0.205u L=0.04u
M23970 U2710/net6 U2710/net4 VDD VDD pmos W=0.24u L=0.04u
M23971 n2071 U2710/net14 VDD VDD pmos W=0.205u L=0.04u
M23972 U2710/net10 WX4544 VDD VDD pmos W=0.205u L=0.04u
M23973 WX276 n1283 U2711/net26 VSS nmos W=0.155u L=0.04u
M23974 WX276 n2072 U2711/net26 VSS nmos W=0.155u L=0.04u
M23975 U2711/net29 n2074 VSS VSS nmos W=0.155u L=0.04u
M23976 U2711/net26 n2073 U2711/net29 VSS nmos W=0.155u L=0.04u
M23977 U2711/net26 n1254 U2711/net29 VSS nmos W=0.155u L=0.04u
M23978 WX276 n2072 U2711/net43 VDD pmos W=0.205u L=0.04u
M23979 WX276 n1254 U2711/net49 VDD pmos W=0.205u L=0.04u
M23980 U2711/net49 n2073 VDD VDD pmos W=0.205u L=0.04u
M23981 U2711/net43 n1283 VDD VDD pmos W=0.205u L=0.04u
M23982 WX276 n2074 VDD VDD pmos W=0.205u L=0.04u
M23983 U2712/net29 n1349 VSS VSS nmos W=0.155u L=0.04u
M23984 n2074 WX519 U2712/net29 VSS nmos W=0.155u L=0.04u
M23985 n2074 n1316 U2712/net23 VSS nmos W=0.155u L=0.04u
M23986 U2712/net23 CRC_OUT_9_14 VSS VSS nmos W=0.155u L=0.04u
M23987 U2712/net20 CRC_OUT_9_14 n2074 VDD pmos W=0.205u L=0.04u
M23988 U2712/net20 n1316 n2074 VDD pmos W=0.205u L=0.04u
M23989 VDD WX519 U2712/net20 VDD pmos W=0.205u L=0.04u
M23990 VDD n1349 U2712/net20 VDD pmos W=0.205u L=0.04u
M23991 WX2750 n1282 U2713/net26 VSS nmos W=0.155u L=0.04u
M23992 WX2750 n1932 U2713/net26 VSS nmos W=0.155u L=0.04u
M23993 U2713/net29 n2076 VSS VSS nmos W=0.155u L=0.04u
M23994 U2713/net26 n2075 U2713/net29 VSS nmos W=0.155u L=0.04u
M23995 U2713/net26 n1254 U2713/net29 VSS nmos W=0.155u L=0.04u
M23996 WX2750 n1932 U2713/net43 VDD pmos W=0.205u L=0.04u
M23997 WX2750 n1254 U2713/net49 VDD pmos W=0.205u L=0.04u
M23998 U2713/net49 n2075 VDD VDD pmos W=0.205u L=0.04u
M23999 U2713/net43 n1282 VDD VDD pmos W=0.205u L=0.04u
M24000 WX2750 n2076 VDD VDD pmos W=0.205u L=0.04u
M24001 U2714/net29 n1349 VSS VSS nmos W=0.155u L=0.04u
M24002 n2076 WX3089 U2714/net29 VSS nmos W=0.155u L=0.04u
M24003 n2076 n1316 U2714/net23 VSS nmos W=0.155u L=0.04u
M24004 U2714/net23 CRC_OUT_7_22 VSS VSS nmos W=0.155u L=0.04u
M24005 U2714/net20 CRC_OUT_7_22 n2076 VDD pmos W=0.205u L=0.04u
M24006 U2714/net20 n1316 n2076 VDD pmos W=0.205u L=0.04u
M24007 VDD WX3089 U2714/net20 VDD pmos W=0.205u L=0.04u
M24008 VDD n1349 U2714/net20 VDD pmos W=0.205u L=0.04u
M24009 n1932 n2077 VSS VSS nmos W=0.135u L=0.04u
M24010 n1932 n2077 VDD VDD pmos W=0.205u L=0.04u
M24011 U2716/net28 U2716/net20 U2716/net64 VSS nmos W=0.155u L=0.04u
M24012 U2716/net24 U2716/net30 U2716/net32 VSS nmos W=0.155u L=0.04u
M24013 U2716/net28 U2716/net40 U2716/net24 VSS nmos W=0.155u L=0.04u
M24014 U2716/net40 n2078 U2716/net108 VSS nmos W=0.155u L=0.04u
M24015 U2716/net40 U2716/net106 U2716/net104 VSS nmos W=0.155u L=0.04u
M24016 U2716/net24 WX4670 U2716/net050 VSS nmos W=0.155u L=0.04u
M24017 U2716/net050 U2716/net32 VSS VSS nmos W=0.155u L=0.04u
M24018 U2716/net20 U2716/net40 VSS VSS nmos W=0.155u L=0.04u
M24019 U2716/net106 n2078 VSS VSS nmos W=0.155u L=0.04u
M24020 U2716/net104 WX4734 VSS VSS nmos W=0.155u L=0.04u
M24021 U2716/net30 WX4670 VSS VSS nmos W=0.155u L=0.04u
M24022 U2716/net108 U2716/net104 VSS VSS nmos W=0.155u L=0.04u
M24023 n2077 U2716/net28 VSS VSS nmos W=0.155u L=0.04u
M24024 U2716/net32 WX4606 VSS VSS nmos W=0.155u L=0.04u
M24025 U2716/net64 U2716/net24 VSS VSS nmos W=0.2u L=0.04u
M24026 U2716/net28 U2716/net40 U2716/net64 VDD pmos W=0.205u L=0.04u
M24027 U2716/net24 WX4670 U2716/net32 VDD pmos W=0.205u L=0.04u
M24028 U2716/net28 U2716/net20 U2716/net24 VDD pmos W=0.205u L=0.04u
M24029 U2716/net40 U2716/net106 U2716/net108 VDD pmos W=0.205u L=0.04u
M24030 U2716/net40 n2078 U2716/net104 VDD pmos W=0.205u L=0.04u
M24031 U2716/net20 U2716/net40 VDD VDD pmos W=0.205u L=0.04u
M24032 U2716/net106 n2078 VDD VDD pmos W=0.205u L=0.04u
M24033 U2716/net104 WX4734 VDD VDD pmos W=0.205u L=0.04u
M24034 U2716/net30 WX4670 VDD VDD pmos W=0.205u L=0.04u
M24035 U2716/net108 U2716/net104 VDD VDD pmos W=0.205u L=0.04u
M24036 n2077 U2716/net28 VDD VDD pmos W=0.205u L=0.04u
M24037 U2716/net32 WX4606 VDD VDD pmos W=0.205u L=0.04u
M24038 U2716/net64 U2716/net24 VDD VDD pmos W=0.28u L=0.04u
M24039 U2716/net24 U2716/net30 U2716/net045 VDD pmos W=0.205u L=0.04u
M24040 U2716/net045 U2716/net32 VDD VDD pmos W=0.205u L=0.04u
M24041 U2717/net4 WX4542 U2717/net14 VSS nmos W=0.155u L=0.04u
M24042 U2717/net6 U2717/net10 U2717/net14 VSS nmos W=0.17u L=0.04u
M24043 U2717/net4 n1373 VSS VSS nmos W=0.155u L=0.04u
M24044 U2717/net6 U2717/net4 VSS VSS nmos W=0.17u L=0.04u
M24045 n2078 U2717/net14 VSS VSS nmos W=0.155u L=0.04u
M24046 U2717/net10 WX4542 VSS VSS nmos W=0.155u L=0.04u
M24047 U2717/net4 U2717/net10 U2717/net14 VDD pmos W=0.255u L=0.04u
M24048 U2717/net6 WX4542 U2717/net14 VDD pmos W=0.28u L=0.04u
M24049 U2717/net4 n1373 VDD VDD pmos W=0.205u L=0.04u
M24050 U2717/net6 U2717/net4 VDD VDD pmos W=0.24u L=0.04u
M24051 n2078 U2717/net14 VDD VDD pmos W=0.205u L=0.04u
M24052 U2717/net10 WX4542 VDD VDD pmos W=0.205u L=0.04u
M24053 WX2736 n1282 U2718/net26 VSS nmos W=0.155u L=0.04u
M24054 WX2736 n1936 U2718/net26 VSS nmos W=0.155u L=0.04u
M24055 U2718/net29 n2080 VSS VSS nmos W=0.155u L=0.04u
M24056 U2718/net26 n2079 U2718/net29 VSS nmos W=0.155u L=0.04u
M24057 U2718/net26 n1254 U2718/net29 VSS nmos W=0.155u L=0.04u
M24058 WX2736 n1936 U2718/net43 VDD pmos W=0.205u L=0.04u
M24059 WX2736 n1254 U2718/net49 VDD pmos W=0.205u L=0.04u
M24060 U2718/net49 n2079 VDD VDD pmos W=0.205u L=0.04u
M24061 U2718/net43 n1282 VDD VDD pmos W=0.205u L=0.04u
M24062 WX2736 n2080 VDD VDD pmos W=0.205u L=0.04u
M24063 U2719/net29 n1349 VSS VSS nmos W=0.155u L=0.04u
M24064 n2080 WX3087 U2719/net29 VSS nmos W=0.155u L=0.04u
M24065 n2080 n1316 U2719/net23 VSS nmos W=0.155u L=0.04u
M24066 U2719/net23 CRC_OUT_7_23 VSS VSS nmos W=0.155u L=0.04u
M24067 U2719/net20 CRC_OUT_7_23 n2080 VDD pmos W=0.205u L=0.04u
M24068 U2719/net20 n1316 n2080 VDD pmos W=0.205u L=0.04u
M24069 VDD WX3087 U2719/net20 VDD pmos W=0.205u L=0.04u
M24070 VDD n1349 U2719/net20 VDD pmos W=0.205u L=0.04u
M24071 n1936 n2081 VSS VSS nmos W=0.135u L=0.04u
M24072 n1936 n2081 VDD VDD pmos W=0.205u L=0.04u
M24073 U2721/net28 U2721/net20 U2721/net64 VSS nmos W=0.155u L=0.04u
M24074 U2721/net24 U2721/net30 U2721/net32 VSS nmos W=0.155u L=0.04u
M24075 U2721/net28 U2721/net40 U2721/net24 VSS nmos W=0.155u L=0.04u
M24076 U2721/net40 n2082 U2721/net108 VSS nmos W=0.155u L=0.04u
M24077 U2721/net40 U2721/net106 U2721/net104 VSS nmos W=0.155u L=0.04u
M24078 U2721/net24 WX4668 U2721/net050 VSS nmos W=0.155u L=0.04u
M24079 U2721/net050 U2721/net32 VSS VSS nmos W=0.155u L=0.04u
M24080 U2721/net20 U2721/net40 VSS VSS nmos W=0.155u L=0.04u
M24081 U2721/net106 n2082 VSS VSS nmos W=0.155u L=0.04u
M24082 U2721/net104 WX4732 VSS VSS nmos W=0.155u L=0.04u
M24083 U2721/net30 WX4668 VSS VSS nmos W=0.155u L=0.04u
M24084 U2721/net108 U2721/net104 VSS VSS nmos W=0.155u L=0.04u
M24085 n2081 U2721/net28 VSS VSS nmos W=0.155u L=0.04u
M24086 U2721/net32 WX4604 VSS VSS nmos W=0.155u L=0.04u
M24087 U2721/net64 U2721/net24 VSS VSS nmos W=0.2u L=0.04u
M24088 U2721/net28 U2721/net40 U2721/net64 VDD pmos W=0.205u L=0.04u
M24089 U2721/net24 WX4668 U2721/net32 VDD pmos W=0.205u L=0.04u
M24090 U2721/net28 U2721/net20 U2721/net24 VDD pmos W=0.205u L=0.04u
M24091 U2721/net40 U2721/net106 U2721/net108 VDD pmos W=0.205u L=0.04u
M24092 U2721/net40 n2082 U2721/net104 VDD pmos W=0.205u L=0.04u
M24093 U2721/net20 U2721/net40 VDD VDD pmos W=0.205u L=0.04u
M24094 U2721/net106 n2082 VDD VDD pmos W=0.205u L=0.04u
M24095 U2721/net104 WX4732 VDD VDD pmos W=0.205u L=0.04u
M24096 U2721/net30 WX4668 VDD VDD pmos W=0.205u L=0.04u
M24097 U2721/net108 U2721/net104 VDD VDD pmos W=0.205u L=0.04u
M24098 n2081 U2721/net28 VDD VDD pmos W=0.205u L=0.04u
M24099 U2721/net32 WX4604 VDD VDD pmos W=0.205u L=0.04u
M24100 U2721/net64 U2721/net24 VDD VDD pmos W=0.28u L=0.04u
M24101 U2721/net24 U2721/net30 U2721/net045 VDD pmos W=0.205u L=0.04u
M24102 U2721/net045 U2721/net32 VDD VDD pmos W=0.205u L=0.04u
M24103 U2722/net4 WX4540 U2722/net14 VSS nmos W=0.155u L=0.04u
M24104 U2722/net6 U2722/net10 U2722/net14 VSS nmos W=0.17u L=0.04u
M24105 U2722/net4 n1373 VSS VSS nmos W=0.155u L=0.04u
M24106 U2722/net6 U2722/net4 VSS VSS nmos W=0.17u L=0.04u
M24107 n2082 U2722/net14 VSS VSS nmos W=0.155u L=0.04u
M24108 U2722/net10 WX4540 VSS VSS nmos W=0.155u L=0.04u
M24109 U2722/net4 U2722/net10 U2722/net14 VDD pmos W=0.255u L=0.04u
M24110 U2722/net6 WX4540 U2722/net14 VDD pmos W=0.28u L=0.04u
M24111 U2722/net4 n1373 VDD VDD pmos W=0.205u L=0.04u
M24112 U2722/net6 U2722/net4 VDD VDD pmos W=0.24u L=0.04u
M24113 n2082 U2722/net14 VDD VDD pmos W=0.205u L=0.04u
M24114 U2722/net10 WX4540 VDD VDD pmos W=0.205u L=0.04u
M24115 WX2722 n1282 U2723/net26 VSS nmos W=0.155u L=0.04u
M24116 WX2722 n1943 U2723/net26 VSS nmos W=0.155u L=0.04u
M24117 U2723/net29 n2084 VSS VSS nmos W=0.155u L=0.04u
M24118 U2723/net26 n2083 U2723/net29 VSS nmos W=0.155u L=0.04u
M24119 U2723/net26 n1254 U2723/net29 VSS nmos W=0.155u L=0.04u
M24120 WX2722 n1943 U2723/net43 VDD pmos W=0.205u L=0.04u
M24121 WX2722 n1254 U2723/net49 VDD pmos W=0.205u L=0.04u
M24122 U2723/net49 n2083 VDD VDD pmos W=0.205u L=0.04u
M24123 U2723/net43 n1282 VDD VDD pmos W=0.205u L=0.04u
M24124 WX2722 n2084 VDD VDD pmos W=0.205u L=0.04u
M24125 U2724/net29 n1349 VSS VSS nmos W=0.155u L=0.04u
M24126 n2084 WX3085 U2724/net29 VSS nmos W=0.155u L=0.04u
M24127 n2084 n1316 U2724/net23 VSS nmos W=0.155u L=0.04u
M24128 U2724/net23 CRC_OUT_7_24 VSS VSS nmos W=0.155u L=0.04u
M24129 U2724/net20 CRC_OUT_7_24 n2084 VDD pmos W=0.205u L=0.04u
M24130 U2724/net20 n1316 n2084 VDD pmos W=0.205u L=0.04u
M24131 VDD WX3085 U2724/net20 VDD pmos W=0.205u L=0.04u
M24132 VDD n1349 U2724/net20 VDD pmos W=0.205u L=0.04u
M24133 n1943 n2085 VSS VSS nmos W=0.135u L=0.04u
M24134 n1943 n2085 VDD VDD pmos W=0.205u L=0.04u
M24135 U2726/net28 U2726/net20 U2726/net64 VSS nmos W=0.155u L=0.04u
M24136 U2726/net24 U2726/net30 U2726/net32 VSS nmos W=0.155u L=0.04u
M24137 U2726/net28 U2726/net40 U2726/net24 VSS nmos W=0.155u L=0.04u
M24138 U2726/net40 n2086 U2726/net108 VSS nmos W=0.155u L=0.04u
M24139 U2726/net40 U2726/net106 U2726/net104 VSS nmos W=0.155u L=0.04u
M24140 U2726/net24 WX4666 U2726/net050 VSS nmos W=0.155u L=0.04u
M24141 U2726/net050 U2726/net32 VSS VSS nmos W=0.155u L=0.04u
M24142 U2726/net20 U2726/net40 VSS VSS nmos W=0.155u L=0.04u
M24143 U2726/net106 n2086 VSS VSS nmos W=0.155u L=0.04u
M24144 U2726/net104 WX4730 VSS VSS nmos W=0.155u L=0.04u
M24145 U2726/net30 WX4666 VSS VSS nmos W=0.155u L=0.04u
M24146 U2726/net108 U2726/net104 VSS VSS nmos W=0.155u L=0.04u
M24147 n2085 U2726/net28 VSS VSS nmos W=0.155u L=0.04u
M24148 U2726/net32 WX4602 VSS VSS nmos W=0.155u L=0.04u
M24149 U2726/net64 U2726/net24 VSS VSS nmos W=0.2u L=0.04u
M24150 U2726/net28 U2726/net40 U2726/net64 VDD pmos W=0.205u L=0.04u
M24151 U2726/net24 WX4666 U2726/net32 VDD pmos W=0.205u L=0.04u
M24152 U2726/net28 U2726/net20 U2726/net24 VDD pmos W=0.205u L=0.04u
M24153 U2726/net40 U2726/net106 U2726/net108 VDD pmos W=0.205u L=0.04u
M24154 U2726/net40 n2086 U2726/net104 VDD pmos W=0.205u L=0.04u
M24155 U2726/net20 U2726/net40 VDD VDD pmos W=0.205u L=0.04u
M24156 U2726/net106 n2086 VDD VDD pmos W=0.205u L=0.04u
M24157 U2726/net104 WX4730 VDD VDD pmos W=0.205u L=0.04u
M24158 U2726/net30 WX4666 VDD VDD pmos W=0.205u L=0.04u
M24159 U2726/net108 U2726/net104 VDD VDD pmos W=0.205u L=0.04u
M24160 n2085 U2726/net28 VDD VDD pmos W=0.205u L=0.04u
M24161 U2726/net32 WX4602 VDD VDD pmos W=0.205u L=0.04u
M24162 U2726/net64 U2726/net24 VDD VDD pmos W=0.28u L=0.04u
M24163 U2726/net24 U2726/net30 U2726/net045 VDD pmos W=0.205u L=0.04u
M24164 U2726/net045 U2726/net32 VDD VDD pmos W=0.205u L=0.04u
M24165 U2727/net4 WX4538 U2727/net14 VSS nmos W=0.155u L=0.04u
M24166 U2727/net6 U2727/net10 U2727/net14 VSS nmos W=0.17u L=0.04u
M24167 U2727/net4 n1374 VSS VSS nmos W=0.155u L=0.04u
M24168 U2727/net6 U2727/net4 VSS VSS nmos W=0.17u L=0.04u
M24169 n2086 U2727/net14 VSS VSS nmos W=0.155u L=0.04u
M24170 U2727/net10 WX4538 VSS VSS nmos W=0.155u L=0.04u
M24171 U2727/net4 U2727/net10 U2727/net14 VDD pmos W=0.255u L=0.04u
M24172 U2727/net6 WX4538 U2727/net14 VDD pmos W=0.28u L=0.04u
M24173 U2727/net4 n1374 VDD VDD pmos W=0.205u L=0.04u
M24174 U2727/net6 U2727/net4 VDD VDD pmos W=0.24u L=0.04u
M24175 n2086 U2727/net14 VDD VDD pmos W=0.205u L=0.04u
M24176 U2727/net10 WX4538 VDD VDD pmos W=0.205u L=0.04u
M24177 WX2708 n1282 U2728/net26 VSS nmos W=0.155u L=0.04u
M24178 WX2708 n1947 U2728/net26 VSS nmos W=0.155u L=0.04u
M24179 U2728/net29 n2088 VSS VSS nmos W=0.155u L=0.04u
M24180 U2728/net26 n2087 U2728/net29 VSS nmos W=0.155u L=0.04u
M24181 U2728/net26 n1254 U2728/net29 VSS nmos W=0.155u L=0.04u
M24182 WX2708 n1947 U2728/net43 VDD pmos W=0.205u L=0.04u
M24183 WX2708 n1254 U2728/net49 VDD pmos W=0.205u L=0.04u
M24184 U2728/net49 n2087 VDD VDD pmos W=0.205u L=0.04u
M24185 U2728/net43 n1282 VDD VDD pmos W=0.205u L=0.04u
M24186 WX2708 n2088 VDD VDD pmos W=0.205u L=0.04u
M24187 U2729/net29 n1349 VSS VSS nmos W=0.155u L=0.04u
M24188 n2088 WX3083 U2729/net29 VSS nmos W=0.155u L=0.04u
M24189 n2088 n1316 U2729/net23 VSS nmos W=0.155u L=0.04u
M24190 U2729/net23 CRC_OUT_7_25 VSS VSS nmos W=0.155u L=0.04u
M24191 U2729/net20 CRC_OUT_7_25 n2088 VDD pmos W=0.205u L=0.04u
M24192 U2729/net20 n1316 n2088 VDD pmos W=0.205u L=0.04u
M24193 VDD WX3083 U2729/net20 VDD pmos W=0.205u L=0.04u
M24194 VDD n1349 U2729/net20 VDD pmos W=0.205u L=0.04u
M24195 n1947 n2089 VSS VSS nmos W=0.135u L=0.04u
M24196 n1947 n2089 VDD VDD pmos W=0.205u L=0.04u
M24197 U2731/net28 U2731/net20 U2731/net64 VSS nmos W=0.155u L=0.04u
M24198 U2731/net24 U2731/net30 U2731/net32 VSS nmos W=0.155u L=0.04u
M24199 U2731/net28 U2731/net40 U2731/net24 VSS nmos W=0.155u L=0.04u
M24200 U2731/net40 n2090 U2731/net108 VSS nmos W=0.155u L=0.04u
M24201 U2731/net40 U2731/net106 U2731/net104 VSS nmos W=0.155u L=0.04u
M24202 U2731/net24 WX4664 U2731/net050 VSS nmos W=0.155u L=0.04u
M24203 U2731/net050 U2731/net32 VSS VSS nmos W=0.155u L=0.04u
M24204 U2731/net20 U2731/net40 VSS VSS nmos W=0.155u L=0.04u
M24205 U2731/net106 n2090 VSS VSS nmos W=0.155u L=0.04u
M24206 U2731/net104 WX4728 VSS VSS nmos W=0.155u L=0.04u
M24207 U2731/net30 WX4664 VSS VSS nmos W=0.155u L=0.04u
M24208 U2731/net108 U2731/net104 VSS VSS nmos W=0.155u L=0.04u
M24209 n2089 U2731/net28 VSS VSS nmos W=0.155u L=0.04u
M24210 U2731/net32 WX4600 VSS VSS nmos W=0.155u L=0.04u
M24211 U2731/net64 U2731/net24 VSS VSS nmos W=0.2u L=0.04u
M24212 U2731/net28 U2731/net40 U2731/net64 VDD pmos W=0.205u L=0.04u
M24213 U2731/net24 WX4664 U2731/net32 VDD pmos W=0.205u L=0.04u
M24214 U2731/net28 U2731/net20 U2731/net24 VDD pmos W=0.205u L=0.04u
M24215 U2731/net40 U2731/net106 U2731/net108 VDD pmos W=0.205u L=0.04u
M24216 U2731/net40 n2090 U2731/net104 VDD pmos W=0.205u L=0.04u
M24217 U2731/net20 U2731/net40 VDD VDD pmos W=0.205u L=0.04u
M24218 U2731/net106 n2090 VDD VDD pmos W=0.205u L=0.04u
M24219 U2731/net104 WX4728 VDD VDD pmos W=0.205u L=0.04u
M24220 U2731/net30 WX4664 VDD VDD pmos W=0.205u L=0.04u
M24221 U2731/net108 U2731/net104 VDD VDD pmos W=0.205u L=0.04u
M24222 n2089 U2731/net28 VDD VDD pmos W=0.205u L=0.04u
M24223 U2731/net32 WX4600 VDD VDD pmos W=0.205u L=0.04u
M24224 U2731/net64 U2731/net24 VDD VDD pmos W=0.28u L=0.04u
M24225 U2731/net24 U2731/net30 U2731/net045 VDD pmos W=0.205u L=0.04u
M24226 U2731/net045 U2731/net32 VDD VDD pmos W=0.205u L=0.04u
M24227 U2732/net4 WX4536 U2732/net14 VSS nmos W=0.155u L=0.04u
M24228 U2732/net6 U2732/net10 U2732/net14 VSS nmos W=0.17u L=0.04u
M24229 U2732/net4 n1374 VSS VSS nmos W=0.155u L=0.04u
M24230 U2732/net6 U2732/net4 VSS VSS nmos W=0.17u L=0.04u
M24231 n2090 U2732/net14 VSS VSS nmos W=0.155u L=0.04u
M24232 U2732/net10 WX4536 VSS VSS nmos W=0.155u L=0.04u
M24233 U2732/net4 U2732/net10 U2732/net14 VDD pmos W=0.255u L=0.04u
M24234 U2732/net6 WX4536 U2732/net14 VDD pmos W=0.28u L=0.04u
M24235 U2732/net4 n1374 VDD VDD pmos W=0.205u L=0.04u
M24236 U2732/net6 U2732/net4 VDD VDD pmos W=0.24u L=0.04u
M24237 n2090 U2732/net14 VDD VDD pmos W=0.205u L=0.04u
M24238 U2732/net10 WX4536 VDD VDD pmos W=0.205u L=0.04u
M24239 WX2694 n1282 U2733/net26 VSS nmos W=0.155u L=0.04u
M24240 WX2694 n1951 U2733/net26 VSS nmos W=0.155u L=0.04u
M24241 U2733/net29 n2092 VSS VSS nmos W=0.155u L=0.04u
M24242 U2733/net26 n2091 U2733/net29 VSS nmos W=0.155u L=0.04u
M24243 U2733/net26 n1254 U2733/net29 VSS nmos W=0.155u L=0.04u
M24244 WX2694 n1951 U2733/net43 VDD pmos W=0.205u L=0.04u
M24245 WX2694 n1254 U2733/net49 VDD pmos W=0.205u L=0.04u
M24246 U2733/net49 n2091 VDD VDD pmos W=0.205u L=0.04u
M24247 U2733/net43 n1282 VDD VDD pmos W=0.205u L=0.04u
M24248 WX2694 n2092 VDD VDD pmos W=0.205u L=0.04u
M24249 U2734/net29 n1349 VSS VSS nmos W=0.155u L=0.04u
M24250 n2092 WX3081 U2734/net29 VSS nmos W=0.155u L=0.04u
M24251 n2092 n1316 U2734/net23 VSS nmos W=0.155u L=0.04u
M24252 U2734/net23 CRC_OUT_7_26 VSS VSS nmos W=0.155u L=0.04u
M24253 U2734/net20 CRC_OUT_7_26 n2092 VDD pmos W=0.205u L=0.04u
M24254 U2734/net20 n1316 n2092 VDD pmos W=0.205u L=0.04u
M24255 VDD WX3081 U2734/net20 VDD pmos W=0.205u L=0.04u
M24256 VDD n1349 U2734/net20 VDD pmos W=0.205u L=0.04u
M24257 n1951 n2093 VSS VSS nmos W=0.135u L=0.04u
M24258 n1951 n2093 VDD VDD pmos W=0.205u L=0.04u
M24259 U2736/net28 U2736/net20 U2736/net64 VSS nmos W=0.155u L=0.04u
M24260 U2736/net24 U2736/net30 U2736/net32 VSS nmos W=0.155u L=0.04u
M24261 U2736/net28 U2736/net40 U2736/net24 VSS nmos W=0.155u L=0.04u
M24262 U2736/net40 n2094 U2736/net108 VSS nmos W=0.155u L=0.04u
M24263 U2736/net40 U2736/net106 U2736/net104 VSS nmos W=0.155u L=0.04u
M24264 U2736/net24 WX4662 U2736/net050 VSS nmos W=0.155u L=0.04u
M24265 U2736/net050 U2736/net32 VSS VSS nmos W=0.155u L=0.04u
M24266 U2736/net20 U2736/net40 VSS VSS nmos W=0.155u L=0.04u
M24267 U2736/net106 n2094 VSS VSS nmos W=0.155u L=0.04u
M24268 U2736/net104 WX4726 VSS VSS nmos W=0.155u L=0.04u
M24269 U2736/net30 WX4662 VSS VSS nmos W=0.155u L=0.04u
M24270 U2736/net108 U2736/net104 VSS VSS nmos W=0.155u L=0.04u
M24271 n2093 U2736/net28 VSS VSS nmos W=0.155u L=0.04u
M24272 U2736/net32 WX4598 VSS VSS nmos W=0.155u L=0.04u
M24273 U2736/net64 U2736/net24 VSS VSS nmos W=0.2u L=0.04u
M24274 U2736/net28 U2736/net40 U2736/net64 VDD pmos W=0.205u L=0.04u
M24275 U2736/net24 WX4662 U2736/net32 VDD pmos W=0.205u L=0.04u
M24276 U2736/net28 U2736/net20 U2736/net24 VDD pmos W=0.205u L=0.04u
M24277 U2736/net40 U2736/net106 U2736/net108 VDD pmos W=0.205u L=0.04u
M24278 U2736/net40 n2094 U2736/net104 VDD pmos W=0.205u L=0.04u
M24279 U2736/net20 U2736/net40 VDD VDD pmos W=0.205u L=0.04u
M24280 U2736/net106 n2094 VDD VDD pmos W=0.205u L=0.04u
M24281 U2736/net104 WX4726 VDD VDD pmos W=0.205u L=0.04u
M24282 U2736/net30 WX4662 VDD VDD pmos W=0.205u L=0.04u
M24283 U2736/net108 U2736/net104 VDD VDD pmos W=0.205u L=0.04u
M24284 n2093 U2736/net28 VDD VDD pmos W=0.205u L=0.04u
M24285 U2736/net32 WX4598 VDD VDD pmos W=0.205u L=0.04u
M24286 U2736/net64 U2736/net24 VDD VDD pmos W=0.28u L=0.04u
M24287 U2736/net24 U2736/net30 U2736/net045 VDD pmos W=0.205u L=0.04u
M24288 U2736/net045 U2736/net32 VDD VDD pmos W=0.205u L=0.04u
M24289 U2737/net4 WX4534 U2737/net14 VSS nmos W=0.155u L=0.04u
M24290 U2737/net6 U2737/net10 U2737/net14 VSS nmos W=0.17u L=0.04u
M24291 U2737/net4 n1374 VSS VSS nmos W=0.155u L=0.04u
M24292 U2737/net6 U2737/net4 VSS VSS nmos W=0.17u L=0.04u
M24293 n2094 U2737/net14 VSS VSS nmos W=0.155u L=0.04u
M24294 U2737/net10 WX4534 VSS VSS nmos W=0.155u L=0.04u
M24295 U2737/net4 U2737/net10 U2737/net14 VDD pmos W=0.255u L=0.04u
M24296 U2737/net6 WX4534 U2737/net14 VDD pmos W=0.28u L=0.04u
M24297 U2737/net4 n1374 VDD VDD pmos W=0.205u L=0.04u
M24298 U2737/net6 U2737/net4 VDD VDD pmos W=0.24u L=0.04u
M24299 n2094 U2737/net14 VDD VDD pmos W=0.205u L=0.04u
M24300 U2737/net10 WX4534 VDD VDD pmos W=0.205u L=0.04u
M24301 WX2680 n1282 U2738/net26 VSS nmos W=0.155u L=0.04u
M24302 WX2680 n1955 U2738/net26 VSS nmos W=0.155u L=0.04u
M24303 U2738/net29 n2096 VSS VSS nmos W=0.155u L=0.04u
M24304 U2738/net26 n2095 U2738/net29 VSS nmos W=0.155u L=0.04u
M24305 U2738/net26 n1254 U2738/net29 VSS nmos W=0.155u L=0.04u
M24306 WX2680 n1955 U2738/net43 VDD pmos W=0.205u L=0.04u
M24307 WX2680 n1254 U2738/net49 VDD pmos W=0.205u L=0.04u
M24308 U2738/net49 n2095 VDD VDD pmos W=0.205u L=0.04u
M24309 U2738/net43 n1282 VDD VDD pmos W=0.205u L=0.04u
M24310 WX2680 n2096 VDD VDD pmos W=0.205u L=0.04u
M24311 U2739/net29 n1349 VSS VSS nmos W=0.155u L=0.04u
M24312 n2096 WX3079 U2739/net29 VSS nmos W=0.155u L=0.04u
M24313 n2096 n1316 U2739/net23 VSS nmos W=0.155u L=0.04u
M24314 U2739/net23 CRC_OUT_7_27 VSS VSS nmos W=0.155u L=0.04u
M24315 U2739/net20 CRC_OUT_7_27 n2096 VDD pmos W=0.205u L=0.04u
M24316 U2739/net20 n1316 n2096 VDD pmos W=0.205u L=0.04u
M24317 VDD WX3079 U2739/net20 VDD pmos W=0.205u L=0.04u
M24318 VDD n1349 U2739/net20 VDD pmos W=0.205u L=0.04u
M24319 n1955 n2097 VSS VSS nmos W=0.135u L=0.04u
M24320 n1955 n2097 VDD VDD pmos W=0.205u L=0.04u
M24321 U2741/net28 U2741/net20 U2741/net64 VSS nmos W=0.155u L=0.04u
M24322 U2741/net24 U2741/net30 U2741/net32 VSS nmos W=0.155u L=0.04u
M24323 U2741/net28 U2741/net40 U2741/net24 VSS nmos W=0.155u L=0.04u
M24324 U2741/net40 n2098 U2741/net108 VSS nmos W=0.155u L=0.04u
M24325 U2741/net40 U2741/net106 U2741/net104 VSS nmos W=0.155u L=0.04u
M24326 U2741/net24 WX4660 U2741/net050 VSS nmos W=0.155u L=0.04u
M24327 U2741/net050 U2741/net32 VSS VSS nmos W=0.155u L=0.04u
M24328 U2741/net20 U2741/net40 VSS VSS nmos W=0.155u L=0.04u
M24329 U2741/net106 n2098 VSS VSS nmos W=0.155u L=0.04u
M24330 U2741/net104 WX4724 VSS VSS nmos W=0.155u L=0.04u
M24331 U2741/net30 WX4660 VSS VSS nmos W=0.155u L=0.04u
M24332 U2741/net108 U2741/net104 VSS VSS nmos W=0.155u L=0.04u
M24333 n2097 U2741/net28 VSS VSS nmos W=0.155u L=0.04u
M24334 U2741/net32 WX4596 VSS VSS nmos W=0.155u L=0.04u
M24335 U2741/net64 U2741/net24 VSS VSS nmos W=0.2u L=0.04u
M24336 U2741/net28 U2741/net40 U2741/net64 VDD pmos W=0.205u L=0.04u
M24337 U2741/net24 WX4660 U2741/net32 VDD pmos W=0.205u L=0.04u
M24338 U2741/net28 U2741/net20 U2741/net24 VDD pmos W=0.205u L=0.04u
M24339 U2741/net40 U2741/net106 U2741/net108 VDD pmos W=0.205u L=0.04u
M24340 U2741/net40 n2098 U2741/net104 VDD pmos W=0.205u L=0.04u
M24341 U2741/net20 U2741/net40 VDD VDD pmos W=0.205u L=0.04u
M24342 U2741/net106 n2098 VDD VDD pmos W=0.205u L=0.04u
M24343 U2741/net104 WX4724 VDD VDD pmos W=0.205u L=0.04u
M24344 U2741/net30 WX4660 VDD VDD pmos W=0.205u L=0.04u
M24345 U2741/net108 U2741/net104 VDD VDD pmos W=0.205u L=0.04u
M24346 n2097 U2741/net28 VDD VDD pmos W=0.205u L=0.04u
M24347 U2741/net32 WX4596 VDD VDD pmos W=0.205u L=0.04u
M24348 U2741/net64 U2741/net24 VDD VDD pmos W=0.28u L=0.04u
M24349 U2741/net24 U2741/net30 U2741/net045 VDD pmos W=0.205u L=0.04u
M24350 U2741/net045 U2741/net32 VDD VDD pmos W=0.205u L=0.04u
M24351 U2742/net4 WX4532 U2742/net14 VSS nmos W=0.155u L=0.04u
M24352 U2742/net6 U2742/net10 U2742/net14 VSS nmos W=0.17u L=0.04u
M24353 U2742/net4 n1374 VSS VSS nmos W=0.155u L=0.04u
M24354 U2742/net6 U2742/net4 VSS VSS nmos W=0.17u L=0.04u
M24355 n2098 U2742/net14 VSS VSS nmos W=0.155u L=0.04u
M24356 U2742/net10 WX4532 VSS VSS nmos W=0.155u L=0.04u
M24357 U2742/net4 U2742/net10 U2742/net14 VDD pmos W=0.255u L=0.04u
M24358 U2742/net6 WX4532 U2742/net14 VDD pmos W=0.28u L=0.04u
M24359 U2742/net4 n1374 VDD VDD pmos W=0.205u L=0.04u
M24360 U2742/net6 U2742/net4 VDD VDD pmos W=0.24u L=0.04u
M24361 n2098 U2742/net14 VDD VDD pmos W=0.205u L=0.04u
M24362 U2742/net10 WX4532 VDD VDD pmos W=0.205u L=0.04u
M24363 WX2666 n1282 U2743/net26 VSS nmos W=0.155u L=0.04u
M24364 WX2666 n1959 U2743/net26 VSS nmos W=0.155u L=0.04u
M24365 U2743/net29 n2100 VSS VSS nmos W=0.155u L=0.04u
M24366 U2743/net26 n2099 U2743/net29 VSS nmos W=0.155u L=0.04u
M24367 U2743/net26 n1254 U2743/net29 VSS nmos W=0.155u L=0.04u
M24368 WX2666 n1959 U2743/net43 VDD pmos W=0.205u L=0.04u
M24369 WX2666 n1254 U2743/net49 VDD pmos W=0.205u L=0.04u
M24370 U2743/net49 n2099 VDD VDD pmos W=0.205u L=0.04u
M24371 U2743/net43 n1282 VDD VDD pmos W=0.205u L=0.04u
M24372 WX2666 n2100 VDD VDD pmos W=0.205u L=0.04u
M24373 U2744/net29 n1349 VSS VSS nmos W=0.155u L=0.04u
M24374 n2100 WX3077 U2744/net29 VSS nmos W=0.155u L=0.04u
M24375 n2100 n1316 U2744/net23 VSS nmos W=0.155u L=0.04u
M24376 U2744/net23 CRC_OUT_7_28 VSS VSS nmos W=0.155u L=0.04u
M24377 U2744/net20 CRC_OUT_7_28 n2100 VDD pmos W=0.205u L=0.04u
M24378 U2744/net20 n1316 n2100 VDD pmos W=0.205u L=0.04u
M24379 VDD WX3077 U2744/net20 VDD pmos W=0.205u L=0.04u
M24380 VDD n1349 U2744/net20 VDD pmos W=0.205u L=0.04u
M24381 n1959 n2101 VSS VSS nmos W=0.135u L=0.04u
M24382 n1959 n2101 VDD VDD pmos W=0.205u L=0.04u
M24383 U2746/net28 U2746/net20 U2746/net64 VSS nmos W=0.155u L=0.04u
M24384 U2746/net24 U2746/net30 U2746/net32 VSS nmos W=0.155u L=0.04u
M24385 U2746/net28 U2746/net40 U2746/net24 VSS nmos W=0.155u L=0.04u
M24386 U2746/net40 n2102 U2746/net108 VSS nmos W=0.155u L=0.04u
M24387 U2746/net40 U2746/net106 U2746/net104 VSS nmos W=0.155u L=0.04u
M24388 U2746/net24 WX4658 U2746/net050 VSS nmos W=0.155u L=0.04u
M24389 U2746/net050 U2746/net32 VSS VSS nmos W=0.155u L=0.04u
M24390 U2746/net20 U2746/net40 VSS VSS nmos W=0.155u L=0.04u
M24391 U2746/net106 n2102 VSS VSS nmos W=0.155u L=0.04u
M24392 U2746/net104 WX4722 VSS VSS nmos W=0.155u L=0.04u
M24393 U2746/net30 WX4658 VSS VSS nmos W=0.155u L=0.04u
M24394 U2746/net108 U2746/net104 VSS VSS nmos W=0.155u L=0.04u
M24395 n2101 U2746/net28 VSS VSS nmos W=0.155u L=0.04u
M24396 U2746/net32 WX4594 VSS VSS nmos W=0.155u L=0.04u
M24397 U2746/net64 U2746/net24 VSS VSS nmos W=0.2u L=0.04u
M24398 U2746/net28 U2746/net40 U2746/net64 VDD pmos W=0.205u L=0.04u
M24399 U2746/net24 WX4658 U2746/net32 VDD pmos W=0.205u L=0.04u
M24400 U2746/net28 U2746/net20 U2746/net24 VDD pmos W=0.205u L=0.04u
M24401 U2746/net40 U2746/net106 U2746/net108 VDD pmos W=0.205u L=0.04u
M24402 U2746/net40 n2102 U2746/net104 VDD pmos W=0.205u L=0.04u
M24403 U2746/net20 U2746/net40 VDD VDD pmos W=0.205u L=0.04u
M24404 U2746/net106 n2102 VDD VDD pmos W=0.205u L=0.04u
M24405 U2746/net104 WX4722 VDD VDD pmos W=0.205u L=0.04u
M24406 U2746/net30 WX4658 VDD VDD pmos W=0.205u L=0.04u
M24407 U2746/net108 U2746/net104 VDD VDD pmos W=0.205u L=0.04u
M24408 n2101 U2746/net28 VDD VDD pmos W=0.205u L=0.04u
M24409 U2746/net32 WX4594 VDD VDD pmos W=0.205u L=0.04u
M24410 U2746/net64 U2746/net24 VDD VDD pmos W=0.28u L=0.04u
M24411 U2746/net24 U2746/net30 U2746/net045 VDD pmos W=0.205u L=0.04u
M24412 U2746/net045 U2746/net32 VDD VDD pmos W=0.205u L=0.04u
M24413 U2747/net4 WX4530 U2747/net14 VSS nmos W=0.155u L=0.04u
M24414 U2747/net6 U2747/net10 U2747/net14 VSS nmos W=0.17u L=0.04u
M24415 U2747/net4 n1374 VSS VSS nmos W=0.155u L=0.04u
M24416 U2747/net6 U2747/net4 VSS VSS nmos W=0.17u L=0.04u
M24417 n2102 U2747/net14 VSS VSS nmos W=0.155u L=0.04u
M24418 U2747/net10 WX4530 VSS VSS nmos W=0.155u L=0.04u
M24419 U2747/net4 U2747/net10 U2747/net14 VDD pmos W=0.255u L=0.04u
M24420 U2747/net6 WX4530 U2747/net14 VDD pmos W=0.28u L=0.04u
M24421 U2747/net4 n1374 VDD VDD pmos W=0.205u L=0.04u
M24422 U2747/net6 U2747/net4 VDD VDD pmos W=0.24u L=0.04u
M24423 n2102 U2747/net14 VDD VDD pmos W=0.205u L=0.04u
M24424 U2747/net10 WX4530 VDD VDD pmos W=0.205u L=0.04u
M24425 WX2652 n1282 U2748/net26 VSS nmos W=0.155u L=0.04u
M24426 WX2652 n1963 U2748/net26 VSS nmos W=0.155u L=0.04u
M24427 U2748/net29 n2104 VSS VSS nmos W=0.155u L=0.04u
M24428 U2748/net26 n2103 U2748/net29 VSS nmos W=0.155u L=0.04u
M24429 U2748/net26 n1254 U2748/net29 VSS nmos W=0.155u L=0.04u
M24430 WX2652 n1963 U2748/net43 VDD pmos W=0.205u L=0.04u
M24431 WX2652 n1254 U2748/net49 VDD pmos W=0.205u L=0.04u
M24432 U2748/net49 n2103 VDD VDD pmos W=0.205u L=0.04u
M24433 U2748/net43 n1282 VDD VDD pmos W=0.205u L=0.04u
M24434 WX2652 n2104 VDD VDD pmos W=0.205u L=0.04u
M24435 U2749/net29 n1349 VSS VSS nmos W=0.155u L=0.04u
M24436 n2104 WX3075 U2749/net29 VSS nmos W=0.155u L=0.04u
M24437 n2104 n1316 U2749/net23 VSS nmos W=0.155u L=0.04u
M24438 U2749/net23 CRC_OUT_7_29 VSS VSS nmos W=0.155u L=0.04u
M24439 U2749/net20 CRC_OUT_7_29 n2104 VDD pmos W=0.205u L=0.04u
M24440 U2749/net20 n1316 n2104 VDD pmos W=0.205u L=0.04u
M24441 VDD WX3075 U2749/net20 VDD pmos W=0.205u L=0.04u
M24442 VDD n1349 U2749/net20 VDD pmos W=0.205u L=0.04u
M24443 n1963 n2105 VSS VSS nmos W=0.135u L=0.04u
M24444 n1963 n2105 VDD VDD pmos W=0.205u L=0.04u
M24445 U2751/net28 U2751/net20 U2751/net64 VSS nmos W=0.155u L=0.04u
M24446 U2751/net24 U2751/net30 U2751/net32 VSS nmos W=0.155u L=0.04u
M24447 U2751/net28 U2751/net40 U2751/net24 VSS nmos W=0.155u L=0.04u
M24448 U2751/net40 n2106 U2751/net108 VSS nmos W=0.155u L=0.04u
M24449 U2751/net40 U2751/net106 U2751/net104 VSS nmos W=0.155u L=0.04u
M24450 U2751/net24 WX4656 U2751/net050 VSS nmos W=0.155u L=0.04u
M24451 U2751/net050 U2751/net32 VSS VSS nmos W=0.155u L=0.04u
M24452 U2751/net20 U2751/net40 VSS VSS nmos W=0.155u L=0.04u
M24453 U2751/net106 n2106 VSS VSS nmos W=0.155u L=0.04u
M24454 U2751/net104 WX4720 VSS VSS nmos W=0.155u L=0.04u
M24455 U2751/net30 WX4656 VSS VSS nmos W=0.155u L=0.04u
M24456 U2751/net108 U2751/net104 VSS VSS nmos W=0.155u L=0.04u
M24457 n2105 U2751/net28 VSS VSS nmos W=0.155u L=0.04u
M24458 U2751/net32 WX4592 VSS VSS nmos W=0.155u L=0.04u
M24459 U2751/net64 U2751/net24 VSS VSS nmos W=0.2u L=0.04u
M24460 U2751/net28 U2751/net40 U2751/net64 VDD pmos W=0.205u L=0.04u
M24461 U2751/net24 WX4656 U2751/net32 VDD pmos W=0.205u L=0.04u
M24462 U2751/net28 U2751/net20 U2751/net24 VDD pmos W=0.205u L=0.04u
M24463 U2751/net40 U2751/net106 U2751/net108 VDD pmos W=0.205u L=0.04u
M24464 U2751/net40 n2106 U2751/net104 VDD pmos W=0.205u L=0.04u
M24465 U2751/net20 U2751/net40 VDD VDD pmos W=0.205u L=0.04u
M24466 U2751/net106 n2106 VDD VDD pmos W=0.205u L=0.04u
M24467 U2751/net104 WX4720 VDD VDD pmos W=0.205u L=0.04u
M24468 U2751/net30 WX4656 VDD VDD pmos W=0.205u L=0.04u
M24469 U2751/net108 U2751/net104 VDD VDD pmos W=0.205u L=0.04u
M24470 n2105 U2751/net28 VDD VDD pmos W=0.205u L=0.04u
M24471 U2751/net32 WX4592 VDD VDD pmos W=0.205u L=0.04u
M24472 U2751/net64 U2751/net24 VDD VDD pmos W=0.28u L=0.04u
M24473 U2751/net24 U2751/net30 U2751/net045 VDD pmos W=0.205u L=0.04u
M24474 U2751/net045 U2751/net32 VDD VDD pmos W=0.205u L=0.04u
M24475 U2752/net4 WX4528 U2752/net14 VSS nmos W=0.155u L=0.04u
M24476 U2752/net6 U2752/net10 U2752/net14 VSS nmos W=0.17u L=0.04u
M24477 U2752/net4 n1374 VSS VSS nmos W=0.155u L=0.04u
M24478 U2752/net6 U2752/net4 VSS VSS nmos W=0.17u L=0.04u
M24479 n2106 U2752/net14 VSS VSS nmos W=0.155u L=0.04u
M24480 U2752/net10 WX4528 VSS VSS nmos W=0.155u L=0.04u
M24481 U2752/net4 U2752/net10 U2752/net14 VDD pmos W=0.255u L=0.04u
M24482 U2752/net6 WX4528 U2752/net14 VDD pmos W=0.28u L=0.04u
M24483 U2752/net4 n1374 VDD VDD pmos W=0.205u L=0.04u
M24484 U2752/net6 U2752/net4 VDD VDD pmos W=0.24u L=0.04u
M24485 n2106 U2752/net14 VDD VDD pmos W=0.205u L=0.04u
M24486 U2752/net10 WX4528 VDD VDD pmos W=0.205u L=0.04u
M24487 WX2638 n1282 U2753/net26 VSS nmos W=0.155u L=0.04u
M24488 WX2638 n1967 U2753/net26 VSS nmos W=0.155u L=0.04u
M24489 U2753/net29 n2108 VSS VSS nmos W=0.155u L=0.04u
M24490 U2753/net26 n2107 U2753/net29 VSS nmos W=0.155u L=0.04u
M24491 U2753/net26 n1254 U2753/net29 VSS nmos W=0.155u L=0.04u
M24492 WX2638 n1967 U2753/net43 VDD pmos W=0.205u L=0.04u
M24493 WX2638 n1254 U2753/net49 VDD pmos W=0.205u L=0.04u
M24494 U2753/net49 n2107 VDD VDD pmos W=0.205u L=0.04u
M24495 U2753/net43 n1282 VDD VDD pmos W=0.205u L=0.04u
M24496 WX2638 n2108 VDD VDD pmos W=0.205u L=0.04u
M24497 U2754/net29 n1349 VSS VSS nmos W=0.155u L=0.04u
M24498 n2108 WX3073 U2754/net29 VSS nmos W=0.155u L=0.04u
M24499 n2108 n1316 U2754/net23 VSS nmos W=0.155u L=0.04u
M24500 U2754/net23 CRC_OUT_7_30 VSS VSS nmos W=0.155u L=0.04u
M24501 U2754/net20 CRC_OUT_7_30 n2108 VDD pmos W=0.205u L=0.04u
M24502 U2754/net20 n1316 n2108 VDD pmos W=0.205u L=0.04u
M24503 VDD WX3073 U2754/net20 VDD pmos W=0.205u L=0.04u
M24504 VDD n1349 U2754/net20 VDD pmos W=0.205u L=0.04u
M24505 n1967 n2109 VSS VSS nmos W=0.135u L=0.04u
M24506 n1967 n2109 VDD VDD pmos W=0.205u L=0.04u
M24507 U2756/net28 U2756/net20 U2756/net64 VSS nmos W=0.155u L=0.04u
M24508 U2756/net24 U2756/net30 U2756/net32 VSS nmos W=0.155u L=0.04u
M24509 U2756/net28 U2756/net40 U2756/net24 VSS nmos W=0.155u L=0.04u
M24510 U2756/net40 n2110 U2756/net108 VSS nmos W=0.155u L=0.04u
M24511 U2756/net40 U2756/net106 U2756/net104 VSS nmos W=0.155u L=0.04u
M24512 U2756/net24 WX4654 U2756/net050 VSS nmos W=0.155u L=0.04u
M24513 U2756/net050 U2756/net32 VSS VSS nmos W=0.155u L=0.04u
M24514 U2756/net20 U2756/net40 VSS VSS nmos W=0.155u L=0.04u
M24515 U2756/net106 n2110 VSS VSS nmos W=0.155u L=0.04u
M24516 U2756/net104 WX4718 VSS VSS nmos W=0.155u L=0.04u
M24517 U2756/net30 WX4654 VSS VSS nmos W=0.155u L=0.04u
M24518 U2756/net108 U2756/net104 VSS VSS nmos W=0.155u L=0.04u
M24519 n2109 U2756/net28 VSS VSS nmos W=0.155u L=0.04u
M24520 U2756/net32 WX4590 VSS VSS nmos W=0.155u L=0.04u
M24521 U2756/net64 U2756/net24 VSS VSS nmos W=0.2u L=0.04u
M24522 U2756/net28 U2756/net40 U2756/net64 VDD pmos W=0.205u L=0.04u
M24523 U2756/net24 WX4654 U2756/net32 VDD pmos W=0.205u L=0.04u
M24524 U2756/net28 U2756/net20 U2756/net24 VDD pmos W=0.205u L=0.04u
M24525 U2756/net40 U2756/net106 U2756/net108 VDD pmos W=0.205u L=0.04u
M24526 U2756/net40 n2110 U2756/net104 VDD pmos W=0.205u L=0.04u
M24527 U2756/net20 U2756/net40 VDD VDD pmos W=0.205u L=0.04u
M24528 U2756/net106 n2110 VDD VDD pmos W=0.205u L=0.04u
M24529 U2756/net104 WX4718 VDD VDD pmos W=0.205u L=0.04u
M24530 U2756/net30 WX4654 VDD VDD pmos W=0.205u L=0.04u
M24531 U2756/net108 U2756/net104 VDD VDD pmos W=0.205u L=0.04u
M24532 n2109 U2756/net28 VDD VDD pmos W=0.205u L=0.04u
M24533 U2756/net32 WX4590 VDD VDD pmos W=0.205u L=0.04u
M24534 U2756/net64 U2756/net24 VDD VDD pmos W=0.28u L=0.04u
M24535 U2756/net24 U2756/net30 U2756/net045 VDD pmos W=0.205u L=0.04u
M24536 U2756/net045 U2756/net32 VDD VDD pmos W=0.205u L=0.04u
M24537 U2757/net4 WX4526 U2757/net14 VSS nmos W=0.155u L=0.04u
M24538 U2757/net6 U2757/net10 U2757/net14 VSS nmos W=0.17u L=0.04u
M24539 U2757/net4 n1374 VSS VSS nmos W=0.155u L=0.04u
M24540 U2757/net6 U2757/net4 VSS VSS nmos W=0.17u L=0.04u
M24541 n2110 U2757/net14 VSS VSS nmos W=0.155u L=0.04u
M24542 U2757/net10 WX4526 VSS VSS nmos W=0.155u L=0.04u
M24543 U2757/net4 U2757/net10 U2757/net14 VDD pmos W=0.255u L=0.04u
M24544 U2757/net6 WX4526 U2757/net14 VDD pmos W=0.28u L=0.04u
M24545 U2757/net4 n1374 VDD VDD pmos W=0.205u L=0.04u
M24546 U2757/net6 U2757/net4 VDD VDD pmos W=0.24u L=0.04u
M24547 n2110 U2757/net14 VDD VDD pmos W=0.205u L=0.04u
M24548 U2757/net10 WX4526 VDD VDD pmos W=0.205u L=0.04u
M24549 WX2624 n1615 U2758/net26 VSS nmos W=0.155u L=0.04u
M24550 WX2624 n1394 U2758/net26 VSS nmos W=0.155u L=0.04u
M24551 U2758/net29 n2111 VSS VSS nmos W=0.155u L=0.04u
M24552 U2758/net26 WX3069 U2758/net29 VSS nmos W=0.155u L=0.04u
M24553 U2758/net26 n1500 U2758/net29 VSS nmos W=0.155u L=0.04u
M24554 WX2624 n1394 U2758/net43 VDD pmos W=0.205u L=0.04u
M24555 WX2624 n1500 U2758/net49 VDD pmos W=0.205u L=0.04u
M24556 U2758/net49 WX3069 VDD VDD pmos W=0.205u L=0.04u
M24557 U2758/net43 n1615 VDD VDD pmos W=0.205u L=0.04u
M24558 WX2624 n2111 VDD VDD pmos W=0.205u L=0.04u
M24559 U2759/net29 n2112 VSS VSS nmos W=0.155u L=0.04u
M24560 n2111 n1430 U2759/net29 VSS nmos W=0.155u L=0.04u
M24561 n2111 n1617 U2759/net23 VSS nmos W=0.155u L=0.04u
M24562 U2759/net23 n1972 VSS VSS nmos W=0.155u L=0.04u
M24563 U2759/net20 n1972 n2111 VDD pmos W=0.205u L=0.04u
M24564 U2759/net20 n1617 n2111 VDD pmos W=0.205u L=0.04u
M24565 VDD n1430 U2759/net20 VDD pmos W=0.205u L=0.04u
M24566 VDD n2112 U2759/net20 VDD pmos W=0.205u L=0.04u
M24567 U2760/net28 U2760/net20 U2760/net64 VSS nmos W=0.155u L=0.04u
M24568 U2760/net24 U2760/net30 U2760/net32 VSS nmos W=0.155u L=0.04u
M24569 U2760/net28 U2760/net40 U2760/net24 VSS nmos W=0.155u L=0.04u
M24570 U2760/net40 n2113 U2760/net108 VSS nmos W=0.155u L=0.04u
M24571 U2760/net40 U2760/net106 U2760/net104 VSS nmos W=0.155u L=0.04u
M24572 U2760/net24 WX4652 U2760/net050 VSS nmos W=0.155u L=0.04u
M24573 U2760/net050 U2760/net32 VSS VSS nmos W=0.155u L=0.04u
M24574 U2760/net20 U2760/net40 VSS VSS nmos W=0.155u L=0.04u
M24575 U2760/net106 n2113 VSS VSS nmos W=0.155u L=0.04u
M24576 U2760/net104 WX4716 VSS VSS nmos W=0.155u L=0.04u
M24577 U2760/net30 WX4652 VSS VSS nmos W=0.155u L=0.04u
M24578 U2760/net108 U2760/net104 VSS VSS nmos W=0.155u L=0.04u
M24579 n1972 U2760/net28 VSS VSS nmos W=0.155u L=0.04u
M24580 U2760/net32 WX4588 VSS VSS nmos W=0.155u L=0.04u
M24581 U2760/net64 U2760/net24 VSS VSS nmos W=0.2u L=0.04u
M24582 U2760/net28 U2760/net40 U2760/net64 VDD pmos W=0.205u L=0.04u
M24583 U2760/net24 WX4652 U2760/net32 VDD pmos W=0.205u L=0.04u
M24584 U2760/net28 U2760/net20 U2760/net24 VDD pmos W=0.205u L=0.04u
M24585 U2760/net40 U2760/net106 U2760/net108 VDD pmos W=0.205u L=0.04u
M24586 U2760/net40 n2113 U2760/net104 VDD pmos W=0.205u L=0.04u
M24587 U2760/net20 U2760/net40 VDD VDD pmos W=0.205u L=0.04u
M24588 U2760/net106 n2113 VDD VDD pmos W=0.205u L=0.04u
M24589 U2760/net104 WX4716 VDD VDD pmos W=0.205u L=0.04u
M24590 U2760/net30 WX4652 VDD VDD pmos W=0.205u L=0.04u
M24591 U2760/net108 U2760/net104 VDD VDD pmos W=0.205u L=0.04u
M24592 n1972 U2760/net28 VDD VDD pmos W=0.205u L=0.04u
M24593 U2760/net32 WX4588 VDD VDD pmos W=0.205u L=0.04u
M24594 U2760/net64 U2760/net24 VDD VDD pmos W=0.28u L=0.04u
M24595 U2760/net24 U2760/net30 U2760/net045 VDD pmos W=0.205u L=0.04u
M24596 U2760/net045 U2760/net32 VDD VDD pmos W=0.205u L=0.04u
M24597 U2761/net4 WX4524 U2761/net14 VSS nmos W=0.155u L=0.04u
M24598 U2761/net6 U2761/net10 U2761/net14 VSS nmos W=0.17u L=0.04u
M24599 U2761/net4 n1374 VSS VSS nmos W=0.155u L=0.04u
M24600 U2761/net6 U2761/net4 VSS VSS nmos W=0.17u L=0.04u
M24601 n2113 U2761/net14 VSS VSS nmos W=0.155u L=0.04u
M24602 U2761/net10 WX4524 VSS VSS nmos W=0.155u L=0.04u
M24603 U2761/net4 U2761/net10 U2761/net14 VDD pmos W=0.255u L=0.04u
M24604 U2761/net6 WX4524 U2761/net14 VDD pmos W=0.28u L=0.04u
M24605 U2761/net4 n1374 VDD VDD pmos W=0.205u L=0.04u
M24606 U2761/net6 U2761/net4 VDD VDD pmos W=0.24u L=0.04u
M24607 n2113 U2761/net14 VDD VDD pmos W=0.205u L=0.04u
M24608 U2761/net10 WX4524 VDD VDD pmos W=0.205u L=0.04u
M24609 WX3069 WX3071 VSS VSS nmos W=0.135u L=0.04u
M24610 WX3069 WX3071 VDD VDD pmos W=0.205u L=0.04u
M24611 n1394 CRC_OUT_7_31 VSS VSS nmos W=0.135u L=0.04u
M24612 n1394 CRC_OUT_7_31 VDD VDD pmos W=0.205u L=0.04u
M24613 WX262 n1282 U2764/net26 VSS nmos W=0.155u L=0.04u
M24614 WX262 n2114 U2764/net26 VSS nmos W=0.155u L=0.04u
M24615 U2764/net29 n2116 VSS VSS nmos W=0.155u L=0.04u
M24616 U2764/net26 n2115 U2764/net29 VSS nmos W=0.155u L=0.04u
M24617 U2764/net26 n1254 U2764/net29 VSS nmos W=0.155u L=0.04u
M24618 WX262 n2114 U2764/net43 VDD pmos W=0.205u L=0.04u
M24619 WX262 n1254 U2764/net49 VDD pmos W=0.205u L=0.04u
M24620 U2764/net49 n2115 VDD VDD pmos W=0.205u L=0.04u
M24621 U2764/net43 n1282 VDD VDD pmos W=0.205u L=0.04u
M24622 WX262 n2116 VDD VDD pmos W=0.205u L=0.04u
M24623 U2765/net29 n1349 VSS VSS nmos W=0.155u L=0.04u
M24624 n2116 WX517 U2765/net29 VSS nmos W=0.155u L=0.04u
M24625 n2116 n1315 U2765/net23 VSS nmos W=0.155u L=0.04u
M24626 U2765/net23 CRC_OUT_9_15 VSS VSS nmos W=0.155u L=0.04u
M24627 U2765/net20 CRC_OUT_9_15 n2116 VDD pmos W=0.205u L=0.04u
M24628 U2765/net20 n1315 n2116 VDD pmos W=0.205u L=0.04u
M24629 VDD WX517 U2765/net20 VDD pmos W=0.205u L=0.04u
M24630 VDD n1349 U2765/net20 VDD pmos W=0.205u L=0.04u
M24631 WX248 n1282 U2766/net26 VSS nmos W=0.155u L=0.04u
M24632 WX248 n2117 U2766/net26 VSS nmos W=0.155u L=0.04u
M24633 U2766/net29 n2119 VSS VSS nmos W=0.155u L=0.04u
M24634 U2766/net26 n2118 U2766/net29 VSS nmos W=0.155u L=0.04u
M24635 U2766/net26 n1253 U2766/net29 VSS nmos W=0.155u L=0.04u
M24636 WX248 n2117 U2766/net43 VDD pmos W=0.205u L=0.04u
M24637 WX248 n1253 U2766/net49 VDD pmos W=0.205u L=0.04u
M24638 U2766/net49 n2118 VDD VDD pmos W=0.205u L=0.04u
M24639 U2766/net43 n1282 VDD VDD pmos W=0.205u L=0.04u
M24640 WX248 n2119 VDD VDD pmos W=0.205u L=0.04u
M24641 U2767/net29 n1349 VSS VSS nmos W=0.155u L=0.04u
M24642 n2119 WX515 U2767/net29 VSS nmos W=0.155u L=0.04u
M24643 n2119 n1315 U2767/net23 VSS nmos W=0.155u L=0.04u
M24644 U2767/net23 CRC_OUT_9_16 VSS VSS nmos W=0.155u L=0.04u
M24645 U2767/net20 CRC_OUT_9_16 n2119 VDD pmos W=0.205u L=0.04u
M24646 U2767/net20 n1315 n2119 VDD pmos W=0.205u L=0.04u
M24647 VDD WX515 U2767/net20 VDD pmos W=0.205u L=0.04u
M24648 VDD n1349 U2767/net20 VDD pmos W=0.205u L=0.04u
M24649 WX234 n1282 U2768/net26 VSS nmos W=0.155u L=0.04u
M24650 WX234 n2120 U2768/net26 VSS nmos W=0.155u L=0.04u
M24651 U2768/net29 n2122 VSS VSS nmos W=0.155u L=0.04u
M24652 U2768/net26 n2121 U2768/net29 VSS nmos W=0.155u L=0.04u
M24653 U2768/net26 n1253 U2768/net29 VSS nmos W=0.155u L=0.04u
M24654 WX234 n2120 U2768/net43 VDD pmos W=0.205u L=0.04u
M24655 WX234 n1253 U2768/net49 VDD pmos W=0.205u L=0.04u
M24656 U2768/net49 n2121 VDD VDD pmos W=0.205u L=0.04u
M24657 U2768/net43 n1282 VDD VDD pmos W=0.205u L=0.04u
M24658 WX234 n2122 VDD VDD pmos W=0.205u L=0.04u
M24659 U2769/net29 n1349 VSS VSS nmos W=0.155u L=0.04u
M24660 n2122 WX513 U2769/net29 VSS nmos W=0.155u L=0.04u
M24661 n2122 n1315 U2769/net23 VSS nmos W=0.155u L=0.04u
M24662 U2769/net23 CRC_OUT_9_17 VSS VSS nmos W=0.155u L=0.04u
M24663 U2769/net20 CRC_OUT_9_17 n2122 VDD pmos W=0.205u L=0.04u
M24664 U2769/net20 n1315 n2122 VDD pmos W=0.205u L=0.04u
M24665 VDD WX513 U2769/net20 VDD pmos W=0.205u L=0.04u
M24666 VDD n1349 U2769/net20 VDD pmos W=0.205u L=0.04u
M24667 WX220 n1282 U2770/net26 VSS nmos W=0.155u L=0.04u
M24668 WX220 n2123 U2770/net26 VSS nmos W=0.155u L=0.04u
M24669 U2770/net29 n2125 VSS VSS nmos W=0.155u L=0.04u
M24670 U2770/net26 n2124 U2770/net29 VSS nmos W=0.155u L=0.04u
M24671 U2770/net26 n1253 U2770/net29 VSS nmos W=0.155u L=0.04u
M24672 WX220 n2123 U2770/net43 VDD pmos W=0.205u L=0.04u
M24673 WX220 n1253 U2770/net49 VDD pmos W=0.205u L=0.04u
M24674 U2770/net49 n2124 VDD VDD pmos W=0.205u L=0.04u
M24675 U2770/net43 n1282 VDD VDD pmos W=0.205u L=0.04u
M24676 WX220 n2125 VDD VDD pmos W=0.205u L=0.04u
M24677 U2771/net29 n1348 VSS VSS nmos W=0.155u L=0.04u
M24678 n2125 WX511 U2771/net29 VSS nmos W=0.155u L=0.04u
M24679 n2125 n1315 U2771/net23 VSS nmos W=0.155u L=0.04u
M24680 U2771/net23 CRC_OUT_9_18 VSS VSS nmos W=0.155u L=0.04u
M24681 U2771/net20 CRC_OUT_9_18 n2125 VDD pmos W=0.205u L=0.04u
M24682 U2771/net20 n1315 n2125 VDD pmos W=0.205u L=0.04u
M24683 VDD WX511 U2771/net20 VDD pmos W=0.205u L=0.04u
M24684 VDD n1348 U2771/net20 VDD pmos W=0.205u L=0.04u
M24685 WX206 n1281 U2772/net26 VSS nmos W=0.155u L=0.04u
M24686 WX206 n2126 U2772/net26 VSS nmos W=0.155u L=0.04u
M24687 U2772/net29 n2128 VSS VSS nmos W=0.155u L=0.04u
M24688 U2772/net26 n2127 U2772/net29 VSS nmos W=0.155u L=0.04u
M24689 U2772/net26 n1253 U2772/net29 VSS nmos W=0.155u L=0.04u
M24690 WX206 n2126 U2772/net43 VDD pmos W=0.205u L=0.04u
M24691 WX206 n1253 U2772/net49 VDD pmos W=0.205u L=0.04u
M24692 U2772/net49 n2127 VDD VDD pmos W=0.205u L=0.04u
M24693 U2772/net43 n1281 VDD VDD pmos W=0.205u L=0.04u
M24694 WX206 n2128 VDD VDD pmos W=0.205u L=0.04u
M24695 U2773/net29 n1348 VSS VSS nmos W=0.155u L=0.04u
M24696 n2128 WX509 U2773/net29 VSS nmos W=0.155u L=0.04u
M24697 n2128 n1315 U2773/net23 VSS nmos W=0.155u L=0.04u
M24698 U2773/net23 CRC_OUT_9_19 VSS VSS nmos W=0.155u L=0.04u
M24699 U2773/net20 CRC_OUT_9_19 n2128 VDD pmos W=0.205u L=0.04u
M24700 U2773/net20 n1315 n2128 VDD pmos W=0.205u L=0.04u
M24701 VDD WX509 U2773/net20 VDD pmos W=0.205u L=0.04u
M24702 VDD n1348 U2773/net20 VDD pmos W=0.205u L=0.04u
M24703 WX192 n1281 U2774/net26 VSS nmos W=0.155u L=0.04u
M24704 WX192 n2129 U2774/net26 VSS nmos W=0.155u L=0.04u
M24705 U2774/net29 n2131 VSS VSS nmos W=0.155u L=0.04u
M24706 U2774/net26 n2130 U2774/net29 VSS nmos W=0.155u L=0.04u
M24707 U2774/net26 n1253 U2774/net29 VSS nmos W=0.155u L=0.04u
M24708 WX192 n2129 U2774/net43 VDD pmos W=0.205u L=0.04u
M24709 WX192 n1253 U2774/net49 VDD pmos W=0.205u L=0.04u
M24710 U2774/net49 n2130 VDD VDD pmos W=0.205u L=0.04u
M24711 U2774/net43 n1281 VDD VDD pmos W=0.205u L=0.04u
M24712 WX192 n2131 VDD VDD pmos W=0.205u L=0.04u
M24713 U2775/net29 n1348 VSS VSS nmos W=0.155u L=0.04u
M24714 n2131 WX507 U2775/net29 VSS nmos W=0.155u L=0.04u
M24715 n2131 n1315 U2775/net23 VSS nmos W=0.155u L=0.04u
M24716 U2775/net23 CRC_OUT_9_20 VSS VSS nmos W=0.155u L=0.04u
M24717 U2775/net20 CRC_OUT_9_20 n2131 VDD pmos W=0.205u L=0.04u
M24718 U2775/net20 n1315 n2131 VDD pmos W=0.205u L=0.04u
M24719 VDD WX507 U2775/net20 VDD pmos W=0.205u L=0.04u
M24720 VDD n1348 U2775/net20 VDD pmos W=0.205u L=0.04u
M24721 WX178 n1281 U2776/net26 VSS nmos W=0.155u L=0.04u
M24722 WX178 n2132 U2776/net26 VSS nmos W=0.155u L=0.04u
M24723 U2776/net29 n2134 VSS VSS nmos W=0.155u L=0.04u
M24724 U2776/net26 n2133 U2776/net29 VSS nmos W=0.155u L=0.04u
M24725 U2776/net26 n1253 U2776/net29 VSS nmos W=0.155u L=0.04u
M24726 WX178 n2132 U2776/net43 VDD pmos W=0.205u L=0.04u
M24727 WX178 n1253 U2776/net49 VDD pmos W=0.205u L=0.04u
M24728 U2776/net49 n2133 VDD VDD pmos W=0.205u L=0.04u
M24729 U2776/net43 n1281 VDD VDD pmos W=0.205u L=0.04u
M24730 WX178 n2134 VDD VDD pmos W=0.205u L=0.04u
M24731 U2777/net29 n1348 VSS VSS nmos W=0.155u L=0.04u
M24732 n2134 WX505 U2777/net29 VSS nmos W=0.155u L=0.04u
M24733 n2134 n1315 U2777/net23 VSS nmos W=0.155u L=0.04u
M24734 U2777/net23 CRC_OUT_9_21 VSS VSS nmos W=0.155u L=0.04u
M24735 U2777/net20 CRC_OUT_9_21 n2134 VDD pmos W=0.205u L=0.04u
M24736 U2777/net20 n1315 n2134 VDD pmos W=0.205u L=0.04u
M24737 VDD WX505 U2777/net20 VDD pmos W=0.205u L=0.04u
M24738 VDD n1348 U2777/net20 VDD pmos W=0.205u L=0.04u
M24739 WX1765 n1241 U2778/net26 VSS nmos W=0.155u L=0.04u
M24740 WX1765 n1846 U2778/net26 VSS nmos W=0.155u L=0.04u
M24741 U2778/net29 n2135 VSS VSS nmos W=0.155u L=0.04u
M24742 U2778/net26 n1995 U2778/net29 VSS nmos W=0.155u L=0.04u
M24743 U2778/net26 n1291 U2778/net29 VSS nmos W=0.155u L=0.04u
M24744 WX1765 n1846 U2778/net43 VDD pmos W=0.205u L=0.04u
M24745 WX1765 n1291 U2778/net49 VDD pmos W=0.205u L=0.04u
M24746 U2778/net49 n1995 VDD VDD pmos W=0.205u L=0.04u
M24747 U2778/net43 n1241 VDD VDD pmos W=0.205u L=0.04u
M24748 WX1765 n2135 VDD VDD pmos W=0.205u L=0.04u
M24749 U2779/net29 n1348 VSS VSS nmos W=0.155u L=0.04u
M24750 n2135 WX1840 U2779/net29 VSS nmos W=0.155u L=0.04u
M24751 n2135 n1315 U2779/net23 VSS nmos W=0.155u L=0.04u
M24752 U2779/net23 CRC_OUT_8_0 VSS VSS nmos W=0.155u L=0.04u
M24753 U2779/net20 CRC_OUT_8_0 n2135 VDD pmos W=0.205u L=0.04u
M24754 U2779/net20 n1315 n2135 VDD pmos W=0.205u L=0.04u
M24755 VDD WX1840 U2779/net20 VDD pmos W=0.205u L=0.04u
M24756 VDD n1348 U2779/net20 VDD pmos W=0.205u L=0.04u
M24757 U2780/net28 U2780/net20 U2780/net64 VSS nmos W=0.155u L=0.04u
M24758 U2780/net24 U2780/net30 U2780/net32 VSS nmos W=0.155u L=0.04u
M24759 U2780/net28 U2780/net40 U2780/net24 VSS nmos W=0.155u L=0.04u
M24760 U2780/net40 WX3421 U2780/net108 VSS nmos W=0.155u L=0.04u
M24761 U2780/net40 U2780/net106 U2780/net104 VSS nmos W=0.155u L=0.04u
M24762 U2780/net24 WX3357 U2780/net050 VSS nmos W=0.155u L=0.04u
M24763 U2780/net050 U2780/net32 VSS VSS nmos W=0.155u L=0.04u
M24764 U2780/net20 U2780/net40 VSS VSS nmos W=0.155u L=0.04u
M24765 U2780/net106 WX3421 VSS VSS nmos W=0.155u L=0.04u
M24766 U2780/net104 n1395 VSS VSS nmos W=0.155u L=0.04u
M24767 U2780/net30 WX3357 VSS VSS nmos W=0.155u L=0.04u
M24768 U2780/net108 U2780/net104 VSS VSS nmos W=0.155u L=0.04u
M24769 n1995 U2780/net28 VSS VSS nmos W=0.155u L=0.04u
M24770 U2780/net32 WX3293 VSS VSS nmos W=0.155u L=0.04u
M24771 U2780/net64 U2780/net24 VSS VSS nmos W=0.2u L=0.04u
M24772 U2780/net28 U2780/net40 U2780/net64 VDD pmos W=0.205u L=0.04u
M24773 U2780/net24 WX3357 U2780/net32 VDD pmos W=0.205u L=0.04u
M24774 U2780/net28 U2780/net20 U2780/net24 VDD pmos W=0.205u L=0.04u
M24775 U2780/net40 U2780/net106 U2780/net108 VDD pmos W=0.205u L=0.04u
M24776 U2780/net40 WX3421 U2780/net104 VDD pmos W=0.205u L=0.04u
M24777 U2780/net20 U2780/net40 VDD VDD pmos W=0.205u L=0.04u
M24778 U2780/net106 WX3421 VDD VDD pmos W=0.205u L=0.04u
M24779 U2780/net104 n1395 VDD VDD pmos W=0.205u L=0.04u
M24780 U2780/net30 WX3357 VDD VDD pmos W=0.205u L=0.04u
M24781 U2780/net108 U2780/net104 VDD VDD pmos W=0.205u L=0.04u
M24782 n1995 U2780/net28 VDD VDD pmos W=0.205u L=0.04u
M24783 U2780/net32 WX3293 VDD VDD pmos W=0.205u L=0.04u
M24784 U2780/net64 U2780/net24 VDD VDD pmos W=0.28u L=0.04u
M24785 U2780/net24 U2780/net30 U2780/net045 VDD pmos W=0.205u L=0.04u
M24786 U2780/net045 U2780/net32 VDD VDD pmos W=0.205u L=0.04u
M24787 n1395 WX3485 VSS VSS nmos W=0.135u L=0.04u
M24788 n1395 WX3485 VDD VDD pmos W=0.205u L=0.04u
M24789 U2782/net28 U2782/net20 U2782/net64 VSS nmos W=0.155u L=0.04u
M24790 U2782/net24 U2782/net30 U2782/net32 VSS nmos W=0.155u L=0.04u
M24791 U2782/net28 U2782/net40 U2782/net24 VSS nmos W=0.155u L=0.04u
M24792 U2782/net40 WX2128 U2782/net108 VSS nmos W=0.155u L=0.04u
M24793 U2782/net40 U2782/net106 U2782/net104 VSS nmos W=0.155u L=0.04u
M24794 U2782/net24 WX2064 U2782/net050 VSS nmos W=0.155u L=0.04u
M24795 U2782/net050 U2782/net32 VSS VSS nmos W=0.155u L=0.04u
M24796 U2782/net20 U2782/net40 VSS VSS nmos W=0.155u L=0.04u
M24797 U2782/net106 WX2128 VSS VSS nmos W=0.155u L=0.04u
M24798 U2782/net104 n1397 VSS VSS nmos W=0.155u L=0.04u
M24799 U2782/net30 WX2064 VSS VSS nmos W=0.155u L=0.04u
M24800 U2782/net108 U2782/net104 VSS VSS nmos W=0.155u L=0.04u
M24801 n1846 U2782/net28 VSS VSS nmos W=0.155u L=0.04u
M24802 U2782/net32 WX2000 VSS VSS nmos W=0.155u L=0.04u
M24803 U2782/net64 U2782/net24 VSS VSS nmos W=0.2u L=0.04u
M24804 U2782/net28 U2782/net40 U2782/net64 VDD pmos W=0.205u L=0.04u
M24805 U2782/net24 WX2064 U2782/net32 VDD pmos W=0.205u L=0.04u
M24806 U2782/net28 U2782/net20 U2782/net24 VDD pmos W=0.205u L=0.04u
M24807 U2782/net40 U2782/net106 U2782/net108 VDD pmos W=0.205u L=0.04u
M24808 U2782/net40 WX2128 U2782/net104 VDD pmos W=0.205u L=0.04u
M24809 U2782/net20 U2782/net40 VDD VDD pmos W=0.205u L=0.04u
M24810 U2782/net106 WX2128 VDD VDD pmos W=0.205u L=0.04u
M24811 U2782/net104 n1397 VDD VDD pmos W=0.205u L=0.04u
M24812 U2782/net30 WX2064 VDD VDD pmos W=0.205u L=0.04u
M24813 U2782/net108 U2782/net104 VDD VDD pmos W=0.205u L=0.04u
M24814 n1846 U2782/net28 VDD VDD pmos W=0.205u L=0.04u
M24815 U2782/net32 WX2000 VDD VDD pmos W=0.205u L=0.04u
M24816 U2782/net64 U2782/net24 VDD VDD pmos W=0.28u L=0.04u
M24817 U2782/net24 U2782/net30 U2782/net045 VDD pmos W=0.205u L=0.04u
M24818 U2782/net045 U2782/net32 VDD VDD pmos W=0.205u L=0.04u
M24819 n1397 WX2192 VSS VSS nmos W=0.135u L=0.04u
M24820 n1397 WX2192 VDD VDD pmos W=0.205u L=0.04u
M24821 WX1751 n1241 U2784/net26 VSS nmos W=0.155u L=0.04u
M24822 WX1751 n1849 U2784/net26 VSS nmos W=0.155u L=0.04u
M24823 U2784/net29 n2136 VSS VSS nmos W=0.155u L=0.04u
M24824 U2784/net26 n1997 U2784/net29 VSS nmos W=0.155u L=0.04u
M24825 U2784/net26 n1291 U2784/net29 VSS nmos W=0.155u L=0.04u
M24826 WX1751 n1849 U2784/net43 VDD pmos W=0.205u L=0.04u
M24827 WX1751 n1291 U2784/net49 VDD pmos W=0.205u L=0.04u
M24828 U2784/net49 n1997 VDD VDD pmos W=0.205u L=0.04u
M24829 U2784/net43 n1241 VDD VDD pmos W=0.205u L=0.04u
M24830 WX1751 n2136 VDD VDD pmos W=0.205u L=0.04u
M24831 U2785/net29 n1348 VSS VSS nmos W=0.155u L=0.04u
M24832 n2136 WX1838 U2785/net29 VSS nmos W=0.155u L=0.04u
M24833 n2136 n1315 U2785/net23 VSS nmos W=0.155u L=0.04u
M24834 U2785/net23 CRC_OUT_8_1 VSS VSS nmos W=0.155u L=0.04u
M24835 U2785/net20 CRC_OUT_8_1 n2136 VDD pmos W=0.205u L=0.04u
M24836 U2785/net20 n1315 n2136 VDD pmos W=0.205u L=0.04u
M24837 VDD WX1838 U2785/net20 VDD pmos W=0.205u L=0.04u
M24838 VDD n1348 U2785/net20 VDD pmos W=0.205u L=0.04u
M24839 n1997 n2137 VSS VSS nmos W=0.135u L=0.04u
M24840 n1997 n2137 VDD VDD pmos W=0.205u L=0.04u
M24841 U2787/net28 U2787/net20 U2787/net64 VSS nmos W=0.155u L=0.04u
M24842 U2787/net24 U2787/net30 U2787/net32 VSS nmos W=0.155u L=0.04u
M24843 U2787/net28 U2787/net40 U2787/net24 VSS nmos W=0.155u L=0.04u
M24844 U2787/net40 WX3419 U2787/net108 VSS nmos W=0.155u L=0.04u
M24845 U2787/net40 U2787/net106 U2787/net104 VSS nmos W=0.155u L=0.04u
M24846 U2787/net24 WX3355 U2787/net050 VSS nmos W=0.155u L=0.04u
M24847 U2787/net050 U2787/net32 VSS VSS nmos W=0.155u L=0.04u
M24848 U2787/net20 U2787/net40 VSS VSS nmos W=0.155u L=0.04u
M24849 U2787/net106 WX3419 VSS VSS nmos W=0.155u L=0.04u
M24850 U2787/net104 WX3483 VSS VSS nmos W=0.155u L=0.04u
M24851 U2787/net30 WX3355 VSS VSS nmos W=0.155u L=0.04u
M24852 U2787/net108 U2787/net104 VSS VSS nmos W=0.155u L=0.04u
M24853 n2137 U2787/net28 VSS VSS nmos W=0.155u L=0.04u
M24854 U2787/net32 WX3291 VSS VSS nmos W=0.155u L=0.04u
M24855 U2787/net64 U2787/net24 VSS VSS nmos W=0.2u L=0.04u
M24856 U2787/net28 U2787/net40 U2787/net64 VDD pmos W=0.205u L=0.04u
M24857 U2787/net24 WX3355 U2787/net32 VDD pmos W=0.205u L=0.04u
M24858 U2787/net28 U2787/net20 U2787/net24 VDD pmos W=0.205u L=0.04u
M24859 U2787/net40 U2787/net106 U2787/net108 VDD pmos W=0.205u L=0.04u
M24860 U2787/net40 WX3419 U2787/net104 VDD pmos W=0.205u L=0.04u
M24861 U2787/net20 U2787/net40 VDD VDD pmos W=0.205u L=0.04u
M24862 U2787/net106 WX3419 VDD VDD pmos W=0.205u L=0.04u
M24863 U2787/net104 WX3483 VDD VDD pmos W=0.205u L=0.04u
M24864 U2787/net30 WX3355 VDD VDD pmos W=0.205u L=0.04u
M24865 U2787/net108 U2787/net104 VDD VDD pmos W=0.205u L=0.04u
M24866 n2137 U2787/net28 VDD VDD pmos W=0.205u L=0.04u
M24867 U2787/net32 WX3291 VDD VDD pmos W=0.205u L=0.04u
M24868 U2787/net64 U2787/net24 VDD VDD pmos W=0.28u L=0.04u
M24869 U2787/net24 U2787/net30 U2787/net045 VDD pmos W=0.205u L=0.04u
M24870 U2787/net045 U2787/net32 VDD VDD pmos W=0.205u L=0.04u
M24871 n1849 n2138 VSS VSS nmos W=0.135u L=0.04u
M24872 n1849 n2138 VDD VDD pmos W=0.205u L=0.04u
M24873 U2789/net28 U2789/net20 U2789/net64 VSS nmos W=0.155u L=0.04u
M24874 U2789/net24 U2789/net30 U2789/net32 VSS nmos W=0.155u L=0.04u
M24875 U2789/net28 U2789/net40 U2789/net24 VSS nmos W=0.155u L=0.04u
M24876 U2789/net40 WX2126 U2789/net108 VSS nmos W=0.155u L=0.04u
M24877 U2789/net40 U2789/net106 U2789/net104 VSS nmos W=0.155u L=0.04u
M24878 U2789/net24 WX2062 U2789/net050 VSS nmos W=0.155u L=0.04u
M24879 U2789/net050 U2789/net32 VSS VSS nmos W=0.155u L=0.04u
M24880 U2789/net20 U2789/net40 VSS VSS nmos W=0.155u L=0.04u
M24881 U2789/net106 WX2126 VSS VSS nmos W=0.155u L=0.04u
M24882 U2789/net104 WX2190 VSS VSS nmos W=0.155u L=0.04u
M24883 U2789/net30 WX2062 VSS VSS nmos W=0.155u L=0.04u
M24884 U2789/net108 U2789/net104 VSS VSS nmos W=0.155u L=0.04u
M24885 n2138 U2789/net28 VSS VSS nmos W=0.155u L=0.04u
M24886 U2789/net32 WX1998 VSS VSS nmos W=0.155u L=0.04u
M24887 U2789/net64 U2789/net24 VSS VSS nmos W=0.2u L=0.04u
M24888 U2789/net28 U2789/net40 U2789/net64 VDD pmos W=0.205u L=0.04u
M24889 U2789/net24 WX2062 U2789/net32 VDD pmos W=0.205u L=0.04u
M24890 U2789/net28 U2789/net20 U2789/net24 VDD pmos W=0.205u L=0.04u
M24891 U2789/net40 U2789/net106 U2789/net108 VDD pmos W=0.205u L=0.04u
M24892 U2789/net40 WX2126 U2789/net104 VDD pmos W=0.205u L=0.04u
M24893 U2789/net20 U2789/net40 VDD VDD pmos W=0.205u L=0.04u
M24894 U2789/net106 WX2126 VDD VDD pmos W=0.205u L=0.04u
M24895 U2789/net104 WX2190 VDD VDD pmos W=0.205u L=0.04u
M24896 U2789/net30 WX2062 VDD VDD pmos W=0.205u L=0.04u
M24897 U2789/net108 U2789/net104 VDD VDD pmos W=0.205u L=0.04u
M24898 n2138 U2789/net28 VDD VDD pmos W=0.205u L=0.04u
M24899 U2789/net32 WX1998 VDD VDD pmos W=0.205u L=0.04u
M24900 U2789/net64 U2789/net24 VDD VDD pmos W=0.28u L=0.04u
M24901 U2789/net24 U2789/net30 U2789/net045 VDD pmos W=0.205u L=0.04u
M24902 U2789/net045 U2789/net32 VDD VDD pmos W=0.205u L=0.04u
M24903 WX1737 n1241 U2790/net26 VSS nmos W=0.155u L=0.04u
M24904 WX1737 n1852 U2790/net26 VSS nmos W=0.155u L=0.04u
M24905 U2790/net29 n2139 VSS VSS nmos W=0.155u L=0.04u
M24906 U2790/net26 n2003 U2790/net29 VSS nmos W=0.155u L=0.04u
M24907 U2790/net26 n1291 U2790/net29 VSS nmos W=0.155u L=0.04u
M24908 WX1737 n1852 U2790/net43 VDD pmos W=0.205u L=0.04u
M24909 WX1737 n1291 U2790/net49 VDD pmos W=0.205u L=0.04u
M24910 U2790/net49 n2003 VDD VDD pmos W=0.205u L=0.04u
M24911 U2790/net43 n1241 VDD VDD pmos W=0.205u L=0.04u
M24912 WX1737 n2139 VDD VDD pmos W=0.205u L=0.04u
M24913 U2791/net29 n1348 VSS VSS nmos W=0.155u L=0.04u
M24914 n2139 WX1836 U2791/net29 VSS nmos W=0.155u L=0.04u
M24915 n2139 n1315 U2791/net23 VSS nmos W=0.155u L=0.04u
M24916 U2791/net23 CRC_OUT_8_2 VSS VSS nmos W=0.155u L=0.04u
M24917 U2791/net20 CRC_OUT_8_2 n2139 VDD pmos W=0.205u L=0.04u
M24918 U2791/net20 n1315 n2139 VDD pmos W=0.205u L=0.04u
M24919 VDD WX1836 U2791/net20 VDD pmos W=0.205u L=0.04u
M24920 VDD n1348 U2791/net20 VDD pmos W=0.205u L=0.04u
M24921 n2003 n2140 VSS VSS nmos W=0.135u L=0.04u
M24922 n2003 n2140 VDD VDD pmos W=0.205u L=0.04u
M24923 U2793/net28 U2793/net20 U2793/net64 VSS nmos W=0.155u L=0.04u
M24924 U2793/net24 U2793/net30 U2793/net32 VSS nmos W=0.155u L=0.04u
M24925 U2793/net28 U2793/net40 U2793/net24 VSS nmos W=0.155u L=0.04u
M24926 U2793/net40 WX3417 U2793/net108 VSS nmos W=0.155u L=0.04u
M24927 U2793/net40 U2793/net106 U2793/net104 VSS nmos W=0.155u L=0.04u
M24928 U2793/net24 WX3353 U2793/net050 VSS nmos W=0.155u L=0.04u
M24929 U2793/net050 U2793/net32 VSS VSS nmos W=0.155u L=0.04u
M24930 U2793/net20 U2793/net40 VSS VSS nmos W=0.155u L=0.04u
M24931 U2793/net106 WX3417 VSS VSS nmos W=0.155u L=0.04u
M24932 U2793/net104 WX3481 VSS VSS nmos W=0.155u L=0.04u
M24933 U2793/net30 WX3353 VSS VSS nmos W=0.155u L=0.04u
M24934 U2793/net108 U2793/net104 VSS VSS nmos W=0.155u L=0.04u
M24935 n2140 U2793/net28 VSS VSS nmos W=0.155u L=0.04u
M24936 U2793/net32 WX3289 VSS VSS nmos W=0.155u L=0.04u
M24937 U2793/net64 U2793/net24 VSS VSS nmos W=0.2u L=0.04u
M24938 U2793/net28 U2793/net40 U2793/net64 VDD pmos W=0.205u L=0.04u
M24939 U2793/net24 WX3353 U2793/net32 VDD pmos W=0.205u L=0.04u
M24940 U2793/net28 U2793/net20 U2793/net24 VDD pmos W=0.205u L=0.04u
M24941 U2793/net40 U2793/net106 U2793/net108 VDD pmos W=0.205u L=0.04u
M24942 U2793/net40 WX3417 U2793/net104 VDD pmos W=0.205u L=0.04u
M24943 U2793/net20 U2793/net40 VDD VDD pmos W=0.205u L=0.04u
M24944 U2793/net106 WX3417 VDD VDD pmos W=0.205u L=0.04u
M24945 U2793/net104 WX3481 VDD VDD pmos W=0.205u L=0.04u
M24946 U2793/net30 WX3353 VDD VDD pmos W=0.205u L=0.04u
M24947 U2793/net108 U2793/net104 VDD VDD pmos W=0.205u L=0.04u
M24948 n2140 U2793/net28 VDD VDD pmos W=0.205u L=0.04u
M24949 U2793/net32 WX3289 VDD VDD pmos W=0.205u L=0.04u
M24950 U2793/net64 U2793/net24 VDD VDD pmos W=0.28u L=0.04u
M24951 U2793/net24 U2793/net30 U2793/net045 VDD pmos W=0.205u L=0.04u
M24952 U2793/net045 U2793/net32 VDD VDD pmos W=0.205u L=0.04u
M24953 n1852 n2141 VSS VSS nmos W=0.135u L=0.04u
M24954 n1852 n2141 VDD VDD pmos W=0.205u L=0.04u
M24955 U2795/net28 U2795/net20 U2795/net64 VSS nmos W=0.155u L=0.04u
M24956 U2795/net24 U2795/net30 U2795/net32 VSS nmos W=0.155u L=0.04u
M24957 U2795/net28 U2795/net40 U2795/net24 VSS nmos W=0.155u L=0.04u
M24958 U2795/net40 WX2124 U2795/net108 VSS nmos W=0.155u L=0.04u
M24959 U2795/net40 U2795/net106 U2795/net104 VSS nmos W=0.155u L=0.04u
M24960 U2795/net24 WX2060 U2795/net050 VSS nmos W=0.155u L=0.04u
M24961 U2795/net050 U2795/net32 VSS VSS nmos W=0.155u L=0.04u
M24962 U2795/net20 U2795/net40 VSS VSS nmos W=0.155u L=0.04u
M24963 U2795/net106 WX2124 VSS VSS nmos W=0.155u L=0.04u
M24964 U2795/net104 WX2188 VSS VSS nmos W=0.155u L=0.04u
M24965 U2795/net30 WX2060 VSS VSS nmos W=0.155u L=0.04u
M24966 U2795/net108 U2795/net104 VSS VSS nmos W=0.155u L=0.04u
M24967 n2141 U2795/net28 VSS VSS nmos W=0.155u L=0.04u
M24968 U2795/net32 WX1996 VSS VSS nmos W=0.155u L=0.04u
M24969 U2795/net64 U2795/net24 VSS VSS nmos W=0.2u L=0.04u
M24970 U2795/net28 U2795/net40 U2795/net64 VDD pmos W=0.205u L=0.04u
M24971 U2795/net24 WX2060 U2795/net32 VDD pmos W=0.205u L=0.04u
M24972 U2795/net28 U2795/net20 U2795/net24 VDD pmos W=0.205u L=0.04u
M24973 U2795/net40 U2795/net106 U2795/net108 VDD pmos W=0.205u L=0.04u
M24974 U2795/net40 WX2124 U2795/net104 VDD pmos W=0.205u L=0.04u
M24975 U2795/net20 U2795/net40 VDD VDD pmos W=0.205u L=0.04u
M24976 U2795/net106 WX2124 VDD VDD pmos W=0.205u L=0.04u
M24977 U2795/net104 WX2188 VDD VDD pmos W=0.205u L=0.04u
M24978 U2795/net30 WX2060 VDD VDD pmos W=0.205u L=0.04u
M24979 U2795/net108 U2795/net104 VDD VDD pmos W=0.205u L=0.04u
M24980 n2141 U2795/net28 VDD VDD pmos W=0.205u L=0.04u
M24981 U2795/net32 WX1996 VDD VDD pmos W=0.205u L=0.04u
M24982 U2795/net64 U2795/net24 VDD VDD pmos W=0.28u L=0.04u
M24983 U2795/net24 U2795/net30 U2795/net045 VDD pmos W=0.205u L=0.04u
M24984 U2795/net045 U2795/net32 VDD VDD pmos W=0.205u L=0.04u
M24985 WX1723 n1242 U2796/net26 VSS nmos W=0.155u L=0.04u
M24986 WX1723 n1866 U2796/net26 VSS nmos W=0.155u L=0.04u
M24987 U2796/net29 n2142 VSS VSS nmos W=0.155u L=0.04u
M24988 U2796/net26 n2006 U2796/net29 VSS nmos W=0.155u L=0.04u
M24989 U2796/net26 n1291 U2796/net29 VSS nmos W=0.155u L=0.04u
M24990 WX1723 n1866 U2796/net43 VDD pmos W=0.205u L=0.04u
M24991 WX1723 n1291 U2796/net49 VDD pmos W=0.205u L=0.04u
M24992 U2796/net49 n2006 VDD VDD pmos W=0.205u L=0.04u
M24993 U2796/net43 n1242 VDD VDD pmos W=0.205u L=0.04u
M24994 WX1723 n2142 VDD VDD pmos W=0.205u L=0.04u
M24995 U2797/net29 n1348 VSS VSS nmos W=0.155u L=0.04u
M24996 n2142 WX1834 U2797/net29 VSS nmos W=0.155u L=0.04u
M24997 n2142 n1315 U2797/net23 VSS nmos W=0.155u L=0.04u
M24998 U2797/net23 CRC_OUT_8_3 VSS VSS nmos W=0.155u L=0.04u
M24999 U2797/net20 CRC_OUT_8_3 n2142 VDD pmos W=0.205u L=0.04u
M25000 U2797/net20 n1315 n2142 VDD pmos W=0.205u L=0.04u
M25001 VDD WX1834 U2797/net20 VDD pmos W=0.205u L=0.04u
M25002 VDD n1348 U2797/net20 VDD pmos W=0.205u L=0.04u
M25003 n2006 n2143 VSS VSS nmos W=0.135u L=0.04u
M25004 n2006 n2143 VDD VDD pmos W=0.205u L=0.04u
M25005 U2799/net28 U2799/net20 U2799/net64 VSS nmos W=0.155u L=0.04u
M25006 U2799/net24 U2799/net30 U2799/net32 VSS nmos W=0.155u L=0.04u
M25007 U2799/net28 U2799/net40 U2799/net24 VSS nmos W=0.155u L=0.04u
M25008 U2799/net40 WX3415 U2799/net108 VSS nmos W=0.155u L=0.04u
M25009 U2799/net40 U2799/net106 U2799/net104 VSS nmos W=0.155u L=0.04u
M25010 U2799/net24 WX3351 U2799/net050 VSS nmos W=0.155u L=0.04u
M25011 U2799/net050 U2799/net32 VSS VSS nmos W=0.155u L=0.04u
M25012 U2799/net20 U2799/net40 VSS VSS nmos W=0.155u L=0.04u
M25013 U2799/net106 WX3415 VSS VSS nmos W=0.155u L=0.04u
M25014 U2799/net104 WX3479 VSS VSS nmos W=0.155u L=0.04u
M25015 U2799/net30 WX3351 VSS VSS nmos W=0.155u L=0.04u
M25016 U2799/net108 U2799/net104 VSS VSS nmos W=0.155u L=0.04u
M25017 n2143 U2799/net28 VSS VSS nmos W=0.155u L=0.04u
M25018 U2799/net32 WX3287 VSS VSS nmos W=0.155u L=0.04u
M25019 U2799/net64 U2799/net24 VSS VSS nmos W=0.2u L=0.04u
M25020 U2799/net28 U2799/net40 U2799/net64 VDD pmos W=0.205u L=0.04u
M25021 U2799/net24 WX3351 U2799/net32 VDD pmos W=0.205u L=0.04u
M25022 U2799/net28 U2799/net20 U2799/net24 VDD pmos W=0.205u L=0.04u
M25023 U2799/net40 U2799/net106 U2799/net108 VDD pmos W=0.205u L=0.04u
M25024 U2799/net40 WX3415 U2799/net104 VDD pmos W=0.205u L=0.04u
M25025 U2799/net20 U2799/net40 VDD VDD pmos W=0.205u L=0.04u
M25026 U2799/net106 WX3415 VDD VDD pmos W=0.205u L=0.04u
M25027 U2799/net104 WX3479 VDD VDD pmos W=0.205u L=0.04u
M25028 U2799/net30 WX3351 VDD VDD pmos W=0.205u L=0.04u
M25029 U2799/net108 U2799/net104 VDD VDD pmos W=0.205u L=0.04u
M25030 n2143 U2799/net28 VDD VDD pmos W=0.205u L=0.04u
M25031 U2799/net32 WX3287 VDD VDD pmos W=0.205u L=0.04u
M25032 U2799/net64 U2799/net24 VDD VDD pmos W=0.28u L=0.04u
M25033 U2799/net24 U2799/net30 U2799/net045 VDD pmos W=0.205u L=0.04u
M25034 U2799/net045 U2799/net32 VDD VDD pmos W=0.205u L=0.04u
M25035 n1866 n2144 VSS VSS nmos W=0.135u L=0.04u
M25036 n1866 n2144 VDD VDD pmos W=0.205u L=0.04u
M25037 U2801/net28 U2801/net20 U2801/net64 VSS nmos W=0.155u L=0.04u
M25038 U2801/net24 U2801/net30 U2801/net32 VSS nmos W=0.155u L=0.04u
M25039 U2801/net28 U2801/net40 U2801/net24 VSS nmos W=0.155u L=0.04u
M25040 U2801/net40 WX2122 U2801/net108 VSS nmos W=0.155u L=0.04u
M25041 U2801/net40 U2801/net106 U2801/net104 VSS nmos W=0.155u L=0.04u
M25042 U2801/net24 WX2058 U2801/net050 VSS nmos W=0.155u L=0.04u
M25043 U2801/net050 U2801/net32 VSS VSS nmos W=0.155u L=0.04u
M25044 U2801/net20 U2801/net40 VSS VSS nmos W=0.155u L=0.04u
M25045 U2801/net106 WX2122 VSS VSS nmos W=0.155u L=0.04u
M25046 U2801/net104 WX2186 VSS VSS nmos W=0.155u L=0.04u
M25047 U2801/net30 WX2058 VSS VSS nmos W=0.155u L=0.04u
M25048 U2801/net108 U2801/net104 VSS VSS nmos W=0.155u L=0.04u
M25049 n2144 U2801/net28 VSS VSS nmos W=0.155u L=0.04u
M25050 U2801/net32 WX1994 VSS VSS nmos W=0.155u L=0.04u
M25051 U2801/net64 U2801/net24 VSS VSS nmos W=0.2u L=0.04u
M25052 U2801/net28 U2801/net40 U2801/net64 VDD pmos W=0.205u L=0.04u
M25053 U2801/net24 WX2058 U2801/net32 VDD pmos W=0.205u L=0.04u
M25054 U2801/net28 U2801/net20 U2801/net24 VDD pmos W=0.205u L=0.04u
M25055 U2801/net40 U2801/net106 U2801/net108 VDD pmos W=0.205u L=0.04u
M25056 U2801/net40 WX2122 U2801/net104 VDD pmos W=0.205u L=0.04u
M25057 U2801/net20 U2801/net40 VDD VDD pmos W=0.205u L=0.04u
M25058 U2801/net106 WX2122 VDD VDD pmos W=0.205u L=0.04u
M25059 U2801/net104 WX2186 VDD VDD pmos W=0.205u L=0.04u
M25060 U2801/net30 WX2058 VDD VDD pmos W=0.205u L=0.04u
M25061 U2801/net108 U2801/net104 VDD VDD pmos W=0.205u L=0.04u
M25062 n2144 U2801/net28 VDD VDD pmos W=0.205u L=0.04u
M25063 U2801/net32 WX1994 VDD VDD pmos W=0.205u L=0.04u
M25064 U2801/net64 U2801/net24 VDD VDD pmos W=0.28u L=0.04u
M25065 U2801/net24 U2801/net30 U2801/net045 VDD pmos W=0.205u L=0.04u
M25066 U2801/net045 U2801/net32 VDD VDD pmos W=0.205u L=0.04u
M25067 WX1709 n1242 U2802/net26 VSS nmos W=0.155u L=0.04u
M25068 WX1709 n1899 U2802/net26 VSS nmos W=0.155u L=0.04u
M25069 U2802/net29 n2145 VSS VSS nmos W=0.155u L=0.04u
M25070 U2802/net26 n2009 U2802/net29 VSS nmos W=0.155u L=0.04u
M25071 U2802/net26 n1291 U2802/net29 VSS nmos W=0.155u L=0.04u
M25072 WX1709 n1899 U2802/net43 VDD pmos W=0.205u L=0.04u
M25073 WX1709 n1291 U2802/net49 VDD pmos W=0.205u L=0.04u
M25074 U2802/net49 n2009 VDD VDD pmos W=0.205u L=0.04u
M25075 U2802/net43 n1242 VDD VDD pmos W=0.205u L=0.04u
M25076 WX1709 n2145 VDD VDD pmos W=0.205u L=0.04u
M25077 U2803/net29 n1348 VSS VSS nmos W=0.155u L=0.04u
M25078 n2145 WX1832 U2803/net29 VSS nmos W=0.155u L=0.04u
M25079 n2145 n1315 U2803/net23 VSS nmos W=0.155u L=0.04u
M25080 U2803/net23 CRC_OUT_8_4 VSS VSS nmos W=0.155u L=0.04u
M25081 U2803/net20 CRC_OUT_8_4 n2145 VDD pmos W=0.205u L=0.04u
M25082 U2803/net20 n1315 n2145 VDD pmos W=0.205u L=0.04u
M25083 VDD WX1832 U2803/net20 VDD pmos W=0.205u L=0.04u
M25084 VDD n1348 U2803/net20 VDD pmos W=0.205u L=0.04u
M25085 n2009 n2146 VSS VSS nmos W=0.135u L=0.04u
M25086 n2009 n2146 VDD VDD pmos W=0.205u L=0.04u
M25087 U2805/net28 U2805/net20 U2805/net64 VSS nmos W=0.155u L=0.04u
M25088 U2805/net24 U2805/net30 U2805/net32 VSS nmos W=0.155u L=0.04u
M25089 U2805/net28 U2805/net40 U2805/net24 VSS nmos W=0.155u L=0.04u
M25090 U2805/net40 WX3413 U2805/net108 VSS nmos W=0.155u L=0.04u
M25091 U2805/net40 U2805/net106 U2805/net104 VSS nmos W=0.155u L=0.04u
M25092 U2805/net24 WX3349 U2805/net050 VSS nmos W=0.155u L=0.04u
M25093 U2805/net050 U2805/net32 VSS VSS nmos W=0.155u L=0.04u
M25094 U2805/net20 U2805/net40 VSS VSS nmos W=0.155u L=0.04u
M25095 U2805/net106 WX3413 VSS VSS nmos W=0.155u L=0.04u
M25096 U2805/net104 WX3477 VSS VSS nmos W=0.155u L=0.04u
M25097 U2805/net30 WX3349 VSS VSS nmos W=0.155u L=0.04u
M25098 U2805/net108 U2805/net104 VSS VSS nmos W=0.155u L=0.04u
M25099 n2146 U2805/net28 VSS VSS nmos W=0.155u L=0.04u
M25100 U2805/net32 WX3285 VSS VSS nmos W=0.155u L=0.04u
M25101 U2805/net64 U2805/net24 VSS VSS nmos W=0.2u L=0.04u
M25102 U2805/net28 U2805/net40 U2805/net64 VDD pmos W=0.205u L=0.04u
M25103 U2805/net24 WX3349 U2805/net32 VDD pmos W=0.205u L=0.04u
M25104 U2805/net28 U2805/net20 U2805/net24 VDD pmos W=0.205u L=0.04u
M25105 U2805/net40 U2805/net106 U2805/net108 VDD pmos W=0.205u L=0.04u
M25106 U2805/net40 WX3413 U2805/net104 VDD pmos W=0.205u L=0.04u
M25107 U2805/net20 U2805/net40 VDD VDD pmos W=0.205u L=0.04u
M25108 U2805/net106 WX3413 VDD VDD pmos W=0.205u L=0.04u
M25109 U2805/net104 WX3477 VDD VDD pmos W=0.205u L=0.04u
M25110 U2805/net30 WX3349 VDD VDD pmos W=0.205u L=0.04u
M25111 U2805/net108 U2805/net104 VDD VDD pmos W=0.205u L=0.04u
M25112 n2146 U2805/net28 VDD VDD pmos W=0.205u L=0.04u
M25113 U2805/net32 WX3285 VDD VDD pmos W=0.205u L=0.04u
M25114 U2805/net64 U2805/net24 VDD VDD pmos W=0.28u L=0.04u
M25115 U2805/net24 U2805/net30 U2805/net045 VDD pmos W=0.205u L=0.04u
M25116 U2805/net045 U2805/net32 VDD VDD pmos W=0.205u L=0.04u
M25117 n1899 n2147 VSS VSS nmos W=0.135u L=0.04u
M25118 n1899 n2147 VDD VDD pmos W=0.205u L=0.04u
M25119 U2807/net28 U2807/net20 U2807/net64 VSS nmos W=0.155u L=0.04u
M25120 U2807/net24 U2807/net30 U2807/net32 VSS nmos W=0.155u L=0.04u
M25121 U2807/net28 U2807/net40 U2807/net24 VSS nmos W=0.155u L=0.04u
M25122 U2807/net40 WX2120 U2807/net108 VSS nmos W=0.155u L=0.04u
M25123 U2807/net40 U2807/net106 U2807/net104 VSS nmos W=0.155u L=0.04u
M25124 U2807/net24 WX2056 U2807/net050 VSS nmos W=0.155u L=0.04u
M25125 U2807/net050 U2807/net32 VSS VSS nmos W=0.155u L=0.04u
M25126 U2807/net20 U2807/net40 VSS VSS nmos W=0.155u L=0.04u
M25127 U2807/net106 WX2120 VSS VSS nmos W=0.155u L=0.04u
M25128 U2807/net104 WX2184 VSS VSS nmos W=0.155u L=0.04u
M25129 U2807/net30 WX2056 VSS VSS nmos W=0.155u L=0.04u
M25130 U2807/net108 U2807/net104 VSS VSS nmos W=0.155u L=0.04u
M25131 n2147 U2807/net28 VSS VSS nmos W=0.155u L=0.04u
M25132 U2807/net32 WX1992 VSS VSS nmos W=0.155u L=0.04u
M25133 U2807/net64 U2807/net24 VSS VSS nmos W=0.2u L=0.04u
M25134 U2807/net28 U2807/net40 U2807/net64 VDD pmos W=0.205u L=0.04u
M25135 U2807/net24 WX2056 U2807/net32 VDD pmos W=0.205u L=0.04u
M25136 U2807/net28 U2807/net20 U2807/net24 VDD pmos W=0.205u L=0.04u
M25137 U2807/net40 U2807/net106 U2807/net108 VDD pmos W=0.205u L=0.04u
M25138 U2807/net40 WX2120 U2807/net104 VDD pmos W=0.205u L=0.04u
M25139 U2807/net20 U2807/net40 VDD VDD pmos W=0.205u L=0.04u
M25140 U2807/net106 WX2120 VDD VDD pmos W=0.205u L=0.04u
M25141 U2807/net104 WX2184 VDD VDD pmos W=0.205u L=0.04u
M25142 U2807/net30 WX2056 VDD VDD pmos W=0.205u L=0.04u
M25143 U2807/net108 U2807/net104 VDD VDD pmos W=0.205u L=0.04u
M25144 n2147 U2807/net28 VDD VDD pmos W=0.205u L=0.04u
M25145 U2807/net32 WX1992 VDD VDD pmos W=0.205u L=0.04u
M25146 U2807/net64 U2807/net24 VDD VDD pmos W=0.28u L=0.04u
M25147 U2807/net24 U2807/net30 U2807/net045 VDD pmos W=0.205u L=0.04u
M25148 U2807/net045 U2807/net32 VDD VDD pmos W=0.205u L=0.04u
M25149 WX1695 n1242 U2808/net26 VSS nmos W=0.155u L=0.04u
M25150 WX1695 n1940 U2808/net26 VSS nmos W=0.155u L=0.04u
M25151 U2808/net29 n2148 VSS VSS nmos W=0.155u L=0.04u
M25152 U2808/net26 n2012 U2808/net29 VSS nmos W=0.155u L=0.04u
M25153 U2808/net26 n1291 U2808/net29 VSS nmos W=0.155u L=0.04u
M25154 WX1695 n1940 U2808/net43 VDD pmos W=0.205u L=0.04u
M25155 WX1695 n1291 U2808/net49 VDD pmos W=0.205u L=0.04u
M25156 U2808/net49 n2012 VDD VDD pmos W=0.205u L=0.04u
M25157 U2808/net43 n1242 VDD VDD pmos W=0.205u L=0.04u
M25158 WX1695 n2148 VDD VDD pmos W=0.205u L=0.04u
M25159 U2809/net29 n1348 VSS VSS nmos W=0.155u L=0.04u
M25160 n2148 WX1830 U2809/net29 VSS nmos W=0.155u L=0.04u
M25161 n2148 n1315 U2809/net23 VSS nmos W=0.155u L=0.04u
M25162 U2809/net23 CRC_OUT_8_5 VSS VSS nmos W=0.155u L=0.04u
M25163 U2809/net20 CRC_OUT_8_5 n2148 VDD pmos W=0.205u L=0.04u
M25164 U2809/net20 n1315 n2148 VDD pmos W=0.205u L=0.04u
M25165 VDD WX1830 U2809/net20 VDD pmos W=0.205u L=0.04u
M25166 VDD n1348 U2809/net20 VDD pmos W=0.205u L=0.04u
M25167 n2012 n2149 VSS VSS nmos W=0.135u L=0.04u
M25168 n2012 n2149 VDD VDD pmos W=0.205u L=0.04u
M25169 U2811/net28 U2811/net20 U2811/net64 VSS nmos W=0.155u L=0.04u
M25170 U2811/net24 U2811/net30 U2811/net32 VSS nmos W=0.155u L=0.04u
M25171 U2811/net28 U2811/net40 U2811/net24 VSS nmos W=0.155u L=0.04u
M25172 U2811/net40 WX3411 U2811/net108 VSS nmos W=0.155u L=0.04u
M25173 U2811/net40 U2811/net106 U2811/net104 VSS nmos W=0.155u L=0.04u
M25174 U2811/net24 WX3347 U2811/net050 VSS nmos W=0.155u L=0.04u
M25175 U2811/net050 U2811/net32 VSS VSS nmos W=0.155u L=0.04u
M25176 U2811/net20 U2811/net40 VSS VSS nmos W=0.155u L=0.04u
M25177 U2811/net106 WX3411 VSS VSS nmos W=0.155u L=0.04u
M25178 U2811/net104 WX3475 VSS VSS nmos W=0.155u L=0.04u
M25179 U2811/net30 WX3347 VSS VSS nmos W=0.155u L=0.04u
M25180 U2811/net108 U2811/net104 VSS VSS nmos W=0.155u L=0.04u
M25181 n2149 U2811/net28 VSS VSS nmos W=0.155u L=0.04u
M25182 U2811/net32 WX3283 VSS VSS nmos W=0.155u L=0.04u
M25183 U2811/net64 U2811/net24 VSS VSS nmos W=0.2u L=0.04u
M25184 U2811/net28 U2811/net40 U2811/net64 VDD pmos W=0.205u L=0.04u
M25185 U2811/net24 WX3347 U2811/net32 VDD pmos W=0.205u L=0.04u
M25186 U2811/net28 U2811/net20 U2811/net24 VDD pmos W=0.205u L=0.04u
M25187 U2811/net40 U2811/net106 U2811/net108 VDD pmos W=0.205u L=0.04u
M25188 U2811/net40 WX3411 U2811/net104 VDD pmos W=0.205u L=0.04u
M25189 U2811/net20 U2811/net40 VDD VDD pmos W=0.205u L=0.04u
M25190 U2811/net106 WX3411 VDD VDD pmos W=0.205u L=0.04u
M25191 U2811/net104 WX3475 VDD VDD pmos W=0.205u L=0.04u
M25192 U2811/net30 WX3347 VDD VDD pmos W=0.205u L=0.04u
M25193 U2811/net108 U2811/net104 VDD VDD pmos W=0.205u L=0.04u
M25194 n2149 U2811/net28 VDD VDD pmos W=0.205u L=0.04u
M25195 U2811/net32 WX3283 VDD VDD pmos W=0.205u L=0.04u
M25196 U2811/net64 U2811/net24 VDD VDD pmos W=0.28u L=0.04u
M25197 U2811/net24 U2811/net30 U2811/net045 VDD pmos W=0.205u L=0.04u
M25198 U2811/net045 U2811/net32 VDD VDD pmos W=0.205u L=0.04u
M25199 n1940 n2150 VSS VSS nmos W=0.135u L=0.04u
M25200 n1940 n2150 VDD VDD pmos W=0.205u L=0.04u
M25201 U2813/net28 U2813/net20 U2813/net64 VSS nmos W=0.155u L=0.04u
M25202 U2813/net24 U2813/net30 U2813/net32 VSS nmos W=0.155u L=0.04u
M25203 U2813/net28 U2813/net40 U2813/net24 VSS nmos W=0.155u L=0.04u
M25204 U2813/net40 WX2118 U2813/net108 VSS nmos W=0.155u L=0.04u
M25205 U2813/net40 U2813/net106 U2813/net104 VSS nmos W=0.155u L=0.04u
M25206 U2813/net24 WX2054 U2813/net050 VSS nmos W=0.155u L=0.04u
M25207 U2813/net050 U2813/net32 VSS VSS nmos W=0.155u L=0.04u
M25208 U2813/net20 U2813/net40 VSS VSS nmos W=0.155u L=0.04u
M25209 U2813/net106 WX2118 VSS VSS nmos W=0.155u L=0.04u
M25210 U2813/net104 WX2182 VSS VSS nmos W=0.155u L=0.04u
M25211 U2813/net30 WX2054 VSS VSS nmos W=0.155u L=0.04u
M25212 U2813/net108 U2813/net104 VSS VSS nmos W=0.155u L=0.04u
M25213 n2150 U2813/net28 VSS VSS nmos W=0.155u L=0.04u
M25214 U2813/net32 WX1990 VSS VSS nmos W=0.155u L=0.04u
M25215 U2813/net64 U2813/net24 VSS VSS nmos W=0.2u L=0.04u
M25216 U2813/net28 U2813/net40 U2813/net64 VDD pmos W=0.205u L=0.04u
M25217 U2813/net24 WX2054 U2813/net32 VDD pmos W=0.205u L=0.04u
M25218 U2813/net28 U2813/net20 U2813/net24 VDD pmos W=0.205u L=0.04u
M25219 U2813/net40 U2813/net106 U2813/net108 VDD pmos W=0.205u L=0.04u
M25220 U2813/net40 WX2118 U2813/net104 VDD pmos W=0.205u L=0.04u
M25221 U2813/net20 U2813/net40 VDD VDD pmos W=0.205u L=0.04u
M25222 U2813/net106 WX2118 VDD VDD pmos W=0.205u L=0.04u
M25223 U2813/net104 WX2182 VDD VDD pmos W=0.205u L=0.04u
M25224 U2813/net30 WX2054 VDD VDD pmos W=0.205u L=0.04u
M25225 U2813/net108 U2813/net104 VDD VDD pmos W=0.205u L=0.04u
M25226 n2150 U2813/net28 VDD VDD pmos W=0.205u L=0.04u
M25227 U2813/net32 WX1990 VDD VDD pmos W=0.205u L=0.04u
M25228 U2813/net64 U2813/net24 VDD VDD pmos W=0.28u L=0.04u
M25229 U2813/net24 U2813/net30 U2813/net045 VDD pmos W=0.205u L=0.04u
M25230 U2813/net045 U2813/net32 VDD VDD pmos W=0.205u L=0.04u
M25231 WX1681 n1242 U2814/net26 VSS nmos W=0.155u L=0.04u
M25232 WX1681 n1974 U2814/net26 VSS nmos W=0.155u L=0.04u
M25233 U2814/net29 n2151 VSS VSS nmos W=0.155u L=0.04u
M25234 U2814/net26 n2015 U2814/net29 VSS nmos W=0.155u L=0.04u
M25235 U2814/net26 n1291 U2814/net29 VSS nmos W=0.155u L=0.04u
M25236 WX1681 n1974 U2814/net43 VDD pmos W=0.205u L=0.04u
M25237 WX1681 n1291 U2814/net49 VDD pmos W=0.205u L=0.04u
M25238 U2814/net49 n2015 VDD VDD pmos W=0.205u L=0.04u
M25239 U2814/net43 n1242 VDD VDD pmos W=0.205u L=0.04u
M25240 WX1681 n2151 VDD VDD pmos W=0.205u L=0.04u
M25241 U2815/net29 n1348 VSS VSS nmos W=0.155u L=0.04u
M25242 n2151 WX1828 U2815/net29 VSS nmos W=0.155u L=0.04u
M25243 n2151 n1314 U2815/net23 VSS nmos W=0.155u L=0.04u
M25244 U2815/net23 CRC_OUT_8_6 VSS VSS nmos W=0.155u L=0.04u
M25245 U2815/net20 CRC_OUT_8_6 n2151 VDD pmos W=0.205u L=0.04u
M25246 U2815/net20 n1314 n2151 VDD pmos W=0.205u L=0.04u
M25247 VDD WX1828 U2815/net20 VDD pmos W=0.205u L=0.04u
M25248 VDD n1348 U2815/net20 VDD pmos W=0.205u L=0.04u
M25249 n2015 n2152 VSS VSS nmos W=0.135u L=0.04u
M25250 n2015 n2152 VDD VDD pmos W=0.205u L=0.04u
M25251 U2817/net28 U2817/net20 U2817/net64 VSS nmos W=0.155u L=0.04u
M25252 U2817/net24 U2817/net30 U2817/net32 VSS nmos W=0.155u L=0.04u
M25253 U2817/net28 U2817/net40 U2817/net24 VSS nmos W=0.155u L=0.04u
M25254 U2817/net40 WX3409 U2817/net108 VSS nmos W=0.155u L=0.04u
M25255 U2817/net40 U2817/net106 U2817/net104 VSS nmos W=0.155u L=0.04u
M25256 U2817/net24 WX3345 U2817/net050 VSS nmos W=0.155u L=0.04u
M25257 U2817/net050 U2817/net32 VSS VSS nmos W=0.155u L=0.04u
M25258 U2817/net20 U2817/net40 VSS VSS nmos W=0.155u L=0.04u
M25259 U2817/net106 WX3409 VSS VSS nmos W=0.155u L=0.04u
M25260 U2817/net104 WX3473 VSS VSS nmos W=0.155u L=0.04u
M25261 U2817/net30 WX3345 VSS VSS nmos W=0.155u L=0.04u
M25262 U2817/net108 U2817/net104 VSS VSS nmos W=0.155u L=0.04u
M25263 n2152 U2817/net28 VSS VSS nmos W=0.155u L=0.04u
M25264 U2817/net32 WX3281 VSS VSS nmos W=0.155u L=0.04u
M25265 U2817/net64 U2817/net24 VSS VSS nmos W=0.2u L=0.04u
M25266 U2817/net28 U2817/net40 U2817/net64 VDD pmos W=0.205u L=0.04u
M25267 U2817/net24 WX3345 U2817/net32 VDD pmos W=0.205u L=0.04u
M25268 U2817/net28 U2817/net20 U2817/net24 VDD pmos W=0.205u L=0.04u
M25269 U2817/net40 U2817/net106 U2817/net108 VDD pmos W=0.205u L=0.04u
M25270 U2817/net40 WX3409 U2817/net104 VDD pmos W=0.205u L=0.04u
M25271 U2817/net20 U2817/net40 VDD VDD pmos W=0.205u L=0.04u
M25272 U2817/net106 WX3409 VDD VDD pmos W=0.205u L=0.04u
M25273 U2817/net104 WX3473 VDD VDD pmos W=0.205u L=0.04u
M25274 U2817/net30 WX3345 VDD VDD pmos W=0.205u L=0.04u
M25275 U2817/net108 U2817/net104 VDD VDD pmos W=0.205u L=0.04u
M25276 n2152 U2817/net28 VDD VDD pmos W=0.205u L=0.04u
M25277 U2817/net32 WX3281 VDD VDD pmos W=0.205u L=0.04u
M25278 U2817/net64 U2817/net24 VDD VDD pmos W=0.28u L=0.04u
M25279 U2817/net24 U2817/net30 U2817/net045 VDD pmos W=0.205u L=0.04u
M25280 U2817/net045 U2817/net32 VDD VDD pmos W=0.205u L=0.04u
M25281 n1974 n2153 VSS VSS nmos W=0.135u L=0.04u
M25282 n1974 n2153 VDD VDD pmos W=0.205u L=0.04u
M25283 U2819/net28 U2819/net20 U2819/net64 VSS nmos W=0.155u L=0.04u
M25284 U2819/net24 U2819/net30 U2819/net32 VSS nmos W=0.155u L=0.04u
M25285 U2819/net28 U2819/net40 U2819/net24 VSS nmos W=0.155u L=0.04u
M25286 U2819/net40 WX2116 U2819/net108 VSS nmos W=0.155u L=0.04u
M25287 U2819/net40 U2819/net106 U2819/net104 VSS nmos W=0.155u L=0.04u
M25288 U2819/net24 WX2052 U2819/net050 VSS nmos W=0.155u L=0.04u
M25289 U2819/net050 U2819/net32 VSS VSS nmos W=0.155u L=0.04u
M25290 U2819/net20 U2819/net40 VSS VSS nmos W=0.155u L=0.04u
M25291 U2819/net106 WX2116 VSS VSS nmos W=0.155u L=0.04u
M25292 U2819/net104 WX2180 VSS VSS nmos W=0.155u L=0.04u
M25293 U2819/net30 WX2052 VSS VSS nmos W=0.155u L=0.04u
M25294 U2819/net108 U2819/net104 VSS VSS nmos W=0.155u L=0.04u
M25295 n2153 U2819/net28 VSS VSS nmos W=0.155u L=0.04u
M25296 U2819/net32 WX1988 VSS VSS nmos W=0.155u L=0.04u
M25297 U2819/net64 U2819/net24 VSS VSS nmos W=0.2u L=0.04u
M25298 U2819/net28 U2819/net40 U2819/net64 VDD pmos W=0.205u L=0.04u
M25299 U2819/net24 WX2052 U2819/net32 VDD pmos W=0.205u L=0.04u
M25300 U2819/net28 U2819/net20 U2819/net24 VDD pmos W=0.205u L=0.04u
M25301 U2819/net40 U2819/net106 U2819/net108 VDD pmos W=0.205u L=0.04u
M25302 U2819/net40 WX2116 U2819/net104 VDD pmos W=0.205u L=0.04u
M25303 U2819/net20 U2819/net40 VDD VDD pmos W=0.205u L=0.04u
M25304 U2819/net106 WX2116 VDD VDD pmos W=0.205u L=0.04u
M25305 U2819/net104 WX2180 VDD VDD pmos W=0.205u L=0.04u
M25306 U2819/net30 WX2052 VDD VDD pmos W=0.205u L=0.04u
M25307 U2819/net108 U2819/net104 VDD VDD pmos W=0.205u L=0.04u
M25308 n2153 U2819/net28 VDD VDD pmos W=0.205u L=0.04u
M25309 U2819/net32 WX1988 VDD VDD pmos W=0.205u L=0.04u
M25310 U2819/net64 U2819/net24 VDD VDD pmos W=0.28u L=0.04u
M25311 U2819/net24 U2819/net30 U2819/net045 VDD pmos W=0.205u L=0.04u
M25312 U2819/net045 U2819/net32 VDD VDD pmos W=0.205u L=0.04u
M25313 WX1667 n1242 U2820/net26 VSS nmos W=0.155u L=0.04u
M25314 WX1667 n1980 U2820/net26 VSS nmos W=0.155u L=0.04u
M25315 U2820/net29 n2154 VSS VSS nmos W=0.155u L=0.04u
M25316 U2820/net26 n2018 U2820/net29 VSS nmos W=0.155u L=0.04u
M25317 U2820/net26 n1291 U2820/net29 VSS nmos W=0.155u L=0.04u
M25318 WX1667 n1980 U2820/net43 VDD pmos W=0.205u L=0.04u
M25319 WX1667 n1291 U2820/net49 VDD pmos W=0.205u L=0.04u
M25320 U2820/net49 n2018 VDD VDD pmos W=0.205u L=0.04u
M25321 U2820/net43 n1242 VDD VDD pmos W=0.205u L=0.04u
M25322 WX1667 n2154 VDD VDD pmos W=0.205u L=0.04u
M25323 U2821/net29 n1348 VSS VSS nmos W=0.155u L=0.04u
M25324 n2154 WX1826 U2821/net29 VSS nmos W=0.155u L=0.04u
M25325 n2154 n1314 U2821/net23 VSS nmos W=0.155u L=0.04u
M25326 U2821/net23 CRC_OUT_8_7 VSS VSS nmos W=0.155u L=0.04u
M25327 U2821/net20 CRC_OUT_8_7 n2154 VDD pmos W=0.205u L=0.04u
M25328 U2821/net20 n1314 n2154 VDD pmos W=0.205u L=0.04u
M25329 VDD WX1826 U2821/net20 VDD pmos W=0.205u L=0.04u
M25330 VDD n1348 U2821/net20 VDD pmos W=0.205u L=0.04u
M25331 n2018 n2155 VSS VSS nmos W=0.135u L=0.04u
M25332 n2018 n2155 VDD VDD pmos W=0.205u L=0.04u
M25333 U2823/net28 U2823/net20 U2823/net64 VSS nmos W=0.155u L=0.04u
M25334 U2823/net24 U2823/net30 U2823/net32 VSS nmos W=0.155u L=0.04u
M25335 U2823/net28 U2823/net40 U2823/net24 VSS nmos W=0.155u L=0.04u
M25336 U2823/net40 WX3407 U2823/net108 VSS nmos W=0.155u L=0.04u
M25337 U2823/net40 U2823/net106 U2823/net104 VSS nmos W=0.155u L=0.04u
M25338 U2823/net24 WX3343 U2823/net050 VSS nmos W=0.155u L=0.04u
M25339 U2823/net050 U2823/net32 VSS VSS nmos W=0.155u L=0.04u
M25340 U2823/net20 U2823/net40 VSS VSS nmos W=0.155u L=0.04u
M25341 U2823/net106 WX3407 VSS VSS nmos W=0.155u L=0.04u
M25342 U2823/net104 WX3471 VSS VSS nmos W=0.155u L=0.04u
M25343 U2823/net30 WX3343 VSS VSS nmos W=0.155u L=0.04u
M25344 U2823/net108 U2823/net104 VSS VSS nmos W=0.155u L=0.04u
M25345 n2155 U2823/net28 VSS VSS nmos W=0.155u L=0.04u
M25346 U2823/net32 WX3279 VSS VSS nmos W=0.155u L=0.04u
M25347 U2823/net64 U2823/net24 VSS VSS nmos W=0.2u L=0.04u
M25348 U2823/net28 U2823/net40 U2823/net64 VDD pmos W=0.205u L=0.04u
M25349 U2823/net24 WX3343 U2823/net32 VDD pmos W=0.205u L=0.04u
M25350 U2823/net28 U2823/net20 U2823/net24 VDD pmos W=0.205u L=0.04u
M25351 U2823/net40 U2823/net106 U2823/net108 VDD pmos W=0.205u L=0.04u
M25352 U2823/net40 WX3407 U2823/net104 VDD pmos W=0.205u L=0.04u
M25353 U2823/net20 U2823/net40 VDD VDD pmos W=0.205u L=0.04u
M25354 U2823/net106 WX3407 VDD VDD pmos W=0.205u L=0.04u
M25355 U2823/net104 WX3471 VDD VDD pmos W=0.205u L=0.04u
M25356 U2823/net30 WX3343 VDD VDD pmos W=0.205u L=0.04u
M25357 U2823/net108 U2823/net104 VDD VDD pmos W=0.205u L=0.04u
M25358 n2155 U2823/net28 VDD VDD pmos W=0.205u L=0.04u
M25359 U2823/net32 WX3279 VDD VDD pmos W=0.205u L=0.04u
M25360 U2823/net64 U2823/net24 VDD VDD pmos W=0.28u L=0.04u
M25361 U2823/net24 U2823/net30 U2823/net045 VDD pmos W=0.205u L=0.04u
M25362 U2823/net045 U2823/net32 VDD VDD pmos W=0.205u L=0.04u
M25363 n1980 n2156 VSS VSS nmos W=0.135u L=0.04u
M25364 n1980 n2156 VDD VDD pmos W=0.205u L=0.04u
M25365 U2825/net28 U2825/net20 U2825/net64 VSS nmos W=0.155u L=0.04u
M25366 U2825/net24 U2825/net30 U2825/net32 VSS nmos W=0.155u L=0.04u
M25367 U2825/net28 U2825/net40 U2825/net24 VSS nmos W=0.155u L=0.04u
M25368 U2825/net40 WX2114 U2825/net108 VSS nmos W=0.155u L=0.04u
M25369 U2825/net40 U2825/net106 U2825/net104 VSS nmos W=0.155u L=0.04u
M25370 U2825/net24 WX2050 U2825/net050 VSS nmos W=0.155u L=0.04u
M25371 U2825/net050 U2825/net32 VSS VSS nmos W=0.155u L=0.04u
M25372 U2825/net20 U2825/net40 VSS VSS nmos W=0.155u L=0.04u
M25373 U2825/net106 WX2114 VSS VSS nmos W=0.155u L=0.04u
M25374 U2825/net104 WX2178 VSS VSS nmos W=0.155u L=0.04u
M25375 U2825/net30 WX2050 VSS VSS nmos W=0.155u L=0.04u
M25376 U2825/net108 U2825/net104 VSS VSS nmos W=0.155u L=0.04u
M25377 n2156 U2825/net28 VSS VSS nmos W=0.155u L=0.04u
M25378 U2825/net32 WX1986 VSS VSS nmos W=0.155u L=0.04u
M25379 U2825/net64 U2825/net24 VSS VSS nmos W=0.2u L=0.04u
M25380 U2825/net28 U2825/net40 U2825/net64 VDD pmos W=0.205u L=0.04u
M25381 U2825/net24 WX2050 U2825/net32 VDD pmos W=0.205u L=0.04u
M25382 U2825/net28 U2825/net20 U2825/net24 VDD pmos W=0.205u L=0.04u
M25383 U2825/net40 U2825/net106 U2825/net108 VDD pmos W=0.205u L=0.04u
M25384 U2825/net40 WX2114 U2825/net104 VDD pmos W=0.205u L=0.04u
M25385 U2825/net20 U2825/net40 VDD VDD pmos W=0.205u L=0.04u
M25386 U2825/net106 WX2114 VDD VDD pmos W=0.205u L=0.04u
M25387 U2825/net104 WX2178 VDD VDD pmos W=0.205u L=0.04u
M25388 U2825/net30 WX2050 VDD VDD pmos W=0.205u L=0.04u
M25389 U2825/net108 U2825/net104 VDD VDD pmos W=0.205u L=0.04u
M25390 n2156 U2825/net28 VDD VDD pmos W=0.205u L=0.04u
M25391 U2825/net32 WX1986 VDD VDD pmos W=0.205u L=0.04u
M25392 U2825/net64 U2825/net24 VDD VDD pmos W=0.28u L=0.04u
M25393 U2825/net24 U2825/net30 U2825/net045 VDD pmos W=0.205u L=0.04u
M25394 U2825/net045 U2825/net32 VDD VDD pmos W=0.205u L=0.04u
M25395 WX1653 n1242 U2826/net26 VSS nmos W=0.155u L=0.04u
M25396 WX1653 n1983 U2826/net26 VSS nmos W=0.155u L=0.04u
M25397 U2826/net29 n2157 VSS VSS nmos W=0.155u L=0.04u
M25398 U2826/net26 n2021 U2826/net29 VSS nmos W=0.155u L=0.04u
M25399 U2826/net26 n1291 U2826/net29 VSS nmos W=0.155u L=0.04u
M25400 WX1653 n1983 U2826/net43 VDD pmos W=0.205u L=0.04u
M25401 WX1653 n1291 U2826/net49 VDD pmos W=0.205u L=0.04u
M25402 U2826/net49 n2021 VDD VDD pmos W=0.205u L=0.04u
M25403 U2826/net43 n1242 VDD VDD pmos W=0.205u L=0.04u
M25404 WX1653 n2157 VDD VDD pmos W=0.205u L=0.04u
M25405 U2827/net29 n1347 VSS VSS nmos W=0.155u L=0.04u
M25406 n2157 WX1824 U2827/net29 VSS nmos W=0.155u L=0.04u
M25407 n2157 n1314 U2827/net23 VSS nmos W=0.155u L=0.04u
M25408 U2827/net23 CRC_OUT_8_8 VSS VSS nmos W=0.155u L=0.04u
M25409 U2827/net20 CRC_OUT_8_8 n2157 VDD pmos W=0.205u L=0.04u
M25410 U2827/net20 n1314 n2157 VDD pmos W=0.205u L=0.04u
M25411 VDD WX1824 U2827/net20 VDD pmos W=0.205u L=0.04u
M25412 VDD n1347 U2827/net20 VDD pmos W=0.205u L=0.04u
M25413 n2021 n2158 VSS VSS nmos W=0.135u L=0.04u
M25414 n2021 n2158 VDD VDD pmos W=0.205u L=0.04u
M25415 U2829/net28 U2829/net20 U2829/net64 VSS nmos W=0.155u L=0.04u
M25416 U2829/net24 U2829/net30 U2829/net32 VSS nmos W=0.155u L=0.04u
M25417 U2829/net28 U2829/net40 U2829/net24 VSS nmos W=0.155u L=0.04u
M25418 U2829/net40 WX3405 U2829/net108 VSS nmos W=0.155u L=0.04u
M25419 U2829/net40 U2829/net106 U2829/net104 VSS nmos W=0.155u L=0.04u
M25420 U2829/net24 WX3341 U2829/net050 VSS nmos W=0.155u L=0.04u
M25421 U2829/net050 U2829/net32 VSS VSS nmos W=0.155u L=0.04u
M25422 U2829/net20 U2829/net40 VSS VSS nmos W=0.155u L=0.04u
M25423 U2829/net106 WX3405 VSS VSS nmos W=0.155u L=0.04u
M25424 U2829/net104 WX3469 VSS VSS nmos W=0.155u L=0.04u
M25425 U2829/net30 WX3341 VSS VSS nmos W=0.155u L=0.04u
M25426 U2829/net108 U2829/net104 VSS VSS nmos W=0.155u L=0.04u
M25427 n2158 U2829/net28 VSS VSS nmos W=0.155u L=0.04u
M25428 U2829/net32 WX3277 VSS VSS nmos W=0.155u L=0.04u
M25429 U2829/net64 U2829/net24 VSS VSS nmos W=0.2u L=0.04u
M25430 U2829/net28 U2829/net40 U2829/net64 VDD pmos W=0.205u L=0.04u
M25431 U2829/net24 WX3341 U2829/net32 VDD pmos W=0.205u L=0.04u
M25432 U2829/net28 U2829/net20 U2829/net24 VDD pmos W=0.205u L=0.04u
M25433 U2829/net40 U2829/net106 U2829/net108 VDD pmos W=0.205u L=0.04u
M25434 U2829/net40 WX3405 U2829/net104 VDD pmos W=0.205u L=0.04u
M25435 U2829/net20 U2829/net40 VDD VDD pmos W=0.205u L=0.04u
M25436 U2829/net106 WX3405 VDD VDD pmos W=0.205u L=0.04u
M25437 U2829/net104 WX3469 VDD VDD pmos W=0.205u L=0.04u
M25438 U2829/net30 WX3341 VDD VDD pmos W=0.205u L=0.04u
M25439 U2829/net108 U2829/net104 VDD VDD pmos W=0.205u L=0.04u
M25440 n2158 U2829/net28 VDD VDD pmos W=0.205u L=0.04u
M25441 U2829/net32 WX3277 VDD VDD pmos W=0.205u L=0.04u
M25442 U2829/net64 U2829/net24 VDD VDD pmos W=0.28u L=0.04u
M25443 U2829/net24 U2829/net30 U2829/net045 VDD pmos W=0.205u L=0.04u
M25444 U2829/net045 U2829/net32 VDD VDD pmos W=0.205u L=0.04u
M25445 n1983 n2159 VSS VSS nmos W=0.135u L=0.04u
M25446 n1983 n2159 VDD VDD pmos W=0.205u L=0.04u
M25447 U2831/net28 U2831/net20 U2831/net64 VSS nmos W=0.155u L=0.04u
M25448 U2831/net24 U2831/net30 U2831/net32 VSS nmos W=0.155u L=0.04u
M25449 U2831/net28 U2831/net40 U2831/net24 VSS nmos W=0.155u L=0.04u
M25450 U2831/net40 WX2112 U2831/net108 VSS nmos W=0.155u L=0.04u
M25451 U2831/net40 U2831/net106 U2831/net104 VSS nmos W=0.155u L=0.04u
M25452 U2831/net24 WX2048 U2831/net050 VSS nmos W=0.155u L=0.04u
M25453 U2831/net050 U2831/net32 VSS VSS nmos W=0.155u L=0.04u
M25454 U2831/net20 U2831/net40 VSS VSS nmos W=0.155u L=0.04u
M25455 U2831/net106 WX2112 VSS VSS nmos W=0.155u L=0.04u
M25456 U2831/net104 WX2176 VSS VSS nmos W=0.155u L=0.04u
M25457 U2831/net30 WX2048 VSS VSS nmos W=0.155u L=0.04u
M25458 U2831/net108 U2831/net104 VSS VSS nmos W=0.155u L=0.04u
M25459 n2159 U2831/net28 VSS VSS nmos W=0.155u L=0.04u
M25460 U2831/net32 WX1984 VSS VSS nmos W=0.155u L=0.04u
M25461 U2831/net64 U2831/net24 VSS VSS nmos W=0.2u L=0.04u
M25462 U2831/net28 U2831/net40 U2831/net64 VDD pmos W=0.205u L=0.04u
M25463 U2831/net24 WX2048 U2831/net32 VDD pmos W=0.205u L=0.04u
M25464 U2831/net28 U2831/net20 U2831/net24 VDD pmos W=0.205u L=0.04u
M25465 U2831/net40 U2831/net106 U2831/net108 VDD pmos W=0.205u L=0.04u
M25466 U2831/net40 WX2112 U2831/net104 VDD pmos W=0.205u L=0.04u
M25467 U2831/net20 U2831/net40 VDD VDD pmos W=0.205u L=0.04u
M25468 U2831/net106 WX2112 VDD VDD pmos W=0.205u L=0.04u
M25469 U2831/net104 WX2176 VDD VDD pmos W=0.205u L=0.04u
M25470 U2831/net30 WX2048 VDD VDD pmos W=0.205u L=0.04u
M25471 U2831/net108 U2831/net104 VDD VDD pmos W=0.205u L=0.04u
M25472 n2159 U2831/net28 VDD VDD pmos W=0.205u L=0.04u
M25473 U2831/net32 WX1984 VDD VDD pmos W=0.205u L=0.04u
M25474 U2831/net64 U2831/net24 VDD VDD pmos W=0.28u L=0.04u
M25475 U2831/net24 U2831/net30 U2831/net045 VDD pmos W=0.205u L=0.04u
M25476 U2831/net045 U2831/net32 VDD VDD pmos W=0.205u L=0.04u
M25477 WX164 n1281 U2832/net26 VSS nmos W=0.155u L=0.04u
M25478 WX164 n2160 U2832/net26 VSS nmos W=0.155u L=0.04u
M25479 U2832/net29 n2162 VSS VSS nmos W=0.155u L=0.04u
M25480 U2832/net26 n2161 U2832/net29 VSS nmos W=0.155u L=0.04u
M25481 U2832/net26 n1253 U2832/net29 VSS nmos W=0.155u L=0.04u
M25482 WX164 n2160 U2832/net43 VDD pmos W=0.205u L=0.04u
M25483 WX164 n1253 U2832/net49 VDD pmos W=0.205u L=0.04u
M25484 U2832/net49 n2161 VDD VDD pmos W=0.205u L=0.04u
M25485 U2832/net43 n1281 VDD VDD pmos W=0.205u L=0.04u
M25486 WX164 n2162 VDD VDD pmos W=0.205u L=0.04u
M25487 U2833/net29 n1347 VSS VSS nmos W=0.155u L=0.04u
M25488 n2162 WX503 U2833/net29 VSS nmos W=0.155u L=0.04u
M25489 n2162 n1314 U2833/net23 VSS nmos W=0.155u L=0.04u
M25490 U2833/net23 CRC_OUT_9_22 VSS VSS nmos W=0.155u L=0.04u
M25491 U2833/net20 CRC_OUT_9_22 n2162 VDD pmos W=0.205u L=0.04u
M25492 U2833/net20 n1314 n2162 VDD pmos W=0.205u L=0.04u
M25493 VDD WX503 U2833/net20 VDD pmos W=0.205u L=0.04u
M25494 VDD n1347 U2833/net20 VDD pmos W=0.205u L=0.04u
M25495 WX1639 n1242 U2834/net26 VSS nmos W=0.155u L=0.04u
M25496 WX1639 n1986 U2834/net26 VSS nmos W=0.155u L=0.04u
M25497 U2834/net29 n2163 VSS VSS nmos W=0.155u L=0.04u
M25498 U2834/net26 n2024 U2834/net29 VSS nmos W=0.155u L=0.04u
M25499 U2834/net26 n1291 U2834/net29 VSS nmos W=0.155u L=0.04u
M25500 WX1639 n1986 U2834/net43 VDD pmos W=0.205u L=0.04u
M25501 WX1639 n1291 U2834/net49 VDD pmos W=0.205u L=0.04u
M25502 U2834/net49 n2024 VDD VDD pmos W=0.205u L=0.04u
M25503 U2834/net43 n1242 VDD VDD pmos W=0.205u L=0.04u
M25504 WX1639 n2163 VDD VDD pmos W=0.205u L=0.04u
M25505 U2835/net29 n1347 VSS VSS nmos W=0.155u L=0.04u
M25506 n2163 WX1822 U2835/net29 VSS nmos W=0.155u L=0.04u
M25507 n2163 n1314 U2835/net23 VSS nmos W=0.155u L=0.04u
M25508 U2835/net23 CRC_OUT_8_9 VSS VSS nmos W=0.155u L=0.04u
M25509 U2835/net20 CRC_OUT_8_9 n2163 VDD pmos W=0.205u L=0.04u
M25510 U2835/net20 n1314 n2163 VDD pmos W=0.205u L=0.04u
M25511 VDD WX1822 U2835/net20 VDD pmos W=0.205u L=0.04u
M25512 VDD n1347 U2835/net20 VDD pmos W=0.205u L=0.04u
M25513 n2024 n2164 VSS VSS nmos W=0.135u L=0.04u
M25514 n2024 n2164 VDD VDD pmos W=0.205u L=0.04u
M25515 U2837/net28 U2837/net20 U2837/net64 VSS nmos W=0.155u L=0.04u
M25516 U2837/net24 U2837/net30 U2837/net32 VSS nmos W=0.155u L=0.04u
M25517 U2837/net28 U2837/net40 U2837/net24 VSS nmos W=0.155u L=0.04u
M25518 U2837/net40 WX3403 U2837/net108 VSS nmos W=0.155u L=0.04u
M25519 U2837/net40 U2837/net106 U2837/net104 VSS nmos W=0.155u L=0.04u
M25520 U2837/net24 WX3339 U2837/net050 VSS nmos W=0.155u L=0.04u
M25521 U2837/net050 U2837/net32 VSS VSS nmos W=0.155u L=0.04u
M25522 U2837/net20 U2837/net40 VSS VSS nmos W=0.155u L=0.04u
M25523 U2837/net106 WX3403 VSS VSS nmos W=0.155u L=0.04u
M25524 U2837/net104 WX3467 VSS VSS nmos W=0.155u L=0.04u
M25525 U2837/net30 WX3339 VSS VSS nmos W=0.155u L=0.04u
M25526 U2837/net108 U2837/net104 VSS VSS nmos W=0.155u L=0.04u
M25527 n2164 U2837/net28 VSS VSS nmos W=0.155u L=0.04u
M25528 U2837/net32 WX3275 VSS VSS nmos W=0.155u L=0.04u
M25529 U2837/net64 U2837/net24 VSS VSS nmos W=0.2u L=0.04u
M25530 U2837/net28 U2837/net40 U2837/net64 VDD pmos W=0.205u L=0.04u
M25531 U2837/net24 WX3339 U2837/net32 VDD pmos W=0.205u L=0.04u
M25532 U2837/net28 U2837/net20 U2837/net24 VDD pmos W=0.205u L=0.04u
M25533 U2837/net40 U2837/net106 U2837/net108 VDD pmos W=0.205u L=0.04u
M25534 U2837/net40 WX3403 U2837/net104 VDD pmos W=0.205u L=0.04u
M25535 U2837/net20 U2837/net40 VDD VDD pmos W=0.205u L=0.04u
M25536 U2837/net106 WX3403 VDD VDD pmos W=0.205u L=0.04u
M25537 U2837/net104 WX3467 VDD VDD pmos W=0.205u L=0.04u
M25538 U2837/net30 WX3339 VDD VDD pmos W=0.205u L=0.04u
M25539 U2837/net108 U2837/net104 VDD VDD pmos W=0.205u L=0.04u
M25540 n2164 U2837/net28 VDD VDD pmos W=0.205u L=0.04u
M25541 U2837/net32 WX3275 VDD VDD pmos W=0.205u L=0.04u
M25542 U2837/net64 U2837/net24 VDD VDD pmos W=0.28u L=0.04u
M25543 U2837/net24 U2837/net30 U2837/net045 VDD pmos W=0.205u L=0.04u
M25544 U2837/net045 U2837/net32 VDD VDD pmos W=0.205u L=0.04u
M25545 n1986 n2165 VSS VSS nmos W=0.135u L=0.04u
M25546 n1986 n2165 VDD VDD pmos W=0.205u L=0.04u
M25547 U2839/net28 U2839/net20 U2839/net64 VSS nmos W=0.155u L=0.04u
M25548 U2839/net24 U2839/net30 U2839/net32 VSS nmos W=0.155u L=0.04u
M25549 U2839/net28 U2839/net40 U2839/net24 VSS nmos W=0.155u L=0.04u
M25550 U2839/net40 WX2110 U2839/net108 VSS nmos W=0.155u L=0.04u
M25551 U2839/net40 U2839/net106 U2839/net104 VSS nmos W=0.155u L=0.04u
M25552 U2839/net24 WX2046 U2839/net050 VSS nmos W=0.155u L=0.04u
M25553 U2839/net050 U2839/net32 VSS VSS nmos W=0.155u L=0.04u
M25554 U2839/net20 U2839/net40 VSS VSS nmos W=0.155u L=0.04u
M25555 U2839/net106 WX2110 VSS VSS nmos W=0.155u L=0.04u
M25556 U2839/net104 WX2174 VSS VSS nmos W=0.155u L=0.04u
M25557 U2839/net30 WX2046 VSS VSS nmos W=0.155u L=0.04u
M25558 U2839/net108 U2839/net104 VSS VSS nmos W=0.155u L=0.04u
M25559 n2165 U2839/net28 VSS VSS nmos W=0.155u L=0.04u
M25560 U2839/net32 WX1982 VSS VSS nmos W=0.155u L=0.04u
M25561 U2839/net64 U2839/net24 VSS VSS nmos W=0.2u L=0.04u
M25562 U2839/net28 U2839/net40 U2839/net64 VDD pmos W=0.205u L=0.04u
M25563 U2839/net24 WX2046 U2839/net32 VDD pmos W=0.205u L=0.04u
M25564 U2839/net28 U2839/net20 U2839/net24 VDD pmos W=0.205u L=0.04u
M25565 U2839/net40 U2839/net106 U2839/net108 VDD pmos W=0.205u L=0.04u
M25566 U2839/net40 WX2110 U2839/net104 VDD pmos W=0.205u L=0.04u
M25567 U2839/net20 U2839/net40 VDD VDD pmos W=0.205u L=0.04u
M25568 U2839/net106 WX2110 VDD VDD pmos W=0.205u L=0.04u
M25569 U2839/net104 WX2174 VDD VDD pmos W=0.205u L=0.04u
M25570 U2839/net30 WX2046 VDD VDD pmos W=0.205u L=0.04u
M25571 U2839/net108 U2839/net104 VDD VDD pmos W=0.205u L=0.04u
M25572 n2165 U2839/net28 VDD VDD pmos W=0.205u L=0.04u
M25573 U2839/net32 WX1982 VDD VDD pmos W=0.205u L=0.04u
M25574 U2839/net64 U2839/net24 VDD VDD pmos W=0.28u L=0.04u
M25575 U2839/net24 U2839/net30 U2839/net045 VDD pmos W=0.205u L=0.04u
M25576 U2839/net045 U2839/net32 VDD VDD pmos W=0.205u L=0.04u
M25577 WX1625 n1242 U2840/net26 VSS nmos W=0.155u L=0.04u
M25578 WX1625 n1989 U2840/net26 VSS nmos W=0.155u L=0.04u
M25579 U2840/net29 n2166 VSS VSS nmos W=0.155u L=0.04u
M25580 U2840/net26 n2027 U2840/net29 VSS nmos W=0.155u L=0.04u
M25581 U2840/net26 n1291 U2840/net29 VSS nmos W=0.155u L=0.04u
M25582 WX1625 n1989 U2840/net43 VDD pmos W=0.205u L=0.04u
M25583 WX1625 n1291 U2840/net49 VDD pmos W=0.205u L=0.04u
M25584 U2840/net49 n2027 VDD VDD pmos W=0.205u L=0.04u
M25585 U2840/net43 n1242 VDD VDD pmos W=0.205u L=0.04u
M25586 WX1625 n2166 VDD VDD pmos W=0.205u L=0.04u
M25587 U2841/net29 n1347 VSS VSS nmos W=0.155u L=0.04u
M25588 n2166 WX1820 U2841/net29 VSS nmos W=0.155u L=0.04u
M25589 n2166 n1314 U2841/net23 VSS nmos W=0.155u L=0.04u
M25590 U2841/net23 CRC_OUT_8_10 VSS VSS nmos W=0.155u L=0.04u
M25591 U2841/net20 CRC_OUT_8_10 n2166 VDD pmos W=0.205u L=0.04u
M25592 U2841/net20 n1314 n2166 VDD pmos W=0.205u L=0.04u
M25593 VDD WX1820 U2841/net20 VDD pmos W=0.205u L=0.04u
M25594 VDD n1347 U2841/net20 VDD pmos W=0.205u L=0.04u
M25595 n2027 n2167 VSS VSS nmos W=0.135u L=0.04u
M25596 n2027 n2167 VDD VDD pmos W=0.205u L=0.04u
M25597 U2843/net28 U2843/net20 U2843/net64 VSS nmos W=0.155u L=0.04u
M25598 U2843/net24 U2843/net30 U2843/net32 VSS nmos W=0.155u L=0.04u
M25599 U2843/net28 U2843/net40 U2843/net24 VSS nmos W=0.155u L=0.04u
M25600 U2843/net40 WX3401 U2843/net108 VSS nmos W=0.155u L=0.04u
M25601 U2843/net40 U2843/net106 U2843/net104 VSS nmos W=0.155u L=0.04u
M25602 U2843/net24 WX3337 U2843/net050 VSS nmos W=0.155u L=0.04u
M25603 U2843/net050 U2843/net32 VSS VSS nmos W=0.155u L=0.04u
M25604 U2843/net20 U2843/net40 VSS VSS nmos W=0.155u L=0.04u
M25605 U2843/net106 WX3401 VSS VSS nmos W=0.155u L=0.04u
M25606 U2843/net104 WX3465 VSS VSS nmos W=0.155u L=0.04u
M25607 U2843/net30 WX3337 VSS VSS nmos W=0.155u L=0.04u
M25608 U2843/net108 U2843/net104 VSS VSS nmos W=0.155u L=0.04u
M25609 n2167 U2843/net28 VSS VSS nmos W=0.155u L=0.04u
M25610 U2843/net32 WX3273 VSS VSS nmos W=0.155u L=0.04u
M25611 U2843/net64 U2843/net24 VSS VSS nmos W=0.2u L=0.04u
M25612 U2843/net28 U2843/net40 U2843/net64 VDD pmos W=0.205u L=0.04u
M25613 U2843/net24 WX3337 U2843/net32 VDD pmos W=0.205u L=0.04u
M25614 U2843/net28 U2843/net20 U2843/net24 VDD pmos W=0.205u L=0.04u
M25615 U2843/net40 U2843/net106 U2843/net108 VDD pmos W=0.205u L=0.04u
M25616 U2843/net40 WX3401 U2843/net104 VDD pmos W=0.205u L=0.04u
M25617 U2843/net20 U2843/net40 VDD VDD pmos W=0.205u L=0.04u
M25618 U2843/net106 WX3401 VDD VDD pmos W=0.205u L=0.04u
M25619 U2843/net104 WX3465 VDD VDD pmos W=0.205u L=0.04u
M25620 U2843/net30 WX3337 VDD VDD pmos W=0.205u L=0.04u
M25621 U2843/net108 U2843/net104 VDD VDD pmos W=0.205u L=0.04u
M25622 n2167 U2843/net28 VDD VDD pmos W=0.205u L=0.04u
M25623 U2843/net32 WX3273 VDD VDD pmos W=0.205u L=0.04u
M25624 U2843/net64 U2843/net24 VDD VDD pmos W=0.28u L=0.04u
M25625 U2843/net24 U2843/net30 U2843/net045 VDD pmos W=0.205u L=0.04u
M25626 U2843/net045 U2843/net32 VDD VDD pmos W=0.205u L=0.04u
M25627 n1989 n2168 VSS VSS nmos W=0.135u L=0.04u
M25628 n1989 n2168 VDD VDD pmos W=0.205u L=0.04u
M25629 U2845/net28 U2845/net20 U2845/net64 VSS nmos W=0.155u L=0.04u
M25630 U2845/net24 U2845/net30 U2845/net32 VSS nmos W=0.155u L=0.04u
M25631 U2845/net28 U2845/net40 U2845/net24 VSS nmos W=0.155u L=0.04u
M25632 U2845/net40 WX2108 U2845/net108 VSS nmos W=0.155u L=0.04u
M25633 U2845/net40 U2845/net106 U2845/net104 VSS nmos W=0.155u L=0.04u
M25634 U2845/net24 WX2044 U2845/net050 VSS nmos W=0.155u L=0.04u
M25635 U2845/net050 U2845/net32 VSS VSS nmos W=0.155u L=0.04u
M25636 U2845/net20 U2845/net40 VSS VSS nmos W=0.155u L=0.04u
M25637 U2845/net106 WX2108 VSS VSS nmos W=0.155u L=0.04u
M25638 U2845/net104 WX2172 VSS VSS nmos W=0.155u L=0.04u
M25639 U2845/net30 WX2044 VSS VSS nmos W=0.155u L=0.04u
M25640 U2845/net108 U2845/net104 VSS VSS nmos W=0.155u L=0.04u
M25641 n2168 U2845/net28 VSS VSS nmos W=0.155u L=0.04u
M25642 U2845/net32 WX1980 VSS VSS nmos W=0.155u L=0.04u
M25643 U2845/net64 U2845/net24 VSS VSS nmos W=0.2u L=0.04u
M25644 U2845/net28 U2845/net40 U2845/net64 VDD pmos W=0.205u L=0.04u
M25645 U2845/net24 WX2044 U2845/net32 VDD pmos W=0.205u L=0.04u
M25646 U2845/net28 U2845/net20 U2845/net24 VDD pmos W=0.205u L=0.04u
M25647 U2845/net40 U2845/net106 U2845/net108 VDD pmos W=0.205u L=0.04u
M25648 U2845/net40 WX2108 U2845/net104 VDD pmos W=0.205u L=0.04u
M25649 U2845/net20 U2845/net40 VDD VDD pmos W=0.205u L=0.04u
M25650 U2845/net106 WX2108 VDD VDD pmos W=0.205u L=0.04u
M25651 U2845/net104 WX2172 VDD VDD pmos W=0.205u L=0.04u
M25652 U2845/net30 WX2044 VDD VDD pmos W=0.205u L=0.04u
M25653 U2845/net108 U2845/net104 VDD VDD pmos W=0.205u L=0.04u
M25654 n2168 U2845/net28 VDD VDD pmos W=0.205u L=0.04u
M25655 U2845/net32 WX1980 VDD VDD pmos W=0.205u L=0.04u
M25656 U2845/net64 U2845/net24 VDD VDD pmos W=0.28u L=0.04u
M25657 U2845/net24 U2845/net30 U2845/net045 VDD pmos W=0.205u L=0.04u
M25658 U2845/net045 U2845/net32 VDD VDD pmos W=0.205u L=0.04u
M25659 WX1611 n1242 U2846/net26 VSS nmos W=0.155u L=0.04u
M25660 WX1611 n1992 U2846/net26 VSS nmos W=0.155u L=0.04u
M25661 U2846/net29 n2169 VSS VSS nmos W=0.155u L=0.04u
M25662 U2846/net26 n2030 U2846/net29 VSS nmos W=0.155u L=0.04u
M25663 U2846/net26 n1290 U2846/net29 VSS nmos W=0.155u L=0.04u
M25664 WX1611 n1992 U2846/net43 VDD pmos W=0.205u L=0.04u
M25665 WX1611 n1290 U2846/net49 VDD pmos W=0.205u L=0.04u
M25666 U2846/net49 n2030 VDD VDD pmos W=0.205u L=0.04u
M25667 U2846/net43 n1242 VDD VDD pmos W=0.205u L=0.04u
M25668 WX1611 n2169 VDD VDD pmos W=0.205u L=0.04u
M25669 U2847/net29 n1347 VSS VSS nmos W=0.155u L=0.04u
M25670 n2169 WX1818 U2847/net29 VSS nmos W=0.155u L=0.04u
M25671 n2169 n1314 U2847/net23 VSS nmos W=0.155u L=0.04u
M25672 U2847/net23 CRC_OUT_8_11 VSS VSS nmos W=0.155u L=0.04u
M25673 U2847/net20 CRC_OUT_8_11 n2169 VDD pmos W=0.205u L=0.04u
M25674 U2847/net20 n1314 n2169 VDD pmos W=0.205u L=0.04u
M25675 VDD WX1818 U2847/net20 VDD pmos W=0.205u L=0.04u
M25676 VDD n1347 U2847/net20 VDD pmos W=0.205u L=0.04u
M25677 n2030 n2170 VSS VSS nmos W=0.135u L=0.04u
M25678 n2030 n2170 VDD VDD pmos W=0.205u L=0.04u
M25679 U2849/net28 U2849/net20 U2849/net64 VSS nmos W=0.155u L=0.04u
M25680 U2849/net24 U2849/net30 U2849/net32 VSS nmos W=0.155u L=0.04u
M25681 U2849/net28 U2849/net40 U2849/net24 VSS nmos W=0.155u L=0.04u
M25682 U2849/net40 WX3399 U2849/net108 VSS nmos W=0.155u L=0.04u
M25683 U2849/net40 U2849/net106 U2849/net104 VSS nmos W=0.155u L=0.04u
M25684 U2849/net24 WX3335 U2849/net050 VSS nmos W=0.155u L=0.04u
M25685 U2849/net050 U2849/net32 VSS VSS nmos W=0.155u L=0.04u
M25686 U2849/net20 U2849/net40 VSS VSS nmos W=0.155u L=0.04u
M25687 U2849/net106 WX3399 VSS VSS nmos W=0.155u L=0.04u
M25688 U2849/net104 WX3463 VSS VSS nmos W=0.155u L=0.04u
M25689 U2849/net30 WX3335 VSS VSS nmos W=0.155u L=0.04u
M25690 U2849/net108 U2849/net104 VSS VSS nmos W=0.155u L=0.04u
M25691 n2170 U2849/net28 VSS VSS nmos W=0.155u L=0.04u
M25692 U2849/net32 WX3271 VSS VSS nmos W=0.155u L=0.04u
M25693 U2849/net64 U2849/net24 VSS VSS nmos W=0.2u L=0.04u
M25694 U2849/net28 U2849/net40 U2849/net64 VDD pmos W=0.205u L=0.04u
M25695 U2849/net24 WX3335 U2849/net32 VDD pmos W=0.205u L=0.04u
M25696 U2849/net28 U2849/net20 U2849/net24 VDD pmos W=0.205u L=0.04u
M25697 U2849/net40 U2849/net106 U2849/net108 VDD pmos W=0.205u L=0.04u
M25698 U2849/net40 WX3399 U2849/net104 VDD pmos W=0.205u L=0.04u
M25699 U2849/net20 U2849/net40 VDD VDD pmos W=0.205u L=0.04u
M25700 U2849/net106 WX3399 VDD VDD pmos W=0.205u L=0.04u
M25701 U2849/net104 WX3463 VDD VDD pmos W=0.205u L=0.04u
M25702 U2849/net30 WX3335 VDD VDD pmos W=0.205u L=0.04u
M25703 U2849/net108 U2849/net104 VDD VDD pmos W=0.205u L=0.04u
M25704 n2170 U2849/net28 VDD VDD pmos W=0.205u L=0.04u
M25705 U2849/net32 WX3271 VDD VDD pmos W=0.205u L=0.04u
M25706 U2849/net64 U2849/net24 VDD VDD pmos W=0.28u L=0.04u
M25707 U2849/net24 U2849/net30 U2849/net045 VDD pmos W=0.205u L=0.04u
M25708 U2849/net045 U2849/net32 VDD VDD pmos W=0.205u L=0.04u
M25709 n1992 n2171 VSS VSS nmos W=0.135u L=0.04u
M25710 n1992 n2171 VDD VDD pmos W=0.205u L=0.04u
M25711 U2851/net28 U2851/net20 U2851/net64 VSS nmos W=0.155u L=0.04u
M25712 U2851/net24 U2851/net30 U2851/net32 VSS nmos W=0.155u L=0.04u
M25713 U2851/net28 U2851/net40 U2851/net24 VSS nmos W=0.155u L=0.04u
M25714 U2851/net40 WX2106 U2851/net108 VSS nmos W=0.155u L=0.04u
M25715 U2851/net40 U2851/net106 U2851/net104 VSS nmos W=0.155u L=0.04u
M25716 U2851/net24 WX2042 U2851/net050 VSS nmos W=0.155u L=0.04u
M25717 U2851/net050 U2851/net32 VSS VSS nmos W=0.155u L=0.04u
M25718 U2851/net20 U2851/net40 VSS VSS nmos W=0.155u L=0.04u
M25719 U2851/net106 WX2106 VSS VSS nmos W=0.155u L=0.04u
M25720 U2851/net104 WX2170 VSS VSS nmos W=0.155u L=0.04u
M25721 U2851/net30 WX2042 VSS VSS nmos W=0.155u L=0.04u
M25722 U2851/net108 U2851/net104 VSS VSS nmos W=0.155u L=0.04u
M25723 n2171 U2851/net28 VSS VSS nmos W=0.155u L=0.04u
M25724 U2851/net32 WX1978 VSS VSS nmos W=0.155u L=0.04u
M25725 U2851/net64 U2851/net24 VSS VSS nmos W=0.2u L=0.04u
M25726 U2851/net28 U2851/net40 U2851/net64 VDD pmos W=0.205u L=0.04u
M25727 U2851/net24 WX2042 U2851/net32 VDD pmos W=0.205u L=0.04u
M25728 U2851/net28 U2851/net20 U2851/net24 VDD pmos W=0.205u L=0.04u
M25729 U2851/net40 U2851/net106 U2851/net108 VDD pmos W=0.205u L=0.04u
M25730 U2851/net40 WX2106 U2851/net104 VDD pmos W=0.205u L=0.04u
M25731 U2851/net20 U2851/net40 VDD VDD pmos W=0.205u L=0.04u
M25732 U2851/net106 WX2106 VDD VDD pmos W=0.205u L=0.04u
M25733 U2851/net104 WX2170 VDD VDD pmos W=0.205u L=0.04u
M25734 U2851/net30 WX2042 VDD VDD pmos W=0.205u L=0.04u
M25735 U2851/net108 U2851/net104 VDD VDD pmos W=0.205u L=0.04u
M25736 n2171 U2851/net28 VDD VDD pmos W=0.205u L=0.04u
M25737 U2851/net32 WX1978 VDD VDD pmos W=0.205u L=0.04u
M25738 U2851/net64 U2851/net24 VDD VDD pmos W=0.28u L=0.04u
M25739 U2851/net24 U2851/net30 U2851/net045 VDD pmos W=0.205u L=0.04u
M25740 U2851/net045 U2851/net32 VDD VDD pmos W=0.205u L=0.04u
M25741 WX1597 n1242 U2852/net26 VSS nmos W=0.155u L=0.04u
M25742 WX1597 n2000 U2852/net26 VSS nmos W=0.155u L=0.04u
M25743 U2852/net29 n2172 VSS VSS nmos W=0.155u L=0.04u
M25744 U2852/net26 n2036 U2852/net29 VSS nmos W=0.155u L=0.04u
M25745 U2852/net26 n1290 U2852/net29 VSS nmos W=0.155u L=0.04u
M25746 WX1597 n2000 U2852/net43 VDD pmos W=0.205u L=0.04u
M25747 WX1597 n1290 U2852/net49 VDD pmos W=0.205u L=0.04u
M25748 U2852/net49 n2036 VDD VDD pmos W=0.205u L=0.04u
M25749 U2852/net43 n1242 VDD VDD pmos W=0.205u L=0.04u
M25750 WX1597 n2172 VDD VDD pmos W=0.205u L=0.04u
M25751 U2853/net29 n1347 VSS VSS nmos W=0.155u L=0.04u
M25752 n2172 WX1816 U2853/net29 VSS nmos W=0.155u L=0.04u
M25753 n2172 n1314 U2853/net23 VSS nmos W=0.155u L=0.04u
M25754 U2853/net23 CRC_OUT_8_12 VSS VSS nmos W=0.155u L=0.04u
M25755 U2853/net20 CRC_OUT_8_12 n2172 VDD pmos W=0.205u L=0.04u
M25756 U2853/net20 n1314 n2172 VDD pmos W=0.205u L=0.04u
M25757 VDD WX1816 U2853/net20 VDD pmos W=0.205u L=0.04u
M25758 VDD n1347 U2853/net20 VDD pmos W=0.205u L=0.04u
M25759 n2036 n2173 VSS VSS nmos W=0.135u L=0.04u
M25760 n2036 n2173 VDD VDD pmos W=0.205u L=0.04u
M25761 U2855/net28 U2855/net20 U2855/net64 VSS nmos W=0.155u L=0.04u
M25762 U2855/net24 U2855/net30 U2855/net32 VSS nmos W=0.155u L=0.04u
M25763 U2855/net28 U2855/net40 U2855/net24 VSS nmos W=0.155u L=0.04u
M25764 U2855/net40 WX3397 U2855/net108 VSS nmos W=0.155u L=0.04u
M25765 U2855/net40 U2855/net106 U2855/net104 VSS nmos W=0.155u L=0.04u
M25766 U2855/net24 WX3333 U2855/net050 VSS nmos W=0.155u L=0.04u
M25767 U2855/net050 U2855/net32 VSS VSS nmos W=0.155u L=0.04u
M25768 U2855/net20 U2855/net40 VSS VSS nmos W=0.155u L=0.04u
M25769 U2855/net106 WX3397 VSS VSS nmos W=0.155u L=0.04u
M25770 U2855/net104 WX3461 VSS VSS nmos W=0.155u L=0.04u
M25771 U2855/net30 WX3333 VSS VSS nmos W=0.155u L=0.04u
M25772 U2855/net108 U2855/net104 VSS VSS nmos W=0.155u L=0.04u
M25773 n2173 U2855/net28 VSS VSS nmos W=0.155u L=0.04u
M25774 U2855/net32 WX3269 VSS VSS nmos W=0.155u L=0.04u
M25775 U2855/net64 U2855/net24 VSS VSS nmos W=0.2u L=0.04u
M25776 U2855/net28 U2855/net40 U2855/net64 VDD pmos W=0.205u L=0.04u
M25777 U2855/net24 WX3333 U2855/net32 VDD pmos W=0.205u L=0.04u
M25778 U2855/net28 U2855/net20 U2855/net24 VDD pmos W=0.205u L=0.04u
M25779 U2855/net40 U2855/net106 U2855/net108 VDD pmos W=0.205u L=0.04u
M25780 U2855/net40 WX3397 U2855/net104 VDD pmos W=0.205u L=0.04u
M25781 U2855/net20 U2855/net40 VDD VDD pmos W=0.205u L=0.04u
M25782 U2855/net106 WX3397 VDD VDD pmos W=0.205u L=0.04u
M25783 U2855/net104 WX3461 VDD VDD pmos W=0.205u L=0.04u
M25784 U2855/net30 WX3333 VDD VDD pmos W=0.205u L=0.04u
M25785 U2855/net108 U2855/net104 VDD VDD pmos W=0.205u L=0.04u
M25786 n2173 U2855/net28 VDD VDD pmos W=0.205u L=0.04u
M25787 U2855/net32 WX3269 VDD VDD pmos W=0.205u L=0.04u
M25788 U2855/net64 U2855/net24 VDD VDD pmos W=0.28u L=0.04u
M25789 U2855/net24 U2855/net30 U2855/net045 VDD pmos W=0.205u L=0.04u
M25790 U2855/net045 U2855/net32 VDD VDD pmos W=0.205u L=0.04u
M25791 n2000 n2174 VSS VSS nmos W=0.135u L=0.04u
M25792 n2000 n2174 VDD VDD pmos W=0.205u L=0.04u
M25793 U2857/net28 U2857/net20 U2857/net64 VSS nmos W=0.155u L=0.04u
M25794 U2857/net24 U2857/net30 U2857/net32 VSS nmos W=0.155u L=0.04u
M25795 U2857/net28 U2857/net40 U2857/net24 VSS nmos W=0.155u L=0.04u
M25796 U2857/net40 WX2104 U2857/net108 VSS nmos W=0.155u L=0.04u
M25797 U2857/net40 U2857/net106 U2857/net104 VSS nmos W=0.155u L=0.04u
M25798 U2857/net24 WX2040 U2857/net050 VSS nmos W=0.155u L=0.04u
M25799 U2857/net050 U2857/net32 VSS VSS nmos W=0.155u L=0.04u
M25800 U2857/net20 U2857/net40 VSS VSS nmos W=0.155u L=0.04u
M25801 U2857/net106 WX2104 VSS VSS nmos W=0.155u L=0.04u
M25802 U2857/net104 WX2168 VSS VSS nmos W=0.155u L=0.04u
M25803 U2857/net30 WX2040 VSS VSS nmos W=0.155u L=0.04u
M25804 U2857/net108 U2857/net104 VSS VSS nmos W=0.155u L=0.04u
M25805 n2174 U2857/net28 VSS VSS nmos W=0.155u L=0.04u
M25806 U2857/net32 WX1976 VSS VSS nmos W=0.155u L=0.04u
M25807 U2857/net64 U2857/net24 VSS VSS nmos W=0.2u L=0.04u
M25808 U2857/net28 U2857/net40 U2857/net64 VDD pmos W=0.205u L=0.04u
M25809 U2857/net24 WX2040 U2857/net32 VDD pmos W=0.205u L=0.04u
M25810 U2857/net28 U2857/net20 U2857/net24 VDD pmos W=0.205u L=0.04u
M25811 U2857/net40 U2857/net106 U2857/net108 VDD pmos W=0.205u L=0.04u
M25812 U2857/net40 WX2104 U2857/net104 VDD pmos W=0.205u L=0.04u
M25813 U2857/net20 U2857/net40 VDD VDD pmos W=0.205u L=0.04u
M25814 U2857/net106 WX2104 VDD VDD pmos W=0.205u L=0.04u
M25815 U2857/net104 WX2168 VDD VDD pmos W=0.205u L=0.04u
M25816 U2857/net30 WX2040 VDD VDD pmos W=0.205u L=0.04u
M25817 U2857/net108 U2857/net104 VDD VDD pmos W=0.205u L=0.04u
M25818 n2174 U2857/net28 VDD VDD pmos W=0.205u L=0.04u
M25819 U2857/net32 WX1976 VDD VDD pmos W=0.205u L=0.04u
M25820 U2857/net64 U2857/net24 VDD VDD pmos W=0.28u L=0.04u
M25821 U2857/net24 U2857/net30 U2857/net045 VDD pmos W=0.205u L=0.04u
M25822 U2857/net045 U2857/net32 VDD VDD pmos W=0.205u L=0.04u
M25823 WX1583 n1242 U2858/net26 VSS nmos W=0.155u L=0.04u
M25824 WX1583 n2033 U2858/net26 VSS nmos W=0.155u L=0.04u
M25825 U2858/net29 n2175 VSS VSS nmos W=0.155u L=0.04u
M25826 U2858/net26 n2039 U2858/net29 VSS nmos W=0.155u L=0.04u
M25827 U2858/net26 n1290 U2858/net29 VSS nmos W=0.155u L=0.04u
M25828 WX1583 n2033 U2858/net43 VDD pmos W=0.205u L=0.04u
M25829 WX1583 n1290 U2858/net49 VDD pmos W=0.205u L=0.04u
M25830 U2858/net49 n2039 VDD VDD pmos W=0.205u L=0.04u
M25831 U2858/net43 n1242 VDD VDD pmos W=0.205u L=0.04u
M25832 WX1583 n2175 VDD VDD pmos W=0.205u L=0.04u
M25833 U2859/net29 n1347 VSS VSS nmos W=0.155u L=0.04u
M25834 n2175 WX1814 U2859/net29 VSS nmos W=0.155u L=0.04u
M25835 n2175 n1314 U2859/net23 VSS nmos W=0.155u L=0.04u
M25836 U2859/net23 CRC_OUT_8_13 VSS VSS nmos W=0.155u L=0.04u
M25837 U2859/net20 CRC_OUT_8_13 n2175 VDD pmos W=0.205u L=0.04u
M25838 U2859/net20 n1314 n2175 VDD pmos W=0.205u L=0.04u
M25839 VDD WX1814 U2859/net20 VDD pmos W=0.205u L=0.04u
M25840 VDD n1347 U2859/net20 VDD pmos W=0.205u L=0.04u
M25841 n2039 n2176 VSS VSS nmos W=0.135u L=0.04u
M25842 n2039 n2176 VDD VDD pmos W=0.205u L=0.04u
M25843 U2861/net28 U2861/net20 U2861/net64 VSS nmos W=0.155u L=0.04u
M25844 U2861/net24 U2861/net30 U2861/net32 VSS nmos W=0.155u L=0.04u
M25845 U2861/net28 U2861/net40 U2861/net24 VSS nmos W=0.155u L=0.04u
M25846 U2861/net40 WX3395 U2861/net108 VSS nmos W=0.155u L=0.04u
M25847 U2861/net40 U2861/net106 U2861/net104 VSS nmos W=0.155u L=0.04u
M25848 U2861/net24 WX3331 U2861/net050 VSS nmos W=0.155u L=0.04u
M25849 U2861/net050 U2861/net32 VSS VSS nmos W=0.155u L=0.04u
M25850 U2861/net20 U2861/net40 VSS VSS nmos W=0.155u L=0.04u
M25851 U2861/net106 WX3395 VSS VSS nmos W=0.155u L=0.04u
M25852 U2861/net104 WX3459 VSS VSS nmos W=0.155u L=0.04u
M25853 U2861/net30 WX3331 VSS VSS nmos W=0.155u L=0.04u
M25854 U2861/net108 U2861/net104 VSS VSS nmos W=0.155u L=0.04u
M25855 n2176 U2861/net28 VSS VSS nmos W=0.155u L=0.04u
M25856 U2861/net32 WX3267 VSS VSS nmos W=0.155u L=0.04u
M25857 U2861/net64 U2861/net24 VSS VSS nmos W=0.2u L=0.04u
M25858 U2861/net28 U2861/net40 U2861/net64 VDD pmos W=0.205u L=0.04u
M25859 U2861/net24 WX3331 U2861/net32 VDD pmos W=0.205u L=0.04u
M25860 U2861/net28 U2861/net20 U2861/net24 VDD pmos W=0.205u L=0.04u
M25861 U2861/net40 U2861/net106 U2861/net108 VDD pmos W=0.205u L=0.04u
M25862 U2861/net40 WX3395 U2861/net104 VDD pmos W=0.205u L=0.04u
M25863 U2861/net20 U2861/net40 VDD VDD pmos W=0.205u L=0.04u
M25864 U2861/net106 WX3395 VDD VDD pmos W=0.205u L=0.04u
M25865 U2861/net104 WX3459 VDD VDD pmos W=0.205u L=0.04u
M25866 U2861/net30 WX3331 VDD VDD pmos W=0.205u L=0.04u
M25867 U2861/net108 U2861/net104 VDD VDD pmos W=0.205u L=0.04u
M25868 n2176 U2861/net28 VDD VDD pmos W=0.205u L=0.04u
M25869 U2861/net32 WX3267 VDD VDD pmos W=0.205u L=0.04u
M25870 U2861/net64 U2861/net24 VDD VDD pmos W=0.28u L=0.04u
M25871 U2861/net24 U2861/net30 U2861/net045 VDD pmos W=0.205u L=0.04u
M25872 U2861/net045 U2861/net32 VDD VDD pmos W=0.205u L=0.04u
M25873 n2033 n2177 VSS VSS nmos W=0.135u L=0.04u
M25874 n2033 n2177 VDD VDD pmos W=0.205u L=0.04u
M25875 U2863/net28 U2863/net20 U2863/net64 VSS nmos W=0.155u L=0.04u
M25876 U2863/net24 U2863/net30 U2863/net32 VSS nmos W=0.155u L=0.04u
M25877 U2863/net28 U2863/net40 U2863/net24 VSS nmos W=0.155u L=0.04u
M25878 U2863/net40 WX2102 U2863/net108 VSS nmos W=0.155u L=0.04u
M25879 U2863/net40 U2863/net106 U2863/net104 VSS nmos W=0.155u L=0.04u
M25880 U2863/net24 WX2038 U2863/net050 VSS nmos W=0.155u L=0.04u
M25881 U2863/net050 U2863/net32 VSS VSS nmos W=0.155u L=0.04u
M25882 U2863/net20 U2863/net40 VSS VSS nmos W=0.155u L=0.04u
M25883 U2863/net106 WX2102 VSS VSS nmos W=0.155u L=0.04u
M25884 U2863/net104 WX2166 VSS VSS nmos W=0.155u L=0.04u
M25885 U2863/net30 WX2038 VSS VSS nmos W=0.155u L=0.04u
M25886 U2863/net108 U2863/net104 VSS VSS nmos W=0.155u L=0.04u
M25887 n2177 U2863/net28 VSS VSS nmos W=0.155u L=0.04u
M25888 U2863/net32 WX1974 VSS VSS nmos W=0.155u L=0.04u
M25889 U2863/net64 U2863/net24 VSS VSS nmos W=0.2u L=0.04u
M25890 U2863/net28 U2863/net40 U2863/net64 VDD pmos W=0.205u L=0.04u
M25891 U2863/net24 WX2038 U2863/net32 VDD pmos W=0.205u L=0.04u
M25892 U2863/net28 U2863/net20 U2863/net24 VDD pmos W=0.205u L=0.04u
M25893 U2863/net40 U2863/net106 U2863/net108 VDD pmos W=0.205u L=0.04u
M25894 U2863/net40 WX2102 U2863/net104 VDD pmos W=0.205u L=0.04u
M25895 U2863/net20 U2863/net40 VDD VDD pmos W=0.205u L=0.04u
M25896 U2863/net106 WX2102 VDD VDD pmos W=0.205u L=0.04u
M25897 U2863/net104 WX2166 VDD VDD pmos W=0.205u L=0.04u
M25898 U2863/net30 WX2038 VDD VDD pmos W=0.205u L=0.04u
M25899 U2863/net108 U2863/net104 VDD VDD pmos W=0.205u L=0.04u
M25900 n2177 U2863/net28 VDD VDD pmos W=0.205u L=0.04u
M25901 U2863/net32 WX1974 VDD VDD pmos W=0.205u L=0.04u
M25902 U2863/net64 U2863/net24 VDD VDD pmos W=0.28u L=0.04u
M25903 U2863/net24 U2863/net30 U2863/net045 VDD pmos W=0.205u L=0.04u
M25904 U2863/net045 U2863/net32 VDD VDD pmos W=0.205u L=0.04u
M25905 WX1569 n1242 U2864/net26 VSS nmos W=0.155u L=0.04u
M25906 WX1569 n2072 U2864/net26 VSS nmos W=0.155u L=0.04u
M25907 U2864/net29 n2178 VSS VSS nmos W=0.155u L=0.04u
M25908 U2864/net26 n2042 U2864/net29 VSS nmos W=0.155u L=0.04u
M25909 U2864/net26 n1290 U2864/net29 VSS nmos W=0.155u L=0.04u
M25910 WX1569 n2072 U2864/net43 VDD pmos W=0.205u L=0.04u
M25911 WX1569 n1290 U2864/net49 VDD pmos W=0.205u L=0.04u
M25912 U2864/net49 n2042 VDD VDD pmos W=0.205u L=0.04u
M25913 U2864/net43 n1242 VDD VDD pmos W=0.205u L=0.04u
M25914 WX1569 n2178 VDD VDD pmos W=0.205u L=0.04u
M25915 U2865/net29 n1347 VSS VSS nmos W=0.155u L=0.04u
M25916 n2178 WX1812 U2865/net29 VSS nmos W=0.155u L=0.04u
M25917 n2178 n1314 U2865/net23 VSS nmos W=0.155u L=0.04u
M25918 U2865/net23 CRC_OUT_8_14 VSS VSS nmos W=0.155u L=0.04u
M25919 U2865/net20 CRC_OUT_8_14 n2178 VDD pmos W=0.205u L=0.04u
M25920 U2865/net20 n1314 n2178 VDD pmos W=0.205u L=0.04u
M25921 VDD WX1812 U2865/net20 VDD pmos W=0.205u L=0.04u
M25922 VDD n1347 U2865/net20 VDD pmos W=0.205u L=0.04u
M25923 n2042 n2179 VSS VSS nmos W=0.135u L=0.04u
M25924 n2042 n2179 VDD VDD pmos W=0.205u L=0.04u
M25925 U2867/net28 U2867/net20 U2867/net64 VSS nmos W=0.155u L=0.04u
M25926 U2867/net24 U2867/net30 U2867/net32 VSS nmos W=0.155u L=0.04u
M25927 U2867/net28 U2867/net40 U2867/net24 VSS nmos W=0.155u L=0.04u
M25928 U2867/net40 WX3393 U2867/net108 VSS nmos W=0.155u L=0.04u
M25929 U2867/net40 U2867/net106 U2867/net104 VSS nmos W=0.155u L=0.04u
M25930 U2867/net24 WX3329 U2867/net050 VSS nmos W=0.155u L=0.04u
M25931 U2867/net050 U2867/net32 VSS VSS nmos W=0.155u L=0.04u
M25932 U2867/net20 U2867/net40 VSS VSS nmos W=0.155u L=0.04u
M25933 U2867/net106 WX3393 VSS VSS nmos W=0.155u L=0.04u
M25934 U2867/net104 WX3457 VSS VSS nmos W=0.155u L=0.04u
M25935 U2867/net30 WX3329 VSS VSS nmos W=0.155u L=0.04u
M25936 U2867/net108 U2867/net104 VSS VSS nmos W=0.155u L=0.04u
M25937 n2179 U2867/net28 VSS VSS nmos W=0.155u L=0.04u
M25938 U2867/net32 WX3265 VSS VSS nmos W=0.155u L=0.04u
M25939 U2867/net64 U2867/net24 VSS VSS nmos W=0.2u L=0.04u
M25940 U2867/net28 U2867/net40 U2867/net64 VDD pmos W=0.205u L=0.04u
M25941 U2867/net24 WX3329 U2867/net32 VDD pmos W=0.205u L=0.04u
M25942 U2867/net28 U2867/net20 U2867/net24 VDD pmos W=0.205u L=0.04u
M25943 U2867/net40 U2867/net106 U2867/net108 VDD pmos W=0.205u L=0.04u
M25944 U2867/net40 WX3393 U2867/net104 VDD pmos W=0.205u L=0.04u
M25945 U2867/net20 U2867/net40 VDD VDD pmos W=0.205u L=0.04u
M25946 U2867/net106 WX3393 VDD VDD pmos W=0.205u L=0.04u
M25947 U2867/net104 WX3457 VDD VDD pmos W=0.205u L=0.04u
M25948 U2867/net30 WX3329 VDD VDD pmos W=0.205u L=0.04u
M25949 U2867/net108 U2867/net104 VDD VDD pmos W=0.205u L=0.04u
M25950 n2179 U2867/net28 VDD VDD pmos W=0.205u L=0.04u
M25951 U2867/net32 WX3265 VDD VDD pmos W=0.205u L=0.04u
M25952 U2867/net64 U2867/net24 VDD VDD pmos W=0.28u L=0.04u
M25953 U2867/net24 U2867/net30 U2867/net045 VDD pmos W=0.205u L=0.04u
M25954 U2867/net045 U2867/net32 VDD VDD pmos W=0.205u L=0.04u
M25955 n2072 n2180 VSS VSS nmos W=0.135u L=0.04u
M25956 n2072 n2180 VDD VDD pmos W=0.205u L=0.04u
M25957 U2869/net28 U2869/net20 U2869/net64 VSS nmos W=0.155u L=0.04u
M25958 U2869/net24 U2869/net30 U2869/net32 VSS nmos W=0.155u L=0.04u
M25959 U2869/net28 U2869/net40 U2869/net24 VSS nmos W=0.155u L=0.04u
M25960 U2869/net40 WX2100 U2869/net108 VSS nmos W=0.155u L=0.04u
M25961 U2869/net40 U2869/net106 U2869/net104 VSS nmos W=0.155u L=0.04u
M25962 U2869/net24 WX2036 U2869/net050 VSS nmos W=0.155u L=0.04u
M25963 U2869/net050 U2869/net32 VSS VSS nmos W=0.155u L=0.04u
M25964 U2869/net20 U2869/net40 VSS VSS nmos W=0.155u L=0.04u
M25965 U2869/net106 WX2100 VSS VSS nmos W=0.155u L=0.04u
M25966 U2869/net104 WX2164 VSS VSS nmos W=0.155u L=0.04u
M25967 U2869/net30 WX2036 VSS VSS nmos W=0.155u L=0.04u
M25968 U2869/net108 U2869/net104 VSS VSS nmos W=0.155u L=0.04u
M25969 n2180 U2869/net28 VSS VSS nmos W=0.155u L=0.04u
M25970 U2869/net32 WX1972 VSS VSS nmos W=0.155u L=0.04u
M25971 U2869/net64 U2869/net24 VSS VSS nmos W=0.2u L=0.04u
M25972 U2869/net28 U2869/net40 U2869/net64 VDD pmos W=0.205u L=0.04u
M25973 U2869/net24 WX2036 U2869/net32 VDD pmos W=0.205u L=0.04u
M25974 U2869/net28 U2869/net20 U2869/net24 VDD pmos W=0.205u L=0.04u
M25975 U2869/net40 U2869/net106 U2869/net108 VDD pmos W=0.205u L=0.04u
M25976 U2869/net40 WX2100 U2869/net104 VDD pmos W=0.205u L=0.04u
M25977 U2869/net20 U2869/net40 VDD VDD pmos W=0.205u L=0.04u
M25978 U2869/net106 WX2100 VDD VDD pmos W=0.205u L=0.04u
M25979 U2869/net104 WX2164 VDD VDD pmos W=0.205u L=0.04u
M25980 U2869/net30 WX2036 VDD VDD pmos W=0.205u L=0.04u
M25981 U2869/net108 U2869/net104 VDD VDD pmos W=0.205u L=0.04u
M25982 n2180 U2869/net28 VDD VDD pmos W=0.205u L=0.04u
M25983 U2869/net32 WX1972 VDD VDD pmos W=0.205u L=0.04u
M25984 U2869/net64 U2869/net24 VDD VDD pmos W=0.28u L=0.04u
M25985 U2869/net24 U2869/net30 U2869/net045 VDD pmos W=0.205u L=0.04u
M25986 U2869/net045 U2869/net32 VDD VDD pmos W=0.205u L=0.04u
M25987 WX1555 n1243 U2870/net26 VSS nmos W=0.155u L=0.04u
M25988 WX1555 n2114 U2870/net26 VSS nmos W=0.155u L=0.04u
M25989 U2870/net29 n2181 VSS VSS nmos W=0.155u L=0.04u
M25990 U2870/net26 n2045 U2870/net29 VSS nmos W=0.155u L=0.04u
M25991 U2870/net26 n1290 U2870/net29 VSS nmos W=0.155u L=0.04u
M25992 WX1555 n2114 U2870/net43 VDD pmos W=0.205u L=0.04u
M25993 WX1555 n1290 U2870/net49 VDD pmos W=0.205u L=0.04u
M25994 U2870/net49 n2045 VDD VDD pmos W=0.205u L=0.04u
M25995 U2870/net43 n1243 VDD VDD pmos W=0.205u L=0.04u
M25996 WX1555 n2181 VDD VDD pmos W=0.205u L=0.04u
M25997 U2871/net29 n1347 VSS VSS nmos W=0.155u L=0.04u
M25998 n2181 WX1810 U2871/net29 VSS nmos W=0.155u L=0.04u
M25999 n2181 n1314 U2871/net23 VSS nmos W=0.155u L=0.04u
M26000 U2871/net23 CRC_OUT_8_15 VSS VSS nmos W=0.155u L=0.04u
M26001 U2871/net20 CRC_OUT_8_15 n2181 VDD pmos W=0.205u L=0.04u
M26002 U2871/net20 n1314 n2181 VDD pmos W=0.205u L=0.04u
M26003 VDD WX1810 U2871/net20 VDD pmos W=0.205u L=0.04u
M26004 VDD n1347 U2871/net20 VDD pmos W=0.205u L=0.04u
M26005 n2045 n2182 VSS VSS nmos W=0.135u L=0.04u
M26006 n2045 n2182 VDD VDD pmos W=0.205u L=0.04u
M26007 U2873/net28 U2873/net20 U2873/net64 VSS nmos W=0.155u L=0.04u
M26008 U2873/net24 U2873/net30 U2873/net32 VSS nmos W=0.155u L=0.04u
M26009 U2873/net28 U2873/net40 U2873/net24 VSS nmos W=0.155u L=0.04u
M26010 U2873/net40 WX3391 U2873/net108 VSS nmos W=0.155u L=0.04u
M26011 U2873/net40 U2873/net106 U2873/net104 VSS nmos W=0.155u L=0.04u
M26012 U2873/net24 WX3327 U2873/net050 VSS nmos W=0.155u L=0.04u
M26013 U2873/net050 U2873/net32 VSS VSS nmos W=0.155u L=0.04u
M26014 U2873/net20 U2873/net40 VSS VSS nmos W=0.155u L=0.04u
M26015 U2873/net106 WX3391 VSS VSS nmos W=0.155u L=0.04u
M26016 U2873/net104 WX3455 VSS VSS nmos W=0.155u L=0.04u
M26017 U2873/net30 WX3327 VSS VSS nmos W=0.155u L=0.04u
M26018 U2873/net108 U2873/net104 VSS VSS nmos W=0.155u L=0.04u
M26019 n2182 U2873/net28 VSS VSS nmos W=0.155u L=0.04u
M26020 U2873/net32 WX3263 VSS VSS nmos W=0.155u L=0.04u
M26021 U2873/net64 U2873/net24 VSS VSS nmos W=0.2u L=0.04u
M26022 U2873/net28 U2873/net40 U2873/net64 VDD pmos W=0.205u L=0.04u
M26023 U2873/net24 WX3327 U2873/net32 VDD pmos W=0.205u L=0.04u
M26024 U2873/net28 U2873/net20 U2873/net24 VDD pmos W=0.205u L=0.04u
M26025 U2873/net40 U2873/net106 U2873/net108 VDD pmos W=0.205u L=0.04u
M26026 U2873/net40 WX3391 U2873/net104 VDD pmos W=0.205u L=0.04u
M26027 U2873/net20 U2873/net40 VDD VDD pmos W=0.205u L=0.04u
M26028 U2873/net106 WX3391 VDD VDD pmos W=0.205u L=0.04u
M26029 U2873/net104 WX3455 VDD VDD pmos W=0.205u L=0.04u
M26030 U2873/net30 WX3327 VDD VDD pmos W=0.205u L=0.04u
M26031 U2873/net108 U2873/net104 VDD VDD pmos W=0.205u L=0.04u
M26032 n2182 U2873/net28 VDD VDD pmos W=0.205u L=0.04u
M26033 U2873/net32 WX3263 VDD VDD pmos W=0.205u L=0.04u
M26034 U2873/net64 U2873/net24 VDD VDD pmos W=0.28u L=0.04u
M26035 U2873/net24 U2873/net30 U2873/net045 VDD pmos W=0.205u L=0.04u
M26036 U2873/net045 U2873/net32 VDD VDD pmos W=0.205u L=0.04u
M26037 n2114 n2183 VSS VSS nmos W=0.135u L=0.04u
M26038 n2114 n2183 VDD VDD pmos W=0.205u L=0.04u
M26039 U2875/net28 U2875/net20 U2875/net64 VSS nmos W=0.155u L=0.04u
M26040 U2875/net24 U2875/net30 U2875/net32 VSS nmos W=0.155u L=0.04u
M26041 U2875/net28 U2875/net40 U2875/net24 VSS nmos W=0.155u L=0.04u
M26042 U2875/net40 WX2098 U2875/net108 VSS nmos W=0.155u L=0.04u
M26043 U2875/net40 U2875/net106 U2875/net104 VSS nmos W=0.155u L=0.04u
M26044 U2875/net24 WX2034 U2875/net050 VSS nmos W=0.155u L=0.04u
M26045 U2875/net050 U2875/net32 VSS VSS nmos W=0.155u L=0.04u
M26046 U2875/net20 U2875/net40 VSS VSS nmos W=0.155u L=0.04u
M26047 U2875/net106 WX2098 VSS VSS nmos W=0.155u L=0.04u
M26048 U2875/net104 WX2162 VSS VSS nmos W=0.155u L=0.04u
M26049 U2875/net30 WX2034 VSS VSS nmos W=0.155u L=0.04u
M26050 U2875/net108 U2875/net104 VSS VSS nmos W=0.155u L=0.04u
M26051 n2183 U2875/net28 VSS VSS nmos W=0.155u L=0.04u
M26052 U2875/net32 WX1970 VSS VSS nmos W=0.155u L=0.04u
M26053 U2875/net64 U2875/net24 VSS VSS nmos W=0.2u L=0.04u
M26054 U2875/net28 U2875/net40 U2875/net64 VDD pmos W=0.205u L=0.04u
M26055 U2875/net24 WX2034 U2875/net32 VDD pmos W=0.205u L=0.04u
M26056 U2875/net28 U2875/net20 U2875/net24 VDD pmos W=0.205u L=0.04u
M26057 U2875/net40 U2875/net106 U2875/net108 VDD pmos W=0.205u L=0.04u
M26058 U2875/net40 WX2098 U2875/net104 VDD pmos W=0.205u L=0.04u
M26059 U2875/net20 U2875/net40 VDD VDD pmos W=0.205u L=0.04u
M26060 U2875/net106 WX2098 VDD VDD pmos W=0.205u L=0.04u
M26061 U2875/net104 WX2162 VDD VDD pmos W=0.205u L=0.04u
M26062 U2875/net30 WX2034 VDD VDD pmos W=0.205u L=0.04u
M26063 U2875/net108 U2875/net104 VDD VDD pmos W=0.205u L=0.04u
M26064 n2183 U2875/net28 VDD VDD pmos W=0.205u L=0.04u
M26065 U2875/net32 WX1970 VDD VDD pmos W=0.205u L=0.04u
M26066 U2875/net64 U2875/net24 VDD VDD pmos W=0.28u L=0.04u
M26067 U2875/net24 U2875/net30 U2875/net045 VDD pmos W=0.205u L=0.04u
M26068 U2875/net045 U2875/net32 VDD VDD pmos W=0.205u L=0.04u
M26069 WX1541 n1243 U2876/net26 VSS nmos W=0.155u L=0.04u
M26070 WX1541 n2117 U2876/net26 VSS nmos W=0.155u L=0.04u
M26071 U2876/net29 n2184 VSS VSS nmos W=0.155u L=0.04u
M26072 U2876/net26 n2048 U2876/net29 VSS nmos W=0.155u L=0.04u
M26073 U2876/net26 n1290 U2876/net29 VSS nmos W=0.155u L=0.04u
M26074 WX1541 n2117 U2876/net43 VDD pmos W=0.205u L=0.04u
M26075 WX1541 n1290 U2876/net49 VDD pmos W=0.205u L=0.04u
M26076 U2876/net49 n2048 VDD VDD pmos W=0.205u L=0.04u
M26077 U2876/net43 n1243 VDD VDD pmos W=0.205u L=0.04u
M26078 WX1541 n2184 VDD VDD pmos W=0.205u L=0.04u
M26079 U2877/net29 n1347 VSS VSS nmos W=0.155u L=0.04u
M26080 n2184 WX1808 U2877/net29 VSS nmos W=0.155u L=0.04u
M26081 n2184 n1314 U2877/net23 VSS nmos W=0.155u L=0.04u
M26082 U2877/net23 CRC_OUT_8_16 VSS VSS nmos W=0.155u L=0.04u
M26083 U2877/net20 CRC_OUT_8_16 n2184 VDD pmos W=0.205u L=0.04u
M26084 U2877/net20 n1314 n2184 VDD pmos W=0.205u L=0.04u
M26085 VDD WX1808 U2877/net20 VDD pmos W=0.205u L=0.04u
M26086 VDD n1347 U2877/net20 VDD pmos W=0.205u L=0.04u
M26087 n2048 n2185 VSS VSS nmos W=0.135u L=0.04u
M26088 n2048 n2185 VDD VDD pmos W=0.205u L=0.04u
M26089 U2879/net28 U2879/net20 U2879/net64 VSS nmos W=0.155u L=0.04u
M26090 U2879/net24 U2879/net30 U2879/net32 VSS nmos W=0.155u L=0.04u
M26091 U2879/net28 U2879/net40 U2879/net24 VSS nmos W=0.155u L=0.04u
M26092 U2879/net40 n2186 U2879/net108 VSS nmos W=0.155u L=0.04u
M26093 U2879/net40 U2879/net106 U2879/net104 VSS nmos W=0.155u L=0.04u
M26094 U2879/net24 WX3389 U2879/net050 VSS nmos W=0.155u L=0.04u
M26095 U2879/net050 U2879/net32 VSS VSS nmos W=0.155u L=0.04u
M26096 U2879/net20 U2879/net40 VSS VSS nmos W=0.155u L=0.04u
M26097 U2879/net106 n2186 VSS VSS nmos W=0.155u L=0.04u
M26098 U2879/net104 WX3453 VSS VSS nmos W=0.155u L=0.04u
M26099 U2879/net30 WX3389 VSS VSS nmos W=0.155u L=0.04u
M26100 U2879/net108 U2879/net104 VSS VSS nmos W=0.155u L=0.04u
M26101 n2185 U2879/net28 VSS VSS nmos W=0.155u L=0.04u
M26102 U2879/net32 WX3325 VSS VSS nmos W=0.155u L=0.04u
M26103 U2879/net64 U2879/net24 VSS VSS nmos W=0.2u L=0.04u
M26104 U2879/net28 U2879/net40 U2879/net64 VDD pmos W=0.205u L=0.04u
M26105 U2879/net24 WX3389 U2879/net32 VDD pmos W=0.205u L=0.04u
M26106 U2879/net28 U2879/net20 U2879/net24 VDD pmos W=0.205u L=0.04u
M26107 U2879/net40 U2879/net106 U2879/net108 VDD pmos W=0.205u L=0.04u
M26108 U2879/net40 n2186 U2879/net104 VDD pmos W=0.205u L=0.04u
M26109 U2879/net20 U2879/net40 VDD VDD pmos W=0.205u L=0.04u
M26110 U2879/net106 n2186 VDD VDD pmos W=0.205u L=0.04u
M26111 U2879/net104 WX3453 VDD VDD pmos W=0.205u L=0.04u
M26112 U2879/net30 WX3389 VDD VDD pmos W=0.205u L=0.04u
M26113 U2879/net108 U2879/net104 VDD VDD pmos W=0.205u L=0.04u
M26114 n2185 U2879/net28 VDD VDD pmos W=0.205u L=0.04u
M26115 U2879/net32 WX3325 VDD VDD pmos W=0.205u L=0.04u
M26116 U2879/net64 U2879/net24 VDD VDD pmos W=0.28u L=0.04u
M26117 U2879/net24 U2879/net30 U2879/net045 VDD pmos W=0.205u L=0.04u
M26118 U2879/net045 U2879/net32 VDD VDD pmos W=0.205u L=0.04u
M26119 U2880/net4 WX3261 U2880/net14 VSS nmos W=0.155u L=0.04u
M26120 U2880/net6 U2880/net10 U2880/net14 VSS nmos W=0.17u L=0.04u
M26121 U2880/net4 n1374 VSS VSS nmos W=0.155u L=0.04u
M26122 U2880/net6 U2880/net4 VSS VSS nmos W=0.17u L=0.04u
M26123 n2186 U2880/net14 VSS VSS nmos W=0.155u L=0.04u
M26124 U2880/net10 WX3261 VSS VSS nmos W=0.155u L=0.04u
M26125 U2880/net4 U2880/net10 U2880/net14 VDD pmos W=0.255u L=0.04u
M26126 U2880/net6 WX3261 U2880/net14 VDD pmos W=0.28u L=0.04u
M26127 U2880/net4 n1374 VDD VDD pmos W=0.205u L=0.04u
M26128 U2880/net6 U2880/net4 VDD VDD pmos W=0.24u L=0.04u
M26129 n2186 U2880/net14 VDD VDD pmos W=0.205u L=0.04u
M26130 U2880/net10 WX3261 VDD VDD pmos W=0.205u L=0.04u
M26131 n2117 n2187 VSS VSS nmos W=0.135u L=0.04u
M26132 n2117 n2187 VDD VDD pmos W=0.205u L=0.04u
M26133 U2882/net28 U2882/net20 U2882/net64 VSS nmos W=0.155u L=0.04u
M26134 U2882/net24 U2882/net30 U2882/net32 VSS nmos W=0.155u L=0.04u
M26135 U2882/net28 U2882/net40 U2882/net24 VSS nmos W=0.155u L=0.04u
M26136 U2882/net40 n2188 U2882/net108 VSS nmos W=0.155u L=0.04u
M26137 U2882/net40 U2882/net106 U2882/net104 VSS nmos W=0.155u L=0.04u
M26138 U2882/net24 WX2096 U2882/net050 VSS nmos W=0.155u L=0.04u
M26139 U2882/net050 U2882/net32 VSS VSS nmos W=0.155u L=0.04u
M26140 U2882/net20 U2882/net40 VSS VSS nmos W=0.155u L=0.04u
M26141 U2882/net106 n2188 VSS VSS nmos W=0.155u L=0.04u
M26142 U2882/net104 WX2160 VSS VSS nmos W=0.155u L=0.04u
M26143 U2882/net30 WX2096 VSS VSS nmos W=0.155u L=0.04u
M26144 U2882/net108 U2882/net104 VSS VSS nmos W=0.155u L=0.04u
M26145 n2187 U2882/net28 VSS VSS nmos W=0.155u L=0.04u
M26146 U2882/net32 WX2032 VSS VSS nmos W=0.155u L=0.04u
M26147 U2882/net64 U2882/net24 VSS VSS nmos W=0.2u L=0.04u
M26148 U2882/net28 U2882/net40 U2882/net64 VDD pmos W=0.205u L=0.04u
M26149 U2882/net24 WX2096 U2882/net32 VDD pmos W=0.205u L=0.04u
M26150 U2882/net28 U2882/net20 U2882/net24 VDD pmos W=0.205u L=0.04u
M26151 U2882/net40 U2882/net106 U2882/net108 VDD pmos W=0.205u L=0.04u
M26152 U2882/net40 n2188 U2882/net104 VDD pmos W=0.205u L=0.04u
M26153 U2882/net20 U2882/net40 VDD VDD pmos W=0.205u L=0.04u
M26154 U2882/net106 n2188 VDD VDD pmos W=0.205u L=0.04u
M26155 U2882/net104 WX2160 VDD VDD pmos W=0.205u L=0.04u
M26156 U2882/net30 WX2096 VDD VDD pmos W=0.205u L=0.04u
M26157 U2882/net108 U2882/net104 VDD VDD pmos W=0.205u L=0.04u
M26158 n2187 U2882/net28 VDD VDD pmos W=0.205u L=0.04u
M26159 U2882/net32 WX2032 VDD VDD pmos W=0.205u L=0.04u
M26160 U2882/net64 U2882/net24 VDD VDD pmos W=0.28u L=0.04u
M26161 U2882/net24 U2882/net30 U2882/net045 VDD pmos W=0.205u L=0.04u
M26162 U2882/net045 U2882/net32 VDD VDD pmos W=0.205u L=0.04u
M26163 U2883/net4 WX1968 U2883/net14 VSS nmos W=0.155u L=0.04u
M26164 U2883/net6 U2883/net10 U2883/net14 VSS nmos W=0.17u L=0.04u
M26165 U2883/net4 n1374 VSS VSS nmos W=0.155u L=0.04u
M26166 U2883/net6 U2883/net4 VSS VSS nmos W=0.17u L=0.04u
M26167 n2188 U2883/net14 VSS VSS nmos W=0.155u L=0.04u
M26168 U2883/net10 WX1968 VSS VSS nmos W=0.155u L=0.04u
M26169 U2883/net4 U2883/net10 U2883/net14 VDD pmos W=0.255u L=0.04u
M26170 U2883/net6 WX1968 U2883/net14 VDD pmos W=0.28u L=0.04u
M26171 U2883/net4 n1374 VDD VDD pmos W=0.205u L=0.04u
M26172 U2883/net6 U2883/net4 VDD VDD pmos W=0.24u L=0.04u
M26173 n2188 U2883/net14 VDD VDD pmos W=0.205u L=0.04u
M26174 U2883/net10 WX1968 VDD VDD pmos W=0.205u L=0.04u
M26175 WX1527 n1243 U2884/net26 VSS nmos W=0.155u L=0.04u
M26176 WX1527 n2120 U2884/net26 VSS nmos W=0.155u L=0.04u
M26177 U2884/net29 n2189 VSS VSS nmos W=0.155u L=0.04u
M26178 U2884/net26 n2052 U2884/net29 VSS nmos W=0.155u L=0.04u
M26179 U2884/net26 n1290 U2884/net29 VSS nmos W=0.155u L=0.04u
M26180 WX1527 n2120 U2884/net43 VDD pmos W=0.205u L=0.04u
M26181 WX1527 n1290 U2884/net49 VDD pmos W=0.205u L=0.04u
M26182 U2884/net49 n2052 VDD VDD pmos W=0.205u L=0.04u
M26183 U2884/net43 n1243 VDD VDD pmos W=0.205u L=0.04u
M26184 WX1527 n2189 VDD VDD pmos W=0.205u L=0.04u
M26185 U2885/net29 n1347 VSS VSS nmos W=0.155u L=0.04u
M26186 n2189 WX1806 U2885/net29 VSS nmos W=0.155u L=0.04u
M26187 n2189 n1314 U2885/net23 VSS nmos W=0.155u L=0.04u
M26188 U2885/net23 CRC_OUT_8_17 VSS VSS nmos W=0.155u L=0.04u
M26189 U2885/net20 CRC_OUT_8_17 n2189 VDD pmos W=0.205u L=0.04u
M26190 U2885/net20 n1314 n2189 VDD pmos W=0.205u L=0.04u
M26191 VDD WX1806 U2885/net20 VDD pmos W=0.205u L=0.04u
M26192 VDD n1347 U2885/net20 VDD pmos W=0.205u L=0.04u
M26193 n2052 n2190 VSS VSS nmos W=0.135u L=0.04u
M26194 n2052 n2190 VDD VDD pmos W=0.205u L=0.04u
M26195 U2887/net28 U2887/net20 U2887/net64 VSS nmos W=0.155u L=0.04u
M26196 U2887/net24 U2887/net30 U2887/net32 VSS nmos W=0.155u L=0.04u
M26197 U2887/net28 U2887/net40 U2887/net24 VSS nmos W=0.155u L=0.04u
M26198 U2887/net40 n2191 U2887/net108 VSS nmos W=0.155u L=0.04u
M26199 U2887/net40 U2887/net106 U2887/net104 VSS nmos W=0.155u L=0.04u
M26200 U2887/net24 WX3387 U2887/net050 VSS nmos W=0.155u L=0.04u
M26201 U2887/net050 U2887/net32 VSS VSS nmos W=0.155u L=0.04u
M26202 U2887/net20 U2887/net40 VSS VSS nmos W=0.155u L=0.04u
M26203 U2887/net106 n2191 VSS VSS nmos W=0.155u L=0.04u
M26204 U2887/net104 WX3451 VSS VSS nmos W=0.155u L=0.04u
M26205 U2887/net30 WX3387 VSS VSS nmos W=0.155u L=0.04u
M26206 U2887/net108 U2887/net104 VSS VSS nmos W=0.155u L=0.04u
M26207 n2190 U2887/net28 VSS VSS nmos W=0.155u L=0.04u
M26208 U2887/net32 WX3323 VSS VSS nmos W=0.155u L=0.04u
M26209 U2887/net64 U2887/net24 VSS VSS nmos W=0.2u L=0.04u
M26210 U2887/net28 U2887/net40 U2887/net64 VDD pmos W=0.205u L=0.04u
M26211 U2887/net24 WX3387 U2887/net32 VDD pmos W=0.205u L=0.04u
M26212 U2887/net28 U2887/net20 U2887/net24 VDD pmos W=0.205u L=0.04u
M26213 U2887/net40 U2887/net106 U2887/net108 VDD pmos W=0.205u L=0.04u
M26214 U2887/net40 n2191 U2887/net104 VDD pmos W=0.205u L=0.04u
M26215 U2887/net20 U2887/net40 VDD VDD pmos W=0.205u L=0.04u
M26216 U2887/net106 n2191 VDD VDD pmos W=0.205u L=0.04u
M26217 U2887/net104 WX3451 VDD VDD pmos W=0.205u L=0.04u
M26218 U2887/net30 WX3387 VDD VDD pmos W=0.205u L=0.04u
M26219 U2887/net108 U2887/net104 VDD VDD pmos W=0.205u L=0.04u
M26220 n2190 U2887/net28 VDD VDD pmos W=0.205u L=0.04u
M26221 U2887/net32 WX3323 VDD VDD pmos W=0.205u L=0.04u
M26222 U2887/net64 U2887/net24 VDD VDD pmos W=0.28u L=0.04u
M26223 U2887/net24 U2887/net30 U2887/net045 VDD pmos W=0.205u L=0.04u
M26224 U2887/net045 U2887/net32 VDD VDD pmos W=0.205u L=0.04u
M26225 U2888/net4 WX3259 U2888/net14 VSS nmos W=0.155u L=0.04u
M26226 U2888/net6 U2888/net10 U2888/net14 VSS nmos W=0.17u L=0.04u
M26227 U2888/net4 n1374 VSS VSS nmos W=0.155u L=0.04u
M26228 U2888/net6 U2888/net4 VSS VSS nmos W=0.17u L=0.04u
M26229 n2191 U2888/net14 VSS VSS nmos W=0.155u L=0.04u
M26230 U2888/net10 WX3259 VSS VSS nmos W=0.155u L=0.04u
M26231 U2888/net4 U2888/net10 U2888/net14 VDD pmos W=0.255u L=0.04u
M26232 U2888/net6 WX3259 U2888/net14 VDD pmos W=0.28u L=0.04u
M26233 U2888/net4 n1374 VDD VDD pmos W=0.205u L=0.04u
M26234 U2888/net6 U2888/net4 VDD VDD pmos W=0.24u L=0.04u
M26235 n2191 U2888/net14 VDD VDD pmos W=0.205u L=0.04u
M26236 U2888/net10 WX3259 VDD VDD pmos W=0.205u L=0.04u
M26237 n2120 n2192 VSS VSS nmos W=0.135u L=0.04u
M26238 n2120 n2192 VDD VDD pmos W=0.205u L=0.04u
M26239 U2890/net28 U2890/net20 U2890/net64 VSS nmos W=0.155u L=0.04u
M26240 U2890/net24 U2890/net30 U2890/net32 VSS nmos W=0.155u L=0.04u
M26241 U2890/net28 U2890/net40 U2890/net24 VSS nmos W=0.155u L=0.04u
M26242 U2890/net40 n2193 U2890/net108 VSS nmos W=0.155u L=0.04u
M26243 U2890/net40 U2890/net106 U2890/net104 VSS nmos W=0.155u L=0.04u
M26244 U2890/net24 WX2094 U2890/net050 VSS nmos W=0.155u L=0.04u
M26245 U2890/net050 U2890/net32 VSS VSS nmos W=0.155u L=0.04u
M26246 U2890/net20 U2890/net40 VSS VSS nmos W=0.155u L=0.04u
M26247 U2890/net106 n2193 VSS VSS nmos W=0.155u L=0.04u
M26248 U2890/net104 WX2158 VSS VSS nmos W=0.155u L=0.04u
M26249 U2890/net30 WX2094 VSS VSS nmos W=0.155u L=0.04u
M26250 U2890/net108 U2890/net104 VSS VSS nmos W=0.155u L=0.04u
M26251 n2192 U2890/net28 VSS VSS nmos W=0.155u L=0.04u
M26252 U2890/net32 WX2030 VSS VSS nmos W=0.155u L=0.04u
M26253 U2890/net64 U2890/net24 VSS VSS nmos W=0.2u L=0.04u
M26254 U2890/net28 U2890/net40 U2890/net64 VDD pmos W=0.205u L=0.04u
M26255 U2890/net24 WX2094 U2890/net32 VDD pmos W=0.205u L=0.04u
M26256 U2890/net28 U2890/net20 U2890/net24 VDD pmos W=0.205u L=0.04u
M26257 U2890/net40 U2890/net106 U2890/net108 VDD pmos W=0.205u L=0.04u
M26258 U2890/net40 n2193 U2890/net104 VDD pmos W=0.205u L=0.04u
M26259 U2890/net20 U2890/net40 VDD VDD pmos W=0.205u L=0.04u
M26260 U2890/net106 n2193 VDD VDD pmos W=0.205u L=0.04u
M26261 U2890/net104 WX2158 VDD VDD pmos W=0.205u L=0.04u
M26262 U2890/net30 WX2094 VDD VDD pmos W=0.205u L=0.04u
M26263 U2890/net108 U2890/net104 VDD VDD pmos W=0.205u L=0.04u
M26264 n2192 U2890/net28 VDD VDD pmos W=0.205u L=0.04u
M26265 U2890/net32 WX2030 VDD VDD pmos W=0.205u L=0.04u
M26266 U2890/net64 U2890/net24 VDD VDD pmos W=0.28u L=0.04u
M26267 U2890/net24 U2890/net30 U2890/net045 VDD pmos W=0.205u L=0.04u
M26268 U2890/net045 U2890/net32 VDD VDD pmos W=0.205u L=0.04u
M26269 U2891/net4 WX1966 U2891/net14 VSS nmos W=0.155u L=0.04u
M26270 U2891/net6 U2891/net10 U2891/net14 VSS nmos W=0.17u L=0.04u
M26271 U2891/net4 n1375 VSS VSS nmos W=0.155u L=0.04u
M26272 U2891/net6 U2891/net4 VSS VSS nmos W=0.17u L=0.04u
M26273 n2193 U2891/net14 VSS VSS nmos W=0.155u L=0.04u
M26274 U2891/net10 WX1966 VSS VSS nmos W=0.155u L=0.04u
M26275 U2891/net4 U2891/net10 U2891/net14 VDD pmos W=0.255u L=0.04u
M26276 U2891/net6 WX1966 U2891/net14 VDD pmos W=0.28u L=0.04u
M26277 U2891/net4 n1375 VDD VDD pmos W=0.205u L=0.04u
M26278 U2891/net6 U2891/net4 VDD VDD pmos W=0.24u L=0.04u
M26279 n2193 U2891/net14 VDD VDD pmos W=0.205u L=0.04u
M26280 U2891/net10 WX1966 VDD VDD pmos W=0.205u L=0.04u
M26281 WX1513 n1243 U2892/net26 VSS nmos W=0.155u L=0.04u
M26282 WX1513 n2123 U2892/net26 VSS nmos W=0.155u L=0.04u
M26283 U2892/net29 n2194 VSS VSS nmos W=0.155u L=0.04u
M26284 U2892/net26 n2056 U2892/net29 VSS nmos W=0.155u L=0.04u
M26285 U2892/net26 n1290 U2892/net29 VSS nmos W=0.155u L=0.04u
M26286 WX1513 n2123 U2892/net43 VDD pmos W=0.205u L=0.04u
M26287 WX1513 n1290 U2892/net49 VDD pmos W=0.205u L=0.04u
M26288 U2892/net49 n2056 VDD VDD pmos W=0.205u L=0.04u
M26289 U2892/net43 n1243 VDD VDD pmos W=0.205u L=0.04u
M26290 WX1513 n2194 VDD VDD pmos W=0.205u L=0.04u
M26291 U2893/net29 n1347 VSS VSS nmos W=0.155u L=0.04u
M26292 n2194 WX1804 U2893/net29 VSS nmos W=0.155u L=0.04u
M26293 n2194 n1313 U2893/net23 VSS nmos W=0.155u L=0.04u
M26294 U2893/net23 CRC_OUT_8_18 VSS VSS nmos W=0.155u L=0.04u
M26295 U2893/net20 CRC_OUT_8_18 n2194 VDD pmos W=0.205u L=0.04u
M26296 U2893/net20 n1313 n2194 VDD pmos W=0.205u L=0.04u
M26297 VDD WX1804 U2893/net20 VDD pmos W=0.205u L=0.04u
M26298 VDD n1347 U2893/net20 VDD pmos W=0.205u L=0.04u
M26299 n2056 n2195 VSS VSS nmos W=0.135u L=0.04u
M26300 n2056 n2195 VDD VDD pmos W=0.205u L=0.04u
M26301 U2895/net28 U2895/net20 U2895/net64 VSS nmos W=0.155u L=0.04u
M26302 U2895/net24 U2895/net30 U2895/net32 VSS nmos W=0.155u L=0.04u
M26303 U2895/net28 U2895/net40 U2895/net24 VSS nmos W=0.155u L=0.04u
M26304 U2895/net40 n2196 U2895/net108 VSS nmos W=0.155u L=0.04u
M26305 U2895/net40 U2895/net106 U2895/net104 VSS nmos W=0.155u L=0.04u
M26306 U2895/net24 WX3385 U2895/net050 VSS nmos W=0.155u L=0.04u
M26307 U2895/net050 U2895/net32 VSS VSS nmos W=0.155u L=0.04u
M26308 U2895/net20 U2895/net40 VSS VSS nmos W=0.155u L=0.04u
M26309 U2895/net106 n2196 VSS VSS nmos W=0.155u L=0.04u
M26310 U2895/net104 WX3449 VSS VSS nmos W=0.155u L=0.04u
M26311 U2895/net30 WX3385 VSS VSS nmos W=0.155u L=0.04u
M26312 U2895/net108 U2895/net104 VSS VSS nmos W=0.155u L=0.04u
M26313 n2195 U2895/net28 VSS VSS nmos W=0.155u L=0.04u
M26314 U2895/net32 WX3321 VSS VSS nmos W=0.155u L=0.04u
M26315 U2895/net64 U2895/net24 VSS VSS nmos W=0.2u L=0.04u
M26316 U2895/net28 U2895/net40 U2895/net64 VDD pmos W=0.205u L=0.04u
M26317 U2895/net24 WX3385 U2895/net32 VDD pmos W=0.205u L=0.04u
M26318 U2895/net28 U2895/net20 U2895/net24 VDD pmos W=0.205u L=0.04u
M26319 U2895/net40 U2895/net106 U2895/net108 VDD pmos W=0.205u L=0.04u
M26320 U2895/net40 n2196 U2895/net104 VDD pmos W=0.205u L=0.04u
M26321 U2895/net20 U2895/net40 VDD VDD pmos W=0.205u L=0.04u
M26322 U2895/net106 n2196 VDD VDD pmos W=0.205u L=0.04u
M26323 U2895/net104 WX3449 VDD VDD pmos W=0.205u L=0.04u
M26324 U2895/net30 WX3385 VDD VDD pmos W=0.205u L=0.04u
M26325 U2895/net108 U2895/net104 VDD VDD pmos W=0.205u L=0.04u
M26326 n2195 U2895/net28 VDD VDD pmos W=0.205u L=0.04u
M26327 U2895/net32 WX3321 VDD VDD pmos W=0.205u L=0.04u
M26328 U2895/net64 U2895/net24 VDD VDD pmos W=0.28u L=0.04u
M26329 U2895/net24 U2895/net30 U2895/net045 VDD pmos W=0.205u L=0.04u
M26330 U2895/net045 U2895/net32 VDD VDD pmos W=0.205u L=0.04u
M26331 U2896/net4 WX3257 U2896/net14 VSS nmos W=0.155u L=0.04u
M26332 U2896/net6 U2896/net10 U2896/net14 VSS nmos W=0.17u L=0.04u
M26333 U2896/net4 n1375 VSS VSS nmos W=0.155u L=0.04u
M26334 U2896/net6 U2896/net4 VSS VSS nmos W=0.17u L=0.04u
M26335 n2196 U2896/net14 VSS VSS nmos W=0.155u L=0.04u
M26336 U2896/net10 WX3257 VSS VSS nmos W=0.155u L=0.04u
M26337 U2896/net4 U2896/net10 U2896/net14 VDD pmos W=0.255u L=0.04u
M26338 U2896/net6 WX3257 U2896/net14 VDD pmos W=0.28u L=0.04u
M26339 U2896/net4 n1375 VDD VDD pmos W=0.205u L=0.04u
M26340 U2896/net6 U2896/net4 VDD VDD pmos W=0.24u L=0.04u
M26341 n2196 U2896/net14 VDD VDD pmos W=0.205u L=0.04u
M26342 U2896/net10 WX3257 VDD VDD pmos W=0.205u L=0.04u
M26343 n2123 n2197 VSS VSS nmos W=0.135u L=0.04u
M26344 n2123 n2197 VDD VDD pmos W=0.205u L=0.04u
M26345 U2898/net28 U2898/net20 U2898/net64 VSS nmos W=0.155u L=0.04u
M26346 U2898/net24 U2898/net30 U2898/net32 VSS nmos W=0.155u L=0.04u
M26347 U2898/net28 U2898/net40 U2898/net24 VSS nmos W=0.155u L=0.04u
M26348 U2898/net40 n2198 U2898/net108 VSS nmos W=0.155u L=0.04u
M26349 U2898/net40 U2898/net106 U2898/net104 VSS nmos W=0.155u L=0.04u
M26350 U2898/net24 WX2092 U2898/net050 VSS nmos W=0.155u L=0.04u
M26351 U2898/net050 U2898/net32 VSS VSS nmos W=0.155u L=0.04u
M26352 U2898/net20 U2898/net40 VSS VSS nmos W=0.155u L=0.04u
M26353 U2898/net106 n2198 VSS VSS nmos W=0.155u L=0.04u
M26354 U2898/net104 WX2156 VSS VSS nmos W=0.155u L=0.04u
M26355 U2898/net30 WX2092 VSS VSS nmos W=0.155u L=0.04u
M26356 U2898/net108 U2898/net104 VSS VSS nmos W=0.155u L=0.04u
M26357 n2197 U2898/net28 VSS VSS nmos W=0.155u L=0.04u
M26358 U2898/net32 WX2028 VSS VSS nmos W=0.155u L=0.04u
M26359 U2898/net64 U2898/net24 VSS VSS nmos W=0.2u L=0.04u
M26360 U2898/net28 U2898/net40 U2898/net64 VDD pmos W=0.205u L=0.04u
M26361 U2898/net24 WX2092 U2898/net32 VDD pmos W=0.205u L=0.04u
M26362 U2898/net28 U2898/net20 U2898/net24 VDD pmos W=0.205u L=0.04u
M26363 U2898/net40 U2898/net106 U2898/net108 VDD pmos W=0.205u L=0.04u
M26364 U2898/net40 n2198 U2898/net104 VDD pmos W=0.205u L=0.04u
M26365 U2898/net20 U2898/net40 VDD VDD pmos W=0.205u L=0.04u
M26366 U2898/net106 n2198 VDD VDD pmos W=0.205u L=0.04u
M26367 U2898/net104 WX2156 VDD VDD pmos W=0.205u L=0.04u
M26368 U2898/net30 WX2092 VDD VDD pmos W=0.205u L=0.04u
M26369 U2898/net108 U2898/net104 VDD VDD pmos W=0.205u L=0.04u
M26370 n2197 U2898/net28 VDD VDD pmos W=0.205u L=0.04u
M26371 U2898/net32 WX2028 VDD VDD pmos W=0.205u L=0.04u
M26372 U2898/net64 U2898/net24 VDD VDD pmos W=0.28u L=0.04u
M26373 U2898/net24 U2898/net30 U2898/net045 VDD pmos W=0.205u L=0.04u
M26374 U2898/net045 U2898/net32 VDD VDD pmos W=0.205u L=0.04u
M26375 U2899/net4 WX1964 U2899/net14 VSS nmos W=0.155u L=0.04u
M26376 U2899/net6 U2899/net10 U2899/net14 VSS nmos W=0.17u L=0.04u
M26377 U2899/net4 n1375 VSS VSS nmos W=0.155u L=0.04u
M26378 U2899/net6 U2899/net4 VSS VSS nmos W=0.17u L=0.04u
M26379 n2198 U2899/net14 VSS VSS nmos W=0.155u L=0.04u
M26380 U2899/net10 WX1964 VSS VSS nmos W=0.155u L=0.04u
M26381 U2899/net4 U2899/net10 U2899/net14 VDD pmos W=0.255u L=0.04u
M26382 U2899/net6 WX1964 U2899/net14 VDD pmos W=0.28u L=0.04u
M26383 U2899/net4 n1375 VDD VDD pmos W=0.205u L=0.04u
M26384 U2899/net6 U2899/net4 VDD VDD pmos W=0.24u L=0.04u
M26385 n2198 U2899/net14 VDD VDD pmos W=0.205u L=0.04u
M26386 U2899/net10 WX1964 VDD VDD pmos W=0.205u L=0.04u
M26387 WX150 n1281 U2900/net26 VSS nmos W=0.155u L=0.04u
M26388 WX150 n2199 U2900/net26 VSS nmos W=0.155u L=0.04u
M26389 U2900/net29 n2201 VSS VSS nmos W=0.155u L=0.04u
M26390 U2900/net26 n2200 U2900/net29 VSS nmos W=0.155u L=0.04u
M26391 U2900/net26 n1253 U2900/net29 VSS nmos W=0.155u L=0.04u
M26392 WX150 n2199 U2900/net43 VDD pmos W=0.205u L=0.04u
M26393 WX150 n1253 U2900/net49 VDD pmos W=0.205u L=0.04u
M26394 U2900/net49 n2200 VDD VDD pmos W=0.205u L=0.04u
M26395 U2900/net43 n1281 VDD VDD pmos W=0.205u L=0.04u
M26396 WX150 n2201 VDD VDD pmos W=0.205u L=0.04u
M26397 U2901/net29 n1347 VSS VSS nmos W=0.155u L=0.04u
M26398 n2201 WX501 U2901/net29 VSS nmos W=0.155u L=0.04u
M26399 n2201 n1313 U2901/net23 VSS nmos W=0.155u L=0.04u
M26400 U2901/net23 CRC_OUT_9_23 VSS VSS nmos W=0.155u L=0.04u
M26401 U2901/net20 CRC_OUT_9_23 n2201 VDD pmos W=0.205u L=0.04u
M26402 U2901/net20 n1313 n2201 VDD pmos W=0.205u L=0.04u
M26403 VDD WX501 U2901/net20 VDD pmos W=0.205u L=0.04u
M26404 VDD n1347 U2901/net20 VDD pmos W=0.205u L=0.04u
M26405 WX1499 n1243 U2902/net26 VSS nmos W=0.155u L=0.04u
M26406 WX1499 n2126 U2902/net26 VSS nmos W=0.155u L=0.04u
M26407 U2902/net29 n2202 VSS VSS nmos W=0.155u L=0.04u
M26408 U2902/net26 n2060 U2902/net29 VSS nmos W=0.155u L=0.04u
M26409 U2902/net26 n1290 U2902/net29 VSS nmos W=0.155u L=0.04u
M26410 WX1499 n2126 U2902/net43 VDD pmos W=0.205u L=0.04u
M26411 WX1499 n1290 U2902/net49 VDD pmos W=0.205u L=0.04u
M26412 U2902/net49 n2060 VDD VDD pmos W=0.205u L=0.04u
M26413 U2902/net43 n1243 VDD VDD pmos W=0.205u L=0.04u
M26414 WX1499 n2202 VDD VDD pmos W=0.205u L=0.04u
M26415 U2903/net29 n1346 VSS VSS nmos W=0.155u L=0.04u
M26416 n2202 WX1802 U2903/net29 VSS nmos W=0.155u L=0.04u
M26417 n2202 n1313 U2903/net23 VSS nmos W=0.155u L=0.04u
M26418 U2903/net23 CRC_OUT_8_19 VSS VSS nmos W=0.155u L=0.04u
M26419 U2903/net20 CRC_OUT_8_19 n2202 VDD pmos W=0.205u L=0.04u
M26420 U2903/net20 n1313 n2202 VDD pmos W=0.205u L=0.04u
M26421 VDD WX1802 U2903/net20 VDD pmos W=0.205u L=0.04u
M26422 VDD n1346 U2903/net20 VDD pmos W=0.205u L=0.04u
M26423 n2060 n2203 VSS VSS nmos W=0.135u L=0.04u
M26424 n2060 n2203 VDD VDD pmos W=0.205u L=0.04u
M26425 U2905/net28 U2905/net20 U2905/net64 VSS nmos W=0.155u L=0.04u
M26426 U2905/net24 U2905/net30 U2905/net32 VSS nmos W=0.155u L=0.04u
M26427 U2905/net28 U2905/net40 U2905/net24 VSS nmos W=0.155u L=0.04u
M26428 U2905/net40 n2204 U2905/net108 VSS nmos W=0.155u L=0.04u
M26429 U2905/net40 U2905/net106 U2905/net104 VSS nmos W=0.155u L=0.04u
M26430 U2905/net24 WX3383 U2905/net050 VSS nmos W=0.155u L=0.04u
M26431 U2905/net050 U2905/net32 VSS VSS nmos W=0.155u L=0.04u
M26432 U2905/net20 U2905/net40 VSS VSS nmos W=0.155u L=0.04u
M26433 U2905/net106 n2204 VSS VSS nmos W=0.155u L=0.04u
M26434 U2905/net104 WX3447 VSS VSS nmos W=0.155u L=0.04u
M26435 U2905/net30 WX3383 VSS VSS nmos W=0.155u L=0.04u
M26436 U2905/net108 U2905/net104 VSS VSS nmos W=0.155u L=0.04u
M26437 n2203 U2905/net28 VSS VSS nmos W=0.155u L=0.04u
M26438 U2905/net32 WX3319 VSS VSS nmos W=0.155u L=0.04u
M26439 U2905/net64 U2905/net24 VSS VSS nmos W=0.2u L=0.04u
M26440 U2905/net28 U2905/net40 U2905/net64 VDD pmos W=0.205u L=0.04u
M26441 U2905/net24 WX3383 U2905/net32 VDD pmos W=0.205u L=0.04u
M26442 U2905/net28 U2905/net20 U2905/net24 VDD pmos W=0.205u L=0.04u
M26443 U2905/net40 U2905/net106 U2905/net108 VDD pmos W=0.205u L=0.04u
M26444 U2905/net40 n2204 U2905/net104 VDD pmos W=0.205u L=0.04u
M26445 U2905/net20 U2905/net40 VDD VDD pmos W=0.205u L=0.04u
M26446 U2905/net106 n2204 VDD VDD pmos W=0.205u L=0.04u
M26447 U2905/net104 WX3447 VDD VDD pmos W=0.205u L=0.04u
M26448 U2905/net30 WX3383 VDD VDD pmos W=0.205u L=0.04u
M26449 U2905/net108 U2905/net104 VDD VDD pmos W=0.205u L=0.04u
M26450 n2203 U2905/net28 VDD VDD pmos W=0.205u L=0.04u
M26451 U2905/net32 WX3319 VDD VDD pmos W=0.205u L=0.04u
M26452 U2905/net64 U2905/net24 VDD VDD pmos W=0.28u L=0.04u
M26453 U2905/net24 U2905/net30 U2905/net045 VDD pmos W=0.205u L=0.04u
M26454 U2905/net045 U2905/net32 VDD VDD pmos W=0.205u L=0.04u
M26455 U2906/net4 WX3255 U2906/net14 VSS nmos W=0.155u L=0.04u
M26456 U2906/net6 U2906/net10 U2906/net14 VSS nmos W=0.17u L=0.04u
M26457 U2906/net4 n1375 VSS VSS nmos W=0.155u L=0.04u
M26458 U2906/net6 U2906/net4 VSS VSS nmos W=0.17u L=0.04u
M26459 n2204 U2906/net14 VSS VSS nmos W=0.155u L=0.04u
M26460 U2906/net10 WX3255 VSS VSS nmos W=0.155u L=0.04u
M26461 U2906/net4 U2906/net10 U2906/net14 VDD pmos W=0.255u L=0.04u
M26462 U2906/net6 WX3255 U2906/net14 VDD pmos W=0.28u L=0.04u
M26463 U2906/net4 n1375 VDD VDD pmos W=0.205u L=0.04u
M26464 U2906/net6 U2906/net4 VDD VDD pmos W=0.24u L=0.04u
M26465 n2204 U2906/net14 VDD VDD pmos W=0.205u L=0.04u
M26466 U2906/net10 WX3255 VDD VDD pmos W=0.205u L=0.04u
M26467 n2126 n2205 VSS VSS nmos W=0.135u L=0.04u
M26468 n2126 n2205 VDD VDD pmos W=0.205u L=0.04u
M26469 U2908/net28 U2908/net20 U2908/net64 VSS nmos W=0.155u L=0.04u
M26470 U2908/net24 U2908/net30 U2908/net32 VSS nmos W=0.155u L=0.04u
M26471 U2908/net28 U2908/net40 U2908/net24 VSS nmos W=0.155u L=0.04u
M26472 U2908/net40 n2206 U2908/net108 VSS nmos W=0.155u L=0.04u
M26473 U2908/net40 U2908/net106 U2908/net104 VSS nmos W=0.155u L=0.04u
M26474 U2908/net24 WX2090 U2908/net050 VSS nmos W=0.155u L=0.04u
M26475 U2908/net050 U2908/net32 VSS VSS nmos W=0.155u L=0.04u
M26476 U2908/net20 U2908/net40 VSS VSS nmos W=0.155u L=0.04u
M26477 U2908/net106 n2206 VSS VSS nmos W=0.155u L=0.04u
M26478 U2908/net104 WX2154 VSS VSS nmos W=0.155u L=0.04u
M26479 U2908/net30 WX2090 VSS VSS nmos W=0.155u L=0.04u
M26480 U2908/net108 U2908/net104 VSS VSS nmos W=0.155u L=0.04u
M26481 n2205 U2908/net28 VSS VSS nmos W=0.155u L=0.04u
M26482 U2908/net32 WX2026 VSS VSS nmos W=0.155u L=0.04u
M26483 U2908/net64 U2908/net24 VSS VSS nmos W=0.2u L=0.04u
M26484 U2908/net28 U2908/net40 U2908/net64 VDD pmos W=0.205u L=0.04u
M26485 U2908/net24 WX2090 U2908/net32 VDD pmos W=0.205u L=0.04u
M26486 U2908/net28 U2908/net20 U2908/net24 VDD pmos W=0.205u L=0.04u
M26487 U2908/net40 U2908/net106 U2908/net108 VDD pmos W=0.205u L=0.04u
M26488 U2908/net40 n2206 U2908/net104 VDD pmos W=0.205u L=0.04u
M26489 U2908/net20 U2908/net40 VDD VDD pmos W=0.205u L=0.04u
M26490 U2908/net106 n2206 VDD VDD pmos W=0.205u L=0.04u
M26491 U2908/net104 WX2154 VDD VDD pmos W=0.205u L=0.04u
M26492 U2908/net30 WX2090 VDD VDD pmos W=0.205u L=0.04u
M26493 U2908/net108 U2908/net104 VDD VDD pmos W=0.205u L=0.04u
M26494 n2205 U2908/net28 VDD VDD pmos W=0.205u L=0.04u
M26495 U2908/net32 WX2026 VDD VDD pmos W=0.205u L=0.04u
M26496 U2908/net64 U2908/net24 VDD VDD pmos W=0.28u L=0.04u
M26497 U2908/net24 U2908/net30 U2908/net045 VDD pmos W=0.205u L=0.04u
M26498 U2908/net045 U2908/net32 VDD VDD pmos W=0.205u L=0.04u
M26499 U2909/net4 WX1962 U2909/net14 VSS nmos W=0.155u L=0.04u
M26500 U2909/net6 U2909/net10 U2909/net14 VSS nmos W=0.17u L=0.04u
M26501 U2909/net4 n1375 VSS VSS nmos W=0.155u L=0.04u
M26502 U2909/net6 U2909/net4 VSS VSS nmos W=0.17u L=0.04u
M26503 n2206 U2909/net14 VSS VSS nmos W=0.155u L=0.04u
M26504 U2909/net10 WX1962 VSS VSS nmos W=0.155u L=0.04u
M26505 U2909/net4 U2909/net10 U2909/net14 VDD pmos W=0.255u L=0.04u
M26506 U2909/net6 WX1962 U2909/net14 VDD pmos W=0.28u L=0.04u
M26507 U2909/net4 n1375 VDD VDD pmos W=0.205u L=0.04u
M26508 U2909/net6 U2909/net4 VDD VDD pmos W=0.24u L=0.04u
M26509 n2206 U2909/net14 VDD VDD pmos W=0.205u L=0.04u
M26510 U2909/net10 WX1962 VDD VDD pmos W=0.205u L=0.04u
M26511 WX1485 n1243 U2910/net26 VSS nmos W=0.155u L=0.04u
M26512 WX1485 n2129 U2910/net26 VSS nmos W=0.155u L=0.04u
M26513 U2910/net29 n2207 VSS VSS nmos W=0.155u L=0.04u
M26514 U2910/net26 n2064 U2910/net29 VSS nmos W=0.155u L=0.04u
M26515 U2910/net26 n1290 U2910/net29 VSS nmos W=0.155u L=0.04u
M26516 WX1485 n2129 U2910/net43 VDD pmos W=0.205u L=0.04u
M26517 WX1485 n1290 U2910/net49 VDD pmos W=0.205u L=0.04u
M26518 U2910/net49 n2064 VDD VDD pmos W=0.205u L=0.04u
M26519 U2910/net43 n1243 VDD VDD pmos W=0.205u L=0.04u
M26520 WX1485 n2207 VDD VDD pmos W=0.205u L=0.04u
M26521 U2911/net29 n1346 VSS VSS nmos W=0.155u L=0.04u
M26522 n2207 WX1800 U2911/net29 VSS nmos W=0.155u L=0.04u
M26523 n2207 n1313 U2911/net23 VSS nmos W=0.155u L=0.04u
M26524 U2911/net23 CRC_OUT_8_20 VSS VSS nmos W=0.155u L=0.04u
M26525 U2911/net20 CRC_OUT_8_20 n2207 VDD pmos W=0.205u L=0.04u
M26526 U2911/net20 n1313 n2207 VDD pmos W=0.205u L=0.04u
M26527 VDD WX1800 U2911/net20 VDD pmos W=0.205u L=0.04u
M26528 VDD n1346 U2911/net20 VDD pmos W=0.205u L=0.04u
M26529 n2064 n2208 VSS VSS nmos W=0.135u L=0.04u
M26530 n2064 n2208 VDD VDD pmos W=0.205u L=0.04u
M26531 U2913/net28 U2913/net20 U2913/net64 VSS nmos W=0.155u L=0.04u
M26532 U2913/net24 U2913/net30 U2913/net32 VSS nmos W=0.155u L=0.04u
M26533 U2913/net28 U2913/net40 U2913/net24 VSS nmos W=0.155u L=0.04u
M26534 U2913/net40 n2209 U2913/net108 VSS nmos W=0.155u L=0.04u
M26535 U2913/net40 U2913/net106 U2913/net104 VSS nmos W=0.155u L=0.04u
M26536 U2913/net24 WX3381 U2913/net050 VSS nmos W=0.155u L=0.04u
M26537 U2913/net050 U2913/net32 VSS VSS nmos W=0.155u L=0.04u
M26538 U2913/net20 U2913/net40 VSS VSS nmos W=0.155u L=0.04u
M26539 U2913/net106 n2209 VSS VSS nmos W=0.155u L=0.04u
M26540 U2913/net104 WX3445 VSS VSS nmos W=0.155u L=0.04u
M26541 U2913/net30 WX3381 VSS VSS nmos W=0.155u L=0.04u
M26542 U2913/net108 U2913/net104 VSS VSS nmos W=0.155u L=0.04u
M26543 n2208 U2913/net28 VSS VSS nmos W=0.155u L=0.04u
M26544 U2913/net32 WX3317 VSS VSS nmos W=0.155u L=0.04u
M26545 U2913/net64 U2913/net24 VSS VSS nmos W=0.2u L=0.04u
M26546 U2913/net28 U2913/net40 U2913/net64 VDD pmos W=0.205u L=0.04u
M26547 U2913/net24 WX3381 U2913/net32 VDD pmos W=0.205u L=0.04u
M26548 U2913/net28 U2913/net20 U2913/net24 VDD pmos W=0.205u L=0.04u
M26549 U2913/net40 U2913/net106 U2913/net108 VDD pmos W=0.205u L=0.04u
M26550 U2913/net40 n2209 U2913/net104 VDD pmos W=0.205u L=0.04u
M26551 U2913/net20 U2913/net40 VDD VDD pmos W=0.205u L=0.04u
M26552 U2913/net106 n2209 VDD VDD pmos W=0.205u L=0.04u
M26553 U2913/net104 WX3445 VDD VDD pmos W=0.205u L=0.04u
M26554 U2913/net30 WX3381 VDD VDD pmos W=0.205u L=0.04u
M26555 U2913/net108 U2913/net104 VDD VDD pmos W=0.205u L=0.04u
M26556 n2208 U2913/net28 VDD VDD pmos W=0.205u L=0.04u
M26557 U2913/net32 WX3317 VDD VDD pmos W=0.205u L=0.04u
M26558 U2913/net64 U2913/net24 VDD VDD pmos W=0.28u L=0.04u
M26559 U2913/net24 U2913/net30 U2913/net045 VDD pmos W=0.205u L=0.04u
M26560 U2913/net045 U2913/net32 VDD VDD pmos W=0.205u L=0.04u
M26561 U2914/net4 WX3253 U2914/net14 VSS nmos W=0.155u L=0.04u
M26562 U2914/net6 U2914/net10 U2914/net14 VSS nmos W=0.17u L=0.04u
M26563 U2914/net4 n1375 VSS VSS nmos W=0.155u L=0.04u
M26564 U2914/net6 U2914/net4 VSS VSS nmos W=0.17u L=0.04u
M26565 n2209 U2914/net14 VSS VSS nmos W=0.155u L=0.04u
M26566 U2914/net10 WX3253 VSS VSS nmos W=0.155u L=0.04u
M26567 U2914/net4 U2914/net10 U2914/net14 VDD pmos W=0.255u L=0.04u
M26568 U2914/net6 WX3253 U2914/net14 VDD pmos W=0.28u L=0.04u
M26569 U2914/net4 n1375 VDD VDD pmos W=0.205u L=0.04u
M26570 U2914/net6 U2914/net4 VDD VDD pmos W=0.24u L=0.04u
M26571 n2209 U2914/net14 VDD VDD pmos W=0.205u L=0.04u
M26572 U2914/net10 WX3253 VDD VDD pmos W=0.205u L=0.04u
M26573 n2129 n2210 VSS VSS nmos W=0.135u L=0.04u
M26574 n2129 n2210 VDD VDD pmos W=0.205u L=0.04u
M26575 U2916/net28 U2916/net20 U2916/net64 VSS nmos W=0.155u L=0.04u
M26576 U2916/net24 U2916/net30 U2916/net32 VSS nmos W=0.155u L=0.04u
M26577 U2916/net28 U2916/net40 U2916/net24 VSS nmos W=0.155u L=0.04u
M26578 U2916/net40 n2211 U2916/net108 VSS nmos W=0.155u L=0.04u
M26579 U2916/net40 U2916/net106 U2916/net104 VSS nmos W=0.155u L=0.04u
M26580 U2916/net24 WX2088 U2916/net050 VSS nmos W=0.155u L=0.04u
M26581 U2916/net050 U2916/net32 VSS VSS nmos W=0.155u L=0.04u
M26582 U2916/net20 U2916/net40 VSS VSS nmos W=0.155u L=0.04u
M26583 U2916/net106 n2211 VSS VSS nmos W=0.155u L=0.04u
M26584 U2916/net104 WX2152 VSS VSS nmos W=0.155u L=0.04u
M26585 U2916/net30 WX2088 VSS VSS nmos W=0.155u L=0.04u
M26586 U2916/net108 U2916/net104 VSS VSS nmos W=0.155u L=0.04u
M26587 n2210 U2916/net28 VSS VSS nmos W=0.155u L=0.04u
M26588 U2916/net32 WX2024 VSS VSS nmos W=0.155u L=0.04u
M26589 U2916/net64 U2916/net24 VSS VSS nmos W=0.2u L=0.04u
M26590 U2916/net28 U2916/net40 U2916/net64 VDD pmos W=0.205u L=0.04u
M26591 U2916/net24 WX2088 U2916/net32 VDD pmos W=0.205u L=0.04u
M26592 U2916/net28 U2916/net20 U2916/net24 VDD pmos W=0.205u L=0.04u
M26593 U2916/net40 U2916/net106 U2916/net108 VDD pmos W=0.205u L=0.04u
M26594 U2916/net40 n2211 U2916/net104 VDD pmos W=0.205u L=0.04u
M26595 U2916/net20 U2916/net40 VDD VDD pmos W=0.205u L=0.04u
M26596 U2916/net106 n2211 VDD VDD pmos W=0.205u L=0.04u
M26597 U2916/net104 WX2152 VDD VDD pmos W=0.205u L=0.04u
M26598 U2916/net30 WX2088 VDD VDD pmos W=0.205u L=0.04u
M26599 U2916/net108 U2916/net104 VDD VDD pmos W=0.205u L=0.04u
M26600 n2210 U2916/net28 VDD VDD pmos W=0.205u L=0.04u
M26601 U2916/net32 WX2024 VDD VDD pmos W=0.205u L=0.04u
M26602 U2916/net64 U2916/net24 VDD VDD pmos W=0.28u L=0.04u
M26603 U2916/net24 U2916/net30 U2916/net045 VDD pmos W=0.205u L=0.04u
M26604 U2916/net045 U2916/net32 VDD VDD pmos W=0.205u L=0.04u
M26605 U2917/net4 WX1960 U2917/net14 VSS nmos W=0.155u L=0.04u
M26606 U2917/net6 U2917/net10 U2917/net14 VSS nmos W=0.17u L=0.04u
M26607 U2917/net4 n1375 VSS VSS nmos W=0.155u L=0.04u
M26608 U2917/net6 U2917/net4 VSS VSS nmos W=0.17u L=0.04u
M26609 n2211 U2917/net14 VSS VSS nmos W=0.155u L=0.04u
M26610 U2917/net10 WX1960 VSS VSS nmos W=0.155u L=0.04u
M26611 U2917/net4 U2917/net10 U2917/net14 VDD pmos W=0.255u L=0.04u
M26612 U2917/net6 WX1960 U2917/net14 VDD pmos W=0.28u L=0.04u
M26613 U2917/net4 n1375 VDD VDD pmos W=0.205u L=0.04u
M26614 U2917/net6 U2917/net4 VDD VDD pmos W=0.24u L=0.04u
M26615 n2211 U2917/net14 VDD VDD pmos W=0.205u L=0.04u
M26616 U2917/net10 WX1960 VDD VDD pmos W=0.205u L=0.04u
M26617 WX1471 n1243 U2918/net26 VSS nmos W=0.155u L=0.04u
M26618 WX1471 n2132 U2918/net26 VSS nmos W=0.155u L=0.04u
M26619 U2918/net29 n2212 VSS VSS nmos W=0.155u L=0.04u
M26620 U2918/net26 n2068 U2918/net29 VSS nmos W=0.155u L=0.04u
M26621 U2918/net26 n1290 U2918/net29 VSS nmos W=0.155u L=0.04u
M26622 WX1471 n2132 U2918/net43 VDD pmos W=0.205u L=0.04u
M26623 WX1471 n1290 U2918/net49 VDD pmos W=0.205u L=0.04u
M26624 U2918/net49 n2068 VDD VDD pmos W=0.205u L=0.04u
M26625 U2918/net43 n1243 VDD VDD pmos W=0.205u L=0.04u
M26626 WX1471 n2212 VDD VDD pmos W=0.205u L=0.04u
M26627 U2919/net29 n1346 VSS VSS nmos W=0.155u L=0.04u
M26628 n2212 WX1798 U2919/net29 VSS nmos W=0.155u L=0.04u
M26629 n2212 n1313 U2919/net23 VSS nmos W=0.155u L=0.04u
M26630 U2919/net23 CRC_OUT_8_21 VSS VSS nmos W=0.155u L=0.04u
M26631 U2919/net20 CRC_OUT_8_21 n2212 VDD pmos W=0.205u L=0.04u
M26632 U2919/net20 n1313 n2212 VDD pmos W=0.205u L=0.04u
M26633 VDD WX1798 U2919/net20 VDD pmos W=0.205u L=0.04u
M26634 VDD n1346 U2919/net20 VDD pmos W=0.205u L=0.04u
M26635 n2068 n2213 VSS VSS nmos W=0.135u L=0.04u
M26636 n2068 n2213 VDD VDD pmos W=0.205u L=0.04u
M26637 U2921/net28 U2921/net20 U2921/net64 VSS nmos W=0.155u L=0.04u
M26638 U2921/net24 U2921/net30 U2921/net32 VSS nmos W=0.155u L=0.04u
M26639 U2921/net28 U2921/net40 U2921/net24 VSS nmos W=0.155u L=0.04u
M26640 U2921/net40 n2214 U2921/net108 VSS nmos W=0.155u L=0.04u
M26641 U2921/net40 U2921/net106 U2921/net104 VSS nmos W=0.155u L=0.04u
M26642 U2921/net24 WX3379 U2921/net050 VSS nmos W=0.155u L=0.04u
M26643 U2921/net050 U2921/net32 VSS VSS nmos W=0.155u L=0.04u
M26644 U2921/net20 U2921/net40 VSS VSS nmos W=0.155u L=0.04u
M26645 U2921/net106 n2214 VSS VSS nmos W=0.155u L=0.04u
M26646 U2921/net104 WX3443 VSS VSS nmos W=0.155u L=0.04u
M26647 U2921/net30 WX3379 VSS VSS nmos W=0.155u L=0.04u
M26648 U2921/net108 U2921/net104 VSS VSS nmos W=0.155u L=0.04u
M26649 n2213 U2921/net28 VSS VSS nmos W=0.155u L=0.04u
M26650 U2921/net32 WX3315 VSS VSS nmos W=0.155u L=0.04u
M26651 U2921/net64 U2921/net24 VSS VSS nmos W=0.2u L=0.04u
M26652 U2921/net28 U2921/net40 U2921/net64 VDD pmos W=0.205u L=0.04u
M26653 U2921/net24 WX3379 U2921/net32 VDD pmos W=0.205u L=0.04u
M26654 U2921/net28 U2921/net20 U2921/net24 VDD pmos W=0.205u L=0.04u
M26655 U2921/net40 U2921/net106 U2921/net108 VDD pmos W=0.205u L=0.04u
M26656 U2921/net40 n2214 U2921/net104 VDD pmos W=0.205u L=0.04u
M26657 U2921/net20 U2921/net40 VDD VDD pmos W=0.205u L=0.04u
M26658 U2921/net106 n2214 VDD VDD pmos W=0.205u L=0.04u
M26659 U2921/net104 WX3443 VDD VDD pmos W=0.205u L=0.04u
M26660 U2921/net30 WX3379 VDD VDD pmos W=0.205u L=0.04u
M26661 U2921/net108 U2921/net104 VDD VDD pmos W=0.205u L=0.04u
M26662 n2213 U2921/net28 VDD VDD pmos W=0.205u L=0.04u
M26663 U2921/net32 WX3315 VDD VDD pmos W=0.205u L=0.04u
M26664 U2921/net64 U2921/net24 VDD VDD pmos W=0.28u L=0.04u
M26665 U2921/net24 U2921/net30 U2921/net045 VDD pmos W=0.205u L=0.04u
M26666 U2921/net045 U2921/net32 VDD VDD pmos W=0.205u L=0.04u
M26667 U2922/net4 WX3251 U2922/net14 VSS nmos W=0.155u L=0.04u
M26668 U2922/net6 U2922/net10 U2922/net14 VSS nmos W=0.17u L=0.04u
M26669 U2922/net4 n1375 VSS VSS nmos W=0.155u L=0.04u
M26670 U2922/net6 U2922/net4 VSS VSS nmos W=0.17u L=0.04u
M26671 n2214 U2922/net14 VSS VSS nmos W=0.155u L=0.04u
M26672 U2922/net10 WX3251 VSS VSS nmos W=0.155u L=0.04u
M26673 U2922/net4 U2922/net10 U2922/net14 VDD pmos W=0.255u L=0.04u
M26674 U2922/net6 WX3251 U2922/net14 VDD pmos W=0.28u L=0.04u
M26675 U2922/net4 n1375 VDD VDD pmos W=0.205u L=0.04u
M26676 U2922/net6 U2922/net4 VDD VDD pmos W=0.24u L=0.04u
M26677 n2214 U2922/net14 VDD VDD pmos W=0.205u L=0.04u
M26678 U2922/net10 WX3251 VDD VDD pmos W=0.205u L=0.04u
M26679 n2132 n2215 VSS VSS nmos W=0.135u L=0.04u
M26680 n2132 n2215 VDD VDD pmos W=0.205u L=0.04u
M26681 U2924/net28 U2924/net20 U2924/net64 VSS nmos W=0.155u L=0.04u
M26682 U2924/net24 U2924/net30 U2924/net32 VSS nmos W=0.155u L=0.04u
M26683 U2924/net28 U2924/net40 U2924/net24 VSS nmos W=0.155u L=0.04u
M26684 U2924/net40 n2216 U2924/net108 VSS nmos W=0.155u L=0.04u
M26685 U2924/net40 U2924/net106 U2924/net104 VSS nmos W=0.155u L=0.04u
M26686 U2924/net24 WX2086 U2924/net050 VSS nmos W=0.155u L=0.04u
M26687 U2924/net050 U2924/net32 VSS VSS nmos W=0.155u L=0.04u
M26688 U2924/net20 U2924/net40 VSS VSS nmos W=0.155u L=0.04u
M26689 U2924/net106 n2216 VSS VSS nmos W=0.155u L=0.04u
M26690 U2924/net104 WX2150 VSS VSS nmos W=0.155u L=0.04u
M26691 U2924/net30 WX2086 VSS VSS nmos W=0.155u L=0.04u
M26692 U2924/net108 U2924/net104 VSS VSS nmos W=0.155u L=0.04u
M26693 n2215 U2924/net28 VSS VSS nmos W=0.155u L=0.04u
M26694 U2924/net32 WX2022 VSS VSS nmos W=0.155u L=0.04u
M26695 U2924/net64 U2924/net24 VSS VSS nmos W=0.2u L=0.04u
M26696 U2924/net28 U2924/net40 U2924/net64 VDD pmos W=0.205u L=0.04u
M26697 U2924/net24 WX2086 U2924/net32 VDD pmos W=0.205u L=0.04u
M26698 U2924/net28 U2924/net20 U2924/net24 VDD pmos W=0.205u L=0.04u
M26699 U2924/net40 U2924/net106 U2924/net108 VDD pmos W=0.205u L=0.04u
M26700 U2924/net40 n2216 U2924/net104 VDD pmos W=0.205u L=0.04u
M26701 U2924/net20 U2924/net40 VDD VDD pmos W=0.205u L=0.04u
M26702 U2924/net106 n2216 VDD VDD pmos W=0.205u L=0.04u
M26703 U2924/net104 WX2150 VDD VDD pmos W=0.205u L=0.04u
M26704 U2924/net30 WX2086 VDD VDD pmos W=0.205u L=0.04u
M26705 U2924/net108 U2924/net104 VDD VDD pmos W=0.205u L=0.04u
M26706 n2215 U2924/net28 VDD VDD pmos W=0.205u L=0.04u
M26707 U2924/net32 WX2022 VDD VDD pmos W=0.205u L=0.04u
M26708 U2924/net64 U2924/net24 VDD VDD pmos W=0.28u L=0.04u
M26709 U2924/net24 U2924/net30 U2924/net045 VDD pmos W=0.205u L=0.04u
M26710 U2924/net045 U2924/net32 VDD VDD pmos W=0.205u L=0.04u
M26711 U2925/net4 WX1958 U2925/net14 VSS nmos W=0.155u L=0.04u
M26712 U2925/net6 U2925/net10 U2925/net14 VSS nmos W=0.17u L=0.04u
M26713 U2925/net4 n1375 VSS VSS nmos W=0.155u L=0.04u
M26714 U2925/net6 U2925/net4 VSS VSS nmos W=0.17u L=0.04u
M26715 n2216 U2925/net14 VSS VSS nmos W=0.155u L=0.04u
M26716 U2925/net10 WX1958 VSS VSS nmos W=0.155u L=0.04u
M26717 U2925/net4 U2925/net10 U2925/net14 VDD pmos W=0.255u L=0.04u
M26718 U2925/net6 WX1958 U2925/net14 VDD pmos W=0.28u L=0.04u
M26719 U2925/net4 n1375 VDD VDD pmos W=0.205u L=0.04u
M26720 U2925/net6 U2925/net4 VDD VDD pmos W=0.24u L=0.04u
M26721 n2216 U2925/net14 VDD VDD pmos W=0.205u L=0.04u
M26722 U2925/net10 WX1958 VDD VDD pmos W=0.205u L=0.04u
M26723 WX1457 n1243 U2926/net26 VSS nmos W=0.155u L=0.04u
M26724 WX1457 n2160 U2926/net26 VSS nmos W=0.155u L=0.04u
M26725 U2926/net29 n2217 VSS VSS nmos W=0.155u L=0.04u
M26726 U2926/net26 n2075 U2926/net29 VSS nmos W=0.155u L=0.04u
M26727 U2926/net26 n1290 U2926/net29 VSS nmos W=0.155u L=0.04u
M26728 WX1457 n2160 U2926/net43 VDD pmos W=0.205u L=0.04u
M26729 WX1457 n1290 U2926/net49 VDD pmos W=0.205u L=0.04u
M26730 U2926/net49 n2075 VDD VDD pmos W=0.205u L=0.04u
M26731 U2926/net43 n1243 VDD VDD pmos W=0.205u L=0.04u
M26732 WX1457 n2217 VDD VDD pmos W=0.205u L=0.04u
M26733 U2927/net29 n1346 VSS VSS nmos W=0.155u L=0.04u
M26734 n2217 WX1796 U2927/net29 VSS nmos W=0.155u L=0.04u
M26735 n2217 n1313 U2927/net23 VSS nmos W=0.155u L=0.04u
M26736 U2927/net23 CRC_OUT_8_22 VSS VSS nmos W=0.155u L=0.04u
M26737 U2927/net20 CRC_OUT_8_22 n2217 VDD pmos W=0.205u L=0.04u
M26738 U2927/net20 n1313 n2217 VDD pmos W=0.205u L=0.04u
M26739 VDD WX1796 U2927/net20 VDD pmos W=0.205u L=0.04u
M26740 VDD n1346 U2927/net20 VDD pmos W=0.205u L=0.04u
M26741 n2075 n2218 VSS VSS nmos W=0.135u L=0.04u
M26742 n2075 n2218 VDD VDD pmos W=0.205u L=0.04u
M26743 U2929/net28 U2929/net20 U2929/net64 VSS nmos W=0.155u L=0.04u
M26744 U2929/net24 U2929/net30 U2929/net32 VSS nmos W=0.155u L=0.04u
M26745 U2929/net28 U2929/net40 U2929/net24 VSS nmos W=0.155u L=0.04u
M26746 U2929/net40 n2219 U2929/net108 VSS nmos W=0.155u L=0.04u
M26747 U2929/net40 U2929/net106 U2929/net104 VSS nmos W=0.155u L=0.04u
M26748 U2929/net24 WX3377 U2929/net050 VSS nmos W=0.155u L=0.04u
M26749 U2929/net050 U2929/net32 VSS VSS nmos W=0.155u L=0.04u
M26750 U2929/net20 U2929/net40 VSS VSS nmos W=0.155u L=0.04u
M26751 U2929/net106 n2219 VSS VSS nmos W=0.155u L=0.04u
M26752 U2929/net104 WX3441 VSS VSS nmos W=0.155u L=0.04u
M26753 U2929/net30 WX3377 VSS VSS nmos W=0.155u L=0.04u
M26754 U2929/net108 U2929/net104 VSS VSS nmos W=0.155u L=0.04u
M26755 n2218 U2929/net28 VSS VSS nmos W=0.155u L=0.04u
M26756 U2929/net32 WX3313 VSS VSS nmos W=0.155u L=0.04u
M26757 U2929/net64 U2929/net24 VSS VSS nmos W=0.2u L=0.04u
M26758 U2929/net28 U2929/net40 U2929/net64 VDD pmos W=0.205u L=0.04u
M26759 U2929/net24 WX3377 U2929/net32 VDD pmos W=0.205u L=0.04u
M26760 U2929/net28 U2929/net20 U2929/net24 VDD pmos W=0.205u L=0.04u
M26761 U2929/net40 U2929/net106 U2929/net108 VDD pmos W=0.205u L=0.04u
M26762 U2929/net40 n2219 U2929/net104 VDD pmos W=0.205u L=0.04u
M26763 U2929/net20 U2929/net40 VDD VDD pmos W=0.205u L=0.04u
M26764 U2929/net106 n2219 VDD VDD pmos W=0.205u L=0.04u
M26765 U2929/net104 WX3441 VDD VDD pmos W=0.205u L=0.04u
M26766 U2929/net30 WX3377 VDD VDD pmos W=0.205u L=0.04u
M26767 U2929/net108 U2929/net104 VDD VDD pmos W=0.205u L=0.04u
M26768 n2218 U2929/net28 VDD VDD pmos W=0.205u L=0.04u
M26769 U2929/net32 WX3313 VDD VDD pmos W=0.205u L=0.04u
M26770 U2929/net64 U2929/net24 VDD VDD pmos W=0.28u L=0.04u
M26771 U2929/net24 U2929/net30 U2929/net045 VDD pmos W=0.205u L=0.04u
M26772 U2929/net045 U2929/net32 VDD VDD pmos W=0.205u L=0.04u
M26773 U2930/net4 WX3249 U2930/net14 VSS nmos W=0.155u L=0.04u
M26774 U2930/net6 U2930/net10 U2930/net14 VSS nmos W=0.17u L=0.04u
M26775 U2930/net4 n1375 VSS VSS nmos W=0.155u L=0.04u
M26776 U2930/net6 U2930/net4 VSS VSS nmos W=0.17u L=0.04u
M26777 n2219 U2930/net14 VSS VSS nmos W=0.155u L=0.04u
M26778 U2930/net10 WX3249 VSS VSS nmos W=0.155u L=0.04u
M26779 U2930/net4 U2930/net10 U2930/net14 VDD pmos W=0.255u L=0.04u
M26780 U2930/net6 WX3249 U2930/net14 VDD pmos W=0.28u L=0.04u
M26781 U2930/net4 n1375 VDD VDD pmos W=0.205u L=0.04u
M26782 U2930/net6 U2930/net4 VDD VDD pmos W=0.24u L=0.04u
M26783 n2219 U2930/net14 VDD VDD pmos W=0.205u L=0.04u
M26784 U2930/net10 WX3249 VDD VDD pmos W=0.205u L=0.04u
M26785 n2160 n2220 VSS VSS nmos W=0.135u L=0.04u
M26786 n2160 n2220 VDD VDD pmos W=0.205u L=0.04u
M26787 U2932/net28 U2932/net20 U2932/net64 VSS nmos W=0.155u L=0.04u
M26788 U2932/net24 U2932/net30 U2932/net32 VSS nmos W=0.155u L=0.04u
M26789 U2932/net28 U2932/net40 U2932/net24 VSS nmos W=0.155u L=0.04u
M26790 U2932/net40 n2221 U2932/net108 VSS nmos W=0.155u L=0.04u
M26791 U2932/net40 U2932/net106 U2932/net104 VSS nmos W=0.155u L=0.04u
M26792 U2932/net24 WX2084 U2932/net050 VSS nmos W=0.155u L=0.04u
M26793 U2932/net050 U2932/net32 VSS VSS nmos W=0.155u L=0.04u
M26794 U2932/net20 U2932/net40 VSS VSS nmos W=0.155u L=0.04u
M26795 U2932/net106 n2221 VSS VSS nmos W=0.155u L=0.04u
M26796 U2932/net104 WX2148 VSS VSS nmos W=0.155u L=0.04u
M26797 U2932/net30 WX2084 VSS VSS nmos W=0.155u L=0.04u
M26798 U2932/net108 U2932/net104 VSS VSS nmos W=0.155u L=0.04u
M26799 n2220 U2932/net28 VSS VSS nmos W=0.155u L=0.04u
M26800 U2932/net32 WX2020 VSS VSS nmos W=0.155u L=0.04u
M26801 U2932/net64 U2932/net24 VSS VSS nmos W=0.2u L=0.04u
M26802 U2932/net28 U2932/net40 U2932/net64 VDD pmos W=0.205u L=0.04u
M26803 U2932/net24 WX2084 U2932/net32 VDD pmos W=0.205u L=0.04u
M26804 U2932/net28 U2932/net20 U2932/net24 VDD pmos W=0.205u L=0.04u
M26805 U2932/net40 U2932/net106 U2932/net108 VDD pmos W=0.205u L=0.04u
M26806 U2932/net40 n2221 U2932/net104 VDD pmos W=0.205u L=0.04u
M26807 U2932/net20 U2932/net40 VDD VDD pmos W=0.205u L=0.04u
M26808 U2932/net106 n2221 VDD VDD pmos W=0.205u L=0.04u
M26809 U2932/net104 WX2148 VDD VDD pmos W=0.205u L=0.04u
M26810 U2932/net30 WX2084 VDD VDD pmos W=0.205u L=0.04u
M26811 U2932/net108 U2932/net104 VDD VDD pmos W=0.205u L=0.04u
M26812 n2220 U2932/net28 VDD VDD pmos W=0.205u L=0.04u
M26813 U2932/net32 WX2020 VDD VDD pmos W=0.205u L=0.04u
M26814 U2932/net64 U2932/net24 VDD VDD pmos W=0.28u L=0.04u
M26815 U2932/net24 U2932/net30 U2932/net045 VDD pmos W=0.205u L=0.04u
M26816 U2932/net045 U2932/net32 VDD VDD pmos W=0.205u L=0.04u
M26817 U2933/net4 WX1956 U2933/net14 VSS nmos W=0.155u L=0.04u
M26818 U2933/net6 U2933/net10 U2933/net14 VSS nmos W=0.17u L=0.04u
M26819 U2933/net4 n1375 VSS VSS nmos W=0.155u L=0.04u
M26820 U2933/net6 U2933/net4 VSS VSS nmos W=0.17u L=0.04u
M26821 n2221 U2933/net14 VSS VSS nmos W=0.155u L=0.04u
M26822 U2933/net10 WX1956 VSS VSS nmos W=0.155u L=0.04u
M26823 U2933/net4 U2933/net10 U2933/net14 VDD pmos W=0.255u L=0.04u
M26824 U2933/net6 WX1956 U2933/net14 VDD pmos W=0.28u L=0.04u
M26825 U2933/net4 n1375 VDD VDD pmos W=0.205u L=0.04u
M26826 U2933/net6 U2933/net4 VDD VDD pmos W=0.24u L=0.04u
M26827 n2221 U2933/net14 VDD VDD pmos W=0.205u L=0.04u
M26828 U2933/net10 WX1956 VDD VDD pmos W=0.205u L=0.04u
M26829 WX1443 n1243 U2934/net26 VSS nmos W=0.155u L=0.04u
M26830 WX1443 n2199 U2934/net26 VSS nmos W=0.155u L=0.04u
M26831 U2934/net29 n2222 VSS VSS nmos W=0.155u L=0.04u
M26832 U2934/net26 n2079 U2934/net29 VSS nmos W=0.155u L=0.04u
M26833 U2934/net26 n1290 U2934/net29 VSS nmos W=0.155u L=0.04u
M26834 WX1443 n2199 U2934/net43 VDD pmos W=0.205u L=0.04u
M26835 WX1443 n1290 U2934/net49 VDD pmos W=0.205u L=0.04u
M26836 U2934/net49 n2079 VDD VDD pmos W=0.205u L=0.04u
M26837 U2934/net43 n1243 VDD VDD pmos W=0.205u L=0.04u
M26838 WX1443 n2222 VDD VDD pmos W=0.205u L=0.04u
M26839 U2935/net29 n1346 VSS VSS nmos W=0.155u L=0.04u
M26840 n2222 WX1794 U2935/net29 VSS nmos W=0.155u L=0.04u
M26841 n2222 n1313 U2935/net23 VSS nmos W=0.155u L=0.04u
M26842 U2935/net23 CRC_OUT_8_23 VSS VSS nmos W=0.155u L=0.04u
M26843 U2935/net20 CRC_OUT_8_23 n2222 VDD pmos W=0.205u L=0.04u
M26844 U2935/net20 n1313 n2222 VDD pmos W=0.205u L=0.04u
M26845 VDD WX1794 U2935/net20 VDD pmos W=0.205u L=0.04u
M26846 VDD n1346 U2935/net20 VDD pmos W=0.205u L=0.04u
M26847 n2079 n2223 VSS VSS nmos W=0.135u L=0.04u
M26848 n2079 n2223 VDD VDD pmos W=0.205u L=0.04u
M26849 U2937/net28 U2937/net20 U2937/net64 VSS nmos W=0.155u L=0.04u
M26850 U2937/net24 U2937/net30 U2937/net32 VSS nmos W=0.155u L=0.04u
M26851 U2937/net28 U2937/net40 U2937/net24 VSS nmos W=0.155u L=0.04u
M26852 U2937/net40 n2224 U2937/net108 VSS nmos W=0.155u L=0.04u
M26853 U2937/net40 U2937/net106 U2937/net104 VSS nmos W=0.155u L=0.04u
M26854 U2937/net24 WX3375 U2937/net050 VSS nmos W=0.155u L=0.04u
M26855 U2937/net050 U2937/net32 VSS VSS nmos W=0.155u L=0.04u
M26856 U2937/net20 U2937/net40 VSS VSS nmos W=0.155u L=0.04u
M26857 U2937/net106 n2224 VSS VSS nmos W=0.155u L=0.04u
M26858 U2937/net104 WX3439 VSS VSS nmos W=0.155u L=0.04u
M26859 U2937/net30 WX3375 VSS VSS nmos W=0.155u L=0.04u
M26860 U2937/net108 U2937/net104 VSS VSS nmos W=0.155u L=0.04u
M26861 n2223 U2937/net28 VSS VSS nmos W=0.155u L=0.04u
M26862 U2937/net32 WX3311 VSS VSS nmos W=0.155u L=0.04u
M26863 U2937/net64 U2937/net24 VSS VSS nmos W=0.2u L=0.04u
M26864 U2937/net28 U2937/net40 U2937/net64 VDD pmos W=0.205u L=0.04u
M26865 U2937/net24 WX3375 U2937/net32 VDD pmos W=0.205u L=0.04u
M26866 U2937/net28 U2937/net20 U2937/net24 VDD pmos W=0.205u L=0.04u
M26867 U2937/net40 U2937/net106 U2937/net108 VDD pmos W=0.205u L=0.04u
M26868 U2937/net40 n2224 U2937/net104 VDD pmos W=0.205u L=0.04u
M26869 U2937/net20 U2937/net40 VDD VDD pmos W=0.205u L=0.04u
M26870 U2937/net106 n2224 VDD VDD pmos W=0.205u L=0.04u
M26871 U2937/net104 WX3439 VDD VDD pmos W=0.205u L=0.04u
M26872 U2937/net30 WX3375 VDD VDD pmos W=0.205u L=0.04u
M26873 U2937/net108 U2937/net104 VDD VDD pmos W=0.205u L=0.04u
M26874 n2223 U2937/net28 VDD VDD pmos W=0.205u L=0.04u
M26875 U2937/net32 WX3311 VDD VDD pmos W=0.205u L=0.04u
M26876 U2937/net64 U2937/net24 VDD VDD pmos W=0.28u L=0.04u
M26877 U2937/net24 U2937/net30 U2937/net045 VDD pmos W=0.205u L=0.04u
M26878 U2937/net045 U2937/net32 VDD VDD pmos W=0.205u L=0.04u
M26879 U2938/net4 WX3247 U2938/net14 VSS nmos W=0.155u L=0.04u
M26880 U2938/net6 U2938/net10 U2938/net14 VSS nmos W=0.17u L=0.04u
M26881 U2938/net4 n1375 VSS VSS nmos W=0.155u L=0.04u
M26882 U2938/net6 U2938/net4 VSS VSS nmos W=0.17u L=0.04u
M26883 n2224 U2938/net14 VSS VSS nmos W=0.155u L=0.04u
M26884 U2938/net10 WX3247 VSS VSS nmos W=0.155u L=0.04u
M26885 U2938/net4 U2938/net10 U2938/net14 VDD pmos W=0.255u L=0.04u
M26886 U2938/net6 WX3247 U2938/net14 VDD pmos W=0.28u L=0.04u
M26887 U2938/net4 n1375 VDD VDD pmos W=0.205u L=0.04u
M26888 U2938/net6 U2938/net4 VDD VDD pmos W=0.24u L=0.04u
M26889 n2224 U2938/net14 VDD VDD pmos W=0.205u L=0.04u
M26890 U2938/net10 WX3247 VDD VDD pmos W=0.205u L=0.04u
M26891 n2199 n2225 VSS VSS nmos W=0.135u L=0.04u
M26892 n2199 n2225 VDD VDD pmos W=0.205u L=0.04u
M26893 U2940/net28 U2940/net20 U2940/net64 VSS nmos W=0.155u L=0.04u
M26894 U2940/net24 U2940/net30 U2940/net32 VSS nmos W=0.155u L=0.04u
M26895 U2940/net28 U2940/net40 U2940/net24 VSS nmos W=0.155u L=0.04u
M26896 U2940/net40 n2226 U2940/net108 VSS nmos W=0.155u L=0.04u
M26897 U2940/net40 U2940/net106 U2940/net104 VSS nmos W=0.155u L=0.04u
M26898 U2940/net24 WX2082 U2940/net050 VSS nmos W=0.155u L=0.04u
M26899 U2940/net050 U2940/net32 VSS VSS nmos W=0.155u L=0.04u
M26900 U2940/net20 U2940/net40 VSS VSS nmos W=0.155u L=0.04u
M26901 U2940/net106 n2226 VSS VSS nmos W=0.155u L=0.04u
M26902 U2940/net104 WX2146 VSS VSS nmos W=0.155u L=0.04u
M26903 U2940/net30 WX2082 VSS VSS nmos W=0.155u L=0.04u
M26904 U2940/net108 U2940/net104 VSS VSS nmos W=0.155u L=0.04u
M26905 n2225 U2940/net28 VSS VSS nmos W=0.155u L=0.04u
M26906 U2940/net32 WX2018 VSS VSS nmos W=0.155u L=0.04u
M26907 U2940/net64 U2940/net24 VSS VSS nmos W=0.2u L=0.04u
M26908 U2940/net28 U2940/net40 U2940/net64 VDD pmos W=0.205u L=0.04u
M26909 U2940/net24 WX2082 U2940/net32 VDD pmos W=0.205u L=0.04u
M26910 U2940/net28 U2940/net20 U2940/net24 VDD pmos W=0.205u L=0.04u
M26911 U2940/net40 U2940/net106 U2940/net108 VDD pmos W=0.205u L=0.04u
M26912 U2940/net40 n2226 U2940/net104 VDD pmos W=0.205u L=0.04u
M26913 U2940/net20 U2940/net40 VDD VDD pmos W=0.205u L=0.04u
M26914 U2940/net106 n2226 VDD VDD pmos W=0.205u L=0.04u
M26915 U2940/net104 WX2146 VDD VDD pmos W=0.205u L=0.04u
M26916 U2940/net30 WX2082 VDD VDD pmos W=0.205u L=0.04u
M26917 U2940/net108 U2940/net104 VDD VDD pmos W=0.205u L=0.04u
M26918 n2225 U2940/net28 VDD VDD pmos W=0.205u L=0.04u
M26919 U2940/net32 WX2018 VDD VDD pmos W=0.205u L=0.04u
M26920 U2940/net64 U2940/net24 VDD VDD pmos W=0.28u L=0.04u
M26921 U2940/net24 U2940/net30 U2940/net045 VDD pmos W=0.205u L=0.04u
M26922 U2940/net045 U2940/net32 VDD VDD pmos W=0.205u L=0.04u
M26923 U2941/net4 WX1954 U2941/net14 VSS nmos W=0.155u L=0.04u
M26924 U2941/net6 U2941/net10 U2941/net14 VSS nmos W=0.17u L=0.04u
M26925 U2941/net4 n1376 VSS VSS nmos W=0.155u L=0.04u
M26926 U2941/net6 U2941/net4 VSS VSS nmos W=0.17u L=0.04u
M26927 n2226 U2941/net14 VSS VSS nmos W=0.155u L=0.04u
M26928 U2941/net10 WX1954 VSS VSS nmos W=0.155u L=0.04u
M26929 U2941/net4 U2941/net10 U2941/net14 VDD pmos W=0.255u L=0.04u
M26930 U2941/net6 WX1954 U2941/net14 VDD pmos W=0.28u L=0.04u
M26931 U2941/net4 n1376 VDD VDD pmos W=0.205u L=0.04u
M26932 U2941/net6 U2941/net4 VDD VDD pmos W=0.24u L=0.04u
M26933 n2226 U2941/net14 VDD VDD pmos W=0.205u L=0.04u
M26934 U2941/net10 WX1954 VDD VDD pmos W=0.205u L=0.04u
M26935 WX1429 n1281 U2942/net26 VSS nmos W=0.155u L=0.04u
M26936 WX1429 n2083 U2942/net26 VSS nmos W=0.155u L=0.04u
M26937 U2942/net29 n2228 VSS VSS nmos W=0.155u L=0.04u
M26938 U2942/net26 n2227 U2942/net29 VSS nmos W=0.155u L=0.04u
M26939 U2942/net26 n1253 U2942/net29 VSS nmos W=0.155u L=0.04u
M26940 WX1429 n2083 U2942/net43 VDD pmos W=0.205u L=0.04u
M26941 WX1429 n1253 U2942/net49 VDD pmos W=0.205u L=0.04u
M26942 U2942/net49 n2227 VDD VDD pmos W=0.205u L=0.04u
M26943 U2942/net43 n1281 VDD VDD pmos W=0.205u L=0.04u
M26944 WX1429 n2228 VDD VDD pmos W=0.205u L=0.04u
M26945 U2943/net29 n1346 VSS VSS nmos W=0.155u L=0.04u
M26946 n2228 WX1792 U2943/net29 VSS nmos W=0.155u L=0.04u
M26947 n2228 n1313 U2943/net23 VSS nmos W=0.155u L=0.04u
M26948 U2943/net23 CRC_OUT_8_24 VSS VSS nmos W=0.155u L=0.04u
M26949 U2943/net20 CRC_OUT_8_24 n2228 VDD pmos W=0.205u L=0.04u
M26950 U2943/net20 n1313 n2228 VDD pmos W=0.205u L=0.04u
M26951 VDD WX1792 U2943/net20 VDD pmos W=0.205u L=0.04u
M26952 VDD n1346 U2943/net20 VDD pmos W=0.205u L=0.04u
M26953 n2083 n2229 VSS VSS nmos W=0.135u L=0.04u
M26954 n2083 n2229 VDD VDD pmos W=0.205u L=0.04u
M26955 U2945/net28 U2945/net20 U2945/net64 VSS nmos W=0.155u L=0.04u
M26956 U2945/net24 U2945/net30 U2945/net32 VSS nmos W=0.155u L=0.04u
M26957 U2945/net28 U2945/net40 U2945/net24 VSS nmos W=0.155u L=0.04u
M26958 U2945/net40 n2230 U2945/net108 VSS nmos W=0.155u L=0.04u
M26959 U2945/net40 U2945/net106 U2945/net104 VSS nmos W=0.155u L=0.04u
M26960 U2945/net24 WX3373 U2945/net050 VSS nmos W=0.155u L=0.04u
M26961 U2945/net050 U2945/net32 VSS VSS nmos W=0.155u L=0.04u
M26962 U2945/net20 U2945/net40 VSS VSS nmos W=0.155u L=0.04u
M26963 U2945/net106 n2230 VSS VSS nmos W=0.155u L=0.04u
M26964 U2945/net104 WX3437 VSS VSS nmos W=0.155u L=0.04u
M26965 U2945/net30 WX3373 VSS VSS nmos W=0.155u L=0.04u
M26966 U2945/net108 U2945/net104 VSS VSS nmos W=0.155u L=0.04u
M26967 n2229 U2945/net28 VSS VSS nmos W=0.155u L=0.04u
M26968 U2945/net32 WX3309 VSS VSS nmos W=0.155u L=0.04u
M26969 U2945/net64 U2945/net24 VSS VSS nmos W=0.2u L=0.04u
M26970 U2945/net28 U2945/net40 U2945/net64 VDD pmos W=0.205u L=0.04u
M26971 U2945/net24 WX3373 U2945/net32 VDD pmos W=0.205u L=0.04u
M26972 U2945/net28 U2945/net20 U2945/net24 VDD pmos W=0.205u L=0.04u
M26973 U2945/net40 U2945/net106 U2945/net108 VDD pmos W=0.205u L=0.04u
M26974 U2945/net40 n2230 U2945/net104 VDD pmos W=0.205u L=0.04u
M26975 U2945/net20 U2945/net40 VDD VDD pmos W=0.205u L=0.04u
M26976 U2945/net106 n2230 VDD VDD pmos W=0.205u L=0.04u
M26977 U2945/net104 WX3437 VDD VDD pmos W=0.205u L=0.04u
M26978 U2945/net30 WX3373 VDD VDD pmos W=0.205u L=0.04u
M26979 U2945/net108 U2945/net104 VDD VDD pmos W=0.205u L=0.04u
M26980 n2229 U2945/net28 VDD VDD pmos W=0.205u L=0.04u
M26981 U2945/net32 WX3309 VDD VDD pmos W=0.205u L=0.04u
M26982 U2945/net64 U2945/net24 VDD VDD pmos W=0.28u L=0.04u
M26983 U2945/net24 U2945/net30 U2945/net045 VDD pmos W=0.205u L=0.04u
M26984 U2945/net045 U2945/net32 VDD VDD pmos W=0.205u L=0.04u
M26985 U2946/net4 WX3245 U2946/net14 VSS nmos W=0.155u L=0.04u
M26986 U2946/net6 U2946/net10 U2946/net14 VSS nmos W=0.17u L=0.04u
M26987 U2946/net4 n1376 VSS VSS nmos W=0.155u L=0.04u
M26988 U2946/net6 U2946/net4 VSS VSS nmos W=0.17u L=0.04u
M26989 n2230 U2946/net14 VSS VSS nmos W=0.155u L=0.04u
M26990 U2946/net10 WX3245 VSS VSS nmos W=0.155u L=0.04u
M26991 U2946/net4 U2946/net10 U2946/net14 VDD pmos W=0.255u L=0.04u
M26992 U2946/net6 WX3245 U2946/net14 VDD pmos W=0.28u L=0.04u
M26993 U2946/net4 n1376 VDD VDD pmos W=0.205u L=0.04u
M26994 U2946/net6 U2946/net4 VDD VDD pmos W=0.24u L=0.04u
M26995 n2230 U2946/net14 VDD VDD pmos W=0.205u L=0.04u
M26996 U2946/net10 WX3245 VDD VDD pmos W=0.205u L=0.04u
M26997 WX1415 n1281 U2947/net26 VSS nmos W=0.155u L=0.04u
M26998 WX1415 n2087 U2947/net26 VSS nmos W=0.155u L=0.04u
M26999 U2947/net29 n2232 VSS VSS nmos W=0.155u L=0.04u
M27000 U2947/net26 n2231 U2947/net29 VSS nmos W=0.155u L=0.04u
M27001 U2947/net26 n1253 U2947/net29 VSS nmos W=0.155u L=0.04u
M27002 WX1415 n2087 U2947/net43 VDD pmos W=0.205u L=0.04u
M27003 WX1415 n1253 U2947/net49 VDD pmos W=0.205u L=0.04u
M27004 U2947/net49 n2231 VDD VDD pmos W=0.205u L=0.04u
M27005 U2947/net43 n1281 VDD VDD pmos W=0.205u L=0.04u
M27006 WX1415 n2232 VDD VDD pmos W=0.205u L=0.04u
M27007 U2948/net29 n1346 VSS VSS nmos W=0.155u L=0.04u
M27008 n2232 WX1790 U2948/net29 VSS nmos W=0.155u L=0.04u
M27009 n2232 n1313 U2948/net23 VSS nmos W=0.155u L=0.04u
M27010 U2948/net23 CRC_OUT_8_25 VSS VSS nmos W=0.155u L=0.04u
M27011 U2948/net20 CRC_OUT_8_25 n2232 VDD pmos W=0.205u L=0.04u
M27012 U2948/net20 n1313 n2232 VDD pmos W=0.205u L=0.04u
M27013 VDD WX1790 U2948/net20 VDD pmos W=0.205u L=0.04u
M27014 VDD n1346 U2948/net20 VDD pmos W=0.205u L=0.04u
M27015 n2087 n2233 VSS VSS nmos W=0.135u L=0.04u
M27016 n2087 n2233 VDD VDD pmos W=0.205u L=0.04u
M27017 U2950/net28 U2950/net20 U2950/net64 VSS nmos W=0.155u L=0.04u
M27018 U2950/net24 U2950/net30 U2950/net32 VSS nmos W=0.155u L=0.04u
M27019 U2950/net28 U2950/net40 U2950/net24 VSS nmos W=0.155u L=0.04u
M27020 U2950/net40 n2234 U2950/net108 VSS nmos W=0.155u L=0.04u
M27021 U2950/net40 U2950/net106 U2950/net104 VSS nmos W=0.155u L=0.04u
M27022 U2950/net24 WX3371 U2950/net050 VSS nmos W=0.155u L=0.04u
M27023 U2950/net050 U2950/net32 VSS VSS nmos W=0.155u L=0.04u
M27024 U2950/net20 U2950/net40 VSS VSS nmos W=0.155u L=0.04u
M27025 U2950/net106 n2234 VSS VSS nmos W=0.155u L=0.04u
M27026 U2950/net104 WX3435 VSS VSS nmos W=0.155u L=0.04u
M27027 U2950/net30 WX3371 VSS VSS nmos W=0.155u L=0.04u
M27028 U2950/net108 U2950/net104 VSS VSS nmos W=0.155u L=0.04u
M27029 n2233 U2950/net28 VSS VSS nmos W=0.155u L=0.04u
M27030 U2950/net32 WX3307 VSS VSS nmos W=0.155u L=0.04u
M27031 U2950/net64 U2950/net24 VSS VSS nmos W=0.2u L=0.04u
M27032 U2950/net28 U2950/net40 U2950/net64 VDD pmos W=0.205u L=0.04u
M27033 U2950/net24 WX3371 U2950/net32 VDD pmos W=0.205u L=0.04u
M27034 U2950/net28 U2950/net20 U2950/net24 VDD pmos W=0.205u L=0.04u
M27035 U2950/net40 U2950/net106 U2950/net108 VDD pmos W=0.205u L=0.04u
M27036 U2950/net40 n2234 U2950/net104 VDD pmos W=0.205u L=0.04u
M27037 U2950/net20 U2950/net40 VDD VDD pmos W=0.205u L=0.04u
M27038 U2950/net106 n2234 VDD VDD pmos W=0.205u L=0.04u
M27039 U2950/net104 WX3435 VDD VDD pmos W=0.205u L=0.04u
M27040 U2950/net30 WX3371 VDD VDD pmos W=0.205u L=0.04u
M27041 U2950/net108 U2950/net104 VDD VDD pmos W=0.205u L=0.04u
M27042 n2233 U2950/net28 VDD VDD pmos W=0.205u L=0.04u
M27043 U2950/net32 WX3307 VDD VDD pmos W=0.205u L=0.04u
M27044 U2950/net64 U2950/net24 VDD VDD pmos W=0.28u L=0.04u
M27045 U2950/net24 U2950/net30 U2950/net045 VDD pmos W=0.205u L=0.04u
M27046 U2950/net045 U2950/net32 VDD VDD pmos W=0.205u L=0.04u
M27047 U2951/net4 WX3243 U2951/net14 VSS nmos W=0.155u L=0.04u
M27048 U2951/net6 U2951/net10 U2951/net14 VSS nmos W=0.17u L=0.04u
M27049 U2951/net4 n1376 VSS VSS nmos W=0.155u L=0.04u
M27050 U2951/net6 U2951/net4 VSS VSS nmos W=0.17u L=0.04u
M27051 n2234 U2951/net14 VSS VSS nmos W=0.155u L=0.04u
M27052 U2951/net10 WX3243 VSS VSS nmos W=0.155u L=0.04u
M27053 U2951/net4 U2951/net10 U2951/net14 VDD pmos W=0.255u L=0.04u
M27054 U2951/net6 WX3243 U2951/net14 VDD pmos W=0.28u L=0.04u
M27055 U2951/net4 n1376 VDD VDD pmos W=0.205u L=0.04u
M27056 U2951/net6 U2951/net4 VDD VDD pmos W=0.24u L=0.04u
M27057 n2234 U2951/net14 VDD VDD pmos W=0.205u L=0.04u
M27058 U2951/net10 WX3243 VDD VDD pmos W=0.205u L=0.04u
M27059 WX1401 n1281 U2952/net26 VSS nmos W=0.155u L=0.04u
M27060 WX1401 n2091 U2952/net26 VSS nmos W=0.155u L=0.04u
M27061 U2952/net29 n2236 VSS VSS nmos W=0.155u L=0.04u
M27062 U2952/net26 n2235 U2952/net29 VSS nmos W=0.155u L=0.04u
M27063 U2952/net26 n1253 U2952/net29 VSS nmos W=0.155u L=0.04u
M27064 WX1401 n2091 U2952/net43 VDD pmos W=0.205u L=0.04u
M27065 WX1401 n1253 U2952/net49 VDD pmos W=0.205u L=0.04u
M27066 U2952/net49 n2235 VDD VDD pmos W=0.205u L=0.04u
M27067 U2952/net43 n1281 VDD VDD pmos W=0.205u L=0.04u
M27068 WX1401 n2236 VDD VDD pmos W=0.205u L=0.04u
M27069 U2953/net29 n1346 VSS VSS nmos W=0.155u L=0.04u
M27070 n2236 WX1788 U2953/net29 VSS nmos W=0.155u L=0.04u
M27071 n2236 n1313 U2953/net23 VSS nmos W=0.155u L=0.04u
M27072 U2953/net23 CRC_OUT_8_26 VSS VSS nmos W=0.155u L=0.04u
M27073 U2953/net20 CRC_OUT_8_26 n2236 VDD pmos W=0.205u L=0.04u
M27074 U2953/net20 n1313 n2236 VDD pmos W=0.205u L=0.04u
M27075 VDD WX1788 U2953/net20 VDD pmos W=0.205u L=0.04u
M27076 VDD n1346 U2953/net20 VDD pmos W=0.205u L=0.04u
M27077 n2091 n2237 VSS VSS nmos W=0.135u L=0.04u
M27078 n2091 n2237 VDD VDD pmos W=0.205u L=0.04u
M27079 U2955/net28 U2955/net20 U2955/net64 VSS nmos W=0.155u L=0.04u
M27080 U2955/net24 U2955/net30 U2955/net32 VSS nmos W=0.155u L=0.04u
M27081 U2955/net28 U2955/net40 U2955/net24 VSS nmos W=0.155u L=0.04u
M27082 U2955/net40 n2238 U2955/net108 VSS nmos W=0.155u L=0.04u
M27083 U2955/net40 U2955/net106 U2955/net104 VSS nmos W=0.155u L=0.04u
M27084 U2955/net24 WX3369 U2955/net050 VSS nmos W=0.155u L=0.04u
M27085 U2955/net050 U2955/net32 VSS VSS nmos W=0.155u L=0.04u
M27086 U2955/net20 U2955/net40 VSS VSS nmos W=0.155u L=0.04u
M27087 U2955/net106 n2238 VSS VSS nmos W=0.155u L=0.04u
M27088 U2955/net104 WX3433 VSS VSS nmos W=0.155u L=0.04u
M27089 U2955/net30 WX3369 VSS VSS nmos W=0.155u L=0.04u
M27090 U2955/net108 U2955/net104 VSS VSS nmos W=0.155u L=0.04u
M27091 n2237 U2955/net28 VSS VSS nmos W=0.155u L=0.04u
M27092 U2955/net32 WX3305 VSS VSS nmos W=0.155u L=0.04u
M27093 U2955/net64 U2955/net24 VSS VSS nmos W=0.2u L=0.04u
M27094 U2955/net28 U2955/net40 U2955/net64 VDD pmos W=0.205u L=0.04u
M27095 U2955/net24 WX3369 U2955/net32 VDD pmos W=0.205u L=0.04u
M27096 U2955/net28 U2955/net20 U2955/net24 VDD pmos W=0.205u L=0.04u
M27097 U2955/net40 U2955/net106 U2955/net108 VDD pmos W=0.205u L=0.04u
M27098 U2955/net40 n2238 U2955/net104 VDD pmos W=0.205u L=0.04u
M27099 U2955/net20 U2955/net40 VDD VDD pmos W=0.205u L=0.04u
M27100 U2955/net106 n2238 VDD VDD pmos W=0.205u L=0.04u
M27101 U2955/net104 WX3433 VDD VDD pmos W=0.205u L=0.04u
M27102 U2955/net30 WX3369 VDD VDD pmos W=0.205u L=0.04u
M27103 U2955/net108 U2955/net104 VDD VDD pmos W=0.205u L=0.04u
M27104 n2237 U2955/net28 VDD VDD pmos W=0.205u L=0.04u
M27105 U2955/net32 WX3305 VDD VDD pmos W=0.205u L=0.04u
M27106 U2955/net64 U2955/net24 VDD VDD pmos W=0.28u L=0.04u
M27107 U2955/net24 U2955/net30 U2955/net045 VDD pmos W=0.205u L=0.04u
M27108 U2955/net045 U2955/net32 VDD VDD pmos W=0.205u L=0.04u
M27109 U2956/net4 WX3241 U2956/net14 VSS nmos W=0.155u L=0.04u
M27110 U2956/net6 U2956/net10 U2956/net14 VSS nmos W=0.17u L=0.04u
M27111 U2956/net4 n1376 VSS VSS nmos W=0.155u L=0.04u
M27112 U2956/net6 U2956/net4 VSS VSS nmos W=0.17u L=0.04u
M27113 n2238 U2956/net14 VSS VSS nmos W=0.155u L=0.04u
M27114 U2956/net10 WX3241 VSS VSS nmos W=0.155u L=0.04u
M27115 U2956/net4 U2956/net10 U2956/net14 VDD pmos W=0.255u L=0.04u
M27116 U2956/net6 WX3241 U2956/net14 VDD pmos W=0.28u L=0.04u
M27117 U2956/net4 n1376 VDD VDD pmos W=0.205u L=0.04u
M27118 U2956/net6 U2956/net4 VDD VDD pmos W=0.24u L=0.04u
M27119 n2238 U2956/net14 VDD VDD pmos W=0.205u L=0.04u
M27120 U2956/net10 WX3241 VDD VDD pmos W=0.205u L=0.04u
M27121 WX1387 n1244 U2957/net26 VSS nmos W=0.155u L=0.04u
M27122 WX1387 n1432 U2957/net26 VSS nmos W=0.155u L=0.04u
M27123 U2957/net29 n2239 VSS VSS nmos W=0.155u L=0.04u
M27124 U2957/net26 n2095 U2957/net29 VSS nmos W=0.155u L=0.04u
M27125 U2957/net26 n1289 U2957/net29 VSS nmos W=0.155u L=0.04u
M27126 WX1387 n1432 U2957/net43 VDD pmos W=0.205u L=0.04u
M27127 WX1387 n1289 U2957/net49 VDD pmos W=0.205u L=0.04u
M27128 U2957/net49 n2095 VDD VDD pmos W=0.205u L=0.04u
M27129 U2957/net43 n1244 VDD VDD pmos W=0.205u L=0.04u
M27130 WX1387 n2239 VDD VDD pmos W=0.205u L=0.04u
M27131 U2958/net29 n1346 VSS VSS nmos W=0.155u L=0.04u
M27132 n2239 WX1786 U2958/net29 VSS nmos W=0.155u L=0.04u
M27133 n2239 n1313 U2958/net23 VSS nmos W=0.155u L=0.04u
M27134 U2958/net23 CRC_OUT_8_27 VSS VSS nmos W=0.155u L=0.04u
M27135 U2958/net20 CRC_OUT_8_27 n2239 VDD pmos W=0.205u L=0.04u
M27136 U2958/net20 n1313 n2239 VDD pmos W=0.205u L=0.04u
M27137 VDD WX1786 U2958/net20 VDD pmos W=0.205u L=0.04u
M27138 VDD n1346 U2958/net20 VDD pmos W=0.205u L=0.04u
M27139 n2095 n2240 VSS VSS nmos W=0.135u L=0.04u
M27140 n2095 n2240 VDD VDD pmos W=0.205u L=0.04u
M27141 U2960/net28 U2960/net20 U2960/net64 VSS nmos W=0.155u L=0.04u
M27142 U2960/net24 U2960/net30 U2960/net32 VSS nmos W=0.155u L=0.04u
M27143 U2960/net28 U2960/net40 U2960/net24 VSS nmos W=0.155u L=0.04u
M27144 U2960/net40 n2241 U2960/net108 VSS nmos W=0.155u L=0.04u
M27145 U2960/net40 U2960/net106 U2960/net104 VSS nmos W=0.155u L=0.04u
M27146 U2960/net24 WX3367 U2960/net050 VSS nmos W=0.155u L=0.04u
M27147 U2960/net050 U2960/net32 VSS VSS nmos W=0.155u L=0.04u
M27148 U2960/net20 U2960/net40 VSS VSS nmos W=0.155u L=0.04u
M27149 U2960/net106 n2241 VSS VSS nmos W=0.155u L=0.04u
M27150 U2960/net104 WX3431 VSS VSS nmos W=0.155u L=0.04u
M27151 U2960/net30 WX3367 VSS VSS nmos W=0.155u L=0.04u
M27152 U2960/net108 U2960/net104 VSS VSS nmos W=0.155u L=0.04u
M27153 n2240 U2960/net28 VSS VSS nmos W=0.155u L=0.04u
M27154 U2960/net32 WX3303 VSS VSS nmos W=0.155u L=0.04u
M27155 U2960/net64 U2960/net24 VSS VSS nmos W=0.2u L=0.04u
M27156 U2960/net28 U2960/net40 U2960/net64 VDD pmos W=0.205u L=0.04u
M27157 U2960/net24 WX3367 U2960/net32 VDD pmos W=0.205u L=0.04u
M27158 U2960/net28 U2960/net20 U2960/net24 VDD pmos W=0.205u L=0.04u
M27159 U2960/net40 U2960/net106 U2960/net108 VDD pmos W=0.205u L=0.04u
M27160 U2960/net40 n2241 U2960/net104 VDD pmos W=0.205u L=0.04u
M27161 U2960/net20 U2960/net40 VDD VDD pmos W=0.205u L=0.04u
M27162 U2960/net106 n2241 VDD VDD pmos W=0.205u L=0.04u
M27163 U2960/net104 WX3431 VDD VDD pmos W=0.205u L=0.04u
M27164 U2960/net30 WX3367 VDD VDD pmos W=0.205u L=0.04u
M27165 U2960/net108 U2960/net104 VDD VDD pmos W=0.205u L=0.04u
M27166 n2240 U2960/net28 VDD VDD pmos W=0.205u L=0.04u
M27167 U2960/net32 WX3303 VDD VDD pmos W=0.205u L=0.04u
M27168 U2960/net64 U2960/net24 VDD VDD pmos W=0.28u L=0.04u
M27169 U2960/net24 U2960/net30 U2960/net045 VDD pmos W=0.205u L=0.04u
M27170 U2960/net045 U2960/net32 VDD VDD pmos W=0.205u L=0.04u
M27171 U2961/net4 WX3239 U2961/net14 VSS nmos W=0.155u L=0.04u
M27172 U2961/net6 U2961/net10 U2961/net14 VSS nmos W=0.17u L=0.04u
M27173 U2961/net4 n1376 VSS VSS nmos W=0.155u L=0.04u
M27174 U2961/net6 U2961/net4 VSS VSS nmos W=0.17u L=0.04u
M27175 n2241 U2961/net14 VSS VSS nmos W=0.155u L=0.04u
M27176 U2961/net10 WX3239 VSS VSS nmos W=0.155u L=0.04u
M27177 U2961/net4 U2961/net10 U2961/net14 VDD pmos W=0.255u L=0.04u
M27178 U2961/net6 WX3239 U2961/net14 VDD pmos W=0.28u L=0.04u
M27179 U2961/net4 n1376 VDD VDD pmos W=0.205u L=0.04u
M27180 U2961/net6 U2961/net4 VDD VDD pmos W=0.24u L=0.04u
M27181 n2241 U2961/net14 VDD VDD pmos W=0.205u L=0.04u
M27182 U2961/net10 WX3239 VDD VDD pmos W=0.205u L=0.04u
M27183 n1432 n2242 VSS VSS nmos W=0.135u L=0.04u
M27184 n1432 n2242 VDD VDD pmos W=0.205u L=0.04u
M27185 U2963/net28 U2963/net20 U2963/net64 VSS nmos W=0.155u L=0.04u
M27186 U2963/net24 U2963/net30 U2963/net32 VSS nmos W=0.155u L=0.04u
M27187 U2963/net28 U2963/net40 U2963/net24 VSS nmos W=0.155u L=0.04u
M27188 U2963/net40 n2243 U2963/net108 VSS nmos W=0.155u L=0.04u
M27189 U2963/net40 U2963/net106 U2963/net104 VSS nmos W=0.155u L=0.04u
M27190 U2963/net24 WX2074 U2963/net050 VSS nmos W=0.155u L=0.04u
M27191 U2963/net050 U2963/net32 VSS VSS nmos W=0.155u L=0.04u
M27192 U2963/net20 U2963/net40 VSS VSS nmos W=0.155u L=0.04u
M27193 U2963/net106 n2243 VSS VSS nmos W=0.155u L=0.04u
M27194 U2963/net104 WX2138 VSS VSS nmos W=0.155u L=0.04u
M27195 U2963/net30 WX2074 VSS VSS nmos W=0.155u L=0.04u
M27196 U2963/net108 U2963/net104 VSS VSS nmos W=0.155u L=0.04u
M27197 n2242 U2963/net28 VSS VSS nmos W=0.155u L=0.04u
M27198 U2963/net32 WX2010 VSS VSS nmos W=0.155u L=0.04u
M27199 U2963/net64 U2963/net24 VSS VSS nmos W=0.2u L=0.04u
M27200 U2963/net28 U2963/net40 U2963/net64 VDD pmos W=0.205u L=0.04u
M27201 U2963/net24 WX2074 U2963/net32 VDD pmos W=0.205u L=0.04u
M27202 U2963/net28 U2963/net20 U2963/net24 VDD pmos W=0.205u L=0.04u
M27203 U2963/net40 U2963/net106 U2963/net108 VDD pmos W=0.205u L=0.04u
M27204 U2963/net40 n2243 U2963/net104 VDD pmos W=0.205u L=0.04u
M27205 U2963/net20 U2963/net40 VDD VDD pmos W=0.205u L=0.04u
M27206 U2963/net106 n2243 VDD VDD pmos W=0.205u L=0.04u
M27207 U2963/net104 WX2138 VDD VDD pmos W=0.205u L=0.04u
M27208 U2963/net30 WX2074 VDD VDD pmos W=0.205u L=0.04u
M27209 U2963/net108 U2963/net104 VDD VDD pmos W=0.205u L=0.04u
M27210 n2242 U2963/net28 VDD VDD pmos W=0.205u L=0.04u
M27211 U2963/net32 WX2010 VDD VDD pmos W=0.205u L=0.04u
M27212 U2963/net64 U2963/net24 VDD VDD pmos W=0.28u L=0.04u
M27213 U2963/net24 U2963/net30 U2963/net045 VDD pmos W=0.205u L=0.04u
M27214 U2963/net045 U2963/net32 VDD VDD pmos W=0.205u L=0.04u
M27215 U2964/net4 WX1946 U2964/net14 VSS nmos W=0.155u L=0.04u
M27216 U2964/net6 U2964/net10 U2964/net14 VSS nmos W=0.17u L=0.04u
M27217 U2964/net4 n1376 VSS VSS nmos W=0.155u L=0.04u
M27218 U2964/net6 U2964/net4 VSS VSS nmos W=0.17u L=0.04u
M27219 n2243 U2964/net14 VSS VSS nmos W=0.155u L=0.04u
M27220 U2964/net10 WX1946 VSS VSS nmos W=0.155u L=0.04u
M27221 U2964/net4 U2964/net10 U2964/net14 VDD pmos W=0.255u L=0.04u
M27222 U2964/net6 WX1946 U2964/net14 VDD pmos W=0.28u L=0.04u
M27223 U2964/net4 n1376 VDD VDD pmos W=0.205u L=0.04u
M27224 U2964/net6 U2964/net4 VDD VDD pmos W=0.24u L=0.04u
M27225 n2243 U2964/net14 VDD VDD pmos W=0.205u L=0.04u
M27226 U2964/net10 WX1946 VDD VDD pmos W=0.205u L=0.04u
M27227 WX1373 n1244 U2965/net26 VSS nmos W=0.155u L=0.04u
M27228 WX1373 n1558 U2965/net26 VSS nmos W=0.155u L=0.04u
M27229 U2965/net29 n2244 VSS VSS nmos W=0.155u L=0.04u
M27230 U2965/net26 n2099 U2965/net29 VSS nmos W=0.155u L=0.04u
M27231 U2965/net26 n1289 U2965/net29 VSS nmos W=0.155u L=0.04u
M27232 WX1373 n1558 U2965/net43 VDD pmos W=0.205u L=0.04u
M27233 WX1373 n1289 U2965/net49 VDD pmos W=0.205u L=0.04u
M27234 U2965/net49 n2099 VDD VDD pmos W=0.205u L=0.04u
M27235 U2965/net43 n1244 VDD VDD pmos W=0.205u L=0.04u
M27236 WX1373 n2244 VDD VDD pmos W=0.205u L=0.04u
M27237 U2966/net29 n1346 VSS VSS nmos W=0.155u L=0.04u
M27238 n2244 WX1784 U2966/net29 VSS nmos W=0.155u L=0.04u
M27239 n2244 n1313 U2966/net23 VSS nmos W=0.155u L=0.04u
M27240 U2966/net23 CRC_OUT_8_28 VSS VSS nmos W=0.155u L=0.04u
M27241 U2966/net20 CRC_OUT_8_28 n2244 VDD pmos W=0.205u L=0.04u
M27242 U2966/net20 n1313 n2244 VDD pmos W=0.205u L=0.04u
M27243 VDD WX1784 U2966/net20 VDD pmos W=0.205u L=0.04u
M27244 VDD n1346 U2966/net20 VDD pmos W=0.205u L=0.04u
M27245 n2099 n2245 VSS VSS nmos W=0.135u L=0.04u
M27246 n2099 n2245 VDD VDD pmos W=0.205u L=0.04u
M27247 U2968/net28 U2968/net20 U2968/net64 VSS nmos W=0.155u L=0.04u
M27248 U2968/net24 U2968/net30 U2968/net32 VSS nmos W=0.155u L=0.04u
M27249 U2968/net28 U2968/net40 U2968/net24 VSS nmos W=0.155u L=0.04u
M27250 U2968/net40 n2246 U2968/net108 VSS nmos W=0.155u L=0.04u
M27251 U2968/net40 U2968/net106 U2968/net104 VSS nmos W=0.155u L=0.04u
M27252 U2968/net24 WX3365 U2968/net050 VSS nmos W=0.155u L=0.04u
M27253 U2968/net050 U2968/net32 VSS VSS nmos W=0.155u L=0.04u
M27254 U2968/net20 U2968/net40 VSS VSS nmos W=0.155u L=0.04u
M27255 U2968/net106 n2246 VSS VSS nmos W=0.155u L=0.04u
M27256 U2968/net104 WX3429 VSS VSS nmos W=0.155u L=0.04u
M27257 U2968/net30 WX3365 VSS VSS nmos W=0.155u L=0.04u
M27258 U2968/net108 U2968/net104 VSS VSS nmos W=0.155u L=0.04u
M27259 n2245 U2968/net28 VSS VSS nmos W=0.155u L=0.04u
M27260 U2968/net32 WX3301 VSS VSS nmos W=0.155u L=0.04u
M27261 U2968/net64 U2968/net24 VSS VSS nmos W=0.2u L=0.04u
M27262 U2968/net28 U2968/net40 U2968/net64 VDD pmos W=0.205u L=0.04u
M27263 U2968/net24 WX3365 U2968/net32 VDD pmos W=0.205u L=0.04u
M27264 U2968/net28 U2968/net20 U2968/net24 VDD pmos W=0.205u L=0.04u
M27265 U2968/net40 U2968/net106 U2968/net108 VDD pmos W=0.205u L=0.04u
M27266 U2968/net40 n2246 U2968/net104 VDD pmos W=0.205u L=0.04u
M27267 U2968/net20 U2968/net40 VDD VDD pmos W=0.205u L=0.04u
M27268 U2968/net106 n2246 VDD VDD pmos W=0.205u L=0.04u
M27269 U2968/net104 WX3429 VDD VDD pmos W=0.205u L=0.04u
M27270 U2968/net30 WX3365 VDD VDD pmos W=0.205u L=0.04u
M27271 U2968/net108 U2968/net104 VDD VDD pmos W=0.205u L=0.04u
M27272 n2245 U2968/net28 VDD VDD pmos W=0.205u L=0.04u
M27273 U2968/net32 WX3301 VDD VDD pmos W=0.205u L=0.04u
M27274 U2968/net64 U2968/net24 VDD VDD pmos W=0.28u L=0.04u
M27275 U2968/net24 U2968/net30 U2968/net045 VDD pmos W=0.205u L=0.04u
M27276 U2968/net045 U2968/net32 VDD VDD pmos W=0.205u L=0.04u
M27277 U2969/net4 WX3237 U2969/net14 VSS nmos W=0.155u L=0.04u
M27278 U2969/net6 U2969/net10 U2969/net14 VSS nmos W=0.17u L=0.04u
M27279 U2969/net4 n1376 VSS VSS nmos W=0.155u L=0.04u
M27280 U2969/net6 U2969/net4 VSS VSS nmos W=0.17u L=0.04u
M27281 n2246 U2969/net14 VSS VSS nmos W=0.155u L=0.04u
M27282 U2969/net10 WX3237 VSS VSS nmos W=0.155u L=0.04u
M27283 U2969/net4 U2969/net10 U2969/net14 VDD pmos W=0.255u L=0.04u
M27284 U2969/net6 WX3237 U2969/net14 VDD pmos W=0.28u L=0.04u
M27285 U2969/net4 n1376 VDD VDD pmos W=0.205u L=0.04u
M27286 U2969/net6 U2969/net4 VDD VDD pmos W=0.24u L=0.04u
M27287 n2246 U2969/net14 VDD VDD pmos W=0.205u L=0.04u
M27288 U2969/net10 WX3237 VDD VDD pmos W=0.205u L=0.04u
M27289 n1558 n2247 VSS VSS nmos W=0.135u L=0.04u
M27290 n1558 n2247 VDD VDD pmos W=0.205u L=0.04u
M27291 U2971/net28 U2971/net20 U2971/net64 VSS nmos W=0.155u L=0.04u
M27292 U2971/net24 U2971/net30 U2971/net32 VSS nmos W=0.155u L=0.04u
M27293 U2971/net28 U2971/net40 U2971/net24 VSS nmos W=0.155u L=0.04u
M27294 U2971/net40 n2248 U2971/net108 VSS nmos W=0.155u L=0.04u
M27295 U2971/net40 U2971/net106 U2971/net104 VSS nmos W=0.155u L=0.04u
M27296 U2971/net24 WX2072 U2971/net050 VSS nmos W=0.155u L=0.04u
M27297 U2971/net050 U2971/net32 VSS VSS nmos W=0.155u L=0.04u
M27298 U2971/net20 U2971/net40 VSS VSS nmos W=0.155u L=0.04u
M27299 U2971/net106 n2248 VSS VSS nmos W=0.155u L=0.04u
M27300 U2971/net104 WX2136 VSS VSS nmos W=0.155u L=0.04u
M27301 U2971/net30 WX2072 VSS VSS nmos W=0.155u L=0.04u
M27302 U2971/net108 U2971/net104 VSS VSS nmos W=0.155u L=0.04u
M27303 n2247 U2971/net28 VSS VSS nmos W=0.155u L=0.04u
M27304 U2971/net32 WX2008 VSS VSS nmos W=0.155u L=0.04u
M27305 U2971/net64 U2971/net24 VSS VSS nmos W=0.2u L=0.04u
M27306 U2971/net28 U2971/net40 U2971/net64 VDD pmos W=0.205u L=0.04u
M27307 U2971/net24 WX2072 U2971/net32 VDD pmos W=0.205u L=0.04u
M27308 U2971/net28 U2971/net20 U2971/net24 VDD pmos W=0.205u L=0.04u
M27309 U2971/net40 U2971/net106 U2971/net108 VDD pmos W=0.205u L=0.04u
M27310 U2971/net40 n2248 U2971/net104 VDD pmos W=0.205u L=0.04u
M27311 U2971/net20 U2971/net40 VDD VDD pmos W=0.205u L=0.04u
M27312 U2971/net106 n2248 VDD VDD pmos W=0.205u L=0.04u
M27313 U2971/net104 WX2136 VDD VDD pmos W=0.205u L=0.04u
M27314 U2971/net30 WX2072 VDD VDD pmos W=0.205u L=0.04u
M27315 U2971/net108 U2971/net104 VDD VDD pmos W=0.205u L=0.04u
M27316 n2247 U2971/net28 VDD VDD pmos W=0.205u L=0.04u
M27317 U2971/net32 WX2008 VDD VDD pmos W=0.205u L=0.04u
M27318 U2971/net64 U2971/net24 VDD VDD pmos W=0.28u L=0.04u
M27319 U2971/net24 U2971/net30 U2971/net045 VDD pmos W=0.205u L=0.04u
M27320 U2971/net045 U2971/net32 VDD VDD pmos W=0.205u L=0.04u
M27321 U2972/net4 WX1944 U2972/net14 VSS nmos W=0.155u L=0.04u
M27322 U2972/net6 U2972/net10 U2972/net14 VSS nmos W=0.17u L=0.04u
M27323 U2972/net4 n1376 VSS VSS nmos W=0.155u L=0.04u
M27324 U2972/net6 U2972/net4 VSS VSS nmos W=0.17u L=0.04u
M27325 n2248 U2972/net14 VSS VSS nmos W=0.155u L=0.04u
M27326 U2972/net10 WX1944 VSS VSS nmos W=0.155u L=0.04u
M27327 U2972/net4 U2972/net10 U2972/net14 VDD pmos W=0.255u L=0.04u
M27328 U2972/net6 WX1944 U2972/net14 VDD pmos W=0.28u L=0.04u
M27329 U2972/net4 n1376 VDD VDD pmos W=0.205u L=0.04u
M27330 U2972/net6 U2972/net4 VDD VDD pmos W=0.24u L=0.04u
M27331 n2248 U2972/net14 VDD VDD pmos W=0.205u L=0.04u
M27332 U2972/net10 WX1944 VDD VDD pmos W=0.205u L=0.04u
M27333 WX136 n1281 U2973/net26 VSS nmos W=0.155u L=0.04u
M27334 WX136 n2227 U2973/net26 VSS nmos W=0.155u L=0.04u
M27335 U2973/net29 n2250 VSS VSS nmos W=0.155u L=0.04u
M27336 U2973/net26 n2249 U2973/net29 VSS nmos W=0.155u L=0.04u
M27337 U2973/net26 n1253 U2973/net29 VSS nmos W=0.155u L=0.04u
M27338 WX136 n2227 U2973/net43 VDD pmos W=0.205u L=0.04u
M27339 WX136 n1253 U2973/net49 VDD pmos W=0.205u L=0.04u
M27340 U2973/net49 n2249 VDD VDD pmos W=0.205u L=0.04u
M27341 U2973/net43 n1281 VDD VDD pmos W=0.205u L=0.04u
M27342 WX136 n2250 VDD VDD pmos W=0.205u L=0.04u
M27343 U2974/net29 n1346 VSS VSS nmos W=0.155u L=0.04u
M27344 n2250 WX499 U2974/net29 VSS nmos W=0.155u L=0.04u
M27345 n2250 n1313 U2974/net23 VSS nmos W=0.155u L=0.04u
M27346 U2974/net23 CRC_OUT_9_24 VSS VSS nmos W=0.155u L=0.04u
M27347 U2974/net20 CRC_OUT_9_24 n2250 VDD pmos W=0.205u L=0.04u
M27348 U2974/net20 n1313 n2250 VDD pmos W=0.205u L=0.04u
M27349 VDD WX499 U2974/net20 VDD pmos W=0.205u L=0.04u
M27350 VDD n1346 U2974/net20 VDD pmos W=0.205u L=0.04u
M27351 n2227 n2251 VSS VSS nmos W=0.135u L=0.04u
M27352 n2227 n2251 VDD VDD pmos W=0.205u L=0.04u
M27353 U2976/net28 U2976/net20 U2976/net64 VSS nmos W=0.155u L=0.04u
M27354 U2976/net24 U2976/net30 U2976/net32 VSS nmos W=0.155u L=0.04u
M27355 U2976/net28 U2976/net40 U2976/net24 VSS nmos W=0.155u L=0.04u
M27356 U2976/net40 n2252 U2976/net108 VSS nmos W=0.155u L=0.04u
M27357 U2976/net40 U2976/net106 U2976/net104 VSS nmos W=0.155u L=0.04u
M27358 U2976/net24 WX2080 U2976/net050 VSS nmos W=0.155u L=0.04u
M27359 U2976/net050 U2976/net32 VSS VSS nmos W=0.155u L=0.04u
M27360 U2976/net20 U2976/net40 VSS VSS nmos W=0.155u L=0.04u
M27361 U2976/net106 n2252 VSS VSS nmos W=0.155u L=0.04u
M27362 U2976/net104 WX2144 VSS VSS nmos W=0.155u L=0.04u
M27363 U2976/net30 WX2080 VSS VSS nmos W=0.155u L=0.04u
M27364 U2976/net108 U2976/net104 VSS VSS nmos W=0.155u L=0.04u
M27365 n2251 U2976/net28 VSS VSS nmos W=0.155u L=0.04u
M27366 U2976/net32 WX2016 VSS VSS nmos W=0.155u L=0.04u
M27367 U2976/net64 U2976/net24 VSS VSS nmos W=0.2u L=0.04u
M27368 U2976/net28 U2976/net40 U2976/net64 VDD pmos W=0.205u L=0.04u
M27369 U2976/net24 WX2080 U2976/net32 VDD pmos W=0.205u L=0.04u
M27370 U2976/net28 U2976/net20 U2976/net24 VDD pmos W=0.205u L=0.04u
M27371 U2976/net40 U2976/net106 U2976/net108 VDD pmos W=0.205u L=0.04u
M27372 U2976/net40 n2252 U2976/net104 VDD pmos W=0.205u L=0.04u
M27373 U2976/net20 U2976/net40 VDD VDD pmos W=0.205u L=0.04u
M27374 U2976/net106 n2252 VDD VDD pmos W=0.205u L=0.04u
M27375 U2976/net104 WX2144 VDD VDD pmos W=0.205u L=0.04u
M27376 U2976/net30 WX2080 VDD VDD pmos W=0.205u L=0.04u
M27377 U2976/net108 U2976/net104 VDD VDD pmos W=0.205u L=0.04u
M27378 n2251 U2976/net28 VDD VDD pmos W=0.205u L=0.04u
M27379 U2976/net32 WX2016 VDD VDD pmos W=0.205u L=0.04u
M27380 U2976/net64 U2976/net24 VDD VDD pmos W=0.28u L=0.04u
M27381 U2976/net24 U2976/net30 U2976/net045 VDD pmos W=0.205u L=0.04u
M27382 U2976/net045 U2976/net32 VDD VDD pmos W=0.205u L=0.04u
M27383 U2977/net4 WX1952 U2977/net14 VSS nmos W=0.155u L=0.04u
M27384 U2977/net6 U2977/net10 U2977/net14 VSS nmos W=0.17u L=0.04u
M27385 U2977/net4 n1376 VSS VSS nmos W=0.155u L=0.04u
M27386 U2977/net6 U2977/net4 VSS VSS nmos W=0.17u L=0.04u
M27387 n2252 U2977/net14 VSS VSS nmos W=0.155u L=0.04u
M27388 U2977/net10 WX1952 VSS VSS nmos W=0.155u L=0.04u
M27389 U2977/net4 U2977/net10 U2977/net14 VDD pmos W=0.255u L=0.04u
M27390 U2977/net6 WX1952 U2977/net14 VDD pmos W=0.28u L=0.04u
M27391 U2977/net4 n1376 VDD VDD pmos W=0.205u L=0.04u
M27392 U2977/net6 U2977/net4 VDD VDD pmos W=0.24u L=0.04u
M27393 n2252 U2977/net14 VDD VDD pmos W=0.205u L=0.04u
M27394 U2977/net10 WX1952 VDD VDD pmos W=0.205u L=0.04u
M27395 WX1359 n1244 U2978/net26 VSS nmos W=0.155u L=0.04u
M27396 WX1359 n1705 U2978/net26 VSS nmos W=0.155u L=0.04u
M27397 U2978/net29 n2253 VSS VSS nmos W=0.155u L=0.04u
M27398 U2978/net26 n2103 U2978/net29 VSS nmos W=0.155u L=0.04u
M27399 U2978/net26 n1289 U2978/net29 VSS nmos W=0.155u L=0.04u
M27400 WX1359 n1705 U2978/net43 VDD pmos W=0.205u L=0.04u
M27401 WX1359 n1289 U2978/net49 VDD pmos W=0.205u L=0.04u
M27402 U2978/net49 n2103 VDD VDD pmos W=0.205u L=0.04u
M27403 U2978/net43 n1244 VDD VDD pmos W=0.205u L=0.04u
M27404 WX1359 n2253 VDD VDD pmos W=0.205u L=0.04u
M27405 U2979/net29 n1346 VSS VSS nmos W=0.155u L=0.04u
M27406 n2253 WX1782 U2979/net29 VSS nmos W=0.155u L=0.04u
M27407 n2253 n1312 U2979/net23 VSS nmos W=0.155u L=0.04u
M27408 U2979/net23 CRC_OUT_8_29 VSS VSS nmos W=0.155u L=0.04u
M27409 U2979/net20 CRC_OUT_8_29 n2253 VDD pmos W=0.205u L=0.04u
M27410 U2979/net20 n1312 n2253 VDD pmos W=0.205u L=0.04u
M27411 VDD WX1782 U2979/net20 VDD pmos W=0.205u L=0.04u
M27412 VDD n1346 U2979/net20 VDD pmos W=0.205u L=0.04u
M27413 n2103 n2254 VSS VSS nmos W=0.135u L=0.04u
M27414 n2103 n2254 VDD VDD pmos W=0.205u L=0.04u
M27415 U2981/net28 U2981/net20 U2981/net64 VSS nmos W=0.155u L=0.04u
M27416 U2981/net24 U2981/net30 U2981/net32 VSS nmos W=0.155u L=0.04u
M27417 U2981/net28 U2981/net40 U2981/net24 VSS nmos W=0.155u L=0.04u
M27418 U2981/net40 n2255 U2981/net108 VSS nmos W=0.155u L=0.04u
M27419 U2981/net40 U2981/net106 U2981/net104 VSS nmos W=0.155u L=0.04u
M27420 U2981/net24 WX3363 U2981/net050 VSS nmos W=0.155u L=0.04u
M27421 U2981/net050 U2981/net32 VSS VSS nmos W=0.155u L=0.04u
M27422 U2981/net20 U2981/net40 VSS VSS nmos W=0.155u L=0.04u
M27423 U2981/net106 n2255 VSS VSS nmos W=0.155u L=0.04u
M27424 U2981/net104 WX3427 VSS VSS nmos W=0.155u L=0.04u
M27425 U2981/net30 WX3363 VSS VSS nmos W=0.155u L=0.04u
M27426 U2981/net108 U2981/net104 VSS VSS nmos W=0.155u L=0.04u
M27427 n2254 U2981/net28 VSS VSS nmos W=0.155u L=0.04u
M27428 U2981/net32 WX3299 VSS VSS nmos W=0.155u L=0.04u
M27429 U2981/net64 U2981/net24 VSS VSS nmos W=0.2u L=0.04u
M27430 U2981/net28 U2981/net40 U2981/net64 VDD pmos W=0.205u L=0.04u
M27431 U2981/net24 WX3363 U2981/net32 VDD pmos W=0.205u L=0.04u
M27432 U2981/net28 U2981/net20 U2981/net24 VDD pmos W=0.205u L=0.04u
M27433 U2981/net40 U2981/net106 U2981/net108 VDD pmos W=0.205u L=0.04u
M27434 U2981/net40 n2255 U2981/net104 VDD pmos W=0.205u L=0.04u
M27435 U2981/net20 U2981/net40 VDD VDD pmos W=0.205u L=0.04u
M27436 U2981/net106 n2255 VDD VDD pmos W=0.205u L=0.04u
M27437 U2981/net104 WX3427 VDD VDD pmos W=0.205u L=0.04u
M27438 U2981/net30 WX3363 VDD VDD pmos W=0.205u L=0.04u
M27439 U2981/net108 U2981/net104 VDD VDD pmos W=0.205u L=0.04u
M27440 n2254 U2981/net28 VDD VDD pmos W=0.205u L=0.04u
M27441 U2981/net32 WX3299 VDD VDD pmos W=0.205u L=0.04u
M27442 U2981/net64 U2981/net24 VDD VDD pmos W=0.28u L=0.04u
M27443 U2981/net24 U2981/net30 U2981/net045 VDD pmos W=0.205u L=0.04u
M27444 U2981/net045 U2981/net32 VDD VDD pmos W=0.205u L=0.04u
M27445 U2982/net4 WX3235 U2982/net14 VSS nmos W=0.155u L=0.04u
M27446 U2982/net6 U2982/net10 U2982/net14 VSS nmos W=0.17u L=0.04u
M27447 U2982/net4 n1376 VSS VSS nmos W=0.155u L=0.04u
M27448 U2982/net6 U2982/net4 VSS VSS nmos W=0.17u L=0.04u
M27449 n2255 U2982/net14 VSS VSS nmos W=0.155u L=0.04u
M27450 U2982/net10 WX3235 VSS VSS nmos W=0.155u L=0.04u
M27451 U2982/net4 U2982/net10 U2982/net14 VDD pmos W=0.255u L=0.04u
M27452 U2982/net6 WX3235 U2982/net14 VDD pmos W=0.28u L=0.04u
M27453 U2982/net4 n1376 VDD VDD pmos W=0.205u L=0.04u
M27454 U2982/net6 U2982/net4 VDD VDD pmos W=0.24u L=0.04u
M27455 n2255 U2982/net14 VDD VDD pmos W=0.205u L=0.04u
M27456 U2982/net10 WX3235 VDD VDD pmos W=0.205u L=0.04u
M27457 n1705 n2256 VSS VSS nmos W=0.135u L=0.04u
M27458 n1705 n2256 VDD VDD pmos W=0.205u L=0.04u
M27459 U2984/net28 U2984/net20 U2984/net64 VSS nmos W=0.155u L=0.04u
M27460 U2984/net24 U2984/net30 U2984/net32 VSS nmos W=0.155u L=0.04u
M27461 U2984/net28 U2984/net40 U2984/net24 VSS nmos W=0.155u L=0.04u
M27462 U2984/net40 n2257 U2984/net108 VSS nmos W=0.155u L=0.04u
M27463 U2984/net40 U2984/net106 U2984/net104 VSS nmos W=0.155u L=0.04u
M27464 U2984/net24 WX2070 U2984/net050 VSS nmos W=0.155u L=0.04u
M27465 U2984/net050 U2984/net32 VSS VSS nmos W=0.155u L=0.04u
M27466 U2984/net20 U2984/net40 VSS VSS nmos W=0.155u L=0.04u
M27467 U2984/net106 n2257 VSS VSS nmos W=0.155u L=0.04u
M27468 U2984/net104 WX2134 VSS VSS nmos W=0.155u L=0.04u
M27469 U2984/net30 WX2070 VSS VSS nmos W=0.155u L=0.04u
M27470 U2984/net108 U2984/net104 VSS VSS nmos W=0.155u L=0.04u
M27471 n2256 U2984/net28 VSS VSS nmos W=0.155u L=0.04u
M27472 U2984/net32 WX2006 VSS VSS nmos W=0.155u L=0.04u
M27473 U2984/net64 U2984/net24 VSS VSS nmos W=0.2u L=0.04u
M27474 U2984/net28 U2984/net40 U2984/net64 VDD pmos W=0.205u L=0.04u
M27475 U2984/net24 WX2070 U2984/net32 VDD pmos W=0.205u L=0.04u
M27476 U2984/net28 U2984/net20 U2984/net24 VDD pmos W=0.205u L=0.04u
M27477 U2984/net40 U2984/net106 U2984/net108 VDD pmos W=0.205u L=0.04u
M27478 U2984/net40 n2257 U2984/net104 VDD pmos W=0.205u L=0.04u
M27479 U2984/net20 U2984/net40 VDD VDD pmos W=0.205u L=0.04u
M27480 U2984/net106 n2257 VDD VDD pmos W=0.205u L=0.04u
M27481 U2984/net104 WX2134 VDD VDD pmos W=0.205u L=0.04u
M27482 U2984/net30 WX2070 VDD VDD pmos W=0.205u L=0.04u
M27483 U2984/net108 U2984/net104 VDD VDD pmos W=0.205u L=0.04u
M27484 n2256 U2984/net28 VDD VDD pmos W=0.205u L=0.04u
M27485 U2984/net32 WX2006 VDD VDD pmos W=0.205u L=0.04u
M27486 U2984/net64 U2984/net24 VDD VDD pmos W=0.28u L=0.04u
M27487 U2984/net24 U2984/net30 U2984/net045 VDD pmos W=0.205u L=0.04u
M27488 U2984/net045 U2984/net32 VDD VDD pmos W=0.205u L=0.04u
M27489 U2985/net4 WX1942 U2985/net14 VSS nmos W=0.155u L=0.04u
M27490 U2985/net6 U2985/net10 U2985/net14 VSS nmos W=0.17u L=0.04u
M27491 U2985/net4 n1376 VSS VSS nmos W=0.155u L=0.04u
M27492 U2985/net6 U2985/net4 VSS VSS nmos W=0.17u L=0.04u
M27493 n2257 U2985/net14 VSS VSS nmos W=0.155u L=0.04u
M27494 U2985/net10 WX1942 VSS VSS nmos W=0.155u L=0.04u
M27495 U2985/net4 U2985/net10 U2985/net14 VDD pmos W=0.255u L=0.04u
M27496 U2985/net6 WX1942 U2985/net14 VDD pmos W=0.28u L=0.04u
M27497 U2985/net4 n1376 VDD VDD pmos W=0.205u L=0.04u
M27498 U2985/net6 U2985/net4 VDD VDD pmos W=0.24u L=0.04u
M27499 n2257 U2985/net14 VDD VDD pmos W=0.205u L=0.04u
M27500 U2985/net10 WX1942 VDD VDD pmos W=0.205u L=0.04u
M27501 WX1345 n1244 U2986/net26 VSS nmos W=0.155u L=0.04u
M27502 WX1345 n1845 U2986/net26 VSS nmos W=0.155u L=0.04u
M27503 U2986/net29 n2258 VSS VSS nmos W=0.155u L=0.04u
M27504 U2986/net26 n2107 U2986/net29 VSS nmos W=0.155u L=0.04u
M27505 U2986/net26 n1289 U2986/net29 VSS nmos W=0.155u L=0.04u
M27506 WX1345 n1845 U2986/net43 VDD pmos W=0.205u L=0.04u
M27507 WX1345 n1289 U2986/net49 VDD pmos W=0.205u L=0.04u
M27508 U2986/net49 n2107 VDD VDD pmos W=0.205u L=0.04u
M27509 U2986/net43 n1244 VDD VDD pmos W=0.205u L=0.04u
M27510 WX1345 n2258 VDD VDD pmos W=0.205u L=0.04u
M27511 U2987/net29 n1346 VSS VSS nmos W=0.155u L=0.04u
M27512 n2258 WX1780 U2987/net29 VSS nmos W=0.155u L=0.04u
M27513 n2258 n1312 U2987/net23 VSS nmos W=0.155u L=0.04u
M27514 U2987/net23 CRC_OUT_8_30 VSS VSS nmos W=0.155u L=0.04u
M27515 U2987/net20 CRC_OUT_8_30 n2258 VDD pmos W=0.205u L=0.04u
M27516 U2987/net20 n1312 n2258 VDD pmos W=0.205u L=0.04u
M27517 VDD WX1780 U2987/net20 VDD pmos W=0.205u L=0.04u
M27518 VDD n1346 U2987/net20 VDD pmos W=0.205u L=0.04u
M27519 n2107 n2259 VSS VSS nmos W=0.135u L=0.04u
M27520 n2107 n2259 VDD VDD pmos W=0.205u L=0.04u
M27521 U2989/net28 U2989/net20 U2989/net64 VSS nmos W=0.155u L=0.04u
M27522 U2989/net24 U2989/net30 U2989/net32 VSS nmos W=0.155u L=0.04u
M27523 U2989/net28 U2989/net40 U2989/net24 VSS nmos W=0.155u L=0.04u
M27524 U2989/net40 n2260 U2989/net108 VSS nmos W=0.155u L=0.04u
M27525 U2989/net40 U2989/net106 U2989/net104 VSS nmos W=0.155u L=0.04u
M27526 U2989/net24 WX3361 U2989/net050 VSS nmos W=0.155u L=0.04u
M27527 U2989/net050 U2989/net32 VSS VSS nmos W=0.155u L=0.04u
M27528 U2989/net20 U2989/net40 VSS VSS nmos W=0.155u L=0.04u
M27529 U2989/net106 n2260 VSS VSS nmos W=0.155u L=0.04u
M27530 U2989/net104 WX3425 VSS VSS nmos W=0.155u L=0.04u
M27531 U2989/net30 WX3361 VSS VSS nmos W=0.155u L=0.04u
M27532 U2989/net108 U2989/net104 VSS VSS nmos W=0.155u L=0.04u
M27533 n2259 U2989/net28 VSS VSS nmos W=0.155u L=0.04u
M27534 U2989/net32 WX3297 VSS VSS nmos W=0.155u L=0.04u
M27535 U2989/net64 U2989/net24 VSS VSS nmos W=0.2u L=0.04u
M27536 U2989/net28 U2989/net40 U2989/net64 VDD pmos W=0.205u L=0.04u
M27537 U2989/net24 WX3361 U2989/net32 VDD pmos W=0.205u L=0.04u
M27538 U2989/net28 U2989/net20 U2989/net24 VDD pmos W=0.205u L=0.04u
M27539 U2989/net40 U2989/net106 U2989/net108 VDD pmos W=0.205u L=0.04u
M27540 U2989/net40 n2260 U2989/net104 VDD pmos W=0.205u L=0.04u
M27541 U2989/net20 U2989/net40 VDD VDD pmos W=0.205u L=0.04u
M27542 U2989/net106 n2260 VDD VDD pmos W=0.205u L=0.04u
M27543 U2989/net104 WX3425 VDD VDD pmos W=0.205u L=0.04u
M27544 U2989/net30 WX3361 VDD VDD pmos W=0.205u L=0.04u
M27545 U2989/net108 U2989/net104 VDD VDD pmos W=0.205u L=0.04u
M27546 n2259 U2989/net28 VDD VDD pmos W=0.205u L=0.04u
M27547 U2989/net32 WX3297 VDD VDD pmos W=0.205u L=0.04u
M27548 U2989/net64 U2989/net24 VDD VDD pmos W=0.28u L=0.04u
M27549 U2989/net24 U2989/net30 U2989/net045 VDD pmos W=0.205u L=0.04u
M27550 U2989/net045 U2989/net32 VDD VDD pmos W=0.205u L=0.04u
M27551 U2990/net4 WX3233 U2990/net14 VSS nmos W=0.155u L=0.04u
M27552 U2990/net6 U2990/net10 U2990/net14 VSS nmos W=0.17u L=0.04u
M27553 U2990/net4 n1376 VSS VSS nmos W=0.155u L=0.04u
M27554 U2990/net6 U2990/net4 VSS VSS nmos W=0.17u L=0.04u
M27555 n2260 U2990/net14 VSS VSS nmos W=0.155u L=0.04u
M27556 U2990/net10 WX3233 VSS VSS nmos W=0.155u L=0.04u
M27557 U2990/net4 U2990/net10 U2990/net14 VDD pmos W=0.255u L=0.04u
M27558 U2990/net6 WX3233 U2990/net14 VDD pmos W=0.28u L=0.04u
M27559 U2990/net4 n1376 VDD VDD pmos W=0.205u L=0.04u
M27560 U2990/net6 U2990/net4 VDD VDD pmos W=0.24u L=0.04u
M27561 n2260 U2990/net14 VDD VDD pmos W=0.205u L=0.04u
M27562 U2990/net10 WX3233 VDD VDD pmos W=0.205u L=0.04u
M27563 n1845 n2261 VSS VSS nmos W=0.135u L=0.04u
M27564 n1845 n2261 VDD VDD pmos W=0.205u L=0.04u
M27565 U2992/net28 U2992/net20 U2992/net64 VSS nmos W=0.155u L=0.04u
M27566 U2992/net24 U2992/net30 U2992/net32 VSS nmos W=0.155u L=0.04u
M27567 U2992/net28 U2992/net40 U2992/net24 VSS nmos W=0.155u L=0.04u
M27568 U2992/net40 n2262 U2992/net108 VSS nmos W=0.155u L=0.04u
M27569 U2992/net40 U2992/net106 U2992/net104 VSS nmos W=0.155u L=0.04u
M27570 U2992/net24 WX2068 U2992/net050 VSS nmos W=0.155u L=0.04u
M27571 U2992/net050 U2992/net32 VSS VSS nmos W=0.155u L=0.04u
M27572 U2992/net20 U2992/net40 VSS VSS nmos W=0.155u L=0.04u
M27573 U2992/net106 n2262 VSS VSS nmos W=0.155u L=0.04u
M27574 U2992/net104 WX2132 VSS VSS nmos W=0.155u L=0.04u
M27575 U2992/net30 WX2068 VSS VSS nmos W=0.155u L=0.04u
M27576 U2992/net108 U2992/net104 VSS VSS nmos W=0.155u L=0.04u
M27577 n2261 U2992/net28 VSS VSS nmos W=0.155u L=0.04u
M27578 U2992/net32 WX2004 VSS VSS nmos W=0.155u L=0.04u
M27579 U2992/net64 U2992/net24 VSS VSS nmos W=0.2u L=0.04u
M27580 U2992/net28 U2992/net40 U2992/net64 VDD pmos W=0.205u L=0.04u
M27581 U2992/net24 WX2068 U2992/net32 VDD pmos W=0.205u L=0.04u
M27582 U2992/net28 U2992/net20 U2992/net24 VDD pmos W=0.205u L=0.04u
M27583 U2992/net40 U2992/net106 U2992/net108 VDD pmos W=0.205u L=0.04u
M27584 U2992/net40 n2262 U2992/net104 VDD pmos W=0.205u L=0.04u
M27585 U2992/net20 U2992/net40 VDD VDD pmos W=0.205u L=0.04u
M27586 U2992/net106 n2262 VDD VDD pmos W=0.205u L=0.04u
M27587 U2992/net104 WX2132 VDD VDD pmos W=0.205u L=0.04u
M27588 U2992/net30 WX2068 VDD VDD pmos W=0.205u L=0.04u
M27589 U2992/net108 U2992/net104 VDD VDD pmos W=0.205u L=0.04u
M27590 n2261 U2992/net28 VDD VDD pmos W=0.205u L=0.04u
M27591 U2992/net32 WX2004 VDD VDD pmos W=0.205u L=0.04u
M27592 U2992/net64 U2992/net24 VDD VDD pmos W=0.28u L=0.04u
M27593 U2992/net24 U2992/net30 U2992/net045 VDD pmos W=0.205u L=0.04u
M27594 U2992/net045 U2992/net32 VDD VDD pmos W=0.205u L=0.04u
M27595 U2993/net4 WX1940 U2993/net14 VSS nmos W=0.155u L=0.04u
M27596 U2993/net6 U2993/net10 U2993/net14 VSS nmos W=0.17u L=0.04u
M27597 U2993/net4 n1377 VSS VSS nmos W=0.155u L=0.04u
M27598 U2993/net6 U2993/net4 VSS VSS nmos W=0.17u L=0.04u
M27599 n2262 U2993/net14 VSS VSS nmos W=0.155u L=0.04u
M27600 U2993/net10 WX1940 VSS VSS nmos W=0.155u L=0.04u
M27601 U2993/net4 U2993/net10 U2993/net14 VDD pmos W=0.255u L=0.04u
M27602 U2993/net6 WX1940 U2993/net14 VDD pmos W=0.28u L=0.04u
M27603 U2993/net4 n1377 VDD VDD pmos W=0.205u L=0.04u
M27604 U2993/net6 U2993/net4 VDD VDD pmos W=0.24u L=0.04u
M27605 n2262 U2993/net14 VDD VDD pmos W=0.205u L=0.04u
M27606 U2993/net10 WX1940 VDD VDD pmos W=0.205u L=0.04u
M27607 WX1331 n1615 U2994/net26 VSS nmos W=0.155u L=0.04u
M27608 WX1331 n1396 U2994/net26 VSS nmos W=0.155u L=0.04u
M27609 U2994/net29 n2263 VSS VSS nmos W=0.155u L=0.04u
M27610 U2994/net26 WX1776 U2994/net29 VSS nmos W=0.155u L=0.04u
M27611 U2994/net26 n1500 U2994/net29 VSS nmos W=0.155u L=0.04u
M27612 WX1331 n1396 U2994/net43 VDD pmos W=0.205u L=0.04u
M27613 WX1331 n1500 U2994/net49 VDD pmos W=0.205u L=0.04u
M27614 U2994/net49 WX1776 VDD VDD pmos W=0.205u L=0.04u
M27615 U2994/net43 n1615 VDD VDD pmos W=0.205u L=0.04u
M27616 WX1331 n2263 VDD VDD pmos W=0.205u L=0.04u
M27617 U2995/net29 n1979 VSS VSS nmos W=0.155u L=0.04u
M27618 n2263 n1430 U2995/net29 VSS nmos W=0.155u L=0.04u
M27619 n2263 n1617 U2995/net23 VSS nmos W=0.155u L=0.04u
M27620 U2995/net23 n2112 VSS VSS nmos W=0.155u L=0.04u
M27621 U2995/net20 n2112 n2263 VDD pmos W=0.205u L=0.04u
M27622 U2995/net20 n1617 n2263 VDD pmos W=0.205u L=0.04u
M27623 VDD n1430 U2995/net20 VDD pmos W=0.205u L=0.04u
M27624 VDD n1979 U2995/net20 VDD pmos W=0.205u L=0.04u
M27625 U2996/net28 U2996/net20 U2996/net64 VSS nmos W=0.155u L=0.04u
M27626 U2996/net24 U2996/net30 U2996/net32 VSS nmos W=0.155u L=0.04u
M27627 U2996/net28 U2996/net40 U2996/net24 VSS nmos W=0.155u L=0.04u
M27628 U2996/net40 n2264 U2996/net108 VSS nmos W=0.155u L=0.04u
M27629 U2996/net40 U2996/net106 U2996/net104 VSS nmos W=0.155u L=0.04u
M27630 U2996/net24 WX2066 U2996/net050 VSS nmos W=0.155u L=0.04u
M27631 U2996/net050 U2996/net32 VSS VSS nmos W=0.155u L=0.04u
M27632 U2996/net20 U2996/net40 VSS VSS nmos W=0.155u L=0.04u
M27633 U2996/net106 n2264 VSS VSS nmos W=0.155u L=0.04u
M27634 U2996/net104 WX2130 VSS VSS nmos W=0.155u L=0.04u
M27635 U2996/net30 WX2066 VSS VSS nmos W=0.155u L=0.04u
M27636 U2996/net108 U2996/net104 VSS VSS nmos W=0.155u L=0.04u
M27637 n1979 U2996/net28 VSS VSS nmos W=0.155u L=0.04u
M27638 U2996/net32 WX2002 VSS VSS nmos W=0.155u L=0.04u
M27639 U2996/net64 U2996/net24 VSS VSS nmos W=0.2u L=0.04u
M27640 U2996/net28 U2996/net40 U2996/net64 VDD pmos W=0.205u L=0.04u
M27641 U2996/net24 WX2066 U2996/net32 VDD pmos W=0.205u L=0.04u
M27642 U2996/net28 U2996/net20 U2996/net24 VDD pmos W=0.205u L=0.04u
M27643 U2996/net40 U2996/net106 U2996/net108 VDD pmos W=0.205u L=0.04u
M27644 U2996/net40 n2264 U2996/net104 VDD pmos W=0.205u L=0.04u
M27645 U2996/net20 U2996/net40 VDD VDD pmos W=0.205u L=0.04u
M27646 U2996/net106 n2264 VDD VDD pmos W=0.205u L=0.04u
M27647 U2996/net104 WX2130 VDD VDD pmos W=0.205u L=0.04u
M27648 U2996/net30 WX2066 VDD VDD pmos W=0.205u L=0.04u
M27649 U2996/net108 U2996/net104 VDD VDD pmos W=0.205u L=0.04u
M27650 n1979 U2996/net28 VDD VDD pmos W=0.205u L=0.04u
M27651 U2996/net32 WX2002 VDD VDD pmos W=0.205u L=0.04u
M27652 U2996/net64 U2996/net24 VDD VDD pmos W=0.28u L=0.04u
M27653 U2996/net24 U2996/net30 U2996/net045 VDD pmos W=0.205u L=0.04u
M27654 U2996/net045 U2996/net32 VDD VDD pmos W=0.205u L=0.04u
M27655 U2997/net4 WX1938 U2997/net14 VSS nmos W=0.155u L=0.04u
M27656 U2997/net6 U2997/net10 U2997/net14 VSS nmos W=0.17u L=0.04u
M27657 U2997/net4 n1377 VSS VSS nmos W=0.155u L=0.04u
M27658 U2997/net6 U2997/net4 VSS VSS nmos W=0.17u L=0.04u
M27659 n2264 U2997/net14 VSS VSS nmos W=0.155u L=0.04u
M27660 U2997/net10 WX1938 VSS VSS nmos W=0.155u L=0.04u
M27661 U2997/net4 U2997/net10 U2997/net14 VDD pmos W=0.255u L=0.04u
M27662 U2997/net6 WX1938 U2997/net14 VDD pmos W=0.28u L=0.04u
M27663 U2997/net4 n1377 VDD VDD pmos W=0.205u L=0.04u
M27664 U2997/net6 U2997/net4 VDD VDD pmos W=0.24u L=0.04u
M27665 n2264 U2997/net14 VDD VDD pmos W=0.205u L=0.04u
M27666 U2997/net10 WX1938 VDD VDD pmos W=0.205u L=0.04u
M27667 U2998/net28 U2998/net20 U2998/net64 VSS nmos W=0.155u L=0.04u
M27668 U2998/net24 U2998/net30 U2998/net32 VSS nmos W=0.155u L=0.04u
M27669 U2998/net28 U2998/net40 U2998/net24 VSS nmos W=0.155u L=0.04u
M27670 U2998/net40 n2265 U2998/net108 VSS nmos W=0.155u L=0.04u
M27671 U2998/net40 U2998/net106 U2998/net104 VSS nmos W=0.155u L=0.04u
M27672 U2998/net24 WX3359 U2998/net050 VSS nmos W=0.155u L=0.04u
M27673 U2998/net050 U2998/net32 VSS VSS nmos W=0.155u L=0.04u
M27674 U2998/net20 U2998/net40 VSS VSS nmos W=0.155u L=0.04u
M27675 U2998/net106 n2265 VSS VSS nmos W=0.155u L=0.04u
M27676 U2998/net104 WX3423 VSS VSS nmos W=0.155u L=0.04u
M27677 U2998/net30 WX3359 VSS VSS nmos W=0.155u L=0.04u
M27678 U2998/net108 U2998/net104 VSS VSS nmos W=0.155u L=0.04u
M27679 n2112 U2998/net28 VSS VSS nmos W=0.155u L=0.04u
M27680 U2998/net32 WX3295 VSS VSS nmos W=0.155u L=0.04u
M27681 U2998/net64 U2998/net24 VSS VSS nmos W=0.2u L=0.04u
M27682 U2998/net28 U2998/net40 U2998/net64 VDD pmos W=0.205u L=0.04u
M27683 U2998/net24 WX3359 U2998/net32 VDD pmos W=0.205u L=0.04u
M27684 U2998/net28 U2998/net20 U2998/net24 VDD pmos W=0.205u L=0.04u
M27685 U2998/net40 U2998/net106 U2998/net108 VDD pmos W=0.205u L=0.04u
M27686 U2998/net40 n2265 U2998/net104 VDD pmos W=0.205u L=0.04u
M27687 U2998/net20 U2998/net40 VDD VDD pmos W=0.205u L=0.04u
M27688 U2998/net106 n2265 VDD VDD pmos W=0.205u L=0.04u
M27689 U2998/net104 WX3423 VDD VDD pmos W=0.205u L=0.04u
M27690 U2998/net30 WX3359 VDD VDD pmos W=0.205u L=0.04u
M27691 U2998/net108 U2998/net104 VDD VDD pmos W=0.205u L=0.04u
M27692 n2112 U2998/net28 VDD VDD pmos W=0.205u L=0.04u
M27693 U2998/net32 WX3295 VDD VDD pmos W=0.205u L=0.04u
M27694 U2998/net64 U2998/net24 VDD VDD pmos W=0.28u L=0.04u
M27695 U2998/net24 U2998/net30 U2998/net045 VDD pmos W=0.205u L=0.04u
M27696 U2998/net045 U2998/net32 VDD VDD pmos W=0.205u L=0.04u
M27697 U2999/net4 WX3231 U2999/net14 VSS nmos W=0.155u L=0.04u
M27698 U2999/net6 U2999/net10 U2999/net14 VSS nmos W=0.17u L=0.04u
M27699 U2999/net4 n1377 VSS VSS nmos W=0.155u L=0.04u
M27700 U2999/net6 U2999/net4 VSS VSS nmos W=0.17u L=0.04u
M27701 n2265 U2999/net14 VSS VSS nmos W=0.155u L=0.04u
M27702 U2999/net10 WX3231 VSS VSS nmos W=0.155u L=0.04u
M27703 U2999/net4 U2999/net10 U2999/net14 VDD pmos W=0.255u L=0.04u
M27704 U2999/net6 WX3231 U2999/net14 VDD pmos W=0.28u L=0.04u
M27705 U2999/net4 n1377 VDD VDD pmos W=0.205u L=0.04u
M27706 U2999/net6 U2999/net4 VDD VDD pmos W=0.24u L=0.04u
M27707 n2265 U2999/net14 VDD VDD pmos W=0.205u L=0.04u
M27708 U2999/net10 WX3231 VDD VDD pmos W=0.205u L=0.04u
M27709 WX1776 WX1778 VSS VSS nmos W=0.135u L=0.04u
M27710 WX1776 WX1778 VDD VDD pmos W=0.205u L=0.04u
M27711 n1396 CRC_OUT_8_31 VSS VSS nmos W=0.135u L=0.04u
M27712 n1396 CRC_OUT_8_31 VDD VDD pmos W=0.205u L=0.04u
M27713 U3002/net4 U3002/net10 U3002/net14 VSS nmos W=0.155u L=0.04u
M27714 U3002/net6 n1847 U3002/net14 VSS nmos W=0.155u L=0.04u
M27715 U3002/net4 n2266 VSS VSS nmos W=0.155u L=0.04u
M27716 U3002/net6 U3002/net4 VSS VSS nmos W=0.155u L=0.04u
M27717 WX1227 U3002/net14 VSS VSS nmos W=0.155u L=0.04u
M27718 U3002/net10 n1847 VSS VSS nmos W=0.155u L=0.04u
M27719 U3002/net4 n1847 U3002/net14 VDD pmos W=0.205u L=0.04u
M27720 U3002/net6 U3002/net10 U3002/net14 VDD pmos W=0.205u L=0.04u
M27721 U3002/net4 n2266 VDD VDD pmos W=0.205u L=0.04u
M27722 U3002/net6 U3002/net4 VDD VDD pmos W=0.205u L=0.04u
M27723 WX1227 U3002/net14 VDD VDD pmos W=0.205u L=0.04u
M27724 U3002/net10 n1847 VDD VDD pmos W=0.205u L=0.04u
M27725 U3003/XU1-net6 TM0 VSS VSS nmos W=0.155u L=0.04u
M27726 n2266 WX547 U3003/XU1-net6 VSS nmos W=0.155u L=0.04u
M27727 n2266 TM0 VDD VDD pmos W=0.155u L=0.04u
M27728 n2266 WX547 VDD VDD pmos W=0.155u L=0.04u
M27729 n1847 n2267 VSS VSS nmos W=0.135u L=0.04u
M27730 n1847 n2267 VDD VDD pmos W=0.205u L=0.04u
M27731 U3005/net28 U3005/net20 U3005/net64 VSS nmos W=0.155u L=0.04u
M27732 U3005/net24 U3005/net30 U3005/net32 VSS nmos W=0.155u L=0.04u
M27733 U3005/net28 U3005/net40 U3005/net24 VSS nmos W=0.155u L=0.04u
M27734 U3005/net40 n2268 U3005/net108 VSS nmos W=0.155u L=0.04u
M27735 U3005/net40 U3005/net106 U3005/net104 VSS nmos W=0.155u L=0.04u
M27736 U3005/net24 WX835 U3005/net050 VSS nmos W=0.155u L=0.04u
M27737 U3005/net050 U3005/net32 VSS VSS nmos W=0.155u L=0.04u
M27738 U3005/net20 U3005/net40 VSS VSS nmos W=0.155u L=0.04u
M27739 U3005/net106 n2268 VSS VSS nmos W=0.155u L=0.04u
M27740 U3005/net104 WX899 VSS VSS nmos W=0.155u L=0.04u
M27741 U3005/net30 WX835 VSS VSS nmos W=0.155u L=0.04u
M27742 U3005/net108 U3005/net104 VSS VSS nmos W=0.155u L=0.04u
M27743 n2267 U3005/net28 VSS VSS nmos W=0.155u L=0.04u
M27744 U3005/net32 WX771 VSS VSS nmos W=0.155u L=0.04u
M27745 U3005/net64 U3005/net24 VSS VSS nmos W=0.2u L=0.04u
M27746 U3005/net28 U3005/net40 U3005/net64 VDD pmos W=0.205u L=0.04u
M27747 U3005/net24 WX835 U3005/net32 VDD pmos W=0.205u L=0.04u
M27748 U3005/net28 U3005/net20 U3005/net24 VDD pmos W=0.205u L=0.04u
M27749 U3005/net40 U3005/net106 U3005/net108 VDD pmos W=0.205u L=0.04u
M27750 U3005/net40 n2268 U3005/net104 VDD pmos W=0.205u L=0.04u
M27751 U3005/net20 U3005/net40 VDD VDD pmos W=0.205u L=0.04u
M27752 U3005/net106 n2268 VDD VDD pmos W=0.205u L=0.04u
M27753 U3005/net104 WX899 VDD VDD pmos W=0.205u L=0.04u
M27754 U3005/net30 WX835 VDD VDD pmos W=0.205u L=0.04u
M27755 U3005/net108 U3005/net104 VDD VDD pmos W=0.205u L=0.04u
M27756 n2267 U3005/net28 VDD VDD pmos W=0.205u L=0.04u
M27757 U3005/net32 WX771 VDD VDD pmos W=0.205u L=0.04u
M27758 U3005/net64 U3005/net24 VDD VDD pmos W=0.28u L=0.04u
M27759 U3005/net24 U3005/net30 U3005/net045 VDD pmos W=0.205u L=0.04u
M27760 U3005/net045 U3005/net32 VDD VDD pmos W=0.205u L=0.04u
M27761 U3006/net4 U3006/net10 U3006/net14 VSS nmos W=0.155u L=0.04u
M27762 U3006/net6 WX707 U3006/net14 VSS nmos W=0.155u L=0.04u
M27763 U3006/net4 TM0 VSS VSS nmos W=0.155u L=0.04u
M27764 U3006/net6 U3006/net4 VSS VSS nmos W=0.155u L=0.04u
M27765 n2268 U3006/net14 VSS VSS nmos W=0.155u L=0.04u
M27766 U3006/net10 WX707 VSS VSS nmos W=0.155u L=0.04u
M27767 U3006/net4 WX707 U3006/net14 VDD pmos W=0.205u L=0.04u
M27768 U3006/net6 U3006/net10 U3006/net14 VDD pmos W=0.205u L=0.04u
M27769 U3006/net4 TM0 VDD VDD pmos W=0.205u L=0.04u
M27770 U3006/net6 U3006/net4 VDD VDD pmos W=0.205u L=0.04u
M27771 n2268 U3006/net14 VDD VDD pmos W=0.205u L=0.04u
M27772 U3006/net10 WX707 VDD VDD pmos W=0.205u L=0.04u
M27773 U3007/net4 U3007/net10 U3007/net14 VSS nmos W=0.155u L=0.04u
M27774 U3007/net6 n1850 U3007/net14 VSS nmos W=0.155u L=0.04u
M27775 U3007/net4 n2269 VSS VSS nmos W=0.155u L=0.04u
M27776 U3007/net6 U3007/net4 VSS VSS nmos W=0.155u L=0.04u
M27777 WX1220 U3007/net14 VSS VSS nmos W=0.155u L=0.04u
M27778 U3007/net10 n1850 VSS VSS nmos W=0.155u L=0.04u
M27779 U3007/net4 n1850 U3007/net14 VDD pmos W=0.205u L=0.04u
M27780 U3007/net6 U3007/net10 U3007/net14 VDD pmos W=0.205u L=0.04u
M27781 U3007/net4 n2269 VDD VDD pmos W=0.205u L=0.04u
M27782 U3007/net6 U3007/net4 VDD VDD pmos W=0.205u L=0.04u
M27783 WX1220 U3007/net14 VDD VDD pmos W=0.205u L=0.04u
M27784 U3007/net10 n1850 VDD VDD pmos W=0.205u L=0.04u
M27785 U3008/XU1-net6 TM0 VSS VSS nmos W=0.155u L=0.04u
M27786 n2269 WX545 U3008/XU1-net6 VSS nmos W=0.155u L=0.04u
M27787 n2269 TM0 VDD VDD pmos W=0.155u L=0.04u
M27788 n2269 WX545 VDD VDD pmos W=0.155u L=0.04u
M27789 n1850 n2270 VSS VSS nmos W=0.135u L=0.04u
M27790 n1850 n2270 VDD VDD pmos W=0.205u L=0.04u
M27791 U3010/net28 U3010/net20 U3010/net64 VSS nmos W=0.155u L=0.04u
M27792 U3010/net24 U3010/net30 U3010/net32 VSS nmos W=0.155u L=0.04u
M27793 U3010/net28 U3010/net40 U3010/net24 VSS nmos W=0.155u L=0.04u
M27794 U3010/net40 n2271 U3010/net108 VSS nmos W=0.155u L=0.04u
M27795 U3010/net40 U3010/net106 U3010/net104 VSS nmos W=0.155u L=0.04u
M27796 U3010/net24 WX833 U3010/net050 VSS nmos W=0.155u L=0.04u
M27797 U3010/net050 U3010/net32 VSS VSS nmos W=0.155u L=0.04u
M27798 U3010/net20 U3010/net40 VSS VSS nmos W=0.155u L=0.04u
M27799 U3010/net106 n2271 VSS VSS nmos W=0.155u L=0.04u
M27800 U3010/net104 WX897 VSS VSS nmos W=0.155u L=0.04u
M27801 U3010/net30 WX833 VSS VSS nmos W=0.155u L=0.04u
M27802 U3010/net108 U3010/net104 VSS VSS nmos W=0.155u L=0.04u
M27803 n2270 U3010/net28 VSS VSS nmos W=0.155u L=0.04u
M27804 U3010/net32 WX769 VSS VSS nmos W=0.155u L=0.04u
M27805 U3010/net64 U3010/net24 VSS VSS nmos W=0.2u L=0.04u
M27806 U3010/net28 U3010/net40 U3010/net64 VDD pmos W=0.205u L=0.04u
M27807 U3010/net24 WX833 U3010/net32 VDD pmos W=0.205u L=0.04u
M27808 U3010/net28 U3010/net20 U3010/net24 VDD pmos W=0.205u L=0.04u
M27809 U3010/net40 U3010/net106 U3010/net108 VDD pmos W=0.205u L=0.04u
M27810 U3010/net40 n2271 U3010/net104 VDD pmos W=0.205u L=0.04u
M27811 U3010/net20 U3010/net40 VDD VDD pmos W=0.205u L=0.04u
M27812 U3010/net106 n2271 VDD VDD pmos W=0.205u L=0.04u
M27813 U3010/net104 WX897 VDD VDD pmos W=0.205u L=0.04u
M27814 U3010/net30 WX833 VDD VDD pmos W=0.205u L=0.04u
M27815 U3010/net108 U3010/net104 VDD VDD pmos W=0.205u L=0.04u
M27816 n2270 U3010/net28 VDD VDD pmos W=0.205u L=0.04u
M27817 U3010/net32 WX769 VDD VDD pmos W=0.205u L=0.04u
M27818 U3010/net64 U3010/net24 VDD VDD pmos W=0.28u L=0.04u
M27819 U3010/net24 U3010/net30 U3010/net045 VDD pmos W=0.205u L=0.04u
M27820 U3010/net045 U3010/net32 VDD VDD pmos W=0.205u L=0.04u
M27821 U3011/net4 U3011/net10 U3011/net14 VSS nmos W=0.155u L=0.04u
M27822 U3011/net6 WX705 U3011/net14 VSS nmos W=0.155u L=0.04u
M27823 U3011/net4 TM0 VSS VSS nmos W=0.155u L=0.04u
M27824 U3011/net6 U3011/net4 VSS VSS nmos W=0.155u L=0.04u
M27825 n2271 U3011/net14 VSS VSS nmos W=0.155u L=0.04u
M27826 U3011/net10 WX705 VSS VSS nmos W=0.155u L=0.04u
M27827 U3011/net4 WX705 U3011/net14 VDD pmos W=0.205u L=0.04u
M27828 U3011/net6 U3011/net10 U3011/net14 VDD pmos W=0.205u L=0.04u
M27829 U3011/net4 TM0 VDD VDD pmos W=0.205u L=0.04u
M27830 U3011/net6 U3011/net4 VDD VDD pmos W=0.205u L=0.04u
M27831 n2271 U3011/net14 VDD VDD pmos W=0.205u L=0.04u
M27832 U3011/net10 WX705 VDD VDD pmos W=0.205u L=0.04u
M27833 WX122 n1281 U3012/net26 VSS nmos W=0.155u L=0.04u
M27834 WX122 n2231 U3012/net26 VSS nmos W=0.155u L=0.04u
M27835 U3012/net29 n2273 VSS VSS nmos W=0.155u L=0.04u
M27836 U3012/net26 n2272 U3012/net29 VSS nmos W=0.155u L=0.04u
M27837 U3012/net26 n1253 U3012/net29 VSS nmos W=0.155u L=0.04u
M27838 WX122 n2231 U3012/net43 VDD pmos W=0.205u L=0.04u
M27839 WX122 n1253 U3012/net49 VDD pmos W=0.205u L=0.04u
M27840 U3012/net49 n2272 VDD VDD pmos W=0.205u L=0.04u
M27841 U3012/net43 n1281 VDD VDD pmos W=0.205u L=0.04u
M27842 WX122 n2273 VDD VDD pmos W=0.205u L=0.04u
M27843 U3013/net29 n1345 VSS VSS nmos W=0.155u L=0.04u
M27844 n2273 WX497 U3013/net29 VSS nmos W=0.155u L=0.04u
M27845 n2273 n1312 U3013/net23 VSS nmos W=0.155u L=0.04u
M27846 U3013/net23 CRC_OUT_9_25 VSS VSS nmos W=0.155u L=0.04u
M27847 U3013/net20 CRC_OUT_9_25 n2273 VDD pmos W=0.205u L=0.04u
M27848 U3013/net20 n1312 n2273 VDD pmos W=0.205u L=0.04u
M27849 VDD WX497 U3013/net20 VDD pmos W=0.205u L=0.04u
M27850 VDD n1345 U3013/net20 VDD pmos W=0.205u L=0.04u
M27851 n2231 n2274 VSS VSS nmos W=0.135u L=0.04u
M27852 n2231 n2274 VDD VDD pmos W=0.205u L=0.04u
M27853 U3015/net28 U3015/net20 U3015/net64 VSS nmos W=0.155u L=0.04u
M27854 U3015/net24 U3015/net30 U3015/net32 VSS nmos W=0.155u L=0.04u
M27855 U3015/net28 U3015/net40 U3015/net24 VSS nmos W=0.155u L=0.04u
M27856 U3015/net40 n2275 U3015/net108 VSS nmos W=0.155u L=0.04u
M27857 U3015/net40 U3015/net106 U3015/net104 VSS nmos W=0.155u L=0.04u
M27858 U3015/net24 WX2078 U3015/net050 VSS nmos W=0.155u L=0.04u
M27859 U3015/net050 U3015/net32 VSS VSS nmos W=0.155u L=0.04u
M27860 U3015/net20 U3015/net40 VSS VSS nmos W=0.155u L=0.04u
M27861 U3015/net106 n2275 VSS VSS nmos W=0.155u L=0.04u
M27862 U3015/net104 WX2142 VSS VSS nmos W=0.155u L=0.04u
M27863 U3015/net30 WX2078 VSS VSS nmos W=0.155u L=0.04u
M27864 U3015/net108 U3015/net104 VSS VSS nmos W=0.155u L=0.04u
M27865 n2274 U3015/net28 VSS VSS nmos W=0.155u L=0.04u
M27866 U3015/net32 WX2014 VSS VSS nmos W=0.155u L=0.04u
M27867 U3015/net64 U3015/net24 VSS VSS nmos W=0.2u L=0.04u
M27868 U3015/net28 U3015/net40 U3015/net64 VDD pmos W=0.205u L=0.04u
M27869 U3015/net24 WX2078 U3015/net32 VDD pmos W=0.205u L=0.04u
M27870 U3015/net28 U3015/net20 U3015/net24 VDD pmos W=0.205u L=0.04u
M27871 U3015/net40 U3015/net106 U3015/net108 VDD pmos W=0.205u L=0.04u
M27872 U3015/net40 n2275 U3015/net104 VDD pmos W=0.205u L=0.04u
M27873 U3015/net20 U3015/net40 VDD VDD pmos W=0.205u L=0.04u
M27874 U3015/net106 n2275 VDD VDD pmos W=0.205u L=0.04u
M27875 U3015/net104 WX2142 VDD VDD pmos W=0.205u L=0.04u
M27876 U3015/net30 WX2078 VDD VDD pmos W=0.205u L=0.04u
M27877 U3015/net108 U3015/net104 VDD VDD pmos W=0.205u L=0.04u
M27878 n2274 U3015/net28 VDD VDD pmos W=0.205u L=0.04u
M27879 U3015/net32 WX2014 VDD VDD pmos W=0.205u L=0.04u
M27880 U3015/net64 U3015/net24 VDD VDD pmos W=0.28u L=0.04u
M27881 U3015/net24 U3015/net30 U3015/net045 VDD pmos W=0.205u L=0.04u
M27882 U3015/net045 U3015/net32 VDD VDD pmos W=0.205u L=0.04u
M27883 U3016/net4 WX1950 U3016/net14 VSS nmos W=0.155u L=0.04u
M27884 U3016/net6 U3016/net10 U3016/net14 VSS nmos W=0.17u L=0.04u
M27885 U3016/net4 n1377 VSS VSS nmos W=0.155u L=0.04u
M27886 U3016/net6 U3016/net4 VSS VSS nmos W=0.17u L=0.04u
M27887 n2275 U3016/net14 VSS VSS nmos W=0.155u L=0.04u
M27888 U3016/net10 WX1950 VSS VSS nmos W=0.155u L=0.04u
M27889 U3016/net4 U3016/net10 U3016/net14 VDD pmos W=0.255u L=0.04u
M27890 U3016/net6 WX1950 U3016/net14 VDD pmos W=0.28u L=0.04u
M27891 U3016/net4 n1377 VDD VDD pmos W=0.205u L=0.04u
M27892 U3016/net6 U3016/net4 VDD VDD pmos W=0.24u L=0.04u
M27893 n2275 U3016/net14 VDD VDD pmos W=0.205u L=0.04u
M27894 U3016/net10 WX1950 VDD VDD pmos W=0.205u L=0.04u
M27895 U3017/net4 U3017/net10 U3017/net14 VSS nmos W=0.155u L=0.04u
M27896 U3017/net6 n1853 U3017/net14 VSS nmos W=0.155u L=0.04u
M27897 U3017/net4 n2276 VSS VSS nmos W=0.155u L=0.04u
M27898 U3017/net6 U3017/net4 VSS VSS nmos W=0.155u L=0.04u
M27899 WX1213 U3017/net14 VSS VSS nmos W=0.155u L=0.04u
M27900 U3017/net10 n1853 VSS VSS nmos W=0.155u L=0.04u
M27901 U3017/net4 n1853 U3017/net14 VDD pmos W=0.205u L=0.04u
M27902 U3017/net6 U3017/net10 U3017/net14 VDD pmos W=0.205u L=0.04u
M27903 U3017/net4 n2276 VDD VDD pmos W=0.205u L=0.04u
M27904 U3017/net6 U3017/net4 VDD VDD pmos W=0.205u L=0.04u
M27905 WX1213 U3017/net14 VDD VDD pmos W=0.205u L=0.04u
M27906 U3017/net10 n1853 VDD VDD pmos W=0.205u L=0.04u
M27907 U3018/XU1-net6 TM0 VSS VSS nmos W=0.155u L=0.04u
M27908 n2276 WX543 U3018/XU1-net6 VSS nmos W=0.155u L=0.04u
M27909 n2276 TM0 VDD VDD pmos W=0.155u L=0.04u
M27910 n2276 WX543 VDD VDD pmos W=0.155u L=0.04u
M27911 n1853 n2277 VSS VSS nmos W=0.135u L=0.04u
M27912 n1853 n2277 VDD VDD pmos W=0.205u L=0.04u
M27913 U3020/net28 U3020/net20 U3020/net64 VSS nmos W=0.155u L=0.04u
M27914 U3020/net24 U3020/net30 U3020/net32 VSS nmos W=0.155u L=0.04u
M27915 U3020/net28 U3020/net40 U3020/net24 VSS nmos W=0.155u L=0.04u
M27916 U3020/net40 n2278 U3020/net108 VSS nmos W=0.155u L=0.04u
M27917 U3020/net40 U3020/net106 U3020/net104 VSS nmos W=0.155u L=0.04u
M27918 U3020/net24 WX831 U3020/net050 VSS nmos W=0.155u L=0.04u
M27919 U3020/net050 U3020/net32 VSS VSS nmos W=0.155u L=0.04u
M27920 U3020/net20 U3020/net40 VSS VSS nmos W=0.155u L=0.04u
M27921 U3020/net106 n2278 VSS VSS nmos W=0.155u L=0.04u
M27922 U3020/net104 WX895 VSS VSS nmos W=0.155u L=0.04u
M27923 U3020/net30 WX831 VSS VSS nmos W=0.155u L=0.04u
M27924 U3020/net108 U3020/net104 VSS VSS nmos W=0.155u L=0.04u
M27925 n2277 U3020/net28 VSS VSS nmos W=0.155u L=0.04u
M27926 U3020/net32 WX767 VSS VSS nmos W=0.155u L=0.04u
M27927 U3020/net64 U3020/net24 VSS VSS nmos W=0.2u L=0.04u
M27928 U3020/net28 U3020/net40 U3020/net64 VDD pmos W=0.205u L=0.04u
M27929 U3020/net24 WX831 U3020/net32 VDD pmos W=0.205u L=0.04u
M27930 U3020/net28 U3020/net20 U3020/net24 VDD pmos W=0.205u L=0.04u
M27931 U3020/net40 U3020/net106 U3020/net108 VDD pmos W=0.205u L=0.04u
M27932 U3020/net40 n2278 U3020/net104 VDD pmos W=0.205u L=0.04u
M27933 U3020/net20 U3020/net40 VDD VDD pmos W=0.205u L=0.04u
M27934 U3020/net106 n2278 VDD VDD pmos W=0.205u L=0.04u
M27935 U3020/net104 WX895 VDD VDD pmos W=0.205u L=0.04u
M27936 U3020/net30 WX831 VDD VDD pmos W=0.205u L=0.04u
M27937 U3020/net108 U3020/net104 VDD VDD pmos W=0.205u L=0.04u
M27938 n2277 U3020/net28 VDD VDD pmos W=0.205u L=0.04u
M27939 U3020/net32 WX767 VDD VDD pmos W=0.205u L=0.04u
M27940 U3020/net64 U3020/net24 VDD VDD pmos W=0.28u L=0.04u
M27941 U3020/net24 U3020/net30 U3020/net045 VDD pmos W=0.205u L=0.04u
M27942 U3020/net045 U3020/net32 VDD VDD pmos W=0.205u L=0.04u
M27943 U3021/net4 U3021/net10 U3021/net14 VSS nmos W=0.155u L=0.04u
M27944 U3021/net6 WX703 U3021/net14 VSS nmos W=0.155u L=0.04u
M27945 U3021/net4 TM0 VSS VSS nmos W=0.155u L=0.04u
M27946 U3021/net6 U3021/net4 VSS VSS nmos W=0.155u L=0.04u
M27947 n2278 U3021/net14 VSS VSS nmos W=0.155u L=0.04u
M27948 U3021/net10 WX703 VSS VSS nmos W=0.155u L=0.04u
M27949 U3021/net4 WX703 U3021/net14 VDD pmos W=0.205u L=0.04u
M27950 U3021/net6 U3021/net10 U3021/net14 VDD pmos W=0.205u L=0.04u
M27951 U3021/net4 TM0 VDD VDD pmos W=0.205u L=0.04u
M27952 U3021/net6 U3021/net4 VDD VDD pmos W=0.205u L=0.04u
M27953 n2278 U3021/net14 VDD VDD pmos W=0.205u L=0.04u
M27954 U3021/net10 WX703 VDD VDD pmos W=0.205u L=0.04u
M27955 U3022/net4 U3022/net10 U3022/net14 VSS nmos W=0.155u L=0.04u
M27956 U3022/net6 n1867 U3022/net14 VSS nmos W=0.155u L=0.04u
M27957 U3022/net4 n2279 VSS VSS nmos W=0.155u L=0.04u
M27958 U3022/net6 U3022/net4 VSS VSS nmos W=0.155u L=0.04u
M27959 WX1206 U3022/net14 VSS VSS nmos W=0.155u L=0.04u
M27960 U3022/net10 n1867 VSS VSS nmos W=0.155u L=0.04u
M27961 U3022/net4 n1867 U3022/net14 VDD pmos W=0.205u L=0.04u
M27962 U3022/net6 U3022/net10 U3022/net14 VDD pmos W=0.205u L=0.04u
M27963 U3022/net4 n2279 VDD VDD pmos W=0.205u L=0.04u
M27964 U3022/net6 U3022/net4 VDD VDD pmos W=0.205u L=0.04u
M27965 WX1206 U3022/net14 VDD VDD pmos W=0.205u L=0.04u
M27966 U3022/net10 n1867 VDD VDD pmos W=0.205u L=0.04u
M27967 U3023/XU1-net6 TM0 VSS VSS nmos W=0.155u L=0.04u
M27968 n2279 WX541 U3023/XU1-net6 VSS nmos W=0.155u L=0.04u
M27969 n2279 TM0 VDD VDD pmos W=0.155u L=0.04u
M27970 n2279 WX541 VDD VDD pmos W=0.155u L=0.04u
M27971 n1867 n2280 VSS VSS nmos W=0.135u L=0.04u
M27972 n1867 n2280 VDD VDD pmos W=0.205u L=0.04u
M27973 U3025/net28 U3025/net20 U3025/net64 VSS nmos W=0.155u L=0.04u
M27974 U3025/net24 U3025/net30 U3025/net32 VSS nmos W=0.155u L=0.04u
M27975 U3025/net28 U3025/net40 U3025/net24 VSS nmos W=0.155u L=0.04u
M27976 U3025/net40 n2281 U3025/net108 VSS nmos W=0.155u L=0.04u
M27977 U3025/net40 U3025/net106 U3025/net104 VSS nmos W=0.155u L=0.04u
M27978 U3025/net24 WX829 U3025/net050 VSS nmos W=0.155u L=0.04u
M27979 U3025/net050 U3025/net32 VSS VSS nmos W=0.155u L=0.04u
M27980 U3025/net20 U3025/net40 VSS VSS nmos W=0.155u L=0.04u
M27981 U3025/net106 n2281 VSS VSS nmos W=0.155u L=0.04u
M27982 U3025/net104 WX893 VSS VSS nmos W=0.155u L=0.04u
M27983 U3025/net30 WX829 VSS VSS nmos W=0.155u L=0.04u
M27984 U3025/net108 U3025/net104 VSS VSS nmos W=0.155u L=0.04u
M27985 n2280 U3025/net28 VSS VSS nmos W=0.155u L=0.04u
M27986 U3025/net32 WX765 VSS VSS nmos W=0.155u L=0.04u
M27987 U3025/net64 U3025/net24 VSS VSS nmos W=0.2u L=0.04u
M27988 U3025/net28 U3025/net40 U3025/net64 VDD pmos W=0.205u L=0.04u
M27989 U3025/net24 WX829 U3025/net32 VDD pmos W=0.205u L=0.04u
M27990 U3025/net28 U3025/net20 U3025/net24 VDD pmos W=0.205u L=0.04u
M27991 U3025/net40 U3025/net106 U3025/net108 VDD pmos W=0.205u L=0.04u
M27992 U3025/net40 n2281 U3025/net104 VDD pmos W=0.205u L=0.04u
M27993 U3025/net20 U3025/net40 VDD VDD pmos W=0.205u L=0.04u
M27994 U3025/net106 n2281 VDD VDD pmos W=0.205u L=0.04u
M27995 U3025/net104 WX893 VDD VDD pmos W=0.205u L=0.04u
M27996 U3025/net30 WX829 VDD VDD pmos W=0.205u L=0.04u
M27997 U3025/net108 U3025/net104 VDD VDD pmos W=0.205u L=0.04u
M27998 n2280 U3025/net28 VDD VDD pmos W=0.205u L=0.04u
M27999 U3025/net32 WX765 VDD VDD pmos W=0.205u L=0.04u
M28000 U3025/net64 U3025/net24 VDD VDD pmos W=0.28u L=0.04u
M28001 U3025/net24 U3025/net30 U3025/net045 VDD pmos W=0.205u L=0.04u
M28002 U3025/net045 U3025/net32 VDD VDD pmos W=0.205u L=0.04u
M28003 U3026/net4 U3026/net10 U3026/net14 VSS nmos W=0.155u L=0.04u
M28004 U3026/net6 WX701 U3026/net14 VSS nmos W=0.155u L=0.04u
M28005 U3026/net4 TM0 VSS VSS nmos W=0.155u L=0.04u
M28006 U3026/net6 U3026/net4 VSS VSS nmos W=0.155u L=0.04u
M28007 n2281 U3026/net14 VSS VSS nmos W=0.155u L=0.04u
M28008 U3026/net10 WX701 VSS VSS nmos W=0.155u L=0.04u
M28009 U3026/net4 WX701 U3026/net14 VDD pmos W=0.205u L=0.04u
M28010 U3026/net6 U3026/net10 U3026/net14 VDD pmos W=0.205u L=0.04u
M28011 U3026/net4 TM0 VDD VDD pmos W=0.205u L=0.04u
M28012 U3026/net6 U3026/net4 VDD VDD pmos W=0.205u L=0.04u
M28013 n2281 U3026/net14 VDD VDD pmos W=0.205u L=0.04u
M28014 U3026/net10 WX701 VDD VDD pmos W=0.205u L=0.04u
M28015 U3027/net4 U3027/net10 U3027/net14 VSS nmos W=0.155u L=0.04u
M28016 U3027/net6 n1900 U3027/net14 VSS nmos W=0.155u L=0.04u
M28017 U3027/net4 n2282 VSS VSS nmos W=0.155u L=0.04u
M28018 U3027/net6 U3027/net4 VSS VSS nmos W=0.155u L=0.04u
M28019 WX1199 U3027/net14 VSS VSS nmos W=0.155u L=0.04u
M28020 U3027/net10 n1900 VSS VSS nmos W=0.155u L=0.04u
M28021 U3027/net4 n1900 U3027/net14 VDD pmos W=0.205u L=0.04u
M28022 U3027/net6 U3027/net10 U3027/net14 VDD pmos W=0.205u L=0.04u
M28023 U3027/net4 n2282 VDD VDD pmos W=0.205u L=0.04u
M28024 U3027/net6 U3027/net4 VDD VDD pmos W=0.205u L=0.04u
M28025 WX1199 U3027/net14 VDD VDD pmos W=0.205u L=0.04u
M28026 U3027/net10 n1900 VDD VDD pmos W=0.205u L=0.04u
M28027 U3028/XU1-net6 TM0 VSS VSS nmos W=0.155u L=0.04u
M28028 n2282 WX539 U3028/XU1-net6 VSS nmos W=0.155u L=0.04u
M28029 n2282 TM0 VDD VDD pmos W=0.155u L=0.04u
M28030 n2282 WX539 VDD VDD pmos W=0.155u L=0.04u
M28031 n1900 n2283 VSS VSS nmos W=0.135u L=0.04u
M28032 n1900 n2283 VDD VDD pmos W=0.205u L=0.04u
M28033 U3030/net28 U3030/net20 U3030/net64 VSS nmos W=0.155u L=0.04u
M28034 U3030/net24 U3030/net30 U3030/net32 VSS nmos W=0.155u L=0.04u
M28035 U3030/net28 U3030/net40 U3030/net24 VSS nmos W=0.155u L=0.04u
M28036 U3030/net40 n2284 U3030/net108 VSS nmos W=0.155u L=0.04u
M28037 U3030/net40 U3030/net106 U3030/net104 VSS nmos W=0.155u L=0.04u
M28038 U3030/net24 WX827 U3030/net050 VSS nmos W=0.155u L=0.04u
M28039 U3030/net050 U3030/net32 VSS VSS nmos W=0.155u L=0.04u
M28040 U3030/net20 U3030/net40 VSS VSS nmos W=0.155u L=0.04u
M28041 U3030/net106 n2284 VSS VSS nmos W=0.155u L=0.04u
M28042 U3030/net104 WX891 VSS VSS nmos W=0.155u L=0.04u
M28043 U3030/net30 WX827 VSS VSS nmos W=0.155u L=0.04u
M28044 U3030/net108 U3030/net104 VSS VSS nmos W=0.155u L=0.04u
M28045 n2283 U3030/net28 VSS VSS nmos W=0.155u L=0.04u
M28046 U3030/net32 WX763 VSS VSS nmos W=0.155u L=0.04u
M28047 U3030/net64 U3030/net24 VSS VSS nmos W=0.2u L=0.04u
M28048 U3030/net28 U3030/net40 U3030/net64 VDD pmos W=0.205u L=0.04u
M28049 U3030/net24 WX827 U3030/net32 VDD pmos W=0.205u L=0.04u
M28050 U3030/net28 U3030/net20 U3030/net24 VDD pmos W=0.205u L=0.04u
M28051 U3030/net40 U3030/net106 U3030/net108 VDD pmos W=0.205u L=0.04u
M28052 U3030/net40 n2284 U3030/net104 VDD pmos W=0.205u L=0.04u
M28053 U3030/net20 U3030/net40 VDD VDD pmos W=0.205u L=0.04u
M28054 U3030/net106 n2284 VDD VDD pmos W=0.205u L=0.04u
M28055 U3030/net104 WX891 VDD VDD pmos W=0.205u L=0.04u
M28056 U3030/net30 WX827 VDD VDD pmos W=0.205u L=0.04u
M28057 U3030/net108 U3030/net104 VDD VDD pmos W=0.205u L=0.04u
M28058 n2283 U3030/net28 VDD VDD pmos W=0.205u L=0.04u
M28059 U3030/net32 WX763 VDD VDD pmos W=0.205u L=0.04u
M28060 U3030/net64 U3030/net24 VDD VDD pmos W=0.28u L=0.04u
M28061 U3030/net24 U3030/net30 U3030/net045 VDD pmos W=0.205u L=0.04u
M28062 U3030/net045 U3030/net32 VDD VDD pmos W=0.205u L=0.04u
M28063 U3031/net4 U3031/net10 U3031/net14 VSS nmos W=0.155u L=0.04u
M28064 U3031/net6 WX699 U3031/net14 VSS nmos W=0.155u L=0.04u
M28065 U3031/net4 TM0 VSS VSS nmos W=0.155u L=0.04u
M28066 U3031/net6 U3031/net4 VSS VSS nmos W=0.155u L=0.04u
M28067 n2284 U3031/net14 VSS VSS nmos W=0.155u L=0.04u
M28068 U3031/net10 WX699 VSS VSS nmos W=0.155u L=0.04u
M28069 U3031/net4 WX699 U3031/net14 VDD pmos W=0.205u L=0.04u
M28070 U3031/net6 U3031/net10 U3031/net14 VDD pmos W=0.205u L=0.04u
M28071 U3031/net4 TM0 VDD VDD pmos W=0.205u L=0.04u
M28072 U3031/net6 U3031/net4 VDD VDD pmos W=0.205u L=0.04u
M28073 n2284 U3031/net14 VDD VDD pmos W=0.205u L=0.04u
M28074 U3031/net10 WX699 VDD VDD pmos W=0.205u L=0.04u
M28075 U3032/net4 U3032/net10 U3032/net14 VSS nmos W=0.155u L=0.04u
M28076 U3032/net6 n1941 U3032/net14 VSS nmos W=0.155u L=0.04u
M28077 U3032/net4 n2285 VSS VSS nmos W=0.155u L=0.04u
M28078 U3032/net6 U3032/net4 VSS VSS nmos W=0.155u L=0.04u
M28079 WX1192 U3032/net14 VSS VSS nmos W=0.155u L=0.04u
M28080 U3032/net10 n1941 VSS VSS nmos W=0.155u L=0.04u
M28081 U3032/net4 n1941 U3032/net14 VDD pmos W=0.205u L=0.04u
M28082 U3032/net6 U3032/net10 U3032/net14 VDD pmos W=0.205u L=0.04u
M28083 U3032/net4 n2285 VDD VDD pmos W=0.205u L=0.04u
M28084 U3032/net6 U3032/net4 VDD VDD pmos W=0.205u L=0.04u
M28085 WX1192 U3032/net14 VDD VDD pmos W=0.205u L=0.04u
M28086 U3032/net10 n1941 VDD VDD pmos W=0.205u L=0.04u
M28087 U3033/XU1-net6 TM0 VSS VSS nmos W=0.155u L=0.04u
M28088 n2285 WX537 U3033/XU1-net6 VSS nmos W=0.155u L=0.04u
M28089 n2285 TM0 VDD VDD pmos W=0.155u L=0.04u
M28090 n2285 WX537 VDD VDD pmos W=0.155u L=0.04u
M28091 n1941 n2286 VSS VSS nmos W=0.135u L=0.04u
M28092 n1941 n2286 VDD VDD pmos W=0.205u L=0.04u
M28093 U3035/net28 U3035/net20 U3035/net64 VSS nmos W=0.155u L=0.04u
M28094 U3035/net24 U3035/net30 U3035/net32 VSS nmos W=0.155u L=0.04u
M28095 U3035/net28 U3035/net40 U3035/net24 VSS nmos W=0.155u L=0.04u
M28096 U3035/net40 n2287 U3035/net108 VSS nmos W=0.155u L=0.04u
M28097 U3035/net40 U3035/net106 U3035/net104 VSS nmos W=0.155u L=0.04u
M28098 U3035/net24 WX825 U3035/net050 VSS nmos W=0.155u L=0.04u
M28099 U3035/net050 U3035/net32 VSS VSS nmos W=0.155u L=0.04u
M28100 U3035/net20 U3035/net40 VSS VSS nmos W=0.155u L=0.04u
M28101 U3035/net106 n2287 VSS VSS nmos W=0.155u L=0.04u
M28102 U3035/net104 WX889 VSS VSS nmos W=0.155u L=0.04u
M28103 U3035/net30 WX825 VSS VSS nmos W=0.155u L=0.04u
M28104 U3035/net108 U3035/net104 VSS VSS nmos W=0.155u L=0.04u
M28105 n2286 U3035/net28 VSS VSS nmos W=0.155u L=0.04u
M28106 U3035/net32 WX761 VSS VSS nmos W=0.155u L=0.04u
M28107 U3035/net64 U3035/net24 VSS VSS nmos W=0.2u L=0.04u
M28108 U3035/net28 U3035/net40 U3035/net64 VDD pmos W=0.205u L=0.04u
M28109 U3035/net24 WX825 U3035/net32 VDD pmos W=0.205u L=0.04u
M28110 U3035/net28 U3035/net20 U3035/net24 VDD pmos W=0.205u L=0.04u
M28111 U3035/net40 U3035/net106 U3035/net108 VDD pmos W=0.205u L=0.04u
M28112 U3035/net40 n2287 U3035/net104 VDD pmos W=0.205u L=0.04u
M28113 U3035/net20 U3035/net40 VDD VDD pmos W=0.205u L=0.04u
M28114 U3035/net106 n2287 VDD VDD pmos W=0.205u L=0.04u
M28115 U3035/net104 WX889 VDD VDD pmos W=0.205u L=0.04u
M28116 U3035/net30 WX825 VDD VDD pmos W=0.205u L=0.04u
M28117 U3035/net108 U3035/net104 VDD VDD pmos W=0.205u L=0.04u
M28118 n2286 U3035/net28 VDD VDD pmos W=0.205u L=0.04u
M28119 U3035/net32 WX761 VDD VDD pmos W=0.205u L=0.04u
M28120 U3035/net64 U3035/net24 VDD VDD pmos W=0.28u L=0.04u
M28121 U3035/net24 U3035/net30 U3035/net045 VDD pmos W=0.205u L=0.04u
M28122 U3035/net045 U3035/net32 VDD VDD pmos W=0.205u L=0.04u
M28123 U3036/net4 U3036/net10 U3036/net14 VSS nmos W=0.155u L=0.04u
M28124 U3036/net6 WX697 U3036/net14 VSS nmos W=0.155u L=0.04u
M28125 U3036/net4 TM0 VSS VSS nmos W=0.155u L=0.04u
M28126 U3036/net6 U3036/net4 VSS VSS nmos W=0.155u L=0.04u
M28127 n2287 U3036/net14 VSS VSS nmos W=0.155u L=0.04u
M28128 U3036/net10 WX697 VSS VSS nmos W=0.155u L=0.04u
M28129 U3036/net4 WX697 U3036/net14 VDD pmos W=0.205u L=0.04u
M28130 U3036/net6 U3036/net10 U3036/net14 VDD pmos W=0.205u L=0.04u
M28131 U3036/net4 TM0 VDD VDD pmos W=0.205u L=0.04u
M28132 U3036/net6 U3036/net4 VDD VDD pmos W=0.205u L=0.04u
M28133 n2287 U3036/net14 VDD VDD pmos W=0.205u L=0.04u
M28134 U3036/net10 WX697 VDD VDD pmos W=0.205u L=0.04u
M28135 U3037/net4 U3037/net10 U3037/net14 VSS nmos W=0.155u L=0.04u
M28136 U3037/net6 n1975 U3037/net14 VSS nmos W=0.155u L=0.04u
M28137 U3037/net4 n2288 VSS VSS nmos W=0.155u L=0.04u
M28138 U3037/net6 U3037/net4 VSS VSS nmos W=0.155u L=0.04u
M28139 WX1185 U3037/net14 VSS VSS nmos W=0.155u L=0.04u
M28140 U3037/net10 n1975 VSS VSS nmos W=0.155u L=0.04u
M28141 U3037/net4 n1975 U3037/net14 VDD pmos W=0.205u L=0.04u
M28142 U3037/net6 U3037/net10 U3037/net14 VDD pmos W=0.205u L=0.04u
M28143 U3037/net4 n2288 VDD VDD pmos W=0.205u L=0.04u
M28144 U3037/net6 U3037/net4 VDD VDD pmos W=0.205u L=0.04u
M28145 WX1185 U3037/net14 VDD VDD pmos W=0.205u L=0.04u
M28146 U3037/net10 n1975 VDD VDD pmos W=0.205u L=0.04u
M28147 U3038/XU1-net6 TM0 VSS VSS nmos W=0.155u L=0.04u
M28148 n2288 WX535 U3038/XU1-net6 VSS nmos W=0.155u L=0.04u
M28149 n2288 TM0 VDD VDD pmos W=0.155u L=0.04u
M28150 n2288 WX535 VDD VDD pmos W=0.155u L=0.04u
M28151 n1975 n2289 VSS VSS nmos W=0.135u L=0.04u
M28152 n1975 n2289 VDD VDD pmos W=0.205u L=0.04u
M28153 U3040/net28 U3040/net20 U3040/net64 VSS nmos W=0.155u L=0.04u
M28154 U3040/net24 U3040/net30 U3040/net32 VSS nmos W=0.155u L=0.04u
M28155 U3040/net28 U3040/net40 U3040/net24 VSS nmos W=0.155u L=0.04u
M28156 U3040/net40 n2290 U3040/net108 VSS nmos W=0.155u L=0.04u
M28157 U3040/net40 U3040/net106 U3040/net104 VSS nmos W=0.155u L=0.04u
M28158 U3040/net24 WX823 U3040/net050 VSS nmos W=0.155u L=0.04u
M28159 U3040/net050 U3040/net32 VSS VSS nmos W=0.155u L=0.04u
M28160 U3040/net20 U3040/net40 VSS VSS nmos W=0.155u L=0.04u
M28161 U3040/net106 n2290 VSS VSS nmos W=0.155u L=0.04u
M28162 U3040/net104 WX887 VSS VSS nmos W=0.155u L=0.04u
M28163 U3040/net30 WX823 VSS VSS nmos W=0.155u L=0.04u
M28164 U3040/net108 U3040/net104 VSS VSS nmos W=0.155u L=0.04u
M28165 n2289 U3040/net28 VSS VSS nmos W=0.155u L=0.04u
M28166 U3040/net32 WX759 VSS VSS nmos W=0.155u L=0.04u
M28167 U3040/net64 U3040/net24 VSS VSS nmos W=0.2u L=0.04u
M28168 U3040/net28 U3040/net40 U3040/net64 VDD pmos W=0.205u L=0.04u
M28169 U3040/net24 WX823 U3040/net32 VDD pmos W=0.205u L=0.04u
M28170 U3040/net28 U3040/net20 U3040/net24 VDD pmos W=0.205u L=0.04u
M28171 U3040/net40 U3040/net106 U3040/net108 VDD pmos W=0.205u L=0.04u
M28172 U3040/net40 n2290 U3040/net104 VDD pmos W=0.205u L=0.04u
M28173 U3040/net20 U3040/net40 VDD VDD pmos W=0.205u L=0.04u
M28174 U3040/net106 n2290 VDD VDD pmos W=0.205u L=0.04u
M28175 U3040/net104 WX887 VDD VDD pmos W=0.205u L=0.04u
M28176 U3040/net30 WX823 VDD VDD pmos W=0.205u L=0.04u
M28177 U3040/net108 U3040/net104 VDD VDD pmos W=0.205u L=0.04u
M28178 n2289 U3040/net28 VDD VDD pmos W=0.205u L=0.04u
M28179 U3040/net32 WX759 VDD VDD pmos W=0.205u L=0.04u
M28180 U3040/net64 U3040/net24 VDD VDD pmos W=0.28u L=0.04u
M28181 U3040/net24 U3040/net30 U3040/net045 VDD pmos W=0.205u L=0.04u
M28182 U3040/net045 U3040/net32 VDD VDD pmos W=0.205u L=0.04u
M28183 U3041/net4 U3041/net10 U3041/net14 VSS nmos W=0.155u L=0.04u
M28184 U3041/net6 WX695 U3041/net14 VSS nmos W=0.155u L=0.04u
M28185 U3041/net4 TM0 VSS VSS nmos W=0.155u L=0.04u
M28186 U3041/net6 U3041/net4 VSS VSS nmos W=0.155u L=0.04u
M28187 n2290 U3041/net14 VSS VSS nmos W=0.155u L=0.04u
M28188 U3041/net10 WX695 VSS VSS nmos W=0.155u L=0.04u
M28189 U3041/net4 WX695 U3041/net14 VDD pmos W=0.205u L=0.04u
M28190 U3041/net6 U3041/net10 U3041/net14 VDD pmos W=0.205u L=0.04u
M28191 U3041/net4 TM0 VDD VDD pmos W=0.205u L=0.04u
M28192 U3041/net6 U3041/net4 VDD VDD pmos W=0.205u L=0.04u
M28193 n2290 U3041/net14 VDD VDD pmos W=0.205u L=0.04u
M28194 U3041/net10 WX695 VDD VDD pmos W=0.205u L=0.04u
M28195 U3042/net4 U3042/net10 U3042/net14 VSS nmos W=0.155u L=0.04u
M28196 U3042/net6 n1981 U3042/net14 VSS nmos W=0.155u L=0.04u
M28197 U3042/net4 n2291 VSS VSS nmos W=0.155u L=0.04u
M28198 U3042/net6 U3042/net4 VSS VSS nmos W=0.155u L=0.04u
M28199 WX1178 U3042/net14 VSS VSS nmos W=0.155u L=0.04u
M28200 U3042/net10 n1981 VSS VSS nmos W=0.155u L=0.04u
M28201 U3042/net4 n1981 U3042/net14 VDD pmos W=0.205u L=0.04u
M28202 U3042/net6 U3042/net10 U3042/net14 VDD pmos W=0.205u L=0.04u
M28203 U3042/net4 n2291 VDD VDD pmos W=0.205u L=0.04u
M28204 U3042/net6 U3042/net4 VDD VDD pmos W=0.205u L=0.04u
M28205 WX1178 U3042/net14 VDD VDD pmos W=0.205u L=0.04u
M28206 U3042/net10 n1981 VDD VDD pmos W=0.205u L=0.04u
M28207 U3043/XU1-net6 TM0 VSS VSS nmos W=0.155u L=0.04u
M28208 n2291 WX533 U3043/XU1-net6 VSS nmos W=0.155u L=0.04u
M28209 n2291 TM0 VDD VDD pmos W=0.155u L=0.04u
M28210 n2291 WX533 VDD VDD pmos W=0.155u L=0.04u
M28211 n1981 n2292 VSS VSS nmos W=0.135u L=0.04u
M28212 n1981 n2292 VDD VDD pmos W=0.205u L=0.04u
M28213 U3045/net28 U3045/net20 U3045/net64 VSS nmos W=0.155u L=0.04u
M28214 U3045/net24 U3045/net30 U3045/net32 VSS nmos W=0.155u L=0.04u
M28215 U3045/net28 U3045/net40 U3045/net24 VSS nmos W=0.155u L=0.04u
M28216 U3045/net40 n2293 U3045/net108 VSS nmos W=0.155u L=0.04u
M28217 U3045/net40 U3045/net106 U3045/net104 VSS nmos W=0.155u L=0.04u
M28218 U3045/net24 WX821 U3045/net050 VSS nmos W=0.155u L=0.04u
M28219 U3045/net050 U3045/net32 VSS VSS nmos W=0.155u L=0.04u
M28220 U3045/net20 U3045/net40 VSS VSS nmos W=0.155u L=0.04u
M28221 U3045/net106 n2293 VSS VSS nmos W=0.155u L=0.04u
M28222 U3045/net104 WX885 VSS VSS nmos W=0.155u L=0.04u
M28223 U3045/net30 WX821 VSS VSS nmos W=0.155u L=0.04u
M28224 U3045/net108 U3045/net104 VSS VSS nmos W=0.155u L=0.04u
M28225 n2292 U3045/net28 VSS VSS nmos W=0.155u L=0.04u
M28226 U3045/net32 WX757 VSS VSS nmos W=0.155u L=0.04u
M28227 U3045/net64 U3045/net24 VSS VSS nmos W=0.2u L=0.04u
M28228 U3045/net28 U3045/net40 U3045/net64 VDD pmos W=0.205u L=0.04u
M28229 U3045/net24 WX821 U3045/net32 VDD pmos W=0.205u L=0.04u
M28230 U3045/net28 U3045/net20 U3045/net24 VDD pmos W=0.205u L=0.04u
M28231 U3045/net40 U3045/net106 U3045/net108 VDD pmos W=0.205u L=0.04u
M28232 U3045/net40 n2293 U3045/net104 VDD pmos W=0.205u L=0.04u
M28233 U3045/net20 U3045/net40 VDD VDD pmos W=0.205u L=0.04u
M28234 U3045/net106 n2293 VDD VDD pmos W=0.205u L=0.04u
M28235 U3045/net104 WX885 VDD VDD pmos W=0.205u L=0.04u
M28236 U3045/net30 WX821 VDD VDD pmos W=0.205u L=0.04u
M28237 U3045/net108 U3045/net104 VDD VDD pmos W=0.205u L=0.04u
M28238 n2292 U3045/net28 VDD VDD pmos W=0.205u L=0.04u
M28239 U3045/net32 WX757 VDD VDD pmos W=0.205u L=0.04u
M28240 U3045/net64 U3045/net24 VDD VDD pmos W=0.28u L=0.04u
M28241 U3045/net24 U3045/net30 U3045/net045 VDD pmos W=0.205u L=0.04u
M28242 U3045/net045 U3045/net32 VDD VDD pmos W=0.205u L=0.04u
M28243 U3046/net4 U3046/net10 U3046/net14 VSS nmos W=0.155u L=0.04u
M28244 U3046/net6 WX693 U3046/net14 VSS nmos W=0.155u L=0.04u
M28245 U3046/net4 TM0 VSS VSS nmos W=0.155u L=0.04u
M28246 U3046/net6 U3046/net4 VSS VSS nmos W=0.155u L=0.04u
M28247 n2293 U3046/net14 VSS VSS nmos W=0.155u L=0.04u
M28248 U3046/net10 WX693 VSS VSS nmos W=0.155u L=0.04u
M28249 U3046/net4 WX693 U3046/net14 VDD pmos W=0.205u L=0.04u
M28250 U3046/net6 U3046/net10 U3046/net14 VDD pmos W=0.205u L=0.04u
M28251 U3046/net4 TM0 VDD VDD pmos W=0.205u L=0.04u
M28252 U3046/net6 U3046/net4 VDD VDD pmos W=0.205u L=0.04u
M28253 n2293 U3046/net14 VDD VDD pmos W=0.205u L=0.04u
M28254 U3046/net10 WX693 VDD VDD pmos W=0.205u L=0.04u
M28255 U3047/net4 U3047/net10 U3047/net14 VSS nmos W=0.155u L=0.04u
M28256 U3047/net6 n1984 U3047/net14 VSS nmos W=0.155u L=0.04u
M28257 U3047/net4 n2294 VSS VSS nmos W=0.155u L=0.04u
M28258 U3047/net6 U3047/net4 VSS VSS nmos W=0.155u L=0.04u
M28259 WX1171 U3047/net14 VSS VSS nmos W=0.155u L=0.04u
M28260 U3047/net10 n1984 VSS VSS nmos W=0.155u L=0.04u
M28261 U3047/net4 n1984 U3047/net14 VDD pmos W=0.205u L=0.04u
M28262 U3047/net6 U3047/net10 U3047/net14 VDD pmos W=0.205u L=0.04u
M28263 U3047/net4 n2294 VDD VDD pmos W=0.205u L=0.04u
M28264 U3047/net6 U3047/net4 VDD VDD pmos W=0.205u L=0.04u
M28265 WX1171 U3047/net14 VDD VDD pmos W=0.205u L=0.04u
M28266 U3047/net10 n1984 VDD VDD pmos W=0.205u L=0.04u
M28267 U3048/XU1-net6 TM0 VSS VSS nmos W=0.155u L=0.04u
M28268 n2294 WX531 U3048/XU1-net6 VSS nmos W=0.155u L=0.04u
M28269 n2294 TM0 VDD VDD pmos W=0.155u L=0.04u
M28270 n2294 WX531 VDD VDD pmos W=0.155u L=0.04u
M28271 n1984 n2295 VSS VSS nmos W=0.135u L=0.04u
M28272 n1984 n2295 VDD VDD pmos W=0.205u L=0.04u
M28273 U3050/net28 U3050/net20 U3050/net64 VSS nmos W=0.155u L=0.04u
M28274 U3050/net24 U3050/net30 U3050/net32 VSS nmos W=0.155u L=0.04u
M28275 U3050/net28 U3050/net40 U3050/net24 VSS nmos W=0.155u L=0.04u
M28276 U3050/net40 n2296 U3050/net108 VSS nmos W=0.155u L=0.04u
M28277 U3050/net40 U3050/net106 U3050/net104 VSS nmos W=0.155u L=0.04u
M28278 U3050/net24 WX819 U3050/net050 VSS nmos W=0.155u L=0.04u
M28279 U3050/net050 U3050/net32 VSS VSS nmos W=0.155u L=0.04u
M28280 U3050/net20 U3050/net40 VSS VSS nmos W=0.155u L=0.04u
M28281 U3050/net106 n2296 VSS VSS nmos W=0.155u L=0.04u
M28282 U3050/net104 WX883 VSS VSS nmos W=0.155u L=0.04u
M28283 U3050/net30 WX819 VSS VSS nmos W=0.155u L=0.04u
M28284 U3050/net108 U3050/net104 VSS VSS nmos W=0.155u L=0.04u
M28285 n2295 U3050/net28 VSS VSS nmos W=0.155u L=0.04u
M28286 U3050/net32 WX755 VSS VSS nmos W=0.155u L=0.04u
M28287 U3050/net64 U3050/net24 VSS VSS nmos W=0.2u L=0.04u
M28288 U3050/net28 U3050/net40 U3050/net64 VDD pmos W=0.205u L=0.04u
M28289 U3050/net24 WX819 U3050/net32 VDD pmos W=0.205u L=0.04u
M28290 U3050/net28 U3050/net20 U3050/net24 VDD pmos W=0.205u L=0.04u
M28291 U3050/net40 U3050/net106 U3050/net108 VDD pmos W=0.205u L=0.04u
M28292 U3050/net40 n2296 U3050/net104 VDD pmos W=0.205u L=0.04u
M28293 U3050/net20 U3050/net40 VDD VDD pmos W=0.205u L=0.04u
M28294 U3050/net106 n2296 VDD VDD pmos W=0.205u L=0.04u
M28295 U3050/net104 WX883 VDD VDD pmos W=0.205u L=0.04u
M28296 U3050/net30 WX819 VDD VDD pmos W=0.205u L=0.04u
M28297 U3050/net108 U3050/net104 VDD VDD pmos W=0.205u L=0.04u
M28298 n2295 U3050/net28 VDD VDD pmos W=0.205u L=0.04u
M28299 U3050/net32 WX755 VDD VDD pmos W=0.205u L=0.04u
M28300 U3050/net64 U3050/net24 VDD VDD pmos W=0.28u L=0.04u
M28301 U3050/net24 U3050/net30 U3050/net045 VDD pmos W=0.205u L=0.04u
M28302 U3050/net045 U3050/net32 VDD VDD pmos W=0.205u L=0.04u
M28303 U3051/net4 U3051/net10 U3051/net14 VSS nmos W=0.155u L=0.04u
M28304 U3051/net6 WX691 U3051/net14 VSS nmos W=0.155u L=0.04u
M28305 U3051/net4 TM0 VSS VSS nmos W=0.155u L=0.04u
M28306 U3051/net6 U3051/net4 VSS VSS nmos W=0.155u L=0.04u
M28307 n2296 U3051/net14 VSS VSS nmos W=0.155u L=0.04u
M28308 U3051/net10 WX691 VSS VSS nmos W=0.155u L=0.04u
M28309 U3051/net4 WX691 U3051/net14 VDD pmos W=0.205u L=0.04u
M28310 U3051/net6 U3051/net10 U3051/net14 VDD pmos W=0.205u L=0.04u
M28311 U3051/net4 TM0 VDD VDD pmos W=0.205u L=0.04u
M28312 U3051/net6 U3051/net4 VDD VDD pmos W=0.205u L=0.04u
M28313 n2296 U3051/net14 VDD VDD pmos W=0.205u L=0.04u
M28314 U3051/net10 WX691 VDD VDD pmos W=0.205u L=0.04u
M28315 U3052/net4 U3052/net10 U3052/net14 VSS nmos W=0.155u L=0.04u
M28316 U3052/net6 n1987 U3052/net14 VSS nmos W=0.155u L=0.04u
M28317 U3052/net4 n2297 VSS VSS nmos W=0.155u L=0.04u
M28318 U3052/net6 U3052/net4 VSS VSS nmos W=0.155u L=0.04u
M28319 WX1164 U3052/net14 VSS VSS nmos W=0.155u L=0.04u
M28320 U3052/net10 n1987 VSS VSS nmos W=0.155u L=0.04u
M28321 U3052/net4 n1987 U3052/net14 VDD pmos W=0.205u L=0.04u
M28322 U3052/net6 U3052/net10 U3052/net14 VDD pmos W=0.205u L=0.04u
M28323 U3052/net4 n2297 VDD VDD pmos W=0.205u L=0.04u
M28324 U3052/net6 U3052/net4 VDD VDD pmos W=0.205u L=0.04u
M28325 WX1164 U3052/net14 VDD VDD pmos W=0.205u L=0.04u
M28326 U3052/net10 n1987 VDD VDD pmos W=0.205u L=0.04u
M28327 U3053/XU1-net6 TM0 VSS VSS nmos W=0.155u L=0.04u
M28328 n2297 WX529 U3053/XU1-net6 VSS nmos W=0.155u L=0.04u
M28329 n2297 TM0 VDD VDD pmos W=0.155u L=0.04u
M28330 n2297 WX529 VDD VDD pmos W=0.155u L=0.04u
M28331 n1987 n2298 VSS VSS nmos W=0.135u L=0.04u
M28332 n1987 n2298 VDD VDD pmos W=0.205u L=0.04u
M28333 U3055/net28 U3055/net20 U3055/net64 VSS nmos W=0.155u L=0.04u
M28334 U3055/net24 U3055/net30 U3055/net32 VSS nmos W=0.155u L=0.04u
M28335 U3055/net28 U3055/net40 U3055/net24 VSS nmos W=0.155u L=0.04u
M28336 U3055/net40 n2299 U3055/net108 VSS nmos W=0.155u L=0.04u
M28337 U3055/net40 U3055/net106 U3055/net104 VSS nmos W=0.155u L=0.04u
M28338 U3055/net24 WX817 U3055/net050 VSS nmos W=0.155u L=0.04u
M28339 U3055/net050 U3055/net32 VSS VSS nmos W=0.155u L=0.04u
M28340 U3055/net20 U3055/net40 VSS VSS nmos W=0.155u L=0.04u
M28341 U3055/net106 n2299 VSS VSS nmos W=0.155u L=0.04u
M28342 U3055/net104 WX881 VSS VSS nmos W=0.155u L=0.04u
M28343 U3055/net30 WX817 VSS VSS nmos W=0.155u L=0.04u
M28344 U3055/net108 U3055/net104 VSS VSS nmos W=0.155u L=0.04u
M28345 n2298 U3055/net28 VSS VSS nmos W=0.155u L=0.04u
M28346 U3055/net32 WX753 VSS VSS nmos W=0.155u L=0.04u
M28347 U3055/net64 U3055/net24 VSS VSS nmos W=0.2u L=0.04u
M28348 U3055/net28 U3055/net40 U3055/net64 VDD pmos W=0.205u L=0.04u
M28349 U3055/net24 WX817 U3055/net32 VDD pmos W=0.205u L=0.04u
M28350 U3055/net28 U3055/net20 U3055/net24 VDD pmos W=0.205u L=0.04u
M28351 U3055/net40 U3055/net106 U3055/net108 VDD pmos W=0.205u L=0.04u
M28352 U3055/net40 n2299 U3055/net104 VDD pmos W=0.205u L=0.04u
M28353 U3055/net20 U3055/net40 VDD VDD pmos W=0.205u L=0.04u
M28354 U3055/net106 n2299 VDD VDD pmos W=0.205u L=0.04u
M28355 U3055/net104 WX881 VDD VDD pmos W=0.205u L=0.04u
M28356 U3055/net30 WX817 VDD VDD pmos W=0.205u L=0.04u
M28357 U3055/net108 U3055/net104 VDD VDD pmos W=0.205u L=0.04u
M28358 n2298 U3055/net28 VDD VDD pmos W=0.205u L=0.04u
M28359 U3055/net32 WX753 VDD VDD pmos W=0.205u L=0.04u
M28360 U3055/net64 U3055/net24 VDD VDD pmos W=0.28u L=0.04u
M28361 U3055/net24 U3055/net30 U3055/net045 VDD pmos W=0.205u L=0.04u
M28362 U3055/net045 U3055/net32 VDD VDD pmos W=0.205u L=0.04u
M28363 U3056/net4 U3056/net10 U3056/net14 VSS nmos W=0.155u L=0.04u
M28364 U3056/net6 WX689 U3056/net14 VSS nmos W=0.155u L=0.04u
M28365 U3056/net4 TM0 VSS VSS nmos W=0.155u L=0.04u
M28366 U3056/net6 U3056/net4 VSS VSS nmos W=0.155u L=0.04u
M28367 n2299 U3056/net14 VSS VSS nmos W=0.155u L=0.04u
M28368 U3056/net10 WX689 VSS VSS nmos W=0.155u L=0.04u
M28369 U3056/net4 WX689 U3056/net14 VDD pmos W=0.205u L=0.04u
M28370 U3056/net6 U3056/net10 U3056/net14 VDD pmos W=0.205u L=0.04u
M28371 U3056/net4 TM0 VDD VDD pmos W=0.205u L=0.04u
M28372 U3056/net6 U3056/net4 VDD VDD pmos W=0.205u L=0.04u
M28373 n2299 U3056/net14 VDD VDD pmos W=0.205u L=0.04u
M28374 U3056/net10 WX689 VDD VDD pmos W=0.205u L=0.04u
M28375 U3057/net4 U3057/net10 U3057/net14 VSS nmos W=0.155u L=0.04u
M28376 U3057/net6 n1990 U3057/net14 VSS nmos W=0.155u L=0.04u
M28377 U3057/net4 n2300 VSS VSS nmos W=0.155u L=0.04u
M28378 U3057/net6 U3057/net4 VSS VSS nmos W=0.155u L=0.04u
M28379 WX1157 U3057/net14 VSS VSS nmos W=0.155u L=0.04u
M28380 U3057/net10 n1990 VSS VSS nmos W=0.155u L=0.04u
M28381 U3057/net4 n1990 U3057/net14 VDD pmos W=0.205u L=0.04u
M28382 U3057/net6 U3057/net10 U3057/net14 VDD pmos W=0.205u L=0.04u
M28383 U3057/net4 n2300 VDD VDD pmos W=0.205u L=0.04u
M28384 U3057/net6 U3057/net4 VDD VDD pmos W=0.205u L=0.04u
M28385 WX1157 U3057/net14 VDD VDD pmos W=0.205u L=0.04u
M28386 U3057/net10 n1990 VDD VDD pmos W=0.205u L=0.04u
M28387 U3058/XU1-net6 TM0 VSS VSS nmos W=0.155u L=0.04u
M28388 n2300 WX527 U3058/XU1-net6 VSS nmos W=0.155u L=0.04u
M28389 n2300 TM0 VDD VDD pmos W=0.155u L=0.04u
M28390 n2300 WX527 VDD VDD pmos W=0.155u L=0.04u
M28391 n1990 n2301 VSS VSS nmos W=0.135u L=0.04u
M28392 n1990 n2301 VDD VDD pmos W=0.205u L=0.04u
M28393 U3060/net28 U3060/net20 U3060/net64 VSS nmos W=0.155u L=0.04u
M28394 U3060/net24 U3060/net30 U3060/net32 VSS nmos W=0.155u L=0.04u
M28395 U3060/net28 U3060/net40 U3060/net24 VSS nmos W=0.155u L=0.04u
M28396 U3060/net40 n2302 U3060/net108 VSS nmos W=0.155u L=0.04u
M28397 U3060/net40 U3060/net106 U3060/net104 VSS nmos W=0.155u L=0.04u
M28398 U3060/net24 WX815 U3060/net050 VSS nmos W=0.155u L=0.04u
M28399 U3060/net050 U3060/net32 VSS VSS nmos W=0.155u L=0.04u
M28400 U3060/net20 U3060/net40 VSS VSS nmos W=0.155u L=0.04u
M28401 U3060/net106 n2302 VSS VSS nmos W=0.155u L=0.04u
M28402 U3060/net104 WX879 VSS VSS nmos W=0.155u L=0.04u
M28403 U3060/net30 WX815 VSS VSS nmos W=0.155u L=0.04u
M28404 U3060/net108 U3060/net104 VSS VSS nmos W=0.155u L=0.04u
M28405 n2301 U3060/net28 VSS VSS nmos W=0.155u L=0.04u
M28406 U3060/net32 WX751 VSS VSS nmos W=0.155u L=0.04u
M28407 U3060/net64 U3060/net24 VSS VSS nmos W=0.2u L=0.04u
M28408 U3060/net28 U3060/net40 U3060/net64 VDD pmos W=0.205u L=0.04u
M28409 U3060/net24 WX815 U3060/net32 VDD pmos W=0.205u L=0.04u
M28410 U3060/net28 U3060/net20 U3060/net24 VDD pmos W=0.205u L=0.04u
M28411 U3060/net40 U3060/net106 U3060/net108 VDD pmos W=0.205u L=0.04u
M28412 U3060/net40 n2302 U3060/net104 VDD pmos W=0.205u L=0.04u
M28413 U3060/net20 U3060/net40 VDD VDD pmos W=0.205u L=0.04u
M28414 U3060/net106 n2302 VDD VDD pmos W=0.205u L=0.04u
M28415 U3060/net104 WX879 VDD VDD pmos W=0.205u L=0.04u
M28416 U3060/net30 WX815 VDD VDD pmos W=0.205u L=0.04u
M28417 U3060/net108 U3060/net104 VDD VDD pmos W=0.205u L=0.04u
M28418 n2301 U3060/net28 VDD VDD pmos W=0.205u L=0.04u
M28419 U3060/net32 WX751 VDD VDD pmos W=0.205u L=0.04u
M28420 U3060/net64 U3060/net24 VDD VDD pmos W=0.28u L=0.04u
M28421 U3060/net24 U3060/net30 U3060/net045 VDD pmos W=0.205u L=0.04u
M28422 U3060/net045 U3060/net32 VDD VDD pmos W=0.205u L=0.04u
M28423 U3061/net4 U3061/net10 U3061/net14 VSS nmos W=0.155u L=0.04u
M28424 U3061/net6 WX687 U3061/net14 VSS nmos W=0.155u L=0.04u
M28425 U3061/net4 TM0 VSS VSS nmos W=0.155u L=0.04u
M28426 U3061/net6 U3061/net4 VSS VSS nmos W=0.155u L=0.04u
M28427 n2302 U3061/net14 VSS VSS nmos W=0.155u L=0.04u
M28428 U3061/net10 WX687 VSS VSS nmos W=0.155u L=0.04u
M28429 U3061/net4 WX687 U3061/net14 VDD pmos W=0.205u L=0.04u
M28430 U3061/net6 U3061/net10 U3061/net14 VDD pmos W=0.205u L=0.04u
M28431 U3061/net4 TM0 VDD VDD pmos W=0.205u L=0.04u
M28432 U3061/net6 U3061/net4 VDD VDD pmos W=0.205u L=0.04u
M28433 n2302 U3061/net14 VDD VDD pmos W=0.205u L=0.04u
M28434 U3061/net10 WX687 VDD VDD pmos W=0.205u L=0.04u
M28435 U3062/net4 U3062/net10 U3062/net14 VSS nmos W=0.155u L=0.04u
M28436 U3062/net6 n1993 U3062/net14 VSS nmos W=0.155u L=0.04u
M28437 U3062/net4 n2303 VSS VSS nmos W=0.155u L=0.04u
M28438 U3062/net6 U3062/net4 VSS VSS nmos W=0.155u L=0.04u
M28439 WX1150 U3062/net14 VSS VSS nmos W=0.155u L=0.04u
M28440 U3062/net10 n1993 VSS VSS nmos W=0.155u L=0.04u
M28441 U3062/net4 n1993 U3062/net14 VDD pmos W=0.205u L=0.04u
M28442 U3062/net6 U3062/net10 U3062/net14 VDD pmos W=0.205u L=0.04u
M28443 U3062/net4 n2303 VDD VDD pmos W=0.205u L=0.04u
M28444 U3062/net6 U3062/net4 VDD VDD pmos W=0.205u L=0.04u
M28445 WX1150 U3062/net14 VDD VDD pmos W=0.205u L=0.04u
M28446 U3062/net10 n1993 VDD VDD pmos W=0.205u L=0.04u
M28447 U3063/XU1-net6 TM0 VSS VSS nmos W=0.155u L=0.04u
M28448 n2303 WX525 U3063/XU1-net6 VSS nmos W=0.155u L=0.04u
M28449 n2303 TM0 VDD VDD pmos W=0.155u L=0.04u
M28450 n2303 WX525 VDD VDD pmos W=0.155u L=0.04u
M28451 n1993 n2304 VSS VSS nmos W=0.135u L=0.04u
M28452 n1993 n2304 VDD VDD pmos W=0.205u L=0.04u
M28453 U3065/net28 U3065/net20 U3065/net64 VSS nmos W=0.155u L=0.04u
M28454 U3065/net24 U3065/net30 U3065/net32 VSS nmos W=0.155u L=0.04u
M28455 U3065/net28 U3065/net40 U3065/net24 VSS nmos W=0.155u L=0.04u
M28456 U3065/net40 n2305 U3065/net108 VSS nmos W=0.155u L=0.04u
M28457 U3065/net40 U3065/net106 U3065/net104 VSS nmos W=0.155u L=0.04u
M28458 U3065/net24 WX813 U3065/net050 VSS nmos W=0.155u L=0.04u
M28459 U3065/net050 U3065/net32 VSS VSS nmos W=0.155u L=0.04u
M28460 U3065/net20 U3065/net40 VSS VSS nmos W=0.155u L=0.04u
M28461 U3065/net106 n2305 VSS VSS nmos W=0.155u L=0.04u
M28462 U3065/net104 WX877 VSS VSS nmos W=0.155u L=0.04u
M28463 U3065/net30 WX813 VSS VSS nmos W=0.155u L=0.04u
M28464 U3065/net108 U3065/net104 VSS VSS nmos W=0.155u L=0.04u
M28465 n2304 U3065/net28 VSS VSS nmos W=0.155u L=0.04u
M28466 U3065/net32 WX749 VSS VSS nmos W=0.155u L=0.04u
M28467 U3065/net64 U3065/net24 VSS VSS nmos W=0.2u L=0.04u
M28468 U3065/net28 U3065/net40 U3065/net64 VDD pmos W=0.205u L=0.04u
M28469 U3065/net24 WX813 U3065/net32 VDD pmos W=0.205u L=0.04u
M28470 U3065/net28 U3065/net20 U3065/net24 VDD pmos W=0.205u L=0.04u
M28471 U3065/net40 U3065/net106 U3065/net108 VDD pmos W=0.205u L=0.04u
M28472 U3065/net40 n2305 U3065/net104 VDD pmos W=0.205u L=0.04u
M28473 U3065/net20 U3065/net40 VDD VDD pmos W=0.205u L=0.04u
M28474 U3065/net106 n2305 VDD VDD pmos W=0.205u L=0.04u
M28475 U3065/net104 WX877 VDD VDD pmos W=0.205u L=0.04u
M28476 U3065/net30 WX813 VDD VDD pmos W=0.205u L=0.04u
M28477 U3065/net108 U3065/net104 VDD VDD pmos W=0.205u L=0.04u
M28478 n2304 U3065/net28 VDD VDD pmos W=0.205u L=0.04u
M28479 U3065/net32 WX749 VDD VDD pmos W=0.205u L=0.04u
M28480 U3065/net64 U3065/net24 VDD VDD pmos W=0.28u L=0.04u
M28481 U3065/net24 U3065/net30 U3065/net045 VDD pmos W=0.205u L=0.04u
M28482 U3065/net045 U3065/net32 VDD VDD pmos W=0.205u L=0.04u
M28483 U3066/net4 U3066/net10 U3066/net14 VSS nmos W=0.155u L=0.04u
M28484 U3066/net6 WX685 U3066/net14 VSS nmos W=0.155u L=0.04u
M28485 U3066/net4 TM0 VSS VSS nmos W=0.155u L=0.04u
M28486 U3066/net6 U3066/net4 VSS VSS nmos W=0.155u L=0.04u
M28487 n2305 U3066/net14 VSS VSS nmos W=0.155u L=0.04u
M28488 U3066/net10 WX685 VSS VSS nmos W=0.155u L=0.04u
M28489 U3066/net4 WX685 U3066/net14 VDD pmos W=0.205u L=0.04u
M28490 U3066/net6 U3066/net10 U3066/net14 VDD pmos W=0.205u L=0.04u
M28491 U3066/net4 TM0 VDD VDD pmos W=0.205u L=0.04u
M28492 U3066/net6 U3066/net4 VDD VDD pmos W=0.205u L=0.04u
M28493 n2305 U3066/net14 VDD VDD pmos W=0.205u L=0.04u
M28494 U3066/net10 WX685 VDD VDD pmos W=0.205u L=0.04u
M28495 U3067/net4 U3067/net10 U3067/net14 VSS nmos W=0.155u L=0.04u
M28496 U3067/net6 n2001 U3067/net14 VSS nmos W=0.155u L=0.04u
M28497 U3067/net4 n2306 VSS VSS nmos W=0.155u L=0.04u
M28498 U3067/net6 U3067/net4 VSS VSS nmos W=0.155u L=0.04u
M28499 WX1143 U3067/net14 VSS VSS nmos W=0.155u L=0.04u
M28500 U3067/net10 n2001 VSS VSS nmos W=0.155u L=0.04u
M28501 U3067/net4 n2001 U3067/net14 VDD pmos W=0.205u L=0.04u
M28502 U3067/net6 U3067/net10 U3067/net14 VDD pmos W=0.205u L=0.04u
M28503 U3067/net4 n2306 VDD VDD pmos W=0.205u L=0.04u
M28504 U3067/net6 U3067/net4 VDD VDD pmos W=0.205u L=0.04u
M28505 WX1143 U3067/net14 VDD VDD pmos W=0.205u L=0.04u
M28506 U3067/net10 n2001 VDD VDD pmos W=0.205u L=0.04u
M28507 U3068/XU1-net6 TM0 VSS VSS nmos W=0.155u L=0.04u
M28508 n2306 WX523 U3068/XU1-net6 VSS nmos W=0.155u L=0.04u
M28509 n2306 TM0 VDD VDD pmos W=0.155u L=0.04u
M28510 n2306 WX523 VDD VDD pmos W=0.155u L=0.04u
M28511 n2001 n2307 VSS VSS nmos W=0.135u L=0.04u
M28512 n2001 n2307 VDD VDD pmos W=0.205u L=0.04u
M28513 U3070/net28 U3070/net20 U3070/net64 VSS nmos W=0.155u L=0.04u
M28514 U3070/net24 U3070/net30 U3070/net32 VSS nmos W=0.155u L=0.04u
M28515 U3070/net28 U3070/net40 U3070/net24 VSS nmos W=0.155u L=0.04u
M28516 U3070/net40 n2308 U3070/net108 VSS nmos W=0.155u L=0.04u
M28517 U3070/net40 U3070/net106 U3070/net104 VSS nmos W=0.155u L=0.04u
M28518 U3070/net24 WX811 U3070/net050 VSS nmos W=0.155u L=0.04u
M28519 U3070/net050 U3070/net32 VSS VSS nmos W=0.155u L=0.04u
M28520 U3070/net20 U3070/net40 VSS VSS nmos W=0.155u L=0.04u
M28521 U3070/net106 n2308 VSS VSS nmos W=0.155u L=0.04u
M28522 U3070/net104 WX875 VSS VSS nmos W=0.155u L=0.04u
M28523 U3070/net30 WX811 VSS VSS nmos W=0.155u L=0.04u
M28524 U3070/net108 U3070/net104 VSS VSS nmos W=0.155u L=0.04u
M28525 n2307 U3070/net28 VSS VSS nmos W=0.155u L=0.04u
M28526 U3070/net32 WX747 VSS VSS nmos W=0.155u L=0.04u
M28527 U3070/net64 U3070/net24 VSS VSS nmos W=0.2u L=0.04u
M28528 U3070/net28 U3070/net40 U3070/net64 VDD pmos W=0.205u L=0.04u
M28529 U3070/net24 WX811 U3070/net32 VDD pmos W=0.205u L=0.04u
M28530 U3070/net28 U3070/net20 U3070/net24 VDD pmos W=0.205u L=0.04u
M28531 U3070/net40 U3070/net106 U3070/net108 VDD pmos W=0.205u L=0.04u
M28532 U3070/net40 n2308 U3070/net104 VDD pmos W=0.205u L=0.04u
M28533 U3070/net20 U3070/net40 VDD VDD pmos W=0.205u L=0.04u
M28534 U3070/net106 n2308 VDD VDD pmos W=0.205u L=0.04u
M28535 U3070/net104 WX875 VDD VDD pmos W=0.205u L=0.04u
M28536 U3070/net30 WX811 VDD VDD pmos W=0.205u L=0.04u
M28537 U3070/net108 U3070/net104 VDD VDD pmos W=0.205u L=0.04u
M28538 n2307 U3070/net28 VDD VDD pmos W=0.205u L=0.04u
M28539 U3070/net32 WX747 VDD VDD pmos W=0.205u L=0.04u
M28540 U3070/net64 U3070/net24 VDD VDD pmos W=0.28u L=0.04u
M28541 U3070/net24 U3070/net30 U3070/net045 VDD pmos W=0.205u L=0.04u
M28542 U3070/net045 U3070/net32 VDD VDD pmos W=0.205u L=0.04u
M28543 U3071/net4 U3071/net10 U3071/net14 VSS nmos W=0.155u L=0.04u
M28544 U3071/net6 WX683 U3071/net14 VSS nmos W=0.155u L=0.04u
M28545 U3071/net4 TM0 VSS VSS nmos W=0.155u L=0.04u
M28546 U3071/net6 U3071/net4 VSS VSS nmos W=0.155u L=0.04u
M28547 n2308 U3071/net14 VSS VSS nmos W=0.155u L=0.04u
M28548 U3071/net10 WX683 VSS VSS nmos W=0.155u L=0.04u
M28549 U3071/net4 WX683 U3071/net14 VDD pmos W=0.205u L=0.04u
M28550 U3071/net6 U3071/net10 U3071/net14 VDD pmos W=0.205u L=0.04u
M28551 U3071/net4 TM0 VDD VDD pmos W=0.205u L=0.04u
M28552 U3071/net6 U3071/net4 VDD VDD pmos W=0.205u L=0.04u
M28553 n2308 U3071/net14 VDD VDD pmos W=0.205u L=0.04u
M28554 U3071/net10 WX683 VDD VDD pmos W=0.205u L=0.04u
M28555 U3072/net4 U3072/net10 U3072/net14 VSS nmos W=0.155u L=0.04u
M28556 U3072/net6 n2034 U3072/net14 VSS nmos W=0.155u L=0.04u
M28557 U3072/net4 n2309 VSS VSS nmos W=0.155u L=0.04u
M28558 U3072/net6 U3072/net4 VSS VSS nmos W=0.155u L=0.04u
M28559 WX1136 U3072/net14 VSS VSS nmos W=0.155u L=0.04u
M28560 U3072/net10 n2034 VSS VSS nmos W=0.155u L=0.04u
M28561 U3072/net4 n2034 U3072/net14 VDD pmos W=0.205u L=0.04u
M28562 U3072/net6 U3072/net10 U3072/net14 VDD pmos W=0.205u L=0.04u
M28563 U3072/net4 n2309 VDD VDD pmos W=0.205u L=0.04u
M28564 U3072/net6 U3072/net4 VDD VDD pmos W=0.205u L=0.04u
M28565 WX1136 U3072/net14 VDD VDD pmos W=0.205u L=0.04u
M28566 U3072/net10 n2034 VDD VDD pmos W=0.205u L=0.04u
M28567 U3073/XU1-net6 TM0 VSS VSS nmos W=0.155u L=0.04u
M28568 n2309 WX521 U3073/XU1-net6 VSS nmos W=0.155u L=0.04u
M28569 n2309 TM0 VDD VDD pmos W=0.155u L=0.04u
M28570 n2309 WX521 VDD VDD pmos W=0.155u L=0.04u
M28571 n2034 n2310 VSS VSS nmos W=0.135u L=0.04u
M28572 n2034 n2310 VDD VDD pmos W=0.205u L=0.04u
M28573 U3075/net28 U3075/net20 U3075/net64 VSS nmos W=0.155u L=0.04u
M28574 U3075/net24 U3075/net30 U3075/net32 VSS nmos W=0.155u L=0.04u
M28575 U3075/net28 U3075/net40 U3075/net24 VSS nmos W=0.155u L=0.04u
M28576 U3075/net40 n2311 U3075/net108 VSS nmos W=0.155u L=0.04u
M28577 U3075/net40 U3075/net106 U3075/net104 VSS nmos W=0.155u L=0.04u
M28578 U3075/net24 WX809 U3075/net050 VSS nmos W=0.155u L=0.04u
M28579 U3075/net050 U3075/net32 VSS VSS nmos W=0.155u L=0.04u
M28580 U3075/net20 U3075/net40 VSS VSS nmos W=0.155u L=0.04u
M28581 U3075/net106 n2311 VSS VSS nmos W=0.155u L=0.04u
M28582 U3075/net104 WX873 VSS VSS nmos W=0.155u L=0.04u
M28583 U3075/net30 WX809 VSS VSS nmos W=0.155u L=0.04u
M28584 U3075/net108 U3075/net104 VSS VSS nmos W=0.155u L=0.04u
M28585 n2310 U3075/net28 VSS VSS nmos W=0.155u L=0.04u
M28586 U3075/net32 WX745 VSS VSS nmos W=0.155u L=0.04u
M28587 U3075/net64 U3075/net24 VSS VSS nmos W=0.2u L=0.04u
M28588 U3075/net28 U3075/net40 U3075/net64 VDD pmos W=0.205u L=0.04u
M28589 U3075/net24 WX809 U3075/net32 VDD pmos W=0.205u L=0.04u
M28590 U3075/net28 U3075/net20 U3075/net24 VDD pmos W=0.205u L=0.04u
M28591 U3075/net40 U3075/net106 U3075/net108 VDD pmos W=0.205u L=0.04u
M28592 U3075/net40 n2311 U3075/net104 VDD pmos W=0.205u L=0.04u
M28593 U3075/net20 U3075/net40 VDD VDD pmos W=0.205u L=0.04u
M28594 U3075/net106 n2311 VDD VDD pmos W=0.205u L=0.04u
M28595 U3075/net104 WX873 VDD VDD pmos W=0.205u L=0.04u
M28596 U3075/net30 WX809 VDD VDD pmos W=0.205u L=0.04u
M28597 U3075/net108 U3075/net104 VDD VDD pmos W=0.205u L=0.04u
M28598 n2310 U3075/net28 VDD VDD pmos W=0.205u L=0.04u
M28599 U3075/net32 WX745 VDD VDD pmos W=0.205u L=0.04u
M28600 U3075/net64 U3075/net24 VDD VDD pmos W=0.28u L=0.04u
M28601 U3075/net24 U3075/net30 U3075/net045 VDD pmos W=0.205u L=0.04u
M28602 U3075/net045 U3075/net32 VDD VDD pmos W=0.205u L=0.04u
M28603 U3076/net4 U3076/net10 U3076/net14 VSS nmos W=0.155u L=0.04u
M28604 U3076/net6 WX681 U3076/net14 VSS nmos W=0.155u L=0.04u
M28605 U3076/net4 TM0 VSS VSS nmos W=0.155u L=0.04u
M28606 U3076/net6 U3076/net4 VSS VSS nmos W=0.155u L=0.04u
M28607 n2311 U3076/net14 VSS VSS nmos W=0.155u L=0.04u
M28608 U3076/net10 WX681 VSS VSS nmos W=0.155u L=0.04u
M28609 U3076/net4 WX681 U3076/net14 VDD pmos W=0.205u L=0.04u
M28610 U3076/net6 U3076/net10 U3076/net14 VDD pmos W=0.205u L=0.04u
M28611 U3076/net4 TM0 VDD VDD pmos W=0.205u L=0.04u
M28612 U3076/net6 U3076/net4 VDD VDD pmos W=0.205u L=0.04u
M28613 n2311 U3076/net14 VDD VDD pmos W=0.205u L=0.04u
M28614 U3076/net10 WX681 VDD VDD pmos W=0.205u L=0.04u
M28615 U3077/net4 U3077/net10 U3077/net14 VSS nmos W=0.155u L=0.04u
M28616 U3077/net6 n2073 U3077/net14 VSS nmos W=0.155u L=0.04u
M28617 U3077/net4 n2312 VSS VSS nmos W=0.155u L=0.04u
M28618 U3077/net6 U3077/net4 VSS VSS nmos W=0.155u L=0.04u
M28619 WX1129 U3077/net14 VSS VSS nmos W=0.155u L=0.04u
M28620 U3077/net10 n2073 VSS VSS nmos W=0.155u L=0.04u
M28621 U3077/net4 n2073 U3077/net14 VDD pmos W=0.205u L=0.04u
M28622 U3077/net6 U3077/net10 U3077/net14 VDD pmos W=0.205u L=0.04u
M28623 U3077/net4 n2312 VDD VDD pmos W=0.205u L=0.04u
M28624 U3077/net6 U3077/net4 VDD VDD pmos W=0.205u L=0.04u
M28625 WX1129 U3077/net14 VDD VDD pmos W=0.205u L=0.04u
M28626 U3077/net10 n2073 VDD VDD pmos W=0.205u L=0.04u
M28627 U3078/XU1-net6 TM0 VSS VSS nmos W=0.155u L=0.04u
M28628 n2312 WX519 U3078/XU1-net6 VSS nmos W=0.155u L=0.04u
M28629 n2312 TM0 VDD VDD pmos W=0.155u L=0.04u
M28630 n2312 WX519 VDD VDD pmos W=0.155u L=0.04u
M28631 n2073 n2313 VSS VSS nmos W=0.135u L=0.04u
M28632 n2073 n2313 VDD VDD pmos W=0.205u L=0.04u
M28633 U3080/net28 U3080/net20 U3080/net64 VSS nmos W=0.155u L=0.04u
M28634 U3080/net24 U3080/net30 U3080/net32 VSS nmos W=0.155u L=0.04u
M28635 U3080/net28 U3080/net40 U3080/net24 VSS nmos W=0.155u L=0.04u
M28636 U3080/net40 n2314 U3080/net108 VSS nmos W=0.155u L=0.04u
M28637 U3080/net40 U3080/net106 U3080/net104 VSS nmos W=0.155u L=0.04u
M28638 U3080/net24 WX807 U3080/net050 VSS nmos W=0.155u L=0.04u
M28639 U3080/net050 U3080/net32 VSS VSS nmos W=0.155u L=0.04u
M28640 U3080/net20 U3080/net40 VSS VSS nmos W=0.155u L=0.04u
M28641 U3080/net106 n2314 VSS VSS nmos W=0.155u L=0.04u
M28642 U3080/net104 WX871 VSS VSS nmos W=0.155u L=0.04u
M28643 U3080/net30 WX807 VSS VSS nmos W=0.155u L=0.04u
M28644 U3080/net108 U3080/net104 VSS VSS nmos W=0.155u L=0.04u
M28645 n2313 U3080/net28 VSS VSS nmos W=0.155u L=0.04u
M28646 U3080/net32 WX743 VSS VSS nmos W=0.155u L=0.04u
M28647 U3080/net64 U3080/net24 VSS VSS nmos W=0.2u L=0.04u
M28648 U3080/net28 U3080/net40 U3080/net64 VDD pmos W=0.205u L=0.04u
M28649 U3080/net24 WX807 U3080/net32 VDD pmos W=0.205u L=0.04u
M28650 U3080/net28 U3080/net20 U3080/net24 VDD pmos W=0.205u L=0.04u
M28651 U3080/net40 U3080/net106 U3080/net108 VDD pmos W=0.205u L=0.04u
M28652 U3080/net40 n2314 U3080/net104 VDD pmos W=0.205u L=0.04u
M28653 U3080/net20 U3080/net40 VDD VDD pmos W=0.205u L=0.04u
M28654 U3080/net106 n2314 VDD VDD pmos W=0.205u L=0.04u
M28655 U3080/net104 WX871 VDD VDD pmos W=0.205u L=0.04u
M28656 U3080/net30 WX807 VDD VDD pmos W=0.205u L=0.04u
M28657 U3080/net108 U3080/net104 VDD VDD pmos W=0.205u L=0.04u
M28658 n2313 U3080/net28 VDD VDD pmos W=0.205u L=0.04u
M28659 U3080/net32 WX743 VDD VDD pmos W=0.205u L=0.04u
M28660 U3080/net64 U3080/net24 VDD VDD pmos W=0.28u L=0.04u
M28661 U3080/net24 U3080/net30 U3080/net045 VDD pmos W=0.205u L=0.04u
M28662 U3080/net045 U3080/net32 VDD VDD pmos W=0.205u L=0.04u
M28663 U3081/net4 U3081/net10 U3081/net14 VSS nmos W=0.155u L=0.04u
M28664 U3081/net6 WX679 U3081/net14 VSS nmos W=0.155u L=0.04u
M28665 U3081/net4 TM0 VSS VSS nmos W=0.155u L=0.04u
M28666 U3081/net6 U3081/net4 VSS VSS nmos W=0.155u L=0.04u
M28667 n2314 U3081/net14 VSS VSS nmos W=0.155u L=0.04u
M28668 U3081/net10 WX679 VSS VSS nmos W=0.155u L=0.04u
M28669 U3081/net4 WX679 U3081/net14 VDD pmos W=0.205u L=0.04u
M28670 U3081/net6 U3081/net10 U3081/net14 VDD pmos W=0.205u L=0.04u
M28671 U3081/net4 TM0 VDD VDD pmos W=0.205u L=0.04u
M28672 U3081/net6 U3081/net4 VDD VDD pmos W=0.205u L=0.04u
M28673 n2314 U3081/net14 VDD VDD pmos W=0.205u L=0.04u
M28674 U3081/net10 WX679 VDD VDD pmos W=0.205u L=0.04u
M28675 U3082/net4 U3082/net10 U3082/net14 VSS nmos W=0.155u L=0.04u
M28676 U3082/net6 n2115 U3082/net14 VSS nmos W=0.155u L=0.04u
M28677 U3082/net4 n2315 VSS VSS nmos W=0.155u L=0.04u
M28678 U3082/net6 U3082/net4 VSS VSS nmos W=0.155u L=0.04u
M28679 WX1122 U3082/net14 VSS VSS nmos W=0.155u L=0.04u
M28680 U3082/net10 n2115 VSS VSS nmos W=0.155u L=0.04u
M28681 U3082/net4 n2115 U3082/net14 VDD pmos W=0.205u L=0.04u
M28682 U3082/net6 U3082/net10 U3082/net14 VDD pmos W=0.205u L=0.04u
M28683 U3082/net4 n2315 VDD VDD pmos W=0.205u L=0.04u
M28684 U3082/net6 U3082/net4 VDD VDD pmos W=0.205u L=0.04u
M28685 WX1122 U3082/net14 VDD VDD pmos W=0.205u L=0.04u
M28686 U3082/net10 n2115 VDD VDD pmos W=0.205u L=0.04u
M28687 U3083/XU1-net6 TM0 VSS VSS nmos W=0.155u L=0.04u
M28688 n2315 WX517 U3083/XU1-net6 VSS nmos W=0.155u L=0.04u
M28689 n2315 TM0 VDD VDD pmos W=0.155u L=0.04u
M28690 n2315 WX517 VDD VDD pmos W=0.155u L=0.04u
M28691 n2115 n2316 VSS VSS nmos W=0.135u L=0.04u
M28692 n2115 n2316 VDD VDD pmos W=0.205u L=0.04u
M28693 U3085/net28 U3085/net20 U3085/net64 VSS nmos W=0.155u L=0.04u
M28694 U3085/net24 U3085/net30 U3085/net32 VSS nmos W=0.155u L=0.04u
M28695 U3085/net28 U3085/net40 U3085/net24 VSS nmos W=0.155u L=0.04u
M28696 U3085/net40 n2317 U3085/net108 VSS nmos W=0.155u L=0.04u
M28697 U3085/net40 U3085/net106 U3085/net104 VSS nmos W=0.155u L=0.04u
M28698 U3085/net24 WX805 U3085/net050 VSS nmos W=0.155u L=0.04u
M28699 U3085/net050 U3085/net32 VSS VSS nmos W=0.155u L=0.04u
M28700 U3085/net20 U3085/net40 VSS VSS nmos W=0.155u L=0.04u
M28701 U3085/net106 n2317 VSS VSS nmos W=0.155u L=0.04u
M28702 U3085/net104 WX869 VSS VSS nmos W=0.155u L=0.04u
M28703 U3085/net30 WX805 VSS VSS nmos W=0.155u L=0.04u
M28704 U3085/net108 U3085/net104 VSS VSS nmos W=0.155u L=0.04u
M28705 n2316 U3085/net28 VSS VSS nmos W=0.155u L=0.04u
M28706 U3085/net32 WX741 VSS VSS nmos W=0.155u L=0.04u
M28707 U3085/net64 U3085/net24 VSS VSS nmos W=0.2u L=0.04u
M28708 U3085/net28 U3085/net40 U3085/net64 VDD pmos W=0.205u L=0.04u
M28709 U3085/net24 WX805 U3085/net32 VDD pmos W=0.205u L=0.04u
M28710 U3085/net28 U3085/net20 U3085/net24 VDD pmos W=0.205u L=0.04u
M28711 U3085/net40 U3085/net106 U3085/net108 VDD pmos W=0.205u L=0.04u
M28712 U3085/net40 n2317 U3085/net104 VDD pmos W=0.205u L=0.04u
M28713 U3085/net20 U3085/net40 VDD VDD pmos W=0.205u L=0.04u
M28714 U3085/net106 n2317 VDD VDD pmos W=0.205u L=0.04u
M28715 U3085/net104 WX869 VDD VDD pmos W=0.205u L=0.04u
M28716 U3085/net30 WX805 VDD VDD pmos W=0.205u L=0.04u
M28717 U3085/net108 U3085/net104 VDD VDD pmos W=0.205u L=0.04u
M28718 n2316 U3085/net28 VDD VDD pmos W=0.205u L=0.04u
M28719 U3085/net32 WX741 VDD VDD pmos W=0.205u L=0.04u
M28720 U3085/net64 U3085/net24 VDD VDD pmos W=0.28u L=0.04u
M28721 U3085/net24 U3085/net30 U3085/net045 VDD pmos W=0.205u L=0.04u
M28722 U3085/net045 U3085/net32 VDD VDD pmos W=0.205u L=0.04u
M28723 U3086/net4 U3086/net10 U3086/net14 VSS nmos W=0.155u L=0.04u
M28724 U3086/net6 WX677 U3086/net14 VSS nmos W=0.155u L=0.04u
M28725 U3086/net4 TM0 VSS VSS nmos W=0.155u L=0.04u
M28726 U3086/net6 U3086/net4 VSS VSS nmos W=0.155u L=0.04u
M28727 n2317 U3086/net14 VSS VSS nmos W=0.155u L=0.04u
M28728 U3086/net10 WX677 VSS VSS nmos W=0.155u L=0.04u
M28729 U3086/net4 WX677 U3086/net14 VDD pmos W=0.205u L=0.04u
M28730 U3086/net6 U3086/net10 U3086/net14 VDD pmos W=0.205u L=0.04u
M28731 U3086/net4 TM0 VDD VDD pmos W=0.205u L=0.04u
M28732 U3086/net6 U3086/net4 VDD VDD pmos W=0.205u L=0.04u
M28733 n2317 U3086/net14 VDD VDD pmos W=0.205u L=0.04u
M28734 U3086/net10 WX677 VDD VDD pmos W=0.205u L=0.04u
M28735 U3087/net4 U3087/net10 U3087/net14 VSS nmos W=0.155u L=0.04u
M28736 U3087/net6 n2118 U3087/net14 VSS nmos W=0.155u L=0.04u
M28737 U3087/net4 n2318 VSS VSS nmos W=0.155u L=0.04u
M28738 U3087/net6 U3087/net4 VSS VSS nmos W=0.155u L=0.04u
M28739 WX1115 U3087/net14 VSS VSS nmos W=0.155u L=0.04u
M28740 U3087/net10 n2118 VSS VSS nmos W=0.155u L=0.04u
M28741 U3087/net4 n2118 U3087/net14 VDD pmos W=0.205u L=0.04u
M28742 U3087/net6 U3087/net10 U3087/net14 VDD pmos W=0.205u L=0.04u
M28743 U3087/net4 n2318 VDD VDD pmos W=0.205u L=0.04u
M28744 U3087/net6 U3087/net4 VDD VDD pmos W=0.205u L=0.04u
M28745 WX1115 U3087/net14 VDD VDD pmos W=0.205u L=0.04u
M28746 U3087/net10 n2118 VDD VDD pmos W=0.205u L=0.04u
M28747 U3088/XU1-net6 TM0 VSS VSS nmos W=0.155u L=0.04u
M28748 n2318 WX515 U3088/XU1-net6 VSS nmos W=0.155u L=0.04u
M28749 n2318 TM0 VDD VDD pmos W=0.155u L=0.04u
M28750 n2318 WX515 VDD VDD pmos W=0.155u L=0.04u
M28751 n2118 n2319 VSS VSS nmos W=0.135u L=0.04u
M28752 n2118 n2319 VDD VDD pmos W=0.205u L=0.04u
M28753 U3090/net28 U3090/net20 U3090/net64 VSS nmos W=0.155u L=0.04u
M28754 U3090/net24 U3090/net30 U3090/net32 VSS nmos W=0.155u L=0.04u
M28755 U3090/net28 U3090/net40 U3090/net24 VSS nmos W=0.155u L=0.04u
M28756 U3090/net40 n2320 U3090/net108 VSS nmos W=0.155u L=0.04u
M28757 U3090/net40 U3090/net106 U3090/net104 VSS nmos W=0.155u L=0.04u
M28758 U3090/net24 WX803 U3090/net050 VSS nmos W=0.155u L=0.04u
M28759 U3090/net050 U3090/net32 VSS VSS nmos W=0.155u L=0.04u
M28760 U3090/net20 U3090/net40 VSS VSS nmos W=0.155u L=0.04u
M28761 U3090/net106 n2320 VSS VSS nmos W=0.155u L=0.04u
M28762 U3090/net104 WX867 VSS VSS nmos W=0.155u L=0.04u
M28763 U3090/net30 WX803 VSS VSS nmos W=0.155u L=0.04u
M28764 U3090/net108 U3090/net104 VSS VSS nmos W=0.155u L=0.04u
M28765 n2319 U3090/net28 VSS VSS nmos W=0.155u L=0.04u
M28766 U3090/net32 WX739 VSS VSS nmos W=0.155u L=0.04u
M28767 U3090/net64 U3090/net24 VSS VSS nmos W=0.2u L=0.04u
M28768 U3090/net28 U3090/net40 U3090/net64 VDD pmos W=0.205u L=0.04u
M28769 U3090/net24 WX803 U3090/net32 VDD pmos W=0.205u L=0.04u
M28770 U3090/net28 U3090/net20 U3090/net24 VDD pmos W=0.205u L=0.04u
M28771 U3090/net40 U3090/net106 U3090/net108 VDD pmos W=0.205u L=0.04u
M28772 U3090/net40 n2320 U3090/net104 VDD pmos W=0.205u L=0.04u
M28773 U3090/net20 U3090/net40 VDD VDD pmos W=0.205u L=0.04u
M28774 U3090/net106 n2320 VDD VDD pmos W=0.205u L=0.04u
M28775 U3090/net104 WX867 VDD VDD pmos W=0.205u L=0.04u
M28776 U3090/net30 WX803 VDD VDD pmos W=0.205u L=0.04u
M28777 U3090/net108 U3090/net104 VDD VDD pmos W=0.205u L=0.04u
M28778 n2319 U3090/net28 VDD VDD pmos W=0.205u L=0.04u
M28779 U3090/net32 WX739 VDD VDD pmos W=0.205u L=0.04u
M28780 U3090/net64 U3090/net24 VDD VDD pmos W=0.28u L=0.04u
M28781 U3090/net24 U3090/net30 U3090/net045 VDD pmos W=0.205u L=0.04u
M28782 U3090/net045 U3090/net32 VDD VDD pmos W=0.205u L=0.04u
M28783 U3091/net4 WX675 U3091/net14 VSS nmos W=0.155u L=0.04u
M28784 U3091/net6 U3091/net10 U3091/net14 VSS nmos W=0.17u L=0.04u
M28785 U3091/net4 n1377 VSS VSS nmos W=0.155u L=0.04u
M28786 U3091/net6 U3091/net4 VSS VSS nmos W=0.17u L=0.04u
M28787 n2320 U3091/net14 VSS VSS nmos W=0.155u L=0.04u
M28788 U3091/net10 WX675 VSS VSS nmos W=0.155u L=0.04u
M28789 U3091/net4 U3091/net10 U3091/net14 VDD pmos W=0.255u L=0.04u
M28790 U3091/net6 WX675 U3091/net14 VDD pmos W=0.28u L=0.04u
M28791 U3091/net4 n1377 VDD VDD pmos W=0.205u L=0.04u
M28792 U3091/net6 U3091/net4 VDD VDD pmos W=0.24u L=0.04u
M28793 n2320 U3091/net14 VDD VDD pmos W=0.205u L=0.04u
M28794 U3091/net10 WX675 VDD VDD pmos W=0.205u L=0.04u
M28795 U3092/net4 U3092/net10 U3092/net14 VSS nmos W=0.155u L=0.04u
M28796 U3092/net6 n2121 U3092/net14 VSS nmos W=0.155u L=0.04u
M28797 U3092/net4 n2321 VSS VSS nmos W=0.155u L=0.04u
M28798 U3092/net6 U3092/net4 VSS VSS nmos W=0.155u L=0.04u
M28799 WX1108 U3092/net14 VSS VSS nmos W=0.155u L=0.04u
M28800 U3092/net10 n2121 VSS VSS nmos W=0.155u L=0.04u
M28801 U3092/net4 n2121 U3092/net14 VDD pmos W=0.205u L=0.04u
M28802 U3092/net6 U3092/net10 U3092/net14 VDD pmos W=0.205u L=0.04u
M28803 U3092/net4 n2321 VDD VDD pmos W=0.205u L=0.04u
M28804 U3092/net6 U3092/net4 VDD VDD pmos W=0.205u L=0.04u
M28805 WX1108 U3092/net14 VDD VDD pmos W=0.205u L=0.04u
M28806 U3092/net10 n2121 VDD VDD pmos W=0.205u L=0.04u
M28807 U3093/XU1-net6 TM0 VSS VSS nmos W=0.155u L=0.04u
M28808 n2321 WX513 U3093/XU1-net6 VSS nmos W=0.155u L=0.04u
M28809 n2321 TM0 VDD VDD pmos W=0.155u L=0.04u
M28810 n2321 WX513 VDD VDD pmos W=0.155u L=0.04u
M28811 n2121 n2322 VSS VSS nmos W=0.135u L=0.04u
M28812 n2121 n2322 VDD VDD pmos W=0.205u L=0.04u
M28813 U3095/net28 U3095/net20 U3095/net64 VSS nmos W=0.155u L=0.04u
M28814 U3095/net24 U3095/net30 U3095/net32 VSS nmos W=0.155u L=0.04u
M28815 U3095/net28 U3095/net40 U3095/net24 VSS nmos W=0.155u L=0.04u
M28816 U3095/net40 n2323 U3095/net108 VSS nmos W=0.155u L=0.04u
M28817 U3095/net40 U3095/net106 U3095/net104 VSS nmos W=0.155u L=0.04u
M28818 U3095/net24 WX801 U3095/net050 VSS nmos W=0.155u L=0.04u
M28819 U3095/net050 U3095/net32 VSS VSS nmos W=0.155u L=0.04u
M28820 U3095/net20 U3095/net40 VSS VSS nmos W=0.155u L=0.04u
M28821 U3095/net106 n2323 VSS VSS nmos W=0.155u L=0.04u
M28822 U3095/net104 WX865 VSS VSS nmos W=0.155u L=0.04u
M28823 U3095/net30 WX801 VSS VSS nmos W=0.155u L=0.04u
M28824 U3095/net108 U3095/net104 VSS VSS nmos W=0.155u L=0.04u
M28825 n2322 U3095/net28 VSS VSS nmos W=0.155u L=0.04u
M28826 U3095/net32 WX737 VSS VSS nmos W=0.155u L=0.04u
M28827 U3095/net64 U3095/net24 VSS VSS nmos W=0.2u L=0.04u
M28828 U3095/net28 U3095/net40 U3095/net64 VDD pmos W=0.205u L=0.04u
M28829 U3095/net24 WX801 U3095/net32 VDD pmos W=0.205u L=0.04u
M28830 U3095/net28 U3095/net20 U3095/net24 VDD pmos W=0.205u L=0.04u
M28831 U3095/net40 U3095/net106 U3095/net108 VDD pmos W=0.205u L=0.04u
M28832 U3095/net40 n2323 U3095/net104 VDD pmos W=0.205u L=0.04u
M28833 U3095/net20 U3095/net40 VDD VDD pmos W=0.205u L=0.04u
M28834 U3095/net106 n2323 VDD VDD pmos W=0.205u L=0.04u
M28835 U3095/net104 WX865 VDD VDD pmos W=0.205u L=0.04u
M28836 U3095/net30 WX801 VDD VDD pmos W=0.205u L=0.04u
M28837 U3095/net108 U3095/net104 VDD VDD pmos W=0.205u L=0.04u
M28838 n2322 U3095/net28 VDD VDD pmos W=0.205u L=0.04u
M28839 U3095/net32 WX737 VDD VDD pmos W=0.205u L=0.04u
M28840 U3095/net64 U3095/net24 VDD VDD pmos W=0.28u L=0.04u
M28841 U3095/net24 U3095/net30 U3095/net045 VDD pmos W=0.205u L=0.04u
M28842 U3095/net045 U3095/net32 VDD VDD pmos W=0.205u L=0.04u
M28843 U3096/net4 WX673 U3096/net14 VSS nmos W=0.155u L=0.04u
M28844 U3096/net6 U3096/net10 U3096/net14 VSS nmos W=0.17u L=0.04u
M28845 U3096/net4 n1377 VSS VSS nmos W=0.155u L=0.04u
M28846 U3096/net6 U3096/net4 VSS VSS nmos W=0.17u L=0.04u
M28847 n2323 U3096/net14 VSS VSS nmos W=0.155u L=0.04u
M28848 U3096/net10 WX673 VSS VSS nmos W=0.155u L=0.04u
M28849 U3096/net4 U3096/net10 U3096/net14 VDD pmos W=0.255u L=0.04u
M28850 U3096/net6 WX673 U3096/net14 VDD pmos W=0.28u L=0.04u
M28851 U3096/net4 n1377 VDD VDD pmos W=0.205u L=0.04u
M28852 U3096/net6 U3096/net4 VDD VDD pmos W=0.24u L=0.04u
M28853 n2323 U3096/net14 VDD VDD pmos W=0.205u L=0.04u
M28854 U3096/net10 WX673 VDD VDD pmos W=0.205u L=0.04u
M28855 U3097/net4 U3097/net10 U3097/net14 VSS nmos W=0.155u L=0.04u
M28856 U3097/net6 n2124 U3097/net14 VSS nmos W=0.155u L=0.04u
M28857 U3097/net4 n2324 VSS VSS nmos W=0.155u L=0.04u
M28858 U3097/net6 U3097/net4 VSS VSS nmos W=0.155u L=0.04u
M28859 WX1101 U3097/net14 VSS VSS nmos W=0.155u L=0.04u
M28860 U3097/net10 n2124 VSS VSS nmos W=0.155u L=0.04u
M28861 U3097/net4 n2124 U3097/net14 VDD pmos W=0.205u L=0.04u
M28862 U3097/net6 U3097/net10 U3097/net14 VDD pmos W=0.205u L=0.04u
M28863 U3097/net4 n2324 VDD VDD pmos W=0.205u L=0.04u
M28864 U3097/net6 U3097/net4 VDD VDD pmos W=0.205u L=0.04u
M28865 WX1101 U3097/net14 VDD VDD pmos W=0.205u L=0.04u
M28866 U3097/net10 n2124 VDD VDD pmos W=0.205u L=0.04u
M28867 U3098/XU1-net6 TM0 VSS VSS nmos W=0.155u L=0.04u
M28868 n2324 WX511 U3098/XU1-net6 VSS nmos W=0.155u L=0.04u
M28869 n2324 TM0 VDD VDD pmos W=0.155u L=0.04u
M28870 n2324 WX511 VDD VDD pmos W=0.155u L=0.04u
M28871 n2124 n2325 VSS VSS nmos W=0.135u L=0.04u
M28872 n2124 n2325 VDD VDD pmos W=0.205u L=0.04u
M28873 U3100/net28 U3100/net20 U3100/net64 VSS nmos W=0.155u L=0.04u
M28874 U3100/net24 U3100/net30 U3100/net32 VSS nmos W=0.155u L=0.04u
M28875 U3100/net28 U3100/net40 U3100/net24 VSS nmos W=0.155u L=0.04u
M28876 U3100/net40 n2326 U3100/net108 VSS nmos W=0.155u L=0.04u
M28877 U3100/net40 U3100/net106 U3100/net104 VSS nmos W=0.155u L=0.04u
M28878 U3100/net24 WX799 U3100/net050 VSS nmos W=0.155u L=0.04u
M28879 U3100/net050 U3100/net32 VSS VSS nmos W=0.155u L=0.04u
M28880 U3100/net20 U3100/net40 VSS VSS nmos W=0.155u L=0.04u
M28881 U3100/net106 n2326 VSS VSS nmos W=0.155u L=0.04u
M28882 U3100/net104 WX863 VSS VSS nmos W=0.155u L=0.04u
M28883 U3100/net30 WX799 VSS VSS nmos W=0.155u L=0.04u
M28884 U3100/net108 U3100/net104 VSS VSS nmos W=0.155u L=0.04u
M28885 n2325 U3100/net28 VSS VSS nmos W=0.155u L=0.04u
M28886 U3100/net32 WX735 VSS VSS nmos W=0.155u L=0.04u
M28887 U3100/net64 U3100/net24 VSS VSS nmos W=0.2u L=0.04u
M28888 U3100/net28 U3100/net40 U3100/net64 VDD pmos W=0.205u L=0.04u
M28889 U3100/net24 WX799 U3100/net32 VDD pmos W=0.205u L=0.04u
M28890 U3100/net28 U3100/net20 U3100/net24 VDD pmos W=0.205u L=0.04u
M28891 U3100/net40 U3100/net106 U3100/net108 VDD pmos W=0.205u L=0.04u
M28892 U3100/net40 n2326 U3100/net104 VDD pmos W=0.205u L=0.04u
M28893 U3100/net20 U3100/net40 VDD VDD pmos W=0.205u L=0.04u
M28894 U3100/net106 n2326 VDD VDD pmos W=0.205u L=0.04u
M28895 U3100/net104 WX863 VDD VDD pmos W=0.205u L=0.04u
M28896 U3100/net30 WX799 VDD VDD pmos W=0.205u L=0.04u
M28897 U3100/net108 U3100/net104 VDD VDD pmos W=0.205u L=0.04u
M28898 n2325 U3100/net28 VDD VDD pmos W=0.205u L=0.04u
M28899 U3100/net32 WX735 VDD VDD pmos W=0.205u L=0.04u
M28900 U3100/net64 U3100/net24 VDD VDD pmos W=0.28u L=0.04u
M28901 U3100/net24 U3100/net30 U3100/net045 VDD pmos W=0.205u L=0.04u
M28902 U3100/net045 U3100/net32 VDD VDD pmos W=0.205u L=0.04u
M28903 U3101/net4 WX671 U3101/net14 VSS nmos W=0.155u L=0.04u
M28904 U3101/net6 U3101/net10 U3101/net14 VSS nmos W=0.17u L=0.04u
M28905 U3101/net4 n1377 VSS VSS nmos W=0.155u L=0.04u
M28906 U3101/net6 U3101/net4 VSS VSS nmos W=0.17u L=0.04u
M28907 n2326 U3101/net14 VSS VSS nmos W=0.155u L=0.04u
M28908 U3101/net10 WX671 VSS VSS nmos W=0.155u L=0.04u
M28909 U3101/net4 U3101/net10 U3101/net14 VDD pmos W=0.255u L=0.04u
M28910 U3101/net6 WX671 U3101/net14 VDD pmos W=0.28u L=0.04u
M28911 U3101/net4 n1377 VDD VDD pmos W=0.205u L=0.04u
M28912 U3101/net6 U3101/net4 VDD VDD pmos W=0.24u L=0.04u
M28913 n2326 U3101/net14 VDD VDD pmos W=0.205u L=0.04u
M28914 U3101/net10 WX671 VDD VDD pmos W=0.205u L=0.04u
M28915 U3102/net4 U3102/net10 U3102/net14 VSS nmos W=0.155u L=0.04u
M28916 U3102/net6 n2127 U3102/net14 VSS nmos W=0.155u L=0.04u
M28917 U3102/net4 n2327 VSS VSS nmos W=0.155u L=0.04u
M28918 U3102/net6 U3102/net4 VSS VSS nmos W=0.155u L=0.04u
M28919 WX1094 U3102/net14 VSS VSS nmos W=0.155u L=0.04u
M28920 U3102/net10 n2127 VSS VSS nmos W=0.155u L=0.04u
M28921 U3102/net4 n2127 U3102/net14 VDD pmos W=0.205u L=0.04u
M28922 U3102/net6 U3102/net10 U3102/net14 VDD pmos W=0.205u L=0.04u
M28923 U3102/net4 n2327 VDD VDD pmos W=0.205u L=0.04u
M28924 U3102/net6 U3102/net4 VDD VDD pmos W=0.205u L=0.04u
M28925 WX1094 U3102/net14 VDD VDD pmos W=0.205u L=0.04u
M28926 U3102/net10 n2127 VDD VDD pmos W=0.205u L=0.04u
M28927 U3103/XU1-net6 TM0 VSS VSS nmos W=0.155u L=0.04u
M28928 n2327 WX509 U3103/XU1-net6 VSS nmos W=0.155u L=0.04u
M28929 n2327 TM0 VDD VDD pmos W=0.155u L=0.04u
M28930 n2327 WX509 VDD VDD pmos W=0.155u L=0.04u
M28931 n2127 n2328 VSS VSS nmos W=0.135u L=0.04u
M28932 n2127 n2328 VDD VDD pmos W=0.205u L=0.04u
M28933 U3105/net28 U3105/net20 U3105/net64 VSS nmos W=0.155u L=0.04u
M28934 U3105/net24 U3105/net30 U3105/net32 VSS nmos W=0.155u L=0.04u
M28935 U3105/net28 U3105/net40 U3105/net24 VSS nmos W=0.155u L=0.04u
M28936 U3105/net40 n2329 U3105/net108 VSS nmos W=0.155u L=0.04u
M28937 U3105/net40 U3105/net106 U3105/net104 VSS nmos W=0.155u L=0.04u
M28938 U3105/net24 WX797 U3105/net050 VSS nmos W=0.155u L=0.04u
M28939 U3105/net050 U3105/net32 VSS VSS nmos W=0.155u L=0.04u
M28940 U3105/net20 U3105/net40 VSS VSS nmos W=0.155u L=0.04u
M28941 U3105/net106 n2329 VSS VSS nmos W=0.155u L=0.04u
M28942 U3105/net104 WX861 VSS VSS nmos W=0.155u L=0.04u
M28943 U3105/net30 WX797 VSS VSS nmos W=0.155u L=0.04u
M28944 U3105/net108 U3105/net104 VSS VSS nmos W=0.155u L=0.04u
M28945 n2328 U3105/net28 VSS VSS nmos W=0.155u L=0.04u
M28946 U3105/net32 WX733 VSS VSS nmos W=0.155u L=0.04u
M28947 U3105/net64 U3105/net24 VSS VSS nmos W=0.2u L=0.04u
M28948 U3105/net28 U3105/net40 U3105/net64 VDD pmos W=0.205u L=0.04u
M28949 U3105/net24 WX797 U3105/net32 VDD pmos W=0.205u L=0.04u
M28950 U3105/net28 U3105/net20 U3105/net24 VDD pmos W=0.205u L=0.04u
M28951 U3105/net40 U3105/net106 U3105/net108 VDD pmos W=0.205u L=0.04u
M28952 U3105/net40 n2329 U3105/net104 VDD pmos W=0.205u L=0.04u
M28953 U3105/net20 U3105/net40 VDD VDD pmos W=0.205u L=0.04u
M28954 U3105/net106 n2329 VDD VDD pmos W=0.205u L=0.04u
M28955 U3105/net104 WX861 VDD VDD pmos W=0.205u L=0.04u
M28956 U3105/net30 WX797 VDD VDD pmos W=0.205u L=0.04u
M28957 U3105/net108 U3105/net104 VDD VDD pmos W=0.205u L=0.04u
M28958 n2328 U3105/net28 VDD VDD pmos W=0.205u L=0.04u
M28959 U3105/net32 WX733 VDD VDD pmos W=0.205u L=0.04u
M28960 U3105/net64 U3105/net24 VDD VDD pmos W=0.28u L=0.04u
M28961 U3105/net24 U3105/net30 U3105/net045 VDD pmos W=0.205u L=0.04u
M28962 U3105/net045 U3105/net32 VDD VDD pmos W=0.205u L=0.04u
M28963 U3106/net4 WX669 U3106/net14 VSS nmos W=0.155u L=0.04u
M28964 U3106/net6 U3106/net10 U3106/net14 VSS nmos W=0.17u L=0.04u
M28965 U3106/net4 n1377 VSS VSS nmos W=0.155u L=0.04u
M28966 U3106/net6 U3106/net4 VSS VSS nmos W=0.17u L=0.04u
M28967 n2329 U3106/net14 VSS VSS nmos W=0.155u L=0.04u
M28968 U3106/net10 WX669 VSS VSS nmos W=0.155u L=0.04u
M28969 U3106/net4 U3106/net10 U3106/net14 VDD pmos W=0.255u L=0.04u
M28970 U3106/net6 WX669 U3106/net14 VDD pmos W=0.28u L=0.04u
M28971 U3106/net4 n1377 VDD VDD pmos W=0.205u L=0.04u
M28972 U3106/net6 U3106/net4 VDD VDD pmos W=0.24u L=0.04u
M28973 n2329 U3106/net14 VDD VDD pmos W=0.205u L=0.04u
M28974 U3106/net10 WX669 VDD VDD pmos W=0.205u L=0.04u
M28975 U3107/net4 U3107/net10 U3107/net14 VSS nmos W=0.155u L=0.04u
M28976 U3107/net6 n2130 U3107/net14 VSS nmos W=0.155u L=0.04u
M28977 U3107/net4 n2330 VSS VSS nmos W=0.155u L=0.04u
M28978 U3107/net6 U3107/net4 VSS VSS nmos W=0.155u L=0.04u
M28979 WX1087 U3107/net14 VSS VSS nmos W=0.155u L=0.04u
M28980 U3107/net10 n2130 VSS VSS nmos W=0.155u L=0.04u
M28981 U3107/net4 n2130 U3107/net14 VDD pmos W=0.205u L=0.04u
M28982 U3107/net6 U3107/net10 U3107/net14 VDD pmos W=0.205u L=0.04u
M28983 U3107/net4 n2330 VDD VDD pmos W=0.205u L=0.04u
M28984 U3107/net6 U3107/net4 VDD VDD pmos W=0.205u L=0.04u
M28985 WX1087 U3107/net14 VDD VDD pmos W=0.205u L=0.04u
M28986 U3107/net10 n2130 VDD VDD pmos W=0.205u L=0.04u
M28987 U3108/XU1-net6 TM0 VSS VSS nmos W=0.155u L=0.04u
M28988 n2330 WX507 U3108/XU1-net6 VSS nmos W=0.155u L=0.04u
M28989 n2330 TM0 VDD VDD pmos W=0.155u L=0.04u
M28990 n2330 WX507 VDD VDD pmos W=0.155u L=0.04u
M28991 n2130 n2331 VSS VSS nmos W=0.135u L=0.04u
M28992 n2130 n2331 VDD VDD pmos W=0.205u L=0.04u
M28993 U3110/net28 U3110/net20 U3110/net64 VSS nmos W=0.155u L=0.04u
M28994 U3110/net24 U3110/net30 U3110/net32 VSS nmos W=0.155u L=0.04u
M28995 U3110/net28 U3110/net40 U3110/net24 VSS nmos W=0.155u L=0.04u
M28996 U3110/net40 n2332 U3110/net108 VSS nmos W=0.155u L=0.04u
M28997 U3110/net40 U3110/net106 U3110/net104 VSS nmos W=0.155u L=0.04u
M28998 U3110/net24 WX795 U3110/net050 VSS nmos W=0.155u L=0.04u
M28999 U3110/net050 U3110/net32 VSS VSS nmos W=0.155u L=0.04u
M29000 U3110/net20 U3110/net40 VSS VSS nmos W=0.155u L=0.04u
M29001 U3110/net106 n2332 VSS VSS nmos W=0.155u L=0.04u
M29002 U3110/net104 WX859 VSS VSS nmos W=0.155u L=0.04u
M29003 U3110/net30 WX795 VSS VSS nmos W=0.155u L=0.04u
M29004 U3110/net108 U3110/net104 VSS VSS nmos W=0.155u L=0.04u
M29005 n2331 U3110/net28 VSS VSS nmos W=0.155u L=0.04u
M29006 U3110/net32 WX731 VSS VSS nmos W=0.155u L=0.04u
M29007 U3110/net64 U3110/net24 VSS VSS nmos W=0.2u L=0.04u
M29008 U3110/net28 U3110/net40 U3110/net64 VDD pmos W=0.205u L=0.04u
M29009 U3110/net24 WX795 U3110/net32 VDD pmos W=0.205u L=0.04u
M29010 U3110/net28 U3110/net20 U3110/net24 VDD pmos W=0.205u L=0.04u
M29011 U3110/net40 U3110/net106 U3110/net108 VDD pmos W=0.205u L=0.04u
M29012 U3110/net40 n2332 U3110/net104 VDD pmos W=0.205u L=0.04u
M29013 U3110/net20 U3110/net40 VDD VDD pmos W=0.205u L=0.04u
M29014 U3110/net106 n2332 VDD VDD pmos W=0.205u L=0.04u
M29015 U3110/net104 WX859 VDD VDD pmos W=0.205u L=0.04u
M29016 U3110/net30 WX795 VDD VDD pmos W=0.205u L=0.04u
M29017 U3110/net108 U3110/net104 VDD VDD pmos W=0.205u L=0.04u
M29018 n2331 U3110/net28 VDD VDD pmos W=0.205u L=0.04u
M29019 U3110/net32 WX731 VDD VDD pmos W=0.205u L=0.04u
M29020 U3110/net64 U3110/net24 VDD VDD pmos W=0.28u L=0.04u
M29021 U3110/net24 U3110/net30 U3110/net045 VDD pmos W=0.205u L=0.04u
M29022 U3110/net045 U3110/net32 VDD VDD pmos W=0.205u L=0.04u
M29023 U3111/net4 WX667 U3111/net14 VSS nmos W=0.155u L=0.04u
M29024 U3111/net6 U3111/net10 U3111/net14 VSS nmos W=0.17u L=0.04u
M29025 U3111/net4 n1377 VSS VSS nmos W=0.155u L=0.04u
M29026 U3111/net6 U3111/net4 VSS VSS nmos W=0.17u L=0.04u
M29027 n2332 U3111/net14 VSS VSS nmos W=0.155u L=0.04u
M29028 U3111/net10 WX667 VSS VSS nmos W=0.155u L=0.04u
M29029 U3111/net4 U3111/net10 U3111/net14 VDD pmos W=0.255u L=0.04u
M29030 U3111/net6 WX667 U3111/net14 VDD pmos W=0.28u L=0.04u
M29031 U3111/net4 n1377 VDD VDD pmos W=0.205u L=0.04u
M29032 U3111/net6 U3111/net4 VDD VDD pmos W=0.24u L=0.04u
M29033 n2332 U3111/net14 VDD VDD pmos W=0.205u L=0.04u
M29034 U3111/net10 WX667 VDD VDD pmos W=0.205u L=0.04u
M29035 WX10816 n1244 U3112/net26 VSS nmos W=0.155u L=0.04u
M29036 WX10816 n1400 U3112/net26 VSS nmos W=0.155u L=0.04u
M29037 U3112/net29 n2334 VSS VSS nmos W=0.155u L=0.04u
M29038 U3112/net26 n2333 U3112/net29 VSS nmos W=0.155u L=0.04u
M29039 U3112/net26 n1615 U3112/net29 VSS nmos W=0.155u L=0.04u
M29040 WX10816 n1400 U3112/net43 VDD pmos W=0.205u L=0.04u
M29041 WX10816 n1615 U3112/net49 VDD pmos W=0.205u L=0.04u
M29042 U3112/net49 n2333 VDD VDD pmos W=0.205u L=0.04u
M29043 U3112/net43 n1244 VDD VDD pmos W=0.205u L=0.04u
M29044 WX10816 n2334 VDD VDD pmos W=0.205u L=0.04u
M29045 U3113/net29 n1345 VSS VSS nmos W=0.155u L=0.04u
M29046 n2334 WX10891 U3113/net29 VSS nmos W=0.155u L=0.04u
M29047 n2334 DATA_0_0 U3113/net23 VSS nmos W=0.155u L=0.04u
M29048 U3113/net23 n1617 VSS VSS nmos W=0.155u L=0.04u
M29049 U3113/net20 n1617 n2334 VDD pmos W=0.205u L=0.04u
M29050 U3113/net20 DATA_0_0 n2334 VDD pmos W=0.205u L=0.04u
M29051 VDD WX10891 U3113/net20 VDD pmos W=0.205u L=0.04u
M29052 VDD n1345 U3113/net20 VDD pmos W=0.205u L=0.04u
M29053 n2333 CRC_OUT_1_0 VSS VSS nmos W=0.135u L=0.04u
M29054 n2333 CRC_OUT_1_0 VDD VDD pmos W=0.205u L=0.04u
M29055 n1400 n2335 VSS VSS nmos W=0.135u L=0.04u
M29056 n1400 n2335 VDD VDD pmos W=0.205u L=0.04u
M29057 U3116/net28 U3116/net20 U3116/net64 VSS nmos W=0.155u L=0.04u
M29058 U3116/net24 U3116/net30 U3116/net32 VSS nmos W=0.155u L=0.04u
M29059 U3116/net28 U3116/net40 U3116/net24 VSS nmos W=0.155u L=0.04u
M29060 U3116/net40 WX11179 U3116/net108 VSS nmos W=0.155u L=0.04u
M29061 U3116/net40 U3116/net106 U3116/net104 VSS nmos W=0.155u L=0.04u
M29062 U3116/net24 WX11115 U3116/net050 VSS nmos W=0.155u L=0.04u
M29063 U3116/net050 U3116/net32 VSS VSS nmos W=0.155u L=0.04u
M29064 U3116/net20 U3116/net40 VSS VSS nmos W=0.155u L=0.04u
M29065 U3116/net106 WX11179 VSS VSS nmos W=0.155u L=0.04u
M29066 U3116/net104 WX11243 VSS VSS nmos W=0.155u L=0.04u
M29067 U3116/net30 WX11115 VSS VSS nmos W=0.155u L=0.04u
M29068 U3116/net108 U3116/net104 VSS VSS nmos W=0.155u L=0.04u
M29069 n2335 U3116/net28 VSS VSS nmos W=0.155u L=0.04u
M29070 U3116/net32 WX11051 VSS VSS nmos W=0.155u L=0.04u
M29071 U3116/net64 U3116/net24 VSS VSS nmos W=0.2u L=0.04u
M29072 U3116/net28 U3116/net40 U3116/net64 VDD pmos W=0.205u L=0.04u
M29073 U3116/net24 WX11115 U3116/net32 VDD pmos W=0.205u L=0.04u
M29074 U3116/net28 U3116/net20 U3116/net24 VDD pmos W=0.205u L=0.04u
M29075 U3116/net40 U3116/net106 U3116/net108 VDD pmos W=0.205u L=0.04u
M29076 U3116/net40 WX11179 U3116/net104 VDD pmos W=0.205u L=0.04u
M29077 U3116/net20 U3116/net40 VDD VDD pmos W=0.205u L=0.04u
M29078 U3116/net106 WX11179 VDD VDD pmos W=0.205u L=0.04u
M29079 U3116/net104 WX11243 VDD VDD pmos W=0.205u L=0.04u
M29080 U3116/net30 WX11115 VDD VDD pmos W=0.205u L=0.04u
M29081 U3116/net108 U3116/net104 VDD VDD pmos W=0.205u L=0.04u
M29082 n2335 U3116/net28 VDD VDD pmos W=0.205u L=0.04u
M29083 U3116/net32 WX11051 VDD VDD pmos W=0.205u L=0.04u
M29084 U3116/net64 U3116/net24 VDD VDD pmos W=0.28u L=0.04u
M29085 U3116/net24 U3116/net30 U3116/net045 VDD pmos W=0.205u L=0.04u
M29086 U3116/net045 U3116/net32 VDD VDD pmos W=0.205u L=0.04u
M29087 WX10802 n1244 U3117/net26 VSS nmos W=0.155u L=0.04u
M29088 WX10802 n1406 U3117/net26 VSS nmos W=0.155u L=0.04u
M29089 U3117/net29 n2337 VSS VSS nmos W=0.155u L=0.04u
M29090 U3117/net26 n2336 U3117/net29 VSS nmos W=0.155u L=0.04u
M29091 U3117/net26 n1615 U3117/net29 VSS nmos W=0.155u L=0.04u
M29092 WX10802 n1406 U3117/net43 VDD pmos W=0.205u L=0.04u
M29093 WX10802 n1615 U3117/net49 VDD pmos W=0.205u L=0.04u
M29094 U3117/net49 n2336 VDD VDD pmos W=0.205u L=0.04u
M29095 U3117/net43 n1244 VDD VDD pmos W=0.205u L=0.04u
M29096 WX10802 n2337 VDD VDD pmos W=0.205u L=0.04u
M29097 U3118/net29 n1345 VSS VSS nmos W=0.155u L=0.04u
M29098 n2337 WX10889 U3118/net29 VSS nmos W=0.155u L=0.04u
M29099 n2337 DATA_0_1 U3118/net23 VSS nmos W=0.155u L=0.04u
M29100 U3118/net23 n1617 VSS VSS nmos W=0.155u L=0.04u
M29101 U3118/net20 n1617 n2337 VDD pmos W=0.205u L=0.04u
M29102 U3118/net20 DATA_0_1 n2337 VDD pmos W=0.205u L=0.04u
M29103 VDD WX10889 U3118/net20 VDD pmos W=0.205u L=0.04u
M29104 VDD n1345 U3118/net20 VDD pmos W=0.205u L=0.04u
M29105 n2336 CRC_OUT_1_1 VSS VSS nmos W=0.135u L=0.04u
M29106 n2336 CRC_OUT_1_1 VDD VDD pmos W=0.205u L=0.04u
M29107 U3120/net28 U3120/net20 U3120/net64 VSS nmos W=0.155u L=0.04u
M29108 U3120/net24 U3120/net30 U3120/net32 VSS nmos W=0.155u L=0.04u
M29109 U3120/net28 U3120/net40 U3120/net24 VSS nmos W=0.155u L=0.04u
M29110 U3120/net40 WX11177 U3120/net108 VSS nmos W=0.155u L=0.04u
M29111 U3120/net40 U3120/net106 U3120/net104 VSS nmos W=0.155u L=0.04u
M29112 U3120/net24 n2338 U3120/net050 VSS nmos W=0.155u L=0.04u
M29113 U3120/net050 U3120/net32 VSS VSS nmos W=0.155u L=0.04u
M29114 U3120/net20 U3120/net40 VSS VSS nmos W=0.155u L=0.04u
M29115 U3120/net106 WX11177 VSS VSS nmos W=0.155u L=0.04u
M29116 U3120/net104 WX11241 VSS VSS nmos W=0.155u L=0.04u
M29117 U3120/net30 n2338 VSS VSS nmos W=0.155u L=0.04u
M29118 U3120/net108 U3120/net104 VSS VSS nmos W=0.155u L=0.04u
M29119 n1406 U3120/net28 VSS VSS nmos W=0.155u L=0.04u
M29120 U3120/net32 WX11049 VSS VSS nmos W=0.155u L=0.04u
M29121 U3120/net64 U3120/net24 VSS VSS nmos W=0.2u L=0.04u
M29122 U3120/net28 U3120/net40 U3120/net64 VDD pmos W=0.205u L=0.04u
M29123 U3120/net24 n2338 U3120/net32 VDD pmos W=0.205u L=0.04u
M29124 U3120/net28 U3120/net20 U3120/net24 VDD pmos W=0.205u L=0.04u
M29125 U3120/net40 U3120/net106 U3120/net108 VDD pmos W=0.205u L=0.04u
M29126 U3120/net40 WX11177 U3120/net104 VDD pmos W=0.205u L=0.04u
M29127 U3120/net20 U3120/net40 VDD VDD pmos W=0.205u L=0.04u
M29128 U3120/net106 WX11177 VDD VDD pmos W=0.205u L=0.04u
M29129 U3120/net104 WX11241 VDD VDD pmos W=0.205u L=0.04u
M29130 U3120/net30 n2338 VDD VDD pmos W=0.205u L=0.04u
M29131 U3120/net108 U3120/net104 VDD VDD pmos W=0.205u L=0.04u
M29132 n1406 U3120/net28 VDD VDD pmos W=0.205u L=0.04u
M29133 U3120/net32 WX11049 VDD VDD pmos W=0.205u L=0.04u
M29134 U3120/net64 U3120/net24 VDD VDD pmos W=0.28u L=0.04u
M29135 U3120/net24 U3120/net30 U3120/net045 VDD pmos W=0.205u L=0.04u
M29136 U3120/net045 U3120/net32 VDD VDD pmos W=0.205u L=0.04u
M29137 n2338 WX11113 VSS VSS nmos W=0.135u L=0.04u
M29138 n2338 WX11113 VDD VDD pmos W=0.205u L=0.04u
M29139 U3122/net4 U3122/net10 U3122/net14 VSS nmos W=0.155u L=0.04u
M29140 U3122/net6 n2133 U3122/net14 VSS nmos W=0.155u L=0.04u
M29141 U3122/net4 n2339 VSS VSS nmos W=0.155u L=0.04u
M29142 U3122/net6 U3122/net4 VSS VSS nmos W=0.155u L=0.04u
M29143 WX1080 U3122/net14 VSS VSS nmos W=0.155u L=0.04u
M29144 U3122/net10 n2133 VSS VSS nmos W=0.155u L=0.04u
M29145 U3122/net4 n2133 U3122/net14 VDD pmos W=0.205u L=0.04u
M29146 U3122/net6 U3122/net10 U3122/net14 VDD pmos W=0.205u L=0.04u
M29147 U3122/net4 n2339 VDD VDD pmos W=0.205u L=0.04u
M29148 U3122/net6 U3122/net4 VDD VDD pmos W=0.205u L=0.04u
M29149 WX1080 U3122/net14 VDD VDD pmos W=0.205u L=0.04u
M29150 U3122/net10 n2133 VDD VDD pmos W=0.205u L=0.04u
M29151 U3123/XU1-net6 TM0 VSS VSS nmos W=0.155u L=0.04u
M29152 n2339 WX505 U3123/XU1-net6 VSS nmos W=0.155u L=0.04u
M29153 n2339 TM0 VDD VDD pmos W=0.155u L=0.04u
M29154 n2339 WX505 VDD VDD pmos W=0.155u L=0.04u
M29155 n2133 n2340 VSS VSS nmos W=0.135u L=0.04u
M29156 n2133 n2340 VDD VDD pmos W=0.205u L=0.04u
M29157 U3125/net28 U3125/net20 U3125/net64 VSS nmos W=0.155u L=0.04u
M29158 U3125/net24 U3125/net30 U3125/net32 VSS nmos W=0.155u L=0.04u
M29159 U3125/net28 U3125/net40 U3125/net24 VSS nmos W=0.155u L=0.04u
M29160 U3125/net40 n2341 U3125/net108 VSS nmos W=0.155u L=0.04u
M29161 U3125/net40 U3125/net106 U3125/net104 VSS nmos W=0.155u L=0.04u
M29162 U3125/net24 WX793 U3125/net050 VSS nmos W=0.155u L=0.04u
M29163 U3125/net050 U3125/net32 VSS VSS nmos W=0.155u L=0.04u
M29164 U3125/net20 U3125/net40 VSS VSS nmos W=0.155u L=0.04u
M29165 U3125/net106 n2341 VSS VSS nmos W=0.155u L=0.04u
M29166 U3125/net104 WX857 VSS VSS nmos W=0.155u L=0.04u
M29167 U3125/net30 WX793 VSS VSS nmos W=0.155u L=0.04u
M29168 U3125/net108 U3125/net104 VSS VSS nmos W=0.155u L=0.04u
M29169 n2340 U3125/net28 VSS VSS nmos W=0.155u L=0.04u
M29170 U3125/net32 WX729 VSS VSS nmos W=0.155u L=0.04u
M29171 U3125/net64 U3125/net24 VSS VSS nmos W=0.2u L=0.04u
M29172 U3125/net28 U3125/net40 U3125/net64 VDD pmos W=0.205u L=0.04u
M29173 U3125/net24 WX793 U3125/net32 VDD pmos W=0.205u L=0.04u
M29174 U3125/net28 U3125/net20 U3125/net24 VDD pmos W=0.205u L=0.04u
M29175 U3125/net40 U3125/net106 U3125/net108 VDD pmos W=0.205u L=0.04u
M29176 U3125/net40 n2341 U3125/net104 VDD pmos W=0.205u L=0.04u
M29177 U3125/net20 U3125/net40 VDD VDD pmos W=0.205u L=0.04u
M29178 U3125/net106 n2341 VDD VDD pmos W=0.205u L=0.04u
M29179 U3125/net104 WX857 VDD VDD pmos W=0.205u L=0.04u
M29180 U3125/net30 WX793 VDD VDD pmos W=0.205u L=0.04u
M29181 U3125/net108 U3125/net104 VDD VDD pmos W=0.205u L=0.04u
M29182 n2340 U3125/net28 VDD VDD pmos W=0.205u L=0.04u
M29183 U3125/net32 WX729 VDD VDD pmos W=0.205u L=0.04u
M29184 U3125/net64 U3125/net24 VDD VDD pmos W=0.28u L=0.04u
M29185 U3125/net24 U3125/net30 U3125/net045 VDD pmos W=0.205u L=0.04u
M29186 U3125/net045 U3125/net32 VDD VDD pmos W=0.205u L=0.04u
M29187 U3126/net4 WX665 U3126/net14 VSS nmos W=0.155u L=0.04u
M29188 U3126/net6 U3126/net10 U3126/net14 VSS nmos W=0.17u L=0.04u
M29189 U3126/net4 n1377 VSS VSS nmos W=0.155u L=0.04u
M29190 U3126/net6 U3126/net4 VSS VSS nmos W=0.17u L=0.04u
M29191 n2341 U3126/net14 VSS VSS nmos W=0.155u L=0.04u
M29192 U3126/net10 WX665 VSS VSS nmos W=0.155u L=0.04u
M29193 U3126/net4 U3126/net10 U3126/net14 VDD pmos W=0.255u L=0.04u
M29194 U3126/net6 WX665 U3126/net14 VDD pmos W=0.28u L=0.04u
M29195 U3126/net4 n1377 VDD VDD pmos W=0.205u L=0.04u
M29196 U3126/net6 U3126/net4 VDD VDD pmos W=0.24u L=0.04u
M29197 n2341 U3126/net14 VDD VDD pmos W=0.205u L=0.04u
M29198 U3126/net10 WX665 VDD VDD pmos W=0.205u L=0.04u
M29199 WX108 n1284 U3127/net26 VSS nmos W=0.155u L=0.04u
M29200 WX108 n2235 U3127/net26 VSS nmos W=0.155u L=0.04u
M29201 U3127/net29 n2343 VSS VSS nmos W=0.155u L=0.04u
M29202 U3127/net26 n2342 U3127/net29 VSS nmos W=0.155u L=0.04u
M29203 U3127/net26 n1257 U3127/net29 VSS nmos W=0.155u L=0.04u
M29204 WX108 n2235 U3127/net43 VDD pmos W=0.205u L=0.04u
M29205 WX108 n1257 U3127/net49 VDD pmos W=0.205u L=0.04u
M29206 U3127/net49 n2342 VDD VDD pmos W=0.205u L=0.04u
M29207 U3127/net43 n1284 VDD VDD pmos W=0.205u L=0.04u
M29208 WX108 n2343 VDD VDD pmos W=0.205u L=0.04u
M29209 U3128/net29 n1345 VSS VSS nmos W=0.155u L=0.04u
M29210 n2343 WX495 U3128/net29 VSS nmos W=0.155u L=0.04u
M29211 n2343 n1317 U3128/net23 VSS nmos W=0.155u L=0.04u
M29212 U3128/net23 CRC_OUT_9_26 VSS VSS nmos W=0.155u L=0.04u
M29213 U3128/net20 CRC_OUT_9_26 n2343 VDD pmos W=0.205u L=0.04u
M29214 U3128/net20 n1317 n2343 VDD pmos W=0.205u L=0.04u
M29215 VDD WX495 U3128/net20 VDD pmos W=0.205u L=0.04u
M29216 VDD n1345 U3128/net20 VDD pmos W=0.205u L=0.04u
M29217 n1401 n1617 VSS VSS nmos W=0.135u L=0.04u
M29218 n1401 n1617 VDD VDD pmos W=0.205u L=0.04u
M29219 n2235 n2344 VSS VSS nmos W=0.135u L=0.04u
M29220 n2235 n2344 VDD VDD pmos W=0.205u L=0.04u
M29221 U3131/net28 U3131/net20 U3131/net64 VSS nmos W=0.155u L=0.04u
M29222 U3131/net24 U3131/net30 U3131/net32 VSS nmos W=0.155u L=0.04u
M29223 U3131/net28 U3131/net40 U3131/net24 VSS nmos W=0.155u L=0.04u
M29224 U3131/net40 n2345 U3131/net108 VSS nmos W=0.155u L=0.04u
M29225 U3131/net40 U3131/net106 U3131/net104 VSS nmos W=0.155u L=0.04u
M29226 U3131/net24 WX2076 U3131/net050 VSS nmos W=0.155u L=0.04u
M29227 U3131/net050 U3131/net32 VSS VSS nmos W=0.155u L=0.04u
M29228 U3131/net20 U3131/net40 VSS VSS nmos W=0.155u L=0.04u
M29229 U3131/net106 n2345 VSS VSS nmos W=0.155u L=0.04u
M29230 U3131/net104 WX2140 VSS VSS nmos W=0.155u L=0.04u
M29231 U3131/net30 WX2076 VSS VSS nmos W=0.155u L=0.04u
M29232 U3131/net108 U3131/net104 VSS VSS nmos W=0.155u L=0.04u
M29233 n2344 U3131/net28 VSS VSS nmos W=0.155u L=0.04u
M29234 U3131/net32 WX2012 VSS VSS nmos W=0.155u L=0.04u
M29235 U3131/net64 U3131/net24 VSS VSS nmos W=0.2u L=0.04u
M29236 U3131/net28 U3131/net40 U3131/net64 VDD pmos W=0.205u L=0.04u
M29237 U3131/net24 WX2076 U3131/net32 VDD pmos W=0.205u L=0.04u
M29238 U3131/net28 U3131/net20 U3131/net24 VDD pmos W=0.205u L=0.04u
M29239 U3131/net40 U3131/net106 U3131/net108 VDD pmos W=0.205u L=0.04u
M29240 U3131/net40 n2345 U3131/net104 VDD pmos W=0.205u L=0.04u
M29241 U3131/net20 U3131/net40 VDD VDD pmos W=0.205u L=0.04u
M29242 U3131/net106 n2345 VDD VDD pmos W=0.205u L=0.04u
M29243 U3131/net104 WX2140 VDD VDD pmos W=0.205u L=0.04u
M29244 U3131/net30 WX2076 VDD VDD pmos W=0.205u L=0.04u
M29245 U3131/net108 U3131/net104 VDD VDD pmos W=0.205u L=0.04u
M29246 n2344 U3131/net28 VDD VDD pmos W=0.205u L=0.04u
M29247 U3131/net32 WX2012 VDD VDD pmos W=0.205u L=0.04u
M29248 U3131/net64 U3131/net24 VDD VDD pmos W=0.28u L=0.04u
M29249 U3131/net24 U3131/net30 U3131/net045 VDD pmos W=0.205u L=0.04u
M29250 U3131/net045 U3131/net32 VDD VDD pmos W=0.205u L=0.04u
M29251 U3132/net4 WX1948 U3132/net14 VSS nmos W=0.155u L=0.04u
M29252 U3132/net6 U3132/net10 U3132/net14 VSS nmos W=0.17u L=0.04u
M29253 U3132/net4 n1377 VSS VSS nmos W=0.155u L=0.04u
M29254 U3132/net6 U3132/net4 VSS VSS nmos W=0.17u L=0.04u
M29255 n2345 U3132/net14 VSS VSS nmos W=0.155u L=0.04u
M29256 U3132/net10 WX1948 VSS VSS nmos W=0.155u L=0.04u
M29257 U3132/net4 U3132/net10 U3132/net14 VDD pmos W=0.255u L=0.04u
M29258 U3132/net6 WX1948 U3132/net14 VDD pmos W=0.28u L=0.04u
M29259 U3132/net4 n1377 VDD VDD pmos W=0.205u L=0.04u
M29260 U3132/net6 U3132/net4 VDD VDD pmos W=0.24u L=0.04u
M29261 n2345 U3132/net14 VDD VDD pmos W=0.205u L=0.04u
M29262 U3132/net10 WX1948 VDD VDD pmos W=0.205u L=0.04u
M29263 WX10788 n1244 U3133/net26 VSS nmos W=0.155u L=0.04u
M29264 WX10788 n1409 U3133/net26 VSS nmos W=0.155u L=0.04u
M29265 U3133/net29 n2347 VSS VSS nmos W=0.155u L=0.04u
M29266 U3133/net26 n2346 U3133/net29 VSS nmos W=0.155u L=0.04u
M29267 U3133/net26 n1615 U3133/net29 VSS nmos W=0.155u L=0.04u
M29268 WX10788 n1409 U3133/net43 VDD pmos W=0.205u L=0.04u
M29269 WX10788 n1615 U3133/net49 VDD pmos W=0.205u L=0.04u
M29270 U3133/net49 n2346 VDD VDD pmos W=0.205u L=0.04u
M29271 U3133/net43 n1244 VDD VDD pmos W=0.205u L=0.04u
M29272 WX10788 n2347 VDD VDD pmos W=0.205u L=0.04u
M29273 U3134/net29 n1345 VSS VSS nmos W=0.155u L=0.04u
M29274 n2347 WX10887 U3134/net29 VSS nmos W=0.155u L=0.04u
M29275 n2347 DATA_0_2 U3134/net23 VSS nmos W=0.155u L=0.04u
M29276 U3134/net23 n1617 VSS VSS nmos W=0.155u L=0.04u
M29277 U3134/net20 n1617 n2347 VDD pmos W=0.205u L=0.04u
M29278 U3134/net20 DATA_0_2 n2347 VDD pmos W=0.205u L=0.04u
M29279 VDD WX10887 U3134/net20 VDD pmos W=0.205u L=0.04u
M29280 VDD n1345 U3134/net20 VDD pmos W=0.205u L=0.04u
M29281 n2346 CRC_OUT_1_2 VSS VSS nmos W=0.135u L=0.04u
M29282 n2346 CRC_OUT_1_2 VDD VDD pmos W=0.205u L=0.04u
M29283 U3136/net28 U3136/net20 U3136/net64 VSS nmos W=0.155u L=0.04u
M29284 U3136/net24 U3136/net30 U3136/net32 VSS nmos W=0.155u L=0.04u
M29285 U3136/net28 U3136/net40 U3136/net24 VSS nmos W=0.155u L=0.04u
M29286 U3136/net40 WX11175 U3136/net108 VSS nmos W=0.155u L=0.04u
M29287 U3136/net40 U3136/net106 U3136/net104 VSS nmos W=0.155u L=0.04u
M29288 U3136/net24 n2348 U3136/net050 VSS nmos W=0.155u L=0.04u
M29289 U3136/net050 U3136/net32 VSS VSS nmos W=0.155u L=0.04u
M29290 U3136/net20 U3136/net40 VSS VSS nmos W=0.155u L=0.04u
M29291 U3136/net106 WX11175 VSS VSS nmos W=0.155u L=0.04u
M29292 U3136/net104 WX11239 VSS VSS nmos W=0.155u L=0.04u
M29293 U3136/net30 n2348 VSS VSS nmos W=0.155u L=0.04u
M29294 U3136/net108 U3136/net104 VSS VSS nmos W=0.155u L=0.04u
M29295 n1409 U3136/net28 VSS VSS nmos W=0.155u L=0.04u
M29296 U3136/net32 WX11047 VSS VSS nmos W=0.155u L=0.04u
M29297 U3136/net64 U3136/net24 VSS VSS nmos W=0.2u L=0.04u
M29298 U3136/net28 U3136/net40 U3136/net64 VDD pmos W=0.205u L=0.04u
M29299 U3136/net24 n2348 U3136/net32 VDD pmos W=0.205u L=0.04u
M29300 U3136/net28 U3136/net20 U3136/net24 VDD pmos W=0.205u L=0.04u
M29301 U3136/net40 U3136/net106 U3136/net108 VDD pmos W=0.205u L=0.04u
M29302 U3136/net40 WX11175 U3136/net104 VDD pmos W=0.205u L=0.04u
M29303 U3136/net20 U3136/net40 VDD VDD pmos W=0.205u L=0.04u
M29304 U3136/net106 WX11175 VDD VDD pmos W=0.205u L=0.04u
M29305 U3136/net104 WX11239 VDD VDD pmos W=0.205u L=0.04u
M29306 U3136/net30 n2348 VDD VDD pmos W=0.205u L=0.04u
M29307 U3136/net108 U3136/net104 VDD VDD pmos W=0.205u L=0.04u
M29308 n1409 U3136/net28 VDD VDD pmos W=0.205u L=0.04u
M29309 U3136/net32 WX11047 VDD VDD pmos W=0.205u L=0.04u
M29310 U3136/net64 U3136/net24 VDD VDD pmos W=0.28u L=0.04u
M29311 U3136/net24 U3136/net30 U3136/net045 VDD pmos W=0.205u L=0.04u
M29312 U3136/net045 U3136/net32 VDD VDD pmos W=0.205u L=0.04u
M29313 n2348 WX11111 VSS VSS nmos W=0.135u L=0.04u
M29314 n2348 WX11111 VDD VDD pmos W=0.205u L=0.04u
M29315 WX10774 n1244 U3138/net26 VSS nmos W=0.155u L=0.04u
M29316 WX10774 n1412 U3138/net26 VSS nmos W=0.155u L=0.04u
M29317 U3138/net29 n2350 VSS VSS nmos W=0.155u L=0.04u
M29318 U3138/net26 n2349 U3138/net29 VSS nmos W=0.155u L=0.04u
M29319 U3138/net26 n1615 U3138/net29 VSS nmos W=0.155u L=0.04u
M29320 WX10774 n1412 U3138/net43 VDD pmos W=0.205u L=0.04u
M29321 WX10774 n1615 U3138/net49 VDD pmos W=0.205u L=0.04u
M29322 U3138/net49 n2349 VDD VDD pmos W=0.205u L=0.04u
M29323 U3138/net43 n1244 VDD VDD pmos W=0.205u L=0.04u
M29324 WX10774 n2350 VDD VDD pmos W=0.205u L=0.04u
M29325 U3139/net29 n1345 VSS VSS nmos W=0.155u L=0.04u
M29326 n2350 WX10885 U3139/net29 VSS nmos W=0.155u L=0.04u
M29327 n2350 DATA_0_3 U3139/net23 VSS nmos W=0.155u L=0.04u
M29328 U3139/net23 n1617 VSS VSS nmos W=0.155u L=0.04u
M29329 U3139/net20 n1617 n2350 VDD pmos W=0.205u L=0.04u
M29330 U3139/net20 DATA_0_3 n2350 VDD pmos W=0.205u L=0.04u
M29331 VDD WX10885 U3139/net20 VDD pmos W=0.205u L=0.04u
M29332 VDD n1345 U3139/net20 VDD pmos W=0.205u L=0.04u
M29333 n2349 CRC_OUT_1_3 VSS VSS nmos W=0.135u L=0.04u
M29334 n2349 CRC_OUT_1_3 VDD VDD pmos W=0.205u L=0.04u
M29335 U3141/net28 U3141/net20 U3141/net64 VSS nmos W=0.155u L=0.04u
M29336 U3141/net24 U3141/net30 U3141/net32 VSS nmos W=0.155u L=0.04u
M29337 U3141/net28 U3141/net40 U3141/net24 VSS nmos W=0.155u L=0.04u
M29338 U3141/net40 WX11173 U3141/net108 VSS nmos W=0.155u L=0.04u
M29339 U3141/net40 U3141/net106 U3141/net104 VSS nmos W=0.155u L=0.04u
M29340 U3141/net24 n2351 U3141/net050 VSS nmos W=0.155u L=0.04u
M29341 U3141/net050 U3141/net32 VSS VSS nmos W=0.155u L=0.04u
M29342 U3141/net20 U3141/net40 VSS VSS nmos W=0.155u L=0.04u
M29343 U3141/net106 WX11173 VSS VSS nmos W=0.155u L=0.04u
M29344 U3141/net104 WX11237 VSS VSS nmos W=0.155u L=0.04u
M29345 U3141/net30 n2351 VSS VSS nmos W=0.155u L=0.04u
M29346 U3141/net108 U3141/net104 VSS VSS nmos W=0.155u L=0.04u
M29347 n1412 U3141/net28 VSS VSS nmos W=0.155u L=0.04u
M29348 U3141/net32 WX11045 VSS VSS nmos W=0.155u L=0.04u
M29349 U3141/net64 U3141/net24 VSS VSS nmos W=0.2u L=0.04u
M29350 U3141/net28 U3141/net40 U3141/net64 VDD pmos W=0.205u L=0.04u
M29351 U3141/net24 n2351 U3141/net32 VDD pmos W=0.205u L=0.04u
M29352 U3141/net28 U3141/net20 U3141/net24 VDD pmos W=0.205u L=0.04u
M29353 U3141/net40 U3141/net106 U3141/net108 VDD pmos W=0.205u L=0.04u
M29354 U3141/net40 WX11173 U3141/net104 VDD pmos W=0.205u L=0.04u
M29355 U3141/net20 U3141/net40 VDD VDD pmos W=0.205u L=0.04u
M29356 U3141/net106 WX11173 VDD VDD pmos W=0.205u L=0.04u
M29357 U3141/net104 WX11237 VDD VDD pmos W=0.205u L=0.04u
M29358 U3141/net30 n2351 VDD VDD pmos W=0.205u L=0.04u
M29359 U3141/net108 U3141/net104 VDD VDD pmos W=0.205u L=0.04u
M29360 n1412 U3141/net28 VDD VDD pmos W=0.205u L=0.04u
M29361 U3141/net32 WX11045 VDD VDD pmos W=0.205u L=0.04u
M29362 U3141/net64 U3141/net24 VDD VDD pmos W=0.28u L=0.04u
M29363 U3141/net24 U3141/net30 U3141/net045 VDD pmos W=0.205u L=0.04u
M29364 U3141/net045 U3141/net32 VDD VDD pmos W=0.205u L=0.04u
M29365 n2351 WX11109 VSS VSS nmos W=0.135u L=0.04u
M29366 n2351 WX11109 VDD VDD pmos W=0.205u L=0.04u
M29367 WX10760 n1244 U3143/net26 VSS nmos W=0.155u L=0.04u
M29368 WX10760 n1415 U3143/net26 VSS nmos W=0.155u L=0.04u
M29369 U3143/net29 n2353 VSS VSS nmos W=0.155u L=0.04u
M29370 U3143/net26 n2352 U3143/net29 VSS nmos W=0.155u L=0.04u
M29371 U3143/net26 n1615 U3143/net29 VSS nmos W=0.155u L=0.04u
M29372 WX10760 n1415 U3143/net43 VDD pmos W=0.205u L=0.04u
M29373 WX10760 n1615 U3143/net49 VDD pmos W=0.205u L=0.04u
M29374 U3143/net49 n2352 VDD VDD pmos W=0.205u L=0.04u
M29375 U3143/net43 n1244 VDD VDD pmos W=0.205u L=0.04u
M29376 WX10760 n2353 VDD VDD pmos W=0.205u L=0.04u
M29377 U3144/net29 n1345 VSS VSS nmos W=0.155u L=0.04u
M29378 n2353 WX10883 U3144/net29 VSS nmos W=0.155u L=0.04u
M29379 n2353 DATA_0_4 U3144/net23 VSS nmos W=0.155u L=0.04u
M29380 U3144/net23 n1617 VSS VSS nmos W=0.155u L=0.04u
M29381 U3144/net20 n1617 n2353 VDD pmos W=0.205u L=0.04u
M29382 U3144/net20 DATA_0_4 n2353 VDD pmos W=0.205u L=0.04u
M29383 VDD WX10883 U3144/net20 VDD pmos W=0.205u L=0.04u
M29384 VDD n1345 U3144/net20 VDD pmos W=0.205u L=0.04u
M29385 n2352 CRC_OUT_1_4 VSS VSS nmos W=0.135u L=0.04u
M29386 n2352 CRC_OUT_1_4 VDD VDD pmos W=0.205u L=0.04u
M29387 U3146/net28 U3146/net20 U3146/net64 VSS nmos W=0.155u L=0.04u
M29388 U3146/net24 U3146/net30 U3146/net32 VSS nmos W=0.155u L=0.04u
M29389 U3146/net28 U3146/net40 U3146/net24 VSS nmos W=0.155u L=0.04u
M29390 U3146/net40 WX11171 U3146/net108 VSS nmos W=0.155u L=0.04u
M29391 U3146/net40 U3146/net106 U3146/net104 VSS nmos W=0.155u L=0.04u
M29392 U3146/net24 n2354 U3146/net050 VSS nmos W=0.155u L=0.04u
M29393 U3146/net050 U3146/net32 VSS VSS nmos W=0.155u L=0.04u
M29394 U3146/net20 U3146/net40 VSS VSS nmos W=0.155u L=0.04u
M29395 U3146/net106 WX11171 VSS VSS nmos W=0.155u L=0.04u
M29396 U3146/net104 WX11235 VSS VSS nmos W=0.155u L=0.04u
M29397 U3146/net30 n2354 VSS VSS nmos W=0.155u L=0.04u
M29398 U3146/net108 U3146/net104 VSS VSS nmos W=0.155u L=0.04u
M29399 n1415 U3146/net28 VSS VSS nmos W=0.155u L=0.04u
M29400 U3146/net32 WX11043 VSS VSS nmos W=0.155u L=0.04u
M29401 U3146/net64 U3146/net24 VSS VSS nmos W=0.2u L=0.04u
M29402 U3146/net28 U3146/net40 U3146/net64 VDD pmos W=0.205u L=0.04u
M29403 U3146/net24 n2354 U3146/net32 VDD pmos W=0.205u L=0.04u
M29404 U3146/net28 U3146/net20 U3146/net24 VDD pmos W=0.205u L=0.04u
M29405 U3146/net40 U3146/net106 U3146/net108 VDD pmos W=0.205u L=0.04u
M29406 U3146/net40 WX11171 U3146/net104 VDD pmos W=0.205u L=0.04u
M29407 U3146/net20 U3146/net40 VDD VDD pmos W=0.205u L=0.04u
M29408 U3146/net106 WX11171 VDD VDD pmos W=0.205u L=0.04u
M29409 U3146/net104 WX11235 VDD VDD pmos W=0.205u L=0.04u
M29410 U3146/net30 n2354 VDD VDD pmos W=0.205u L=0.04u
M29411 U3146/net108 U3146/net104 VDD VDD pmos W=0.205u L=0.04u
M29412 n1415 U3146/net28 VDD VDD pmos W=0.205u L=0.04u
M29413 U3146/net32 WX11043 VDD VDD pmos W=0.205u L=0.04u
M29414 U3146/net64 U3146/net24 VDD VDD pmos W=0.28u L=0.04u
M29415 U3146/net24 U3146/net30 U3146/net045 VDD pmos W=0.205u L=0.04u
M29416 U3146/net045 U3146/net32 VDD VDD pmos W=0.205u L=0.04u
M29417 n2354 WX11107 VSS VSS nmos W=0.135u L=0.04u
M29418 n2354 WX11107 VDD VDD pmos W=0.205u L=0.04u
M29419 WX10746 n1244 U3148/net26 VSS nmos W=0.155u L=0.04u
M29420 WX10746 n1418 U3148/net26 VSS nmos W=0.155u L=0.04u
M29421 U3148/net29 n2356 VSS VSS nmos W=0.155u L=0.04u
M29422 U3148/net26 n2355 U3148/net29 VSS nmos W=0.155u L=0.04u
M29423 U3148/net26 n1615 U3148/net29 VSS nmos W=0.155u L=0.04u
M29424 WX10746 n1418 U3148/net43 VDD pmos W=0.205u L=0.04u
M29425 WX10746 n1615 U3148/net49 VDD pmos W=0.205u L=0.04u
M29426 U3148/net49 n2355 VDD VDD pmos W=0.205u L=0.04u
M29427 U3148/net43 n1244 VDD VDD pmos W=0.205u L=0.04u
M29428 WX10746 n2356 VDD VDD pmos W=0.205u L=0.04u
M29429 U3149/net29 n1345 VSS VSS nmos W=0.155u L=0.04u
M29430 n2356 WX10881 U3149/net29 VSS nmos W=0.155u L=0.04u
M29431 n2356 DATA_0_5 U3149/net23 VSS nmos W=0.155u L=0.04u
M29432 U3149/net23 n1617 VSS VSS nmos W=0.155u L=0.04u
M29433 U3149/net20 n1617 n2356 VDD pmos W=0.205u L=0.04u
M29434 U3149/net20 DATA_0_5 n2356 VDD pmos W=0.205u L=0.04u
M29435 VDD WX10881 U3149/net20 VDD pmos W=0.205u L=0.04u
M29436 VDD n1345 U3149/net20 VDD pmos W=0.205u L=0.04u
M29437 n2355 CRC_OUT_1_5 VSS VSS nmos W=0.135u L=0.04u
M29438 n2355 CRC_OUT_1_5 VDD VDD pmos W=0.205u L=0.04u
M29439 U3151/net28 U3151/net20 U3151/net64 VSS nmos W=0.155u L=0.04u
M29440 U3151/net24 U3151/net30 U3151/net32 VSS nmos W=0.155u L=0.04u
M29441 U3151/net28 U3151/net40 U3151/net24 VSS nmos W=0.155u L=0.04u
M29442 U3151/net40 WX11169 U3151/net108 VSS nmos W=0.155u L=0.04u
M29443 U3151/net40 U3151/net106 U3151/net104 VSS nmos W=0.155u L=0.04u
M29444 U3151/net24 n2357 U3151/net050 VSS nmos W=0.155u L=0.04u
M29445 U3151/net050 U3151/net32 VSS VSS nmos W=0.155u L=0.04u
M29446 U3151/net20 U3151/net40 VSS VSS nmos W=0.155u L=0.04u
M29447 U3151/net106 WX11169 VSS VSS nmos W=0.155u L=0.04u
M29448 U3151/net104 WX11233 VSS VSS nmos W=0.155u L=0.04u
M29449 U3151/net30 n2357 VSS VSS nmos W=0.155u L=0.04u
M29450 U3151/net108 U3151/net104 VSS VSS nmos W=0.155u L=0.04u
M29451 n1418 U3151/net28 VSS VSS nmos W=0.155u L=0.04u
M29452 U3151/net32 WX11041 VSS VSS nmos W=0.155u L=0.04u
M29453 U3151/net64 U3151/net24 VSS VSS nmos W=0.2u L=0.04u
M29454 U3151/net28 U3151/net40 U3151/net64 VDD pmos W=0.205u L=0.04u
M29455 U3151/net24 n2357 U3151/net32 VDD pmos W=0.205u L=0.04u
M29456 U3151/net28 U3151/net20 U3151/net24 VDD pmos W=0.205u L=0.04u
M29457 U3151/net40 U3151/net106 U3151/net108 VDD pmos W=0.205u L=0.04u
M29458 U3151/net40 WX11169 U3151/net104 VDD pmos W=0.205u L=0.04u
M29459 U3151/net20 U3151/net40 VDD VDD pmos W=0.205u L=0.04u
M29460 U3151/net106 WX11169 VDD VDD pmos W=0.205u L=0.04u
M29461 U3151/net104 WX11233 VDD VDD pmos W=0.205u L=0.04u
M29462 U3151/net30 n2357 VDD VDD pmos W=0.205u L=0.04u
M29463 U3151/net108 U3151/net104 VDD VDD pmos W=0.205u L=0.04u
M29464 n1418 U3151/net28 VDD VDD pmos W=0.205u L=0.04u
M29465 U3151/net32 WX11041 VDD VDD pmos W=0.205u L=0.04u
M29466 U3151/net64 U3151/net24 VDD VDD pmos W=0.28u L=0.04u
M29467 U3151/net24 U3151/net30 U3151/net045 VDD pmos W=0.205u L=0.04u
M29468 U3151/net045 U3151/net32 VDD VDD pmos W=0.205u L=0.04u
M29469 n2357 WX11105 VSS VSS nmos W=0.135u L=0.04u
M29470 n2357 WX11105 VDD VDD pmos W=0.205u L=0.04u
M29471 WX10732 n1245 U3153/net26 VSS nmos W=0.155u L=0.04u
M29472 WX10732 n1421 U3153/net26 VSS nmos W=0.155u L=0.04u
M29473 U3153/net29 n2359 VSS VSS nmos W=0.155u L=0.04u
M29474 U3153/net26 n2358 U3153/net29 VSS nmos W=0.155u L=0.04u
M29475 U3153/net26 n1615 U3153/net29 VSS nmos W=0.155u L=0.04u
M29476 WX10732 n1421 U3153/net43 VDD pmos W=0.205u L=0.04u
M29477 WX10732 n1615 U3153/net49 VDD pmos W=0.205u L=0.04u
M29478 U3153/net49 n2358 VDD VDD pmos W=0.205u L=0.04u
M29479 U3153/net43 n1245 VDD VDD pmos W=0.205u L=0.04u
M29480 WX10732 n2359 VDD VDD pmos W=0.205u L=0.04u
M29481 U3154/net29 n1345 VSS VSS nmos W=0.155u L=0.04u
M29482 n2359 WX10879 U3154/net29 VSS nmos W=0.155u L=0.04u
M29483 n2359 DATA_0_6 U3154/net23 VSS nmos W=0.155u L=0.04u
M29484 U3154/net23 n1617 VSS VSS nmos W=0.155u L=0.04u
M29485 U3154/net20 n1617 n2359 VDD pmos W=0.205u L=0.04u
M29486 U3154/net20 DATA_0_6 n2359 VDD pmos W=0.205u L=0.04u
M29487 VDD WX10879 U3154/net20 VDD pmos W=0.205u L=0.04u
M29488 VDD n1345 U3154/net20 VDD pmos W=0.205u L=0.04u
M29489 n2358 CRC_OUT_1_6 VSS VSS nmos W=0.135u L=0.04u
M29490 n2358 CRC_OUT_1_6 VDD VDD pmos W=0.205u L=0.04u
M29491 U3156/net28 U3156/net20 U3156/net64 VSS nmos W=0.155u L=0.04u
M29492 U3156/net24 U3156/net30 U3156/net32 VSS nmos W=0.155u L=0.04u
M29493 U3156/net28 U3156/net40 U3156/net24 VSS nmos W=0.155u L=0.04u
M29494 U3156/net40 WX11167 U3156/net108 VSS nmos W=0.155u L=0.04u
M29495 U3156/net40 U3156/net106 U3156/net104 VSS nmos W=0.155u L=0.04u
M29496 U3156/net24 n2360 U3156/net050 VSS nmos W=0.155u L=0.04u
M29497 U3156/net050 U3156/net32 VSS VSS nmos W=0.155u L=0.04u
M29498 U3156/net20 U3156/net40 VSS VSS nmos W=0.155u L=0.04u
M29499 U3156/net106 WX11167 VSS VSS nmos W=0.155u L=0.04u
M29500 U3156/net104 WX11231 VSS VSS nmos W=0.155u L=0.04u
M29501 U3156/net30 n2360 VSS VSS nmos W=0.155u L=0.04u
M29502 U3156/net108 U3156/net104 VSS VSS nmos W=0.155u L=0.04u
M29503 n1421 U3156/net28 VSS VSS nmos W=0.155u L=0.04u
M29504 U3156/net32 WX11039 VSS VSS nmos W=0.155u L=0.04u
M29505 U3156/net64 U3156/net24 VSS VSS nmos W=0.2u L=0.04u
M29506 U3156/net28 U3156/net40 U3156/net64 VDD pmos W=0.205u L=0.04u
M29507 U3156/net24 n2360 U3156/net32 VDD pmos W=0.205u L=0.04u
M29508 U3156/net28 U3156/net20 U3156/net24 VDD pmos W=0.205u L=0.04u
M29509 U3156/net40 U3156/net106 U3156/net108 VDD pmos W=0.205u L=0.04u
M29510 U3156/net40 WX11167 U3156/net104 VDD pmos W=0.205u L=0.04u
M29511 U3156/net20 U3156/net40 VDD VDD pmos W=0.205u L=0.04u
M29512 U3156/net106 WX11167 VDD VDD pmos W=0.205u L=0.04u
M29513 U3156/net104 WX11231 VDD VDD pmos W=0.205u L=0.04u
M29514 U3156/net30 n2360 VDD VDD pmos W=0.205u L=0.04u
M29515 U3156/net108 U3156/net104 VDD VDD pmos W=0.205u L=0.04u
M29516 n1421 U3156/net28 VDD VDD pmos W=0.205u L=0.04u
M29517 U3156/net32 WX11039 VDD VDD pmos W=0.205u L=0.04u
M29518 U3156/net64 U3156/net24 VDD VDD pmos W=0.28u L=0.04u
M29519 U3156/net24 U3156/net30 U3156/net045 VDD pmos W=0.205u L=0.04u
M29520 U3156/net045 U3156/net32 VDD VDD pmos W=0.205u L=0.04u
M29521 n2360 WX11103 VSS VSS nmos W=0.135u L=0.04u
M29522 n2360 WX11103 VDD VDD pmos W=0.205u L=0.04u
M29523 U3158/net4 U3158/net10 U3158/net14 VSS nmos W=0.155u L=0.04u
M29524 U3158/net6 n2161 U3158/net14 VSS nmos W=0.155u L=0.04u
M29525 U3158/net4 n2361 VSS VSS nmos W=0.155u L=0.04u
M29526 U3158/net6 U3158/net4 VSS VSS nmos W=0.155u L=0.04u
M29527 WX1073 U3158/net14 VSS VSS nmos W=0.155u L=0.04u
M29528 U3158/net10 n2161 VSS VSS nmos W=0.155u L=0.04u
M29529 U3158/net4 n2161 U3158/net14 VDD pmos W=0.205u L=0.04u
M29530 U3158/net6 U3158/net10 U3158/net14 VDD pmos W=0.205u L=0.04u
M29531 U3158/net4 n2361 VDD VDD pmos W=0.205u L=0.04u
M29532 U3158/net6 U3158/net4 VDD VDD pmos W=0.205u L=0.04u
M29533 WX1073 U3158/net14 VDD VDD pmos W=0.205u L=0.04u
M29534 U3158/net10 n2161 VDD VDD pmos W=0.205u L=0.04u
M29535 U3159/XU1-net6 TM0 VSS VSS nmos W=0.155u L=0.04u
M29536 n2361 WX503 U3159/XU1-net6 VSS nmos W=0.155u L=0.04u
M29537 n2361 TM0 VDD VDD pmos W=0.155u L=0.04u
M29538 n2361 WX503 VDD VDD pmos W=0.155u L=0.04u
M29539 n2161 n2362 VSS VSS nmos W=0.135u L=0.04u
M29540 n2161 n2362 VDD VDD pmos W=0.205u L=0.04u
M29541 U3161/net28 U3161/net20 U3161/net64 VSS nmos W=0.155u L=0.04u
M29542 U3161/net24 U3161/net30 U3161/net32 VSS nmos W=0.155u L=0.04u
M29543 U3161/net28 U3161/net40 U3161/net24 VSS nmos W=0.155u L=0.04u
M29544 U3161/net40 n2363 U3161/net108 VSS nmos W=0.155u L=0.04u
M29545 U3161/net40 U3161/net106 U3161/net104 VSS nmos W=0.155u L=0.04u
M29546 U3161/net24 WX791 U3161/net050 VSS nmos W=0.155u L=0.04u
M29547 U3161/net050 U3161/net32 VSS VSS nmos W=0.155u L=0.04u
M29548 U3161/net20 U3161/net40 VSS VSS nmos W=0.155u L=0.04u
M29549 U3161/net106 n2363 VSS VSS nmos W=0.155u L=0.04u
M29550 U3161/net104 WX855 VSS VSS nmos W=0.155u L=0.04u
M29551 U3161/net30 WX791 VSS VSS nmos W=0.155u L=0.04u
M29552 U3161/net108 U3161/net104 VSS VSS nmos W=0.155u L=0.04u
M29553 n2362 U3161/net28 VSS VSS nmos W=0.155u L=0.04u
M29554 U3161/net32 WX727 VSS VSS nmos W=0.155u L=0.04u
M29555 U3161/net64 U3161/net24 VSS VSS nmos W=0.2u L=0.04u
M29556 U3161/net28 U3161/net40 U3161/net64 VDD pmos W=0.205u L=0.04u
M29557 U3161/net24 WX791 U3161/net32 VDD pmos W=0.205u L=0.04u
M29558 U3161/net28 U3161/net20 U3161/net24 VDD pmos W=0.205u L=0.04u
M29559 U3161/net40 U3161/net106 U3161/net108 VDD pmos W=0.205u L=0.04u
M29560 U3161/net40 n2363 U3161/net104 VDD pmos W=0.205u L=0.04u
M29561 U3161/net20 U3161/net40 VDD VDD pmos W=0.205u L=0.04u
M29562 U3161/net106 n2363 VDD VDD pmos W=0.205u L=0.04u
M29563 U3161/net104 WX855 VDD VDD pmos W=0.205u L=0.04u
M29564 U3161/net30 WX791 VDD VDD pmos W=0.205u L=0.04u
M29565 U3161/net108 U3161/net104 VDD VDD pmos W=0.205u L=0.04u
M29566 n2362 U3161/net28 VDD VDD pmos W=0.205u L=0.04u
M29567 U3161/net32 WX727 VDD VDD pmos W=0.205u L=0.04u
M29568 U3161/net64 U3161/net24 VDD VDD pmos W=0.28u L=0.04u
M29569 U3161/net24 U3161/net30 U3161/net045 VDD pmos W=0.205u L=0.04u
M29570 U3161/net045 U3161/net32 VDD VDD pmos W=0.205u L=0.04u
M29571 U3162/net4 WX663 U3162/net14 VSS nmos W=0.155u L=0.04u
M29572 U3162/net6 U3162/net10 U3162/net14 VSS nmos W=0.17u L=0.04u
M29573 U3162/net4 n1377 VSS VSS nmos W=0.155u L=0.04u
M29574 U3162/net6 U3162/net4 VSS VSS nmos W=0.17u L=0.04u
M29575 n2363 U3162/net14 VSS VSS nmos W=0.155u L=0.04u
M29576 U3162/net10 WX663 VSS VSS nmos W=0.155u L=0.04u
M29577 U3162/net4 U3162/net10 U3162/net14 VDD pmos W=0.255u L=0.04u
M29578 U3162/net6 WX663 U3162/net14 VDD pmos W=0.28u L=0.04u
M29579 U3162/net4 n1377 VDD VDD pmos W=0.205u L=0.04u
M29580 U3162/net6 U3162/net4 VDD VDD pmos W=0.24u L=0.04u
M29581 n2363 U3162/net14 VDD VDD pmos W=0.205u L=0.04u
M29582 U3162/net10 WX663 VDD VDD pmos W=0.205u L=0.04u
M29583 WX10718 n1245 U3163/net26 VSS nmos W=0.155u L=0.04u
M29584 WX10718 n1424 U3163/net26 VSS nmos W=0.155u L=0.04u
M29585 U3163/net29 n2365 VSS VSS nmos W=0.155u L=0.04u
M29586 U3163/net26 n2364 U3163/net29 VSS nmos W=0.155u L=0.04u
M29587 U3163/net26 n1615 U3163/net29 VSS nmos W=0.155u L=0.04u
M29588 WX10718 n1424 U3163/net43 VDD pmos W=0.205u L=0.04u
M29589 WX10718 n1615 U3163/net49 VDD pmos W=0.205u L=0.04u
M29590 U3163/net49 n2364 VDD VDD pmos W=0.205u L=0.04u
M29591 U3163/net43 n1245 VDD VDD pmos W=0.205u L=0.04u
M29592 WX10718 n2365 VDD VDD pmos W=0.205u L=0.04u
M29593 U3164/net29 n1345 VSS VSS nmos W=0.155u L=0.04u
M29594 n2365 WX10877 U3164/net29 VSS nmos W=0.155u L=0.04u
M29595 n2365 DATA_0_7 U3164/net23 VSS nmos W=0.155u L=0.04u
M29596 U3164/net23 n1617 VSS VSS nmos W=0.155u L=0.04u
M29597 U3164/net20 n1617 n2365 VDD pmos W=0.205u L=0.04u
M29598 U3164/net20 DATA_0_7 n2365 VDD pmos W=0.205u L=0.04u
M29599 VDD WX10877 U3164/net20 VDD pmos W=0.205u L=0.04u
M29600 VDD n1345 U3164/net20 VDD pmos W=0.205u L=0.04u
M29601 n2364 CRC_OUT_1_7 VSS VSS nmos W=0.135u L=0.04u
M29602 n2364 CRC_OUT_1_7 VDD VDD pmos W=0.205u L=0.04u
M29603 U3166/net28 U3166/net20 U3166/net64 VSS nmos W=0.155u L=0.04u
M29604 U3166/net24 U3166/net30 U3166/net32 VSS nmos W=0.155u L=0.04u
M29605 U3166/net28 U3166/net40 U3166/net24 VSS nmos W=0.155u L=0.04u
M29606 U3166/net40 WX11165 U3166/net108 VSS nmos W=0.155u L=0.04u
M29607 U3166/net40 U3166/net106 U3166/net104 VSS nmos W=0.155u L=0.04u
M29608 U3166/net24 n2366 U3166/net050 VSS nmos W=0.155u L=0.04u
M29609 U3166/net050 U3166/net32 VSS VSS nmos W=0.155u L=0.04u
M29610 U3166/net20 U3166/net40 VSS VSS nmos W=0.155u L=0.04u
M29611 U3166/net106 WX11165 VSS VSS nmos W=0.155u L=0.04u
M29612 U3166/net104 WX11229 VSS VSS nmos W=0.155u L=0.04u
M29613 U3166/net30 n2366 VSS VSS nmos W=0.155u L=0.04u
M29614 U3166/net108 U3166/net104 VSS VSS nmos W=0.155u L=0.04u
M29615 n1424 U3166/net28 VSS VSS nmos W=0.155u L=0.04u
M29616 U3166/net32 WX11037 VSS VSS nmos W=0.155u L=0.04u
M29617 U3166/net64 U3166/net24 VSS VSS nmos W=0.2u L=0.04u
M29618 U3166/net28 U3166/net40 U3166/net64 VDD pmos W=0.205u L=0.04u
M29619 U3166/net24 n2366 U3166/net32 VDD pmos W=0.205u L=0.04u
M29620 U3166/net28 U3166/net20 U3166/net24 VDD pmos W=0.205u L=0.04u
M29621 U3166/net40 U3166/net106 U3166/net108 VDD pmos W=0.205u L=0.04u
M29622 U3166/net40 WX11165 U3166/net104 VDD pmos W=0.205u L=0.04u
M29623 U3166/net20 U3166/net40 VDD VDD pmos W=0.205u L=0.04u
M29624 U3166/net106 WX11165 VDD VDD pmos W=0.205u L=0.04u
M29625 U3166/net104 WX11229 VDD VDD pmos W=0.205u L=0.04u
M29626 U3166/net30 n2366 VDD VDD pmos W=0.205u L=0.04u
M29627 U3166/net108 U3166/net104 VDD VDD pmos W=0.205u L=0.04u
M29628 n1424 U3166/net28 VDD VDD pmos W=0.205u L=0.04u
M29629 U3166/net32 WX11037 VDD VDD pmos W=0.205u L=0.04u
M29630 U3166/net64 U3166/net24 VDD VDD pmos W=0.28u L=0.04u
M29631 U3166/net24 U3166/net30 U3166/net045 VDD pmos W=0.205u L=0.04u
M29632 U3166/net045 U3166/net32 VDD VDD pmos W=0.205u L=0.04u
M29633 n2366 WX11101 VSS VSS nmos W=0.135u L=0.04u
M29634 n2366 WX11101 VDD VDD pmos W=0.205u L=0.04u
M29635 WX10704 n1245 U3168/net26 VSS nmos W=0.155u L=0.04u
M29636 WX10704 n1427 U3168/net26 VSS nmos W=0.155u L=0.04u
M29637 U3168/net29 n2368 VSS VSS nmos W=0.155u L=0.04u
M29638 U3168/net26 n2367 U3168/net29 VSS nmos W=0.155u L=0.04u
M29639 U3168/net26 n1615 U3168/net29 VSS nmos W=0.155u L=0.04u
M29640 WX10704 n1427 U3168/net43 VDD pmos W=0.205u L=0.04u
M29641 WX10704 n1615 U3168/net49 VDD pmos W=0.205u L=0.04u
M29642 U3168/net49 n2367 VDD VDD pmos W=0.205u L=0.04u
M29643 U3168/net43 n1245 VDD VDD pmos W=0.205u L=0.04u
M29644 WX10704 n2368 VDD VDD pmos W=0.205u L=0.04u
M29645 U3169/net29 n1345 VSS VSS nmos W=0.155u L=0.04u
M29646 n2368 WX10875 U3169/net29 VSS nmos W=0.155u L=0.04u
M29647 n2368 DATA_0_8 U3169/net23 VSS nmos W=0.155u L=0.04u
M29648 U3169/net23 n1617 VSS VSS nmos W=0.155u L=0.04u
M29649 U3169/net20 n1617 n2368 VDD pmos W=0.205u L=0.04u
M29650 U3169/net20 DATA_0_8 n2368 VDD pmos W=0.205u L=0.04u
M29651 VDD WX10875 U3169/net20 VDD pmos W=0.205u L=0.04u
M29652 VDD n1345 U3169/net20 VDD pmos W=0.205u L=0.04u
M29653 n2367 CRC_OUT_1_8 VSS VSS nmos W=0.135u L=0.04u
M29654 n2367 CRC_OUT_1_8 VDD VDD pmos W=0.205u L=0.04u
M29655 U3171/net28 U3171/net20 U3171/net64 VSS nmos W=0.155u L=0.04u
M29656 U3171/net24 U3171/net30 U3171/net32 VSS nmos W=0.155u L=0.04u
M29657 U3171/net28 U3171/net40 U3171/net24 VSS nmos W=0.155u L=0.04u
M29658 U3171/net40 WX11163 U3171/net108 VSS nmos W=0.155u L=0.04u
M29659 U3171/net40 U3171/net106 U3171/net104 VSS nmos W=0.155u L=0.04u
M29660 U3171/net24 n2369 U3171/net050 VSS nmos W=0.155u L=0.04u
M29661 U3171/net050 U3171/net32 VSS VSS nmos W=0.155u L=0.04u
M29662 U3171/net20 U3171/net40 VSS VSS nmos W=0.155u L=0.04u
M29663 U3171/net106 WX11163 VSS VSS nmos W=0.155u L=0.04u
M29664 U3171/net104 WX11227 VSS VSS nmos W=0.155u L=0.04u
M29665 U3171/net30 n2369 VSS VSS nmos W=0.155u L=0.04u
M29666 U3171/net108 U3171/net104 VSS VSS nmos W=0.155u L=0.04u
M29667 n1427 U3171/net28 VSS VSS nmos W=0.155u L=0.04u
M29668 U3171/net32 WX11035 VSS VSS nmos W=0.155u L=0.04u
M29669 U3171/net64 U3171/net24 VSS VSS nmos W=0.2u L=0.04u
M29670 U3171/net28 U3171/net40 U3171/net64 VDD pmos W=0.205u L=0.04u
M29671 U3171/net24 n2369 U3171/net32 VDD pmos W=0.205u L=0.04u
M29672 U3171/net28 U3171/net20 U3171/net24 VDD pmos W=0.205u L=0.04u
M29673 U3171/net40 U3171/net106 U3171/net108 VDD pmos W=0.205u L=0.04u
M29674 U3171/net40 WX11163 U3171/net104 VDD pmos W=0.205u L=0.04u
M29675 U3171/net20 U3171/net40 VDD VDD pmos W=0.205u L=0.04u
M29676 U3171/net106 WX11163 VDD VDD pmos W=0.205u L=0.04u
M29677 U3171/net104 WX11227 VDD VDD pmos W=0.205u L=0.04u
M29678 U3171/net30 n2369 VDD VDD pmos W=0.205u L=0.04u
M29679 U3171/net108 U3171/net104 VDD VDD pmos W=0.205u L=0.04u
M29680 n1427 U3171/net28 VDD VDD pmos W=0.205u L=0.04u
M29681 U3171/net32 WX11035 VDD VDD pmos W=0.205u L=0.04u
M29682 U3171/net64 U3171/net24 VDD VDD pmos W=0.28u L=0.04u
M29683 U3171/net24 U3171/net30 U3171/net045 VDD pmos W=0.205u L=0.04u
M29684 U3171/net045 U3171/net32 VDD VDD pmos W=0.205u L=0.04u
M29685 n2369 WX11099 VSS VSS nmos W=0.135u L=0.04u
M29686 n2369 WX11099 VDD VDD pmos W=0.205u L=0.04u
M29687 WX10690 n1245 U3173/net26 VSS nmos W=0.155u L=0.04u
M29688 WX10690 n1434 U3173/net26 VSS nmos W=0.155u L=0.04u
M29689 U3173/net29 n2371 VSS VSS nmos W=0.155u L=0.04u
M29690 U3173/net26 n2370 U3173/net29 VSS nmos W=0.155u L=0.04u
M29691 U3173/net26 n1615 U3173/net29 VSS nmos W=0.155u L=0.04u
M29692 WX10690 n1434 U3173/net43 VDD pmos W=0.205u L=0.04u
M29693 WX10690 n1615 U3173/net49 VDD pmos W=0.205u L=0.04u
M29694 U3173/net49 n2370 VDD VDD pmos W=0.205u L=0.04u
M29695 U3173/net43 n1245 VDD VDD pmos W=0.205u L=0.04u
M29696 WX10690 n2371 VDD VDD pmos W=0.205u L=0.04u
M29697 U3174/net29 n1345 VSS VSS nmos W=0.155u L=0.04u
M29698 n2371 WX10873 U3174/net29 VSS nmos W=0.155u L=0.04u
M29699 n2371 DATA_0_9 U3174/net23 VSS nmos W=0.155u L=0.04u
M29700 U3174/net23 n1617 VSS VSS nmos W=0.155u L=0.04u
M29701 U3174/net20 n1617 n2371 VDD pmos W=0.205u L=0.04u
M29702 U3174/net20 DATA_0_9 n2371 VDD pmos W=0.205u L=0.04u
M29703 VDD WX10873 U3174/net20 VDD pmos W=0.205u L=0.04u
M29704 VDD n1345 U3174/net20 VDD pmos W=0.205u L=0.04u
M29705 n2370 CRC_OUT_1_9 VSS VSS nmos W=0.135u L=0.04u
M29706 n2370 CRC_OUT_1_9 VDD VDD pmos W=0.205u L=0.04u
M29707 U3176/net28 U3176/net20 U3176/net64 VSS nmos W=0.155u L=0.04u
M29708 U3176/net24 U3176/net30 U3176/net32 VSS nmos W=0.155u L=0.04u
M29709 U3176/net28 U3176/net40 U3176/net24 VSS nmos W=0.155u L=0.04u
M29710 U3176/net40 WX11161 U3176/net108 VSS nmos W=0.155u L=0.04u
M29711 U3176/net40 U3176/net106 U3176/net104 VSS nmos W=0.155u L=0.04u
M29712 U3176/net24 n2372 U3176/net050 VSS nmos W=0.155u L=0.04u
M29713 U3176/net050 U3176/net32 VSS VSS nmos W=0.155u L=0.04u
M29714 U3176/net20 U3176/net40 VSS VSS nmos W=0.155u L=0.04u
M29715 U3176/net106 WX11161 VSS VSS nmos W=0.155u L=0.04u
M29716 U3176/net104 WX11225 VSS VSS nmos W=0.155u L=0.04u
M29717 U3176/net30 n2372 VSS VSS nmos W=0.155u L=0.04u
M29718 U3176/net108 U3176/net104 VSS VSS nmos W=0.155u L=0.04u
M29719 n1434 U3176/net28 VSS VSS nmos W=0.155u L=0.04u
M29720 U3176/net32 WX11033 VSS VSS nmos W=0.155u L=0.04u
M29721 U3176/net64 U3176/net24 VSS VSS nmos W=0.2u L=0.04u
M29722 U3176/net28 U3176/net40 U3176/net64 VDD pmos W=0.205u L=0.04u
M29723 U3176/net24 n2372 U3176/net32 VDD pmos W=0.205u L=0.04u
M29724 U3176/net28 U3176/net20 U3176/net24 VDD pmos W=0.205u L=0.04u
M29725 U3176/net40 U3176/net106 U3176/net108 VDD pmos W=0.205u L=0.04u
M29726 U3176/net40 WX11161 U3176/net104 VDD pmos W=0.205u L=0.04u
M29727 U3176/net20 U3176/net40 VDD VDD pmos W=0.205u L=0.04u
M29728 U3176/net106 WX11161 VDD VDD pmos W=0.205u L=0.04u
M29729 U3176/net104 WX11225 VDD VDD pmos W=0.205u L=0.04u
M29730 U3176/net30 n2372 VDD VDD pmos W=0.205u L=0.04u
M29731 U3176/net108 U3176/net104 VDD VDD pmos W=0.205u L=0.04u
M29732 n1434 U3176/net28 VDD VDD pmos W=0.205u L=0.04u
M29733 U3176/net32 WX11033 VDD VDD pmos W=0.205u L=0.04u
M29734 U3176/net64 U3176/net24 VDD VDD pmos W=0.28u L=0.04u
M29735 U3176/net24 U3176/net30 U3176/net045 VDD pmos W=0.205u L=0.04u
M29736 U3176/net045 U3176/net32 VDD VDD pmos W=0.205u L=0.04u
M29737 n2372 WX11097 VSS VSS nmos W=0.135u L=0.04u
M29738 n2372 WX11097 VDD VDD pmos W=0.205u L=0.04u
M29739 WX10676 n1245 U3178/net26 VSS nmos W=0.155u L=0.04u
M29740 WX10676 n1437 U3178/net26 VSS nmos W=0.155u L=0.04u
M29741 U3178/net29 n2374 VSS VSS nmos W=0.155u L=0.04u
M29742 U3178/net26 n2373 U3178/net29 VSS nmos W=0.155u L=0.04u
M29743 U3178/net26 n1615 U3178/net29 VSS nmos W=0.155u L=0.04u
M29744 WX10676 n1437 U3178/net43 VDD pmos W=0.205u L=0.04u
M29745 WX10676 n1615 U3178/net49 VDD pmos W=0.205u L=0.04u
M29746 U3178/net49 n2373 VDD VDD pmos W=0.205u L=0.04u
M29747 U3178/net43 n1245 VDD VDD pmos W=0.205u L=0.04u
M29748 WX10676 n2374 VDD VDD pmos W=0.205u L=0.04u
M29749 U3179/net29 n1345 VSS VSS nmos W=0.155u L=0.04u
M29750 n2374 WX10871 U3179/net29 VSS nmos W=0.155u L=0.04u
M29751 n2374 DATA_0_10 U3179/net23 VSS nmos W=0.155u L=0.04u
M29752 U3179/net23 n1617 VSS VSS nmos W=0.155u L=0.04u
M29753 U3179/net20 n1617 n2374 VDD pmos W=0.205u L=0.04u
M29754 U3179/net20 DATA_0_10 n2374 VDD pmos W=0.205u L=0.04u
M29755 VDD WX10871 U3179/net20 VDD pmos W=0.205u L=0.04u
M29756 VDD n1345 U3179/net20 VDD pmos W=0.205u L=0.04u
M29757 n2373 CRC_OUT_1_10 VSS VSS nmos W=0.135u L=0.04u
M29758 n2373 CRC_OUT_1_10 VDD VDD pmos W=0.205u L=0.04u
M29759 U3181/net28 U3181/net20 U3181/net64 VSS nmos W=0.155u L=0.04u
M29760 U3181/net24 U3181/net30 U3181/net32 VSS nmos W=0.155u L=0.04u
M29761 U3181/net28 U3181/net40 U3181/net24 VSS nmos W=0.155u L=0.04u
M29762 U3181/net40 WX11159 U3181/net108 VSS nmos W=0.155u L=0.04u
M29763 U3181/net40 U3181/net106 U3181/net104 VSS nmos W=0.155u L=0.04u
M29764 U3181/net24 n2375 U3181/net050 VSS nmos W=0.155u L=0.04u
M29765 U3181/net050 U3181/net32 VSS VSS nmos W=0.155u L=0.04u
M29766 U3181/net20 U3181/net40 VSS VSS nmos W=0.155u L=0.04u
M29767 U3181/net106 WX11159 VSS VSS nmos W=0.155u L=0.04u
M29768 U3181/net104 WX11223 VSS VSS nmos W=0.155u L=0.04u
M29769 U3181/net30 n2375 VSS VSS nmos W=0.155u L=0.04u
M29770 U3181/net108 U3181/net104 VSS VSS nmos W=0.155u L=0.04u
M29771 n1437 U3181/net28 VSS VSS nmos W=0.155u L=0.04u
M29772 U3181/net32 WX11031 VSS VSS nmos W=0.155u L=0.04u
M29773 U3181/net64 U3181/net24 VSS VSS nmos W=0.2u L=0.04u
M29774 U3181/net28 U3181/net40 U3181/net64 VDD pmos W=0.205u L=0.04u
M29775 U3181/net24 n2375 U3181/net32 VDD pmos W=0.205u L=0.04u
M29776 U3181/net28 U3181/net20 U3181/net24 VDD pmos W=0.205u L=0.04u
M29777 U3181/net40 U3181/net106 U3181/net108 VDD pmos W=0.205u L=0.04u
M29778 U3181/net40 WX11159 U3181/net104 VDD pmos W=0.205u L=0.04u
M29779 U3181/net20 U3181/net40 VDD VDD pmos W=0.205u L=0.04u
M29780 U3181/net106 WX11159 VDD VDD pmos W=0.205u L=0.04u
M29781 U3181/net104 WX11223 VDD VDD pmos W=0.205u L=0.04u
M29782 U3181/net30 n2375 VDD VDD pmos W=0.205u L=0.04u
M29783 U3181/net108 U3181/net104 VDD VDD pmos W=0.205u L=0.04u
M29784 n1437 U3181/net28 VDD VDD pmos W=0.205u L=0.04u
M29785 U3181/net32 WX11031 VDD VDD pmos W=0.205u L=0.04u
M29786 U3181/net64 U3181/net24 VDD VDD pmos W=0.28u L=0.04u
M29787 U3181/net24 U3181/net30 U3181/net045 VDD pmos W=0.205u L=0.04u
M29788 U3181/net045 U3181/net32 VDD VDD pmos W=0.205u L=0.04u
M29789 n2375 WX11095 VSS VSS nmos W=0.135u L=0.04u
M29790 n2375 WX11095 VDD VDD pmos W=0.205u L=0.04u
M29791 WX10662 n1245 U3183/net26 VSS nmos W=0.155u L=0.04u
M29792 WX10662 n1440 U3183/net26 VSS nmos W=0.155u L=0.04u
M29793 U3183/net29 n2377 VSS VSS nmos W=0.155u L=0.04u
M29794 U3183/net26 n2376 U3183/net29 VSS nmos W=0.155u L=0.04u
M29795 U3183/net26 n1615 U3183/net29 VSS nmos W=0.155u L=0.04u
M29796 WX10662 n1440 U3183/net43 VDD pmos W=0.205u L=0.04u
M29797 WX10662 n1615 U3183/net49 VDD pmos W=0.205u L=0.04u
M29798 U3183/net49 n2376 VDD VDD pmos W=0.205u L=0.04u
M29799 U3183/net43 n1245 VDD VDD pmos W=0.205u L=0.04u
M29800 WX10662 n2377 VDD VDD pmos W=0.205u L=0.04u
M29801 U3184/net29 n1344 VSS VSS nmos W=0.155u L=0.04u
M29802 n2377 WX10869 U3184/net29 VSS nmos W=0.155u L=0.04u
M29803 n2377 DATA_0_11 U3184/net23 VSS nmos W=0.155u L=0.04u
M29804 U3184/net23 n1617 VSS VSS nmos W=0.155u L=0.04u
M29805 U3184/net20 n1617 n2377 VDD pmos W=0.205u L=0.04u
M29806 U3184/net20 DATA_0_11 n2377 VDD pmos W=0.205u L=0.04u
M29807 VDD WX10869 U3184/net20 VDD pmos W=0.205u L=0.04u
M29808 VDD n1344 U3184/net20 VDD pmos W=0.205u L=0.04u
M29809 n2376 CRC_OUT_1_11 VSS VSS nmos W=0.135u L=0.04u
M29810 n2376 CRC_OUT_1_11 VDD VDD pmos W=0.205u L=0.04u
M29811 U3186/net28 U3186/net20 U3186/net64 VSS nmos W=0.155u L=0.04u
M29812 U3186/net24 U3186/net30 U3186/net32 VSS nmos W=0.155u L=0.04u
M29813 U3186/net28 U3186/net40 U3186/net24 VSS nmos W=0.155u L=0.04u
M29814 U3186/net40 WX11157 U3186/net108 VSS nmos W=0.155u L=0.04u
M29815 U3186/net40 U3186/net106 U3186/net104 VSS nmos W=0.155u L=0.04u
M29816 U3186/net24 n2378 U3186/net050 VSS nmos W=0.155u L=0.04u
M29817 U3186/net050 U3186/net32 VSS VSS nmos W=0.155u L=0.04u
M29818 U3186/net20 U3186/net40 VSS VSS nmos W=0.155u L=0.04u
M29819 U3186/net106 WX11157 VSS VSS nmos W=0.155u L=0.04u
M29820 U3186/net104 WX11221 VSS VSS nmos W=0.155u L=0.04u
M29821 U3186/net30 n2378 VSS VSS nmos W=0.155u L=0.04u
M29822 U3186/net108 U3186/net104 VSS VSS nmos W=0.155u L=0.04u
M29823 n1440 U3186/net28 VSS VSS nmos W=0.155u L=0.04u
M29824 U3186/net32 WX11029 VSS VSS nmos W=0.155u L=0.04u
M29825 U3186/net64 U3186/net24 VSS VSS nmos W=0.2u L=0.04u
M29826 U3186/net28 U3186/net40 U3186/net64 VDD pmos W=0.205u L=0.04u
M29827 U3186/net24 n2378 U3186/net32 VDD pmos W=0.205u L=0.04u
M29828 U3186/net28 U3186/net20 U3186/net24 VDD pmos W=0.205u L=0.04u
M29829 U3186/net40 U3186/net106 U3186/net108 VDD pmos W=0.205u L=0.04u
M29830 U3186/net40 WX11157 U3186/net104 VDD pmos W=0.205u L=0.04u
M29831 U3186/net20 U3186/net40 VDD VDD pmos W=0.205u L=0.04u
M29832 U3186/net106 WX11157 VDD VDD pmos W=0.205u L=0.04u
M29833 U3186/net104 WX11221 VDD VDD pmos W=0.205u L=0.04u
M29834 U3186/net30 n2378 VDD VDD pmos W=0.205u L=0.04u
M29835 U3186/net108 U3186/net104 VDD VDD pmos W=0.205u L=0.04u
M29836 n1440 U3186/net28 VDD VDD pmos W=0.205u L=0.04u
M29837 U3186/net32 WX11029 VDD VDD pmos W=0.205u L=0.04u
M29838 U3186/net64 U3186/net24 VDD VDD pmos W=0.28u L=0.04u
M29839 U3186/net24 U3186/net30 U3186/net045 VDD pmos W=0.205u L=0.04u
M29840 U3186/net045 U3186/net32 VDD VDD pmos W=0.205u L=0.04u
M29841 n2378 WX11093 VSS VSS nmos W=0.135u L=0.04u
M29842 n2378 WX11093 VDD VDD pmos W=0.205u L=0.04u
M29843 U3188/net4 U3188/net10 U3188/net14 VSS nmos W=0.155u L=0.04u
M29844 U3188/net6 n2200 U3188/net14 VSS nmos W=0.155u L=0.04u
M29845 U3188/net4 n2379 VSS VSS nmos W=0.155u L=0.04u
M29846 U3188/net6 U3188/net4 VSS VSS nmos W=0.155u L=0.04u
M29847 WX1066 U3188/net14 VSS VSS nmos W=0.155u L=0.04u
M29848 U3188/net10 n2200 VSS VSS nmos W=0.155u L=0.04u
M29849 U3188/net4 n2200 U3188/net14 VDD pmos W=0.205u L=0.04u
M29850 U3188/net6 U3188/net10 U3188/net14 VDD pmos W=0.205u L=0.04u
M29851 U3188/net4 n2379 VDD VDD pmos W=0.205u L=0.04u
M29852 U3188/net6 U3188/net4 VDD VDD pmos W=0.205u L=0.04u
M29853 WX1066 U3188/net14 VDD VDD pmos W=0.205u L=0.04u
M29854 U3188/net10 n2200 VDD VDD pmos W=0.205u L=0.04u
M29855 U3189/XU1-net6 TM0 VSS VSS nmos W=0.155u L=0.04u
M29856 n2379 WX501 U3189/XU1-net6 VSS nmos W=0.155u L=0.04u
M29857 n2379 TM0 VDD VDD pmos W=0.155u L=0.04u
M29858 n2379 WX501 VDD VDD pmos W=0.155u L=0.04u
M29859 n2200 n2380 VSS VSS nmos W=0.135u L=0.04u
M29860 n2200 n2380 VDD VDD pmos W=0.205u L=0.04u
M29861 U3191/net28 U3191/net20 U3191/net64 VSS nmos W=0.155u L=0.04u
M29862 U3191/net24 U3191/net30 U3191/net32 VSS nmos W=0.155u L=0.04u
M29863 U3191/net28 U3191/net40 U3191/net24 VSS nmos W=0.155u L=0.04u
M29864 U3191/net40 n2381 U3191/net108 VSS nmos W=0.155u L=0.04u
M29865 U3191/net40 U3191/net106 U3191/net104 VSS nmos W=0.155u L=0.04u
M29866 U3191/net24 WX789 U3191/net050 VSS nmos W=0.155u L=0.04u
M29867 U3191/net050 U3191/net32 VSS VSS nmos W=0.155u L=0.04u
M29868 U3191/net20 U3191/net40 VSS VSS nmos W=0.155u L=0.04u
M29869 U3191/net106 n2381 VSS VSS nmos W=0.155u L=0.04u
M29870 U3191/net104 WX853 VSS VSS nmos W=0.155u L=0.04u
M29871 U3191/net30 WX789 VSS VSS nmos W=0.155u L=0.04u
M29872 U3191/net108 U3191/net104 VSS VSS nmos W=0.155u L=0.04u
M29873 n2380 U3191/net28 VSS VSS nmos W=0.155u L=0.04u
M29874 U3191/net32 WX725 VSS VSS nmos W=0.155u L=0.04u
M29875 U3191/net64 U3191/net24 VSS VSS nmos W=0.2u L=0.04u
M29876 U3191/net28 U3191/net40 U3191/net64 VDD pmos W=0.205u L=0.04u
M29877 U3191/net24 WX789 U3191/net32 VDD pmos W=0.205u L=0.04u
M29878 U3191/net28 U3191/net20 U3191/net24 VDD pmos W=0.205u L=0.04u
M29879 U3191/net40 U3191/net106 U3191/net108 VDD pmos W=0.205u L=0.04u
M29880 U3191/net40 n2381 U3191/net104 VDD pmos W=0.205u L=0.04u
M29881 U3191/net20 U3191/net40 VDD VDD pmos W=0.205u L=0.04u
M29882 U3191/net106 n2381 VDD VDD pmos W=0.205u L=0.04u
M29883 U3191/net104 WX853 VDD VDD pmos W=0.205u L=0.04u
M29884 U3191/net30 WX789 VDD VDD pmos W=0.205u L=0.04u
M29885 U3191/net108 U3191/net104 VDD VDD pmos W=0.205u L=0.04u
M29886 n2380 U3191/net28 VDD VDD pmos W=0.205u L=0.04u
M29887 U3191/net32 WX725 VDD VDD pmos W=0.205u L=0.04u
M29888 U3191/net64 U3191/net24 VDD VDD pmos W=0.28u L=0.04u
M29889 U3191/net24 U3191/net30 U3191/net045 VDD pmos W=0.205u L=0.04u
M29890 U3191/net045 U3191/net32 VDD VDD pmos W=0.205u L=0.04u
M29891 U3192/net4 WX661 U3192/net14 VSS nmos W=0.155u L=0.04u
M29892 U3192/net6 U3192/net10 U3192/net14 VSS nmos W=0.17u L=0.04u
M29893 U3192/net4 n1378 VSS VSS nmos W=0.155u L=0.04u
M29894 U3192/net6 U3192/net4 VSS VSS nmos W=0.17u L=0.04u
M29895 n2381 U3192/net14 VSS VSS nmos W=0.155u L=0.04u
M29896 U3192/net10 WX661 VSS VSS nmos W=0.155u L=0.04u
M29897 U3192/net4 U3192/net10 U3192/net14 VDD pmos W=0.255u L=0.04u
M29898 U3192/net6 WX661 U3192/net14 VDD pmos W=0.28u L=0.04u
M29899 U3192/net4 n1378 VDD VDD pmos W=0.205u L=0.04u
M29900 U3192/net6 U3192/net4 VDD VDD pmos W=0.24u L=0.04u
M29901 n2381 U3192/net14 VDD VDD pmos W=0.205u L=0.04u
M29902 U3192/net10 WX661 VDD VDD pmos W=0.205u L=0.04u
M29903 WX10648 n1245 U3193/net26 VSS nmos W=0.155u L=0.04u
M29904 WX10648 n1443 U3193/net26 VSS nmos W=0.155u L=0.04u
M29905 U3193/net29 n2383 VSS VSS nmos W=0.155u L=0.04u
M29906 U3193/net26 n2382 U3193/net29 VSS nmos W=0.155u L=0.04u
M29907 U3193/net26 n1615 U3193/net29 VSS nmos W=0.155u L=0.04u
M29908 WX10648 n1443 U3193/net43 VDD pmos W=0.205u L=0.04u
M29909 WX10648 n1615 U3193/net49 VDD pmos W=0.205u L=0.04u
M29910 U3193/net49 n2382 VDD VDD pmos W=0.205u L=0.04u
M29911 U3193/net43 n1245 VDD VDD pmos W=0.205u L=0.04u
M29912 WX10648 n2383 VDD VDD pmos W=0.205u L=0.04u
M29913 U3194/net29 n1344 VSS VSS nmos W=0.155u L=0.04u
M29914 n2383 WX10867 U3194/net29 VSS nmos W=0.155u L=0.04u
M29915 n2383 DATA_0_12 U3194/net23 VSS nmos W=0.155u L=0.04u
M29916 U3194/net23 n1617 VSS VSS nmos W=0.155u L=0.04u
M29917 U3194/net20 n1617 n2383 VDD pmos W=0.205u L=0.04u
M29918 U3194/net20 DATA_0_12 n2383 VDD pmos W=0.205u L=0.04u
M29919 VDD WX10867 U3194/net20 VDD pmos W=0.205u L=0.04u
M29920 VDD n1344 U3194/net20 VDD pmos W=0.205u L=0.04u
M29921 n2382 CRC_OUT_1_12 VSS VSS nmos W=0.135u L=0.04u
M29922 n2382 CRC_OUT_1_12 VDD VDD pmos W=0.205u L=0.04u
M29923 U3196/net28 U3196/net20 U3196/net64 VSS nmos W=0.155u L=0.04u
M29924 U3196/net24 U3196/net30 U3196/net32 VSS nmos W=0.155u L=0.04u
M29925 U3196/net28 U3196/net40 U3196/net24 VSS nmos W=0.155u L=0.04u
M29926 U3196/net40 WX11155 U3196/net108 VSS nmos W=0.155u L=0.04u
M29927 U3196/net40 U3196/net106 U3196/net104 VSS nmos W=0.155u L=0.04u
M29928 U3196/net24 n2384 U3196/net050 VSS nmos W=0.155u L=0.04u
M29929 U3196/net050 U3196/net32 VSS VSS nmos W=0.155u L=0.04u
M29930 U3196/net20 U3196/net40 VSS VSS nmos W=0.155u L=0.04u
M29931 U3196/net106 WX11155 VSS VSS nmos W=0.155u L=0.04u
M29932 U3196/net104 WX11219 VSS VSS nmos W=0.155u L=0.04u
M29933 U3196/net30 n2384 VSS VSS nmos W=0.155u L=0.04u
M29934 U3196/net108 U3196/net104 VSS VSS nmos W=0.155u L=0.04u
M29935 n1443 U3196/net28 VSS VSS nmos W=0.155u L=0.04u
M29936 U3196/net32 WX11027 VSS VSS nmos W=0.155u L=0.04u
M29937 U3196/net64 U3196/net24 VSS VSS nmos W=0.2u L=0.04u
M29938 U3196/net28 U3196/net40 U3196/net64 VDD pmos W=0.205u L=0.04u
M29939 U3196/net24 n2384 U3196/net32 VDD pmos W=0.205u L=0.04u
M29940 U3196/net28 U3196/net20 U3196/net24 VDD pmos W=0.205u L=0.04u
M29941 U3196/net40 U3196/net106 U3196/net108 VDD pmos W=0.205u L=0.04u
M29942 U3196/net40 WX11155 U3196/net104 VDD pmos W=0.205u L=0.04u
M29943 U3196/net20 U3196/net40 VDD VDD pmos W=0.205u L=0.04u
M29944 U3196/net106 WX11155 VDD VDD pmos W=0.205u L=0.04u
M29945 U3196/net104 WX11219 VDD VDD pmos W=0.205u L=0.04u
M29946 U3196/net30 n2384 VDD VDD pmos W=0.205u L=0.04u
M29947 U3196/net108 U3196/net104 VDD VDD pmos W=0.205u L=0.04u
M29948 n1443 U3196/net28 VDD VDD pmos W=0.205u L=0.04u
M29949 U3196/net32 WX11027 VDD VDD pmos W=0.205u L=0.04u
M29950 U3196/net64 U3196/net24 VDD VDD pmos W=0.28u L=0.04u
M29951 U3196/net24 U3196/net30 U3196/net045 VDD pmos W=0.205u L=0.04u
M29952 U3196/net045 U3196/net32 VDD VDD pmos W=0.205u L=0.04u
M29953 n2384 WX11091 VSS VSS nmos W=0.135u L=0.04u
M29954 n2384 WX11091 VDD VDD pmos W=0.205u L=0.04u
M29955 WX10634 n1245 U3198/net26 VSS nmos W=0.155u L=0.04u
M29956 WX10634 n1446 U3198/net26 VSS nmos W=0.155u L=0.04u
M29957 U3198/net29 n2386 VSS VSS nmos W=0.155u L=0.04u
M29958 U3198/net26 n2385 U3198/net29 VSS nmos W=0.155u L=0.04u
M29959 U3198/net26 n1615 U3198/net29 VSS nmos W=0.155u L=0.04u
M29960 WX10634 n1446 U3198/net43 VDD pmos W=0.205u L=0.04u
M29961 WX10634 n1615 U3198/net49 VDD pmos W=0.205u L=0.04u
M29962 U3198/net49 n2385 VDD VDD pmos W=0.205u L=0.04u
M29963 U3198/net43 n1245 VDD VDD pmos W=0.205u L=0.04u
M29964 WX10634 n2386 VDD VDD pmos W=0.205u L=0.04u
M29965 U3199/net29 n1344 VSS VSS nmos W=0.155u L=0.04u
M29966 n2386 WX10865 U3199/net29 VSS nmos W=0.155u L=0.04u
M29967 n2386 DATA_0_13 U3199/net23 VSS nmos W=0.155u L=0.04u
M29968 U3199/net23 n1617 VSS VSS nmos W=0.155u L=0.04u
M29969 U3199/net20 n1617 n2386 VDD pmos W=0.205u L=0.04u
M29970 U3199/net20 DATA_0_13 n2386 VDD pmos W=0.205u L=0.04u
M29971 VDD WX10865 U3199/net20 VDD pmos W=0.205u L=0.04u
M29972 VDD n1344 U3199/net20 VDD pmos W=0.205u L=0.04u
M29973 n2385 CRC_OUT_1_13 VSS VSS nmos W=0.135u L=0.04u
M29974 n2385 CRC_OUT_1_13 VDD VDD pmos W=0.205u L=0.04u
M29975 U3201/net28 U3201/net20 U3201/net64 VSS nmos W=0.155u L=0.04u
M29976 U3201/net24 U3201/net30 U3201/net32 VSS nmos W=0.155u L=0.04u
M29977 U3201/net28 U3201/net40 U3201/net24 VSS nmos W=0.155u L=0.04u
M29978 U3201/net40 WX11153 U3201/net108 VSS nmos W=0.155u L=0.04u
M29979 U3201/net40 U3201/net106 U3201/net104 VSS nmos W=0.155u L=0.04u
M29980 U3201/net24 n2387 U3201/net050 VSS nmos W=0.155u L=0.04u
M29981 U3201/net050 U3201/net32 VSS VSS nmos W=0.155u L=0.04u
M29982 U3201/net20 U3201/net40 VSS VSS nmos W=0.155u L=0.04u
M29983 U3201/net106 WX11153 VSS VSS nmos W=0.155u L=0.04u
M29984 U3201/net104 WX11217 VSS VSS nmos W=0.155u L=0.04u
M29985 U3201/net30 n2387 VSS VSS nmos W=0.155u L=0.04u
M29986 U3201/net108 U3201/net104 VSS VSS nmos W=0.155u L=0.04u
M29987 n1446 U3201/net28 VSS VSS nmos W=0.155u L=0.04u
M29988 U3201/net32 WX11025 VSS VSS nmos W=0.155u L=0.04u
M29989 U3201/net64 U3201/net24 VSS VSS nmos W=0.2u L=0.04u
M29990 U3201/net28 U3201/net40 U3201/net64 VDD pmos W=0.205u L=0.04u
M29991 U3201/net24 n2387 U3201/net32 VDD pmos W=0.205u L=0.04u
M29992 U3201/net28 U3201/net20 U3201/net24 VDD pmos W=0.205u L=0.04u
M29993 U3201/net40 U3201/net106 U3201/net108 VDD pmos W=0.205u L=0.04u
M29994 U3201/net40 WX11153 U3201/net104 VDD pmos W=0.205u L=0.04u
M29995 U3201/net20 U3201/net40 VDD VDD pmos W=0.205u L=0.04u
M29996 U3201/net106 WX11153 VDD VDD pmos W=0.205u L=0.04u
M29997 U3201/net104 WX11217 VDD VDD pmos W=0.205u L=0.04u
M29998 U3201/net30 n2387 VDD VDD pmos W=0.205u L=0.04u
M29999 U3201/net108 U3201/net104 VDD VDD pmos W=0.205u L=0.04u
M30000 n1446 U3201/net28 VDD VDD pmos W=0.205u L=0.04u
M30001 U3201/net32 WX11025 VDD VDD pmos W=0.205u L=0.04u
M30002 U3201/net64 U3201/net24 VDD VDD pmos W=0.28u L=0.04u
M30003 U3201/net24 U3201/net30 U3201/net045 VDD pmos W=0.205u L=0.04u
M30004 U3201/net045 U3201/net32 VDD VDD pmos W=0.205u L=0.04u
M30005 n2387 WX11089 VSS VSS nmos W=0.135u L=0.04u
M30006 n2387 WX11089 VDD VDD pmos W=0.205u L=0.04u
M30007 WX10620 n1245 U3203/net26 VSS nmos W=0.155u L=0.04u
M30008 WX10620 n1449 U3203/net26 VSS nmos W=0.155u L=0.04u
M30009 U3203/net29 n2389 VSS VSS nmos W=0.155u L=0.04u
M30010 U3203/net26 n2388 U3203/net29 VSS nmos W=0.155u L=0.04u
M30011 U3203/net26 n1615 U3203/net29 VSS nmos W=0.155u L=0.04u
M30012 WX10620 n1449 U3203/net43 VDD pmos W=0.205u L=0.04u
M30013 WX10620 n1615 U3203/net49 VDD pmos W=0.205u L=0.04u
M30014 U3203/net49 n2388 VDD VDD pmos W=0.205u L=0.04u
M30015 U3203/net43 n1245 VDD VDD pmos W=0.205u L=0.04u
M30016 WX10620 n2389 VDD VDD pmos W=0.205u L=0.04u
M30017 U3204/net29 n1344 VSS VSS nmos W=0.155u L=0.04u
M30018 n2389 WX10863 U3204/net29 VSS nmos W=0.155u L=0.04u
M30019 n2389 DATA_0_14 U3204/net23 VSS nmos W=0.155u L=0.04u
M30020 U3204/net23 n1617 VSS VSS nmos W=0.155u L=0.04u
M30021 U3204/net20 n1617 n2389 VDD pmos W=0.205u L=0.04u
M30022 U3204/net20 DATA_0_14 n2389 VDD pmos W=0.205u L=0.04u
M30023 VDD WX10863 U3204/net20 VDD pmos W=0.205u L=0.04u
M30024 VDD n1344 U3204/net20 VDD pmos W=0.205u L=0.04u
M30025 n2388 CRC_OUT_1_14 VSS VSS nmos W=0.135u L=0.04u
M30026 n2388 CRC_OUT_1_14 VDD VDD pmos W=0.205u L=0.04u
M30027 U3206/net28 U3206/net20 U3206/net64 VSS nmos W=0.155u L=0.04u
M30028 U3206/net24 U3206/net30 U3206/net32 VSS nmos W=0.155u L=0.04u
M30029 U3206/net28 U3206/net40 U3206/net24 VSS nmos W=0.155u L=0.04u
M30030 U3206/net40 WX11151 U3206/net108 VSS nmos W=0.155u L=0.04u
M30031 U3206/net40 U3206/net106 U3206/net104 VSS nmos W=0.155u L=0.04u
M30032 U3206/net24 n2390 U3206/net050 VSS nmos W=0.155u L=0.04u
M30033 U3206/net050 U3206/net32 VSS VSS nmos W=0.155u L=0.04u
M30034 U3206/net20 U3206/net40 VSS VSS nmos W=0.155u L=0.04u
M30035 U3206/net106 WX11151 VSS VSS nmos W=0.155u L=0.04u
M30036 U3206/net104 WX11215 VSS VSS nmos W=0.155u L=0.04u
M30037 U3206/net30 n2390 VSS VSS nmos W=0.155u L=0.04u
M30038 U3206/net108 U3206/net104 VSS VSS nmos W=0.155u L=0.04u
M30039 n1449 U3206/net28 VSS VSS nmos W=0.155u L=0.04u
M30040 U3206/net32 WX11023 VSS VSS nmos W=0.155u L=0.04u
M30041 U3206/net64 U3206/net24 VSS VSS nmos W=0.2u L=0.04u
M30042 U3206/net28 U3206/net40 U3206/net64 VDD pmos W=0.205u L=0.04u
M30043 U3206/net24 n2390 U3206/net32 VDD pmos W=0.205u L=0.04u
M30044 U3206/net28 U3206/net20 U3206/net24 VDD pmos W=0.205u L=0.04u
M30045 U3206/net40 U3206/net106 U3206/net108 VDD pmos W=0.205u L=0.04u
M30046 U3206/net40 WX11151 U3206/net104 VDD pmos W=0.205u L=0.04u
M30047 U3206/net20 U3206/net40 VDD VDD pmos W=0.205u L=0.04u
M30048 U3206/net106 WX11151 VDD VDD pmos W=0.205u L=0.04u
M30049 U3206/net104 WX11215 VDD VDD pmos W=0.205u L=0.04u
M30050 U3206/net30 n2390 VDD VDD pmos W=0.205u L=0.04u
M30051 U3206/net108 U3206/net104 VDD VDD pmos W=0.205u L=0.04u
M30052 n1449 U3206/net28 VDD VDD pmos W=0.205u L=0.04u
M30053 U3206/net32 WX11023 VDD VDD pmos W=0.205u L=0.04u
M30054 U3206/net64 U3206/net24 VDD VDD pmos W=0.28u L=0.04u
M30055 U3206/net24 U3206/net30 U3206/net045 VDD pmos W=0.205u L=0.04u
M30056 U3206/net045 U3206/net32 VDD VDD pmos W=0.205u L=0.04u
M30057 n2390 WX11087 VSS VSS nmos W=0.135u L=0.04u
M30058 n2390 WX11087 VDD VDD pmos W=0.205u L=0.04u
M30059 WX10606 n1245 U3208/net26 VSS nmos W=0.155u L=0.04u
M30060 WX10606 n1452 U3208/net26 VSS nmos W=0.155u L=0.04u
M30061 U3208/net29 n2392 VSS VSS nmos W=0.155u L=0.04u
M30062 U3208/net26 n2391 U3208/net29 VSS nmos W=0.155u L=0.04u
M30063 U3208/net26 n1615 U3208/net29 VSS nmos W=0.155u L=0.04u
M30064 WX10606 n1452 U3208/net43 VDD pmos W=0.205u L=0.04u
M30065 WX10606 n1615 U3208/net49 VDD pmos W=0.205u L=0.04u
M30066 U3208/net49 n2391 VDD VDD pmos W=0.205u L=0.04u
M30067 U3208/net43 n1245 VDD VDD pmos W=0.205u L=0.04u
M30068 WX10606 n2392 VDD VDD pmos W=0.205u L=0.04u
M30069 U3209/net29 n1344 VSS VSS nmos W=0.155u L=0.04u
M30070 n2392 WX10861 U3209/net29 VSS nmos W=0.155u L=0.04u
M30071 n2392 DATA_0_15 U3209/net23 VSS nmos W=0.155u L=0.04u
M30072 U3209/net23 n1617 VSS VSS nmos W=0.155u L=0.04u
M30073 U3209/net20 n1617 n2392 VDD pmos W=0.205u L=0.04u
M30074 U3209/net20 DATA_0_15 n2392 VDD pmos W=0.205u L=0.04u
M30075 VDD WX10861 U3209/net20 VDD pmos W=0.205u L=0.04u
M30076 VDD n1344 U3209/net20 VDD pmos W=0.205u L=0.04u
M30077 n2391 CRC_OUT_1_15 VSS VSS nmos W=0.135u L=0.04u
M30078 n2391 CRC_OUT_1_15 VDD VDD pmos W=0.205u L=0.04u
M30079 U3211/net28 U3211/net20 U3211/net64 VSS nmos W=0.155u L=0.04u
M30080 U3211/net24 U3211/net30 U3211/net32 VSS nmos W=0.155u L=0.04u
M30081 U3211/net28 U3211/net40 U3211/net24 VSS nmos W=0.155u L=0.04u
M30082 U3211/net40 WX11149 U3211/net108 VSS nmos W=0.155u L=0.04u
M30083 U3211/net40 U3211/net106 U3211/net104 VSS nmos W=0.155u L=0.04u
M30084 U3211/net24 n2393 U3211/net050 VSS nmos W=0.155u L=0.04u
M30085 U3211/net050 U3211/net32 VSS VSS nmos W=0.155u L=0.04u
M30086 U3211/net20 U3211/net40 VSS VSS nmos W=0.155u L=0.04u
M30087 U3211/net106 WX11149 VSS VSS nmos W=0.155u L=0.04u
M30088 U3211/net104 WX11213 VSS VSS nmos W=0.155u L=0.04u
M30089 U3211/net30 n2393 VSS VSS nmos W=0.155u L=0.04u
M30090 U3211/net108 U3211/net104 VSS VSS nmos W=0.155u L=0.04u
M30091 n1452 U3211/net28 VSS VSS nmos W=0.155u L=0.04u
M30092 U3211/net32 WX11021 VSS VSS nmos W=0.155u L=0.04u
M30093 U3211/net64 U3211/net24 VSS VSS nmos W=0.2u L=0.04u
M30094 U3211/net28 U3211/net40 U3211/net64 VDD pmos W=0.205u L=0.04u
M30095 U3211/net24 n2393 U3211/net32 VDD pmos W=0.205u L=0.04u
M30096 U3211/net28 U3211/net20 U3211/net24 VDD pmos W=0.205u L=0.04u
M30097 U3211/net40 U3211/net106 U3211/net108 VDD pmos W=0.205u L=0.04u
M30098 U3211/net40 WX11149 U3211/net104 VDD pmos W=0.205u L=0.04u
M30099 U3211/net20 U3211/net40 VDD VDD pmos W=0.205u L=0.04u
M30100 U3211/net106 WX11149 VDD VDD pmos W=0.205u L=0.04u
M30101 U3211/net104 WX11213 VDD VDD pmos W=0.205u L=0.04u
M30102 U3211/net30 n2393 VDD VDD pmos W=0.205u L=0.04u
M30103 U3211/net108 U3211/net104 VDD VDD pmos W=0.205u L=0.04u
M30104 n1452 U3211/net28 VDD VDD pmos W=0.205u L=0.04u
M30105 U3211/net32 WX11021 VDD VDD pmos W=0.205u L=0.04u
M30106 U3211/net64 U3211/net24 VDD VDD pmos W=0.28u L=0.04u
M30107 U3211/net24 U3211/net30 U3211/net045 VDD pmos W=0.205u L=0.04u
M30108 U3211/net045 U3211/net32 VDD VDD pmos W=0.205u L=0.04u
M30109 n2393 WX11085 VSS VSS nmos W=0.135u L=0.04u
M30110 n2393 WX11085 VDD VDD pmos W=0.205u L=0.04u
M30111 WX10592 n1245 U3213/net26 VSS nmos W=0.155u L=0.04u
M30112 WX10592 n1455 U3213/net26 VSS nmos W=0.155u L=0.04u
M30113 U3213/net29 n2395 VSS VSS nmos W=0.155u L=0.04u
M30114 U3213/net26 n2394 U3213/net29 VSS nmos W=0.155u L=0.04u
M30115 U3213/net26 n1615 U3213/net29 VSS nmos W=0.155u L=0.04u
M30116 WX10592 n1455 U3213/net43 VDD pmos W=0.205u L=0.04u
M30117 WX10592 n1615 U3213/net49 VDD pmos W=0.205u L=0.04u
M30118 U3213/net49 n2394 VDD VDD pmos W=0.205u L=0.04u
M30119 U3213/net43 n1245 VDD VDD pmos W=0.205u L=0.04u
M30120 WX10592 n2395 VDD VDD pmos W=0.205u L=0.04u
M30121 U3214/net29 n1344 VSS VSS nmos W=0.155u L=0.04u
M30122 n2395 WX10859 U3214/net29 VSS nmos W=0.155u L=0.04u
M30123 n2395 DATA_0_16 U3214/net23 VSS nmos W=0.155u L=0.04u
M30124 U3214/net23 n1617 VSS VSS nmos W=0.155u L=0.04u
M30125 U3214/net20 n1617 n2395 VDD pmos W=0.205u L=0.04u
M30126 U3214/net20 DATA_0_16 n2395 VDD pmos W=0.205u L=0.04u
M30127 VDD WX10859 U3214/net20 VDD pmos W=0.205u L=0.04u
M30128 VDD n1344 U3214/net20 VDD pmos W=0.205u L=0.04u
M30129 n2394 CRC_OUT_1_16 VSS VSS nmos W=0.135u L=0.04u
M30130 n2394 CRC_OUT_1_16 VDD VDD pmos W=0.205u L=0.04u
M30131 U3216/net28 U3216/net20 U3216/net64 VSS nmos W=0.155u L=0.04u
M30132 U3216/net24 U3216/net30 U3216/net32 VSS nmos W=0.155u L=0.04u
M30133 U3216/net28 U3216/net40 U3216/net24 VSS nmos W=0.155u L=0.04u
M30134 U3216/net40 n2397 U3216/net108 VSS nmos W=0.155u L=0.04u
M30135 U3216/net40 U3216/net106 U3216/net104 VSS nmos W=0.155u L=0.04u
M30136 U3216/net24 n2396 U3216/net050 VSS nmos W=0.155u L=0.04u
M30137 U3216/net050 U3216/net32 VSS VSS nmos W=0.155u L=0.04u
M30138 U3216/net20 U3216/net40 VSS VSS nmos W=0.155u L=0.04u
M30139 U3216/net106 n2397 VSS VSS nmos W=0.155u L=0.04u
M30140 U3216/net104 WX11211 VSS VSS nmos W=0.155u L=0.04u
M30141 U3216/net30 n2396 VSS VSS nmos W=0.155u L=0.04u
M30142 U3216/net108 U3216/net104 VSS VSS nmos W=0.155u L=0.04u
M30143 n1455 U3216/net28 VSS VSS nmos W=0.155u L=0.04u
M30144 U3216/net32 WX11083 VSS VSS nmos W=0.155u L=0.04u
M30145 U3216/net64 U3216/net24 VSS VSS nmos W=0.2u L=0.04u
M30146 U3216/net28 U3216/net40 U3216/net64 VDD pmos W=0.205u L=0.04u
M30147 U3216/net24 n2396 U3216/net32 VDD pmos W=0.205u L=0.04u
M30148 U3216/net28 U3216/net20 U3216/net24 VDD pmos W=0.205u L=0.04u
M30149 U3216/net40 U3216/net106 U3216/net108 VDD pmos W=0.205u L=0.04u
M30150 U3216/net40 n2397 U3216/net104 VDD pmos W=0.205u L=0.04u
M30151 U3216/net20 U3216/net40 VDD VDD pmos W=0.205u L=0.04u
M30152 U3216/net106 n2397 VDD VDD pmos W=0.205u L=0.04u
M30153 U3216/net104 WX11211 VDD VDD pmos W=0.205u L=0.04u
M30154 U3216/net30 n2396 VDD VDD pmos W=0.205u L=0.04u
M30155 U3216/net108 U3216/net104 VDD VDD pmos W=0.205u L=0.04u
M30156 n1455 U3216/net28 VDD VDD pmos W=0.205u L=0.04u
M30157 U3216/net32 WX11083 VDD VDD pmos W=0.205u L=0.04u
M30158 U3216/net64 U3216/net24 VDD VDD pmos W=0.28u L=0.04u
M30159 U3216/net24 U3216/net30 U3216/net045 VDD pmos W=0.205u L=0.04u
M30160 U3216/net045 U3216/net32 VDD VDD pmos W=0.205u L=0.04u
M30161 U3217/net4 WX11019 U3217/net14 VSS nmos W=0.155u L=0.04u
M30162 U3217/net6 U3217/net10 U3217/net14 VSS nmos W=0.17u L=0.04u
M30163 U3217/net4 n1378 VSS VSS nmos W=0.155u L=0.04u
M30164 U3217/net6 U3217/net4 VSS VSS nmos W=0.17u L=0.04u
M30165 n2397 U3217/net14 VSS VSS nmos W=0.155u L=0.04u
M30166 U3217/net10 WX11019 VSS VSS nmos W=0.155u L=0.04u
M30167 U3217/net4 U3217/net10 U3217/net14 VDD pmos W=0.255u L=0.04u
M30168 U3217/net6 WX11019 U3217/net14 VDD pmos W=0.28u L=0.04u
M30169 U3217/net4 n1378 VDD VDD pmos W=0.205u L=0.04u
M30170 U3217/net6 U3217/net4 VDD VDD pmos W=0.24u L=0.04u
M30171 n2397 U3217/net14 VDD VDD pmos W=0.205u L=0.04u
M30172 U3217/net10 WX11019 VDD VDD pmos W=0.205u L=0.04u
M30173 n2396 WX11147 VSS VSS nmos W=0.135u L=0.04u
M30174 n2396 WX11147 VDD VDD pmos W=0.205u L=0.04u
M30175 U3219/net4 U3219/net10 U3219/net14 VSS nmos W=0.155u L=0.04u
M30176 U3219/net6 n2249 U3219/net14 VSS nmos W=0.155u L=0.04u
M30177 U3219/net4 n2398 VSS VSS nmos W=0.155u L=0.04u
M30178 U3219/net6 U3219/net4 VSS VSS nmos W=0.155u L=0.04u
M30179 WX1059 U3219/net14 VSS VSS nmos W=0.155u L=0.04u
M30180 U3219/net10 n2249 VSS VSS nmos W=0.155u L=0.04u
M30181 U3219/net4 n2249 U3219/net14 VDD pmos W=0.205u L=0.04u
M30182 U3219/net6 U3219/net10 U3219/net14 VDD pmos W=0.205u L=0.04u
M30183 U3219/net4 n2398 VDD VDD pmos W=0.205u L=0.04u
M30184 U3219/net6 U3219/net4 VDD VDD pmos W=0.205u L=0.04u
M30185 WX1059 U3219/net14 VDD VDD pmos W=0.205u L=0.04u
M30186 U3219/net10 n2249 VDD VDD pmos W=0.205u L=0.04u
M30187 U3220/XU1-net6 TM0 VSS VSS nmos W=0.155u L=0.04u
M30188 n2398 WX499 U3220/XU1-net6 VSS nmos W=0.155u L=0.04u
M30189 n2398 TM0 VDD VDD pmos W=0.155u L=0.04u
M30190 n2398 WX499 VDD VDD pmos W=0.155u L=0.04u
M30191 n2249 n2399 VSS VSS nmos W=0.135u L=0.04u
M30192 n2249 n2399 VDD VDD pmos W=0.205u L=0.04u
M30193 U3222/net28 U3222/net20 U3222/net64 VSS nmos W=0.155u L=0.04u
M30194 U3222/net24 U3222/net30 U3222/net32 VSS nmos W=0.155u L=0.04u
M30195 U3222/net28 U3222/net40 U3222/net24 VSS nmos W=0.155u L=0.04u
M30196 U3222/net40 n2400 U3222/net108 VSS nmos W=0.155u L=0.04u
M30197 U3222/net40 U3222/net106 U3222/net104 VSS nmos W=0.155u L=0.04u
M30198 U3222/net24 WX787 U3222/net050 VSS nmos W=0.155u L=0.04u
M30199 U3222/net050 U3222/net32 VSS VSS nmos W=0.155u L=0.04u
M30200 U3222/net20 U3222/net40 VSS VSS nmos W=0.155u L=0.04u
M30201 U3222/net106 n2400 VSS VSS nmos W=0.155u L=0.04u
M30202 U3222/net104 WX851 VSS VSS nmos W=0.155u L=0.04u
M30203 U3222/net30 WX787 VSS VSS nmos W=0.155u L=0.04u
M30204 U3222/net108 U3222/net104 VSS VSS nmos W=0.155u L=0.04u
M30205 n2399 U3222/net28 VSS VSS nmos W=0.155u L=0.04u
M30206 U3222/net32 WX723 VSS VSS nmos W=0.155u L=0.04u
M30207 U3222/net64 U3222/net24 VSS VSS nmos W=0.2u L=0.04u
M30208 U3222/net28 U3222/net40 U3222/net64 VDD pmos W=0.205u L=0.04u
M30209 U3222/net24 WX787 U3222/net32 VDD pmos W=0.205u L=0.04u
M30210 U3222/net28 U3222/net20 U3222/net24 VDD pmos W=0.205u L=0.04u
M30211 U3222/net40 U3222/net106 U3222/net108 VDD pmos W=0.205u L=0.04u
M30212 U3222/net40 n2400 U3222/net104 VDD pmos W=0.205u L=0.04u
M30213 U3222/net20 U3222/net40 VDD VDD pmos W=0.205u L=0.04u
M30214 U3222/net106 n2400 VDD VDD pmos W=0.205u L=0.04u
M30215 U3222/net104 WX851 VDD VDD pmos W=0.205u L=0.04u
M30216 U3222/net30 WX787 VDD VDD pmos W=0.205u L=0.04u
M30217 U3222/net108 U3222/net104 VDD VDD pmos W=0.205u L=0.04u
M30218 n2399 U3222/net28 VDD VDD pmos W=0.205u L=0.04u
M30219 U3222/net32 WX723 VDD VDD pmos W=0.205u L=0.04u
M30220 U3222/net64 U3222/net24 VDD VDD pmos W=0.28u L=0.04u
M30221 U3222/net24 U3222/net30 U3222/net045 VDD pmos W=0.205u L=0.04u
M30222 U3222/net045 U3222/net32 VDD VDD pmos W=0.205u L=0.04u
M30223 U3223/net4 WX659 U3223/net14 VSS nmos W=0.155u L=0.04u
M30224 U3223/net6 U3223/net10 U3223/net14 VSS nmos W=0.17u L=0.04u
M30225 U3223/net4 n1378 VSS VSS nmos W=0.155u L=0.04u
M30226 U3223/net6 U3223/net4 VSS VSS nmos W=0.17u L=0.04u
M30227 n2400 U3223/net14 VSS VSS nmos W=0.155u L=0.04u
M30228 U3223/net10 WX659 VSS VSS nmos W=0.155u L=0.04u
M30229 U3223/net4 U3223/net10 U3223/net14 VDD pmos W=0.255u L=0.04u
M30230 U3223/net6 WX659 U3223/net14 VDD pmos W=0.28u L=0.04u
M30231 U3223/net4 n1378 VDD VDD pmos W=0.205u L=0.04u
M30232 U3223/net6 U3223/net4 VDD VDD pmos W=0.24u L=0.04u
M30233 n2400 U3223/net14 VDD VDD pmos W=0.205u L=0.04u
M30234 U3223/net10 WX659 VDD VDD pmos W=0.205u L=0.04u
M30235 WX10578 n1245 U3224/net26 VSS nmos W=0.155u L=0.04u
M30236 WX10578 n1458 U3224/net26 VSS nmos W=0.155u L=0.04u
M30237 U3224/net29 n2402 VSS VSS nmos W=0.155u L=0.04u
M30238 U3224/net26 n2401 U3224/net29 VSS nmos W=0.155u L=0.04u
M30239 U3224/net26 n1615 U3224/net29 VSS nmos W=0.155u L=0.04u
M30240 WX10578 n1458 U3224/net43 VDD pmos W=0.205u L=0.04u
M30241 WX10578 n1615 U3224/net49 VDD pmos W=0.205u L=0.04u
M30242 U3224/net49 n2401 VDD VDD pmos W=0.205u L=0.04u
M30243 U3224/net43 n1245 VDD VDD pmos W=0.205u L=0.04u
M30244 WX10578 n2402 VDD VDD pmos W=0.205u L=0.04u
M30245 U3225/net29 n1344 VSS VSS nmos W=0.155u L=0.04u
M30246 n2402 WX10857 U3225/net29 VSS nmos W=0.155u L=0.04u
M30247 n2402 DATA_0_17 U3225/net23 VSS nmos W=0.155u L=0.04u
M30248 U3225/net23 n1617 VSS VSS nmos W=0.155u L=0.04u
M30249 U3225/net20 n1617 n2402 VDD pmos W=0.205u L=0.04u
M30250 U3225/net20 DATA_0_17 n2402 VDD pmos W=0.205u L=0.04u
M30251 VDD WX10857 U3225/net20 VDD pmos W=0.205u L=0.04u
M30252 VDD n1344 U3225/net20 VDD pmos W=0.205u L=0.04u
M30253 n2401 CRC_OUT_1_17 VSS VSS nmos W=0.135u L=0.04u
M30254 n2401 CRC_OUT_1_17 VDD VDD pmos W=0.205u L=0.04u
M30255 U3227/net28 U3227/net20 U3227/net64 VSS nmos W=0.155u L=0.04u
M30256 U3227/net24 U3227/net30 U3227/net32 VSS nmos W=0.155u L=0.04u
M30257 U3227/net28 U3227/net40 U3227/net24 VSS nmos W=0.155u L=0.04u
M30258 U3227/net40 n2404 U3227/net108 VSS nmos W=0.155u L=0.04u
M30259 U3227/net40 U3227/net106 U3227/net104 VSS nmos W=0.155u L=0.04u
M30260 U3227/net24 n2403 U3227/net050 VSS nmos W=0.155u L=0.04u
M30261 U3227/net050 U3227/net32 VSS VSS nmos W=0.155u L=0.04u
M30262 U3227/net20 U3227/net40 VSS VSS nmos W=0.155u L=0.04u
M30263 U3227/net106 n2404 VSS VSS nmos W=0.155u L=0.04u
M30264 U3227/net104 WX11209 VSS VSS nmos W=0.155u L=0.04u
M30265 U3227/net30 n2403 VSS VSS nmos W=0.155u L=0.04u
M30266 U3227/net108 U3227/net104 VSS VSS nmos W=0.155u L=0.04u
M30267 n1458 U3227/net28 VSS VSS nmos W=0.155u L=0.04u
M30268 U3227/net32 WX11081 VSS VSS nmos W=0.155u L=0.04u
M30269 U3227/net64 U3227/net24 VSS VSS nmos W=0.2u L=0.04u
M30270 U3227/net28 U3227/net40 U3227/net64 VDD pmos W=0.205u L=0.04u
M30271 U3227/net24 n2403 U3227/net32 VDD pmos W=0.205u L=0.04u
M30272 U3227/net28 U3227/net20 U3227/net24 VDD pmos W=0.205u L=0.04u
M30273 U3227/net40 U3227/net106 U3227/net108 VDD pmos W=0.205u L=0.04u
M30274 U3227/net40 n2404 U3227/net104 VDD pmos W=0.205u L=0.04u
M30275 U3227/net20 U3227/net40 VDD VDD pmos W=0.205u L=0.04u
M30276 U3227/net106 n2404 VDD VDD pmos W=0.205u L=0.04u
M30277 U3227/net104 WX11209 VDD VDD pmos W=0.205u L=0.04u
M30278 U3227/net30 n2403 VDD VDD pmos W=0.205u L=0.04u
M30279 U3227/net108 U3227/net104 VDD VDD pmos W=0.205u L=0.04u
M30280 n1458 U3227/net28 VDD VDD pmos W=0.205u L=0.04u
M30281 U3227/net32 WX11081 VDD VDD pmos W=0.205u L=0.04u
M30282 U3227/net64 U3227/net24 VDD VDD pmos W=0.28u L=0.04u
M30283 U3227/net24 U3227/net30 U3227/net045 VDD pmos W=0.205u L=0.04u
M30284 U3227/net045 U3227/net32 VDD VDD pmos W=0.205u L=0.04u
M30285 U3228/net4 WX11017 U3228/net14 VSS nmos W=0.155u L=0.04u
M30286 U3228/net6 U3228/net10 U3228/net14 VSS nmos W=0.17u L=0.04u
M30287 U3228/net4 n1378 VSS VSS nmos W=0.155u L=0.04u
M30288 U3228/net6 U3228/net4 VSS VSS nmos W=0.17u L=0.04u
M30289 n2404 U3228/net14 VSS VSS nmos W=0.155u L=0.04u
M30290 U3228/net10 WX11017 VSS VSS nmos W=0.155u L=0.04u
M30291 U3228/net4 U3228/net10 U3228/net14 VDD pmos W=0.255u L=0.04u
M30292 U3228/net6 WX11017 U3228/net14 VDD pmos W=0.28u L=0.04u
M30293 U3228/net4 n1378 VDD VDD pmos W=0.205u L=0.04u
M30294 U3228/net6 U3228/net4 VDD VDD pmos W=0.24u L=0.04u
M30295 n2404 U3228/net14 VDD VDD pmos W=0.205u L=0.04u
M30296 U3228/net10 WX11017 VDD VDD pmos W=0.205u L=0.04u
M30297 n2403 WX11145 VSS VSS nmos W=0.135u L=0.04u
M30298 n2403 WX11145 VDD VDD pmos W=0.205u L=0.04u
M30299 WX10564 n1245 U3230/net26 VSS nmos W=0.155u L=0.04u
M30300 WX10564 n1461 U3230/net26 VSS nmos W=0.155u L=0.04u
M30301 U3230/net29 n2406 VSS VSS nmos W=0.155u L=0.04u
M30302 U3230/net26 n2405 U3230/net29 VSS nmos W=0.155u L=0.04u
M30303 U3230/net26 n1615 U3230/net29 VSS nmos W=0.155u L=0.04u
M30304 WX10564 n1461 U3230/net43 VDD pmos W=0.205u L=0.04u
M30305 WX10564 n1615 U3230/net49 VDD pmos W=0.205u L=0.04u
M30306 U3230/net49 n2405 VDD VDD pmos W=0.205u L=0.04u
M30307 U3230/net43 n1245 VDD VDD pmos W=0.205u L=0.04u
M30308 WX10564 n2406 VDD VDD pmos W=0.205u L=0.04u
M30309 U3231/net29 n1344 VSS VSS nmos W=0.155u L=0.04u
M30310 n2406 WX10855 U3231/net29 VSS nmos W=0.155u L=0.04u
M30311 n2406 DATA_0_18 U3231/net23 VSS nmos W=0.155u L=0.04u
M30312 U3231/net23 n1617 VSS VSS nmos W=0.155u L=0.04u
M30313 U3231/net20 n1617 n2406 VDD pmos W=0.205u L=0.04u
M30314 U3231/net20 DATA_0_18 n2406 VDD pmos W=0.205u L=0.04u
M30315 VDD WX10855 U3231/net20 VDD pmos W=0.205u L=0.04u
M30316 VDD n1344 U3231/net20 VDD pmos W=0.205u L=0.04u
M30317 n2405 CRC_OUT_1_18 VSS VSS nmos W=0.135u L=0.04u
M30318 n2405 CRC_OUT_1_18 VDD VDD pmos W=0.205u L=0.04u
M30319 U3233/net28 U3233/net20 U3233/net64 VSS nmos W=0.155u L=0.04u
M30320 U3233/net24 U3233/net30 U3233/net32 VSS nmos W=0.155u L=0.04u
M30321 U3233/net28 U3233/net40 U3233/net24 VSS nmos W=0.155u L=0.04u
M30322 U3233/net40 n2408 U3233/net108 VSS nmos W=0.155u L=0.04u
M30323 U3233/net40 U3233/net106 U3233/net104 VSS nmos W=0.155u L=0.04u
M30324 U3233/net24 n2407 U3233/net050 VSS nmos W=0.155u L=0.04u
M30325 U3233/net050 U3233/net32 VSS VSS nmos W=0.155u L=0.04u
M30326 U3233/net20 U3233/net40 VSS VSS nmos W=0.155u L=0.04u
M30327 U3233/net106 n2408 VSS VSS nmos W=0.155u L=0.04u
M30328 U3233/net104 WX11207 VSS VSS nmos W=0.155u L=0.04u
M30329 U3233/net30 n2407 VSS VSS nmos W=0.155u L=0.04u
M30330 U3233/net108 U3233/net104 VSS VSS nmos W=0.155u L=0.04u
M30331 n1461 U3233/net28 VSS VSS nmos W=0.155u L=0.04u
M30332 U3233/net32 WX11079 VSS VSS nmos W=0.155u L=0.04u
M30333 U3233/net64 U3233/net24 VSS VSS nmos W=0.2u L=0.04u
M30334 U3233/net28 U3233/net40 U3233/net64 VDD pmos W=0.205u L=0.04u
M30335 U3233/net24 n2407 U3233/net32 VDD pmos W=0.205u L=0.04u
M30336 U3233/net28 U3233/net20 U3233/net24 VDD pmos W=0.205u L=0.04u
M30337 U3233/net40 U3233/net106 U3233/net108 VDD pmos W=0.205u L=0.04u
M30338 U3233/net40 n2408 U3233/net104 VDD pmos W=0.205u L=0.04u
M30339 U3233/net20 U3233/net40 VDD VDD pmos W=0.205u L=0.04u
M30340 U3233/net106 n2408 VDD VDD pmos W=0.205u L=0.04u
M30341 U3233/net104 WX11207 VDD VDD pmos W=0.205u L=0.04u
M30342 U3233/net30 n2407 VDD VDD pmos W=0.205u L=0.04u
M30343 U3233/net108 U3233/net104 VDD VDD pmos W=0.205u L=0.04u
M30344 n1461 U3233/net28 VDD VDD pmos W=0.205u L=0.04u
M30345 U3233/net32 WX11079 VDD VDD pmos W=0.205u L=0.04u
M30346 U3233/net64 U3233/net24 VDD VDD pmos W=0.28u L=0.04u
M30347 U3233/net24 U3233/net30 U3233/net045 VDD pmos W=0.205u L=0.04u
M30348 U3233/net045 U3233/net32 VDD VDD pmos W=0.205u L=0.04u
M30349 U3234/net4 WX11015 U3234/net14 VSS nmos W=0.155u L=0.04u
M30350 U3234/net6 U3234/net10 U3234/net14 VSS nmos W=0.17u L=0.04u
M30351 U3234/net4 n1378 VSS VSS nmos W=0.155u L=0.04u
M30352 U3234/net6 U3234/net4 VSS VSS nmos W=0.17u L=0.04u
M30353 n2408 U3234/net14 VSS VSS nmos W=0.155u L=0.04u
M30354 U3234/net10 WX11015 VSS VSS nmos W=0.155u L=0.04u
M30355 U3234/net4 U3234/net10 U3234/net14 VDD pmos W=0.255u L=0.04u
M30356 U3234/net6 WX11015 U3234/net14 VDD pmos W=0.28u L=0.04u
M30357 U3234/net4 n1378 VDD VDD pmos W=0.205u L=0.04u
M30358 U3234/net6 U3234/net4 VDD VDD pmos W=0.24u L=0.04u
M30359 n2408 U3234/net14 VDD VDD pmos W=0.205u L=0.04u
M30360 U3234/net10 WX11015 VDD VDD pmos W=0.205u L=0.04u
M30361 n2407 WX11143 VSS VSS nmos W=0.135u L=0.04u
M30362 n2407 WX11143 VDD VDD pmos W=0.205u L=0.04u
M30363 WX10550 n1246 U3236/net26 VSS nmos W=0.155u L=0.04u
M30364 WX10550 n1464 U3236/net26 VSS nmos W=0.155u L=0.04u
M30365 U3236/net29 n2410 VSS VSS nmos W=0.155u L=0.04u
M30366 U3236/net26 n2409 U3236/net29 VSS nmos W=0.155u L=0.04u
M30367 U3236/net26 n1615 U3236/net29 VSS nmos W=0.155u L=0.04u
M30368 WX10550 n1464 U3236/net43 VDD pmos W=0.205u L=0.04u
M30369 WX10550 n1615 U3236/net49 VDD pmos W=0.205u L=0.04u
M30370 U3236/net49 n2409 VDD VDD pmos W=0.205u L=0.04u
M30371 U3236/net43 n1246 VDD VDD pmos W=0.205u L=0.04u
M30372 WX10550 n2410 VDD VDD pmos W=0.205u L=0.04u
M30373 U3237/net29 n1344 VSS VSS nmos W=0.155u L=0.04u
M30374 n2410 WX10853 U3237/net29 VSS nmos W=0.155u L=0.04u
M30375 n2410 DATA_0_19 U3237/net23 VSS nmos W=0.155u L=0.04u
M30376 U3237/net23 n1617 VSS VSS nmos W=0.155u L=0.04u
M30377 U3237/net20 n1617 n2410 VDD pmos W=0.205u L=0.04u
M30378 U3237/net20 DATA_0_19 n2410 VDD pmos W=0.205u L=0.04u
M30379 VDD WX10853 U3237/net20 VDD pmos W=0.205u L=0.04u
M30380 VDD n1344 U3237/net20 VDD pmos W=0.205u L=0.04u
M30381 n2409 CRC_OUT_1_19 VSS VSS nmos W=0.135u L=0.04u
M30382 n2409 CRC_OUT_1_19 VDD VDD pmos W=0.205u L=0.04u
M30383 U3239/net28 U3239/net20 U3239/net64 VSS nmos W=0.155u L=0.04u
M30384 U3239/net24 U3239/net30 U3239/net32 VSS nmos W=0.155u L=0.04u
M30385 U3239/net28 U3239/net40 U3239/net24 VSS nmos W=0.155u L=0.04u
M30386 U3239/net40 n2412 U3239/net108 VSS nmos W=0.155u L=0.04u
M30387 U3239/net40 U3239/net106 U3239/net104 VSS nmos W=0.155u L=0.04u
M30388 U3239/net24 n2411 U3239/net050 VSS nmos W=0.155u L=0.04u
M30389 U3239/net050 U3239/net32 VSS VSS nmos W=0.155u L=0.04u
M30390 U3239/net20 U3239/net40 VSS VSS nmos W=0.155u L=0.04u
M30391 U3239/net106 n2412 VSS VSS nmos W=0.155u L=0.04u
M30392 U3239/net104 WX11205 VSS VSS nmos W=0.155u L=0.04u
M30393 U3239/net30 n2411 VSS VSS nmos W=0.155u L=0.04u
M30394 U3239/net108 U3239/net104 VSS VSS nmos W=0.155u L=0.04u
M30395 n1464 U3239/net28 VSS VSS nmos W=0.155u L=0.04u
M30396 U3239/net32 WX11077 VSS VSS nmos W=0.155u L=0.04u
M30397 U3239/net64 U3239/net24 VSS VSS nmos W=0.2u L=0.04u
M30398 U3239/net28 U3239/net40 U3239/net64 VDD pmos W=0.205u L=0.04u
M30399 U3239/net24 n2411 U3239/net32 VDD pmos W=0.205u L=0.04u
M30400 U3239/net28 U3239/net20 U3239/net24 VDD pmos W=0.205u L=0.04u
M30401 U3239/net40 U3239/net106 U3239/net108 VDD pmos W=0.205u L=0.04u
M30402 U3239/net40 n2412 U3239/net104 VDD pmos W=0.205u L=0.04u
M30403 U3239/net20 U3239/net40 VDD VDD pmos W=0.205u L=0.04u
M30404 U3239/net106 n2412 VDD VDD pmos W=0.205u L=0.04u
M30405 U3239/net104 WX11205 VDD VDD pmos W=0.205u L=0.04u
M30406 U3239/net30 n2411 VDD VDD pmos W=0.205u L=0.04u
M30407 U3239/net108 U3239/net104 VDD VDD pmos W=0.205u L=0.04u
M30408 n1464 U3239/net28 VDD VDD pmos W=0.205u L=0.04u
M30409 U3239/net32 WX11077 VDD VDD pmos W=0.205u L=0.04u
M30410 U3239/net64 U3239/net24 VDD VDD pmos W=0.28u L=0.04u
M30411 U3239/net24 U3239/net30 U3239/net045 VDD pmos W=0.205u L=0.04u
M30412 U3239/net045 U3239/net32 VDD VDD pmos W=0.205u L=0.04u
M30413 U3240/net4 WX11013 U3240/net14 VSS nmos W=0.155u L=0.04u
M30414 U3240/net6 U3240/net10 U3240/net14 VSS nmos W=0.17u L=0.04u
M30415 U3240/net4 n1378 VSS VSS nmos W=0.155u L=0.04u
M30416 U3240/net6 U3240/net4 VSS VSS nmos W=0.17u L=0.04u
M30417 n2412 U3240/net14 VSS VSS nmos W=0.155u L=0.04u
M30418 U3240/net10 WX11013 VSS VSS nmos W=0.155u L=0.04u
M30419 U3240/net4 U3240/net10 U3240/net14 VDD pmos W=0.255u L=0.04u
M30420 U3240/net6 WX11013 U3240/net14 VDD pmos W=0.28u L=0.04u
M30421 U3240/net4 n1378 VDD VDD pmos W=0.205u L=0.04u
M30422 U3240/net6 U3240/net4 VDD VDD pmos W=0.24u L=0.04u
M30423 n2412 U3240/net14 VDD VDD pmos W=0.205u L=0.04u
M30424 U3240/net10 WX11013 VDD VDD pmos W=0.205u L=0.04u
M30425 n2411 WX11141 VSS VSS nmos W=0.135u L=0.04u
M30426 n2411 WX11141 VDD VDD pmos W=0.205u L=0.04u
M30427 WX10536 n1246 U3242/net26 VSS nmos W=0.155u L=0.04u
M30428 WX10536 n1467 U3242/net26 VSS nmos W=0.155u L=0.04u
M30429 U3242/net29 n2414 VSS VSS nmos W=0.155u L=0.04u
M30430 U3242/net26 n2413 U3242/net29 VSS nmos W=0.155u L=0.04u
M30431 U3242/net26 n1615 U3242/net29 VSS nmos W=0.155u L=0.04u
M30432 WX10536 n1467 U3242/net43 VDD pmos W=0.205u L=0.04u
M30433 WX10536 n1615 U3242/net49 VDD pmos W=0.205u L=0.04u
M30434 U3242/net49 n2413 VDD VDD pmos W=0.205u L=0.04u
M30435 U3242/net43 n1246 VDD VDD pmos W=0.205u L=0.04u
M30436 WX10536 n2414 VDD VDD pmos W=0.205u L=0.04u
M30437 U3243/net29 n1344 VSS VSS nmos W=0.155u L=0.04u
M30438 n2414 WX10851 U3243/net29 VSS nmos W=0.155u L=0.04u
M30439 n2414 DATA_0_20 U3243/net23 VSS nmos W=0.155u L=0.04u
M30440 U3243/net23 n1617 VSS VSS nmos W=0.155u L=0.04u
M30441 U3243/net20 n1617 n2414 VDD pmos W=0.205u L=0.04u
M30442 U3243/net20 DATA_0_20 n2414 VDD pmos W=0.205u L=0.04u
M30443 VDD WX10851 U3243/net20 VDD pmos W=0.205u L=0.04u
M30444 VDD n1344 U3243/net20 VDD pmos W=0.205u L=0.04u
M30445 n2413 CRC_OUT_1_20 VSS VSS nmos W=0.135u L=0.04u
M30446 n2413 CRC_OUT_1_20 VDD VDD pmos W=0.205u L=0.04u
M30447 U3245/net28 U3245/net20 U3245/net64 VSS nmos W=0.155u L=0.04u
M30448 U3245/net24 U3245/net30 U3245/net32 VSS nmos W=0.155u L=0.04u
M30449 U3245/net28 U3245/net40 U3245/net24 VSS nmos W=0.155u L=0.04u
M30450 U3245/net40 n2416 U3245/net108 VSS nmos W=0.155u L=0.04u
M30451 U3245/net40 U3245/net106 U3245/net104 VSS nmos W=0.155u L=0.04u
M30452 U3245/net24 n2415 U3245/net050 VSS nmos W=0.155u L=0.04u
M30453 U3245/net050 U3245/net32 VSS VSS nmos W=0.155u L=0.04u
M30454 U3245/net20 U3245/net40 VSS VSS nmos W=0.155u L=0.04u
M30455 U3245/net106 n2416 VSS VSS nmos W=0.155u L=0.04u
M30456 U3245/net104 WX11203 VSS VSS nmos W=0.155u L=0.04u
M30457 U3245/net30 n2415 VSS VSS nmos W=0.155u L=0.04u
M30458 U3245/net108 U3245/net104 VSS VSS nmos W=0.155u L=0.04u
M30459 n1467 U3245/net28 VSS VSS nmos W=0.155u L=0.04u
M30460 U3245/net32 WX11075 VSS VSS nmos W=0.155u L=0.04u
M30461 U3245/net64 U3245/net24 VSS VSS nmos W=0.2u L=0.04u
M30462 U3245/net28 U3245/net40 U3245/net64 VDD pmos W=0.205u L=0.04u
M30463 U3245/net24 n2415 U3245/net32 VDD pmos W=0.205u L=0.04u
M30464 U3245/net28 U3245/net20 U3245/net24 VDD pmos W=0.205u L=0.04u
M30465 U3245/net40 U3245/net106 U3245/net108 VDD pmos W=0.205u L=0.04u
M30466 U3245/net40 n2416 U3245/net104 VDD pmos W=0.205u L=0.04u
M30467 U3245/net20 U3245/net40 VDD VDD pmos W=0.205u L=0.04u
M30468 U3245/net106 n2416 VDD VDD pmos W=0.205u L=0.04u
M30469 U3245/net104 WX11203 VDD VDD pmos W=0.205u L=0.04u
M30470 U3245/net30 n2415 VDD VDD pmos W=0.205u L=0.04u
M30471 U3245/net108 U3245/net104 VDD VDD pmos W=0.205u L=0.04u
M30472 n1467 U3245/net28 VDD VDD pmos W=0.205u L=0.04u
M30473 U3245/net32 WX11075 VDD VDD pmos W=0.205u L=0.04u
M30474 U3245/net64 U3245/net24 VDD VDD pmos W=0.28u L=0.04u
M30475 U3245/net24 U3245/net30 U3245/net045 VDD pmos W=0.205u L=0.04u
M30476 U3245/net045 U3245/net32 VDD VDD pmos W=0.205u L=0.04u
M30477 U3246/net4 WX11011 U3246/net14 VSS nmos W=0.155u L=0.04u
M30478 U3246/net6 U3246/net10 U3246/net14 VSS nmos W=0.17u L=0.04u
M30479 U3246/net4 n1378 VSS VSS nmos W=0.155u L=0.04u
M30480 U3246/net6 U3246/net4 VSS VSS nmos W=0.17u L=0.04u
M30481 n2416 U3246/net14 VSS VSS nmos W=0.155u L=0.04u
M30482 U3246/net10 WX11011 VSS VSS nmos W=0.155u L=0.04u
M30483 U3246/net4 U3246/net10 U3246/net14 VDD pmos W=0.255u L=0.04u
M30484 U3246/net6 WX11011 U3246/net14 VDD pmos W=0.28u L=0.04u
M30485 U3246/net4 n1378 VDD VDD pmos W=0.205u L=0.04u
M30486 U3246/net6 U3246/net4 VDD VDD pmos W=0.24u L=0.04u
M30487 n2416 U3246/net14 VDD VDD pmos W=0.205u L=0.04u
M30488 U3246/net10 WX11011 VDD VDD pmos W=0.205u L=0.04u
M30489 n2415 WX11139 VSS VSS nmos W=0.135u L=0.04u
M30490 n2415 WX11139 VDD VDD pmos W=0.205u L=0.04u
M30491 WX10522 n1246 U3248/net26 VSS nmos W=0.155u L=0.04u
M30492 WX10522 n1470 U3248/net26 VSS nmos W=0.155u L=0.04u
M30493 U3248/net29 n2418 VSS VSS nmos W=0.155u L=0.04u
M30494 U3248/net26 n2417 U3248/net29 VSS nmos W=0.155u L=0.04u
M30495 U3248/net26 n1615 U3248/net29 VSS nmos W=0.155u L=0.04u
M30496 WX10522 n1470 U3248/net43 VDD pmos W=0.205u L=0.04u
M30497 WX10522 n1615 U3248/net49 VDD pmos W=0.205u L=0.04u
M30498 U3248/net49 n2417 VDD VDD pmos W=0.205u L=0.04u
M30499 U3248/net43 n1246 VDD VDD pmos W=0.205u L=0.04u
M30500 WX10522 n2418 VDD VDD pmos W=0.205u L=0.04u
M30501 U3249/net29 n1344 VSS VSS nmos W=0.155u L=0.04u
M30502 n2418 WX10849 U3249/net29 VSS nmos W=0.155u L=0.04u
M30503 n2418 DATA_0_21 U3249/net23 VSS nmos W=0.155u L=0.04u
M30504 U3249/net23 n1617 VSS VSS nmos W=0.155u L=0.04u
M30505 U3249/net20 n1617 n2418 VDD pmos W=0.205u L=0.04u
M30506 U3249/net20 DATA_0_21 n2418 VDD pmos W=0.205u L=0.04u
M30507 VDD WX10849 U3249/net20 VDD pmos W=0.205u L=0.04u
M30508 VDD n1344 U3249/net20 VDD pmos W=0.205u L=0.04u
M30509 n2417 CRC_OUT_1_21 VSS VSS nmos W=0.135u L=0.04u
M30510 n2417 CRC_OUT_1_21 VDD VDD pmos W=0.205u L=0.04u
M30511 U3251/net28 U3251/net20 U3251/net64 VSS nmos W=0.155u L=0.04u
M30512 U3251/net24 U3251/net30 U3251/net32 VSS nmos W=0.155u L=0.04u
M30513 U3251/net28 U3251/net40 U3251/net24 VSS nmos W=0.155u L=0.04u
M30514 U3251/net40 n2420 U3251/net108 VSS nmos W=0.155u L=0.04u
M30515 U3251/net40 U3251/net106 U3251/net104 VSS nmos W=0.155u L=0.04u
M30516 U3251/net24 n2419 U3251/net050 VSS nmos W=0.155u L=0.04u
M30517 U3251/net050 U3251/net32 VSS VSS nmos W=0.155u L=0.04u
M30518 U3251/net20 U3251/net40 VSS VSS nmos W=0.155u L=0.04u
M30519 U3251/net106 n2420 VSS VSS nmos W=0.155u L=0.04u
M30520 U3251/net104 WX11201 VSS VSS nmos W=0.155u L=0.04u
M30521 U3251/net30 n2419 VSS VSS nmos W=0.155u L=0.04u
M30522 U3251/net108 U3251/net104 VSS VSS nmos W=0.155u L=0.04u
M30523 n1470 U3251/net28 VSS VSS nmos W=0.155u L=0.04u
M30524 U3251/net32 WX11073 VSS VSS nmos W=0.155u L=0.04u
M30525 U3251/net64 U3251/net24 VSS VSS nmos W=0.2u L=0.04u
M30526 U3251/net28 U3251/net40 U3251/net64 VDD pmos W=0.205u L=0.04u
M30527 U3251/net24 n2419 U3251/net32 VDD pmos W=0.205u L=0.04u
M30528 U3251/net28 U3251/net20 U3251/net24 VDD pmos W=0.205u L=0.04u
M30529 U3251/net40 U3251/net106 U3251/net108 VDD pmos W=0.205u L=0.04u
M30530 U3251/net40 n2420 U3251/net104 VDD pmos W=0.205u L=0.04u
M30531 U3251/net20 U3251/net40 VDD VDD pmos W=0.205u L=0.04u
M30532 U3251/net106 n2420 VDD VDD pmos W=0.205u L=0.04u
M30533 U3251/net104 WX11201 VDD VDD pmos W=0.205u L=0.04u
M30534 U3251/net30 n2419 VDD VDD pmos W=0.205u L=0.04u
M30535 U3251/net108 U3251/net104 VDD VDD pmos W=0.205u L=0.04u
M30536 n1470 U3251/net28 VDD VDD pmos W=0.205u L=0.04u
M30537 U3251/net32 WX11073 VDD VDD pmos W=0.205u L=0.04u
M30538 U3251/net64 U3251/net24 VDD VDD pmos W=0.28u L=0.04u
M30539 U3251/net24 U3251/net30 U3251/net045 VDD pmos W=0.205u L=0.04u
M30540 U3251/net045 U3251/net32 VDD VDD pmos W=0.205u L=0.04u
M30541 U3252/net4 WX11009 U3252/net14 VSS nmos W=0.155u L=0.04u
M30542 U3252/net6 U3252/net10 U3252/net14 VSS nmos W=0.17u L=0.04u
M30543 U3252/net4 n1378 VSS VSS nmos W=0.155u L=0.04u
M30544 U3252/net6 U3252/net4 VSS VSS nmos W=0.17u L=0.04u
M30545 n2420 U3252/net14 VSS VSS nmos W=0.155u L=0.04u
M30546 U3252/net10 WX11009 VSS VSS nmos W=0.155u L=0.04u
M30547 U3252/net4 U3252/net10 U3252/net14 VDD pmos W=0.255u L=0.04u
M30548 U3252/net6 WX11009 U3252/net14 VDD pmos W=0.28u L=0.04u
M30549 U3252/net4 n1378 VDD VDD pmos W=0.205u L=0.04u
M30550 U3252/net6 U3252/net4 VDD VDD pmos W=0.24u L=0.04u
M30551 n2420 U3252/net14 VDD VDD pmos W=0.205u L=0.04u
M30552 U3252/net10 WX11009 VDD VDD pmos W=0.205u L=0.04u
M30553 n2419 WX11137 VSS VSS nmos W=0.135u L=0.04u
M30554 n2419 WX11137 VDD VDD pmos W=0.205u L=0.04u
M30555 U3254/net4 U3254/net10 U3254/net14 VSS nmos W=0.155u L=0.04u
M30556 U3254/net6 n2272 U3254/net14 VSS nmos W=0.155u L=0.04u
M30557 U3254/net4 n2421 VSS VSS nmos W=0.155u L=0.04u
M30558 U3254/net6 U3254/net4 VSS VSS nmos W=0.155u L=0.04u
M30559 WX1052 U3254/net14 VSS VSS nmos W=0.155u L=0.04u
M30560 U3254/net10 n2272 VSS VSS nmos W=0.155u L=0.04u
M30561 U3254/net4 n2272 U3254/net14 VDD pmos W=0.205u L=0.04u
M30562 U3254/net6 U3254/net10 U3254/net14 VDD pmos W=0.205u L=0.04u
M30563 U3254/net4 n2421 VDD VDD pmos W=0.205u L=0.04u
M30564 U3254/net6 U3254/net4 VDD VDD pmos W=0.205u L=0.04u
M30565 WX1052 U3254/net14 VDD VDD pmos W=0.205u L=0.04u
M30566 U3254/net10 n2272 VDD VDD pmos W=0.205u L=0.04u
M30567 U3255/XU1-net6 TM0 VSS VSS nmos W=0.155u L=0.04u
M30568 n2421 WX497 U3255/XU1-net6 VSS nmos W=0.155u L=0.04u
M30569 n2421 TM0 VDD VDD pmos W=0.155u L=0.04u
M30570 n2421 WX497 VDD VDD pmos W=0.155u L=0.04u
M30571 n2272 n2422 VSS VSS nmos W=0.135u L=0.04u
M30572 n2272 n2422 VDD VDD pmos W=0.205u L=0.04u
M30573 U3257/net28 U3257/net20 U3257/net64 VSS nmos W=0.155u L=0.04u
M30574 U3257/net24 U3257/net30 U3257/net32 VSS nmos W=0.155u L=0.04u
M30575 U3257/net28 U3257/net40 U3257/net24 VSS nmos W=0.155u L=0.04u
M30576 U3257/net40 n2423 U3257/net108 VSS nmos W=0.155u L=0.04u
M30577 U3257/net40 U3257/net106 U3257/net104 VSS nmos W=0.155u L=0.04u
M30578 U3257/net24 WX785 U3257/net050 VSS nmos W=0.155u L=0.04u
M30579 U3257/net050 U3257/net32 VSS VSS nmos W=0.155u L=0.04u
M30580 U3257/net20 U3257/net40 VSS VSS nmos W=0.155u L=0.04u
M30581 U3257/net106 n2423 VSS VSS nmos W=0.155u L=0.04u
M30582 U3257/net104 WX849 VSS VSS nmos W=0.155u L=0.04u
M30583 U3257/net30 WX785 VSS VSS nmos W=0.155u L=0.04u
M30584 U3257/net108 U3257/net104 VSS VSS nmos W=0.155u L=0.04u
M30585 n2422 U3257/net28 VSS VSS nmos W=0.155u L=0.04u
M30586 U3257/net32 WX721 VSS VSS nmos W=0.155u L=0.04u
M30587 U3257/net64 U3257/net24 VSS VSS nmos W=0.2u L=0.04u
M30588 U3257/net28 U3257/net40 U3257/net64 VDD pmos W=0.205u L=0.04u
M30589 U3257/net24 WX785 U3257/net32 VDD pmos W=0.205u L=0.04u
M30590 U3257/net28 U3257/net20 U3257/net24 VDD pmos W=0.205u L=0.04u
M30591 U3257/net40 U3257/net106 U3257/net108 VDD pmos W=0.205u L=0.04u
M30592 U3257/net40 n2423 U3257/net104 VDD pmos W=0.205u L=0.04u
M30593 U3257/net20 U3257/net40 VDD VDD pmos W=0.205u L=0.04u
M30594 U3257/net106 n2423 VDD VDD pmos W=0.205u L=0.04u
M30595 U3257/net104 WX849 VDD VDD pmos W=0.205u L=0.04u
M30596 U3257/net30 WX785 VDD VDD pmos W=0.205u L=0.04u
M30597 U3257/net108 U3257/net104 VDD VDD pmos W=0.205u L=0.04u
M30598 n2422 U3257/net28 VDD VDD pmos W=0.205u L=0.04u
M30599 U3257/net32 WX721 VDD VDD pmos W=0.205u L=0.04u
M30600 U3257/net64 U3257/net24 VDD VDD pmos W=0.28u L=0.04u
M30601 U3257/net24 U3257/net30 U3257/net045 VDD pmos W=0.205u L=0.04u
M30602 U3257/net045 U3257/net32 VDD VDD pmos W=0.205u L=0.04u
M30603 U3258/net4 WX657 U3258/net14 VSS nmos W=0.155u L=0.04u
M30604 U3258/net6 U3258/net10 U3258/net14 VSS nmos W=0.17u L=0.04u
M30605 U3258/net4 n1378 VSS VSS nmos W=0.155u L=0.04u
M30606 U3258/net6 U3258/net4 VSS VSS nmos W=0.17u L=0.04u
M30607 n2423 U3258/net14 VSS VSS nmos W=0.155u L=0.04u
M30608 U3258/net10 WX657 VSS VSS nmos W=0.155u L=0.04u
M30609 U3258/net4 U3258/net10 U3258/net14 VDD pmos W=0.255u L=0.04u
M30610 U3258/net6 WX657 U3258/net14 VDD pmos W=0.28u L=0.04u
M30611 U3258/net4 n1378 VDD VDD pmos W=0.205u L=0.04u
M30612 U3258/net6 U3258/net4 VDD VDD pmos W=0.24u L=0.04u
M30613 n2423 U3258/net14 VDD VDD pmos W=0.205u L=0.04u
M30614 U3258/net10 WX657 VDD VDD pmos W=0.205u L=0.04u
M30615 WX10508 n1246 U3259/net26 VSS nmos W=0.155u L=0.04u
M30616 WX10508 n1473 U3259/net26 VSS nmos W=0.155u L=0.04u
M30617 U3259/net29 n2425 VSS VSS nmos W=0.155u L=0.04u
M30618 U3259/net26 n2424 U3259/net29 VSS nmos W=0.155u L=0.04u
M30619 U3259/net26 n1615 U3259/net29 VSS nmos W=0.155u L=0.04u
M30620 WX10508 n1473 U3259/net43 VDD pmos W=0.205u L=0.04u
M30621 WX10508 n1615 U3259/net49 VDD pmos W=0.205u L=0.04u
M30622 U3259/net49 n2424 VDD VDD pmos W=0.205u L=0.04u
M30623 U3259/net43 n1246 VDD VDD pmos W=0.205u L=0.04u
M30624 WX10508 n2425 VDD VDD pmos W=0.205u L=0.04u
M30625 U3260/net29 n1344 VSS VSS nmos W=0.155u L=0.04u
M30626 n2425 WX10847 U3260/net29 VSS nmos W=0.155u L=0.04u
M30627 n2425 DATA_0_22 U3260/net23 VSS nmos W=0.155u L=0.04u
M30628 U3260/net23 n1617 VSS VSS nmos W=0.155u L=0.04u
M30629 U3260/net20 n1617 n2425 VDD pmos W=0.205u L=0.04u
M30630 U3260/net20 DATA_0_22 n2425 VDD pmos W=0.205u L=0.04u
M30631 VDD WX10847 U3260/net20 VDD pmos W=0.205u L=0.04u
M30632 VDD n1344 U3260/net20 VDD pmos W=0.205u L=0.04u
M30633 n2424 CRC_OUT_1_22 VSS VSS nmos W=0.135u L=0.04u
M30634 n2424 CRC_OUT_1_22 VDD VDD pmos W=0.205u L=0.04u
M30635 U3262/net28 U3262/net20 U3262/net64 VSS nmos W=0.155u L=0.04u
M30636 U3262/net24 U3262/net30 U3262/net32 VSS nmos W=0.155u L=0.04u
M30637 U3262/net28 U3262/net40 U3262/net24 VSS nmos W=0.155u L=0.04u
M30638 U3262/net40 n2427 U3262/net108 VSS nmos W=0.155u L=0.04u
M30639 U3262/net40 U3262/net106 U3262/net104 VSS nmos W=0.155u L=0.04u
M30640 U3262/net24 n2426 U3262/net050 VSS nmos W=0.155u L=0.04u
M30641 U3262/net050 U3262/net32 VSS VSS nmos W=0.155u L=0.04u
M30642 U3262/net20 U3262/net40 VSS VSS nmos W=0.155u L=0.04u
M30643 U3262/net106 n2427 VSS VSS nmos W=0.155u L=0.04u
M30644 U3262/net104 WX11199 VSS VSS nmos W=0.155u L=0.04u
M30645 U3262/net30 n2426 VSS VSS nmos W=0.155u L=0.04u
M30646 U3262/net108 U3262/net104 VSS VSS nmos W=0.155u L=0.04u
M30647 n1473 U3262/net28 VSS VSS nmos W=0.155u L=0.04u
M30648 U3262/net32 WX11071 VSS VSS nmos W=0.155u L=0.04u
M30649 U3262/net64 U3262/net24 VSS VSS nmos W=0.2u L=0.04u
M30650 U3262/net28 U3262/net40 U3262/net64 VDD pmos W=0.205u L=0.04u
M30651 U3262/net24 n2426 U3262/net32 VDD pmos W=0.205u L=0.04u
M30652 U3262/net28 U3262/net20 U3262/net24 VDD pmos W=0.205u L=0.04u
M30653 U3262/net40 U3262/net106 U3262/net108 VDD pmos W=0.205u L=0.04u
M30654 U3262/net40 n2427 U3262/net104 VDD pmos W=0.205u L=0.04u
M30655 U3262/net20 U3262/net40 VDD VDD pmos W=0.205u L=0.04u
M30656 U3262/net106 n2427 VDD VDD pmos W=0.205u L=0.04u
M30657 U3262/net104 WX11199 VDD VDD pmos W=0.205u L=0.04u
M30658 U3262/net30 n2426 VDD VDD pmos W=0.205u L=0.04u
M30659 U3262/net108 U3262/net104 VDD VDD pmos W=0.205u L=0.04u
M30660 n1473 U3262/net28 VDD VDD pmos W=0.205u L=0.04u
M30661 U3262/net32 WX11071 VDD VDD pmos W=0.205u L=0.04u
M30662 U3262/net64 U3262/net24 VDD VDD pmos W=0.28u L=0.04u
M30663 U3262/net24 U3262/net30 U3262/net045 VDD pmos W=0.205u L=0.04u
M30664 U3262/net045 U3262/net32 VDD VDD pmos W=0.205u L=0.04u
M30665 U3263/net4 WX11007 U3263/net14 VSS nmos W=0.155u L=0.04u
M30666 U3263/net6 U3263/net10 U3263/net14 VSS nmos W=0.17u L=0.04u
M30667 U3263/net4 n1378 VSS VSS nmos W=0.155u L=0.04u
M30668 U3263/net6 U3263/net4 VSS VSS nmos W=0.17u L=0.04u
M30669 n2427 U3263/net14 VSS VSS nmos W=0.155u L=0.04u
M30670 U3263/net10 WX11007 VSS VSS nmos W=0.155u L=0.04u
M30671 U3263/net4 U3263/net10 U3263/net14 VDD pmos W=0.255u L=0.04u
M30672 U3263/net6 WX11007 U3263/net14 VDD pmos W=0.28u L=0.04u
M30673 U3263/net4 n1378 VDD VDD pmos W=0.205u L=0.04u
M30674 U3263/net6 U3263/net4 VDD VDD pmos W=0.24u L=0.04u
M30675 n2427 U3263/net14 VDD VDD pmos W=0.205u L=0.04u
M30676 U3263/net10 WX11007 VDD VDD pmos W=0.205u L=0.04u
M30677 n2426 WX11135 VSS VSS nmos W=0.135u L=0.04u
M30678 n2426 WX11135 VDD VDD pmos W=0.205u L=0.04u
M30679 WX10494 n1246 U3265/net26 VSS nmos W=0.155u L=0.04u
M30680 WX10494 n1476 U3265/net26 VSS nmos W=0.155u L=0.04u
M30681 U3265/net29 n2429 VSS VSS nmos W=0.155u L=0.04u
M30682 U3265/net26 n2428 U3265/net29 VSS nmos W=0.155u L=0.04u
M30683 U3265/net26 n1615 U3265/net29 VSS nmos W=0.155u L=0.04u
M30684 WX10494 n1476 U3265/net43 VDD pmos W=0.205u L=0.04u
M30685 WX10494 n1615 U3265/net49 VDD pmos W=0.205u L=0.04u
M30686 U3265/net49 n2428 VDD VDD pmos W=0.205u L=0.04u
M30687 U3265/net43 n1246 VDD VDD pmos W=0.205u L=0.04u
M30688 WX10494 n2429 VDD VDD pmos W=0.205u L=0.04u
M30689 U3266/net29 n1344 VSS VSS nmos W=0.155u L=0.04u
M30690 n2429 WX10845 U3266/net29 VSS nmos W=0.155u L=0.04u
M30691 n2429 DATA_0_23 U3266/net23 VSS nmos W=0.155u L=0.04u
M30692 U3266/net23 n1617 VSS VSS nmos W=0.155u L=0.04u
M30693 U3266/net20 n1617 n2429 VDD pmos W=0.205u L=0.04u
M30694 U3266/net20 DATA_0_23 n2429 VDD pmos W=0.205u L=0.04u
M30695 VDD WX10845 U3266/net20 VDD pmos W=0.205u L=0.04u
M30696 VDD n1344 U3266/net20 VDD pmos W=0.205u L=0.04u
M30697 n2428 CRC_OUT_1_23 VSS VSS nmos W=0.135u L=0.04u
M30698 n2428 CRC_OUT_1_23 VDD VDD pmos W=0.205u L=0.04u
M30699 U3268/net28 U3268/net20 U3268/net64 VSS nmos W=0.155u L=0.04u
M30700 U3268/net24 U3268/net30 U3268/net32 VSS nmos W=0.155u L=0.04u
M30701 U3268/net28 U3268/net40 U3268/net24 VSS nmos W=0.155u L=0.04u
M30702 U3268/net40 n2431 U3268/net108 VSS nmos W=0.155u L=0.04u
M30703 U3268/net40 U3268/net106 U3268/net104 VSS nmos W=0.155u L=0.04u
M30704 U3268/net24 n2430 U3268/net050 VSS nmos W=0.155u L=0.04u
M30705 U3268/net050 U3268/net32 VSS VSS nmos W=0.155u L=0.04u
M30706 U3268/net20 U3268/net40 VSS VSS nmos W=0.155u L=0.04u
M30707 U3268/net106 n2431 VSS VSS nmos W=0.155u L=0.04u
M30708 U3268/net104 WX11197 VSS VSS nmos W=0.155u L=0.04u
M30709 U3268/net30 n2430 VSS VSS nmos W=0.155u L=0.04u
M30710 U3268/net108 U3268/net104 VSS VSS nmos W=0.155u L=0.04u
M30711 n1476 U3268/net28 VSS VSS nmos W=0.155u L=0.04u
M30712 U3268/net32 WX11069 VSS VSS nmos W=0.155u L=0.04u
M30713 U3268/net64 U3268/net24 VSS VSS nmos W=0.2u L=0.04u
M30714 U3268/net28 U3268/net40 U3268/net64 VDD pmos W=0.205u L=0.04u
M30715 U3268/net24 n2430 U3268/net32 VDD pmos W=0.205u L=0.04u
M30716 U3268/net28 U3268/net20 U3268/net24 VDD pmos W=0.205u L=0.04u
M30717 U3268/net40 U3268/net106 U3268/net108 VDD pmos W=0.205u L=0.04u
M30718 U3268/net40 n2431 U3268/net104 VDD pmos W=0.205u L=0.04u
M30719 U3268/net20 U3268/net40 VDD VDD pmos W=0.205u L=0.04u
M30720 U3268/net106 n2431 VDD VDD pmos W=0.205u L=0.04u
M30721 U3268/net104 WX11197 VDD VDD pmos W=0.205u L=0.04u
M30722 U3268/net30 n2430 VDD VDD pmos W=0.205u L=0.04u
M30723 U3268/net108 U3268/net104 VDD VDD pmos W=0.205u L=0.04u
M30724 n1476 U3268/net28 VDD VDD pmos W=0.205u L=0.04u
M30725 U3268/net32 WX11069 VDD VDD pmos W=0.205u L=0.04u
M30726 U3268/net64 U3268/net24 VDD VDD pmos W=0.28u L=0.04u
M30727 U3268/net24 U3268/net30 U3268/net045 VDD pmos W=0.205u L=0.04u
M30728 U3268/net045 U3268/net32 VDD VDD pmos W=0.205u L=0.04u
M30729 U3269/net4 WX11005 U3269/net14 VSS nmos W=0.155u L=0.04u
M30730 U3269/net6 U3269/net10 U3269/net14 VSS nmos W=0.17u L=0.04u
M30731 U3269/net4 n1378 VSS VSS nmos W=0.155u L=0.04u
M30732 U3269/net6 U3269/net4 VSS VSS nmos W=0.17u L=0.04u
M30733 n2431 U3269/net14 VSS VSS nmos W=0.155u L=0.04u
M30734 U3269/net10 WX11005 VSS VSS nmos W=0.155u L=0.04u
M30735 U3269/net4 U3269/net10 U3269/net14 VDD pmos W=0.255u L=0.04u
M30736 U3269/net6 WX11005 U3269/net14 VDD pmos W=0.28u L=0.04u
M30737 U3269/net4 n1378 VDD VDD pmos W=0.205u L=0.04u
M30738 U3269/net6 U3269/net4 VDD VDD pmos W=0.24u L=0.04u
M30739 n2431 U3269/net14 VDD VDD pmos W=0.205u L=0.04u
M30740 U3269/net10 WX11005 VDD VDD pmos W=0.205u L=0.04u
M30741 n2430 WX11133 VSS VSS nmos W=0.135u L=0.04u
M30742 n2430 WX11133 VDD VDD pmos W=0.205u L=0.04u
M30743 WX10480 n1246 U3271/net26 VSS nmos W=0.155u L=0.04u
M30744 WX10480 n1479 U3271/net26 VSS nmos W=0.155u L=0.04u
M30745 U3271/net29 n2433 VSS VSS nmos W=0.155u L=0.04u
M30746 U3271/net26 n2432 U3271/net29 VSS nmos W=0.155u L=0.04u
M30747 U3271/net26 n1615 U3271/net29 VSS nmos W=0.155u L=0.04u
M30748 WX10480 n1479 U3271/net43 VDD pmos W=0.205u L=0.04u
M30749 WX10480 n1615 U3271/net49 VDD pmos W=0.205u L=0.04u
M30750 U3271/net49 n2432 VDD VDD pmos W=0.205u L=0.04u
M30751 U3271/net43 n1246 VDD VDD pmos W=0.205u L=0.04u
M30752 WX10480 n2433 VDD VDD pmos W=0.205u L=0.04u
M30753 U3272/net29 n1343 VSS VSS nmos W=0.155u L=0.04u
M30754 n2433 WX10843 U3272/net29 VSS nmos W=0.155u L=0.04u
M30755 n2433 DATA_0_24 U3272/net23 VSS nmos W=0.155u L=0.04u
M30756 U3272/net23 n1617 VSS VSS nmos W=0.155u L=0.04u
M30757 U3272/net20 n1617 n2433 VDD pmos W=0.205u L=0.04u
M30758 U3272/net20 DATA_0_24 n2433 VDD pmos W=0.205u L=0.04u
M30759 VDD WX10843 U3272/net20 VDD pmos W=0.205u L=0.04u
M30760 VDD n1343 U3272/net20 VDD pmos W=0.205u L=0.04u
M30761 n2432 CRC_OUT_1_24 VSS VSS nmos W=0.135u L=0.04u
M30762 n2432 CRC_OUT_1_24 VDD VDD pmos W=0.205u L=0.04u
M30763 U3274/net28 U3274/net20 U3274/net64 VSS nmos W=0.155u L=0.04u
M30764 U3274/net24 U3274/net30 U3274/net32 VSS nmos W=0.155u L=0.04u
M30765 U3274/net28 U3274/net40 U3274/net24 VSS nmos W=0.155u L=0.04u
M30766 U3274/net40 n2435 U3274/net108 VSS nmos W=0.155u L=0.04u
M30767 U3274/net40 U3274/net106 U3274/net104 VSS nmos W=0.155u L=0.04u
M30768 U3274/net24 n2434 U3274/net050 VSS nmos W=0.155u L=0.04u
M30769 U3274/net050 U3274/net32 VSS VSS nmos W=0.155u L=0.04u
M30770 U3274/net20 U3274/net40 VSS VSS nmos W=0.155u L=0.04u
M30771 U3274/net106 n2435 VSS VSS nmos W=0.155u L=0.04u
M30772 U3274/net104 WX11195 VSS VSS nmos W=0.155u L=0.04u
M30773 U3274/net30 n2434 VSS VSS nmos W=0.155u L=0.04u
M30774 U3274/net108 U3274/net104 VSS VSS nmos W=0.155u L=0.04u
M30775 n1479 U3274/net28 VSS VSS nmos W=0.155u L=0.04u
M30776 U3274/net32 WX11067 VSS VSS nmos W=0.155u L=0.04u
M30777 U3274/net64 U3274/net24 VSS VSS nmos W=0.2u L=0.04u
M30778 U3274/net28 U3274/net40 U3274/net64 VDD pmos W=0.205u L=0.04u
M30779 U3274/net24 n2434 U3274/net32 VDD pmos W=0.205u L=0.04u
M30780 U3274/net28 U3274/net20 U3274/net24 VDD pmos W=0.205u L=0.04u
M30781 U3274/net40 U3274/net106 U3274/net108 VDD pmos W=0.205u L=0.04u
M30782 U3274/net40 n2435 U3274/net104 VDD pmos W=0.205u L=0.04u
M30783 U3274/net20 U3274/net40 VDD VDD pmos W=0.205u L=0.04u
M30784 U3274/net106 n2435 VDD VDD pmos W=0.205u L=0.04u
M30785 U3274/net104 WX11195 VDD VDD pmos W=0.205u L=0.04u
M30786 U3274/net30 n2434 VDD VDD pmos W=0.205u L=0.04u
M30787 U3274/net108 U3274/net104 VDD VDD pmos W=0.205u L=0.04u
M30788 n1479 U3274/net28 VDD VDD pmos W=0.205u L=0.04u
M30789 U3274/net32 WX11067 VDD VDD pmos W=0.205u L=0.04u
M30790 U3274/net64 U3274/net24 VDD VDD pmos W=0.28u L=0.04u
M30791 U3274/net24 U3274/net30 U3274/net045 VDD pmos W=0.205u L=0.04u
M30792 U3274/net045 U3274/net32 VDD VDD pmos W=0.205u L=0.04u
M30793 U3275/net4 WX11003 U3275/net14 VSS nmos W=0.155u L=0.04u
M30794 U3275/net6 U3275/net10 U3275/net14 VSS nmos W=0.17u L=0.04u
M30795 U3275/net4 n1378 VSS VSS nmos W=0.155u L=0.04u
M30796 U3275/net6 U3275/net4 VSS VSS nmos W=0.17u L=0.04u
M30797 n2435 U3275/net14 VSS VSS nmos W=0.155u L=0.04u
M30798 U3275/net10 WX11003 VSS VSS nmos W=0.155u L=0.04u
M30799 U3275/net4 U3275/net10 U3275/net14 VDD pmos W=0.255u L=0.04u
M30800 U3275/net6 WX11003 U3275/net14 VDD pmos W=0.28u L=0.04u
M30801 U3275/net4 n1378 VDD VDD pmos W=0.205u L=0.04u
M30802 U3275/net6 U3275/net4 VDD VDD pmos W=0.24u L=0.04u
M30803 n2435 U3275/net14 VDD VDD pmos W=0.205u L=0.04u
M30804 U3275/net10 WX11003 VDD VDD pmos W=0.205u L=0.04u
M30805 n2434 WX11131 VSS VSS nmos W=0.135u L=0.04u
M30806 n2434 WX11131 VDD VDD pmos W=0.205u L=0.04u
M30807 WX10466 n1246 U3277/net26 VSS nmos W=0.155u L=0.04u
M30808 WX10466 n1482 U3277/net26 VSS nmos W=0.155u L=0.04u
M30809 U3277/net29 n2437 VSS VSS nmos W=0.155u L=0.04u
M30810 U3277/net26 n2436 U3277/net29 VSS nmos W=0.155u L=0.04u
M30811 U3277/net26 n1615 U3277/net29 VSS nmos W=0.155u L=0.04u
M30812 WX10466 n1482 U3277/net43 VDD pmos W=0.205u L=0.04u
M30813 WX10466 n1615 U3277/net49 VDD pmos W=0.205u L=0.04u
M30814 U3277/net49 n2436 VDD VDD pmos W=0.205u L=0.04u
M30815 U3277/net43 n1246 VDD VDD pmos W=0.205u L=0.04u
M30816 WX10466 n2437 VDD VDD pmos W=0.205u L=0.04u
M30817 U3278/net29 n1343 VSS VSS nmos W=0.155u L=0.04u
M30818 n2437 WX10841 U3278/net29 VSS nmos W=0.155u L=0.04u
M30819 n2437 DATA_0_25 U3278/net23 VSS nmos W=0.155u L=0.04u
M30820 U3278/net23 n1617 VSS VSS nmos W=0.155u L=0.04u
M30821 U3278/net20 n1617 n2437 VDD pmos W=0.205u L=0.04u
M30822 U3278/net20 DATA_0_25 n2437 VDD pmos W=0.205u L=0.04u
M30823 VDD WX10841 U3278/net20 VDD pmos W=0.205u L=0.04u
M30824 VDD n1343 U3278/net20 VDD pmos W=0.205u L=0.04u
M30825 n2436 CRC_OUT_1_25 VSS VSS nmos W=0.135u L=0.04u
M30826 n2436 CRC_OUT_1_25 VDD VDD pmos W=0.205u L=0.04u
M30827 U3280/net28 U3280/net20 U3280/net64 VSS nmos W=0.155u L=0.04u
M30828 U3280/net24 U3280/net30 U3280/net32 VSS nmos W=0.155u L=0.04u
M30829 U3280/net28 U3280/net40 U3280/net24 VSS nmos W=0.155u L=0.04u
M30830 U3280/net40 n2439 U3280/net108 VSS nmos W=0.155u L=0.04u
M30831 U3280/net40 U3280/net106 U3280/net104 VSS nmos W=0.155u L=0.04u
M30832 U3280/net24 n2438 U3280/net050 VSS nmos W=0.155u L=0.04u
M30833 U3280/net050 U3280/net32 VSS VSS nmos W=0.155u L=0.04u
M30834 U3280/net20 U3280/net40 VSS VSS nmos W=0.155u L=0.04u
M30835 U3280/net106 n2439 VSS VSS nmos W=0.155u L=0.04u
M30836 U3280/net104 WX11193 VSS VSS nmos W=0.155u L=0.04u
M30837 U3280/net30 n2438 VSS VSS nmos W=0.155u L=0.04u
M30838 U3280/net108 U3280/net104 VSS VSS nmos W=0.155u L=0.04u
M30839 n1482 U3280/net28 VSS VSS nmos W=0.155u L=0.04u
M30840 U3280/net32 WX11065 VSS VSS nmos W=0.155u L=0.04u
M30841 U3280/net64 U3280/net24 VSS VSS nmos W=0.2u L=0.04u
M30842 U3280/net28 U3280/net40 U3280/net64 VDD pmos W=0.205u L=0.04u
M30843 U3280/net24 n2438 U3280/net32 VDD pmos W=0.205u L=0.04u
M30844 U3280/net28 U3280/net20 U3280/net24 VDD pmos W=0.205u L=0.04u
M30845 U3280/net40 U3280/net106 U3280/net108 VDD pmos W=0.205u L=0.04u
M30846 U3280/net40 n2439 U3280/net104 VDD pmos W=0.205u L=0.04u
M30847 U3280/net20 U3280/net40 VDD VDD pmos W=0.205u L=0.04u
M30848 U3280/net106 n2439 VDD VDD pmos W=0.205u L=0.04u
M30849 U3280/net104 WX11193 VDD VDD pmos W=0.205u L=0.04u
M30850 U3280/net30 n2438 VDD VDD pmos W=0.205u L=0.04u
M30851 U3280/net108 U3280/net104 VDD VDD pmos W=0.205u L=0.04u
M30852 n1482 U3280/net28 VDD VDD pmos W=0.205u L=0.04u
M30853 U3280/net32 WX11065 VDD VDD pmos W=0.205u L=0.04u
M30854 U3280/net64 U3280/net24 VDD VDD pmos W=0.28u L=0.04u
M30855 U3280/net24 U3280/net30 U3280/net045 VDD pmos W=0.205u L=0.04u
M30856 U3280/net045 U3280/net32 VDD VDD pmos W=0.205u L=0.04u
M30857 U3281/net4 WX11001 U3281/net14 VSS nmos W=0.155u L=0.04u
M30858 U3281/net6 U3281/net10 U3281/net14 VSS nmos W=0.17u L=0.04u
M30859 U3281/net4 n1379 VSS VSS nmos W=0.155u L=0.04u
M30860 U3281/net6 U3281/net4 VSS VSS nmos W=0.17u L=0.04u
M30861 n2439 U3281/net14 VSS VSS nmos W=0.155u L=0.04u
M30862 U3281/net10 WX11001 VSS VSS nmos W=0.155u L=0.04u
M30863 U3281/net4 U3281/net10 U3281/net14 VDD pmos W=0.255u L=0.04u
M30864 U3281/net6 WX11001 U3281/net14 VDD pmos W=0.28u L=0.04u
M30865 U3281/net4 n1379 VDD VDD pmos W=0.205u L=0.04u
M30866 U3281/net6 U3281/net4 VDD VDD pmos W=0.24u L=0.04u
M30867 n2439 U3281/net14 VDD VDD pmos W=0.205u L=0.04u
M30868 U3281/net10 WX11001 VDD VDD pmos W=0.205u L=0.04u
M30869 n2438 WX11129 VSS VSS nmos W=0.135u L=0.04u
M30870 n2438 WX11129 VDD VDD pmos W=0.205u L=0.04u
M30871 WX10452 n1246 U3283/net26 VSS nmos W=0.155u L=0.04u
M30872 WX10452 n1485 U3283/net26 VSS nmos W=0.155u L=0.04u
M30873 U3283/net29 n2441 VSS VSS nmos W=0.155u L=0.04u
M30874 U3283/net26 n2440 U3283/net29 VSS nmos W=0.155u L=0.04u
M30875 U3283/net26 n1615 U3283/net29 VSS nmos W=0.155u L=0.04u
M30876 WX10452 n1485 U3283/net43 VDD pmos W=0.205u L=0.04u
M30877 WX10452 n1615 U3283/net49 VDD pmos W=0.205u L=0.04u
M30878 U3283/net49 n2440 VDD VDD pmos W=0.205u L=0.04u
M30879 U3283/net43 n1246 VDD VDD pmos W=0.205u L=0.04u
M30880 WX10452 n2441 VDD VDD pmos W=0.205u L=0.04u
M30881 U3284/net29 n1343 VSS VSS nmos W=0.155u L=0.04u
M30882 n2441 WX10839 U3284/net29 VSS nmos W=0.155u L=0.04u
M30883 n2441 DATA_0_26 U3284/net23 VSS nmos W=0.155u L=0.04u
M30884 U3284/net23 n1617 VSS VSS nmos W=0.155u L=0.04u
M30885 U3284/net20 n1617 n2441 VDD pmos W=0.205u L=0.04u
M30886 U3284/net20 DATA_0_26 n2441 VDD pmos W=0.205u L=0.04u
M30887 VDD WX10839 U3284/net20 VDD pmos W=0.205u L=0.04u
M30888 VDD n1343 U3284/net20 VDD pmos W=0.205u L=0.04u
M30889 n2440 CRC_OUT_1_26 VSS VSS nmos W=0.135u L=0.04u
M30890 n2440 CRC_OUT_1_26 VDD VDD pmos W=0.205u L=0.04u
M30891 U3286/net28 U3286/net20 U3286/net64 VSS nmos W=0.155u L=0.04u
M30892 U3286/net24 U3286/net30 U3286/net32 VSS nmos W=0.155u L=0.04u
M30893 U3286/net28 U3286/net40 U3286/net24 VSS nmos W=0.155u L=0.04u
M30894 U3286/net40 n2443 U3286/net108 VSS nmos W=0.155u L=0.04u
M30895 U3286/net40 U3286/net106 U3286/net104 VSS nmos W=0.155u L=0.04u
M30896 U3286/net24 n2442 U3286/net050 VSS nmos W=0.155u L=0.04u
M30897 U3286/net050 U3286/net32 VSS VSS nmos W=0.155u L=0.04u
M30898 U3286/net20 U3286/net40 VSS VSS nmos W=0.155u L=0.04u
M30899 U3286/net106 n2443 VSS VSS nmos W=0.155u L=0.04u
M30900 U3286/net104 WX11191 VSS VSS nmos W=0.155u L=0.04u
M30901 U3286/net30 n2442 VSS VSS nmos W=0.155u L=0.04u
M30902 U3286/net108 U3286/net104 VSS VSS nmos W=0.155u L=0.04u
M30903 n1485 U3286/net28 VSS VSS nmos W=0.155u L=0.04u
M30904 U3286/net32 WX11063 VSS VSS nmos W=0.155u L=0.04u
M30905 U3286/net64 U3286/net24 VSS VSS nmos W=0.2u L=0.04u
M30906 U3286/net28 U3286/net40 U3286/net64 VDD pmos W=0.205u L=0.04u
M30907 U3286/net24 n2442 U3286/net32 VDD pmos W=0.205u L=0.04u
M30908 U3286/net28 U3286/net20 U3286/net24 VDD pmos W=0.205u L=0.04u
M30909 U3286/net40 U3286/net106 U3286/net108 VDD pmos W=0.205u L=0.04u
M30910 U3286/net40 n2443 U3286/net104 VDD pmos W=0.205u L=0.04u
M30911 U3286/net20 U3286/net40 VDD VDD pmos W=0.205u L=0.04u
M30912 U3286/net106 n2443 VDD VDD pmos W=0.205u L=0.04u
M30913 U3286/net104 WX11191 VDD VDD pmos W=0.205u L=0.04u
M30914 U3286/net30 n2442 VDD VDD pmos W=0.205u L=0.04u
M30915 U3286/net108 U3286/net104 VDD VDD pmos W=0.205u L=0.04u
M30916 n1485 U3286/net28 VDD VDD pmos W=0.205u L=0.04u
M30917 U3286/net32 WX11063 VDD VDD pmos W=0.205u L=0.04u
M30918 U3286/net64 U3286/net24 VDD VDD pmos W=0.28u L=0.04u
M30919 U3286/net24 U3286/net30 U3286/net045 VDD pmos W=0.205u L=0.04u
M30920 U3286/net045 U3286/net32 VDD VDD pmos W=0.205u L=0.04u
M30921 U3287/net4 WX10999 U3287/net14 VSS nmos W=0.155u L=0.04u
M30922 U3287/net6 U3287/net10 U3287/net14 VSS nmos W=0.17u L=0.04u
M30923 U3287/net4 n1379 VSS VSS nmos W=0.155u L=0.04u
M30924 U3287/net6 U3287/net4 VSS VSS nmos W=0.17u L=0.04u
M30925 n2443 U3287/net14 VSS VSS nmos W=0.155u L=0.04u
M30926 U3287/net10 WX10999 VSS VSS nmos W=0.155u L=0.04u
M30927 U3287/net4 U3287/net10 U3287/net14 VDD pmos W=0.255u L=0.04u
M30928 U3287/net6 WX10999 U3287/net14 VDD pmos W=0.28u L=0.04u
M30929 U3287/net4 n1379 VDD VDD pmos W=0.205u L=0.04u
M30930 U3287/net6 U3287/net4 VDD VDD pmos W=0.24u L=0.04u
M30931 n2443 U3287/net14 VDD VDD pmos W=0.205u L=0.04u
M30932 U3287/net10 WX10999 VDD VDD pmos W=0.205u L=0.04u
M30933 n2442 WX11127 VSS VSS nmos W=0.135u L=0.04u
M30934 n2442 WX11127 VDD VDD pmos W=0.205u L=0.04u
M30935 U3289/net4 U3289/net10 U3289/net14 VSS nmos W=0.155u L=0.04u
M30936 U3289/net6 n2342 U3289/net14 VSS nmos W=0.155u L=0.04u
M30937 U3289/net4 n2444 VSS VSS nmos W=0.155u L=0.04u
M30938 U3289/net6 U3289/net4 VSS VSS nmos W=0.155u L=0.04u
M30939 WX1045 U3289/net14 VSS VSS nmos W=0.155u L=0.04u
M30940 U3289/net10 n2342 VSS VSS nmos W=0.155u L=0.04u
M30941 U3289/net4 n2342 U3289/net14 VDD pmos W=0.205u L=0.04u
M30942 U3289/net6 U3289/net10 U3289/net14 VDD pmos W=0.205u L=0.04u
M30943 U3289/net4 n2444 VDD VDD pmos W=0.205u L=0.04u
M30944 U3289/net6 U3289/net4 VDD VDD pmos W=0.205u L=0.04u
M30945 WX1045 U3289/net14 VDD VDD pmos W=0.205u L=0.04u
M30946 U3289/net10 n2342 VDD VDD pmos W=0.205u L=0.04u
M30947 U3290/XU1-net6 TM0 VSS VSS nmos W=0.155u L=0.04u
M30948 n2444 WX495 U3290/XU1-net6 VSS nmos W=0.155u L=0.04u
M30949 n2444 TM0 VDD VDD pmos W=0.155u L=0.04u
M30950 n2444 WX495 VDD VDD pmos W=0.155u L=0.04u
M30951 n2342 n2445 VSS VSS nmos W=0.135u L=0.04u
M30952 n2342 n2445 VDD VDD pmos W=0.205u L=0.04u
M30953 U3292/net28 U3292/net20 U3292/net64 VSS nmos W=0.155u L=0.04u
M30954 U3292/net24 U3292/net30 U3292/net32 VSS nmos W=0.155u L=0.04u
M30955 U3292/net28 U3292/net40 U3292/net24 VSS nmos W=0.155u L=0.04u
M30956 U3292/net40 n2446 U3292/net108 VSS nmos W=0.155u L=0.04u
M30957 U3292/net40 U3292/net106 U3292/net104 VSS nmos W=0.155u L=0.04u
M30958 U3292/net24 WX783 U3292/net050 VSS nmos W=0.155u L=0.04u
M30959 U3292/net050 U3292/net32 VSS VSS nmos W=0.155u L=0.04u
M30960 U3292/net20 U3292/net40 VSS VSS nmos W=0.155u L=0.04u
M30961 U3292/net106 n2446 VSS VSS nmos W=0.155u L=0.04u
M30962 U3292/net104 WX847 VSS VSS nmos W=0.155u L=0.04u
M30963 U3292/net30 WX783 VSS VSS nmos W=0.155u L=0.04u
M30964 U3292/net108 U3292/net104 VSS VSS nmos W=0.155u L=0.04u
M30965 n2445 U3292/net28 VSS VSS nmos W=0.155u L=0.04u
M30966 U3292/net32 WX719 VSS VSS nmos W=0.155u L=0.04u
M30967 U3292/net64 U3292/net24 VSS VSS nmos W=0.2u L=0.04u
M30968 U3292/net28 U3292/net40 U3292/net64 VDD pmos W=0.205u L=0.04u
M30969 U3292/net24 WX783 U3292/net32 VDD pmos W=0.205u L=0.04u
M30970 U3292/net28 U3292/net20 U3292/net24 VDD pmos W=0.205u L=0.04u
M30971 U3292/net40 U3292/net106 U3292/net108 VDD pmos W=0.205u L=0.04u
M30972 U3292/net40 n2446 U3292/net104 VDD pmos W=0.205u L=0.04u
M30973 U3292/net20 U3292/net40 VDD VDD pmos W=0.205u L=0.04u
M30974 U3292/net106 n2446 VDD VDD pmos W=0.205u L=0.04u
M30975 U3292/net104 WX847 VDD VDD pmos W=0.205u L=0.04u
M30976 U3292/net30 WX783 VDD VDD pmos W=0.205u L=0.04u
M30977 U3292/net108 U3292/net104 VDD VDD pmos W=0.205u L=0.04u
M30978 n2445 U3292/net28 VDD VDD pmos W=0.205u L=0.04u
M30979 U3292/net32 WX719 VDD VDD pmos W=0.205u L=0.04u
M30980 U3292/net64 U3292/net24 VDD VDD pmos W=0.28u L=0.04u
M30981 U3292/net24 U3292/net30 U3292/net045 VDD pmos W=0.205u L=0.04u
M30982 U3292/net045 U3292/net32 VDD VDD pmos W=0.205u L=0.04u
M30983 U3293/net4 WX655 U3293/net14 VSS nmos W=0.155u L=0.04u
M30984 U3293/net6 U3293/net10 U3293/net14 VSS nmos W=0.17u L=0.04u
M30985 U3293/net4 n1379 VSS VSS nmos W=0.155u L=0.04u
M30986 U3293/net6 U3293/net4 VSS VSS nmos W=0.17u L=0.04u
M30987 n2446 U3293/net14 VSS VSS nmos W=0.155u L=0.04u
M30988 U3293/net10 WX655 VSS VSS nmos W=0.155u L=0.04u
M30989 U3293/net4 U3293/net10 U3293/net14 VDD pmos W=0.255u L=0.04u
M30990 U3293/net6 WX655 U3293/net14 VDD pmos W=0.28u L=0.04u
M30991 U3293/net4 n1379 VDD VDD pmos W=0.205u L=0.04u
M30992 U3293/net6 U3293/net4 VDD VDD pmos W=0.24u L=0.04u
M30993 n2446 U3293/net14 VDD VDD pmos W=0.205u L=0.04u
M30994 U3293/net10 WX655 VDD VDD pmos W=0.205u L=0.04u
M30995 WX10438 n1246 U3294/net26 VSS nmos W=0.155u L=0.04u
M30996 WX10438 n1488 U3294/net26 VSS nmos W=0.155u L=0.04u
M30997 U3294/net29 n2448 VSS VSS nmos W=0.155u L=0.04u
M30998 U3294/net26 n2447 U3294/net29 VSS nmos W=0.155u L=0.04u
M30999 U3294/net26 n1615 U3294/net29 VSS nmos W=0.155u L=0.04u
M31000 WX10438 n1488 U3294/net43 VDD pmos W=0.205u L=0.04u
M31001 WX10438 n1615 U3294/net49 VDD pmos W=0.205u L=0.04u
M31002 U3294/net49 n2447 VDD VDD pmos W=0.205u L=0.04u
M31003 U3294/net43 n1246 VDD VDD pmos W=0.205u L=0.04u
M31004 WX10438 n2448 VDD VDD pmos W=0.205u L=0.04u
M31005 U3295/net29 n1343 VSS VSS nmos W=0.155u L=0.04u
M31006 n2448 WX10837 U3295/net29 VSS nmos W=0.155u L=0.04u
M31007 n2448 DATA_0_27 U3295/net23 VSS nmos W=0.155u L=0.04u
M31008 U3295/net23 n1617 VSS VSS nmos W=0.155u L=0.04u
M31009 U3295/net20 n1617 n2448 VDD pmos W=0.205u L=0.04u
M31010 U3295/net20 DATA_0_27 n2448 VDD pmos W=0.205u L=0.04u
M31011 VDD WX10837 U3295/net20 VDD pmos W=0.205u L=0.04u
M31012 VDD n1343 U3295/net20 VDD pmos W=0.205u L=0.04u
M31013 n2447 CRC_OUT_1_27 VSS VSS nmos W=0.135u L=0.04u
M31014 n2447 CRC_OUT_1_27 VDD VDD pmos W=0.205u L=0.04u
M31015 U3297/net28 U3297/net20 U3297/net64 VSS nmos W=0.155u L=0.04u
M31016 U3297/net24 U3297/net30 U3297/net32 VSS nmos W=0.155u L=0.04u
M31017 U3297/net28 U3297/net40 U3297/net24 VSS nmos W=0.155u L=0.04u
M31018 U3297/net40 n2450 U3297/net108 VSS nmos W=0.155u L=0.04u
M31019 U3297/net40 U3297/net106 U3297/net104 VSS nmos W=0.155u L=0.04u
M31020 U3297/net24 n2449 U3297/net050 VSS nmos W=0.155u L=0.04u
M31021 U3297/net050 U3297/net32 VSS VSS nmos W=0.155u L=0.04u
M31022 U3297/net20 U3297/net40 VSS VSS nmos W=0.155u L=0.04u
M31023 U3297/net106 n2450 VSS VSS nmos W=0.155u L=0.04u
M31024 U3297/net104 WX11189 VSS VSS nmos W=0.155u L=0.04u
M31025 U3297/net30 n2449 VSS VSS nmos W=0.155u L=0.04u
M31026 U3297/net108 U3297/net104 VSS VSS nmos W=0.155u L=0.04u
M31027 n1488 U3297/net28 VSS VSS nmos W=0.155u L=0.04u
M31028 U3297/net32 WX11061 VSS VSS nmos W=0.155u L=0.04u
M31029 U3297/net64 U3297/net24 VSS VSS nmos W=0.2u L=0.04u
M31030 U3297/net28 U3297/net40 U3297/net64 VDD pmos W=0.205u L=0.04u
M31031 U3297/net24 n2449 U3297/net32 VDD pmos W=0.205u L=0.04u
M31032 U3297/net28 U3297/net20 U3297/net24 VDD pmos W=0.205u L=0.04u
M31033 U3297/net40 U3297/net106 U3297/net108 VDD pmos W=0.205u L=0.04u
M31034 U3297/net40 n2450 U3297/net104 VDD pmos W=0.205u L=0.04u
M31035 U3297/net20 U3297/net40 VDD VDD pmos W=0.205u L=0.04u
M31036 U3297/net106 n2450 VDD VDD pmos W=0.205u L=0.04u
M31037 U3297/net104 WX11189 VDD VDD pmos W=0.205u L=0.04u
M31038 U3297/net30 n2449 VDD VDD pmos W=0.205u L=0.04u
M31039 U3297/net108 U3297/net104 VDD VDD pmos W=0.205u L=0.04u
M31040 n1488 U3297/net28 VDD VDD pmos W=0.205u L=0.04u
M31041 U3297/net32 WX11061 VDD VDD pmos W=0.205u L=0.04u
M31042 U3297/net64 U3297/net24 VDD VDD pmos W=0.28u L=0.04u
M31043 U3297/net24 U3297/net30 U3297/net045 VDD pmos W=0.205u L=0.04u
M31044 U3297/net045 U3297/net32 VDD VDD pmos W=0.205u L=0.04u
M31045 U3298/net4 WX10997 U3298/net14 VSS nmos W=0.155u L=0.04u
M31046 U3298/net6 U3298/net10 U3298/net14 VSS nmos W=0.17u L=0.04u
M31047 U3298/net4 n1379 VSS VSS nmos W=0.155u L=0.04u
M31048 U3298/net6 U3298/net4 VSS VSS nmos W=0.17u L=0.04u
M31049 n2450 U3298/net14 VSS VSS nmos W=0.155u L=0.04u
M31050 U3298/net10 WX10997 VSS VSS nmos W=0.155u L=0.04u
M31051 U3298/net4 U3298/net10 U3298/net14 VDD pmos W=0.255u L=0.04u
M31052 U3298/net6 WX10997 U3298/net14 VDD pmos W=0.28u L=0.04u
M31053 U3298/net4 n1379 VDD VDD pmos W=0.205u L=0.04u
M31054 U3298/net6 U3298/net4 VDD VDD pmos W=0.24u L=0.04u
M31055 n2450 U3298/net14 VDD VDD pmos W=0.205u L=0.04u
M31056 U3298/net10 WX10997 VDD VDD pmos W=0.205u L=0.04u
M31057 n2449 WX11125 VSS VSS nmos W=0.135u L=0.04u
M31058 n2449 WX11125 VDD VDD pmos W=0.205u L=0.04u
M31059 WX10424 n1246 U3300/net26 VSS nmos W=0.155u L=0.04u
M31060 WX10424 n1491 U3300/net26 VSS nmos W=0.155u L=0.04u
M31061 U3300/net29 n2452 VSS VSS nmos W=0.155u L=0.04u
M31062 U3300/net26 n2451 U3300/net29 VSS nmos W=0.155u L=0.04u
M31063 U3300/net26 n1615 U3300/net29 VSS nmos W=0.155u L=0.04u
M31064 WX10424 n1491 U3300/net43 VDD pmos W=0.205u L=0.04u
M31065 WX10424 n1615 U3300/net49 VDD pmos W=0.205u L=0.04u
M31066 U3300/net49 n2451 VDD VDD pmos W=0.205u L=0.04u
M31067 U3300/net43 n1246 VDD VDD pmos W=0.205u L=0.04u
M31068 WX10424 n2452 VDD VDD pmos W=0.205u L=0.04u
M31069 U3301/net29 n1343 VSS VSS nmos W=0.155u L=0.04u
M31070 n2452 WX10835 U3301/net29 VSS nmos W=0.155u L=0.04u
M31071 n2452 DATA_0_28 U3301/net23 VSS nmos W=0.155u L=0.04u
M31072 U3301/net23 n1617 VSS VSS nmos W=0.155u L=0.04u
M31073 U3301/net20 n1617 n2452 VDD pmos W=0.205u L=0.04u
M31074 U3301/net20 DATA_0_28 n2452 VDD pmos W=0.205u L=0.04u
M31075 VDD WX10835 U3301/net20 VDD pmos W=0.205u L=0.04u
M31076 VDD n1343 U3301/net20 VDD pmos W=0.205u L=0.04u
M31077 n2451 CRC_OUT_1_28 VSS VSS nmos W=0.135u L=0.04u
M31078 n2451 CRC_OUT_1_28 VDD VDD pmos W=0.205u L=0.04u
M31079 U3303/net28 U3303/net20 U3303/net64 VSS nmos W=0.155u L=0.04u
M31080 U3303/net24 U3303/net30 U3303/net32 VSS nmos W=0.155u L=0.04u
M31081 U3303/net28 U3303/net40 U3303/net24 VSS nmos W=0.155u L=0.04u
M31082 U3303/net40 n2454 U3303/net108 VSS nmos W=0.155u L=0.04u
M31083 U3303/net40 U3303/net106 U3303/net104 VSS nmos W=0.155u L=0.04u
M31084 U3303/net24 n2453 U3303/net050 VSS nmos W=0.155u L=0.04u
M31085 U3303/net050 U3303/net32 VSS VSS nmos W=0.155u L=0.04u
M31086 U3303/net20 U3303/net40 VSS VSS nmos W=0.155u L=0.04u
M31087 U3303/net106 n2454 VSS VSS nmos W=0.155u L=0.04u
M31088 U3303/net104 WX11187 VSS VSS nmos W=0.155u L=0.04u
M31089 U3303/net30 n2453 VSS VSS nmos W=0.155u L=0.04u
M31090 U3303/net108 U3303/net104 VSS VSS nmos W=0.155u L=0.04u
M31091 n1491 U3303/net28 VSS VSS nmos W=0.155u L=0.04u
M31092 U3303/net32 WX11059 VSS VSS nmos W=0.155u L=0.04u
M31093 U3303/net64 U3303/net24 VSS VSS nmos W=0.2u L=0.04u
M31094 U3303/net28 U3303/net40 U3303/net64 VDD pmos W=0.205u L=0.04u
M31095 U3303/net24 n2453 U3303/net32 VDD pmos W=0.205u L=0.04u
M31096 U3303/net28 U3303/net20 U3303/net24 VDD pmos W=0.205u L=0.04u
M31097 U3303/net40 U3303/net106 U3303/net108 VDD pmos W=0.205u L=0.04u
M31098 U3303/net40 n2454 U3303/net104 VDD pmos W=0.205u L=0.04u
M31099 U3303/net20 U3303/net40 VDD VDD pmos W=0.205u L=0.04u
M31100 U3303/net106 n2454 VDD VDD pmos W=0.205u L=0.04u
M31101 U3303/net104 WX11187 VDD VDD pmos W=0.205u L=0.04u
M31102 U3303/net30 n2453 VDD VDD pmos W=0.205u L=0.04u
M31103 U3303/net108 U3303/net104 VDD VDD pmos W=0.205u L=0.04u
M31104 n1491 U3303/net28 VDD VDD pmos W=0.205u L=0.04u
M31105 U3303/net32 WX11059 VDD VDD pmos W=0.205u L=0.04u
M31106 U3303/net64 U3303/net24 VDD VDD pmos W=0.28u L=0.04u
M31107 U3303/net24 U3303/net30 U3303/net045 VDD pmos W=0.205u L=0.04u
M31108 U3303/net045 U3303/net32 VDD VDD pmos W=0.205u L=0.04u
M31109 U3304/net4 WX10995 U3304/net14 VSS nmos W=0.155u L=0.04u
M31110 U3304/net6 U3304/net10 U3304/net14 VSS nmos W=0.17u L=0.04u
M31111 U3304/net4 n1379 VSS VSS nmos W=0.155u L=0.04u
M31112 U3304/net6 U3304/net4 VSS VSS nmos W=0.17u L=0.04u
M31113 n2454 U3304/net14 VSS VSS nmos W=0.155u L=0.04u
M31114 U3304/net10 WX10995 VSS VSS nmos W=0.155u L=0.04u
M31115 U3304/net4 U3304/net10 U3304/net14 VDD pmos W=0.255u L=0.04u
M31116 U3304/net6 WX10995 U3304/net14 VDD pmos W=0.28u L=0.04u
M31117 U3304/net4 n1379 VDD VDD pmos W=0.205u L=0.04u
M31118 U3304/net6 U3304/net4 VDD VDD pmos W=0.24u L=0.04u
M31119 n2454 U3304/net14 VDD VDD pmos W=0.205u L=0.04u
M31120 U3304/net10 WX10995 VDD VDD pmos W=0.205u L=0.04u
M31121 n2453 WX11123 VSS VSS nmos W=0.135u L=0.04u
M31122 n2453 WX11123 VDD VDD pmos W=0.205u L=0.04u
M31123 WX10410 n1246 U3306/net26 VSS nmos W=0.155u L=0.04u
M31124 WX10410 n1494 U3306/net26 VSS nmos W=0.155u L=0.04u
M31125 U3306/net29 n2456 VSS VSS nmos W=0.155u L=0.04u
M31126 U3306/net26 n2455 U3306/net29 VSS nmos W=0.155u L=0.04u
M31127 U3306/net26 n1615 U3306/net29 VSS nmos W=0.155u L=0.04u
M31128 WX10410 n1494 U3306/net43 VDD pmos W=0.205u L=0.04u
M31129 WX10410 n1615 U3306/net49 VDD pmos W=0.205u L=0.04u
M31130 U3306/net49 n2455 VDD VDD pmos W=0.205u L=0.04u
M31131 U3306/net43 n1246 VDD VDD pmos W=0.205u L=0.04u
M31132 WX10410 n2456 VDD VDD pmos W=0.205u L=0.04u
M31133 U3307/net29 n1348 VSS VSS nmos W=0.155u L=0.04u
M31134 n2456 WX10833 U3307/net29 VSS nmos W=0.155u L=0.04u
M31135 n2456 DATA_0_29 U3307/net23 VSS nmos W=0.155u L=0.04u
M31136 U3307/net23 n1617 VSS VSS nmos W=0.155u L=0.04u
M31137 U3307/net20 n1617 n2456 VDD pmos W=0.205u L=0.04u
M31138 U3307/net20 DATA_0_29 n2456 VDD pmos W=0.205u L=0.04u
M31139 VDD WX10833 U3307/net20 VDD pmos W=0.205u L=0.04u
M31140 VDD n1348 U3307/net20 VDD pmos W=0.205u L=0.04u
M31141 n2455 CRC_OUT_1_29 VSS VSS nmos W=0.135u L=0.04u
M31142 n2455 CRC_OUT_1_29 VDD VDD pmos W=0.205u L=0.04u
M31143 U3309/net28 U3309/net20 U3309/net64 VSS nmos W=0.155u L=0.04u
M31144 U3309/net24 U3309/net30 U3309/net32 VSS nmos W=0.155u L=0.04u
M31145 U3309/net28 U3309/net40 U3309/net24 VSS nmos W=0.155u L=0.04u
M31146 U3309/net40 n2458 U3309/net108 VSS nmos W=0.155u L=0.04u
M31147 U3309/net40 U3309/net106 U3309/net104 VSS nmos W=0.155u L=0.04u
M31148 U3309/net24 n2457 U3309/net050 VSS nmos W=0.155u L=0.04u
M31149 U3309/net050 U3309/net32 VSS VSS nmos W=0.155u L=0.04u
M31150 U3309/net20 U3309/net40 VSS VSS nmos W=0.155u L=0.04u
M31151 U3309/net106 n2458 VSS VSS nmos W=0.155u L=0.04u
M31152 U3309/net104 WX11185 VSS VSS nmos W=0.155u L=0.04u
M31153 U3309/net30 n2457 VSS VSS nmos W=0.155u L=0.04u
M31154 U3309/net108 U3309/net104 VSS VSS nmos W=0.155u L=0.04u
M31155 n1494 U3309/net28 VSS VSS nmos W=0.155u L=0.04u
M31156 U3309/net32 WX11057 VSS VSS nmos W=0.155u L=0.04u
M31157 U3309/net64 U3309/net24 VSS VSS nmos W=0.2u L=0.04u
M31158 U3309/net28 U3309/net40 U3309/net64 VDD pmos W=0.205u L=0.04u
M31159 U3309/net24 n2457 U3309/net32 VDD pmos W=0.205u L=0.04u
M31160 U3309/net28 U3309/net20 U3309/net24 VDD pmos W=0.205u L=0.04u
M31161 U3309/net40 U3309/net106 U3309/net108 VDD pmos W=0.205u L=0.04u
M31162 U3309/net40 n2458 U3309/net104 VDD pmos W=0.205u L=0.04u
M31163 U3309/net20 U3309/net40 VDD VDD pmos W=0.205u L=0.04u
M31164 U3309/net106 n2458 VDD VDD pmos W=0.205u L=0.04u
M31165 U3309/net104 WX11185 VDD VDD pmos W=0.205u L=0.04u
M31166 U3309/net30 n2457 VDD VDD pmos W=0.205u L=0.04u
M31167 U3309/net108 U3309/net104 VDD VDD pmos W=0.205u L=0.04u
M31168 n1494 U3309/net28 VDD VDD pmos W=0.205u L=0.04u
M31169 U3309/net32 WX11057 VDD VDD pmos W=0.205u L=0.04u
M31170 U3309/net64 U3309/net24 VDD VDD pmos W=0.28u L=0.04u
M31171 U3309/net24 U3309/net30 U3309/net045 VDD pmos W=0.205u L=0.04u
M31172 U3309/net045 U3309/net32 VDD VDD pmos W=0.205u L=0.04u
M31173 U3310/net4 WX10993 U3310/net14 VSS nmos W=0.155u L=0.04u
M31174 U3310/net6 U3310/net10 U3310/net14 VSS nmos W=0.17u L=0.04u
M31175 U3310/net4 n1379 VSS VSS nmos W=0.155u L=0.04u
M31176 U3310/net6 U3310/net4 VSS VSS nmos W=0.17u L=0.04u
M31177 n2458 U3310/net14 VSS VSS nmos W=0.155u L=0.04u
M31178 U3310/net10 WX10993 VSS VSS nmos W=0.155u L=0.04u
M31179 U3310/net4 U3310/net10 U3310/net14 VDD pmos W=0.255u L=0.04u
M31180 U3310/net6 WX10993 U3310/net14 VDD pmos W=0.28u L=0.04u
M31181 U3310/net4 n1379 VDD VDD pmos W=0.205u L=0.04u
M31182 U3310/net6 U3310/net4 VDD VDD pmos W=0.24u L=0.04u
M31183 n2458 U3310/net14 VDD VDD pmos W=0.205u L=0.04u
M31184 U3310/net10 WX10993 VDD VDD pmos W=0.205u L=0.04u
M31185 n2457 WX11121 VSS VSS nmos W=0.135u L=0.04u
M31186 n2457 WX11121 VDD VDD pmos W=0.205u L=0.04u
M31187 WX10396 n1246 U3312/net26 VSS nmos W=0.155u L=0.04u
M31188 WX10396 n1497 U3312/net26 VSS nmos W=0.155u L=0.04u
M31189 U3312/net29 n2460 VSS VSS nmos W=0.155u L=0.04u
M31190 U3312/net26 n2459 U3312/net29 VSS nmos W=0.155u L=0.04u
M31191 U3312/net26 n1615 U3312/net29 VSS nmos W=0.155u L=0.04u
M31192 WX10396 n1497 U3312/net43 VDD pmos W=0.205u L=0.04u
M31193 WX10396 n1615 U3312/net49 VDD pmos W=0.205u L=0.04u
M31194 U3312/net49 n2459 VDD VDD pmos W=0.205u L=0.04u
M31195 U3312/net43 n1246 VDD VDD pmos W=0.205u L=0.04u
M31196 WX10396 n2460 VDD VDD pmos W=0.205u L=0.04u
M31197 U3313/net29 n1333 VSS VSS nmos W=0.155u L=0.04u
M31198 n2460 WX10831 U3313/net29 VSS nmos W=0.155u L=0.04u
M31199 n2460 DATA_0_30 U3313/net23 VSS nmos W=0.155u L=0.04u
M31200 U3313/net23 n1617 VSS VSS nmos W=0.155u L=0.04u
M31201 U3313/net20 n1617 n2460 VDD pmos W=0.205u L=0.04u
M31202 U3313/net20 DATA_0_30 n2460 VDD pmos W=0.205u L=0.04u
M31203 VDD WX10831 U3313/net20 VDD pmos W=0.205u L=0.04u
M31204 VDD n1333 U3313/net20 VDD pmos W=0.205u L=0.04u
M31205 n1404 n1500 VSS VSS nmos W=0.135u L=0.04u
M31206 n1404 n1500 VDD VDD pmos W=0.205u L=0.04u
M31207 n2459 CRC_OUT_1_30 VSS VSS nmos W=0.135u L=0.04u
M31208 n2459 CRC_OUT_1_30 VDD VDD pmos W=0.205u L=0.04u
M31209 U3316/net28 U3316/net20 U3316/net64 VSS nmos W=0.155u L=0.04u
M31210 U3316/net24 U3316/net30 U3316/net32 VSS nmos W=0.155u L=0.04u
M31211 U3316/net28 U3316/net40 U3316/net24 VSS nmos W=0.155u L=0.04u
M31212 U3316/net40 n2462 U3316/net108 VSS nmos W=0.155u L=0.04u
M31213 U3316/net40 U3316/net106 U3316/net104 VSS nmos W=0.155u L=0.04u
M31214 U3316/net24 n2461 U3316/net050 VSS nmos W=0.155u L=0.04u
M31215 U3316/net050 U3316/net32 VSS VSS nmos W=0.155u L=0.04u
M31216 U3316/net20 U3316/net40 VSS VSS nmos W=0.155u L=0.04u
M31217 U3316/net106 n2462 VSS VSS nmos W=0.155u L=0.04u
M31218 U3316/net104 WX11183 VSS VSS nmos W=0.155u L=0.04u
M31219 U3316/net30 n2461 VSS VSS nmos W=0.155u L=0.04u
M31220 U3316/net108 U3316/net104 VSS VSS nmos W=0.155u L=0.04u
M31221 n1497 U3316/net28 VSS VSS nmos W=0.155u L=0.04u
M31222 U3316/net32 WX11055 VSS VSS nmos W=0.155u L=0.04u
M31223 U3316/net64 U3316/net24 VSS VSS nmos W=0.2u L=0.04u
M31224 U3316/net28 U3316/net40 U3316/net64 VDD pmos W=0.205u L=0.04u
M31225 U3316/net24 n2461 U3316/net32 VDD pmos W=0.205u L=0.04u
M31226 U3316/net28 U3316/net20 U3316/net24 VDD pmos W=0.205u L=0.04u
M31227 U3316/net40 U3316/net106 U3316/net108 VDD pmos W=0.205u L=0.04u
M31228 U3316/net40 n2462 U3316/net104 VDD pmos W=0.205u L=0.04u
M31229 U3316/net20 U3316/net40 VDD VDD pmos W=0.205u L=0.04u
M31230 U3316/net106 n2462 VDD VDD pmos W=0.205u L=0.04u
M31231 U3316/net104 WX11183 VDD VDD pmos W=0.205u L=0.04u
M31232 U3316/net30 n2461 VDD VDD pmos W=0.205u L=0.04u
M31233 U3316/net108 U3316/net104 VDD VDD pmos W=0.205u L=0.04u
M31234 n1497 U3316/net28 VDD VDD pmos W=0.205u L=0.04u
M31235 U3316/net32 WX11055 VDD VDD pmos W=0.205u L=0.04u
M31236 U3316/net64 U3316/net24 VDD VDD pmos W=0.28u L=0.04u
M31237 U3316/net24 U3316/net30 U3316/net045 VDD pmos W=0.205u L=0.04u
M31238 U3316/net045 U3316/net32 VDD VDD pmos W=0.205u L=0.04u
M31239 U3317/net4 WX10991 U3317/net14 VSS nmos W=0.155u L=0.04u
M31240 U3317/net6 U3317/net10 U3317/net14 VSS nmos W=0.17u L=0.04u
M31241 U3317/net4 n1379 VSS VSS nmos W=0.155u L=0.04u
M31242 U3317/net6 U3317/net4 VSS VSS nmos W=0.17u L=0.04u
M31243 n2462 U3317/net14 VSS VSS nmos W=0.155u L=0.04u
M31244 U3317/net10 WX10991 VSS VSS nmos W=0.155u L=0.04u
M31245 U3317/net4 U3317/net10 U3317/net14 VDD pmos W=0.255u L=0.04u
M31246 U3317/net6 WX10991 U3317/net14 VDD pmos W=0.28u L=0.04u
M31247 U3317/net4 n1379 VDD VDD pmos W=0.205u L=0.04u
M31248 U3317/net6 U3317/net4 VDD VDD pmos W=0.24u L=0.04u
M31249 n2462 U3317/net14 VDD VDD pmos W=0.205u L=0.04u
M31250 U3317/net10 WX10991 VDD VDD pmos W=0.205u L=0.04u
M31251 n2461 WX11119 VSS VSS nmos W=0.135u L=0.04u
M31252 n2461 WX11119 VDD VDD pmos W=0.205u L=0.04u
M31253 WX10382 n1500 U3319/net26 VSS nmos W=0.155u L=0.04u
M31254 WX10382 WX10827 U3319/net26 VSS nmos W=0.155u L=0.04u
M31255 U3319/net29 n2463 VSS VSS nmos W=0.155u L=0.04u
M31256 U3319/net26 n1499 U3319/net29 VSS nmos W=0.155u L=0.04u
M31257 U3319/net26 n1249 U3319/net29 VSS nmos W=0.155u L=0.04u
M31258 WX10382 WX10827 U3319/net43 VDD pmos W=0.205u L=0.04u
M31259 WX10382 n1249 U3319/net49 VDD pmos W=0.205u L=0.04u
M31260 U3319/net49 n1499 VDD VDD pmos W=0.205u L=0.04u
M31261 U3319/net43 n1500 VDD VDD pmos W=0.205u L=0.04u
M31262 WX10382 n2463 VDD VDD pmos W=0.205u L=0.04u
M31263 U3320/net29 n1617 VSS VSS nmos W=0.155u L=0.04u
M31264 n2463 DATA_0_31 U3320/net29 VSS nmos W=0.155u L=0.04u
M31265 n2463 n1303 U3320/net23 VSS nmos W=0.155u L=0.04u
M31266 U3320/net23 CRC_OUT_1_31 VSS VSS nmos W=0.155u L=0.04u
M31267 U3320/net20 CRC_OUT_1_31 n2463 VDD pmos W=0.205u L=0.04u
M31268 U3320/net20 n1303 n2463 VDD pmos W=0.205u L=0.04u
M31269 VDD DATA_0_31 U3320/net20 VDD pmos W=0.205u L=0.04u
M31270 VDD n1617 U3320/net20 VDD pmos W=0.205u L=0.04u
M31271 n1403 n1615 VSS VSS nmos W=0.135u L=0.04u
M31272 n1403 n1615 VDD VDD pmos W=0.205u L=0.04u
M31273 n1399 n1430 VSS VSS nmos W=0.135u L=0.04u
M31274 n1399 n1430 VDD VDD pmos W=0.205u L=0.04u
M31275 n1430 n1380 VSS VSS nmos W=0.155u L=0.04u
M31276 n1430 TM0 VSS VSS nmos W=0.155u L=0.04u
M31277 U3323/XI1-net8 TM0 VDD VDD pmos W=0.205u L=0.04u
M31278 n1430 n1380 U3323/XI1-net8 VDD pmos W=0.205u L=0.04u
M31279 U3324/net28 U3324/net20 U3324/net64 VSS nmos W=0.155u L=0.04u
M31280 U3324/net24 U3324/net30 U3324/net32 VSS nmos W=0.155u L=0.04u
M31281 U3324/net28 U3324/net40 U3324/net24 VSS nmos W=0.155u L=0.04u
M31282 U3324/net40 n2465 U3324/net108 VSS nmos W=0.155u L=0.04u
M31283 U3324/net40 U3324/net106 U3324/net104 VSS nmos W=0.155u L=0.04u
M31284 U3324/net24 n2464 U3324/net050 VSS nmos W=0.155u L=0.04u
M31285 U3324/net050 U3324/net32 VSS VSS nmos W=0.155u L=0.04u
M31286 U3324/net20 U3324/net40 VSS VSS nmos W=0.155u L=0.04u
M31287 U3324/net106 n2465 VSS VSS nmos W=0.155u L=0.04u
M31288 U3324/net104 WX11181 VSS VSS nmos W=0.155u L=0.04u
M31289 U3324/net30 n2464 VSS VSS nmos W=0.155u L=0.04u
M31290 U3324/net108 U3324/net104 VSS VSS nmos W=0.155u L=0.04u
M31291 n1499 U3324/net28 VSS VSS nmos W=0.155u L=0.04u
M31292 U3324/net32 WX11053 VSS VSS nmos W=0.155u L=0.04u
M31293 U3324/net64 U3324/net24 VSS VSS nmos W=0.2u L=0.04u
M31294 U3324/net28 U3324/net40 U3324/net64 VDD pmos W=0.205u L=0.04u
M31295 U3324/net24 n2464 U3324/net32 VDD pmos W=0.205u L=0.04u
M31296 U3324/net28 U3324/net20 U3324/net24 VDD pmos W=0.205u L=0.04u
M31297 U3324/net40 U3324/net106 U3324/net108 VDD pmos W=0.205u L=0.04u
M31298 U3324/net40 n2465 U3324/net104 VDD pmos W=0.205u L=0.04u
M31299 U3324/net20 U3324/net40 VDD VDD pmos W=0.205u L=0.04u
M31300 U3324/net106 n2465 VDD VDD pmos W=0.205u L=0.04u
M31301 U3324/net104 WX11181 VDD VDD pmos W=0.205u L=0.04u
M31302 U3324/net30 n2464 VDD VDD pmos W=0.205u L=0.04u
M31303 U3324/net108 U3324/net104 VDD VDD pmos W=0.205u L=0.04u
M31304 n1499 U3324/net28 VDD VDD pmos W=0.205u L=0.04u
M31305 U3324/net32 WX11053 VDD VDD pmos W=0.205u L=0.04u
M31306 U3324/net64 U3324/net24 VDD VDD pmos W=0.28u L=0.04u
M31307 U3324/net24 U3324/net30 U3324/net045 VDD pmos W=0.205u L=0.04u
M31308 U3324/net045 U3324/net32 VDD VDD pmos W=0.205u L=0.04u
M31309 U3325/net4 WX10989 U3325/net14 VSS nmos W=0.155u L=0.04u
M31310 U3325/net6 U3325/net10 U3325/net14 VSS nmos W=0.17u L=0.04u
M31311 U3325/net4 n1379 VSS VSS nmos W=0.155u L=0.04u
M31312 U3325/net6 U3325/net4 VSS VSS nmos W=0.17u L=0.04u
M31313 n2465 U3325/net14 VSS VSS nmos W=0.155u L=0.04u
M31314 U3325/net10 WX10989 VSS VSS nmos W=0.155u L=0.04u
M31315 U3325/net4 U3325/net10 U3325/net14 VDD pmos W=0.255u L=0.04u
M31316 U3325/net6 WX10989 U3325/net14 VDD pmos W=0.28u L=0.04u
M31317 U3325/net4 n1379 VDD VDD pmos W=0.205u L=0.04u
M31318 U3325/net6 U3325/net4 VDD VDD pmos W=0.24u L=0.04u
M31319 n2465 U3325/net14 VDD VDD pmos W=0.205u L=0.04u
M31320 U3325/net10 WX10989 VDD VDD pmos W=0.205u L=0.04u
M31321 n2464 WX11117 VSS VSS nmos W=0.135u L=0.04u
M31322 n2464 WX11117 VDD VDD pmos W=0.205u L=0.04u
M31323 U3327/XU1-net6 TM1 VSS VSS nmos W=0.155u L=0.04u
M31324 n1500 TM0 U3327/XU1-net6 VSS nmos W=0.155u L=0.04u
M31325 n1500 TM1 VDD VDD pmos W=0.155u L=0.04u
M31326 n1500 TM0 VDD VDD pmos W=0.155u L=0.04u
M31327 WX10827 WX10829 VSS VSS nmos W=0.135u L=0.04u
M31328 WX10827 WX10829 VDD VDD pmos W=0.205u L=0.04u
M31329 U3329/net4 n1429 U3329/net14 VSS nmos W=0.155u L=0.04u
M31330 U3329/net6 U3329/net10 U3329/net14 VSS nmos W=0.17u L=0.04u
M31331 U3329/net4 n2466 VSS VSS nmos W=0.155u L=0.04u
M31332 U3329/net6 U3329/net4 VSS VSS nmos W=0.17u L=0.04u
M31333 WX1038 U3329/net14 VSS VSS nmos W=0.155u L=0.04u
M31334 U3329/net10 n1429 VSS VSS nmos W=0.155u L=0.04u
M31335 U3329/net4 U3329/net10 U3329/net14 VDD pmos W=0.255u L=0.04u
M31336 U3329/net6 n1429 U3329/net14 VDD pmos W=0.28u L=0.04u
M31337 U3329/net4 n2466 VDD VDD pmos W=0.205u L=0.04u
M31338 U3329/net6 U3329/net4 VDD VDD pmos W=0.24u L=0.04u
M31339 WX1038 U3329/net14 VDD VDD pmos W=0.205u L=0.04u
M31340 U3329/net10 n1429 VDD VDD pmos W=0.205u L=0.04u
M31341 U3330/XU1-net6 TM0 VSS VSS nmos W=0.155u L=0.04u
M31342 n2466 WX493 U3330/XU1-net6 VSS nmos W=0.155u L=0.04u
M31343 n2466 TM0 VDD VDD pmos W=0.155u L=0.04u
M31344 n2466 WX493 VDD VDD pmos W=0.155u L=0.04u
M31345 U3331/net28 U3331/net20 U3331/net64 VSS nmos W=0.155u L=0.04u
M31346 U3331/net24 U3331/net30 U3331/net32 VSS nmos W=0.155u L=0.04u
M31347 U3331/net28 U3331/net40 U3331/net24 VSS nmos W=0.155u L=0.04u
M31348 U3331/net40 n2467 U3331/net108 VSS nmos W=0.155u L=0.04u
M31349 U3331/net40 U3331/net106 U3331/net104 VSS nmos W=0.155u L=0.04u
M31350 U3331/net24 WX781 U3331/net050 VSS nmos W=0.155u L=0.04u
M31351 U3331/net050 U3331/net32 VSS VSS nmos W=0.155u L=0.04u
M31352 U3331/net20 U3331/net40 VSS VSS nmos W=0.155u L=0.04u
M31353 U3331/net106 n2467 VSS VSS nmos W=0.155u L=0.04u
M31354 U3331/net104 WX845 VSS VSS nmos W=0.155u L=0.04u
M31355 U3331/net30 WX781 VSS VSS nmos W=0.155u L=0.04u
M31356 U3331/net108 U3331/net104 VSS VSS nmos W=0.155u L=0.04u
M31357 n1429 U3331/net28 VSS VSS nmos W=0.155u L=0.04u
M31358 U3331/net32 WX717 VSS VSS nmos W=0.155u L=0.04u
M31359 U3331/net64 U3331/net24 VSS VSS nmos W=0.2u L=0.04u
M31360 U3331/net28 U3331/net40 U3331/net64 VDD pmos W=0.205u L=0.04u
M31361 U3331/net24 WX781 U3331/net32 VDD pmos W=0.205u L=0.04u
M31362 U3331/net28 U3331/net20 U3331/net24 VDD pmos W=0.205u L=0.04u
M31363 U3331/net40 U3331/net106 U3331/net108 VDD pmos W=0.205u L=0.04u
M31364 U3331/net40 n2467 U3331/net104 VDD pmos W=0.205u L=0.04u
M31365 U3331/net20 U3331/net40 VDD VDD pmos W=0.205u L=0.04u
M31366 U3331/net106 n2467 VDD VDD pmos W=0.205u L=0.04u
M31367 U3331/net104 WX845 VDD VDD pmos W=0.205u L=0.04u
M31368 U3331/net30 WX781 VDD VDD pmos W=0.205u L=0.04u
M31369 U3331/net108 U3331/net104 VDD VDD pmos W=0.205u L=0.04u
M31370 n1429 U3331/net28 VDD VDD pmos W=0.205u L=0.04u
M31371 U3331/net32 WX717 VDD VDD pmos W=0.205u L=0.04u
M31372 U3331/net64 U3331/net24 VDD VDD pmos W=0.28u L=0.04u
M31373 U3331/net24 U3331/net30 U3331/net045 VDD pmos W=0.205u L=0.04u
M31374 U3331/net045 U3331/net32 VDD VDD pmos W=0.205u L=0.04u
M31375 U3332/net4 WX653 U3332/net14 VSS nmos W=0.155u L=0.04u
M31376 U3332/net6 U3332/net10 U3332/net14 VSS nmos W=0.17u L=0.04u
M31377 U3332/net4 n1379 VSS VSS nmos W=0.155u L=0.04u
M31378 U3332/net6 U3332/net4 VSS VSS nmos W=0.17u L=0.04u
M31379 n2467 U3332/net14 VSS VSS nmos W=0.155u L=0.04u
M31380 U3332/net10 WX653 VSS VSS nmos W=0.155u L=0.04u
M31381 U3332/net4 U3332/net10 U3332/net14 VDD pmos W=0.255u L=0.04u
M31382 U3332/net6 WX653 U3332/net14 VDD pmos W=0.28u L=0.04u
M31383 U3332/net4 n1379 VDD VDD pmos W=0.205u L=0.04u
M31384 U3332/net6 U3332/net4 VDD VDD pmos W=0.24u L=0.04u
M31385 n2467 U3332/net14 VDD VDD pmos W=0.205u L=0.04u
M31386 U3332/net10 WX653 VDD VDD pmos W=0.205u L=0.04u
M31387 U3333/net4 n1556 U3333/net14 VSS nmos W=0.155u L=0.04u
M31388 U3333/net6 U3333/net10 U3333/net14 VSS nmos W=0.17u L=0.04u
M31389 U3333/net4 n2468 VSS VSS nmos W=0.155u L=0.04u
M31390 U3333/net6 U3333/net4 VSS VSS nmos W=0.17u L=0.04u
M31391 WX1031 U3333/net14 VSS VSS nmos W=0.155u L=0.04u
M31392 U3333/net10 n1556 VSS VSS nmos W=0.155u L=0.04u
M31393 U3333/net4 U3333/net10 U3333/net14 VDD pmos W=0.255u L=0.04u
M31394 U3333/net6 n1556 U3333/net14 VDD pmos W=0.28u L=0.04u
M31395 U3333/net4 n2468 VDD VDD pmos W=0.205u L=0.04u
M31396 U3333/net6 U3333/net4 VDD VDD pmos W=0.24u L=0.04u
M31397 WX1031 U3333/net14 VDD VDD pmos W=0.205u L=0.04u
M31398 U3333/net10 n1556 VDD VDD pmos W=0.205u L=0.04u
M31399 U3334/XU1-net6 TM0 VSS VSS nmos W=0.155u L=0.04u
M31400 n2468 WX491 U3334/XU1-net6 VSS nmos W=0.155u L=0.04u
M31401 n2468 TM0 VDD VDD pmos W=0.155u L=0.04u
M31402 n2468 WX491 VDD VDD pmos W=0.155u L=0.04u
M31403 U3335/net28 U3335/net20 U3335/net64 VSS nmos W=0.155u L=0.04u
M31404 U3335/net24 U3335/net30 U3335/net32 VSS nmos W=0.155u L=0.04u
M31405 U3335/net28 U3335/net40 U3335/net24 VSS nmos W=0.155u L=0.04u
M31406 U3335/net40 n2469 U3335/net108 VSS nmos W=0.155u L=0.04u
M31407 U3335/net40 U3335/net106 U3335/net104 VSS nmos W=0.155u L=0.04u
M31408 U3335/net24 WX779 U3335/net050 VSS nmos W=0.155u L=0.04u
M31409 U3335/net050 U3335/net32 VSS VSS nmos W=0.155u L=0.04u
M31410 U3335/net20 U3335/net40 VSS VSS nmos W=0.155u L=0.04u
M31411 U3335/net106 n2469 VSS VSS nmos W=0.155u L=0.04u
M31412 U3335/net104 WX843 VSS VSS nmos W=0.155u L=0.04u
M31413 U3335/net30 WX779 VSS VSS nmos W=0.155u L=0.04u
M31414 U3335/net108 U3335/net104 VSS VSS nmos W=0.155u L=0.04u
M31415 n1556 U3335/net28 VSS VSS nmos W=0.155u L=0.04u
M31416 U3335/net32 WX715 VSS VSS nmos W=0.155u L=0.04u
M31417 U3335/net64 U3335/net24 VSS VSS nmos W=0.2u L=0.04u
M31418 U3335/net28 U3335/net40 U3335/net64 VDD pmos W=0.205u L=0.04u
M31419 U3335/net24 WX779 U3335/net32 VDD pmos W=0.205u L=0.04u
M31420 U3335/net28 U3335/net20 U3335/net24 VDD pmos W=0.205u L=0.04u
M31421 U3335/net40 U3335/net106 U3335/net108 VDD pmos W=0.205u L=0.04u
M31422 U3335/net40 n2469 U3335/net104 VDD pmos W=0.205u L=0.04u
M31423 U3335/net20 U3335/net40 VDD VDD pmos W=0.205u L=0.04u
M31424 U3335/net106 n2469 VDD VDD pmos W=0.205u L=0.04u
M31425 U3335/net104 WX843 VDD VDD pmos W=0.205u L=0.04u
M31426 U3335/net30 WX779 VDD VDD pmos W=0.205u L=0.04u
M31427 U3335/net108 U3335/net104 VDD VDD pmos W=0.205u L=0.04u
M31428 n1556 U3335/net28 VDD VDD pmos W=0.205u L=0.04u
M31429 U3335/net32 WX715 VDD VDD pmos W=0.205u L=0.04u
M31430 U3335/net64 U3335/net24 VDD VDD pmos W=0.28u L=0.04u
M31431 U3335/net24 U3335/net30 U3335/net045 VDD pmos W=0.205u L=0.04u
M31432 U3335/net045 U3335/net32 VDD VDD pmos W=0.205u L=0.04u
M31433 U3336/net4 WX651 U3336/net14 VSS nmos W=0.155u L=0.04u
M31434 U3336/net6 U3336/net10 U3336/net14 VSS nmos W=0.17u L=0.04u
M31435 U3336/net4 n1379 VSS VSS nmos W=0.155u L=0.04u
M31436 U3336/net6 U3336/net4 VSS VSS nmos W=0.17u L=0.04u
M31437 n2469 U3336/net14 VSS VSS nmos W=0.155u L=0.04u
M31438 U3336/net10 WX651 VSS VSS nmos W=0.155u L=0.04u
M31439 U3336/net4 U3336/net10 U3336/net14 VDD pmos W=0.255u L=0.04u
M31440 U3336/net6 WX651 U3336/net14 VDD pmos W=0.28u L=0.04u
M31441 U3336/net4 n1379 VDD VDD pmos W=0.205u L=0.04u
M31442 U3336/net6 U3336/net4 VDD VDD pmos W=0.24u L=0.04u
M31443 n2469 U3336/net14 VDD VDD pmos W=0.205u L=0.04u
M31444 U3336/net10 WX651 VDD VDD pmos W=0.205u L=0.04u
M31445 U3337/net4 n1703 U3337/net14 VSS nmos W=0.155u L=0.04u
M31446 U3337/net6 U3337/net10 U3337/net14 VSS nmos W=0.17u L=0.04u
M31447 U3337/net4 n2470 VSS VSS nmos W=0.155u L=0.04u
M31448 U3337/net6 U3337/net4 VSS VSS nmos W=0.17u L=0.04u
M31449 WX1024 U3337/net14 VSS VSS nmos W=0.155u L=0.04u
M31450 U3337/net10 n1703 VSS VSS nmos W=0.155u L=0.04u
M31451 U3337/net4 U3337/net10 U3337/net14 VDD pmos W=0.255u L=0.04u
M31452 U3337/net6 n1703 U3337/net14 VDD pmos W=0.28u L=0.04u
M31453 U3337/net4 n2470 VDD VDD pmos W=0.205u L=0.04u
M31454 U3337/net6 U3337/net4 VDD VDD pmos W=0.24u L=0.04u
M31455 WX1024 U3337/net14 VDD VDD pmos W=0.205u L=0.04u
M31456 U3337/net10 n1703 VDD VDD pmos W=0.205u L=0.04u
M31457 U3338/XU1-net6 TM0 VSS VSS nmos W=0.155u L=0.04u
M31458 n2470 WX489 U3338/XU1-net6 VSS nmos W=0.155u L=0.04u
M31459 n2470 TM0 VDD VDD pmos W=0.155u L=0.04u
M31460 n2470 WX489 VDD VDD pmos W=0.155u L=0.04u
M31461 U3339/net28 U3339/net20 U3339/net64 VSS nmos W=0.155u L=0.04u
M31462 U3339/net24 U3339/net30 U3339/net32 VSS nmos W=0.155u L=0.04u
M31463 U3339/net28 U3339/net40 U3339/net24 VSS nmos W=0.155u L=0.04u
M31464 U3339/net40 n2471 U3339/net108 VSS nmos W=0.155u L=0.04u
M31465 U3339/net40 U3339/net106 U3339/net104 VSS nmos W=0.155u L=0.04u
M31466 U3339/net24 WX777 U3339/net050 VSS nmos W=0.155u L=0.04u
M31467 U3339/net050 U3339/net32 VSS VSS nmos W=0.155u L=0.04u
M31468 U3339/net20 U3339/net40 VSS VSS nmos W=0.155u L=0.04u
M31469 U3339/net106 n2471 VSS VSS nmos W=0.155u L=0.04u
M31470 U3339/net104 WX841 VSS VSS nmos W=0.155u L=0.04u
M31471 U3339/net30 WX777 VSS VSS nmos W=0.155u L=0.04u
M31472 U3339/net108 U3339/net104 VSS VSS nmos W=0.155u L=0.04u
M31473 n1703 U3339/net28 VSS VSS nmos W=0.155u L=0.04u
M31474 U3339/net32 WX713 VSS VSS nmos W=0.155u L=0.04u
M31475 U3339/net64 U3339/net24 VSS VSS nmos W=0.2u L=0.04u
M31476 U3339/net28 U3339/net40 U3339/net64 VDD pmos W=0.205u L=0.04u
M31477 U3339/net24 WX777 U3339/net32 VDD pmos W=0.205u L=0.04u
M31478 U3339/net28 U3339/net20 U3339/net24 VDD pmos W=0.205u L=0.04u
M31479 U3339/net40 U3339/net106 U3339/net108 VDD pmos W=0.205u L=0.04u
M31480 U3339/net40 n2471 U3339/net104 VDD pmos W=0.205u L=0.04u
M31481 U3339/net20 U3339/net40 VDD VDD pmos W=0.205u L=0.04u
M31482 U3339/net106 n2471 VDD VDD pmos W=0.205u L=0.04u
M31483 U3339/net104 WX841 VDD VDD pmos W=0.205u L=0.04u
M31484 U3339/net30 WX777 VDD VDD pmos W=0.205u L=0.04u
M31485 U3339/net108 U3339/net104 VDD VDD pmos W=0.205u L=0.04u
M31486 n1703 U3339/net28 VDD VDD pmos W=0.205u L=0.04u
M31487 U3339/net32 WX713 VDD VDD pmos W=0.205u L=0.04u
M31488 U3339/net64 U3339/net24 VDD VDD pmos W=0.28u L=0.04u
M31489 U3339/net24 U3339/net30 U3339/net045 VDD pmos W=0.205u L=0.04u
M31490 U3339/net045 U3339/net32 VDD VDD pmos W=0.205u L=0.04u
M31491 U3340/net4 WX649 U3340/net14 VSS nmos W=0.155u L=0.04u
M31492 U3340/net6 U3340/net10 U3340/net14 VSS nmos W=0.17u L=0.04u
M31493 U3340/net4 n1379 VSS VSS nmos W=0.155u L=0.04u
M31494 U3340/net6 U3340/net4 VSS VSS nmos W=0.17u L=0.04u
M31495 n2471 U3340/net14 VSS VSS nmos W=0.155u L=0.04u
M31496 U3340/net10 WX649 VSS VSS nmos W=0.155u L=0.04u
M31497 U3340/net4 U3340/net10 U3340/net14 VDD pmos W=0.255u L=0.04u
M31498 U3340/net6 WX649 U3340/net14 VDD pmos W=0.28u L=0.04u
M31499 U3340/net4 n1379 VDD VDD pmos W=0.205u L=0.04u
M31500 U3340/net6 U3340/net4 VDD VDD pmos W=0.24u L=0.04u
M31501 n2471 U3340/net14 VDD VDD pmos W=0.205u L=0.04u
M31502 U3340/net10 WX649 VDD VDD pmos W=0.205u L=0.04u
M31503 U3341/net4 n1843 U3341/net14 VSS nmos W=0.155u L=0.04u
M31504 U3341/net6 U3341/net10 U3341/net14 VSS nmos W=0.17u L=0.04u
M31505 U3341/net4 n2472 VSS VSS nmos W=0.155u L=0.04u
M31506 U3341/net6 U3341/net4 VSS VSS nmos W=0.17u L=0.04u
M31507 WX1017 U3341/net14 VSS VSS nmos W=0.155u L=0.04u
M31508 U3341/net10 n1843 VSS VSS nmos W=0.155u L=0.04u
M31509 U3341/net4 U3341/net10 U3341/net14 VDD pmos W=0.255u L=0.04u
M31510 U3341/net6 n1843 U3341/net14 VDD pmos W=0.28u L=0.04u
M31511 U3341/net4 n2472 VDD VDD pmos W=0.205u L=0.04u
M31512 U3341/net6 U3341/net4 VDD VDD pmos W=0.24u L=0.04u
M31513 WX1017 U3341/net14 VDD VDD pmos W=0.205u L=0.04u
M31514 U3341/net10 n1843 VDD VDD pmos W=0.205u L=0.04u
M31515 U3342/XU1-net6 TM0 VSS VSS nmos W=0.155u L=0.04u
M31516 n2472 WX487 U3342/XU1-net6 VSS nmos W=0.155u L=0.04u
M31517 n2472 TM0 VDD VDD pmos W=0.155u L=0.04u
M31518 n2472 WX487 VDD VDD pmos W=0.155u L=0.04u
M31519 U3343/net28 U3343/net20 U3343/net64 VSS nmos W=0.155u L=0.04u
M31520 U3343/net24 U3343/net30 U3343/net32 VSS nmos W=0.155u L=0.04u
M31521 U3343/net28 U3343/net40 U3343/net24 VSS nmos W=0.155u L=0.04u
M31522 U3343/net40 n2473 U3343/net108 VSS nmos W=0.155u L=0.04u
M31523 U3343/net40 U3343/net106 U3343/net104 VSS nmos W=0.155u L=0.04u
M31524 U3343/net24 WX775 U3343/net050 VSS nmos W=0.155u L=0.04u
M31525 U3343/net050 U3343/net32 VSS VSS nmos W=0.155u L=0.04u
M31526 U3343/net20 U3343/net40 VSS VSS nmos W=0.155u L=0.04u
M31527 U3343/net106 n2473 VSS VSS nmos W=0.155u L=0.04u
M31528 U3343/net104 WX839 VSS VSS nmos W=0.155u L=0.04u
M31529 U3343/net30 WX775 VSS VSS nmos W=0.155u L=0.04u
M31530 U3343/net108 U3343/net104 VSS VSS nmos W=0.155u L=0.04u
M31531 n1843 U3343/net28 VSS VSS nmos W=0.155u L=0.04u
M31532 U3343/net32 WX711 VSS VSS nmos W=0.155u L=0.04u
M31533 U3343/net64 U3343/net24 VSS VSS nmos W=0.2u L=0.04u
M31534 U3343/net28 U3343/net40 U3343/net64 VDD pmos W=0.205u L=0.04u
M31535 U3343/net24 WX775 U3343/net32 VDD pmos W=0.205u L=0.04u
M31536 U3343/net28 U3343/net20 U3343/net24 VDD pmos W=0.205u L=0.04u
M31537 U3343/net40 U3343/net106 U3343/net108 VDD pmos W=0.205u L=0.04u
M31538 U3343/net40 n2473 U3343/net104 VDD pmos W=0.205u L=0.04u
M31539 U3343/net20 U3343/net40 VDD VDD pmos W=0.205u L=0.04u
M31540 U3343/net106 n2473 VDD VDD pmos W=0.205u L=0.04u
M31541 U3343/net104 WX839 VDD VDD pmos W=0.205u L=0.04u
M31542 U3343/net30 WX775 VDD VDD pmos W=0.205u L=0.04u
M31543 U3343/net108 U3343/net104 VDD VDD pmos W=0.205u L=0.04u
M31544 n1843 U3343/net28 VDD VDD pmos W=0.205u L=0.04u
M31545 U3343/net32 WX711 VDD VDD pmos W=0.205u L=0.04u
M31546 U3343/net64 U3343/net24 VDD VDD pmos W=0.28u L=0.04u
M31547 U3343/net24 U3343/net30 U3343/net045 VDD pmos W=0.205u L=0.04u
M31548 U3343/net045 U3343/net32 VDD VDD pmos W=0.205u L=0.04u
M31549 U3344/net4 WX647 U3344/net14 VSS nmos W=0.155u L=0.04u
M31550 U3344/net6 U3344/net10 U3344/net14 VSS nmos W=0.17u L=0.04u
M31551 U3344/net4 n1379 VSS VSS nmos W=0.155u L=0.04u
M31552 U3344/net6 U3344/net4 VSS VSS nmos W=0.17u L=0.04u
M31553 n2473 U3344/net14 VSS VSS nmos W=0.155u L=0.04u
M31554 U3344/net10 WX647 VSS VSS nmos W=0.155u L=0.04u
M31555 U3344/net4 U3344/net10 U3344/net14 VDD pmos W=0.255u L=0.04u
M31556 U3344/net6 WX647 U3344/net14 VDD pmos W=0.28u L=0.04u
M31557 U3344/net4 n1379 VDD VDD pmos W=0.205u L=0.04u
M31558 U3344/net6 U3344/net4 VDD VDD pmos W=0.24u L=0.04u
M31559 n2473 U3344/net14 VDD VDD pmos W=0.205u L=0.04u
M31560 U3344/net10 WX647 VDD VDD pmos W=0.205u L=0.04u
M31561 U3345/net4 U3345/net10 U3345/net14 VSS nmos W=0.155u L=0.04u
M31562 U3345/net6 n1977 U3345/net14 VSS nmos W=0.155u L=0.04u
M31563 U3345/net4 n2474 VSS VSS nmos W=0.155u L=0.04u
M31564 U3345/net6 U3345/net4 VSS VSS nmos W=0.155u L=0.04u
M31565 WX1010 U3345/net14 VSS VSS nmos W=0.155u L=0.04u
M31566 U3345/net10 n1977 VSS VSS nmos W=0.155u L=0.04u
M31567 U3345/net4 n1977 U3345/net14 VDD pmos W=0.205u L=0.04u
M31568 U3345/net6 U3345/net10 U3345/net14 VDD pmos W=0.205u L=0.04u
M31569 U3345/net4 n2474 VDD VDD pmos W=0.205u L=0.04u
M31570 U3345/net6 U3345/net4 VDD VDD pmos W=0.205u L=0.04u
M31571 WX1010 U3345/net14 VDD VDD pmos W=0.205u L=0.04u
M31572 U3345/net10 n1977 VDD VDD pmos W=0.205u L=0.04u
M31573 U3346/XU1-net6 WX485 VSS VSS nmos W=0.155u L=0.04u
M31574 n2474 TM0 U3346/XU1-net6 VSS nmos W=0.155u L=0.04u
M31575 n2474 WX485 VDD VDD pmos W=0.155u L=0.04u
M31576 n2474 TM0 VDD VDD pmos W=0.155u L=0.04u
M31577 n1977 n2475 VSS VSS nmos W=0.135u L=0.04u
M31578 n1977 n2475 VDD VDD pmos W=0.205u L=0.04u
M31579 U3348/net28 U3348/net20 U3348/net64 VSS nmos W=0.155u L=0.04u
M31580 U3348/net24 U3348/net30 U3348/net32 VSS nmos W=0.155u L=0.04u
M31581 U3348/net28 U3348/net40 U3348/net24 VSS nmos W=0.155u L=0.04u
M31582 U3348/net40 n2476 U3348/net108 VSS nmos W=0.155u L=0.04u
M31583 U3348/net40 U3348/net106 U3348/net104 VSS nmos W=0.155u L=0.04u
M31584 U3348/net24 WX773 U3348/net050 VSS nmos W=0.155u L=0.04u
M31585 U3348/net050 U3348/net32 VSS VSS nmos W=0.155u L=0.04u
M31586 U3348/net20 U3348/net40 VSS VSS nmos W=0.155u L=0.04u
M31587 U3348/net106 n2476 VSS VSS nmos W=0.155u L=0.04u
M31588 U3348/net104 WX837 VSS VSS nmos W=0.155u L=0.04u
M31589 U3348/net30 WX773 VSS VSS nmos W=0.155u L=0.04u
M31590 U3348/net108 U3348/net104 VSS VSS nmos W=0.155u L=0.04u
M31591 n2475 U3348/net28 VSS VSS nmos W=0.155u L=0.04u
M31592 U3348/net32 WX709 VSS VSS nmos W=0.155u L=0.04u
M31593 U3348/net64 U3348/net24 VSS VSS nmos W=0.2u L=0.04u
M31594 U3348/net28 U3348/net40 U3348/net64 VDD pmos W=0.205u L=0.04u
M31595 U3348/net24 WX773 U3348/net32 VDD pmos W=0.205u L=0.04u
M31596 U3348/net28 U3348/net20 U3348/net24 VDD pmos W=0.205u L=0.04u
M31597 U3348/net40 U3348/net106 U3348/net108 VDD pmos W=0.205u L=0.04u
M31598 U3348/net40 n2476 U3348/net104 VDD pmos W=0.205u L=0.04u
M31599 U3348/net20 U3348/net40 VDD VDD pmos W=0.205u L=0.04u
M31600 U3348/net106 n2476 VDD VDD pmos W=0.205u L=0.04u
M31601 U3348/net104 WX837 VDD VDD pmos W=0.205u L=0.04u
M31602 U3348/net30 WX773 VDD VDD pmos W=0.205u L=0.04u
M31603 U3348/net108 U3348/net104 VDD VDD pmos W=0.205u L=0.04u
M31604 n2475 U3348/net28 VDD VDD pmos W=0.205u L=0.04u
M31605 U3348/net32 WX709 VDD VDD pmos W=0.205u L=0.04u
M31606 U3348/net64 U3348/net24 VDD VDD pmos W=0.28u L=0.04u
M31607 U3348/net24 U3348/net30 U3348/net045 VDD pmos W=0.205u L=0.04u
M31608 U3348/net045 U3348/net32 VDD VDD pmos W=0.205u L=0.04u
M31609 U3349/net4 WX645 U3349/net14 VSS nmos W=0.155u L=0.04u
M31610 U3349/net6 U3349/net10 U3349/net14 VSS nmos W=0.17u L=0.04u
M31611 U3349/net4 n1368 VSS VSS nmos W=0.155u L=0.04u
M31612 U3349/net6 U3349/net4 VSS VSS nmos W=0.17u L=0.04u
M31613 n2476 U3349/net14 VSS VSS nmos W=0.155u L=0.04u
M31614 U3349/net10 WX645 VSS VSS nmos W=0.155u L=0.04u
M31615 U3349/net4 U3349/net10 U3349/net14 VDD pmos W=0.255u L=0.04u
M31616 U3349/net6 WX645 U3349/net14 VDD pmos W=0.28u L=0.04u
M31617 U3349/net4 n1368 VDD VDD pmos W=0.205u L=0.04u
M31618 U3349/net6 U3349/net4 VDD VDD pmos W=0.24u L=0.04u
M31619 n2476 U3349/net14 VDD VDD pmos W=0.205u L=0.04u
M31620 U3349/net10 WX645 VDD VDD pmos W=0.205u L=0.04u
M31621 n1555 TM1 VSS VSS nmos W=0.135u L=0.04u
M31622 n1555 TM1 VDD VDD pmos W=0.205u L=0.04u
.ENDS
