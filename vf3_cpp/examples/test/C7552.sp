* Synopsys Nettran: RHEL64 R-2020.09.5783960 2020/08/19
* Created:  8/01/2025  14:17
* Options: -verilog c7552_net_mod.v -sp tcbn45gsbwp_120b.spi -verilog-b0 VSS -verilog-b1 VDD -outType SPICE_FLAT -outName c7552_net_ft.sp

.GLOBAL VDDL VDD VSS

.SUBCKT c7552 N1 N5 N9 N12 N15 N18 N23 N26 N29 N32 N35 N38 N41 N44 N47 N50 N53 N54
+ N55 N56 N57 N58 N59 N60 N61 N62 N63 N64 N65 N66 N69 N70 N73 N74 N75 N76 N77 N78
+ N79 N80 N81 N82 N83 N84 N85 N86 N87 N88 N89 N94 N97 N100 N103 N106 N109 N110 N111
+ N112 N113 N114 N115 N118 N121 N124 N127 N130 N133 N134 N135 N138 N141 N144 N147
+ N150 N151 N152 N153 N154 N155 N156 N157 N158 N159 N160 N161 N162 N163 N164 N165
+ N166 N167 N168 N169 N170 N171 N172 N173 N174 N175 N176 N177 N178 N179 N180 N181
+ N182 N183 N184 N185 N186 N187 N188 N189 N190 N191 N192 N193 N194 N195 N196 N197
+ N198 N199 N200 N201 N202 N203 N204 N205 N206 N207 N208 N209 N210 N211 N212 N213
+ N214 N215 N216 N217 N218 N219 N220 N221 N222 N223 N224 N225 N226 N227 N228 N229
+ N230 N231 N232 N233 N234 N235 N236 N237 N238 N239 N240 N242 N245 N248 N251 N254
+ N257 N260 N263 N267 N271 N274 N277 N280 N283 N286 N289 N293 N296 N299 N303 N307
+ N310 N313 N316 N319 N322 N325 N328 N331 N334 N337 N340 N343 N346 N349 N352 N355
+ N358 N361 N364 N367 N382 N241_I N582 N881 N882 N883 N884 N885 N1112 N1113 N1781
+ N10025 N10759 N10628 N10706 N10109 N10110 N10111 N10112 N10350 N10351 N10352 N10353
+ N10574 N10575 N10576 N10632 N10641 N10704 N10711 N10712 N10713 N10714 N10715 N10716
+ N10717 N10718 N10729 N10760 N10761 N10762 N10763 N10827 N10778 N10781 N10868 N10869
+ N10870 N10871 N10905 N10906 N10907 N10908 N1387 N1388 N1394 N1397 VDD VSS
M_U771/M_u2 n1184 N18 VSS VSS nch W=0.27u L=0.04u
M_U771/M_u1 n1184 N18 VDD VDD pch W=0.41u L=0.04u
M_U772/MU1-M_u2 N881 U772/net7 VSS VSS nch W=0.155u L=0.04u
M_U772/M_u7-M_u4 U772/net7 N57 VSS VSS nch W=0.155u L=0.04u
M_U772/M_u7-M_u3 U772/net7 N5 VSS VSS nch W=0.155u L=0.04u
M_U772/MU1-M_u3 N881 U772/net7 VDD VDD pch W=0.205u L=0.04u
M_U772/M_u7-M_u1 U772/X_u7-net8 N5 VDD VDD pch W=0.205u L=0.04u
M_U772/M_u7-M_u2 U772/net7 N57 U772/X_u7-net8 VDD pch W=0.205u L=0.04u
M_U773/M_u2 N582 N15 VSS VSS nch W=0.135u L=0.04u
M_U773/M_u1 N582 N15 VDD VDD pch W=0.205u L=0.04u
M_U774/M_u3-M_u2 N1781 U774/net6 VSS VSS nch W=0.155u L=0.04u
M_U774/M_u2-M_u4 U774/X_u2-net6 N1 VSS VSS nch W=0.155u L=0.04u
M_U774/M_u2-M_u3 U774/net6 N163 U774/X_u2-net6 VSS nch W=0.155u L=0.04u
M_U774/M_u3-M_u3 N1781 U774/net6 VDD VDD pch W=0.205u L=0.04u
M_U774/M_u2-M_u2 U774/net6 N1 VDD VDD pch W=0.205u L=0.04u
M_U774/M_u2-M_u1 U774/net6 N163 VDD VDD pch W=0.205u L=0.04u
M_U775/MI15-M_u2 U775/net19 n749 VSS VSS nch W=0.155u L=0.04u
M_U775/MI21 N1397 n749 U775/net40 VSS nch W=0.155u L=0.04u
M_U775/MI12 N1397 U775/net19 U775/net36 VSS nch W=0.155u L=0.04u
M_U775/MI20 U775/net40 n748 VSS VSS nch W=0.31u L=0.04u
M_U775/MI19 U775/net36 n747 VSS VSS nch W=0.155u L=0.04u
M_U775/MI15-M_u3 U775/net19 n749 VDD VDD pch W=0.205u L=0.04u
M_U775/MI25 N1397 U775/net19 U775/net26 VDD pch W=0.325u L=0.04u
M_U775/MI24 U775/net26 n748 VDD VDD pch W=0.41u L=0.04u
M_U775/MI5 N1397 n749 U775/net30 VDD pch W=0.325u L=0.04u
M_U775/MI111 U775/net30 n747 VDD VDD pch W=0.205u L=0.04u
M_U776/MI15-M_u3 U776/net28 U776/net20 U776/net64 VSS nch W=0.155u L=0.04u
M_U776/MI8-M_u3 U776/net24 U776/net30 U776/net32 VSS nch W=0.155u L=0.04u
M_U776/MI17-M_u3 U776/net28 U776/net40 U776/net24 VSS nch W=0.155u L=0.04u
M_U776/MI11-M_u3 U776/net40 n753 U776/net108 VSS nch W=0.155u L=0.04u
M_U776/MI9-M_u3 U776/net40 U776/net106 U776/net104 VSS nch W=0.155u L=0.04u
M_U776/MI21 U776/net24 n750 U776/net050 VSS nch W=0.155u L=0.04u
M_U776/MI22 U776/net050 U776/net32 VSS VSS nch W=0.155u L=0.04u
M_U776/MI19-M_u2 U776/net20 U776/net40 VSS VSS nch W=0.155u L=0.04u
M_U776/MI13-M_u2 U776/net106 n753 VSS VSS nch W=0.155u L=0.04u
M_U776/MI14-M_u2 U776/net104 n752 VSS VSS nch W=0.155u L=0.04u
M_U776/M_u8-M_u2 U776/net30 n750 VSS VSS nch W=0.155u L=0.04u
M_U776/MI12-M_u2 U776/net108 U776/net104 VSS VSS nch W=0.155u L=0.04u
M_U776/MU20-M_u2 n748 U776/net28 VSS VSS nch W=0.155u L=0.04u
M_U776/MI1-M_u2 U776/net32 n751 VSS VSS nch W=0.155u L=0.04u
M_U776/MI16-M_u2 U776/net64 U776/net24 VSS VSS nch W=0.2u L=0.04u
M_U776/MI15-M_u2 U776/net28 U776/net40 U776/net64 VDD pch W=0.205u L=0.04u
M_U776/MI8-M_u2 U776/net24 n750 U776/net32 VDD pch W=0.205u L=0.04u
M_U776/MI17-M_u2 U776/net28 U776/net20 U776/net24 VDD pch W=0.205u L=0.04u
M_U776/MI11-M_u2 U776/net40 U776/net106 U776/net108 VDD pch W=0.205u L=0.04u
M_U776/MI9-M_u2 U776/net40 n753 U776/net104 VDD pch W=0.205u L=0.04u
M_U776/MI19-M_u3 U776/net20 U776/net40 VDD VDD pch W=0.205u L=0.04u
M_U776/MI13-M_u3 U776/net106 n753 VDD VDD pch W=0.205u L=0.04u
M_U776/MI14-M_u3 U776/net104 n752 VDD VDD pch W=0.205u L=0.04u
M_U776/M_u8-M_u3 U776/net30 n750 VDD VDD pch W=0.205u L=0.04u
M_U776/MI12-M_u3 U776/net108 U776/net104 VDD VDD pch W=0.205u L=0.04u
M_U776/MU20-M_u3 n748 U776/net28 VDD VDD pch W=0.205u L=0.04u
M_U776/MI1-M_u3 U776/net32 n751 VDD VDD pch W=0.205u L=0.04u
M_U776/MI16-M_u3 U776/net64 U776/net24 VDD VDD pch W=0.28u L=0.04u
M_U776/MI20 U776/net24 U776/net30 U776/net045 VDD pch W=0.205u L=0.04u
M_U776/M_u2 U776/net045 U776/net32 VDD VDD pch W=0.205u L=0.04u
M_U777/MI15 U777/net29 U777/net21 U777/net041 VSS nch W=0.155u L=0.04u
M_U777/MU63 U777/net035 U777/net19 VSS VSS nch W=0.155u L=0.04u
M_U777/MI14 U777/net041 U777/net13 VSS VSS nch W=0.155u L=0.04u
M_U777/MI42 U777/net25 n755 U777/net035 VSS nch W=0.155u L=0.04u
M_U777/M_u6-M_u3 U777/net19 U777/net17 U777/net25 VSS nch W=0.155u L=0.04u
M_U777/MU18-M_u3 U777/net13 U777/net25 U777/net29 VSS nch W=0.155u L=0.04u
M_U777/MI1-M_u2 n752 U777/net29 VSS VSS nch W=0.155u L=0.04u
M_U777/MI3-M_u2 U777/net13 n756 VSS VSS nch W=0.155u L=0.04u
M_U777/MI7-M_u2 U777/net17 n755 VSS VSS nch W=0.155u L=0.04u
M_U777/MI2-M_u2 U777/net19 n754 VSS VSS nch W=0.155u L=0.04u
M_U777/MI6-M_u2 U777/net21 U777/net25 VSS VSS nch W=0.155u L=0.04u
M_U777/MU62 U777/net028 U777/net19 VDD VDD pch W=0.205u L=0.04u
M_U777/MI8 U777/net25 U777/net17 U777/net028 VDD pch W=0.205u L=0.04u
M_U777/MI12 U777/net29 U777/net25 U777/net029 VDD pch W=0.205u L=0.04u
M_U777/MI13 U777/net029 U777/net13 VDD VDD pch W=0.205u L=0.04u
M_U777/M_u6-M_u2 U777/net19 n755 U777/net25 VDD pch W=0.205u L=0.04u
M_U777/MU18-M_u2 U777/net13 U777/net21 U777/net29 VDD pch W=0.205u L=0.04u
M_U777/MI1-M_u3 n752 U777/net29 VDD VDD pch W=0.205u L=0.04u
M_U777/MI3-M_u3 U777/net13 n756 VDD VDD pch W=0.205u L=0.04u
M_U777/MI7-M_u3 U777/net17 n755 VDD VDD pch W=0.205u L=0.04u
M_U777/MI2-M_u3 U777/net19 n754 VDD VDD pch W=0.205u L=0.04u
M_U777/MI6-M_u3 U777/net21 U777/net25 VDD VDD pch W=0.205u L=0.04u
M_U778/MI15-M_u3 U778/net28 U778/net20 U778/net64 VSS nch W=0.155u L=0.04u
M_U778/MI8-M_u3 U778/net24 U778/net30 U778/net32 VSS nch W=0.155u L=0.04u
M_U778/MI17-M_u3 U778/net28 U778/net40 U778/net24 VSS nch W=0.155u L=0.04u
M_U778/MI11-M_u3 U778/net40 n753 U778/net108 VSS nch W=0.155u L=0.04u
M_U778/MI9-M_u3 U778/net40 U778/net106 U778/net104 VSS nch W=0.155u L=0.04u
M_U778/MI21 U778/net24 n757 U778/net050 VSS nch W=0.155u L=0.04u
M_U778/MI22 U778/net050 U778/net32 VSS VSS nch W=0.155u L=0.04u
M_U778/MI19-M_u2 U778/net20 U778/net40 VSS VSS nch W=0.155u L=0.04u
M_U778/MI13-M_u2 U778/net106 n753 VSS VSS nch W=0.155u L=0.04u
M_U778/MI14-M_u2 U778/net104 n759 VSS VSS nch W=0.155u L=0.04u
M_U778/M_u8-M_u2 U778/net30 n757 VSS VSS nch W=0.155u L=0.04u
M_U778/MI12-M_u2 U778/net108 U778/net104 VSS VSS nch W=0.155u L=0.04u
M_U778/MU20-M_u2 n747 U778/net28 VSS VSS nch W=0.155u L=0.04u
M_U778/MI1-M_u2 U778/net32 n758 VSS VSS nch W=0.155u L=0.04u
M_U778/MI16-M_u2 U778/net64 U778/net24 VSS VSS nch W=0.2u L=0.04u
M_U778/MI15-M_u2 U778/net28 U778/net40 U778/net64 VDD pch W=0.205u L=0.04u
M_U778/MI8-M_u2 U778/net24 n757 U778/net32 VDD pch W=0.205u L=0.04u
M_U778/MI17-M_u2 U778/net28 U778/net20 U778/net24 VDD pch W=0.205u L=0.04u
M_U778/MI11-M_u2 U778/net40 U778/net106 U778/net108 VDD pch W=0.205u L=0.04u
M_U778/MI9-M_u2 U778/net40 n753 U778/net104 VDD pch W=0.205u L=0.04u
M_U778/MI19-M_u3 U778/net20 U778/net40 VDD VDD pch W=0.205u L=0.04u
M_U778/MI13-M_u3 U778/net106 n753 VDD VDD pch W=0.205u L=0.04u
M_U778/MI14-M_u3 U778/net104 n759 VDD VDD pch W=0.205u L=0.04u
M_U778/M_u8-M_u3 U778/net30 n757 VDD VDD pch W=0.205u L=0.04u
M_U778/MI12-M_u3 U778/net108 U778/net104 VDD VDD pch W=0.205u L=0.04u
M_U778/MU20-M_u3 n747 U778/net28 VDD VDD pch W=0.205u L=0.04u
M_U778/MI1-M_u3 U778/net32 n758 VDD VDD pch W=0.205u L=0.04u
M_U778/MI16-M_u3 U778/net64 U778/net24 VDD VDD pch W=0.28u L=0.04u
M_U778/MI20 U778/net24 U778/net30 U778/net045 VDD pch W=0.205u L=0.04u
M_U778/M_u2 U778/net045 U778/net32 VDD VDD pch W=0.205u L=0.04u
M_U779/MI15-M_u2 U779/net19 N367 VSS VSS nch W=0.155u L=0.04u
M_U779/MI21 n753 N367 U779/net40 VSS nch W=0.155u L=0.04u
M_U779/MI12 n753 U779/net19 U779/net36 VSS nch W=0.155u L=0.04u
M_U779/MI20 U779/net40 n761 VSS VSS nch W=0.31u L=0.04u
M_U779/MI19 U779/net36 n760 VSS VSS nch W=0.155u L=0.04u
M_U779/MI15-M_u3 U779/net19 N367 VDD VDD pch W=0.205u L=0.04u
M_U779/MI25 n753 U779/net19 U779/net26 VDD pch W=0.325u L=0.04u
M_U779/MI24 U779/net26 n761 VDD VDD pch W=0.41u L=0.04u
M_U779/MI5 n753 N367 U779/net30 VDD pch W=0.325u L=0.04u
M_U779/MI111 U779/net30 n760 VDD VDD pch W=0.205u L=0.04u
M_U780/MI15 U780/net29 U780/net21 U780/net041 VSS nch W=0.155u L=0.04u
M_U780/MU63 U780/net035 U780/net19 VSS VSS nch W=0.155u L=0.04u
M_U780/MI14 U780/net041 U780/net13 VSS VSS nch W=0.155u L=0.04u
M_U780/MI42 U780/net25 n763 U780/net035 VSS nch W=0.155u L=0.04u
M_U780/M_u6-M_u3 U780/net19 U780/net17 U780/net25 VSS nch W=0.155u L=0.04u
M_U780/MU18-M_u3 U780/net13 U780/net25 U780/net29 VSS nch W=0.155u L=0.04u
M_U780/MI1-M_u2 n761 U780/net29 VSS VSS nch W=0.155u L=0.04u
M_U780/MI3-M_u2 U780/net13 n764 VSS VSS nch W=0.155u L=0.04u
M_U780/MI7-M_u2 U780/net17 n763 VSS VSS nch W=0.155u L=0.04u
M_U780/MI2-M_u2 U780/net19 n762 VSS VSS nch W=0.155u L=0.04u
M_U780/MI6-M_u2 U780/net21 U780/net25 VSS VSS nch W=0.155u L=0.04u
M_U780/MU62 U780/net028 U780/net19 VDD VDD pch W=0.205u L=0.04u
M_U780/MI8 U780/net25 U780/net17 U780/net028 VDD pch W=0.205u L=0.04u
M_U780/MI12 U780/net29 U780/net25 U780/net029 VDD pch W=0.205u L=0.04u
M_U780/MI13 U780/net029 U780/net13 VDD VDD pch W=0.205u L=0.04u
M_U780/M_u6-M_u2 U780/net19 n763 U780/net25 VDD pch W=0.205u L=0.04u
M_U780/MU18-M_u2 U780/net13 U780/net21 U780/net29 VDD pch W=0.205u L=0.04u
M_U780/MI1-M_u3 n761 U780/net29 VDD VDD pch W=0.205u L=0.04u
M_U780/MI3-M_u3 U780/net13 n764 VDD VDD pch W=0.205u L=0.04u
M_U780/MI7-M_u3 U780/net17 n763 VDD VDD pch W=0.205u L=0.04u
M_U780/MI2-M_u3 U780/net19 n762 VDD VDD pch W=0.205u L=0.04u
M_U780/MI6-M_u3 U780/net21 U780/net25 VDD VDD pch W=0.205u L=0.04u
M_U781/MU18-M_u2 U781/net24 n768 VSS VSS nch W=0.155u L=0.04u
M_U781/MI47-M_u2 U781/net74 n766 VSS VSS nch W=0.155u L=0.04u
M_U781/MI55-M_u2 U781/net72 n765 VSS VSS nch W=0.155u L=0.04u
M_U781/MI57-M_u2 U781/net76 n765 VSS VSS nch W=0.31u L=0.04u
M_U781/MI58-M_u2 U781/net044 n767 VSS VSS nch W=0.155u L=0.04u
M_U781/MI56-M_u2 U781/net052 n766 VSS VSS nch W=0.31u L=0.04u
M_U781/MI51-M_u3 U781/PG2 n768 n764 VSS nch W=0.22u L=0.04u
M_U781/MI52-M_u3 U781/net74 U781/net044 U781/PG2 VSS nch W=0.12u L=0.04u
M_U781/MI49-M_u3 U781/net052 n767 U781/PG1 VSS nch W=0.155u L=0.04u
M_U781/MI50-M_u3 U781/PG1 U781/net24 n764 VSS nch W=0.155u L=0.04u
M_U781/MI54-M_u3 U781/net76 n767 U781/PG2 VSS nch W=0.155u L=0.04u
M_U781/MI48-M_u3 U781/net72 U781/net044 U781/PG1 VSS nch W=0.12u L=0.04u
M_U781/MU18-M_u3 U781/net24 n768 VDD VDD pch W=0.205u L=0.04u
M_U781/MI47-M_u3 U781/net74 n766 VDD VDD pch W=0.205u L=0.04u
M_U781/MI55-M_u3 U781/net72 n765 VDD VDD pch W=0.205u L=0.04u
M_U781/MI57-M_u3 U781/net76 n765 VDD VDD pch W=0.41u L=0.04u
M_U781/MI58-M_u3 U781/net044 n767 VDD VDD pch W=0.205u L=0.04u
M_U781/MI56-M_u3 U781/net052 n766 VDD VDD pch W=0.41u L=0.04u
M_U781/MI51-M_u2 U781/PG2 U781/net24 n764 VDD pch W=0.205u L=0.04u
M_U781/MI52-M_u2 U781/net74 n767 U781/PG2 VDD pch W=0.205u L=0.04u
M_U781/MI49-M_u2 U781/net052 U781/net044 U781/PG1 VDD pch W=0.205u L=0.04u
M_U781/MI50-M_u2 U781/PG1 n768 n764 VDD pch W=0.29u L=0.04u
M_U781/MI54-M_u2 U781/net76 U781/net044 U781/PG2 VDD pch W=0.205u L=0.04u
M_U781/MI48-M_u2 U781/net72 n767 U781/PG1 VDD pch W=0.205u L=0.04u
M_U782/MI15 U782/net29 U782/net21 U782/net041 VSS nch W=0.155u L=0.04u
M_U782/MU63 U782/net035 U782/net19 VSS VSS nch W=0.155u L=0.04u
M_U782/MI14 U782/net041 U782/net13 VSS VSS nch W=0.155u L=0.04u
M_U782/MI42 U782/net25 n770 U782/net035 VSS nch W=0.155u L=0.04u
M_U782/M_u6-M_u3 U782/net19 U782/net17 U782/net25 VSS nch W=0.155u L=0.04u
M_U782/MU18-M_u3 U782/net13 U782/net25 U782/net29 VSS nch W=0.155u L=0.04u
M_U782/MI1-M_u2 n768 U782/net29 VSS VSS nch W=0.155u L=0.04u
M_U782/MI3-M_u2 U782/net13 n771 VSS VSS nch W=0.155u L=0.04u
M_U782/MI7-M_u2 U782/net17 n770 VSS VSS nch W=0.155u L=0.04u
M_U782/MI2-M_u2 U782/net19 n769 VSS VSS nch W=0.155u L=0.04u
M_U782/MI6-M_u2 U782/net21 U782/net25 VSS VSS nch W=0.155u L=0.04u
M_U782/MU62 U782/net028 U782/net19 VDD VDD pch W=0.205u L=0.04u
M_U782/MI8 U782/net25 U782/net17 U782/net028 VDD pch W=0.205u L=0.04u
M_U782/MI12 U782/net29 U782/net25 U782/net029 VDD pch W=0.205u L=0.04u
M_U782/MI13 U782/net029 U782/net13 VDD VDD pch W=0.205u L=0.04u
M_U782/M_u6-M_u2 U782/net19 n770 U782/net25 VDD pch W=0.205u L=0.04u
M_U782/MU18-M_u2 U782/net13 U782/net21 U782/net29 VDD pch W=0.205u L=0.04u
M_U782/MI1-M_u3 n768 U782/net29 VDD VDD pch W=0.205u L=0.04u
M_U782/MI3-M_u3 U782/net13 n771 VDD VDD pch W=0.205u L=0.04u
M_U782/MI7-M_u3 U782/net17 n770 VDD VDD pch W=0.205u L=0.04u
M_U782/MI2-M_u3 U782/net19 n769 VDD VDD pch W=0.205u L=0.04u
M_U782/MI6-M_u3 U782/net21 U782/net25 VDD VDD pch W=0.205u L=0.04u
M_U783/MI1-M_u4 n771 n772 VSS VSS nch W=0.155u L=0.04u
M_U783/MI1-M_u3 n771 n773 VSS VSS nch W=0.155u L=0.04u
M_U783/MI1-M_u1 U783/XI1-net8 n773 VDD VDD pch W=0.205u L=0.04u
M_U783/MI1-M_u2 n771 n772 U783/XI1-net8 VDD pch W=0.205u L=0.04u
M_U784/MI2 n770 n772 U784/net27 VSS nch W=0.155u L=0.04u
M_U784/MI10 U784/net27 n774 VSS VSS nch W=0.155u L=0.04u
M_U784/MI11 n770 n775 VSS VSS nch W=0.155u L=0.04u
M_U784/MI8 n770 n774 U784/net13 VDD pch W=0.205u L=0.04u
M_U784/M_u2 U784/net13 n775 VDD VDD pch W=0.205u L=0.04u
M_U784/MI9 n770 n772 U784/net13 VDD pch W=0.205u L=0.04u
M_U785/MI2 n762 n776 U785/net27 VSS nch W=0.155u L=0.04u
M_U785/MI10 U785/net27 n772 VSS VSS nch W=0.155u L=0.04u
M_U785/MI11 n762 n777 VSS VSS nch W=0.155u L=0.04u
M_U785/MI8 n762 n772 U785/net13 VDD pch W=0.205u L=0.04u
M_U785/M_u2 U785/net13 n777 VDD VDD pch W=0.205u L=0.04u
M_U785/MI9 n762 n776 U785/net13 VDD pch W=0.205u L=0.04u
M_U786/MI15 U786/net29 U786/net21 U786/net041 VSS nch W=0.155u L=0.04u
M_U786/MU63 U786/net035 U786/net19 VSS VSS nch W=0.155u L=0.04u
M_U786/MI14 U786/net041 U786/net13 VSS VSS nch W=0.155u L=0.04u
M_U786/MI42 U786/net25 n763 U786/net035 VSS nch W=0.155u L=0.04u
M_U786/M_u6-M_u3 U786/net19 U786/net17 U786/net25 VSS nch W=0.155u L=0.04u
M_U786/MU18-M_u3 U786/net13 U786/net25 U786/net29 VSS nch W=0.155u L=0.04u
M_U786/MI1-M_u2 n760 U786/net29 VSS VSS nch W=0.155u L=0.04u
M_U786/MI3-M_u2 U786/net13 n779 VSS VSS nch W=0.155u L=0.04u
M_U786/MI7-M_u2 U786/net17 n763 VSS VSS nch W=0.155u L=0.04u
M_U786/MI2-M_u2 U786/net19 n778 VSS VSS nch W=0.155u L=0.04u
M_U786/MI6-M_u2 U786/net21 U786/net25 VSS VSS nch W=0.155u L=0.04u
M_U786/MU62 U786/net028 U786/net19 VDD VDD pch W=0.205u L=0.04u
M_U786/MI8 U786/net25 U786/net17 U786/net028 VDD pch W=0.205u L=0.04u
M_U786/MI12 U786/net29 U786/net25 U786/net029 VDD pch W=0.205u L=0.04u
M_U786/MI13 U786/net029 U786/net13 VDD VDD pch W=0.205u L=0.04u
M_U786/M_u6-M_u2 U786/net19 n763 U786/net25 VDD pch W=0.205u L=0.04u
M_U786/MU18-M_u2 U786/net13 U786/net21 U786/net29 VDD pch W=0.205u L=0.04u
M_U786/MI1-M_u3 n760 U786/net29 VDD VDD pch W=0.205u L=0.04u
M_U786/MI3-M_u3 U786/net13 n779 VDD VDD pch W=0.205u L=0.04u
M_U786/MI7-M_u3 U786/net17 n763 VDD VDD pch W=0.205u L=0.04u
M_U786/MI2-M_u3 U786/net19 n778 VDD VDD pch W=0.205u L=0.04u
M_U786/MI6-M_u3 U786/net21 U786/net25 VDD VDD pch W=0.205u L=0.04u
M_U787/MU18-M_u2 U787/net24 n781 VSS VSS nch W=0.155u L=0.04u
M_U787/MI47-M_u2 U787/net74 n766 VSS VSS nch W=0.155u L=0.04u
M_U787/MI55-M_u2 U787/net72 n765 VSS VSS nch W=0.155u L=0.04u
M_U787/MI57-M_u2 U787/net76 n765 VSS VSS nch W=0.31u L=0.04u
M_U787/MI58-M_u2 U787/net044 n780 VSS VSS nch W=0.155u L=0.04u
M_U787/MI56-M_u2 U787/net052 n766 VSS VSS nch W=0.31u L=0.04u
M_U787/MI51-M_u3 U787/PG2 n781 n779 VSS nch W=0.22u L=0.04u
M_U787/MI52-M_u3 U787/net74 U787/net044 U787/PG2 VSS nch W=0.12u L=0.04u
M_U787/MI49-M_u3 U787/net052 n780 U787/PG1 VSS nch W=0.155u L=0.04u
M_U787/MI50-M_u3 U787/PG1 U787/net24 n779 VSS nch W=0.155u L=0.04u
M_U787/MI54-M_u3 U787/net76 n780 U787/PG2 VSS nch W=0.155u L=0.04u
M_U787/MI48-M_u3 U787/net72 U787/net044 U787/PG1 VSS nch W=0.12u L=0.04u
M_U787/MU18-M_u3 U787/net24 n781 VDD VDD pch W=0.205u L=0.04u
M_U787/MI47-M_u3 U787/net74 n766 VDD VDD pch W=0.205u L=0.04u
M_U787/MI55-M_u3 U787/net72 n765 VDD VDD pch W=0.205u L=0.04u
M_U787/MI57-M_u3 U787/net76 n765 VDD VDD pch W=0.41u L=0.04u
M_U787/MI58-M_u3 U787/net044 n780 VDD VDD pch W=0.205u L=0.04u
M_U787/MI56-M_u3 U787/net052 n766 VDD VDD pch W=0.41u L=0.04u
M_U787/MI51-M_u2 U787/PG2 U787/net24 n779 VDD pch W=0.205u L=0.04u
M_U787/MI52-M_u2 U787/net74 n780 U787/PG2 VDD pch W=0.205u L=0.04u
M_U787/MI49-M_u2 U787/net052 U787/net044 U787/PG1 VDD pch W=0.205u L=0.04u
M_U787/MI50-M_u2 U787/PG1 n781 n779 VDD pch W=0.29u L=0.04u
M_U787/MI54-M_u2 U787/net76 U787/net044 U787/PG2 VDD pch W=0.205u L=0.04u
M_U787/MI48-M_u2 U787/net72 n780 U787/PG1 VDD pch W=0.205u L=0.04u
M_U788/M_u4 n781 n784 VSS VSS nch W=0.155u L=0.04u
M_U788/MI2 n781 n783 VSS VSS nch W=0.155u L=0.04u
M_U788/MI3 n781 n782 VSS VSS nch W=0.155u L=0.04u
M_U788/M_u1 U788/net25 n784 VDD VDD pch W=0.41u L=0.04u
M_U788/MI0 U788/net28 n783 U788/net25 VDD pch W=0.41u L=0.04u
M_U788/MI1 n781 n782 U788/net28 VDD pch W=0.41u L=0.04u
M_U789/MI9 n782 n785 U789/net10 VSS nch W=0.155u L=0.04u
M_U789/M_u4 U789/net10 n788 VSS VSS nch W=0.155u L=0.04u
M_U789/MI8 n782 n786 U789/net10 VSS nch W=0.155u L=0.04u
M_U789/MI7 U789/net10 n787 VSS VSS nch W=0.155u L=0.04u
M_U789/MU24 U789/net30 n788 VDD VDD pch W=0.205u L=0.04u
M_U789/MI6 n782 n785 U789/net24 VDD pch W=0.205u L=0.04u
M_U789/MI5 U789/net24 n786 VDD VDD pch W=0.205u L=0.04u
M_U789/MI4 n782 n787 U789/net30 VDD pch W=0.205u L=0.04u
M_U790/MI0-M_u3 U790/net4 n789 U790/net14 VSS nch W=0.155u L=0.04u
M_U790/M_u7-M_u3 U790/net6 U790/net10 U790/net14 VSS nch W=0.17u L=0.04u
M_U790/M_u2-M_u2 U790/net4 n790 VSS VSS nch W=0.155u L=0.04u
M_U790/M_u5-M_u2 U790/net6 U790/net4 VSS VSS nch W=0.17u L=0.04u
M_U790/M_u4-M_u2 n766 U790/net14 VSS VSS nch W=0.155u L=0.04u
M_U790/M_u8-M_u2 U790/net10 n789 VSS VSS nch W=0.155u L=0.04u
M_U790/MI0-M_u2 U790/net4 U790/net10 U790/net14 VDD pch W=0.255u L=0.04u
M_U790/M_u7-M_u2 U790/net6 n789 U790/net14 VDD pch W=0.28u L=0.04u
M_U790/M_u2-M_u3 U790/net4 n790 VDD VDD pch W=0.205u L=0.04u
M_U790/M_u5-M_u3 U790/net6 U790/net4 VDD VDD pch W=0.24u L=0.04u
M_U790/M_u4-M_u3 n766 U790/net14 VDD VDD pch W=0.205u L=0.04u
M_U790/M_u8-M_u3 U790/net10 n789 VDD VDD pch W=0.205u L=0.04u
M_U791/MI12 U791/net32 n789 VSS VSS nch W=0.155u L=0.04u
M_U791/MI11 U791/net59 n791 U791/net32 VSS nch W=0.155u L=0.04u
M_U791/MI6 U791/net59 n772 VSS VSS nch W=0.155u L=0.04u
M_U791/MI8-M_u2 n765 U791/net59 VSS VSS nch W=0.155u L=0.04u
M_U791/MI8-M_u3 n765 U791/net59 VDD VDD pch W=0.2u L=0.04u
M_U791/MI10 U791/net59 n791 U791/net22 VDD pch W=0.205u L=0.04u
M_U791/MI9 U791/net59 n789 U791/net22 VDD pch W=0.205u L=0.04u
M_U791/M_u2 U791/net22 n772 VDD VDD pch W=0.2u L=0.04u
M_U792/M_u6-M_u3 U792/net4 U792/net10 U792/net14 VSS nch W=0.155u L=0.04u
M_U792/MI3-M_u3 U792/net6 n774 U792/net14 VSS nch W=0.155u L=0.04u
M_U792/MI1-M_u2 U792/net4 n792 VSS VSS nch W=0.155u L=0.04u
M_U792/M_u5-M_u2 U792/net6 U792/net4 VSS VSS nch W=0.155u L=0.04u
M_U792/M_u4-M_u2 n763 U792/net14 VSS VSS nch W=0.155u L=0.04u
M_U792/MI2-M_u2 U792/net10 n774 VSS VSS nch W=0.155u L=0.04u
M_U792/M_u6-M_u2 U792/net4 n774 U792/net14 VDD pch W=0.205u L=0.04u
M_U792/MI3-M_u2 U792/net6 U792/net10 U792/net14 VDD pch W=0.205u L=0.04u
M_U792/MI1-M_u3 U792/net4 n792 VDD VDD pch W=0.205u L=0.04u
M_U792/M_u5-M_u3 U792/net6 U792/net4 VDD VDD pch W=0.205u L=0.04u
M_U792/M_u4-M_u3 n763 U792/net14 VDD VDD pch W=0.205u L=0.04u
M_U792/MI2-M_u3 U792/net10 n774 VDD VDD pch W=0.205u L=0.04u
M_U793/MI15 U793/net29 U793/net21 U793/net041 VSS nch W=0.155u L=0.04u
M_U793/MU63 U793/net035 U793/net19 VSS VSS nch W=0.155u L=0.04u
M_U793/MI14 U793/net041 U793/net13 VSS VSS nch W=0.155u L=0.04u
M_U793/MI42 U793/net25 n775 U793/net035 VSS nch W=0.155u L=0.04u
M_U793/M_u6-M_u3 U793/net19 U793/net17 U793/net25 VSS nch W=0.155u L=0.04u
M_U793/MU18-M_u3 U793/net13 U793/net25 U793/net29 VSS nch W=0.155u L=0.04u
M_U793/MI1-M_u2 n778 U793/net29 VSS VSS nch W=0.155u L=0.04u
M_U793/MI3-M_u2 U793/net13 n767 VSS VSS nch W=0.155u L=0.04u
M_U793/MI7-M_u2 U793/net17 n775 VSS VSS nch W=0.155u L=0.04u
M_U793/MI2-M_u2 U793/net19 n773 VSS VSS nch W=0.155u L=0.04u
M_U793/MI6-M_u2 U793/net21 U793/net25 VSS VSS nch W=0.155u L=0.04u
M_U793/MU62 U793/net028 U793/net19 VDD VDD pch W=0.205u L=0.04u
M_U793/MI8 U793/net25 U793/net17 U793/net028 VDD pch W=0.205u L=0.04u
M_U793/MI12 U793/net29 U793/net25 U793/net029 VDD pch W=0.205u L=0.04u
M_U793/MI13 U793/net029 U793/net13 VDD VDD pch W=0.205u L=0.04u
M_U793/M_u6-M_u2 U793/net19 n775 U793/net25 VDD pch W=0.205u L=0.04u
M_U793/MU18-M_u2 U793/net13 U793/net21 U793/net29 VDD pch W=0.205u L=0.04u
M_U793/MI1-M_u3 n778 U793/net29 VDD VDD pch W=0.205u L=0.04u
M_U793/MI3-M_u3 U793/net13 n767 VDD VDD pch W=0.205u L=0.04u
M_U793/MI7-M_u3 U793/net17 n775 VDD VDD pch W=0.205u L=0.04u
M_U793/MI2-M_u3 U793/net19 n773 VDD VDD pch W=0.205u L=0.04u
M_U793/MI6-M_u3 U793/net21 U793/net25 VDD VDD pch W=0.205u L=0.04u
M_U794/MI15 U794/net29 U794/net21 U794/net041 VSS nch W=0.155u L=0.04u
M_U794/MU63 U794/net035 U794/net19 VSS VSS nch W=0.155u L=0.04u
M_U794/MI14 U794/net041 U794/net13 VSS VSS nch W=0.155u L=0.04u
M_U794/MI42 U794/net25 n793 U794/net035 VSS nch W=0.155u L=0.04u
M_U794/M_u6-M_u3 U794/net19 U794/net17 U794/net25 VSS nch W=0.155u L=0.04u
M_U794/MU18-M_u3 U794/net13 U794/net25 U794/net29 VSS nch W=0.155u L=0.04u
M_U794/MI1-M_u2 n759 U794/net29 VSS VSS nch W=0.155u L=0.04u
M_U794/MI3-M_u2 U794/net13 n794 VSS VSS nch W=0.155u L=0.04u
M_U794/MI7-M_u2 U794/net17 n793 VSS VSS nch W=0.155u L=0.04u
M_U794/MI2-M_u2 U794/net19 n755 VSS VSS nch W=0.155u L=0.04u
M_U794/MI6-M_u2 U794/net21 U794/net25 VSS VSS nch W=0.155u L=0.04u
M_U794/MU62 U794/net028 U794/net19 VDD VDD pch W=0.205u L=0.04u
M_U794/MI8 U794/net25 U794/net17 U794/net028 VDD pch W=0.205u L=0.04u
M_U794/MI12 U794/net29 U794/net25 U794/net029 VDD pch W=0.205u L=0.04u
M_U794/MI13 U794/net029 U794/net13 VDD VDD pch W=0.205u L=0.04u
M_U794/M_u6-M_u2 U794/net19 n793 U794/net25 VDD pch W=0.205u L=0.04u
M_U794/MU18-M_u2 U794/net13 U794/net21 U794/net29 VDD pch W=0.205u L=0.04u
M_U794/MI1-M_u3 n759 U794/net29 VDD VDD pch W=0.205u L=0.04u
M_U794/MI3-M_u3 U794/net13 n794 VDD VDD pch W=0.205u L=0.04u
M_U794/MI7-M_u3 U794/net17 n793 VDD VDD pch W=0.205u L=0.04u
M_U794/MI2-M_u3 U794/net19 n755 VDD VDD pch W=0.205u L=0.04u
M_U794/MI6-M_u3 U794/net21 U794/net25 VDD VDD pch W=0.205u L=0.04u
M_U795/MI15-M_u2 U795/net19 n796 VSS VSS nch W=0.155u L=0.04u
M_U795/MI21 n758 n796 U795/net40 VSS nch W=0.155u L=0.04u
M_U795/MI12 n758 U795/net19 U795/net36 VSS nch W=0.155u L=0.04u
M_U795/MI20 U795/net40 n756 VSS VSS nch W=0.31u L=0.04u
M_U795/MI19 U795/net36 n795 VSS VSS nch W=0.155u L=0.04u
M_U795/MI15-M_u3 U795/net19 n796 VDD VDD pch W=0.205u L=0.04u
M_U795/MI25 n758 U795/net19 U795/net26 VDD pch W=0.325u L=0.04u
M_U795/MI24 U795/net26 n756 VDD VDD pch W=0.41u L=0.04u
M_U795/MI5 n758 n796 U795/net30 VDD pch W=0.325u L=0.04u
M_U795/MI111 U795/net30 n795 VDD VDD pch W=0.205u L=0.04u
M_U796/M_u2 n757 n750 VSS VSS nch W=0.135u L=0.04u
M_U796/M_u1 n757 n750 VDD VDD pch W=0.205u L=0.04u
M_U797/M_u6-M_u3 U797/net4 U797/net10 U797/net14 VSS nch W=0.155u L=0.04u
M_U797/MI3-M_u3 U797/net6 n797 U797/net14 VSS nch W=0.155u L=0.04u
M_U797/MI1-M_u2 U797/net4 n798 VSS VSS nch W=0.155u L=0.04u
M_U797/M_u5-M_u2 U797/net6 U797/net4 VSS VSS nch W=0.155u L=0.04u
M_U797/M_u4-M_u2 n750 U797/net14 VSS VSS nch W=0.155u L=0.04u
M_U797/MI2-M_u2 U797/net10 n797 VSS VSS nch W=0.155u L=0.04u
M_U797/M_u6-M_u2 U797/net4 n797 U797/net14 VDD pch W=0.205u L=0.04u
M_U797/MI3-M_u2 U797/net6 U797/net10 U797/net14 VDD pch W=0.205u L=0.04u
M_U797/MI1-M_u3 U797/net4 n798 VDD VDD pch W=0.205u L=0.04u
M_U797/M_u5-M_u3 U797/net6 U797/net4 VDD VDD pch W=0.205u L=0.04u
M_U797/M_u4-M_u3 n750 U797/net14 VDD VDD pch W=0.205u L=0.04u
M_U797/MI2-M_u3 U797/net10 n797 VDD VDD pch W=0.205u L=0.04u
M_U798/MI15-M_u2 U798/net19 n801 VSS VSS nch W=0.155u L=0.04u
M_U798/MI21 N1394 n801 U798/net40 VSS nch W=0.155u L=0.04u
M_U798/MI12 N1394 U798/net19 U798/net36 VSS nch W=0.155u L=0.04u
M_U798/MI20 U798/net40 n800 VSS VSS nch W=0.31u L=0.04u
M_U798/MI19 U798/net36 n799 VSS VSS nch W=0.155u L=0.04u
M_U798/MI15-M_u3 U798/net19 n801 VDD VDD pch W=0.205u L=0.04u
M_U798/MI25 N1394 U798/net19 U798/net26 VDD pch W=0.325u L=0.04u
M_U798/MI24 U798/net26 n800 VDD VDD pch W=0.41u L=0.04u
M_U798/MI5 N1394 n801 U798/net30 VDD pch W=0.325u L=0.04u
M_U798/MI111 U798/net30 n799 VDD VDD pch W=0.205u L=0.04u
M_U799/MI2 n801 n802 U799/net27 VSS nch W=0.155u L=0.04u
M_U799/MI10 U799/net27 n803 VSS VSS nch W=0.155u L=0.04u
M_U799/MI11 n801 n804 VSS VSS nch W=0.155u L=0.04u
M_U799/MI8 n801 n803 U799/net13 VDD pch W=0.205u L=0.04u
M_U799/M_u2 U799/net13 n804 VDD VDD pch W=0.205u L=0.04u
M_U799/MI9 n801 n802 U799/net13 VDD pch W=0.205u L=0.04u
M_U800/MI15-M_u3 U800/net28 U800/net20 U800/net64 VSS nch W=0.155u L=0.04u
M_U800/MI8-M_u3 U800/net24 U800/net30 U800/net32 VSS nch W=0.155u L=0.04u
M_U800/MI17-M_u3 U800/net28 U800/net40 U800/net24 VSS nch W=0.155u L=0.04u
M_U800/MI11-M_u3 U800/net40 n808 U800/net108 VSS nch W=0.155u L=0.04u
M_U800/MI9-M_u3 U800/net40 U800/net106 U800/net104 VSS nch W=0.155u L=0.04u
M_U800/MI21 U800/net24 n805 U800/net050 VSS nch W=0.155u L=0.04u
M_U800/MI22 U800/net050 U800/net32 VSS VSS nch W=0.155u L=0.04u
M_U800/MI19-M_u2 U800/net20 U800/net40 VSS VSS nch W=0.155u L=0.04u
M_U800/MI13-M_u2 U800/net106 n808 VSS VSS nch W=0.155u L=0.04u
M_U800/MI14-M_u2 U800/net104 n807 VSS VSS nch W=0.155u L=0.04u
M_U800/M_u8-M_u2 U800/net30 n805 VSS VSS nch W=0.155u L=0.04u
M_U800/MI12-M_u2 U800/net108 U800/net104 VSS VSS nch W=0.155u L=0.04u
M_U800/MU20-M_u2 n800 U800/net28 VSS VSS nch W=0.155u L=0.04u
M_U800/MI1-M_u2 U800/net32 n806 VSS VSS nch W=0.155u L=0.04u
M_U800/MI16-M_u2 U800/net64 U800/net24 VSS VSS nch W=0.2u L=0.04u
M_U800/MI15-M_u2 U800/net28 U800/net40 U800/net64 VDD pch W=0.205u L=0.04u
M_U800/MI8-M_u2 U800/net24 n805 U800/net32 VDD pch W=0.205u L=0.04u
M_U800/MI17-M_u2 U800/net28 U800/net20 U800/net24 VDD pch W=0.205u L=0.04u
M_U800/MI11-M_u2 U800/net40 U800/net106 U800/net108 VDD pch W=0.205u L=0.04u
M_U800/MI9-M_u2 U800/net40 n808 U800/net104 VDD pch W=0.205u L=0.04u
M_U800/MI19-M_u3 U800/net20 U800/net40 VDD VDD pch W=0.205u L=0.04u
M_U800/MI13-M_u3 U800/net106 n808 VDD VDD pch W=0.205u L=0.04u
M_U800/MI14-M_u3 U800/net104 n807 VDD VDD pch W=0.205u L=0.04u
M_U800/M_u8-M_u3 U800/net30 n805 VDD VDD pch W=0.205u L=0.04u
M_U800/MI12-M_u3 U800/net108 U800/net104 VDD VDD pch W=0.205u L=0.04u
M_U800/MU20-M_u3 n800 U800/net28 VDD VDD pch W=0.205u L=0.04u
M_U800/MI1-M_u3 U800/net32 n806 VDD VDD pch W=0.205u L=0.04u
M_U800/MI16-M_u3 U800/net64 U800/net24 VDD VDD pch W=0.28u L=0.04u
M_U800/MI20 U800/net24 U800/net30 U800/net045 VDD pch W=0.205u L=0.04u
M_U800/M_u2 U800/net045 U800/net32 VDD VDD pch W=0.205u L=0.04u
M_U801/MI15-M_u2 U801/net19 n811 VSS VSS nch W=0.155u L=0.04u
M_U801/MI21 n806 n811 U801/net40 VSS nch W=0.155u L=0.04u
M_U801/MI12 n806 U801/net19 U801/net36 VSS nch W=0.155u L=0.04u
M_U801/MI20 U801/net40 n810 VSS VSS nch W=0.31u L=0.04u
M_U801/MI19 U801/net36 n809 VSS VSS nch W=0.155u L=0.04u
M_U801/MI15-M_u3 U801/net19 n811 VDD VDD pch W=0.205u L=0.04u
M_U801/MI25 n806 U801/net19 U801/net26 VDD pch W=0.325u L=0.04u
M_U801/MI24 U801/net26 n810 VDD VDD pch W=0.41u L=0.04u
M_U801/MI5 n806 n811 U801/net30 VDD pch W=0.325u L=0.04u
M_U801/MI111 U801/net30 n809 VDD VDD pch W=0.205u L=0.04u
M_U802/M_u6-M_u3 U802/net4 U802/net10 U802/net14 VSS nch W=0.155u L=0.04u
M_U802/MI3-M_u3 U802/net6 n812 U802/net14 VSS nch W=0.155u L=0.04u
M_U802/MI1-M_u2 U802/net4 n813 VSS VSS nch W=0.155u L=0.04u
M_U802/M_u5-M_u2 U802/net6 U802/net4 VSS VSS nch W=0.155u L=0.04u
M_U802/M_u4-M_u2 n810 U802/net14 VSS VSS nch W=0.155u L=0.04u
M_U802/MI2-M_u2 U802/net10 n812 VSS VSS nch W=0.155u L=0.04u
M_U802/M_u6-M_u2 U802/net4 n812 U802/net14 VDD pch W=0.205u L=0.04u
M_U802/MI3-M_u2 U802/net6 U802/net10 U802/net14 VDD pch W=0.205u L=0.04u
M_U802/MI1-M_u3 U802/net4 n813 VDD VDD pch W=0.205u L=0.04u
M_U802/M_u5-M_u3 U802/net6 U802/net4 VDD VDD pch W=0.205u L=0.04u
M_U802/M_u4-M_u3 n810 U802/net14 VDD VDD pch W=0.205u L=0.04u
M_U802/MI2-M_u3 U802/net10 n812 VDD VDD pch W=0.205u L=0.04u
M_U803/MI1-M_u4 n809 n814 VSS VSS nch W=0.155u L=0.04u
M_U803/MI1-M_u3 n809 n815 VSS VSS nch W=0.155u L=0.04u
M_U803/MI1-M_u1 U803/XI1-net8 n815 VDD VDD pch W=0.205u L=0.04u
M_U803/MI1-M_u2 n809 n814 U803/XI1-net8 VDD pch W=0.205u L=0.04u
M_U804/MI15-M_u2 U804/net19 n817 VSS VSS nch W=0.155u L=0.04u
M_U804/MI21 n815 n817 U804/net40 VSS nch W=0.155u L=0.04u
M_U804/MI12 n815 U804/net19 U804/net36 VSS nch W=0.155u L=0.04u
M_U804/MI20 U804/net40 n816 VSS VSS nch W=0.31u L=0.04u
M_U804/MI19 U804/net36 n812 VSS VSS nch W=0.155u L=0.04u
M_U804/MI15-M_u3 U804/net19 n817 VDD VDD pch W=0.205u L=0.04u
M_U804/MI25 n815 U804/net19 U804/net26 VDD pch W=0.325u L=0.04u
M_U804/MI24 U804/net26 n816 VDD VDD pch W=0.41u L=0.04u
M_U804/MI5 n815 n817 U804/net30 VDD pch W=0.325u L=0.04u
M_U804/MI111 U804/net30 n812 VDD VDD pch W=0.205u L=0.04u
M_U805/MI15-M_u3 U805/net28 U805/net20 U805/net64 VSS nch W=0.155u L=0.04u
M_U805/MI8-M_u3 U805/net24 U805/net30 U805/net32 VSS nch W=0.155u L=0.04u
M_U805/MI17-M_u3 U805/net28 U805/net40 U805/net24 VSS nch W=0.155u L=0.04u
M_U805/MI11-M_u3 U805/net40 n820 U805/net108 VSS nch W=0.155u L=0.04u
M_U805/MI9-M_u3 U805/net40 U805/net106 U805/net104 VSS nch W=0.155u L=0.04u
M_U805/MI21 U805/net24 n805 U805/net050 VSS nch W=0.155u L=0.04u
M_U805/MI22 U805/net050 U805/net32 VSS VSS nch W=0.155u L=0.04u
M_U805/MI19-M_u2 U805/net20 U805/net40 VSS VSS nch W=0.155u L=0.04u
M_U805/MI13-M_u2 U805/net106 n820 VSS VSS nch W=0.155u L=0.04u
M_U805/MI14-M_u2 U805/net104 n819 VSS VSS nch W=0.155u L=0.04u
M_U805/M_u8-M_u2 U805/net30 n805 VSS VSS nch W=0.155u L=0.04u
M_U805/MI12-M_u2 U805/net108 U805/net104 VSS VSS nch W=0.155u L=0.04u
M_U805/MU20-M_u2 n799 U805/net28 VSS VSS nch W=0.155u L=0.04u
M_U805/MI1-M_u2 U805/net32 n818 VSS VSS nch W=0.155u L=0.04u
M_U805/MI16-M_u2 U805/net64 U805/net24 VSS VSS nch W=0.2u L=0.04u
M_U805/MI15-M_u2 U805/net28 U805/net40 U805/net64 VDD pch W=0.205u L=0.04u
M_U805/MI8-M_u2 U805/net24 n805 U805/net32 VDD pch W=0.205u L=0.04u
M_U805/MI17-M_u2 U805/net28 U805/net20 U805/net24 VDD pch W=0.205u L=0.04u
M_U805/MI11-M_u2 U805/net40 U805/net106 U805/net108 VDD pch W=0.205u L=0.04u
M_U805/MI9-M_u2 U805/net40 n820 U805/net104 VDD pch W=0.205u L=0.04u
M_U805/MI19-M_u3 U805/net20 U805/net40 VDD VDD pch W=0.205u L=0.04u
M_U805/MI13-M_u3 U805/net106 n820 VDD VDD pch W=0.205u L=0.04u
M_U805/MI14-M_u3 U805/net104 n819 VDD VDD pch W=0.205u L=0.04u
M_U805/M_u8-M_u3 U805/net30 n805 VDD VDD pch W=0.205u L=0.04u
M_U805/MI12-M_u3 U805/net108 U805/net104 VDD VDD pch W=0.205u L=0.04u
M_U805/MU20-M_u3 n799 U805/net28 VDD VDD pch W=0.205u L=0.04u
M_U805/MI1-M_u3 U805/net32 n818 VDD VDD pch W=0.205u L=0.04u
M_U805/MI16-M_u3 U805/net64 U805/net24 VDD VDD pch W=0.28u L=0.04u
M_U805/MI20 U805/net24 U805/net30 U805/net045 VDD pch W=0.205u L=0.04u
M_U805/M_u2 U805/net045 U805/net32 VDD VDD pch W=0.205u L=0.04u
M_U806/MI15 U806/net29 U806/net21 U806/net041 VSS nch W=0.155u L=0.04u
M_U806/MU63 U806/net035 U806/net19 VSS VSS nch W=0.155u L=0.04u
M_U806/MI14 U806/net041 U806/net13 VSS VSS nch W=0.155u L=0.04u
M_U806/MI42 U806/net25 n808 U806/net035 VSS nch W=0.155u L=0.04u
M_U806/M_u6-M_u3 U806/net19 U806/net17 U806/net25 VSS nch W=0.155u L=0.04u
M_U806/MU18-M_u3 U806/net13 U806/net25 U806/net29 VSS nch W=0.155u L=0.04u
M_U806/MI1-M_u2 n819 U806/net29 VSS VSS nch W=0.155u L=0.04u
M_U806/MI3-M_u2 U806/net13 n821 VSS VSS nch W=0.155u L=0.04u
M_U806/MI7-M_u2 U806/net17 n808 VSS VSS nch W=0.155u L=0.04u
M_U806/MI2-M_u2 U806/net19 n817 VSS VSS nch W=0.155u L=0.04u
M_U806/MI6-M_u2 U806/net21 U806/net25 VSS VSS nch W=0.155u L=0.04u
M_U806/MU62 U806/net028 U806/net19 VDD VDD pch W=0.205u L=0.04u
M_U806/MI8 U806/net25 U806/net17 U806/net028 VDD pch W=0.205u L=0.04u
M_U806/MI12 U806/net29 U806/net25 U806/net029 VDD pch W=0.205u L=0.04u
M_U806/MI13 U806/net029 U806/net13 VDD VDD pch W=0.205u L=0.04u
M_U806/M_u6-M_u2 U806/net19 n808 U806/net25 VDD pch W=0.205u L=0.04u
M_U806/MU18-M_u2 U806/net13 U806/net21 U806/net29 VDD pch W=0.205u L=0.04u
M_U806/MI1-M_u3 n819 U806/net29 VDD VDD pch W=0.205u L=0.04u
M_U806/MI3-M_u3 U806/net13 n821 VDD VDD pch W=0.205u L=0.04u
M_U806/MI7-M_u3 U806/net17 n808 VDD VDD pch W=0.205u L=0.04u
M_U806/MI2-M_u3 U806/net19 n817 VDD VDD pch W=0.205u L=0.04u
M_U806/MI6-M_u3 U806/net21 U806/net25 VDD VDD pch W=0.205u L=0.04u
M_U807/M_u6-M_u3 U807/net4 U807/net10 U807/net14 VSS nch W=0.155u L=0.04u
M_U807/MI3-M_u3 U807/net6 n822 U807/net14 VSS nch W=0.155u L=0.04u
M_U807/MI1-M_u2 U807/net4 n823 VSS VSS nch W=0.155u L=0.04u
M_U807/M_u5-M_u2 U807/net6 U807/net4 VSS VSS nch W=0.155u L=0.04u
M_U807/M_u4-M_u2 n808 U807/net14 VSS VSS nch W=0.155u L=0.04u
M_U807/MI2-M_u2 U807/net10 n822 VSS VSS nch W=0.155u L=0.04u
M_U807/M_u6-M_u2 U807/net4 n822 U807/net14 VDD pch W=0.205u L=0.04u
M_U807/MI3-M_u2 U807/net6 U807/net10 U807/net14 VDD pch W=0.205u L=0.04u
M_U807/MI1-M_u3 U807/net4 n823 VDD VDD pch W=0.205u L=0.04u
M_U807/M_u5-M_u3 U807/net6 U807/net4 VDD VDD pch W=0.205u L=0.04u
M_U807/M_u4-M_u3 n808 U807/net14 VDD VDD pch W=0.205u L=0.04u
M_U807/MI2-M_u3 U807/net10 n822 VDD VDD pch W=0.205u L=0.04u
M_U808/MI15-M_u2 U808/net19 n826 VSS VSS nch W=0.155u L=0.04u
M_U808/MI21 n818 n826 U808/net40 VSS nch W=0.155u L=0.04u
M_U808/MI12 n818 U808/net19 U808/net36 VSS nch W=0.155u L=0.04u
M_U808/MI20 U808/net40 n825 VSS VSS nch W=0.31u L=0.04u
M_U808/MI19 U808/net36 n824 VSS VSS nch W=0.155u L=0.04u
M_U808/MI15-M_u3 U808/net19 n826 VDD VDD pch W=0.205u L=0.04u
M_U808/MI25 n818 U808/net19 U808/net26 VDD pch W=0.325u L=0.04u
M_U808/MI24 U808/net26 n825 VDD VDD pch W=0.41u L=0.04u
M_U808/MI5 n818 n826 U808/net30 VDD pch W=0.325u L=0.04u
M_U808/MI111 U808/net30 n824 VDD VDD pch W=0.205u L=0.04u
M_U809/MU29-M_u2 n805 U809/net28 VSS VSS nch W=0.155u L=0.04u
M_U809/MI111 U809/net47 n827 VSS VSS nch W=0.155u L=0.04u
M_U809/MI5 U809/net28 U809/net6 U809/net47 VSS nch W=0.155u L=0.04u
M_U809/MI14 U809/net44 n828 VSS VSS nch W=0.155u L=0.04u
M_U809/MI13 U809/net28 n803 U809/net44 VSS nch W=0.155u L=0.04u
M_U809/MU24 U809/net6 n803 VSS VSS nch W=0.155u L=0.04u
M_U809/MU29-M_u3 n805 U809/net28 VDD VDD pch W=0.205u L=0.04u
M_U809/MI2 VDD n827 U809/net47 VDD pch W=0.205u L=0.04u
M_U809/MI4 U809/net47 n803 U809/net28 VDD pch W=0.205u L=0.04u
M_U809/MI12 U809/net44 U809/net6 U809/net28 VDD pch W=0.205u L=0.04u
M_U809/MI10 VDD n828 U809/net44 VDD pch W=0.205u L=0.04u
M_U809/MU25 VDD n803 U809/net6 VDD pch W=0.205u L=0.04u
M_U810/MI15 U810/net29 U810/net21 U810/net041 VSS nch W=0.155u L=0.04u
M_U810/MU63 U810/net035 U810/net19 VSS VSS nch W=0.155u L=0.04u
M_U810/MI14 U810/net041 U810/net13 VSS VSS nch W=0.155u L=0.04u
M_U810/MI42 U810/net25 n830 U810/net035 VSS nch W=0.155u L=0.04u
M_U810/M_u6-M_u3 U810/net19 U810/net17 U810/net25 VSS nch W=0.155u L=0.04u
M_U810/MU18-M_u3 U810/net13 U810/net25 U810/net29 VSS nch W=0.155u L=0.04u
M_U810/MI1-M_u2 n828 U810/net29 VSS VSS nch W=0.155u L=0.04u
M_U810/MI3-M_u2 U810/net13 n831 VSS VSS nch W=0.155u L=0.04u
M_U810/MI7-M_u2 U810/net17 n830 VSS VSS nch W=0.155u L=0.04u
M_U810/MI2-M_u2 U810/net19 n829 VSS VSS nch W=0.155u L=0.04u
M_U810/MI6-M_u2 U810/net21 U810/net25 VSS VSS nch W=0.155u L=0.04u
M_U810/MU62 U810/net028 U810/net19 VDD VDD pch W=0.205u L=0.04u
M_U810/MI8 U810/net25 U810/net17 U810/net028 VDD pch W=0.205u L=0.04u
M_U810/MI12 U810/net29 U810/net25 U810/net029 VDD pch W=0.205u L=0.04u
M_U810/MI13 U810/net029 U810/net13 VDD VDD pch W=0.205u L=0.04u
M_U810/M_u6-M_u2 U810/net19 n830 U810/net25 VDD pch W=0.205u L=0.04u
M_U810/MU18-M_u2 U810/net13 U810/net21 U810/net29 VDD pch W=0.205u L=0.04u
M_U810/MI1-M_u3 n828 U810/net29 VDD VDD pch W=0.205u L=0.04u
M_U810/MI3-M_u3 U810/net13 n831 VDD VDD pch W=0.205u L=0.04u
M_U810/MI7-M_u3 U810/net17 n830 VDD VDD pch W=0.205u L=0.04u
M_U810/MI2-M_u3 U810/net19 n829 VDD VDD pch W=0.205u L=0.04u
M_U810/MI6-M_u3 U810/net21 U810/net25 VDD VDD pch W=0.205u L=0.04u
M_U811/MU18-M_u2 U811/net24 n835 VSS VSS nch W=0.155u L=0.04u
M_U811/MI47-M_u2 U811/net74 n833 VSS VSS nch W=0.155u L=0.04u
M_U811/MI55-M_u2 U811/net72 n832 VSS VSS nch W=0.155u L=0.04u
M_U811/MI57-M_u2 U811/net76 n832 VSS VSS nch W=0.31u L=0.04u
M_U811/MI58-M_u2 U811/net044 n834 VSS VSS nch W=0.155u L=0.04u
M_U811/MI56-M_u2 U811/net052 n833 VSS VSS nch W=0.31u L=0.04u
M_U811/MI51-M_u3 U811/PG2 n835 n831 VSS nch W=0.22u L=0.04u
M_U811/MI52-M_u3 U811/net74 U811/net044 U811/PG2 VSS nch W=0.12u L=0.04u
M_U811/MI49-M_u3 U811/net052 n834 U811/PG1 VSS nch W=0.155u L=0.04u
M_U811/MI50-M_u3 U811/PG1 U811/net24 n831 VSS nch W=0.155u L=0.04u
M_U811/MI54-M_u3 U811/net76 n834 U811/PG2 VSS nch W=0.155u L=0.04u
M_U811/MI48-M_u3 U811/net72 U811/net044 U811/PG1 VSS nch W=0.12u L=0.04u
M_U811/MU18-M_u3 U811/net24 n835 VDD VDD pch W=0.205u L=0.04u
M_U811/MI47-M_u3 U811/net74 n833 VDD VDD pch W=0.205u L=0.04u
M_U811/MI55-M_u3 U811/net72 n832 VDD VDD pch W=0.205u L=0.04u
M_U811/MI57-M_u3 U811/net76 n832 VDD VDD pch W=0.41u L=0.04u
M_U811/MI58-M_u3 U811/net044 n834 VDD VDD pch W=0.205u L=0.04u
M_U811/MI56-M_u3 U811/net052 n833 VDD VDD pch W=0.41u L=0.04u
M_U811/MI51-M_u2 U811/PG2 U811/net24 n831 VDD pch W=0.205u L=0.04u
M_U811/MI52-M_u2 U811/net74 n834 U811/PG2 VDD pch W=0.205u L=0.04u
M_U811/MI49-M_u2 U811/net052 U811/net044 U811/PG1 VDD pch W=0.205u L=0.04u
M_U811/MI50-M_u2 U811/PG1 n835 n831 VDD pch W=0.29u L=0.04u
M_U811/MI54-M_u2 U811/net76 U811/net044 U811/PG2 VDD pch W=0.205u L=0.04u
M_U811/MI48-M_u2 U811/net72 n834 U811/PG1 VDD pch W=0.205u L=0.04u
M_U812/MI15 U812/net29 U812/net21 U812/net041 VSS nch W=0.155u L=0.04u
M_U812/MU63 U812/net035 U812/net19 VSS VSS nch W=0.155u L=0.04u
M_U812/MI14 U812/net041 U812/net13 VSS VSS nch W=0.155u L=0.04u
M_U812/MI42 U812/net25 n837 U812/net035 VSS nch W=0.155u L=0.04u
M_U812/M_u6-M_u3 U812/net19 U812/net17 U812/net25 VSS nch W=0.155u L=0.04u
M_U812/MU18-M_u3 U812/net13 U812/net25 U812/net29 VSS nch W=0.155u L=0.04u
M_U812/MI1-M_u2 n835 U812/net29 VSS VSS nch W=0.155u L=0.04u
M_U812/MI3-M_u2 U812/net13 n838 VSS VSS nch W=0.155u L=0.04u
M_U812/MI7-M_u2 U812/net17 n837 VSS VSS nch W=0.155u L=0.04u
M_U812/MI2-M_u2 U812/net19 n836 VSS VSS nch W=0.155u L=0.04u
M_U812/MI6-M_u2 U812/net21 U812/net25 VSS VSS nch W=0.155u L=0.04u
M_U812/MU62 U812/net028 U812/net19 VDD VDD pch W=0.205u L=0.04u
M_U812/MI8 U812/net25 U812/net17 U812/net028 VDD pch W=0.205u L=0.04u
M_U812/MI12 U812/net29 U812/net25 U812/net029 VDD pch W=0.205u L=0.04u
M_U812/MI13 U812/net029 U812/net13 VDD VDD pch W=0.205u L=0.04u
M_U812/M_u6-M_u2 U812/net19 n837 U812/net25 VDD pch W=0.205u L=0.04u
M_U812/MU18-M_u2 U812/net13 U812/net21 U812/net29 VDD pch W=0.205u L=0.04u
M_U812/MI1-M_u3 n835 U812/net29 VDD VDD pch W=0.205u L=0.04u
M_U812/MI3-M_u3 U812/net13 n838 VDD VDD pch W=0.205u L=0.04u
M_U812/MI7-M_u3 U812/net17 n837 VDD VDD pch W=0.205u L=0.04u
M_U812/MI2-M_u3 U812/net19 n836 VDD VDD pch W=0.205u L=0.04u
M_U812/MI6-M_u3 U812/net21 U812/net25 VDD VDD pch W=0.205u L=0.04u
M_U813/M_u2 n838 n839 U813/net15 VSS nch W=0.155u L=0.04u
M_U813/M_u3 n838 n840 U813/net15 VSS nch W=0.155u L=0.04u
M_U813/M_u4 U813/net15 n841 VSS VSS nch W=0.155u L=0.04u
M_U813/M_u9 n838 n841 VDD VDD pch W=0.205u L=0.04u
M_U813/MI16-MI12 n838 n839 U813/XI16-net11 VDD pch W=0.205u L=0.04u
M_U813/MI16-MI13 U813/XI16-net11 n840 VDD VDD pch W=0.205u L=0.04u
M_U814/MI1-M_u4 n836 n842 VSS VSS nch W=0.155u L=0.04u
M_U814/MI1-M_u3 n836 n843 VSS VSS nch W=0.155u L=0.04u
M_U814/MI1-M_u1 U814/XI1-net8 n843 VDD VDD pch W=0.205u L=0.04u
M_U814/MI1-M_u2 n836 n842 U814/XI1-net8 VDD pch W=0.205u L=0.04u
M_U815/MI2 n829 n842 U815/net27 VSS nch W=0.155u L=0.04u
M_U815/MI10 U815/net27 n844 VSS VSS nch W=0.155u L=0.04u
M_U815/MI11 n829 n845 VSS VSS nch W=0.155u L=0.04u
M_U815/MI8 n829 n844 U815/net13 VDD pch W=0.205u L=0.04u
M_U815/M_u2 U815/net13 n845 VDD VDD pch W=0.205u L=0.04u
M_U815/MI9 n829 n842 U815/net13 VDD pch W=0.205u L=0.04u
M_U816/MI15 U816/net29 U816/net21 U816/net041 VSS nch W=0.155u L=0.04u
M_U816/MU63 U816/net035 U816/net19 VSS VSS nch W=0.155u L=0.04u
M_U816/MI14 U816/net041 U816/net13 VSS VSS nch W=0.155u L=0.04u
M_U816/MI42 U816/net25 n830 U816/net035 VSS nch W=0.155u L=0.04u
M_U816/M_u6-M_u3 U816/net19 U816/net17 U816/net25 VSS nch W=0.155u L=0.04u
M_U816/MU18-M_u3 U816/net13 U816/net25 U816/net29 VSS nch W=0.155u L=0.04u
M_U816/MI1-M_u2 n827 U816/net29 VSS VSS nch W=0.155u L=0.04u
M_U816/MI3-M_u2 U816/net13 n847 VSS VSS nch W=0.155u L=0.04u
M_U816/MI7-M_u2 U816/net17 n830 VSS VSS nch W=0.155u L=0.04u
M_U816/MI2-M_u2 U816/net19 n846 VSS VSS nch W=0.155u L=0.04u
M_U816/MI6-M_u2 U816/net21 U816/net25 VSS VSS nch W=0.155u L=0.04u
M_U816/MU62 U816/net028 U816/net19 VDD VDD pch W=0.205u L=0.04u
M_U816/MI8 U816/net25 U816/net17 U816/net028 VDD pch W=0.205u L=0.04u
M_U816/MI12 U816/net29 U816/net25 U816/net029 VDD pch W=0.205u L=0.04u
M_U816/MI13 U816/net029 U816/net13 VDD VDD pch W=0.205u L=0.04u
M_U816/M_u6-M_u2 U816/net19 n830 U816/net25 VDD pch W=0.205u L=0.04u
M_U816/MU18-M_u2 U816/net13 U816/net21 U816/net29 VDD pch W=0.205u L=0.04u
M_U816/MI1-M_u3 n827 U816/net29 VDD VDD pch W=0.205u L=0.04u
M_U816/MI3-M_u3 U816/net13 n847 VDD VDD pch W=0.205u L=0.04u
M_U816/MI7-M_u3 U816/net17 n830 VDD VDD pch W=0.205u L=0.04u
M_U816/MI2-M_u3 U816/net19 n846 VDD VDD pch W=0.205u L=0.04u
M_U816/MI6-M_u3 U816/net21 U816/net25 VDD VDD pch W=0.205u L=0.04u
M_U817/MU18-M_u2 U817/net24 n849 VSS VSS nch W=0.155u L=0.04u
M_U817/MI47-M_u2 U817/net74 n833 VSS VSS nch W=0.155u L=0.04u
M_U817/MI55-M_u2 U817/net72 n832 VSS VSS nch W=0.155u L=0.04u
M_U817/MI57-M_u2 U817/net76 n832 VSS VSS nch W=0.31u L=0.04u
M_U817/MI58-M_u2 U817/net044 n848 VSS VSS nch W=0.155u L=0.04u
M_U817/MI56-M_u2 U817/net052 n833 VSS VSS nch W=0.31u L=0.04u
M_U817/MI51-M_u3 U817/PG2 n849 n847 VSS nch W=0.22u L=0.04u
M_U817/MI52-M_u3 U817/net74 U817/net044 U817/PG2 VSS nch W=0.12u L=0.04u
M_U817/MI49-M_u3 U817/net052 n848 U817/PG1 VSS nch W=0.155u L=0.04u
M_U817/MI50-M_u3 U817/PG1 U817/net24 n847 VSS nch W=0.155u L=0.04u
M_U817/MI54-M_u3 U817/net76 n848 U817/PG2 VSS nch W=0.155u L=0.04u
M_U817/MI48-M_u3 U817/net72 U817/net044 U817/PG1 VSS nch W=0.12u L=0.04u
M_U817/MU18-M_u3 U817/net24 n849 VDD VDD pch W=0.205u L=0.04u
M_U817/MI47-M_u3 U817/net74 n833 VDD VDD pch W=0.205u L=0.04u
M_U817/MI55-M_u3 U817/net72 n832 VDD VDD pch W=0.205u L=0.04u
M_U817/MI57-M_u3 U817/net76 n832 VDD VDD pch W=0.41u L=0.04u
M_U817/MI58-M_u3 U817/net044 n848 VDD VDD pch W=0.205u L=0.04u
M_U817/MI56-M_u3 U817/net052 n833 VDD VDD pch W=0.41u L=0.04u
M_U817/MI51-M_u2 U817/PG2 U817/net24 n847 VDD pch W=0.205u L=0.04u
M_U817/MI52-M_u2 U817/net74 n848 U817/PG2 VDD pch W=0.205u L=0.04u
M_U817/MI49-M_u2 U817/net052 U817/net044 U817/PG1 VDD pch W=0.205u L=0.04u
M_U817/MI50-M_u2 U817/PG1 n849 n847 VDD pch W=0.29u L=0.04u
M_U817/MI54-M_u2 U817/net76 U817/net044 U817/PG2 VDD pch W=0.205u L=0.04u
M_U817/MI48-M_u2 U817/net72 n848 U817/PG1 VDD pch W=0.205u L=0.04u
M_U818/M_u2 n848 n850 VSS VSS nch W=0.135u L=0.04u
M_U818/M_u1 n848 n850 VDD VDD pch W=0.205u L=0.04u
M_U819/M_u6-M_u3 U819/net4 U819/net10 U819/net14 VSS nch W=0.155u L=0.04u
M_U819/MI3-M_u3 U819/net6 n851 U819/net14 VSS nch W=0.155u L=0.04u
M_U819/MI1-M_u2 U819/net4 n852 VSS VSS nch W=0.155u L=0.04u
M_U819/M_u5-M_u2 U819/net6 U819/net4 VSS VSS nch W=0.155u L=0.04u
M_U819/M_u4-M_u2 n833 U819/net14 VSS VSS nch W=0.155u L=0.04u
M_U819/MI2-M_u2 U819/net10 n851 VSS VSS nch W=0.155u L=0.04u
M_U819/M_u6-M_u2 U819/net4 n851 U819/net14 VDD pch W=0.205u L=0.04u
M_U819/MI3-M_u2 U819/net6 U819/net10 U819/net14 VDD pch W=0.205u L=0.04u
M_U819/MI1-M_u3 U819/net4 n852 VDD VDD pch W=0.205u L=0.04u
M_U819/M_u5-M_u3 U819/net6 U819/net4 VDD VDD pch W=0.205u L=0.04u
M_U819/M_u4-M_u3 n833 U819/net14 VDD VDD pch W=0.205u L=0.04u
M_U819/MI2-M_u3 U819/net10 n851 VDD VDD pch W=0.205u L=0.04u
M_U820/MI12 U820/net32 n852 VSS VSS nch W=0.155u L=0.04u
M_U820/MI11 U820/net59 n851 U820/net32 VSS nch W=0.155u L=0.04u
M_U820/MI6 U820/net59 n842 VSS VSS nch W=0.155u L=0.04u
M_U820/MI8-M_u2 n832 U820/net59 VSS VSS nch W=0.155u L=0.04u
M_U820/MI8-M_u3 n832 U820/net59 VDD VDD pch W=0.2u L=0.04u
M_U820/MI10 U820/net59 n851 U820/net22 VDD pch W=0.205u L=0.04u
M_U820/MI9 U820/net59 n852 U820/net22 VDD pch W=0.205u L=0.04u
M_U820/M_u2 U820/net22 n842 VDD VDD pch W=0.2u L=0.04u
M_U821/M_u6-M_u3 U821/net4 U821/net10 U821/net14 VSS nch W=0.155u L=0.04u
M_U821/MI3-M_u3 U821/net6 n853 U821/net14 VSS nch W=0.155u L=0.04u
M_U821/MI1-M_u2 U821/net4 n854 VSS VSS nch W=0.155u L=0.04u
M_U821/M_u5-M_u2 U821/net6 U821/net4 VSS VSS nch W=0.155u L=0.04u
M_U821/M_u4-M_u2 n830 U821/net14 VSS VSS nch W=0.155u L=0.04u
M_U821/MI2-M_u2 U821/net10 n853 VSS VSS nch W=0.155u L=0.04u
M_U821/M_u6-M_u2 U821/net4 n853 U821/net14 VDD pch W=0.205u L=0.04u
M_U821/MI3-M_u2 U821/net6 U821/net10 U821/net14 VDD pch W=0.205u L=0.04u
M_U821/MI1-M_u3 U821/net4 n854 VDD VDD pch W=0.205u L=0.04u
M_U821/M_u5-M_u3 U821/net6 U821/net4 VDD VDD pch W=0.205u L=0.04u
M_U821/M_u4-M_u3 n830 U821/net14 VDD VDD pch W=0.205u L=0.04u
M_U821/MI2-M_u3 U821/net10 n853 VDD VDD pch W=0.205u L=0.04u
M_U822/MI15 U822/net29 U822/net21 U822/net041 VSS nch W=0.155u L=0.04u
M_U822/MU63 U822/net035 U822/net19 VSS VSS nch W=0.155u L=0.04u
M_U822/MI14 U822/net041 U822/net13 VSS VSS nch W=0.155u L=0.04u
M_U822/MI42 U822/net25 n843 U822/net035 VSS nch W=0.155u L=0.04u
M_U822/M_u6-M_u3 U822/net19 U822/net17 U822/net25 VSS nch W=0.155u L=0.04u
M_U822/MU18-M_u3 U822/net13 U822/net25 U822/net29 VSS nch W=0.155u L=0.04u
M_U822/MI1-M_u2 n846 U822/net29 VSS VSS nch W=0.155u L=0.04u
M_U822/MI3-M_u2 U822/net13 n855 VSS VSS nch W=0.155u L=0.04u
M_U822/MI7-M_u2 U822/net17 n843 VSS VSS nch W=0.155u L=0.04u
M_U822/MI2-M_u2 U822/net19 n834 VSS VSS nch W=0.155u L=0.04u
M_U822/MI6-M_u2 U822/net21 U822/net25 VSS VSS nch W=0.155u L=0.04u
M_U822/MU62 U822/net028 U822/net19 VDD VDD pch W=0.205u L=0.04u
M_U822/MI8 U822/net25 U822/net17 U822/net028 VDD pch W=0.205u L=0.04u
M_U822/MI12 U822/net29 U822/net25 U822/net029 VDD pch W=0.205u L=0.04u
M_U822/MI13 U822/net029 U822/net13 VDD VDD pch W=0.205u L=0.04u
M_U822/M_u6-M_u2 U822/net19 n843 U822/net25 VDD pch W=0.205u L=0.04u
M_U822/MU18-M_u2 U822/net13 U822/net21 U822/net29 VDD pch W=0.205u L=0.04u
M_U822/MI1-M_u3 n846 U822/net29 VDD VDD pch W=0.205u L=0.04u
M_U822/MI3-M_u3 U822/net13 n855 VDD VDD pch W=0.205u L=0.04u
M_U822/MI7-M_u3 U822/net17 n843 VDD VDD pch W=0.205u L=0.04u
M_U822/MI2-M_u3 U822/net19 n834 VDD VDD pch W=0.205u L=0.04u
M_U822/MI6-M_u3 U822/net21 U822/net25 VDD VDD pch W=0.205u L=0.04u
M_U823/M_u6-M_u3 U823/net4 U823/net10 U823/net14 VSS nch W=0.155u L=0.04u
M_U823/MI3-M_u3 U823/net6 n856 U823/net14 VSS nch W=0.155u L=0.04u
M_U823/MI1-M_u2 U823/net4 n857 VSS VSS nch W=0.155u L=0.04u
M_U823/M_u5-M_u2 U823/net6 U823/net4 VSS VSS nch W=0.155u L=0.04u
M_U823/M_u4-M_u2 N1388 U823/net14 VSS VSS nch W=0.155u L=0.04u
M_U823/MI2-M_u2 U823/net10 n856 VSS VSS nch W=0.155u L=0.04u
M_U823/M_u6-M_u2 U823/net4 n856 U823/net14 VDD pch W=0.205u L=0.04u
M_U823/MI3-M_u2 U823/net6 U823/net10 U823/net14 VDD pch W=0.205u L=0.04u
M_U823/MI1-M_u3 U823/net4 n857 VDD VDD pch W=0.205u L=0.04u
M_U823/M_u5-M_u3 U823/net6 U823/net4 VDD VDD pch W=0.205u L=0.04u
M_U823/M_u4-M_u3 N1388 U823/net14 VDD VDD pch W=0.205u L=0.04u
M_U823/MI2-M_u3 U823/net10 n856 VDD VDD pch W=0.205u L=0.04u
M_U824/MI15-M_u2 U824/net19 n860 VSS VSS nch W=0.155u L=0.04u
M_U824/MI21 n857 n860 U824/net40 VSS nch W=0.155u L=0.04u
M_U824/MI12 n857 U824/net19 U824/net36 VSS nch W=0.155u L=0.04u
M_U824/MI20 U824/net40 n859 VSS VSS nch W=0.31u L=0.04u
M_U824/MI19 U824/net36 n858 VSS VSS nch W=0.155u L=0.04u
M_U824/MI15-M_u3 U824/net19 n860 VDD VDD pch W=0.205u L=0.04u
M_U824/MI25 n857 U824/net19 U824/net26 VDD pch W=0.325u L=0.04u
M_U824/MI24 U824/net26 n859 VDD VDD pch W=0.41u L=0.04u
M_U824/MI5 n857 n860 U824/net30 VDD pch W=0.325u L=0.04u
M_U824/MI111 U824/net30 n858 VDD VDD pch W=0.205u L=0.04u
M_U825/MI15-M_u3 U825/net28 U825/net20 U825/net64 VSS nch W=0.155u L=0.04u
M_U825/MI8-M_u3 U825/net24 U825/net30 U825/net32 VSS nch W=0.155u L=0.04u
M_U825/MI17-M_u3 U825/net28 U825/net40 U825/net24 VSS nch W=0.155u L=0.04u
M_U825/MI11-M_u3 U825/net40 n864 U825/net108 VSS nch W=0.155u L=0.04u
M_U825/MI9-M_u3 U825/net40 U825/net106 U825/net104 VSS nch W=0.155u L=0.04u
M_U825/MI21 U825/net24 n861 U825/net050 VSS nch W=0.155u L=0.04u
M_U825/MI22 U825/net050 U825/net32 VSS VSS nch W=0.155u L=0.04u
M_U825/MI19-M_u2 U825/net20 U825/net40 VSS VSS nch W=0.155u L=0.04u
M_U825/MI13-M_u2 U825/net106 n864 VSS VSS nch W=0.155u L=0.04u
M_U825/MI14-M_u2 U825/net104 n863 VSS VSS nch W=0.155u L=0.04u
M_U825/M_u8-M_u2 U825/net30 n861 VSS VSS nch W=0.155u L=0.04u
M_U825/MI12-M_u2 U825/net108 U825/net104 VSS VSS nch W=0.155u L=0.04u
M_U825/MU20-M_u2 n859 U825/net28 VSS VSS nch W=0.155u L=0.04u
M_U825/MI1-M_u2 U825/net32 n862 VSS VSS nch W=0.155u L=0.04u
M_U825/MI16-M_u2 U825/net64 U825/net24 VSS VSS nch W=0.2u L=0.04u
M_U825/MI15-M_u2 U825/net28 U825/net40 U825/net64 VDD pch W=0.205u L=0.04u
M_U825/MI8-M_u2 U825/net24 n861 U825/net32 VDD pch W=0.205u L=0.04u
M_U825/MI17-M_u2 U825/net28 U825/net20 U825/net24 VDD pch W=0.205u L=0.04u
M_U825/MI11-M_u2 U825/net40 U825/net106 U825/net108 VDD pch W=0.205u L=0.04u
M_U825/MI9-M_u2 U825/net40 n864 U825/net104 VDD pch W=0.205u L=0.04u
M_U825/MI19-M_u3 U825/net20 U825/net40 VDD VDD pch W=0.205u L=0.04u
M_U825/MI13-M_u3 U825/net106 n864 VDD VDD pch W=0.205u L=0.04u
M_U825/MI14-M_u3 U825/net104 n863 VDD VDD pch W=0.205u L=0.04u
M_U825/M_u8-M_u3 U825/net30 n861 VDD VDD pch W=0.205u L=0.04u
M_U825/MI12-M_u3 U825/net108 U825/net104 VDD VDD pch W=0.205u L=0.04u
M_U825/MU20-M_u3 n859 U825/net28 VDD VDD pch W=0.205u L=0.04u
M_U825/MI1-M_u3 U825/net32 n862 VDD VDD pch W=0.205u L=0.04u
M_U825/MI16-M_u3 U825/net64 U825/net24 VDD VDD pch W=0.28u L=0.04u
M_U825/MI20 U825/net24 U825/net30 U825/net045 VDD pch W=0.205u L=0.04u
M_U825/M_u2 U825/net045 U825/net32 VDD VDD pch W=0.205u L=0.04u
M_U826/MU18-M_u2 U826/net24 n868 VSS VSS nch W=0.155u L=0.04u
M_U826/MI47-M_u2 U826/net74 n866 VSS VSS nch W=0.155u L=0.04u
M_U826/MI55-M_u2 U826/net72 n865 VSS VSS nch W=0.155u L=0.04u
M_U826/MI57-M_u2 U826/net76 n865 VSS VSS nch W=0.31u L=0.04u
M_U826/MI58-M_u2 U826/net044 n867 VSS VSS nch W=0.155u L=0.04u
M_U826/MI56-M_u2 U826/net052 n866 VSS VSS nch W=0.31u L=0.04u
M_U826/MI51-M_u3 U826/PG2 n868 n864 VSS nch W=0.22u L=0.04u
M_U826/MI52-M_u3 U826/net74 U826/net044 U826/PG2 VSS nch W=0.12u L=0.04u
M_U826/MI49-M_u3 U826/net052 n867 U826/PG1 VSS nch W=0.155u L=0.04u
M_U826/MI50-M_u3 U826/PG1 U826/net24 n864 VSS nch W=0.155u L=0.04u
M_U826/MI54-M_u3 U826/net76 n867 U826/PG2 VSS nch W=0.155u L=0.04u
M_U826/MI48-M_u3 U826/net72 U826/net044 U826/PG1 VSS nch W=0.12u L=0.04u
M_U826/MU18-M_u3 U826/net24 n868 VDD VDD pch W=0.205u L=0.04u
M_U826/MI47-M_u3 U826/net74 n866 VDD VDD pch W=0.205u L=0.04u
M_U826/MI55-M_u3 U826/net72 n865 VDD VDD pch W=0.205u L=0.04u
M_U826/MI57-M_u3 U826/net76 n865 VDD VDD pch W=0.41u L=0.04u
M_U826/MI58-M_u3 U826/net044 n867 VDD VDD pch W=0.205u L=0.04u
M_U826/MI56-M_u3 U826/net052 n866 VDD VDD pch W=0.41u L=0.04u
M_U826/MI51-M_u2 U826/PG2 U826/net24 n864 VDD pch W=0.205u L=0.04u
M_U826/MI52-M_u2 U826/net74 n867 U826/PG2 VDD pch W=0.205u L=0.04u
M_U826/MI49-M_u2 U826/net052 U826/net044 U826/PG1 VDD pch W=0.205u L=0.04u
M_U826/MI50-M_u2 U826/PG1 n868 n864 VDD pch W=0.29u L=0.04u
M_U826/MI54-M_u2 U826/net76 U826/net044 U826/PG2 VDD pch W=0.205u L=0.04u
M_U826/MI48-M_u2 U826/net72 n867 U826/PG1 VDD pch W=0.205u L=0.04u
M_U827/MI15 U827/net29 U827/net21 U827/net041 VSS nch W=0.155u L=0.04u
M_U827/MU63 U827/net035 U827/net19 VSS VSS nch W=0.155u L=0.04u
M_U827/MI14 U827/net041 U827/net13 VSS VSS nch W=0.155u L=0.04u
M_U827/MI42 U827/net25 n870 U827/net035 VSS nch W=0.155u L=0.04u
M_U827/M_u6-M_u3 U827/net19 U827/net17 U827/net25 VSS nch W=0.155u L=0.04u
M_U827/MU18-M_u3 U827/net13 U827/net25 U827/net29 VSS nch W=0.155u L=0.04u
M_U827/MI1-M_u2 n863 U827/net29 VSS VSS nch W=0.155u L=0.04u
M_U827/MI3-M_u2 U827/net13 n871 VSS VSS nch W=0.155u L=0.04u
M_U827/MI7-M_u2 U827/net17 n870 VSS VSS nch W=0.155u L=0.04u
M_U827/MI2-M_u2 U827/net19 n869 VSS VSS nch W=0.155u L=0.04u
M_U827/MI6-M_u2 U827/net21 U827/net25 VSS VSS nch W=0.155u L=0.04u
M_U827/MU62 U827/net028 U827/net19 VDD VDD pch W=0.205u L=0.04u
M_U827/MI8 U827/net25 U827/net17 U827/net028 VDD pch W=0.205u L=0.04u
M_U827/MI12 U827/net29 U827/net25 U827/net029 VDD pch W=0.205u L=0.04u
M_U827/MI13 U827/net029 U827/net13 VDD VDD pch W=0.205u L=0.04u
M_U827/M_u6-M_u2 U827/net19 n870 U827/net25 VDD pch W=0.205u L=0.04u
M_U827/MU18-M_u2 U827/net13 U827/net21 U827/net29 VDD pch W=0.205u L=0.04u
M_U827/MI1-M_u3 n863 U827/net29 VDD VDD pch W=0.205u L=0.04u
M_U827/MI3-M_u3 U827/net13 n871 VDD VDD pch W=0.205u L=0.04u
M_U827/MI7-M_u3 U827/net17 n870 VDD VDD pch W=0.205u L=0.04u
M_U827/MI2-M_u3 U827/net19 n869 VDD VDD pch W=0.205u L=0.04u
M_U827/MI6-M_u3 U827/net21 U827/net25 VDD VDD pch W=0.205u L=0.04u
M_U828/MI15-M_u3 U828/net28 U828/net20 U828/net64 VSS nch W=0.155u L=0.04u
M_U828/MI8-M_u3 U828/net24 U828/net30 U828/net32 VSS nch W=0.155u L=0.04u
M_U828/MI17-M_u3 U828/net28 U828/net40 U828/net24 VSS nch W=0.155u L=0.04u
M_U828/MI11-M_u3 U828/net40 n875 U828/net108 VSS nch W=0.155u L=0.04u
M_U828/MI9-M_u3 U828/net40 U828/net106 U828/net104 VSS nch W=0.155u L=0.04u
M_U828/MI21 U828/net24 n872 U828/net050 VSS nch W=0.155u L=0.04u
M_U828/MI22 U828/net050 U828/net32 VSS VSS nch W=0.155u L=0.04u
M_U828/MI19-M_u2 U828/net20 U828/net40 VSS VSS nch W=0.155u L=0.04u
M_U828/MI13-M_u2 U828/net106 n875 VSS VSS nch W=0.155u L=0.04u
M_U828/MI14-M_u2 U828/net104 n874 VSS VSS nch W=0.155u L=0.04u
M_U828/M_u8-M_u2 U828/net30 n872 VSS VSS nch W=0.155u L=0.04u
M_U828/MI12-M_u2 U828/net108 U828/net104 VSS VSS nch W=0.155u L=0.04u
M_U828/MU20-M_u2 n858 U828/net28 VSS VSS nch W=0.155u L=0.04u
M_U828/MI1-M_u2 U828/net32 n873 VSS VSS nch W=0.155u L=0.04u
M_U828/MI16-M_u2 U828/net64 U828/net24 VSS VSS nch W=0.2u L=0.04u
M_U828/MI15-M_u2 U828/net28 U828/net40 U828/net64 VDD pch W=0.205u L=0.04u
M_U828/MI8-M_u2 U828/net24 n872 U828/net32 VDD pch W=0.205u L=0.04u
M_U828/MI17-M_u2 U828/net28 U828/net20 U828/net24 VDD pch W=0.205u L=0.04u
M_U828/MI11-M_u2 U828/net40 U828/net106 U828/net108 VDD pch W=0.205u L=0.04u
M_U828/MI9-M_u2 U828/net40 n875 U828/net104 VDD pch W=0.205u L=0.04u
M_U828/MI19-M_u3 U828/net20 U828/net40 VDD VDD pch W=0.205u L=0.04u
M_U828/MI13-M_u3 U828/net106 n875 VDD VDD pch W=0.205u L=0.04u
M_U828/MI14-M_u3 U828/net104 n874 VDD VDD pch W=0.205u L=0.04u
M_U828/M_u8-M_u3 U828/net30 n872 VDD VDD pch W=0.205u L=0.04u
M_U828/MI12-M_u3 U828/net108 U828/net104 VDD VDD pch W=0.205u L=0.04u
M_U828/MU20-M_u3 n858 U828/net28 VDD VDD pch W=0.205u L=0.04u
M_U828/MI1-M_u3 U828/net32 n873 VDD VDD pch W=0.205u L=0.04u
M_U828/MI16-M_u3 U828/net64 U828/net24 VDD VDD pch W=0.28u L=0.04u
M_U828/MI20 U828/net24 U828/net30 U828/net045 VDD pch W=0.205u L=0.04u
M_U828/M_u2 U828/net045 U828/net32 VDD VDD pch W=0.205u L=0.04u
M_U829/MU18-M_u2 U829/net24 n876 VSS VSS nch W=0.155u L=0.04u
M_U829/MI47-M_u2 U829/net74 n865 VSS VSS nch W=0.155u L=0.04u
M_U829/MI55-M_u2 U829/net72 n866 VSS VSS nch W=0.155u L=0.04u
M_U829/MI57-M_u2 U829/net76 n866 VSS VSS nch W=0.31u L=0.04u
M_U829/MI58-M_u2 U829/net044 n869 VSS VSS nch W=0.155u L=0.04u
M_U829/MI56-M_u2 U829/net052 n865 VSS VSS nch W=0.31u L=0.04u
M_U829/MI51-M_u3 U829/PG2 n876 n875 VSS nch W=0.22u L=0.04u
M_U829/MI52-M_u3 U829/net74 U829/net044 U829/PG2 VSS nch W=0.12u L=0.04u
M_U829/MI49-M_u3 U829/net052 n869 U829/PG1 VSS nch W=0.155u L=0.04u
M_U829/MI50-M_u3 U829/PG1 U829/net24 n875 VSS nch W=0.155u L=0.04u
M_U829/MI54-M_u3 U829/net76 n869 U829/PG2 VSS nch W=0.155u L=0.04u
M_U829/MI48-M_u3 U829/net72 U829/net044 U829/PG1 VSS nch W=0.12u L=0.04u
M_U829/MU18-M_u3 U829/net24 n876 VDD VDD pch W=0.205u L=0.04u
M_U829/MI47-M_u3 U829/net74 n865 VDD VDD pch W=0.205u L=0.04u
M_U829/MI55-M_u3 U829/net72 n866 VDD VDD pch W=0.205u L=0.04u
M_U829/MI57-M_u3 U829/net76 n866 VDD VDD pch W=0.41u L=0.04u
M_U829/MI58-M_u3 U829/net044 n869 VDD VDD pch W=0.205u L=0.04u
M_U829/MI56-M_u3 U829/net052 n865 VDD VDD pch W=0.41u L=0.04u
M_U829/MI51-M_u2 U829/PG2 U829/net24 n875 VDD pch W=0.205u L=0.04u
M_U829/MI52-M_u2 U829/net74 n869 U829/PG2 VDD pch W=0.205u L=0.04u
M_U829/MI49-M_u2 U829/net052 U829/net044 U829/PG1 VDD pch W=0.205u L=0.04u
M_U829/MI50-M_u2 U829/PG1 n876 n875 VDD pch W=0.29u L=0.04u
M_U829/MI54-M_u2 U829/net76 U829/net044 U829/PG2 VDD pch W=0.205u L=0.04u
M_U829/MI48-M_u2 U829/net72 n869 U829/PG1 VDD pch W=0.205u L=0.04u
M_U830/MI15 U830/net29 U830/net21 U830/net041 VSS nch W=0.155u L=0.04u
M_U830/MU63 U830/net035 U830/net19 VSS VSS nch W=0.155u L=0.04u
M_U830/MI14 U830/net041 U830/net13 VSS VSS nch W=0.155u L=0.04u
M_U830/MI42 U830/net25 n878 U830/net035 VSS nch W=0.155u L=0.04u
M_U830/M_u6-M_u3 U830/net19 U830/net17 U830/net25 VSS nch W=0.155u L=0.04u
M_U830/MU18-M_u3 U830/net13 U830/net25 U830/net29 VSS nch W=0.155u L=0.04u
M_U830/MI1-M_u2 n876 U830/net29 VSS VSS nch W=0.155u L=0.04u
M_U830/MI3-M_u2 U830/net13 n879 VSS VSS nch W=0.155u L=0.04u
M_U830/MI7-M_u2 U830/net17 n878 VSS VSS nch W=0.155u L=0.04u
M_U830/MI2-M_u2 U830/net19 n877 VSS VSS nch W=0.155u L=0.04u
M_U830/MI6-M_u2 U830/net21 U830/net25 VSS VSS nch W=0.155u L=0.04u
M_U830/MU62 U830/net028 U830/net19 VDD VDD pch W=0.205u L=0.04u
M_U830/MI8 U830/net25 U830/net17 U830/net028 VDD pch W=0.205u L=0.04u
M_U830/MI12 U830/net29 U830/net25 U830/net029 VDD pch W=0.205u L=0.04u
M_U830/MI13 U830/net029 U830/net13 VDD VDD pch W=0.205u L=0.04u
M_U830/M_u6-M_u2 U830/net19 n878 U830/net25 VDD pch W=0.205u L=0.04u
M_U830/MU18-M_u2 U830/net13 U830/net21 U830/net29 VDD pch W=0.205u L=0.04u
M_U830/MI1-M_u3 n876 U830/net29 VDD VDD pch W=0.205u L=0.04u
M_U830/MI3-M_u3 U830/net13 n879 VDD VDD pch W=0.205u L=0.04u
M_U830/MI7-M_u3 U830/net17 n878 VDD VDD pch W=0.205u L=0.04u
M_U830/MI2-M_u3 U830/net19 n877 VDD VDD pch W=0.205u L=0.04u
M_U830/MI6-M_u3 U830/net21 U830/net25 VDD VDD pch W=0.205u L=0.04u
M_U831/MI1-M_u4 n879 n880 VSS VSS nch W=0.155u L=0.04u
M_U831/MI1-M_u3 n879 n870 VSS VSS nch W=0.155u L=0.04u
M_U831/MI1-M_u1 U831/XI1-net8 n870 VDD VDD pch W=0.205u L=0.04u
M_U831/MI1-M_u2 n879 n880 U831/XI1-net8 VDD pch W=0.205u L=0.04u
M_U832/MI2 n878 n880 U832/net27 VSS nch W=0.155u L=0.04u
M_U832/MI10 U832/net27 n869 VSS VSS nch W=0.155u L=0.04u
M_U832/MI11 n878 n862 VSS VSS nch W=0.155u L=0.04u
M_U832/MI8 n878 n869 U832/net13 VDD pch W=0.205u L=0.04u
M_U832/M_u2 U832/net13 n862 VDD VDD pch W=0.205u L=0.04u
M_U832/MI9 n878 n880 U832/net13 VDD pch W=0.205u L=0.04u
M_U833/M_u6-M_u3 U833/net4 U833/net10 U833/net14 VSS nch W=0.155u L=0.04u
M_U833/MI3-M_u3 U833/net6 n881 U833/net14 VSS nch W=0.155u L=0.04u
M_U833/MI1-M_u2 U833/net4 n882 VSS VSS nch W=0.155u L=0.04u
M_U833/M_u5-M_u2 U833/net6 U833/net4 VSS VSS nch W=0.155u L=0.04u
M_U833/M_u4-M_u2 n865 U833/net14 VSS VSS nch W=0.155u L=0.04u
M_U833/MI2-M_u2 U833/net10 n881 VSS VSS nch W=0.155u L=0.04u
M_U833/M_u6-M_u2 U833/net4 n881 U833/net14 VDD pch W=0.205u L=0.04u
M_U833/MI3-M_u2 U833/net6 U833/net10 U833/net14 VDD pch W=0.205u L=0.04u
M_U833/MI1-M_u3 U833/net4 n882 VDD VDD pch W=0.205u L=0.04u
M_U833/M_u5-M_u3 U833/net6 U833/net4 VDD VDD pch W=0.205u L=0.04u
M_U833/M_u4-M_u3 n865 U833/net14 VDD VDD pch W=0.205u L=0.04u
M_U833/MI2-M_u3 U833/net10 n881 VDD VDD pch W=0.205u L=0.04u
M_U834/MI12 U834/net32 n882 VSS VSS nch W=0.155u L=0.04u
M_U834/MI11 U834/net59 n881 U834/net32 VSS nch W=0.155u L=0.04u
M_U834/MI6 U834/net59 n880 VSS VSS nch W=0.155u L=0.04u
M_U834/MI8-M_u2 n866 U834/net59 VSS VSS nch W=0.155u L=0.04u
M_U834/MI8-M_u3 n866 U834/net59 VDD VDD pch W=0.2u L=0.04u
M_U834/MI10 U834/net59 n881 U834/net22 VDD pch W=0.205u L=0.04u
M_U834/MI9 U834/net59 n882 U834/net22 VDD pch W=0.205u L=0.04u
M_U834/M_u2 U834/net22 n880 VDD VDD pch W=0.2u L=0.04u
M_U835/MI2 n872 n880 U835/net27 VSS nch W=0.155u L=0.04u
M_U835/MI10 U835/net27 n883 VSS VSS nch W=0.155u L=0.04u
M_U835/MI11 n872 n884 VSS VSS nch W=0.155u L=0.04u
M_U835/MI8 n872 n883 U835/net13 VDD pch W=0.205u L=0.04u
M_U835/M_u2 U835/net13 n884 VDD VDD pch W=0.205u L=0.04u
M_U835/MI9 n872 n880 U835/net13 VDD pch W=0.205u L=0.04u
M_U836/MI15-M_u2 U836/net19 n887 VSS VSS nch W=0.155u L=0.04u
M_U836/MI21 n856 n887 U836/net40 VSS nch W=0.155u L=0.04u
M_U836/MI12 n856 U836/net19 U836/net36 VSS nch W=0.155u L=0.04u
M_U836/MI20 U836/net40 n886 VSS VSS nch W=0.31u L=0.04u
M_U836/MI19 U836/net36 n885 VSS VSS nch W=0.155u L=0.04u
M_U836/MI15-M_u3 U836/net19 n887 VDD VDD pch W=0.205u L=0.04u
M_U836/MI25 n856 U836/net19 U836/net26 VDD pch W=0.325u L=0.04u
M_U836/MI24 U836/net26 n886 VDD VDD pch W=0.41u L=0.04u
M_U836/MI5 n856 n887 U836/net30 VDD pch W=0.325u L=0.04u
M_U836/MI111 U836/net30 n885 VDD VDD pch W=0.205u L=0.04u
M_U837/M_u6-M_u3 U837/net4 U837/net10 U837/net14 VSS nch W=0.155u L=0.04u
M_U837/MI3-M_u3 U837/net6 n888 U837/net14 VSS nch W=0.155u L=0.04u
M_U837/MI1-M_u2 U837/net4 n889 VSS VSS nch W=0.155u L=0.04u
M_U837/M_u5-M_u2 U837/net6 U837/net4 VSS VSS nch W=0.155u L=0.04u
M_U837/M_u4-M_u2 n886 U837/net14 VSS VSS nch W=0.155u L=0.04u
M_U837/MI2-M_u2 U837/net10 n888 VSS VSS nch W=0.155u L=0.04u
M_U837/M_u6-M_u2 U837/net4 n888 U837/net14 VDD pch W=0.205u L=0.04u
M_U837/MI3-M_u2 U837/net6 U837/net10 U837/net14 VDD pch W=0.205u L=0.04u
M_U837/MI1-M_u3 U837/net4 n889 VDD VDD pch W=0.205u L=0.04u
M_U837/M_u5-M_u3 U837/net6 U837/net4 VDD VDD pch W=0.205u L=0.04u
M_U837/M_u4-M_u3 n886 U837/net14 VDD VDD pch W=0.205u L=0.04u
M_U837/MI2-M_u3 U837/net10 n888 VDD VDD pch W=0.205u L=0.04u
M_U838/M_u6-M_u3 U838/net4 U838/net10 U838/net14 VSS nch W=0.155u L=0.04u
M_U838/MI3-M_u3 U838/net6 n888 U838/net14 VSS nch W=0.155u L=0.04u
M_U838/MI1-M_u2 U838/net4 n890 VSS VSS nch W=0.155u L=0.04u
M_U838/M_u5-M_u2 U838/net6 U838/net4 VSS VSS nch W=0.155u L=0.04u
M_U838/M_u4-M_u2 n885 U838/net14 VSS VSS nch W=0.155u L=0.04u
M_U838/MI2-M_u2 U838/net10 n888 VSS VSS nch W=0.155u L=0.04u
M_U838/M_u6-M_u2 U838/net4 n888 U838/net14 VDD pch W=0.205u L=0.04u
M_U838/MI3-M_u2 U838/net6 U838/net10 U838/net14 VDD pch W=0.205u L=0.04u
M_U838/MI1-M_u3 U838/net4 n890 VDD VDD pch W=0.205u L=0.04u
M_U838/M_u5-M_u3 U838/net6 U838/net4 VDD VDD pch W=0.205u L=0.04u
M_U838/M_u4-M_u3 n885 U838/net14 VDD VDD pch W=0.205u L=0.04u
M_U838/MI2-M_u3 U838/net10 n888 VDD VDD pch W=0.205u L=0.04u
M_U839/MI0-M_u3 U839/net4 n891 U839/net14 VSS nch W=0.155u L=0.04u
M_U839/M_u7-M_u3 U839/net6 U839/net10 U839/net14 VSS nch W=0.17u L=0.04u
M_U839/M_u2-M_u2 U839/net4 n892 VSS VSS nch W=0.155u L=0.04u
M_U839/M_u5-M_u2 U839/net6 U839/net4 VSS VSS nch W=0.17u L=0.04u
M_U839/M_u4-M_u2 n888 U839/net14 VSS VSS nch W=0.155u L=0.04u
M_U839/M_u8-M_u2 U839/net10 n891 VSS VSS nch W=0.155u L=0.04u
M_U839/MI0-M_u2 U839/net4 U839/net10 U839/net14 VDD pch W=0.255u L=0.04u
M_U839/M_u7-M_u2 U839/net6 n891 U839/net14 VDD pch W=0.28u L=0.04u
M_U839/M_u2-M_u3 U839/net4 n892 VDD VDD pch W=0.205u L=0.04u
M_U839/M_u5-M_u3 U839/net6 U839/net4 VDD VDD pch W=0.24u L=0.04u
M_U839/M_u4-M_u3 n888 U839/net14 VDD VDD pch W=0.205u L=0.04u
M_U839/M_u8-M_u3 U839/net10 n891 VDD VDD pch W=0.205u L=0.04u
M_U840/MI15-M_u2 U840/net19 n895 VSS VSS nch W=0.155u L=0.04u
M_U840/MI21 N1387 n895 U840/net40 VSS nch W=0.155u L=0.04u
M_U840/MI12 N1387 U840/net19 U840/net36 VSS nch W=0.155u L=0.04u
M_U840/MI20 U840/net40 n894 VSS VSS nch W=0.31u L=0.04u
M_U840/MI19 U840/net36 n893 VSS VSS nch W=0.155u L=0.04u
M_U840/MI15-M_u3 U840/net19 n895 VDD VDD pch W=0.205u L=0.04u
M_U840/MI25 N1387 U840/net19 U840/net26 VDD pch W=0.325u L=0.04u
M_U840/MI24 U840/net26 n894 VDD VDD pch W=0.41u L=0.04u
M_U840/MI5 N1387 n895 U840/net30 VDD pch W=0.325u L=0.04u
M_U840/MI111 U840/net30 n893 VDD VDD pch W=0.205u L=0.04u
M_U841/MI2 n895 n896 U841/net27 VSS nch W=0.155u L=0.04u
M_U841/MI10 U841/net27 n897 VSS VSS nch W=0.155u L=0.04u
M_U841/MI11 n895 n898 VSS VSS nch W=0.155u L=0.04u
M_U841/MI8 n895 n897 U841/net13 VDD pch W=0.205u L=0.04u
M_U841/M_u2 U841/net13 n898 VDD VDD pch W=0.205u L=0.04u
M_U841/MI9 n895 n896 U841/net13 VDD pch W=0.205u L=0.04u
M_U842/MI15-M_u3 U842/net28 U842/net20 U842/net64 VSS nch W=0.155u L=0.04u
M_U842/MI8-M_u3 U842/net24 U842/net30 U842/net32 VSS nch W=0.155u L=0.04u
M_U842/MI17-M_u3 U842/net28 U842/net40 U842/net24 VSS nch W=0.155u L=0.04u
M_U842/MI11-M_u3 U842/net40 n902 U842/net108 VSS nch W=0.155u L=0.04u
M_U842/MI9-M_u3 U842/net40 U842/net106 U842/net104 VSS nch W=0.155u L=0.04u
M_U842/MI21 U842/net24 n899 U842/net050 VSS nch W=0.155u L=0.04u
M_U842/MI22 U842/net050 U842/net32 VSS VSS nch W=0.155u L=0.04u
M_U842/MI19-M_u2 U842/net20 U842/net40 VSS VSS nch W=0.155u L=0.04u
M_U842/MI13-M_u2 U842/net106 n902 VSS VSS nch W=0.155u L=0.04u
M_U842/MI14-M_u2 U842/net104 n901 VSS VSS nch W=0.155u L=0.04u
M_U842/M_u8-M_u2 U842/net30 n899 VSS VSS nch W=0.155u L=0.04u
M_U842/MI12-M_u2 U842/net108 U842/net104 VSS VSS nch W=0.155u L=0.04u
M_U842/MU20-M_u2 n894 U842/net28 VSS VSS nch W=0.155u L=0.04u
M_U842/MI1-M_u2 U842/net32 n900 VSS VSS nch W=0.155u L=0.04u
M_U842/MI16-M_u2 U842/net64 U842/net24 VSS VSS nch W=0.2u L=0.04u
M_U842/MI15-M_u2 U842/net28 U842/net40 U842/net64 VDD pch W=0.205u L=0.04u
M_U842/MI8-M_u2 U842/net24 n899 U842/net32 VDD pch W=0.205u L=0.04u
M_U842/MI17-M_u2 U842/net28 U842/net20 U842/net24 VDD pch W=0.205u L=0.04u
M_U842/MI11-M_u2 U842/net40 U842/net106 U842/net108 VDD pch W=0.205u L=0.04u
M_U842/MI9-M_u2 U842/net40 n902 U842/net104 VDD pch W=0.205u L=0.04u
M_U842/MI19-M_u3 U842/net20 U842/net40 VDD VDD pch W=0.205u L=0.04u
M_U842/MI13-M_u3 U842/net106 n902 VDD VDD pch W=0.205u L=0.04u
M_U842/MI14-M_u3 U842/net104 n901 VDD VDD pch W=0.205u L=0.04u
M_U842/M_u8-M_u3 U842/net30 n899 VDD VDD pch W=0.205u L=0.04u
M_U842/MI12-M_u3 U842/net108 U842/net104 VDD VDD pch W=0.205u L=0.04u
M_U842/MU20-M_u3 n894 U842/net28 VDD VDD pch W=0.205u L=0.04u
M_U842/MI1-M_u3 U842/net32 n900 VDD VDD pch W=0.205u L=0.04u
M_U842/MI16-M_u3 U842/net64 U842/net24 VDD VDD pch W=0.28u L=0.04u
M_U842/MI20 U842/net24 U842/net30 U842/net045 VDD pch W=0.205u L=0.04u
M_U842/M_u2 U842/net045 U842/net32 VDD VDD pch W=0.205u L=0.04u
M_U843/MI1-M_u4 n899 n903 VSS VSS nch W=0.155u L=0.04u
M_U843/MI1-M_u3 n899 n904 VSS VSS nch W=0.155u L=0.04u
M_U843/MI1-M_u1 U843/XI1-net8 n904 VDD VDD pch W=0.205u L=0.04u
M_U843/MI1-M_u2 n899 n903 U843/XI1-net8 VDD pch W=0.205u L=0.04u
M_U844/M_u6-M_u3 U844/net4 U844/net10 U844/net14 VSS nch W=0.155u L=0.04u
M_U844/MI3-M_u3 U844/net6 n905 U844/net14 VSS nch W=0.155u L=0.04u
M_U844/MI1-M_u2 U844/net4 n906 VSS VSS nch W=0.155u L=0.04u
M_U844/M_u5-M_u2 U844/net6 U844/net4 VSS VSS nch W=0.155u L=0.04u
M_U844/M_u4-M_u2 n904 U844/net14 VSS VSS nch W=0.155u L=0.04u
M_U844/MI2-M_u2 U844/net10 n905 VSS VSS nch W=0.155u L=0.04u
M_U844/M_u6-M_u2 U844/net4 n905 U844/net14 VDD pch W=0.205u L=0.04u
M_U844/MI3-M_u2 U844/net6 U844/net10 U844/net14 VDD pch W=0.205u L=0.04u
M_U844/MI1-M_u3 U844/net4 n906 VDD VDD pch W=0.205u L=0.04u
M_U844/M_u5-M_u3 U844/net6 U844/net4 VDD VDD pch W=0.205u L=0.04u
M_U844/M_u4-M_u3 n904 U844/net14 VDD VDD pch W=0.205u L=0.04u
M_U844/MI2-M_u3 U844/net10 n905 VDD VDD pch W=0.205u L=0.04u
M_U845/MI15-M_u3 U845/net28 U845/net20 U845/net64 VSS nch W=0.155u L=0.04u
M_U845/MI8-M_u3 U845/net24 U845/net30 U845/net32 VSS nch W=0.155u L=0.04u
M_U845/MI17-M_u3 U845/net28 U845/net40 U845/net24 VSS nch W=0.155u L=0.04u
M_U845/MI11-M_u3 U845/net40 n902 U845/net108 VSS nch W=0.155u L=0.04u
M_U845/MI9-M_u3 U845/net40 U845/net106 U845/net104 VSS nch W=0.155u L=0.04u
M_U845/MI21 U845/net24 n900 U845/net050 VSS nch W=0.155u L=0.04u
M_U845/MI22 U845/net050 U845/net32 VSS VSS nch W=0.155u L=0.04u
M_U845/MI19-M_u2 U845/net20 U845/net40 VSS VSS nch W=0.155u L=0.04u
M_U845/MI13-M_u2 U845/net106 n902 VSS VSS nch W=0.155u L=0.04u
M_U845/MI14-M_u2 U845/net104 n908 VSS VSS nch W=0.155u L=0.04u
M_U845/M_u8-M_u2 U845/net30 n900 VSS VSS nch W=0.155u L=0.04u
M_U845/MI12-M_u2 U845/net108 U845/net104 VSS VSS nch W=0.155u L=0.04u
M_U845/MU20-M_u2 n893 U845/net28 VSS VSS nch W=0.155u L=0.04u
M_U845/MI1-M_u2 U845/net32 n907 VSS VSS nch W=0.155u L=0.04u
M_U845/MI16-M_u2 U845/net64 U845/net24 VSS VSS nch W=0.2u L=0.04u
M_U845/MI15-M_u2 U845/net28 U845/net40 U845/net64 VDD pch W=0.205u L=0.04u
M_U845/MI8-M_u2 U845/net24 n900 U845/net32 VDD pch W=0.205u L=0.04u
M_U845/MI17-M_u2 U845/net28 U845/net20 U845/net24 VDD pch W=0.205u L=0.04u
M_U845/MI11-M_u2 U845/net40 U845/net106 U845/net108 VDD pch W=0.205u L=0.04u
M_U845/MI9-M_u2 U845/net40 n902 U845/net104 VDD pch W=0.205u L=0.04u
M_U845/MI19-M_u3 U845/net20 U845/net40 VDD VDD pch W=0.205u L=0.04u
M_U845/MI13-M_u3 U845/net106 n902 VDD VDD pch W=0.205u L=0.04u
M_U845/MI14-M_u3 U845/net104 n908 VDD VDD pch W=0.205u L=0.04u
M_U845/M_u8-M_u3 U845/net30 n900 VDD VDD pch W=0.205u L=0.04u
M_U845/MI12-M_u3 U845/net108 U845/net104 VDD VDD pch W=0.205u L=0.04u
M_U845/MU20-M_u3 n893 U845/net28 VDD VDD pch W=0.205u L=0.04u
M_U845/MI1-M_u3 U845/net32 n907 VDD VDD pch W=0.205u L=0.04u
M_U845/MI16-M_u3 U845/net64 U845/net24 VDD VDD pch W=0.28u L=0.04u
M_U845/MI20 U845/net24 U845/net30 U845/net045 VDD pch W=0.205u L=0.04u
M_U845/M_u2 U845/net045 U845/net32 VDD VDD pch W=0.205u L=0.04u
M_U846/MI15-M_u2 U846/net19 n911 VSS VSS nch W=0.155u L=0.04u
M_U846/MI21 n902 n911 U846/net40 VSS nch W=0.155u L=0.04u
M_U846/MI12 n902 U846/net19 U846/net36 VSS nch W=0.155u L=0.04u
M_U846/MI20 U846/net40 n910 VSS VSS nch W=0.31u L=0.04u
M_U846/MI19 U846/net36 n909 VSS VSS nch W=0.155u L=0.04u
M_U846/MI15-M_u3 U846/net19 n911 VDD VDD pch W=0.205u L=0.04u
M_U846/MI25 n902 U846/net19 U846/net26 VDD pch W=0.325u L=0.04u
M_U846/MI24 U846/net26 n910 VDD VDD pch W=0.41u L=0.04u
M_U846/MI5 n902 n911 U846/net30 VDD pch W=0.325u L=0.04u
M_U846/MI111 U846/net30 n909 VDD VDD pch W=0.205u L=0.04u
M_U847/MI15-M_u3 U847/net28 U847/net20 U847/net64 VSS nch W=0.155u L=0.04u
M_U847/MI8-M_u3 U847/net24 U847/net30 U847/net32 VSS nch W=0.155u L=0.04u
M_U847/MI17-M_u3 U847/net28 U847/net40 U847/net24 VSS nch W=0.155u L=0.04u
M_U847/MI11-M_u3 U847/net40 n915 U847/net108 VSS nch W=0.155u L=0.04u
M_U847/MI9-M_u3 U847/net40 U847/net106 U847/net104 VSS nch W=0.155u L=0.04u
M_U847/MI21 U847/net24 n912 U847/net050 VSS nch W=0.155u L=0.04u
M_U847/MI22 U847/net050 U847/net32 VSS VSS nch W=0.155u L=0.04u
M_U847/MI19-M_u2 U847/net20 U847/net40 VSS VSS nch W=0.155u L=0.04u
M_U847/MI13-M_u2 U847/net106 n915 VSS VSS nch W=0.155u L=0.04u
M_U847/MI14-M_u2 U847/net104 n914 VSS VSS nch W=0.155u L=0.04u
M_U847/M_u8-M_u2 U847/net30 n912 VSS VSS nch W=0.155u L=0.04u
M_U847/MI12-M_u2 U847/net108 U847/net104 VSS VSS nch W=0.155u L=0.04u
M_U847/MU20-M_u2 n910 U847/net28 VSS VSS nch W=0.155u L=0.04u
M_U847/MI1-M_u2 U847/net32 n913 VSS VSS nch W=0.155u L=0.04u
M_U847/MI16-M_u2 U847/net64 U847/net24 VSS VSS nch W=0.2u L=0.04u
M_U847/MI15-M_u2 U847/net28 U847/net40 U847/net64 VDD pch W=0.205u L=0.04u
M_U847/MI8-M_u2 U847/net24 n912 U847/net32 VDD pch W=0.205u L=0.04u
M_U847/MI17-M_u2 U847/net28 U847/net20 U847/net24 VDD pch W=0.205u L=0.04u
M_U847/MI11-M_u2 U847/net40 U847/net106 U847/net108 VDD pch W=0.205u L=0.04u
M_U847/MI9-M_u2 U847/net40 n915 U847/net104 VDD pch W=0.205u L=0.04u
M_U847/MI19-M_u3 U847/net20 U847/net40 VDD VDD pch W=0.205u L=0.04u
M_U847/MI13-M_u3 U847/net106 n915 VDD VDD pch W=0.205u L=0.04u
M_U847/MI14-M_u3 U847/net104 n914 VDD VDD pch W=0.205u L=0.04u
M_U847/M_u8-M_u3 U847/net30 n912 VDD VDD pch W=0.205u L=0.04u
M_U847/MI12-M_u3 U847/net108 U847/net104 VDD VDD pch W=0.205u L=0.04u
M_U847/MU20-M_u3 n910 U847/net28 VDD VDD pch W=0.205u L=0.04u
M_U847/MI1-M_u3 U847/net32 n913 VDD VDD pch W=0.205u L=0.04u
M_U847/MI16-M_u3 U847/net64 U847/net24 VDD VDD pch W=0.28u L=0.04u
M_U847/MI20 U847/net24 U847/net30 U847/net045 VDD pch W=0.205u L=0.04u
M_U847/M_u2 U847/net045 U847/net32 VDD VDD pch W=0.205u L=0.04u
M_U848/MU18-M_u2 U848/net24 n919 VSS VSS nch W=0.155u L=0.04u
M_U848/MI47-M_u2 U848/net74 n917 VSS VSS nch W=0.155u L=0.04u
M_U848/MI55-M_u2 U848/net72 n916 VSS VSS nch W=0.155u L=0.04u
M_U848/MI57-M_u2 U848/net76 n916 VSS VSS nch W=0.31u L=0.04u
M_U848/MI58-M_u2 U848/net044 n918 VSS VSS nch W=0.155u L=0.04u
M_U848/MI56-M_u2 U848/net052 n917 VSS VSS nch W=0.31u L=0.04u
M_U848/MI51-M_u3 U848/PG2 n919 n914 VSS nch W=0.22u L=0.04u
M_U848/MI52-M_u3 U848/net74 U848/net044 U848/PG2 VSS nch W=0.12u L=0.04u
M_U848/MI49-M_u3 U848/net052 n918 U848/PG1 VSS nch W=0.155u L=0.04u
M_U848/MI50-M_u3 U848/PG1 U848/net24 n914 VSS nch W=0.155u L=0.04u
M_U848/MI54-M_u3 U848/net76 n918 U848/PG2 VSS nch W=0.155u L=0.04u
M_U848/MI48-M_u3 U848/net72 U848/net044 U848/PG1 VSS nch W=0.12u L=0.04u
M_U848/MU18-M_u3 U848/net24 n919 VDD VDD pch W=0.205u L=0.04u
M_U848/MI47-M_u3 U848/net74 n917 VDD VDD pch W=0.205u L=0.04u
M_U848/MI55-M_u3 U848/net72 n916 VDD VDD pch W=0.205u L=0.04u
M_U848/MI57-M_u3 U848/net76 n916 VDD VDD pch W=0.41u L=0.04u
M_U848/MI58-M_u3 U848/net044 n918 VDD VDD pch W=0.205u L=0.04u
M_U848/MI56-M_u3 U848/net052 n917 VDD VDD pch W=0.41u L=0.04u
M_U848/MI51-M_u2 U848/PG2 U848/net24 n914 VDD pch W=0.205u L=0.04u
M_U848/MI52-M_u2 U848/net74 n918 U848/PG2 VDD pch W=0.205u L=0.04u
M_U848/MI49-M_u2 U848/net052 U848/net044 U848/PG1 VDD pch W=0.205u L=0.04u
M_U848/MI50-M_u2 U848/PG1 n919 n914 VDD pch W=0.29u L=0.04u
M_U848/MI54-M_u2 U848/net76 U848/net044 U848/PG2 VDD pch W=0.205u L=0.04u
M_U848/MI48-M_u2 U848/net72 n918 U848/PG1 VDD pch W=0.205u L=0.04u
M_U849/M_u4 n919 n922 VSS VSS nch W=0.155u L=0.04u
M_U849/MI2 n919 n921 VSS VSS nch W=0.155u L=0.04u
M_U849/MI3 n919 n920 VSS VSS nch W=0.155u L=0.04u
M_U849/M_u1 U849/net25 n922 VDD VDD pch W=0.41u L=0.04u
M_U849/MI0 U849/net28 n921 U849/net25 VDD pch W=0.41u L=0.04u
M_U849/MI1 n919 n920 U849/net28 VDD pch W=0.41u L=0.04u
M_U850/MI9 n920 n923 U850/net10 VSS nch W=0.155u L=0.04u
M_U850/M_u4 U850/net10 n926 VSS VSS nch W=0.155u L=0.04u
M_U850/MI8 n920 n924 U850/net10 VSS nch W=0.155u L=0.04u
M_U850/MI7 U850/net10 n925 VSS VSS nch W=0.155u L=0.04u
M_U850/MU24 U850/net30 n926 VDD VDD pch W=0.205u L=0.04u
M_U850/MI6 n920 n923 U850/net24 VDD pch W=0.205u L=0.04u
M_U850/MI5 U850/net24 n924 VDD VDD pch W=0.205u L=0.04u
M_U850/MI4 n920 n925 U850/net30 VDD pch W=0.205u L=0.04u
M_U851/M_u6-M_u3 U851/net4 U851/net10 U851/net14 VSS nch W=0.155u L=0.04u
M_U851/MI3-M_u3 U851/net6 n927 U851/net14 VSS nch W=0.155u L=0.04u
M_U851/MI1-M_u2 U851/net4 n928 VSS VSS nch W=0.155u L=0.04u
M_U851/M_u5-M_u2 U851/net6 U851/net4 VSS VSS nch W=0.155u L=0.04u
M_U851/M_u4-M_u2 n913 U851/net14 VSS VSS nch W=0.155u L=0.04u
M_U851/MI2-M_u2 U851/net10 n927 VSS VSS nch W=0.155u L=0.04u
M_U851/M_u6-M_u2 U851/net4 n927 U851/net14 VDD pch W=0.205u L=0.04u
M_U851/MI3-M_u2 U851/net6 U851/net10 U851/net14 VDD pch W=0.205u L=0.04u
M_U851/MI1-M_u3 U851/net4 n928 VDD VDD pch W=0.205u L=0.04u
M_U851/M_u5-M_u3 U851/net6 U851/net4 VDD VDD pch W=0.205u L=0.04u
M_U851/M_u4-M_u3 n913 U851/net14 VDD VDD pch W=0.205u L=0.04u
M_U851/MI2-M_u3 U851/net10 n927 VDD VDD pch W=0.205u L=0.04u
M_U852/MI15 U852/net29 U852/net21 U852/net041 VSS nch W=0.155u L=0.04u
M_U852/MU63 U852/net035 U852/net19 VSS VSS nch W=0.155u L=0.04u
M_U852/MI14 U852/net041 U852/net13 VSS VSS nch W=0.155u L=0.04u
M_U852/MI42 U852/net25 n915 U852/net035 VSS nch W=0.155u L=0.04u
M_U852/M_u6-M_u3 U852/net19 U852/net17 U852/net25 VSS nch W=0.155u L=0.04u
M_U852/MU18-M_u3 U852/net13 U852/net25 U852/net29 VSS nch W=0.155u L=0.04u
M_U852/MI1-M_u2 n909 U852/net29 VSS VSS nch W=0.155u L=0.04u
M_U852/MI3-M_u2 U852/net13 n930 VSS VSS nch W=0.155u L=0.04u
M_U852/MI7-M_u2 U852/net17 n915 VSS VSS nch W=0.155u L=0.04u
M_U852/MI2-M_u2 U852/net19 n929 VSS VSS nch W=0.155u L=0.04u
M_U852/MI6-M_u2 U852/net21 U852/net25 VSS VSS nch W=0.155u L=0.04u
M_U852/MU62 U852/net028 U852/net19 VDD VDD pch W=0.205u L=0.04u
M_U852/MI8 U852/net25 U852/net17 U852/net028 VDD pch W=0.205u L=0.04u
M_U852/MI12 U852/net29 U852/net25 U852/net029 VDD pch W=0.205u L=0.04u
M_U852/MI13 U852/net029 U852/net13 VDD VDD pch W=0.205u L=0.04u
M_U852/M_u6-M_u2 U852/net19 n915 U852/net25 VDD pch W=0.205u L=0.04u
M_U852/MU18-M_u2 U852/net13 U852/net21 U852/net29 VDD pch W=0.205u L=0.04u
M_U852/MI1-M_u3 n909 U852/net29 VDD VDD pch W=0.205u L=0.04u
M_U852/MI3-M_u3 U852/net13 n930 VDD VDD pch W=0.205u L=0.04u
M_U852/MI7-M_u3 U852/net17 n915 VDD VDD pch W=0.205u L=0.04u
M_U852/MI2-M_u3 U852/net19 n929 VDD VDD pch W=0.205u L=0.04u
M_U852/MI6-M_u3 U852/net21 U852/net25 VDD VDD pch W=0.205u L=0.04u
M_U853/MU18-M_u2 U853/net24 n931 VSS VSS nch W=0.155u L=0.04u
M_U853/MI47-M_u2 U853/net74 n916 VSS VSS nch W=0.155u L=0.04u
M_U853/MI55-M_u2 U853/net72 n917 VSS VSS nch W=0.155u L=0.04u
M_U853/MI57-M_u2 U853/net76 n917 VSS VSS nch W=0.31u L=0.04u
M_U853/MI58-M_u2 U853/net044 n925 VSS VSS nch W=0.155u L=0.04u
M_U853/MI56-M_u2 U853/net052 n916 VSS VSS nch W=0.31u L=0.04u
M_U853/MI51-M_u3 U853/PG2 n931 n930 VSS nch W=0.22u L=0.04u
M_U853/MI52-M_u3 U853/net74 U853/net044 U853/PG2 VSS nch W=0.12u L=0.04u
M_U853/MI49-M_u3 U853/net052 n925 U853/PG1 VSS nch W=0.155u L=0.04u
M_U853/MI50-M_u3 U853/PG1 U853/net24 n930 VSS nch W=0.155u L=0.04u
M_U853/MI54-M_u3 U853/net76 n925 U853/PG2 VSS nch W=0.155u L=0.04u
M_U853/MI48-M_u3 U853/net72 U853/net044 U853/PG1 VSS nch W=0.12u L=0.04u
M_U853/MU18-M_u3 U853/net24 n931 VDD VDD pch W=0.205u L=0.04u
M_U853/MI47-M_u3 U853/net74 n916 VDD VDD pch W=0.205u L=0.04u
M_U853/MI55-M_u3 U853/net72 n917 VDD VDD pch W=0.205u L=0.04u
M_U853/MI57-M_u3 U853/net76 n917 VDD VDD pch W=0.41u L=0.04u
M_U853/MI58-M_u3 U853/net044 n925 VDD VDD pch W=0.205u L=0.04u
M_U853/MI56-M_u3 U853/net052 n916 VDD VDD pch W=0.41u L=0.04u
M_U853/MI51-M_u2 U853/PG2 U853/net24 n930 VDD pch W=0.205u L=0.04u
M_U853/MI52-M_u2 U853/net74 n925 U853/PG2 VDD pch W=0.205u L=0.04u
M_U853/MI49-M_u2 U853/net052 U853/net044 U853/PG1 VDD pch W=0.205u L=0.04u
M_U853/MI50-M_u2 U853/PG1 n931 n930 VDD pch W=0.29u L=0.04u
M_U853/MI54-M_u2 U853/net76 U853/net044 U853/PG2 VDD pch W=0.205u L=0.04u
M_U853/MI48-M_u2 U853/net72 n925 U853/PG1 VDD pch W=0.205u L=0.04u
M_U854/MI15 U854/net29 U854/net21 U854/net041 VSS nch W=0.155u L=0.04u
M_U854/MU63 U854/net035 U854/net19 VSS VSS nch W=0.155u L=0.04u
M_U854/MI14 U854/net041 U854/net13 VSS VSS nch W=0.155u L=0.04u
M_U854/MI42 U854/net25 n933 U854/net035 VSS nch W=0.155u L=0.04u
M_U854/M_u6-M_u3 U854/net19 U854/net17 U854/net25 VSS nch W=0.155u L=0.04u
M_U854/MU18-M_u3 U854/net13 U854/net25 U854/net29 VSS nch W=0.155u L=0.04u
M_U854/MI1-M_u2 n931 U854/net29 VSS VSS nch W=0.155u L=0.04u
M_U854/MI3-M_u2 U854/net13 n934 VSS VSS nch W=0.155u L=0.04u
M_U854/MI7-M_u2 U854/net17 n933 VSS VSS nch W=0.155u L=0.04u
M_U854/MI2-M_u2 U854/net19 n932 VSS VSS nch W=0.155u L=0.04u
M_U854/MI6-M_u2 U854/net21 U854/net25 VSS VSS nch W=0.155u L=0.04u
M_U854/MU62 U854/net028 U854/net19 VDD VDD pch W=0.205u L=0.04u
M_U854/MI8 U854/net25 U854/net17 U854/net028 VDD pch W=0.205u L=0.04u
M_U854/MI12 U854/net29 U854/net25 U854/net029 VDD pch W=0.205u L=0.04u
M_U854/MI13 U854/net029 U854/net13 VDD VDD pch W=0.205u L=0.04u
M_U854/M_u6-M_u2 U854/net19 n933 U854/net25 VDD pch W=0.205u L=0.04u
M_U854/MU18-M_u2 U854/net13 U854/net21 U854/net29 VDD pch W=0.205u L=0.04u
M_U854/MI1-M_u3 n931 U854/net29 VDD VDD pch W=0.205u L=0.04u
M_U854/MI3-M_u3 U854/net13 n934 VDD VDD pch W=0.205u L=0.04u
M_U854/MI7-M_u3 U854/net17 n933 VDD VDD pch W=0.205u L=0.04u
M_U854/MI2-M_u3 U854/net19 n932 VDD VDD pch W=0.205u L=0.04u
M_U854/MI6-M_u3 U854/net21 U854/net25 VDD VDD pch W=0.205u L=0.04u
M_U855/MI12 U855/net32 n936 VSS VSS nch W=0.155u L=0.04u
M_U855/MI11 U855/net59 n935 U855/net32 VSS nch W=0.155u L=0.04u
M_U855/MI6 U855/net59 n927 VSS VSS nch W=0.155u L=0.04u
M_U855/MI8-M_u2 n934 U855/net59 VSS VSS nch W=0.155u L=0.04u
M_U855/MI8-M_u3 n934 U855/net59 VDD VDD pch W=0.2u L=0.04u
M_U855/MI10 U855/net59 n935 U855/net22 VDD pch W=0.205u L=0.04u
M_U855/MI9 U855/net59 n936 U855/net22 VDD pch W=0.205u L=0.04u
M_U855/M_u2 U855/net22 n927 VDD VDD pch W=0.2u L=0.04u
M_U856/MI1-M_u4 n932 n936 VSS VSS nch W=0.155u L=0.04u
M_U856/MI1-M_u3 n932 n928 VSS VSS nch W=0.155u L=0.04u
M_U856/MI1-M_u1 U856/XI1-net8 n928 VDD VDD pch W=0.205u L=0.04u
M_U856/MI1-M_u2 n932 n936 U856/XI1-net8 VDD pch W=0.205u L=0.04u
M_U857/M_u2 n916 n937 U857/net15 VSS nch W=0.155u L=0.04u
M_U857/M_u3 n916 n938 U857/net15 VSS nch W=0.155u L=0.04u
M_U857/M_u4 U857/net15 n939 VSS VSS nch W=0.155u L=0.04u
M_U857/M_u9 n916 n939 VDD VDD pch W=0.205u L=0.04u
M_U857/MI16-MI12 n916 n937 U857/XI16-net11 VDD pch W=0.205u L=0.04u
M_U857/MI16-MI13 U857/XI16-net11 n938 VDD VDD pch W=0.205u L=0.04u
M_U858/M_u6-M_u3 U858/net4 U858/net10 U858/net14 VSS nch W=0.155u L=0.04u
M_U858/MI3-M_u3 U858/net6 n940 U858/net14 VSS nch W=0.155u L=0.04u
M_U858/MI1-M_u2 U858/net4 n941 VSS VSS nch W=0.155u L=0.04u
M_U858/M_u5-M_u2 U858/net6 U858/net4 VSS VSS nch W=0.155u L=0.04u
M_U858/M_u4-M_u2 n917 U858/net14 VSS VSS nch W=0.155u L=0.04u
M_U858/MI2-M_u2 U858/net10 n940 VSS VSS nch W=0.155u L=0.04u
M_U858/M_u6-M_u2 U858/net4 n940 U858/net14 VDD pch W=0.205u L=0.04u
M_U858/MI3-M_u2 U858/net6 U858/net10 U858/net14 VDD pch W=0.205u L=0.04u
M_U858/MI1-M_u3 U858/net4 n941 VDD VDD pch W=0.205u L=0.04u
M_U858/M_u5-M_u3 U858/net6 U858/net4 VDD VDD pch W=0.205u L=0.04u
M_U858/M_u4-M_u3 n917 U858/net14 VDD VDD pch W=0.205u L=0.04u
M_U858/MI2-M_u3 U858/net10 n940 VDD VDD pch W=0.205u L=0.04u
M_U859/M_u6-M_u3 U859/net4 U859/net10 U859/net14 VSS nch W=0.155u L=0.04u
M_U859/MI3-M_u3 U859/net6 n942 U859/net14 VSS nch W=0.155u L=0.04u
M_U859/MI1-M_u2 U859/net4 n935 VSS VSS nch W=0.155u L=0.04u
M_U859/M_u5-M_u2 U859/net6 U859/net4 VSS VSS nch W=0.155u L=0.04u
M_U859/M_u4-M_u2 n915 U859/net14 VSS VSS nch W=0.155u L=0.04u
M_U859/MI2-M_u2 U859/net10 n942 VSS VSS nch W=0.155u L=0.04u
M_U859/M_u6-M_u2 U859/net4 n942 U859/net14 VDD pch W=0.205u L=0.04u
M_U859/MI3-M_u2 U859/net6 U859/net10 U859/net14 VDD pch W=0.205u L=0.04u
M_U859/MI1-M_u3 U859/net4 n935 VDD VDD pch W=0.205u L=0.04u
M_U859/M_u5-M_u3 U859/net6 U859/net4 VDD VDD pch W=0.205u L=0.04u
M_U859/M_u4-M_u3 n915 U859/net14 VDD VDD pch W=0.205u L=0.04u
M_U859/MI2-M_u3 U859/net10 n942 VDD VDD pch W=0.205u L=0.04u
M_U860/MI2 n929 n936 U860/net27 VSS nch W=0.155u L=0.04u
M_U860/MI10 U860/net27 n943 VSS VSS nch W=0.155u L=0.04u
M_U860/MI11 n929 n944 VSS VSS nch W=0.155u L=0.04u
M_U860/MI8 n929 n943 U860/net13 VDD pch W=0.205u L=0.04u
M_U860/M_u2 U860/net13 n944 VDD VDD pch W=0.205u L=0.04u
M_U860/MI9 n929 n936 U860/net13 VDD pch W=0.205u L=0.04u
M_U861/M_u2 n936 n939 VSS VSS nch W=0.135u L=0.04u
M_U861/M_u1 n936 n939 VDD VDD pch W=0.205u L=0.04u
M_U862/MI15 U862/net29 U862/net21 U862/net041 VSS nch W=0.155u L=0.04u
M_U862/MU63 U862/net035 U862/net19 VSS VSS nch W=0.155u L=0.04u
M_U862/MI14 U862/net041 U862/net13 VSS VSS nch W=0.155u L=0.04u
M_U862/MI42 U862/net25 n903 U862/net035 VSS nch W=0.155u L=0.04u
M_U862/M_u6-M_u3 U862/net19 U862/net17 U862/net25 VSS nch W=0.155u L=0.04u
M_U862/MU18-M_u3 U862/net13 U862/net25 U862/net29 VSS nch W=0.155u L=0.04u
M_U862/MI1-M_u2 n908 U862/net29 VSS VSS nch W=0.155u L=0.04u
M_U862/MI3-M_u2 U862/net13 n946 VSS VSS nch W=0.155u L=0.04u
M_U862/MI7-M_u2 U862/net17 n903 VSS VSS nch W=0.155u L=0.04u
M_U862/MI2-M_u2 U862/net19 n945 VSS VSS nch W=0.155u L=0.04u
M_U862/MI6-M_u2 U862/net21 U862/net25 VSS VSS nch W=0.155u L=0.04u
M_U862/MU62 U862/net028 U862/net19 VDD VDD pch W=0.205u L=0.04u
M_U862/MI8 U862/net25 U862/net17 U862/net028 VDD pch W=0.205u L=0.04u
M_U862/MI12 U862/net29 U862/net25 U862/net029 VDD pch W=0.205u L=0.04u
M_U862/MI13 U862/net029 U862/net13 VDD VDD pch W=0.205u L=0.04u
M_U862/M_u6-M_u2 U862/net19 n903 U862/net25 VDD pch W=0.205u L=0.04u
M_U862/MU18-M_u2 U862/net13 U862/net21 U862/net29 VDD pch W=0.205u L=0.04u
M_U862/MI1-M_u3 n908 U862/net29 VDD VDD pch W=0.205u L=0.04u
M_U862/MI3-M_u3 U862/net13 n946 VDD VDD pch W=0.205u L=0.04u
M_U862/MI7-M_u3 U862/net17 n903 VDD VDD pch W=0.205u L=0.04u
M_U862/MI2-M_u3 U862/net19 n945 VDD VDD pch W=0.205u L=0.04u
M_U862/MI6-M_u3 U862/net21 U862/net25 VDD VDD pch W=0.205u L=0.04u
M_U863/MI15-M_u2 U863/net19 n948 VSS VSS nch W=0.155u L=0.04u
M_U863/MI21 n907 n948 U863/net40 VSS nch W=0.155u L=0.04u
M_U863/MI12 n907 U863/net19 U863/net36 VSS nch W=0.155u L=0.04u
M_U863/MI20 U863/net40 n947 VSS VSS nch W=0.31u L=0.04u
M_U863/MI19 U863/net36 n906 VSS VSS nch W=0.155u L=0.04u
M_U863/MI15-M_u3 U863/net19 n948 VDD VDD pch W=0.205u L=0.04u
M_U863/MI25 n907 U863/net19 U863/net26 VDD pch W=0.325u L=0.04u
M_U863/MI24 U863/net26 n947 VDD VDD pch W=0.41u L=0.04u
M_U863/MI5 n907 n948 U863/net30 VDD pch W=0.325u L=0.04u
M_U863/MI111 U863/net30 n906 VDD VDD pch W=0.205u L=0.04u
M_U864/M_u6-M_u3 U864/net4 U864/net10 U864/net14 VSS nch W=0.155u L=0.04u
M_U864/MI3-M_u3 U864/net6 n949 U864/net14 VSS nch W=0.155u L=0.04u
M_U864/MI1-M_u2 U864/net4 n950 VSS VSS nch W=0.155u L=0.04u
M_U864/M_u5-M_u2 U864/net6 U864/net4 VSS VSS nch W=0.155u L=0.04u
M_U864/M_u4-M_u2 n900 U864/net14 VSS VSS nch W=0.155u L=0.04u
M_U864/MI2-M_u2 U864/net10 n949 VSS VSS nch W=0.155u L=0.04u
M_U864/M_u6-M_u2 U864/net4 n949 U864/net14 VDD pch W=0.205u L=0.04u
M_U864/MI3-M_u2 U864/net6 U864/net10 U864/net14 VDD pch W=0.205u L=0.04u
M_U864/MI1-M_u3 U864/net4 n950 VDD VDD pch W=0.205u L=0.04u
M_U864/M_u5-M_u3 U864/net6 U864/net4 VDD VDD pch W=0.205u L=0.04u
M_U864/M_u4-M_u3 n900 U864/net14 VDD VDD pch W=0.205u L=0.04u
M_U864/MI2-M_u3 U864/net10 n949 VDD VDD pch W=0.205u L=0.04u
M_U865/MI0-M_u4 N1113 N133 U865/XI0-net10 VSS nch W=0.155u L=0.04u
M_U865/MI0-M_u5 U865/XI0-net10 n951 U865/XI0-net13 VSS nch W=0.155u L=0.04u
M_U865/MI0-M_u6 U865/XI0-net13 N134 VSS VSS nch W=0.155u L=0.04u
M_U865/MI0-M_u3 N1113 N134 VDD VDD pch W=0.205u L=0.04u
M_U865/MI0-M_u1 N1113 N133 VDD VDD pch W=0.205u L=0.04u
M_U865/MI0-M_u2 N1113 n951 VDD VDD pch W=0.205u L=0.04u
M_U866/MU1-M_u4 U866/XU1-net6 n951 VSS VSS nch W=0.155u L=0.04u
M_U866/MU1-M_u3 N1112 N242 U866/XU1-net6 VSS nch W=0.155u L=0.04u
M_U866/MU1-M_u2 N1112 n951 VDD VDD pch W=0.155u L=0.04u
M_U866/MU1-M_u1 N1112 N242 VDD VDD pch W=0.155u L=0.04u
M_U867/M_u2 n951 N5 VSS VSS nch W=0.135u L=0.04u
M_U867/M_u1 n951 N5 VDD VDD pch W=0.205u L=0.04u
M_U868/M_u6-M_u3 U868/net4 U868/net10 U868/net14 VSS nch W=0.155u L=0.04u
M_U868/MI3-M_u3 U868/net6 n952 U868/net14 VSS nch W=0.155u L=0.04u
M_U868/MI1-M_u2 U868/net4 n822 VSS VSS nch W=0.155u L=0.04u
M_U868/M_u5-M_u2 U868/net6 U868/net4 VSS VSS nch W=0.155u L=0.04u
M_U868/M_u4-M_u2 N10908 U868/net14 VSS VSS nch W=0.155u L=0.04u
M_U868/MI2-M_u2 U868/net10 n952 VSS VSS nch W=0.155u L=0.04u
M_U868/M_u6-M_u2 U868/net4 n952 U868/net14 VDD pch W=0.205u L=0.04u
M_U868/MI3-M_u2 U868/net6 U868/net10 U868/net14 VDD pch W=0.205u L=0.04u
M_U868/MI1-M_u3 U868/net4 n822 VDD VDD pch W=0.205u L=0.04u
M_U868/M_u5-M_u3 U868/net6 U868/net4 VDD VDD pch W=0.205u L=0.04u
M_U868/M_u4-M_u3 N10908 U868/net14 VDD VDD pch W=0.205u L=0.04u
M_U868/MI2-M_u3 U868/net10 n952 VDD VDD pch W=0.205u L=0.04u
M_U869/MI15-M_u2 U869/net19 n952 VSS VSS nch W=0.155u L=0.04u
M_U869/MI21 N10907 n952 U869/net40 VSS nch W=0.155u L=0.04u
M_U869/MI12 N10907 U869/net19 U869/net36 VSS nch W=0.155u L=0.04u
M_U869/MI20 U869/net40 n812 VSS VSS nch W=0.31u L=0.04u
M_U869/MI19 U869/net36 n953 VSS VSS nch W=0.155u L=0.04u
M_U869/MI15-M_u3 U869/net19 n952 VDD VDD pch W=0.205u L=0.04u
M_U869/MI25 N10907 U869/net19 U869/net26 VDD pch W=0.325u L=0.04u
M_U869/MI24 U869/net26 n812 VDD VDD pch W=0.41u L=0.04u
M_U869/MI5 N10907 n952 U869/net30 VDD pch W=0.325u L=0.04u
M_U869/MI111 U869/net30 n953 VDD VDD pch W=0.205u L=0.04u
M_U870/M_u6-M_u3 U870/net4 U870/net10 U870/net14 VSS nch W=0.155u L=0.04u
M_U870/MI3-M_u3 U870/net6 n820 U870/net14 VSS nch W=0.155u L=0.04u
M_U870/MI1-M_u2 U870/net4 n954 VSS VSS nch W=0.155u L=0.04u
M_U870/M_u5-M_u2 U870/net6 U870/net4 VSS VSS nch W=0.155u L=0.04u
M_U870/M_u4-M_u2 n812 U870/net14 VSS VSS nch W=0.155u L=0.04u
M_U870/MI2-M_u2 U870/net10 n820 VSS VSS nch W=0.155u L=0.04u
M_U870/M_u6-M_u2 U870/net4 n820 U870/net14 VDD pch W=0.205u L=0.04u
M_U870/MI3-M_u2 U870/net6 U870/net10 U870/net14 VDD pch W=0.205u L=0.04u
M_U870/MI1-M_u3 U870/net4 n954 VDD VDD pch W=0.205u L=0.04u
M_U870/M_u5-M_u3 U870/net6 U870/net4 VDD VDD pch W=0.205u L=0.04u
M_U870/M_u4-M_u3 n812 U870/net14 VDD VDD pch W=0.205u L=0.04u
M_U870/MI2-M_u3 U870/net10 n820 VDD VDD pch W=0.205u L=0.04u
M_U871/M_u2 n820 n955 VSS VSS nch W=0.135u L=0.04u
M_U871/M_u1 n820 n955 VDD VDD pch W=0.205u L=0.04u
M_U872/M_u6-M_u3 U872/net4 U872/net10 U872/net14 VSS nch W=0.155u L=0.04u
M_U872/MI3-M_u3 U872/net6 n955 U872/net14 VSS nch W=0.155u L=0.04u
M_U872/MI1-M_u2 U872/net4 n826 VSS VSS nch W=0.155u L=0.04u
M_U872/M_u5-M_u2 U872/net6 U872/net4 VSS VSS nch W=0.155u L=0.04u
M_U872/M_u4-M_u2 n953 U872/net14 VSS VSS nch W=0.155u L=0.04u
M_U872/MI2-M_u2 U872/net10 n955 VSS VSS nch W=0.155u L=0.04u
M_U872/M_u6-M_u2 U872/net4 n955 U872/net14 VDD pch W=0.205u L=0.04u
M_U872/MI3-M_u2 U872/net6 U872/net10 U872/net14 VDD pch W=0.205u L=0.04u
M_U872/MI1-M_u3 U872/net4 n826 VDD VDD pch W=0.205u L=0.04u
M_U872/M_u5-M_u3 U872/net6 U872/net4 VDD VDD pch W=0.205u L=0.04u
M_U872/M_u4-M_u3 n953 U872/net14 VDD VDD pch W=0.205u L=0.04u
M_U872/MI2-M_u3 U872/net10 n955 VDD VDD pch W=0.205u L=0.04u
M_U873/M_u6-M_u3 U873/net4 U873/net10 U873/net14 VSS nch W=0.155u L=0.04u
M_U873/MI3-M_u3 U873/net6 n817 U873/net14 VSS nch W=0.155u L=0.04u
M_U873/MI1-M_u2 U873/net4 n956 VSS VSS nch W=0.155u L=0.04u
M_U873/M_u5-M_u2 U873/net6 U873/net4 VSS VSS nch W=0.155u L=0.04u
M_U873/M_u4-M_u2 N10906 U873/net14 VSS VSS nch W=0.155u L=0.04u
M_U873/MI2-M_u2 U873/net10 n817 VSS VSS nch W=0.155u L=0.04u
M_U873/M_u6-M_u2 U873/net4 n817 U873/net14 VDD pch W=0.205u L=0.04u
M_U873/MI3-M_u2 U873/net6 U873/net10 U873/net14 VDD pch W=0.205u L=0.04u
M_U873/MI1-M_u3 U873/net4 n956 VDD VDD pch W=0.205u L=0.04u
M_U873/M_u5-M_u3 U873/net6 U873/net4 VDD VDD pch W=0.205u L=0.04u
M_U873/M_u4-M_u3 N10906 U873/net14 VDD VDD pch W=0.205u L=0.04u
M_U873/MI2-M_u3 U873/net10 n817 VDD VDD pch W=0.205u L=0.04u
M_U874/M_u2 n956 n825 U874/net15 VSS nch W=0.155u L=0.04u
M_U874/M_u3 n956 n952 U874/net15 VSS nch W=0.155u L=0.04u
M_U874/M_u4 U874/net15 n807 VSS VSS nch W=0.155u L=0.04u
M_U874/M_u9 n956 n807 VDD VDD pch W=0.205u L=0.04u
M_U874/MI16-MI12 n956 n825 U874/XI16-net11 VDD pch W=0.205u L=0.04u
M_U874/MI16-MI13 U874/XI16-net11 n952 VDD VDD pch W=0.205u L=0.04u
M_U875/M_u2 n807 n824 VSS VSS nch W=0.135u L=0.04u
M_U875/M_u1 n807 n824 VDD VDD pch W=0.205u L=0.04u
M_U876/MI1-M_u4 n825 n824 VSS VSS nch W=0.155u L=0.04u
M_U876/MI1-M_u3 n825 n957 VSS VSS nch W=0.155u L=0.04u
M_U876/MI1-M_u1 U876/XI1-net8 n957 VDD VDD pch W=0.205u L=0.04u
M_U876/MI1-M_u2 n825 n824 U876/XI1-net8 VDD pch W=0.205u L=0.04u
M_U877/M_u6-M_u3 U877/net4 U877/net10 U877/net14 VSS nch W=0.155u L=0.04u
M_U877/MI3-M_u3 U877/net6 n958 U877/net14 VSS nch W=0.155u L=0.04u
M_U877/MI1-M_u2 U877/net4 n959 VSS VSS nch W=0.155u L=0.04u
M_U877/M_u5-M_u2 U877/net6 U877/net4 VSS VSS nch W=0.155u L=0.04u
M_U877/M_u4-M_u2 N10905 U877/net14 VSS VSS nch W=0.155u L=0.04u
M_U877/MI2-M_u2 U877/net10 n958 VSS VSS nch W=0.155u L=0.04u
M_U877/M_u6-M_u2 U877/net4 n958 U877/net14 VDD pch W=0.205u L=0.04u
M_U877/MI3-M_u2 U877/net6 U877/net10 U877/net14 VDD pch W=0.205u L=0.04u
M_U877/MI1-M_u3 U877/net4 n959 VDD VDD pch W=0.205u L=0.04u
M_U877/M_u5-M_u3 U877/net6 U877/net4 VDD VDD pch W=0.205u L=0.04u
M_U877/M_u4-M_u3 N10905 U877/net14 VDD VDD pch W=0.205u L=0.04u
M_U877/MI2-M_u3 U877/net10 n958 VDD VDD pch W=0.205u L=0.04u
M_U878/M_u2 n959 n960 U878/net15 VSS nch W=0.155u L=0.04u
M_U878/M_u3 n959 n952 U878/net15 VSS nch W=0.155u L=0.04u
M_U878/M_u4 U878/net15 n811 VSS VSS nch W=0.155u L=0.04u
M_U878/M_u9 n959 n811 VDD VDD pch W=0.205u L=0.04u
M_U878/MI16-MI12 n959 n960 U878/XI16-net11 VDD pch W=0.205u L=0.04u
M_U878/MI16-MI13 U878/XI16-net11 n952 VDD VDD pch W=0.205u L=0.04u
M_U879/MI1-M_u4 U879/net11 n854 VSS VSS nch W=0.155u L=0.04u
M_U879/MI1-M_u3 U879/net11 n961 VSS VSS nch W=0.155u L=0.04u
M_U879/MU39-M_u4 n952 n804 VSS VSS nch W=0.155u L=0.04u
M_U879/MU39-M_u3 n952 U879/net11 VSS VSS nch W=0.155u L=0.04u
M_U879/MI1-M_u1 U879/XI1-net8 n961 VDD VDD pch W=0.205u L=0.04u
M_U879/MI1-M_u2 U879/net11 n854 U879/XI1-net8 VDD pch W=0.205u L=0.04u
M_U879/MU39-M_u1 U879/XU39-net8 U879/net11 VDD VDD pch W=0.205u L=0.04u
M_U879/MU39-M_u2 n952 n804 U879/XU39-net8 VDD pch W=0.205u L=0.04u
M_U880/M_u2 n960 n821 VSS VSS nch W=0.135u L=0.04u
M_U880/M_u1 n960 n821 VDD VDD pch W=0.205u L=0.04u
M_U881/MU1-M_u4 U881/XU1-net6 n962 VSS VSS nch W=0.155u L=0.04u
M_U881/MU1-M_u3 n821 n811 U881/XU1-net6 VSS nch W=0.155u L=0.04u
M_U881/MU1-M_u2 n821 n962 VDD VDD pch W=0.155u L=0.04u
M_U881/MU1-M_u1 n821 n811 VDD VDD pch W=0.155u L=0.04u
M_U882/M_u6-M_u3 U882/net4 U882/net10 U882/net14 VSS nch W=0.155u L=0.04u
M_U882/MI3-M_u3 U882/net6 n963 U882/net14 VSS nch W=0.155u L=0.04u
M_U882/MI1-M_u2 U882/net4 n852 VSS VSS nch W=0.155u L=0.04u
M_U882/M_u5-M_u2 U882/net6 U882/net4 VSS VSS nch W=0.155u L=0.04u
M_U882/M_u4-M_u2 N10871 U882/net14 VSS VSS nch W=0.155u L=0.04u
M_U882/MI2-M_u2 U882/net10 n963 VSS VSS nch W=0.155u L=0.04u
M_U882/M_u6-M_u2 U882/net4 n963 U882/net14 VDD pch W=0.205u L=0.04u
M_U882/MI3-M_u2 U882/net6 U882/net10 U882/net14 VDD pch W=0.205u L=0.04u
M_U882/MI1-M_u3 U882/net4 n852 VDD VDD pch W=0.205u L=0.04u
M_U882/M_u5-M_u3 U882/net6 U882/net4 VDD VDD pch W=0.205u L=0.04u
M_U882/M_u4-M_u3 N10871 U882/net14 VDD VDD pch W=0.205u L=0.04u
M_U882/MI2-M_u3 U882/net10 n963 VDD VDD pch W=0.205u L=0.04u
M_U883/MI19 U883/net14 n964 U883/net20 VSS nch W=0.155u L=0.04u
M_U883/MI11 U883/net14 n851 U883/net20 VSS nch W=0.155u L=0.04u
M_U883/MI20 U883/net20 n850 VSS VSS nch W=0.155u L=0.04u
M_U883/MI8-M_u2 n963 U883/net14 VSS VSS nch W=0.155u L=0.04u
M_U883/MI8-M_u3 n963 U883/net14 VDD VDD pch W=0.205u L=0.04u
M_U883/M_u2 U883/net14 n850 VDD VDD pch W=0.205u L=0.04u
M_U883/MI17 U883/net24 n964 VDD VDD pch W=0.205u L=0.04u
M_U883/MI18 U883/net14 n851 U883/net24 VDD pch W=0.205u L=0.04u
M_U884/M_u6-M_u3 U884/net4 U884/net10 U884/net14 VSS nch W=0.155u L=0.04u
M_U884/MI3-M_u3 U884/net6 n965 U884/net14 VSS nch W=0.155u L=0.04u
M_U884/MI1-M_u2 U884/net4 n839 VSS VSS nch W=0.155u L=0.04u
M_U884/M_u5-M_u2 U884/net6 U884/net4 VSS VSS nch W=0.155u L=0.04u
M_U884/M_u4-M_u2 N10870 U884/net14 VSS VSS nch W=0.155u L=0.04u
M_U884/MI2-M_u2 U884/net10 n965 VSS VSS nch W=0.155u L=0.04u
M_U884/M_u6-M_u2 U884/net4 n965 U884/net14 VDD pch W=0.205u L=0.04u
M_U884/MI3-M_u2 U884/net6 U884/net10 U884/net14 VDD pch W=0.205u L=0.04u
M_U884/MI1-M_u3 U884/net4 n839 VDD VDD pch W=0.205u L=0.04u
M_U884/M_u5-M_u3 U884/net6 U884/net4 VDD VDD pch W=0.205u L=0.04u
M_U884/M_u4-M_u3 N10870 U884/net14 VDD VDD pch W=0.205u L=0.04u
M_U884/MI2-M_u3 U884/net10 n965 VDD VDD pch W=0.205u L=0.04u
M_U885/MI1-M_u4 n965 n966 VSS VSS nch W=0.155u L=0.04u
M_U885/MI1-M_u3 n965 n843 VSS VSS nch W=0.155u L=0.04u
M_U885/MI1-M_u1 U885/XI1-net8 n843 VDD VDD pch W=0.205u L=0.04u
M_U885/MI1-M_u2 n965 n966 U885/XI1-net8 VDD pch W=0.205u L=0.04u
M_U886/M_u6-M_u3 U886/net4 U886/net10 U886/net14 VSS nch W=0.155u L=0.04u
M_U886/MI3-M_u3 U886/net6 n967 U886/net14 VSS nch W=0.155u L=0.04u
M_U886/MI1-M_u2 U886/net4 n968 VSS VSS nch W=0.155u L=0.04u
M_U886/M_u5-M_u2 U886/net6 U886/net4 VSS VSS nch W=0.155u L=0.04u
M_U886/M_u4-M_u2 N10869 U886/net14 VSS VSS nch W=0.155u L=0.04u
M_U886/MI2-M_u2 U886/net10 n967 VSS VSS nch W=0.155u L=0.04u
M_U886/M_u6-M_u2 U886/net4 n967 U886/net14 VDD pch W=0.205u L=0.04u
M_U886/MI3-M_u2 U886/net6 U886/net10 U886/net14 VDD pch W=0.205u L=0.04u
M_U886/MI1-M_u3 U886/net4 n968 VDD VDD pch W=0.205u L=0.04u
M_U886/M_u5-M_u3 U886/net6 U886/net4 VDD VDD pch W=0.205u L=0.04u
M_U886/M_u4-M_u3 N10869 U886/net14 VDD VDD pch W=0.205u L=0.04u
M_U886/MI2-M_u3 U886/net10 n967 VDD VDD pch W=0.205u L=0.04u
M_U887/MI2 n967 n966 U887/net27 VSS nch W=0.155u L=0.04u
M_U887/MI10 U887/net27 n853 VSS VSS nch W=0.155u L=0.04u
M_U887/MI11 n967 n855 VSS VSS nch W=0.155u L=0.04u
M_U887/MI8 n967 n853 U887/net13 VDD pch W=0.205u L=0.04u
M_U887/M_u2 U887/net13 n855 VDD VDD pch W=0.205u L=0.04u
M_U887/MI9 n967 n966 U887/net13 VDD pch W=0.205u L=0.04u
M_U888/M_u2 n855 n841 VSS VSS nch W=0.135u L=0.04u
M_U888/M_u1 n855 n841 VDD VDD pch W=0.205u L=0.04u
M_U889/MI2 n841 n843 U889/net27 VSS nch W=0.155u L=0.04u
M_U889/MI10 U889/net27 n853 VSS VSS nch W=0.155u L=0.04u
M_U889/MI11 n841 n969 VSS VSS nch W=0.155u L=0.04u
M_U889/MI8 n841 n853 U889/net13 VDD pch W=0.205u L=0.04u
M_U889/M_u2 U889/net13 n969 VDD VDD pch W=0.205u L=0.04u
M_U889/MI9 n841 n843 U889/net13 VDD pch W=0.205u L=0.04u
M_U890/M_u6-M_u3 U890/net4 U890/net10 U890/net14 VSS nch W=0.155u L=0.04u
M_U890/MI3-M_u3 U890/net6 n970 U890/net14 VSS nch W=0.155u L=0.04u
M_U890/MI1-M_u2 U890/net4 n854 VSS VSS nch W=0.155u L=0.04u
M_U890/M_u5-M_u2 U890/net6 U890/net4 VSS VSS nch W=0.155u L=0.04u
M_U890/M_u4-M_u2 N10868 U890/net14 VSS VSS nch W=0.155u L=0.04u
M_U890/MI2-M_u2 U890/net10 n970 VSS VSS nch W=0.155u L=0.04u
M_U890/M_u6-M_u2 U890/net4 n970 U890/net14 VDD pch W=0.205u L=0.04u
M_U890/MI3-M_u2 U890/net6 U890/net10 U890/net14 VDD pch W=0.205u L=0.04u
M_U890/MI1-M_u3 U890/net4 n854 VDD VDD pch W=0.205u L=0.04u
M_U890/M_u5-M_u3 U890/net6 U890/net4 VDD VDD pch W=0.205u L=0.04u
M_U890/M_u4-M_u3 N10868 U890/net14 VDD VDD pch W=0.205u L=0.04u
M_U890/MI2-M_u3 U890/net10 n970 VDD VDD pch W=0.205u L=0.04u
M_U891/MU1-M_u4 n970 n845 VSS VSS nch W=0.155u L=0.04u
M_U891/MU1-M_u3 n970 U891/net4 VSS VSS nch W=0.155u L=0.04u
M_U891/MU6-M_u2 U891/net4 n961 VSS VSS nch W=0.155u L=0.04u
M_U891/MU1-M_u1 U891/XU1-net8 U891/net4 VDD VDD pch W=0.205u L=0.04u
M_U891/MU1-M_u2 n970 n845 U891/XU1-net8 VDD pch W=0.205u L=0.04u
M_U891/MU6-M_u3 U891/net4 n961 VDD VDD pch W=0.205u L=0.04u
M_U892/M_u2 n845 n849 VSS VSS nch W=0.135u L=0.04u
M_U892/M_u1 n845 n849 VDD VDD pch W=0.205u L=0.04u
M_U893/MU1-M_u4 U893/XU1-net6 n844 VSS VSS nch W=0.155u L=0.04u
M_U893/MU1-M_u3 n961 n966 U893/XU1-net6 VSS nch W=0.155u L=0.04u
M_U893/MU1-M_u2 n961 n844 VDD VDD pch W=0.155u L=0.04u
M_U893/MU1-M_u1 n961 n966 VDD VDD pch W=0.155u L=0.04u
M_U894/MI1-M_u4 n966 n840 VSS VSS nch W=0.155u L=0.04u
M_U894/MI1-M_u3 n966 n964 VSS VSS nch W=0.155u L=0.04u
M_U894/MI1-M_u1 U894/XI1-net8 n964 VDD VDD pch W=0.205u L=0.04u
M_U894/MI1-M_u2 n966 n840 U894/XI1-net8 VDD pch W=0.205u L=0.04u
M_U895/M_u6-M_u3 U895/net4 U895/net10 U895/net14 VSS nch W=0.155u L=0.04u
M_U895/MI3-M_u3 U895/net6 n964 U895/net14 VSS nch W=0.155u L=0.04u
M_U895/MI1-M_u2 U895/net4 n851 VSS VSS nch W=0.155u L=0.04u
M_U895/M_u5-M_u2 U895/net6 U895/net4 VSS VSS nch W=0.155u L=0.04u
M_U895/M_u4-M_u2 N10827 U895/net14 VSS VSS nch W=0.155u L=0.04u
M_U895/MI2-M_u2 U895/net10 n964 VSS VSS nch W=0.155u L=0.04u
M_U895/M_u6-M_u2 U895/net4 n964 U895/net14 VDD pch W=0.205u L=0.04u
M_U895/MI3-M_u2 U895/net6 U895/net10 U895/net14 VDD pch W=0.205u L=0.04u
M_U895/MI1-M_u3 U895/net4 n851 VDD VDD pch W=0.205u L=0.04u
M_U895/M_u5-M_u3 U895/net6 U895/net4 VDD VDD pch W=0.205u L=0.04u
M_U895/M_u4-M_u3 N10827 U895/net14 VDD VDD pch W=0.205u L=0.04u
M_U895/MI2-M_u3 U895/net10 n964 VDD VDD pch W=0.205u L=0.04u
M_U896/M_u6-M_u3 U896/net4 U896/net10 U896/net14 VSS nch W=0.155u L=0.04u
M_U896/MI3-M_u3 U896/net6 n971 U896/net14 VSS nch W=0.155u L=0.04u
M_U896/MI1-M_u2 U896/net4 n891 VSS VSS nch W=0.155u L=0.04u
M_U896/M_u5-M_u2 U896/net6 U896/net4 VSS VSS nch W=0.155u L=0.04u
M_U896/M_u4-M_u2 N10781 U896/net14 VSS VSS nch W=0.155u L=0.04u
M_U896/MI2-M_u2 U896/net10 n971 VSS VSS nch W=0.155u L=0.04u
M_U896/M_u6-M_u2 U896/net4 n971 U896/net14 VDD pch W=0.205u L=0.04u
M_U896/MI3-M_u2 U896/net6 U896/net10 U896/net14 VDD pch W=0.205u L=0.04u
M_U896/MI1-M_u3 U896/net4 n891 VDD VDD pch W=0.205u L=0.04u
M_U896/M_u5-M_u3 U896/net6 U896/net4 VDD VDD pch W=0.205u L=0.04u
M_U896/M_u4-M_u3 N10781 U896/net14 VDD VDD pch W=0.205u L=0.04u
M_U896/MI2-M_u3 U896/net10 n971 VDD VDD pch W=0.205u L=0.04u
M_U897/M_u6-M_u3 U897/net4 U897/net10 U897/net14 VSS nch W=0.155u L=0.04u
M_U897/MI3-M_u3 U897/net6 n972 U897/net14 VSS nch W=0.155u L=0.04u
M_U897/MI1-M_u2 U897/net4 n892 VSS VSS nch W=0.155u L=0.04u
M_U897/M_u5-M_u2 U897/net6 U897/net4 VSS VSS nch W=0.155u L=0.04u
M_U897/M_u4-M_u2 N10778 U897/net14 VSS VSS nch W=0.155u L=0.04u
M_U897/MI2-M_u2 U897/net10 n972 VSS VSS nch W=0.155u L=0.04u
M_U897/M_u6-M_u2 U897/net4 n972 U897/net14 VDD pch W=0.205u L=0.04u
M_U897/MI3-M_u2 U897/net6 U897/net10 U897/net14 VDD pch W=0.205u L=0.04u
M_U897/MI1-M_u3 U897/net4 n892 VDD VDD pch W=0.205u L=0.04u
M_U897/M_u5-M_u3 U897/net6 U897/net4 VDD VDD pch W=0.205u L=0.04u
M_U897/M_u4-M_u3 N10778 U897/net14 VDD VDD pch W=0.205u L=0.04u
M_U897/MI2-M_u3 U897/net10 n972 VDD VDD pch W=0.205u L=0.04u
M_U898/MI2 n972 n973 U898/net27 VSS nch W=0.155u L=0.04u
M_U898/MI10 U898/net27 n890 VSS VSS nch W=0.155u L=0.04u
M_U898/MI11 n972 n974 VSS VSS nch W=0.155u L=0.04u
M_U898/MI8 n972 n890 U898/net13 VDD pch W=0.205u L=0.04u
M_U898/M_u2 U898/net13 n974 VDD VDD pch W=0.205u L=0.04u
M_U898/MI9 n972 n973 U898/net13 VDD pch W=0.205u L=0.04u
M_U899/M_u6-M_u3 U899/net4 U899/net10 U899/net14 VSS nch W=0.155u L=0.04u
M_U899/MI3-M_u3 U899/net6 n975 U899/net14 VSS nch W=0.155u L=0.04u
M_U899/MI1-M_u2 U899/net4 n949 VSS VSS nch W=0.155u L=0.04u
M_U899/M_u5-M_u2 U899/net6 U899/net4 VSS VSS nch W=0.155u L=0.04u
M_U899/M_u4-M_u2 N10763 U899/net14 VSS VSS nch W=0.155u L=0.04u
M_U899/MI2-M_u2 U899/net10 n975 VSS VSS nch W=0.155u L=0.04u
M_U899/M_u6-M_u2 U899/net4 n975 U899/net14 VDD pch W=0.205u L=0.04u
M_U899/MI3-M_u2 U899/net6 U899/net10 U899/net14 VDD pch W=0.205u L=0.04u
M_U899/MI1-M_u3 U899/net4 n949 VDD VDD pch W=0.205u L=0.04u
M_U899/M_u5-M_u3 U899/net6 U899/net4 VDD VDD pch W=0.205u L=0.04u
M_U899/M_u4-M_u3 N10763 U899/net14 VDD VDD pch W=0.205u L=0.04u
M_U899/MI2-M_u3 U899/net10 n975 VDD VDD pch W=0.205u L=0.04u
M_U900/MI15-M_u2 U900/net19 n975 VSS VSS nch W=0.155u L=0.04u
M_U900/MI21 N10762 n975 U900/net40 VSS nch W=0.155u L=0.04u
M_U900/MI12 N10762 U900/net19 U900/net36 VSS nch W=0.155u L=0.04u
M_U900/MI20 U900/net40 n901 VSS VSS nch W=0.31u L=0.04u
M_U900/MI19 U900/net36 n976 VSS VSS nch W=0.155u L=0.04u
M_U900/MI15-M_u3 U900/net19 n975 VDD VDD pch W=0.205u L=0.04u
M_U900/MI25 N10762 U900/net19 U900/net26 VDD pch W=0.325u L=0.04u
M_U900/MI24 U900/net26 n901 VDD VDD pch W=0.41u L=0.04u
M_U900/MI5 N10762 n975 U900/net30 VDD pch W=0.325u L=0.04u
M_U900/MI111 U900/net30 n976 VDD VDD pch W=0.205u L=0.04u
M_U901/M_u6-M_u3 U901/net4 U901/net10 U901/net14 VSS nch W=0.155u L=0.04u
M_U901/MI3-M_u3 U901/net6 n945 U901/net14 VSS nch W=0.155u L=0.04u
M_U901/MI1-M_u2 U901/net4 n977 VSS VSS nch W=0.155u L=0.04u
M_U901/M_u5-M_u2 U901/net6 U901/net4 VSS VSS nch W=0.155u L=0.04u
M_U901/M_u4-M_u2 n901 U901/net14 VSS VSS nch W=0.155u L=0.04u
M_U901/MI2-M_u2 U901/net10 n945 VSS VSS nch W=0.155u L=0.04u
M_U901/M_u6-M_u2 U901/net4 n945 U901/net14 VDD pch W=0.205u L=0.04u
M_U901/MI3-M_u2 U901/net6 U901/net10 U901/net14 VDD pch W=0.205u L=0.04u
M_U901/MI1-M_u3 U901/net4 n977 VDD VDD pch W=0.205u L=0.04u
M_U901/M_u5-M_u3 U901/net6 U901/net4 VDD VDD pch W=0.205u L=0.04u
M_U901/M_u4-M_u3 n901 U901/net14 VDD VDD pch W=0.205u L=0.04u
M_U901/MI2-M_u3 U901/net10 n945 VDD VDD pch W=0.205u L=0.04u
M_U902/M_u2 n945 n978 VSS VSS nch W=0.135u L=0.04u
M_U902/M_u1 n945 n978 VDD VDD pch W=0.205u L=0.04u
M_U903/M_u6-M_u3 U903/net4 U903/net10 U903/net14 VSS nch W=0.155u L=0.04u
M_U903/MI3-M_u3 U903/net6 n978 U903/net14 VSS nch W=0.155u L=0.04u
M_U903/MI1-M_u2 U903/net4 n948 VSS VSS nch W=0.155u L=0.04u
M_U903/M_u5-M_u2 U903/net6 U903/net4 VSS VSS nch W=0.155u L=0.04u
M_U903/M_u4-M_u2 n976 U903/net14 VSS VSS nch W=0.155u L=0.04u
M_U903/MI2-M_u2 U903/net10 n978 VSS VSS nch W=0.155u L=0.04u
M_U903/M_u6-M_u2 U903/net4 n978 U903/net14 VDD pch W=0.205u L=0.04u
M_U903/MI3-M_u2 U903/net6 U903/net10 U903/net14 VDD pch W=0.205u L=0.04u
M_U903/MI1-M_u3 U903/net4 n948 VDD VDD pch W=0.205u L=0.04u
M_U903/M_u5-M_u3 U903/net6 U903/net4 VDD VDD pch W=0.205u L=0.04u
M_U903/M_u4-M_u3 n976 U903/net14 VDD VDD pch W=0.205u L=0.04u
M_U903/MI2-M_u3 U903/net10 n978 VDD VDD pch W=0.205u L=0.04u
M_U904/MI0-M_u3 U904/net4 n979 U904/net14 VSS nch W=0.155u L=0.04u
M_U904/M_u7-M_u3 U904/net6 U904/net10 U904/net14 VSS nch W=0.17u L=0.04u
M_U904/M_u2-M_u2 U904/net4 n903 VSS VSS nch W=0.155u L=0.04u
M_U904/M_u5-M_u2 U904/net6 U904/net4 VSS VSS nch W=0.17u L=0.04u
M_U904/M_u4-M_u2 N10761 U904/net14 VSS VSS nch W=0.155u L=0.04u
M_U904/M_u8-M_u2 U904/net10 n979 VSS VSS nch W=0.155u L=0.04u
M_U904/MI0-M_u2 U904/net4 U904/net10 U904/net14 VDD pch W=0.255u L=0.04u
M_U904/M_u7-M_u2 U904/net6 n979 U904/net14 VDD pch W=0.28u L=0.04u
M_U904/M_u2-M_u3 U904/net4 n903 VDD VDD pch W=0.205u L=0.04u
M_U904/M_u5-M_u3 U904/net6 U904/net4 VDD VDD pch W=0.24u L=0.04u
M_U904/M_u4-M_u3 N10761 U904/net14 VDD VDD pch W=0.205u L=0.04u
M_U904/M_u8-M_u3 U904/net10 n979 VDD VDD pch W=0.205u L=0.04u
M_U905/MI1-M_u4 U905/net11 n975 VSS VSS nch W=0.155u L=0.04u
M_U905/MI1-M_u3 U905/net11 n947 VSS VSS nch W=0.155u L=0.04u
M_U905/MU39-M_u4 n979 n906 VSS VSS nch W=0.155u L=0.04u
M_U905/MU39-M_u3 n979 U905/net11 VSS VSS nch W=0.155u L=0.04u
M_U905/MI1-M_u1 U905/XI1-net8 n947 VDD VDD pch W=0.205u L=0.04u
M_U905/MI1-M_u2 U905/net11 n975 U905/XI1-net8 VDD pch W=0.205u L=0.04u
M_U905/MU39-M_u1 U905/XU39-net8 U905/net11 VDD VDD pch W=0.205u L=0.04u
M_U905/MU39-M_u2 n979 n906 U905/XU39-net8 VDD pch W=0.205u L=0.04u
M_U906/MI1-M_u4 n947 n906 VSS VSS nch W=0.155u L=0.04u
M_U906/MI1-M_u3 n947 n980 VSS VSS nch W=0.155u L=0.04u
M_U906/MI1-M_u1 U906/XI1-net8 n980 VDD VDD pch W=0.205u L=0.04u
M_U906/MI1-M_u2 n947 n906 U906/XI1-net8 VDD pch W=0.205u L=0.04u
M_U907/MI0-M_u3 U907/net4 n981 U907/net14 VSS nch W=0.155u L=0.04u
M_U907/M_u7-M_u3 U907/net6 U907/net10 U907/net14 VSS nch W=0.17u L=0.04u
M_U907/M_u2-M_u2 U907/net4 n950 VSS VSS nch W=0.155u L=0.04u
M_U907/M_u5-M_u2 U907/net6 U907/net4 VSS VSS nch W=0.17u L=0.04u
M_U907/M_u4-M_u2 N10760 U907/net14 VSS VSS nch W=0.155u L=0.04u
M_U907/M_u8-M_u2 U907/net10 n981 VSS VSS nch W=0.155u L=0.04u
M_U907/MI0-M_u2 U907/net4 U907/net10 U907/net14 VDD pch W=0.255u L=0.04u
M_U907/M_u7-M_u2 U907/net6 n981 U907/net14 VDD pch W=0.28u L=0.04u
M_U907/M_u2-M_u3 U907/net4 n950 VDD VDD pch W=0.205u L=0.04u
M_U907/M_u5-M_u3 U907/net6 U907/net4 VDD VDD pch W=0.24u L=0.04u
M_U907/M_u4-M_u3 N10760 U907/net14 VDD VDD pch W=0.205u L=0.04u
M_U907/M_u8-M_u3 U907/net10 n981 VDD VDD pch W=0.205u L=0.04u
M_U908/MI2 n981 n982 U908/net27 VSS nch W=0.155u L=0.04u
M_U908/MI10 U908/net27 n946 VSS VSS nch W=0.155u L=0.04u
M_U908/MI11 n981 n905 VSS VSS nch W=0.155u L=0.04u
M_U908/MI8 n981 n946 U908/net13 VDD pch W=0.205u L=0.04u
M_U908/M_u2 U908/net13 n905 VDD VDD pch W=0.205u L=0.04u
M_U908/MI9 n981 n982 U908/net13 VDD pch W=0.205u L=0.04u
M_U909/MU1-M_u2 n946 U909/net7 VSS VSS nch W=0.155u L=0.04u
M_U909/M_u7-M_u4 U909/net7 n983 VSS VSS nch W=0.155u L=0.04u
M_U909/M_u7-M_u3 U909/net7 n905 VSS VSS nch W=0.155u L=0.04u
M_U909/MU1-M_u3 n946 U909/net7 VDD VDD pch W=0.205u L=0.04u
M_U909/M_u7-M_u1 U909/X_u7-net8 n905 VDD VDD pch W=0.205u L=0.04u
M_U909/M_u7-M_u2 U909/net7 n983 U909/X_u7-net8 VDD pch W=0.205u L=0.04u
M_U910/M_u2 n982 n975 VSS VSS nch W=0.135u L=0.04u
M_U910/M_u1 n982 n975 VDD VDD pch W=0.205u L=0.04u
M_U911/MI1-M_u4 U911/net11 n942 VSS VSS nch W=0.155u L=0.04u
M_U911/MI1-M_u3 U911/net11 n984 VSS VSS nch W=0.155u L=0.04u
M_U911/MU39-M_u4 n975 n898 VSS VSS nch W=0.155u L=0.04u
M_U911/MU39-M_u3 n975 U911/net11 VSS VSS nch W=0.155u L=0.04u
M_U911/MI1-M_u1 U911/XI1-net8 n984 VDD VDD pch W=0.205u L=0.04u
M_U911/MI1-M_u2 U911/net11 n942 U911/XI1-net8 VDD pch W=0.205u L=0.04u
M_U911/MU39-M_u1 U911/XU39-net8 U911/net11 VDD VDD pch W=0.205u L=0.04u
M_U911/MU39-M_u2 n975 n898 U911/XU39-net8 VDD pch W=0.205u L=0.04u
M_U912/MU8-M_u4 U912/net14 N10575 VSS VSS nch W=0.155u L=0.04u
M_U912/MU8-M_u3 U912/net14 N10576 VSS VSS nch W=0.155u L=0.04u
M_U912/MU8-M_u5 U912/net14 N10574 VSS VSS nch W=0.155u L=0.04u
M_U912/MU8-M_u8 U912/net14 n985 VSS VSS nch W=0.155u L=0.04u
M_U912/M_u3-M_u2 N10729 U912/net14 VSS VSS nch W=0.155u L=0.04u
M_U912/MU8-M_u7 U912/net14 n985 U912/XU8-net7 VDD pch W=0.205u L=0.04u
M_U912/MU8-M_u6 U912/XU8-net7 N10574 U912/XU8-net10 VDD pch W=0.205u L=0.04u
M_U912/MU8-M_u2 U912/XU8-net10 N10576 U912/XU8-net13 VDD pch W=0.205u L=0.04u
M_U912/MU8-M_u1 U912/XU8-net13 N10575 VDD VDD pch W=0.205u L=0.04u
M_U912/M_u3-M_u3 N10729 U912/net14 VDD VDD pch W=0.205u L=0.04u
M_U913/MU8-M_u4 U913/net14 N885 VSS VSS nch W=0.155u L=0.04u
M_U913/MU8-M_u3 U913/net14 N884 VSS VSS nch W=0.155u L=0.04u
M_U913/MU8-M_u5 U913/net14 N883 VSS VSS nch W=0.155u L=0.04u
M_U913/MU8-M_u8 U913/net14 N882 VSS VSS nch W=0.155u L=0.04u
M_U913/M_u3-M_u2 n985 U913/net14 VSS VSS nch W=0.155u L=0.04u
M_U913/MU8-M_u7 U913/net14 N882 U913/XU8-net7 VDD pch W=0.205u L=0.04u
M_U913/MU8-M_u6 U913/XU8-net7 N883 U913/XU8-net10 VDD pch W=0.205u L=0.04u
M_U913/MU8-M_u2 U913/XU8-net10 N884 U913/XU8-net13 VDD pch W=0.205u L=0.04u
M_U913/MU8-M_u1 U913/XU8-net13 N885 VDD VDD pch W=0.205u L=0.04u
M_U913/M_u3-M_u3 n985 U913/net14 VDD VDD pch W=0.205u L=0.04u
M_U914/MI19 U914/p2 N150 VSS VSS nch W=0.155u L=0.04u
M_U914/MI17 U914/p0 N228 U914/p1 VSS nch W=0.155u L=0.04u
M_U914/MI18 U914/p1 N184 U914/p2 VSS nch W=0.155u L=0.04u
M_U914/MU53 N882 N240 U914/p0 VSS nch W=0.155u L=0.04u
M_U914/MI14 N882 N184 VDD VDD pch W=0.205u L=0.04u
M_U914/MI15 N882 N228 VDD VDD pch W=0.205u L=0.04u
M_U914/MI16 N882 N240 VDD VDD pch W=0.205u L=0.04u
M_U914/MI9 N882 N150 VDD VDD pch W=0.205u L=0.04u
M_U915/MI19 U915/p2 N152 VSS VSS nch W=0.155u L=0.04u
M_U915/MI17 U915/p0 N218 U915/p1 VSS nch W=0.155u L=0.04u
M_U915/MI18 U915/p1 N210 U915/p2 VSS nch W=0.155u L=0.04u
M_U915/MU53 N883 N230 U915/p0 VSS nch W=0.155u L=0.04u
M_U915/MI14 N883 N210 VDD VDD pch W=0.205u L=0.04u
M_U915/MI15 N883 N218 VDD VDD pch W=0.205u L=0.04u
M_U915/MI16 N883 N230 VDD VDD pch W=0.205u L=0.04u
M_U915/MI9 N883 N152 VDD VDD pch W=0.205u L=0.04u
M_U916/MI19 U916/p2 N182 VSS VSS nch W=0.155u L=0.04u
M_U916/MI17 U916/p0 N185 U916/p1 VSS nch W=0.155u L=0.04u
M_U916/MI18 U916/p1 N183 U916/p2 VSS nch W=0.155u L=0.04u
M_U916/MU53 N884 N186 U916/p0 VSS nch W=0.155u L=0.04u
M_U916/MI14 N884 N183 VDD VDD pch W=0.205u L=0.04u
M_U916/MI15 N884 N185 VDD VDD pch W=0.205u L=0.04u
M_U916/MI16 N884 N186 VDD VDD pch W=0.205u L=0.04u
M_U916/MI9 N884 N182 VDD VDD pch W=0.205u L=0.04u
M_U917/MI19 U917/p2 N162 VSS VSS nch W=0.155u L=0.04u
M_U917/MI17 U917/p0 N188 U917/p1 VSS nch W=0.155u L=0.04u
M_U917/MI18 U917/p1 N172 U917/p2 VSS nch W=0.155u L=0.04u
M_U917/MU53 N885 N199 U917/p0 VSS nch W=0.155u L=0.04u
M_U917/MI14 N885 N172 VDD VDD pch W=0.205u L=0.04u
M_U917/MI15 N885 N188 VDD VDD pch W=0.205u L=0.04u
M_U917/MI16 N885 N199 VDD VDD pch W=0.205u L=0.04u
M_U917/MI9 N885 N162 VDD VDD pch W=0.205u L=0.04u
M_U918/MI0-M_u3 U918/net4 n882 U918/net14 VSS nch W=0.155u L=0.04u
M_U918/M_u7-M_u3 U918/net6 U918/net10 U918/net14 VSS nch W=0.17u L=0.04u
M_U918/M_u2-M_u2 U918/net4 n986 VSS VSS nch W=0.155u L=0.04u
M_U918/M_u5-M_u2 U918/net6 U918/net4 VSS VSS nch W=0.17u L=0.04u
M_U918/M_u4-M_u2 N10718 U918/net14 VSS VSS nch W=0.155u L=0.04u
M_U918/M_u8-M_u2 U918/net10 n882 VSS VSS nch W=0.155u L=0.04u
M_U918/MI0-M_u2 U918/net4 U918/net10 U918/net14 VDD pch W=0.255u L=0.04u
M_U918/M_u7-M_u2 U918/net6 n882 U918/net14 VDD pch W=0.28u L=0.04u
M_U918/M_u2-M_u3 U918/net4 n986 VDD VDD pch W=0.205u L=0.04u
M_U918/M_u5-M_u3 U918/net6 U918/net4 VDD VDD pch W=0.24u L=0.04u
M_U918/M_u4-M_u3 N10718 U918/net14 VDD VDD pch W=0.205u L=0.04u
M_U918/M_u8-M_u3 U918/net10 n882 VDD VDD pch W=0.205u L=0.04u
M_U919/M_u2 n986 n987 U919/net15 VSS nch W=0.155u L=0.04u
M_U919/M_u3 n986 n881 U919/net15 VSS nch W=0.155u L=0.04u
M_U919/M_u4 U919/net15 n867 VSS VSS nch W=0.155u L=0.04u
M_U919/M_u9 n986 n867 VDD VDD pch W=0.205u L=0.04u
M_U919/MI16-MI12 n986 n987 U919/XI16-net11 VDD pch W=0.205u L=0.04u
M_U919/MI16-MI13 U919/XI16-net11 n881 VDD VDD pch W=0.205u L=0.04u
M_U920/MI0-M_u3 U920/net4 n988 U920/net14 VSS nch W=0.155u L=0.04u
M_U920/M_u7-M_u3 U920/net6 U920/net10 U920/net14 VSS nch W=0.17u L=0.04u
M_U920/M_u2-M_u2 U920/net4 n869 VSS VSS nch W=0.155u L=0.04u
M_U920/M_u5-M_u2 U920/net6 U920/net4 VSS VSS nch W=0.17u L=0.04u
M_U920/M_u4-M_u2 N10717 U920/net14 VSS VSS nch W=0.155u L=0.04u
M_U920/M_u8-M_u2 U920/net10 n988 VSS VSS nch W=0.155u L=0.04u
M_U920/MI0-M_u2 U920/net4 U920/net10 U920/net14 VDD pch W=0.255u L=0.04u
M_U920/M_u7-M_u2 U920/net6 n988 U920/net14 VDD pch W=0.28u L=0.04u
M_U920/M_u2-M_u3 U920/net4 n869 VDD VDD pch W=0.205u L=0.04u
M_U920/M_u5-M_u3 U920/net6 U920/net4 VDD VDD pch W=0.24u L=0.04u
M_U920/M_u4-M_u3 N10717 U920/net14 VDD VDD pch W=0.205u L=0.04u
M_U920/M_u8-M_u3 U920/net10 n988 VDD VDD pch W=0.205u L=0.04u
M_U921/MI1-M_u4 n988 n989 VSS VSS nch W=0.155u L=0.04u
M_U921/MI1-M_u3 n988 n870 VSS VSS nch W=0.155u L=0.04u
M_U921/MI1-M_u1 U921/XI1-net8 n870 VDD VDD pch W=0.205u L=0.04u
M_U921/MI1-M_u2 n988 n989 U921/XI1-net8 VDD pch W=0.205u L=0.04u
M_U922/M_u6-M_u3 U922/net4 U922/net10 U922/net14 VSS nch W=0.155u L=0.04u
M_U922/MI3-M_u3 U922/net6 n990 U922/net14 VSS nch W=0.155u L=0.04u
M_U922/MI1-M_u2 U922/net4 n873 VSS VSS nch W=0.155u L=0.04u
M_U922/M_u5-M_u2 U922/net6 U922/net4 VSS VSS nch W=0.155u L=0.04u
M_U922/M_u4-M_u2 N10716 U922/net14 VSS VSS nch W=0.155u L=0.04u
M_U922/MI2-M_u2 U922/net10 n990 VSS VSS nch W=0.155u L=0.04u
M_U922/M_u6-M_u2 U922/net4 n990 U922/net14 VDD pch W=0.205u L=0.04u
M_U922/MI3-M_u2 U922/net6 U922/net10 U922/net14 VDD pch W=0.205u L=0.04u
M_U922/MI1-M_u3 U922/net4 n873 VDD VDD pch W=0.205u L=0.04u
M_U922/M_u5-M_u3 U922/net6 U922/net4 VDD VDD pch W=0.205u L=0.04u
M_U922/M_u4-M_u3 N10716 U922/net14 VDD VDD pch W=0.205u L=0.04u
M_U922/MI2-M_u3 U922/net10 n990 VDD VDD pch W=0.205u L=0.04u
M_U923/MI2 n990 n989 U923/net27 VSS nch W=0.155u L=0.04u
M_U923/MI10 U923/net27 n869 VSS VSS nch W=0.155u L=0.04u
M_U923/MI11 n990 n862 VSS VSS nch W=0.155u L=0.04u
M_U923/MI8 n990 n869 U923/net13 VDD pch W=0.205u L=0.04u
M_U923/M_u2 U923/net13 n862 VDD VDD pch W=0.205u L=0.04u
M_U923/MI9 n990 n989 U923/net13 VDD pch W=0.205u L=0.04u
M_U924/MI12 U924/net32 n869 VSS VSS nch W=0.155u L=0.04u
M_U924/MI11 U924/net59 n870 U924/net32 VSS nch W=0.155u L=0.04u
M_U924/MI6 U924/net59 n991 VSS VSS nch W=0.155u L=0.04u
M_U924/MI8-M_u2 n862 U924/net59 VSS VSS nch W=0.155u L=0.04u
M_U924/MI8-M_u3 n862 U924/net59 VDD VDD pch W=0.2u L=0.04u
M_U924/MI10 U924/net59 n870 U924/net22 VDD pch W=0.205u L=0.04u
M_U924/MI9 U924/net59 n869 U924/net22 VDD pch W=0.205u L=0.04u
M_U924/M_u2 U924/net22 n991 VDD VDD pch W=0.2u L=0.04u
M_U925/M_u6-M_u3 U925/net4 U925/net10 U925/net14 VSS nch W=0.155u L=0.04u
M_U925/MI3-M_u3 U925/net6 n992 U925/net14 VSS nch W=0.155u L=0.04u
M_U925/MI1-M_u2 U925/net4 n874 VSS VSS nch W=0.155u L=0.04u
M_U925/M_u5-M_u2 U925/net6 U925/net4 VSS VSS nch W=0.155u L=0.04u
M_U925/M_u4-M_u2 N10715 U925/net14 VSS VSS nch W=0.155u L=0.04u
M_U925/MI2-M_u2 U925/net10 n992 VSS VSS nch W=0.155u L=0.04u
M_U925/M_u6-M_u2 U925/net4 n992 U925/net14 VDD pch W=0.205u L=0.04u
M_U925/MI3-M_u2 U925/net6 U925/net10 U925/net14 VDD pch W=0.205u L=0.04u
M_U925/MI1-M_u3 U925/net4 n874 VDD VDD pch W=0.205u L=0.04u
M_U925/M_u5-M_u3 U925/net6 U925/net4 VDD VDD pch W=0.205u L=0.04u
M_U925/M_u4-M_u3 N10715 U925/net14 VDD VDD pch W=0.205u L=0.04u
M_U925/MI2-M_u3 U925/net10 n992 VDD VDD pch W=0.205u L=0.04u
M_U926/MU1-M_u4 n992 n884 VSS VSS nch W=0.155u L=0.04u
M_U926/MU1-M_u3 n992 U926/net4 VSS VSS nch W=0.155u L=0.04u
M_U926/MU6-M_u2 U926/net4 n993 VSS VSS nch W=0.155u L=0.04u
M_U926/MU1-M_u1 U926/XU1-net8 U926/net4 VDD VDD pch W=0.205u L=0.04u
M_U926/MU1-M_u2 n992 n884 U926/XU1-net8 VDD pch W=0.205u L=0.04u
M_U926/MU6-M_u3 U926/net4 n993 VDD VDD pch W=0.205u L=0.04u
M_U927/M_u2 n884 n868 VSS VSS nch W=0.135u L=0.04u
M_U927/M_u1 n884 n868 VDD VDD pch W=0.205u L=0.04u
M_U928/M_u6-M_u3 U928/net4 U928/net10 U928/net14 VSS nch W=0.155u L=0.04u
M_U928/MI3-M_u3 U928/net6 n994 U928/net14 VSS nch W=0.155u L=0.04u
M_U928/MI1-M_u2 U928/net4 n941 VSS VSS nch W=0.155u L=0.04u
M_U928/M_u5-M_u2 U928/net6 U928/net4 VSS VSS nch W=0.155u L=0.04u
M_U928/M_u4-M_u2 N10714 U928/net14 VSS VSS nch W=0.155u L=0.04u
M_U928/MI2-M_u2 U928/net10 n994 VSS VSS nch W=0.155u L=0.04u
M_U928/M_u6-M_u2 U928/net4 n994 U928/net14 VDD pch W=0.205u L=0.04u
M_U928/MI3-M_u2 U928/net6 U928/net10 U928/net14 VDD pch W=0.205u L=0.04u
M_U928/MI1-M_u3 U928/net4 n941 VDD VDD pch W=0.205u L=0.04u
M_U928/M_u5-M_u3 U928/net6 U928/net4 VDD VDD pch W=0.205u L=0.04u
M_U928/M_u4-M_u3 N10714 U928/net14 VDD VDD pch W=0.205u L=0.04u
M_U928/MI2-M_u3 U928/net10 n994 VDD VDD pch W=0.205u L=0.04u
M_U929/MI2 n994 n937 U929/net27 VSS nch W=0.155u L=0.04u
M_U929/MI10 U929/net27 n995 VSS VSS nch W=0.155u L=0.04u
M_U929/MI11 n994 n918 VSS VSS nch W=0.155u L=0.04u
M_U929/MI8 n994 n995 U929/net13 VDD pch W=0.205u L=0.04u
M_U929/M_u2 U929/net13 n918 VDD VDD pch W=0.205u L=0.04u
M_U929/MI9 n994 n937 U929/net13 VDD pch W=0.205u L=0.04u
M_U930/M_u6-M_u3 U930/net4 U930/net10 U930/net14 VSS nch W=0.155u L=0.04u
M_U930/MI3-M_u3 U930/net6 n996 U930/net14 VSS nch W=0.155u L=0.04u
M_U930/MI1-M_u2 U930/net4 n997 VSS VSS nch W=0.155u L=0.04u
M_U930/M_u5-M_u2 U930/net6 U930/net4 VSS VSS nch W=0.155u L=0.04u
M_U930/M_u4-M_u2 N10713 U930/net14 VSS VSS nch W=0.155u L=0.04u
M_U930/MI2-M_u2 U930/net10 n996 VSS VSS nch W=0.155u L=0.04u
M_U930/M_u6-M_u2 U930/net4 n996 U930/net14 VDD pch W=0.205u L=0.04u
M_U930/MI3-M_u2 U930/net6 U930/net10 U930/net14 VDD pch W=0.205u L=0.04u
M_U930/MI1-M_u3 U930/net4 n997 VDD VDD pch W=0.205u L=0.04u
M_U930/M_u5-M_u3 U930/net6 U930/net4 VDD VDD pch W=0.205u L=0.04u
M_U930/M_u4-M_u3 N10713 U930/net14 VDD VDD pch W=0.205u L=0.04u
M_U930/MI2-M_u3 U930/net10 n996 VDD VDD pch W=0.205u L=0.04u
M_U931/MI1-M_u4 n996 n998 VSS VSS nch W=0.155u L=0.04u
M_U931/MI1-M_u3 n996 n928 VSS VSS nch W=0.155u L=0.04u
M_U931/MI1-M_u1 U931/XI1-net8 n928 VDD VDD pch W=0.205u L=0.04u
M_U931/MI1-M_u2 n996 n998 U931/XI1-net8 VDD pch W=0.205u L=0.04u
M_U932/MI0-M_u3 U932/net4 n999 U932/net14 VSS nch W=0.155u L=0.04u
M_U932/M_u7-M_u3 U932/net6 U932/net10 U932/net14 VSS nch W=0.17u L=0.04u
M_U932/M_u2-M_u2 U932/net4 n912 VSS VSS nch W=0.155u L=0.04u
M_U932/M_u5-M_u2 U932/net6 U932/net4 VSS VSS nch W=0.17u L=0.04u
M_U932/M_u4-M_u2 N10712 U932/net14 VSS VSS nch W=0.155u L=0.04u
M_U932/M_u8-M_u2 U932/net10 n999 VSS VSS nch W=0.155u L=0.04u
M_U932/MI0-M_u2 U932/net4 U932/net10 U932/net14 VDD pch W=0.255u L=0.04u
M_U932/M_u7-M_u2 U932/net6 n999 U932/net14 VDD pch W=0.28u L=0.04u
M_U932/M_u2-M_u3 U932/net4 n912 VDD VDD pch W=0.205u L=0.04u
M_U932/M_u5-M_u3 U932/net6 U932/net4 VDD VDD pch W=0.24u L=0.04u
M_U932/M_u4-M_u3 N10712 U932/net14 VDD VDD pch W=0.205u L=0.04u
M_U932/M_u8-M_u3 U932/net10 n999 VDD VDD pch W=0.205u L=0.04u
M_U933/M_u2 n912 n925 VSS VSS nch W=0.135u L=0.04u
M_U933/M_u1 n912 n925 VDD VDD pch W=0.205u L=0.04u
M_U934/MI2 n999 n998 U934/net27 VSS nch W=0.155u L=0.04u
M_U934/MI10 U934/net27 n935 VSS VSS nch W=0.155u L=0.04u
M_U934/MI11 n999 n927 VSS VSS nch W=0.155u L=0.04u
M_U934/MI8 n999 n935 U934/net13 VDD pch W=0.205u L=0.04u
M_U934/M_u2 U934/net13 n927 VDD VDD pch W=0.205u L=0.04u
M_U934/MI9 n999 n998 U934/net13 VDD pch W=0.205u L=0.04u
M_U935/MI8 U935/net36 n926 U935/net24 VSS nch W=0.155u L=0.04u
M_U935/MI9 U935/net24 n1000 VSS VSS nch W=0.155u L=0.04u
M_U935/M_u2 n927 n997 U935/net36 VSS nch W=0.155u L=0.04u
M_U935/MI7 n927 n924 U935/net36 VSS nch W=0.155u L=0.04u
M_U935/MI6 n927 n924 U935/net35 VDD pch W=0.205u L=0.04u
M_U935/MI5 U935/net35 n997 VDD VDD pch W=0.205u L=0.04u
M_U935/MI4 n927 n1000 VDD VDD pch W=0.205u L=0.04u
M_U935/M_u12 n927 n926 VDD VDD pch W=0.205u L=0.04u
M_U936/M_u6-M_u3 U936/net4 U936/net10 U936/net14 VSS nch W=0.155u L=0.04u
M_U936/MI3-M_u3 U936/net6 n1001 U936/net14 VSS nch W=0.155u L=0.04u
M_U936/MI1-M_u2 U936/net4 n942 VSS VSS nch W=0.155u L=0.04u
M_U936/M_u5-M_u2 U936/net6 U936/net4 VSS VSS nch W=0.155u L=0.04u
M_U936/M_u4-M_u2 N10711 U936/net14 VSS VSS nch W=0.155u L=0.04u
M_U936/MI2-M_u2 U936/net10 n1001 VSS VSS nch W=0.155u L=0.04u
M_U936/M_u6-M_u2 U936/net4 n1001 U936/net14 VDD pch W=0.205u L=0.04u
M_U936/MI3-M_u2 U936/net6 U936/net10 U936/net14 VDD pch W=0.205u L=0.04u
M_U936/MI1-M_u3 U936/net4 n942 VDD VDD pch W=0.205u L=0.04u
M_U936/M_u5-M_u3 U936/net6 U936/net4 VDD VDD pch W=0.205u L=0.04u
M_U936/M_u4-M_u3 N10711 U936/net14 VDD VDD pch W=0.205u L=0.04u
M_U936/MI2-M_u3 U936/net10 n1001 VDD VDD pch W=0.205u L=0.04u
M_U937/MU1-M_u4 n1001 n944 VSS VSS nch W=0.155u L=0.04u
M_U937/MU1-M_u3 n1001 U937/net4 VSS VSS nch W=0.155u L=0.04u
M_U937/MU6-M_u2 U937/net4 n984 VSS VSS nch W=0.155u L=0.04u
M_U937/MU1-M_u1 U937/XU1-net8 U937/net4 VDD VDD pch W=0.205u L=0.04u
M_U937/MU1-M_u2 n1001 n944 U937/XU1-net8 VDD pch W=0.205u L=0.04u
M_U937/MU6-M_u3 U937/net4 n984 VDD VDD pch W=0.205u L=0.04u
M_U938/MI14 n944 n926 U938/net26 VSS nch W=0.155u L=0.04u
M_U938/MI7 n944 n925 U938/net26 VSS nch W=0.155u L=0.04u
M_U938/MI6 U938/net29 n1002 VSS VSS nch W=0.155u L=0.04u
M_U938/M_u4 U938/net26 n923 U938/net29 VSS nch W=0.155u L=0.04u
M_U938/MI5 U938/net26 n924 U938/net29 VSS nch W=0.155u L=0.04u
M_U938/MI13 n944 n925 U938/net43 VDD pch W=0.205u L=0.04u
M_U938/MI11 n944 n924 U938/net49 VDD pch W=0.205u L=0.04u
M_U938/MI9 U938/net49 n923 VDD VDD pch W=0.205u L=0.04u
M_U938/MI12 U938/net43 n926 VDD VDD pch W=0.205u L=0.04u
M_U938/MU24 n944 n1002 VDD VDD pch W=0.205u L=0.04u
M_U939/MI1-M_u4 n1002 n921 VSS VSS nch W=0.155u L=0.04u
M_U939/MI1-M_u3 n1002 n922 VSS VSS nch W=0.155u L=0.04u
M_U939/MI1-M_u1 U939/XI1-net8 n922 VDD VDD pch W=0.205u L=0.04u
M_U939/MI1-M_u2 n1002 n921 U939/XI1-net8 VDD pch W=0.205u L=0.04u
M_U940/MU1-M_u2 n926 U940/net7 VSS VSS nch W=0.155u L=0.04u
M_U940/M_u7-M_u4 U940/net7 n1003 VSS VSS nch W=0.155u L=0.04u
M_U940/M_u7-M_u3 U940/net7 n997 VSS VSS nch W=0.155u L=0.04u
M_U940/MU1-M_u3 n926 U940/net7 VDD VDD pch W=0.205u L=0.04u
M_U940/M_u7-M_u1 U940/X_u7-net8 n997 VDD VDD pch W=0.205u L=0.04u
M_U940/M_u7-M_u2 U940/net7 n1003 U940/X_u7-net8 VDD pch W=0.205u L=0.04u
M_U941/MU1-M_u4 U941/XU1-net6 n943 VSS VSS nch W=0.155u L=0.04u
M_U941/MU1-M_u3 n984 n998 U941/XU1-net6 VSS nch W=0.155u L=0.04u
M_U941/MU1-M_u2 n984 n943 VDD VDD pch W=0.155u L=0.04u
M_U941/MU1-M_u1 n984 n998 VDD VDD pch W=0.155u L=0.04u
M_U942/MI1-M_u4 n998 n939 VSS VSS nch W=0.155u L=0.04u
M_U942/MI1-M_u3 n998 n1004 VSS VSS nch W=0.155u L=0.04u
M_U942/MI1-M_u1 U942/XI1-net8 n1004 VDD VDD pch W=0.205u L=0.04u
M_U942/MI1-M_u2 n998 n939 U942/XI1-net8 VDD pch W=0.205u L=0.04u
M_U943/M_u5 VSS n1005 U943/net22 VSS nch W=0.155u L=0.04u
M_U943/MI8 U943/net22 n892 N10706 VSS nch W=0.155u L=0.04u
M_U943/MI7 U943/net22 n887 N10706 VSS nch W=0.155u L=0.04u
M_U943/MI6 U943/net22 n891 N10706 VSS nch W=0.155u L=0.04u
M_U943/MI3 U943/net38 n891 VDD VDD pch W=0.205u L=0.04u
M_U943/MI4 U943/net35 n887 U943/net38 VDD pch W=0.205u L=0.04u
M_U943/MI5 N10706 n892 U943/net35 VDD pch W=0.205u L=0.04u
M_U943/M_u11 N10706 n1005 VDD VDD pch W=0.205u L=0.04u
M_U944/M_u5 VSS n1008 U944/net22 VSS nch W=0.155u L=0.04u
M_U944/MI15 U944/net22 n1007 U944/net30 VSS nch W=0.155u L=0.04u
M_U944/MI14 U944/net22 n860 U944/net30 VSS nch W=0.155u L=0.04u
M_U944/MI13 U944/net22 n1006 U944/net30 VSS nch W=0.155u L=0.04u
M_U944/MU1-M_u2 n887 U944/net30 VSS VSS nch W=0.155u L=0.04u
M_U944/MU1-M_u3 n887 U944/net30 VDD VDD pch W=0.205u L=0.04u
M_U944/MI3 U944/net38 n1006 VDD VDD pch W=0.205u L=0.04u
M_U944/MI9 U944/net35 n860 U944/net38 VDD pch W=0.205u L=0.04u
M_U944/MI11 U944/net30 n1007 U944/net35 VDD pch W=0.205u L=0.04u
M_U944/MI12 U944/net30 n1008 VDD VDD pch W=0.205u L=0.04u
M_U945/MI8 U945/net36 n1010 U945/net24 VSS nch W=0.155u L=0.04u
M_U945/MI9 U945/net24 n1011 VSS VSS nch W=0.155u L=0.04u
M_U945/M_u2 U945/net33 n911 U945/net36 VSS nch W=0.155u L=0.04u
M_U945/MI7 U945/net33 n1009 U945/net36 VSS nch W=0.155u L=0.04u
M_U945/MI11-M_u2 n860 U945/net33 VSS VSS nch W=0.155u L=0.04u
M_U945/MI11-M_u3 n860 U945/net33 VDD VDD pch W=0.205u L=0.04u
M_U945/MI6 U945/net33 n1009 U945/net35 VDD pch W=0.205u L=0.04u
M_U945/MI5 U945/net35 n911 VDD VDD pch W=0.205u L=0.04u
M_U945/MI4 U945/net33 n1011 VDD VDD pch W=0.205u L=0.04u
M_U945/M_u12 U945/net33 n1010 VDD VDD pch W=0.205u L=0.04u
M_U946/M_u2 n911 n897 VSS VSS nch W=0.135u L=0.04u
M_U946/M_u1 n911 n897 VDD VDD pch W=0.205u L=0.04u
M_U947/MI14 n897 n823 U947/net26 VSS nch W=0.155u L=0.04u
M_U947/MI7 n897 n1012 U947/net26 VSS nch W=0.155u L=0.04u
M_U947/MI6 U947/net29 n1015 VSS VSS nch W=0.155u L=0.04u
M_U947/M_u4 U947/net26 n1013 U947/net29 VSS nch W=0.155u L=0.04u
M_U947/MI5 U947/net26 n1014 U947/net29 VSS nch W=0.155u L=0.04u
M_U947/MI13 n897 n1012 U947/net43 VDD pch W=0.205u L=0.04u
M_U947/MI11 n897 n1014 U947/net49 VDD pch W=0.205u L=0.04u
M_U947/MI9 U947/net49 n1013 VDD VDD pch W=0.205u L=0.04u
M_U947/MI12 U947/net43 n823 VDD VDD pch W=0.205u L=0.04u
M_U947/MU24 n897 n1015 VDD VDD pch W=0.205u L=0.04u
M_U948/M_u2 n1013 n803 VSS VSS nch W=0.135u L=0.04u
M_U948/M_u1 n1013 n803 VDD VDD pch W=0.205u L=0.04u
M_U949/MI14 n803 n1017 U949/net26 VSS nch W=0.155u L=0.04u
M_U949/MI7 n803 n1016 U949/net26 VSS nch W=0.155u L=0.04u
M_U949/MI6 U949/net29 n1019 VSS VSS nch W=0.155u L=0.04u
M_U949/M_u4 U949/net26 n749 U949/net29 VSS nch W=0.155u L=0.04u
M_U949/MI5 U949/net26 n1018 U949/net29 VSS nch W=0.155u L=0.04u
M_U949/MI13 n803 n1016 U949/net43 VDD pch W=0.205u L=0.04u
M_U949/MI11 n803 n1018 U949/net49 VDD pch W=0.205u L=0.04u
M_U949/MI9 U949/net49 n749 VDD VDD pch W=0.205u L=0.04u
M_U949/MI12 U949/net43 n1017 VDD VDD pch W=0.205u L=0.04u
M_U949/MU24 n803 n1019 VDD VDD pch W=0.205u L=0.04u
M_U950/MI2 n1016 n755 U950/net27 VSS nch W=0.155u L=0.04u
M_U950/MI10 U950/net27 n756 VSS VSS nch W=0.155u L=0.04u
M_U950/MI11 n1016 n1020 VSS VSS nch W=0.155u L=0.04u
M_U950/MI8 n1016 n756 U950/net13 VDD pch W=0.205u L=0.04u
M_U950/M_u2 U950/net13 n1020 VDD VDD pch W=0.205u L=0.04u
M_U950/MI9 n1016 n755 U950/net13 VDD pch W=0.205u L=0.04u
M_U951/MI2 n1012 n817 U951/net27 VSS nch W=0.155u L=0.04u
M_U951/MI10 U951/net27 n824 VSS VSS nch W=0.155u L=0.04u
M_U951/MI11 n1012 n1021 VSS VSS nch W=0.155u L=0.04u
M_U951/MI8 n1012 n824 U951/net13 VDD pch W=0.205u L=0.04u
M_U951/M_u2 U951/net13 n1021 VDD VDD pch W=0.205u L=0.04u
M_U951/MI9 n1012 n817 U951/net13 VDD pch W=0.205u L=0.04u
M_U952/MI9 n824 N358 U952/net10 VSS nch W=0.155u L=0.04u
M_U952/M_u4 U952/net10 n954 VSS VSS nch W=0.155u L=0.04u
M_U952/MI8 n824 n1022 U952/net10 VSS nch W=0.155u L=0.04u
M_U952/MI7 U952/net10 n955 VSS VSS nch W=0.155u L=0.04u
M_U952/MU24 U952/net30 n954 VDD VDD pch W=0.205u L=0.04u
M_U952/MI6 n824 N358 U952/net24 VDD pch W=0.205u L=0.04u
M_U952/MI5 U952/net24 n1022 VDD VDD pch W=0.205u L=0.04u
M_U952/MI4 n824 n955 U952/net30 VDD pch W=0.205u L=0.04u
M_U953/MU1-M_u4 U953/XU1-net6 n861 VSS VSS nch W=0.155u L=0.04u
M_U953/MU1-M_u3 n1006 n880 U953/XU1-net6 VSS nch W=0.155u L=0.04u
M_U953/MU1-M_u2 n1006 n861 VDD VDD pch W=0.155u L=0.04u
M_U953/MU1-M_u1 n1006 n880 VDD VDD pch W=0.155u L=0.04u
M_U954/M_u2 n861 n874 VSS VSS nch W=0.135u L=0.04u
M_U954/M_u1 n861 n874 VDD VDD pch W=0.205u L=0.04u
M_U955/M_u6-M_u3 U955/net4 U955/net10 U955/net14 VSS nch W=0.155u L=0.04u
M_U955/MI3-M_u3 U955/net6 n987 U955/net14 VSS nch W=0.155u L=0.04u
M_U955/MI1-M_u2 U955/net4 n881 VSS VSS nch W=0.155u L=0.04u
M_U955/M_u5-M_u2 U955/net6 U955/net4 VSS VSS nch W=0.155u L=0.04u
M_U955/M_u4-M_u2 N10641 U955/net14 VSS VSS nch W=0.155u L=0.04u
M_U955/MI2-M_u2 U955/net10 n987 VSS VSS nch W=0.155u L=0.04u
M_U955/M_u6-M_u2 U955/net4 n987 U955/net14 VDD pch W=0.205u L=0.04u
M_U955/MI3-M_u2 U955/net6 U955/net10 U955/net14 VDD pch W=0.205u L=0.04u
M_U955/MI1-M_u3 U955/net4 n881 VDD VDD pch W=0.205u L=0.04u
M_U955/M_u5-M_u3 U955/net6 U955/net4 VDD VDD pch W=0.205u L=0.04u
M_U955/M_u4-M_u3 N10641 U955/net14 VDD VDD pch W=0.205u L=0.04u
M_U955/MI2-M_u3 U955/net10 n987 VDD VDD pch W=0.205u L=0.04u
M_U956/M_u6-M_u3 U956/net4 U956/net10 U956/net14 VSS nch W=0.155u L=0.04u
M_U956/MI3-M_u3 U956/net6 n1004 U956/net14 VSS nch W=0.155u L=0.04u
M_U956/MI1-M_u2 U956/net4 n940 VSS VSS nch W=0.155u L=0.04u
M_U956/M_u5-M_u2 U956/net6 U956/net4 VSS VSS nch W=0.155u L=0.04u
M_U956/M_u4-M_u2 N10632 U956/net14 VSS VSS nch W=0.155u L=0.04u
M_U956/MI2-M_u2 U956/net10 n1004 VSS VSS nch W=0.155u L=0.04u
M_U956/M_u6-M_u2 U956/net4 n1004 U956/net14 VDD pch W=0.205u L=0.04u
M_U956/MI3-M_u2 U956/net6 U956/net10 U956/net14 VDD pch W=0.205u L=0.04u
M_U956/MI1-M_u3 U956/net4 n940 VDD VDD pch W=0.205u L=0.04u
M_U956/M_u5-M_u3 U956/net6 U956/net4 VDD VDD pch W=0.205u L=0.04u
M_U956/M_u4-M_u3 N10632 U956/net14 VDD VDD pch W=0.205u L=0.04u
M_U956/MI2-M_u3 U956/net10 n1004 VDD VDD pch W=0.205u L=0.04u
M_U957/MI9 N10628 n1023 U957/net10 VSS nch W=0.155u L=0.04u
M_U957/M_u4 U957/net10 n1026 VSS VSS nch W=0.155u L=0.04u
M_U957/MI8 N10628 n1024 U957/net10 VSS nch W=0.155u L=0.04u
M_U957/MI7 U957/net10 n1025 VSS VSS nch W=0.155u L=0.04u
M_U957/MU24 U957/net30 n1026 VDD VDD pch W=0.205u L=0.04u
M_U957/MI6 N10628 n1023 U957/net24 VDD pch W=0.205u L=0.04u
M_U957/MI5 U957/net24 n1024 VDD VDD pch W=0.205u L=0.04u
M_U957/MI4 N10628 n1025 U957/net30 VDD pch W=0.205u L=0.04u
M_U958/MI2 n1026 N271 U958/net27 VSS nch W=0.155u L=0.04u
M_U958/MI10 U958/net27 N245 VSS VSS nch W=0.155u L=0.04u
M_U958/MI11 n1026 n1027 VSS VSS nch W=0.155u L=0.04u
M_U958/MI8 n1026 N245 U958/net13 VDD pch W=0.205u L=0.04u
M_U958/M_u2 U958/net13 n1027 VDD VDD pch W=0.205u L=0.04u
M_U958/MI9 n1026 N271 U958/net13 VDD pch W=0.205u L=0.04u
M_U959/MU8-M_u4 n1023 U959/net15 VSS VSS nch W=0.155u L=0.04u
M_U959/MU8-M_u3 n1023 N271 VSS VSS nch W=0.155u L=0.04u
M_U959/MU8-M_u5 n1023 N245 VSS VSS nch W=0.155u L=0.04u
M_U959/MU8-M_u8 n1023 n1027 VSS VSS nch W=0.155u L=0.04u
M_U959/MU47-M_u2 U959/net15 n1025 VSS VSS nch W=0.155u L=0.04u
M_U959/MU8-M_u7 n1023 n1027 U959/XU8-net7 VDD pch W=0.41u L=0.04u
M_U959/MU8-M_u6 U959/XU8-net7 N245 U959/XU8-net10 VDD pch W=0.41u L=0.04u
M_U959/MU8-M_u2 U959/XU8-net10 N271 U959/XU8-net13 VDD pch W=0.41u L=0.04u
M_U959/MU8-M_u1 U959/XU8-net13 U959/net15 VDD VDD pch W=0.41u L=0.04u
M_U959/MU47-M_u3 U959/net15 n1025 VDD VDD pch W=0.31u L=0.04u
M_U960/MI2 n1025 n1028 U960/net27 VSS nch W=0.155u L=0.04u
M_U960/MI10 U960/net27 n1029 VSS VSS nch W=0.155u L=0.04u
M_U960/MI11 n1025 n1030 VSS VSS nch W=0.155u L=0.04u
M_U960/MI8 n1025 n1029 U960/net13 VDD pch W=0.205u L=0.04u
M_U960/M_u2 U960/net13 n1030 VDD VDD pch W=0.205u L=0.04u
M_U960/MI9 n1025 n1028 U960/net13 VDD pch W=0.205u L=0.04u
M_U961/MU10 U961/net26 n1033 VSS VSS nch W=0.155u L=0.04u
M_U961/MU9 U961/net26 n1031 n1030 VSS nch W=0.155u L=0.04u
M_U961/MU8 U961/net26 n1032 n1030 VSS nch W=0.155u L=0.04u
M_U961/MU6 n1030 n1031 U961/net38 VSS nch W=0.155u L=0.04u
M_U961/MU7 U961/net38 n1032 VSS VSS nch W=0.155u L=0.04u
M_U961/MU2 U961/net16 n1032 VDD VDD pch W=0.205u L=0.04u
M_U961/MU5 U961/net20 n1031 n1030 VDD pch W=0.205u L=0.04u
M_U961/MU3 n1030 n1031 U961/net16 VDD pch W=0.205u L=0.04u
M_U961/MU4 U961/net20 n1032 n1030 VDD pch W=0.205u L=0.04u
M_U961/MU1 U961/net20 n1033 VDD VDD pch W=0.205u L=0.04u
M_U962/MI22 U962/net29 n1037 VSS VSS nch W=0.155u L=0.04u
M_U962/MI21 n1032 n1036 U962/net29 VSS nch W=0.155u L=0.04u
M_U962/MI9 n1032 n1034 U962/net23 VSS nch W=0.155u L=0.04u
M_U962/MI20 U962/net23 n1035 VSS VSS nch W=0.155u L=0.04u
M_U962/MI18 U962/net20 n1035 n1032 VDD pch W=0.205u L=0.04u
M_U962/MI19 U962/net20 n1034 n1032 VDD pch W=0.205u L=0.04u
M_U962/MI17 VDD n1036 U962/net20 VDD pch W=0.205u L=0.04u
M_U962/M_u5 VDD n1037 U962/net20 VDD pch W=0.205u L=0.04u
M_U963/M_u2 n1035 n1038 VSS VSS nch W=0.135u L=0.04u
M_U963/M_u1 n1035 n1038 VDD VDD pch W=0.205u L=0.04u
M_U964/MI9 n1034 n1039 U964/net10 VSS nch W=0.155u L=0.04u
M_U964/M_u4 U964/net10 n1042 VSS VSS nch W=0.155u L=0.04u
M_U964/MI8 n1034 n1040 U964/net10 VSS nch W=0.155u L=0.04u
M_U964/MI7 U964/net10 n1041 VSS VSS nch W=0.155u L=0.04u
M_U964/MU24 U964/net30 n1042 VDD VDD pch W=0.205u L=0.04u
M_U964/MI6 n1034 n1039 U964/net24 VDD pch W=0.205u L=0.04u
M_U964/MI5 U964/net24 n1040 VDD VDD pch W=0.205u L=0.04u
M_U964/MI4 n1034 n1041 U964/net30 VDD pch W=0.205u L=0.04u
M_U965/MI12 U965/net14 n1046 VSS VSS nch W=0.155u L=0.04u
M_U965/MI11 U965/net14 n1047 VSS VSS nch W=0.155u L=0.04u
M_U965/MI3 U965/net35 n1045 U965/net14 VSS nch W=0.155u L=0.04u
M_U965/MI8 U965/net35 n1044 U965/net14 VSS nch W=0.155u L=0.04u
M_U965/MI9 U965/net35 n1043 U965/net14 VSS nch W=0.155u L=0.04u
M_U965/MU1-M_u2 n1042 U965/net35 VSS VSS nch W=0.155u L=0.04u
M_U965/MU1-M_u3 n1042 U965/net35 VDD VDD pch W=0.205u L=0.04u
M_U965/MI16-MI12 U965/net35 n1047 U965/XI16-net11 VDD pch W=0.205u L=0.04u
M_U965/MI16-MI13 U965/XI16-net11 n1046 VDD VDD pch W=0.205u L=0.04u
M_U965/MI15-MI12 U965/net35 n1045 U965/XI15-net11 VDD pch W=0.205u L=0.04u
M_U965/MI15-MI13 U965/XI15-net11 n1044 U965/XI15-net18 VDD pch W=0.205u L=0.04u
M_U965/MI15-MI15 U965/XI15-net18 n1043 VDD VDD pch W=0.205u L=0.04u
M_U966/MI36 n1029 n1048 VSS VSS nch W=0.155u L=0.04u
M_U966/MI35 n1029 n1043 VSS VSS nch W=0.155u L=0.04u
M_U966/MI34 n1029 n1038 VSS VSS nch W=0.155u L=0.04u
M_U966/MI5 n1029 n1041 VSS VSS nch W=0.155u L=0.04u
M_U966/MI26 U966/net49 n1043 U966/net52 VDD pch W=0.41u L=0.04u
M_U966/MI7 U966/net52 n1048 VDD VDD pch W=0.41u L=0.04u
M_U966/MI27 U966/net46 n1038 U966/net49 VDD pch W=0.41u L=0.04u
M_U966/MI28 n1029 n1041 U966/net46 VDD pch W=0.41u L=0.04u
M_U967/MI1-M_u4 n1048 n1049 VSS VSS nch W=0.155u L=0.04u
M_U967/MI1-M_u3 n1048 n1050 VSS VSS nch W=0.155u L=0.04u
M_U967/MI1-M_u1 U967/XI1-net8 n1050 VDD VDD pch W=0.205u L=0.04u
M_U967/MI1-M_u2 n1048 n1049 U967/XI1-net8 VDD pch W=0.205u L=0.04u
M_U968/M_u3-M_u2 n1043 U968/net6 VSS VSS nch W=0.155u L=0.04u
M_U968/M_u2-M_u4 U968/X_u2-net6 n1047 VSS VSS nch W=0.155u L=0.04u
M_U968/M_u2-M_u3 U968/net6 n1046 U968/X_u2-net6 VSS nch W=0.155u L=0.04u
M_U968/M_u3-M_u3 n1043 U968/net6 VDD VDD pch W=0.205u L=0.04u
M_U968/M_u2-M_u2 U968/net6 n1047 VDD VDD pch W=0.205u L=0.04u
M_U968/M_u2-M_u1 U968/net6 n1046 VDD VDD pch W=0.205u L=0.04u
M_U969/MI1-M_u4 n1038 n1036 VSS VSS nch W=0.155u L=0.04u
M_U969/MI1-M_u3 n1038 n1037 VSS VSS nch W=0.155u L=0.04u
M_U969/MI1-M_u1 U969/XI1-net8 n1037 VDD VDD pch W=0.205u L=0.04u
M_U969/MI1-M_u2 n1038 n1036 U969/XI1-net8 VDD pch W=0.205u L=0.04u
M_U970/M_u3-M_u2 n1041 U970/net6 VSS VSS nch W=0.155u L=0.04u
M_U970/M_u2-M_u4 U970/X_u2-net6 n1039 VSS VSS nch W=0.155u L=0.04u
M_U970/M_u2-M_u3 U970/net6 n1040 U970/X_u2-net6 VSS nch W=0.155u L=0.04u
M_U970/M_u3-M_u3 n1041 U970/net6 VDD VDD pch W=0.205u L=0.04u
M_U970/M_u2-M_u2 U970/net6 n1039 VDD VDD pch W=0.205u L=0.04u
M_U970/M_u2-M_u1 U970/net6 n1040 VDD VDD pch W=0.205u L=0.04u
M_U971/MU20 n1028 n1053 VSS VSS nch W=0.155u L=0.04u
M_U971/MI17-M_u10 n1028 n1051 U971/XI17-net17 VSS nch W=0.155u L=0.04u
M_U971/MI17-M_u11 U971/XI17-net17 n1052 VSS VSS nch W=0.155u L=0.04u
M_U971/MI10-M_u10 n1028 n1031 U971/XI10-net17 VSS nch W=0.155u L=0.04u
M_U971/MI10-M_u11 U971/XI10-net17 n1033 VSS VSS nch W=0.155u L=0.04u
M_U971/MI9 U971/net30 n1031 n1028 VDD pch W=0.205u L=0.04u
M_U971/MI8 U971/net30 n1033 n1028 VDD pch W=0.205u L=0.04u
M_U971/MU22 VDD n1053 U971/net36 VDD pch W=0.205u L=0.04u
M_U971/MI6 U971/net36 n1052 U971/net30 VDD pch W=0.205u L=0.04u
M_U971/MI7 U971/net36 n1051 U971/net30 VDD pch W=0.205u L=0.04u
M_U972/MI2 n1053 n1054 U972/net27 VSS nch W=0.155u L=0.04u
M_U972/MI10 U972/net27 n1055 VSS VSS nch W=0.155u L=0.04u
M_U972/MI11 n1053 n1056 VSS VSS nch W=0.155u L=0.04u
M_U972/MI8 n1053 n1055 U972/net13 VDD pch W=0.205u L=0.04u
M_U972/M_u2 U972/net13 n1056 VDD VDD pch W=0.205u L=0.04u
M_U972/MI9 n1053 n1054 U972/net13 VDD pch W=0.205u L=0.04u
M_U973/M_u2 n1051 n1055 VSS VSS nch W=0.135u L=0.04u
M_U973/M_u1 n1051 n1055 VDD VDD pch W=0.205u L=0.04u
M_U974/MU10 U974/net26 n1059 VSS VSS nch W=0.155u L=0.04u
M_U974/MU9 U974/net26 n1057 n1055 VSS nch W=0.155u L=0.04u
M_U974/MU8 U974/net26 n1058 n1055 VSS nch W=0.155u L=0.04u
M_U974/MU6 n1055 n1057 U974/net38 VSS nch W=0.155u L=0.04u
M_U974/MU7 U974/net38 n1058 VSS VSS nch W=0.155u L=0.04u
M_U974/MU2 U974/net16 n1058 VDD VDD pch W=0.205u L=0.04u
M_U974/MU5 U974/net20 n1057 n1055 VDD pch W=0.205u L=0.04u
M_U974/MU3 n1055 n1057 U974/net16 VDD pch W=0.205u L=0.04u
M_U974/MU4 U974/net20 n1058 n1055 VDD pch W=0.205u L=0.04u
M_U974/MU1 U974/net20 n1059 VDD VDD pch W=0.205u L=0.04u
M_U975/MI18 U975/net17 n1063 VSS VSS nch W=0.155u L=0.04u
M_U975/MI12 U975/net17 n1062 VSS VSS nch W=0.155u L=0.04u
M_U975/MI20 U975/net63 n1061 VSS VSS nch W=0.155u L=0.04u
M_U975/MI21 n1059 U975/net17 VSS VSS nch W=0.155u L=0.04u
M_U975/MI19 n1059 n1060 U975/net63 VSS nch W=0.155u L=0.04u
M_U975/MI16 n1059 n1061 U975/net31 VDD pch W=0.205u L=0.04u
M_U975/MI1 U975/net39 n1063 VDD VDD pch W=0.195u L=0.04u
M_U975/MI15 U975/net31 U975/net17 VDD VDD pch W=0.195u L=0.04u
M_U975/MI17 n1059 n1060 U975/net31 VDD pch W=0.195u L=0.04u
M_U975/MI14 U975/net17 n1062 U975/net39 VDD pch W=0.195u L=0.04u
M_U976/MU1-M_u4 U976/XU1-net6 n1063 VSS VSS nch W=0.155u L=0.04u
M_U976/MU1-M_u3 n1061 n1062 U976/XU1-net6 VSS nch W=0.155u L=0.04u
M_U976/MU1-M_u2 n1061 n1063 VDD VDD pch W=0.155u L=0.04u
M_U976/MU1-M_u1 n1061 n1062 VDD VDD pch W=0.155u L=0.04u
M_U977/M_u2 n1060 n1064 U977/net15 VSS nch W=0.155u L=0.04u
M_U977/M_u3 n1060 n1065 U977/net15 VSS nch W=0.155u L=0.04u
M_U977/M_u4 U977/net15 n1066 VSS VSS nch W=0.155u L=0.04u
M_U977/M_u9 n1060 n1066 VDD VDD pch W=0.205u L=0.04u
M_U977/MI16-MI12 n1060 n1064 U977/XI16-net11 VDD pch W=0.205u L=0.04u
M_U977/MI16-MI13 U977/XI16-net11 n1065 VDD VDD pch W=0.205u L=0.04u
M_U978/MU1 U978/net8 n1064 U978/net26 VSS nch W=0.155u L=0.04u
M_U978/MI5 U978/net26 n1065 VSS VSS nch W=0.155u L=0.04u
M_U978/MI6 U978/net29 U978/net8 VSS VSS nch W=0.155u L=0.04u
M_U978/MU9 U978/net29 n1067 n1066 VSS nch W=0.155u L=0.04u
M_U978/MU10 U978/net29 n1068 n1066 VSS nch W=0.155u L=0.04u
M_U978/MU3 U978/net8 n1065 VDD VDD pch W=0.205u L=0.04u
M_U978/MI1 U978/net8 n1064 VDD VDD pch W=0.205u L=0.04u
M_U978/MI2 n1066 U978/net8 VDD VDD pch W=0.205u L=0.04u
M_U978/MI4 n1066 n1067 U978/net20 VDD pch W=0.205u L=0.04u
M_U978/MI3 U978/net20 n1068 VDD VDD pch W=0.205u L=0.04u
M_U979/MI9 n1068 n1069 U979/net10 VSS nch W=0.155u L=0.04u
M_U979/M_u4 U979/net10 n1072 VSS VSS nch W=0.155u L=0.04u
M_U979/MI8 n1068 n1070 U979/net10 VSS nch W=0.155u L=0.04u
M_U979/MI7 U979/net10 n1071 VSS VSS nch W=0.155u L=0.04u
M_U979/MU24 U979/net30 n1072 VDD VDD pch W=0.205u L=0.04u
M_U979/MI6 n1068 n1069 U979/net24 VDD pch W=0.205u L=0.04u
M_U979/MI5 U979/net24 n1070 VDD VDD pch W=0.205u L=0.04u
M_U979/MI4 n1068 n1071 U979/net30 VDD pch W=0.205u L=0.04u
M_U980/MI22 U980/net29 n1076 VSS VSS nch W=0.155u L=0.04u
M_U980/MI21 n1072 n1075 U980/net29 VSS nch W=0.155u L=0.04u
M_U980/MI9 n1072 n1073 U980/net23 VSS nch W=0.155u L=0.04u
M_U980/MI20 U980/net23 n1074 VSS VSS nch W=0.155u L=0.04u
M_U980/MI18 U980/net20 n1074 n1072 VDD pch W=0.205u L=0.04u
M_U980/MI19 U980/net20 n1073 n1072 VDD pch W=0.205u L=0.04u
M_U980/MI17 VDD n1075 U980/net20 VDD pch W=0.205u L=0.04u
M_U980/M_u5 VDD n1076 U980/net20 VDD pch W=0.205u L=0.04u
M_U981/M_u2 n1074 n1077 VSS VSS nch W=0.135u L=0.04u
M_U981/M_u1 n1074 n1077 VDD VDD pch W=0.205u L=0.04u
M_U982/MI9 n1073 n1078 U982/net10 VSS nch W=0.155u L=0.04u
M_U982/M_u4 U982/net10 n1081 VSS VSS nch W=0.155u L=0.04u
M_U982/MI8 n1073 n1079 U982/net10 VSS nch W=0.155u L=0.04u
M_U982/MI7 U982/net10 n1080 VSS VSS nch W=0.155u L=0.04u
M_U982/MU24 U982/net30 n1081 VDD VDD pch W=0.205u L=0.04u
M_U982/MI6 n1073 n1078 U982/net24 VDD pch W=0.205u L=0.04u
M_U982/MI5 U982/net24 n1079 VDD VDD pch W=0.205u L=0.04u
M_U982/MI4 n1073 n1080 U982/net30 VDD pch W=0.205u L=0.04u
M_U983/MI8 n1081 n1082 U983/net23 VDD pch W=0.205u L=0.04u
M_U983/MI6 n1081 n1084 U983/net23 VDD pch W=0.205u L=0.04u
M_U983/MI7 n1081 n1083 U983/net23 VDD pch W=0.205u L=0.04u
M_U983/MU20 U983/net23 n1085 VDD VDD pch W=0.205u L=0.04u
M_U983/MI5 U983/net23 n1086 VDD VDD pch W=0.205u L=0.04u
M_U983/MI20-MI12 U983/XI20-net13 n1084 VSS VSS nch W=0.155u L=0.04u
M_U983/MI20-M_u10 n1081 n1082 U983/XI20-net17 VSS nch W=0.155u L=0.04u
M_U983/MI20-M_u11 U983/XI20-net17 n1083 U983/XI20-net13 VSS nch W=0.155u L=0.04u
M_U983/MI17-M_u10 n1081 n1085 U983/XI17-net17 VSS nch W=0.155u L=0.04u
M_U983/MI17-M_u11 U983/XI17-net17 n1086 VSS VSS nch W=0.155u L=0.04u
M_U984/M_u2 n1086 n1087 VSS VSS nch W=0.135u L=0.04u
M_U984/M_u1 n1086 n1087 VDD VDD pch W=0.205u L=0.04u
M_U985/M_u2 n1085 n1088 VSS VSS nch W=0.135u L=0.04u
M_U985/M_u1 n1085 n1088 VDD VDD pch W=0.205u L=0.04u
M_U986/M_u2 n1080 n1089 VSS VSS nch W=0.135u L=0.04u
M_U986/M_u1 n1080 n1089 VDD VDD pch W=0.205u L=0.04u
M_U987/MU8-M_u4 n1067 U987/net15 VSS VSS nch W=0.155u L=0.04u
M_U987/MU8-M_u3 n1067 n1090 VSS VSS nch W=0.155u L=0.04u
M_U987/MU8-M_u5 n1067 n1077 VSS VSS nch W=0.155u L=0.04u
M_U987/MU8-M_u8 n1067 n1071 VSS VSS nch W=0.155u L=0.04u
M_U987/MU47-M_u2 U987/net15 N10704 VSS VSS nch W=0.155u L=0.04u
M_U987/MU8-M_u7 n1067 n1071 U987/XU8-net7 VDD pch W=0.41u L=0.04u
M_U987/MU8-M_u6 U987/XU8-net7 n1077 U987/XU8-net10 VDD pch W=0.41u L=0.04u
M_U987/MU8-M_u2 U987/XU8-net10 n1090 U987/XU8-net13 VDD pch W=0.41u L=0.04u
M_U987/MU8-M_u1 U987/XU8-net13 U987/net15 VDD VDD pch W=0.41u L=0.04u
M_U987/MU47-M_u3 U987/net15 N10704 VDD VDD pch W=0.31u L=0.04u
M_U988/M_u3-M_u2 n1071 U988/net6 VSS VSS nch W=0.155u L=0.04u
M_U988/M_u2-M_u4 U988/X_u2-net6 n1069 VSS VSS nch W=0.155u L=0.04u
M_U988/M_u2-M_u3 U988/net6 n1070 U988/X_u2-net6 VSS nch W=0.155u L=0.04u
M_U988/M_u3-M_u3 n1071 U988/net6 VDD VDD pch W=0.205u L=0.04u
M_U988/M_u2-M_u2 U988/net6 n1069 VDD VDD pch W=0.205u L=0.04u
M_U988/M_u2-M_u1 U988/net6 n1070 VDD VDD pch W=0.205u L=0.04u
M_U989/MI1-M_u4 n1077 n1076 VSS VSS nch W=0.155u L=0.04u
M_U989/MI1-M_u3 n1077 n1075 VSS VSS nch W=0.155u L=0.04u
M_U989/MI1-M_u1 U989/XI1-net8 n1075 VDD VDD pch W=0.205u L=0.04u
M_U989/MI1-M_u2 n1077 n1076 U989/XI1-net8 VDD pch W=0.205u L=0.04u
M_U990/M_u2 n1076 n1091 VSS VSS nch W=0.135u L=0.04u
M_U990/M_u1 n1076 n1091 VDD VDD pch W=0.205u L=0.04u
M_U991/MI8 U991/net36 n1083 U991/net24 VSS nch W=0.155u L=0.04u
M_U991/MI9 U991/net24 n1089 VSS VSS nch W=0.155u L=0.04u
M_U991/M_u2 n1090 n1084 U991/net36 VSS nch W=0.155u L=0.04u
M_U991/MI7 n1090 n1082 U991/net36 VSS nch W=0.155u L=0.04u
M_U991/MI6 n1090 n1082 U991/net35 VDD pch W=0.205u L=0.04u
M_U991/MI5 U991/net35 n1084 VDD VDD pch W=0.205u L=0.04u
M_U991/MI4 n1090 n1089 VDD VDD pch W=0.205u L=0.04u
M_U991/M_u12 n1090 n1083 VDD VDD pch W=0.205u L=0.04u
M_U992/MU1-M_u4 U992/XU1-net6 n1079 VSS VSS nch W=0.155u L=0.04u
M_U992/MU1-M_u3 n1089 n1078 U992/XU1-net6 VSS nch W=0.155u L=0.04u
M_U992/MU1-M_u2 n1089 n1079 VDD VDD pch W=0.155u L=0.04u
M_U992/MU1-M_u1 n1089 n1078 VDD VDD pch W=0.155u L=0.04u
M_U993/MU1-M_u4 U993/XU1-net6 n1088 VSS VSS nch W=0.155u L=0.04u
M_U993/MU1-M_u3 n1083 n1087 U993/XU1-net6 VSS nch W=0.155u L=0.04u
M_U993/MU1-M_u2 n1083 n1088 VDD VDD pch W=0.155u L=0.04u
M_U993/MU1-M_u1 n1083 n1087 VDD VDD pch W=0.155u L=0.04u
M_U994/MI8 U994/net36 n1094 U994/net24 VSS nch W=0.155u L=0.04u
M_U994/MI9 U994/net24 n1095 VSS VSS nch W=0.155u L=0.04u
M_U994/M_u2 N10704 n1092 U994/net36 VSS nch W=0.155u L=0.04u
M_U994/MI7 N10704 n1093 U994/net36 VSS nch W=0.155u L=0.04u
M_U994/MI6 N10704 n1093 U994/net35 VDD pch W=0.205u L=0.04u
M_U994/MI5 U994/net35 n1092 VDD VDD pch W=0.205u L=0.04u
M_U994/MI4 N10704 n1095 VDD VDD pch W=0.205u L=0.04u
M_U994/M_u12 N10704 n1094 VDD VDD pch W=0.205u L=0.04u
M_U995/MI8-M_u3 n1095 U995/net27 VDD VDD pch W=0.205u L=0.04u
M_U995/M_u3 U995/net11 n1092 U995/net27 VDD pch W=0.205u L=0.04u
M_U995/MI0 U995/net11 n1096 U995/net27 VDD pch W=0.205u L=0.04u
M_U995/MI16-MI12 U995/net11 n1097 U995/XI16-net11 VDD pch W=0.205u L=0.04u
M_U995/MI16-MI13 U995/XI16-net11 n1098 VDD VDD pch W=0.205u L=0.04u
M_U995/M_u12 U995/net27 n1098 VSS VSS nch W=0.155u L=0.04u
M_U995/M_u13 U995/net27 n1097 VSS VSS nch W=0.155u L=0.04u
M_U995/MI8-M_u2 n1095 U995/net27 VSS VSS nch W=0.155u L=0.04u
M_U995/MI12-M_u10 U995/net27 n1092 U995/XI12-net17 VSS nch W=0.155u L=0.04u
M_U995/MI12-M_u11 U995/XI12-net17 n1096 VSS VSS nch W=0.155u L=0.04u
M_U996/MI14 n1098 n1100 U996/net26 VSS nch W=0.155u L=0.04u
M_U996/MI7 n1098 n1099 U996/net26 VSS nch W=0.155u L=0.04u
M_U996/MI6 U996/net29 n1103 VSS VSS nch W=0.155u L=0.04u
M_U996/M_u4 U996/net26 n1101 U996/net29 VSS nch W=0.155u L=0.04u
M_U996/MI5 U996/net26 n1102 U996/net29 VSS nch W=0.155u L=0.04u
M_U996/MI13 n1098 n1099 U996/net43 VDD pch W=0.205u L=0.04u
M_U996/MI11 n1098 n1102 U996/net49 VDD pch W=0.205u L=0.04u
M_U996/MI9 U996/net49 n1101 VDD VDD pch W=0.205u L=0.04u
M_U996/MI12 U996/net43 n1100 VDD VDD pch W=0.205u L=0.04u
M_U996/MU24 n1098 n1103 VDD VDD pch W=0.205u L=0.04u
M_U997/MU20 n1097 n1108 VSS VSS nch W=0.155u L=0.04u
M_U997/MI17-M_u10 n1097 n1106 U997/XI17-net17 VSS nch W=0.155u L=0.04u
M_U997/MI17-M_u11 U997/XI17-net17 n1107 VSS VSS nch W=0.155u L=0.04u
M_U997/MI10-M_u10 n1097 n1104 U997/XI10-net17 VSS nch W=0.155u L=0.04u
M_U997/MI10-M_u11 U997/XI10-net17 n1105 VSS VSS nch W=0.155u L=0.04u
M_U997/MI9 U997/net30 n1104 n1097 VDD pch W=0.205u L=0.04u
M_U997/MI8 U997/net30 n1105 n1097 VDD pch W=0.205u L=0.04u
M_U997/MU22 VDD n1108 U997/net36 VDD pch W=0.205u L=0.04u
M_U997/MI6 U997/net36 n1107 U997/net30 VDD pch W=0.205u L=0.04u
M_U997/MI7 U997/net36 n1106 U997/net30 VDD pch W=0.205u L=0.04u
M_U998/MI36 n1108 n1112 VSS VSS nch W=0.155u L=0.04u
M_U998/MI35 n1108 n1111 VSS VSS nch W=0.155u L=0.04u
M_U998/MI34 n1108 n1110 VSS VSS nch W=0.155u L=0.04u
M_U998/MI5 n1108 n1109 VSS VSS nch W=0.155u L=0.04u
M_U998/MI26 U998/net49 n1111 U998/net52 VDD pch W=0.41u L=0.04u
M_U998/MI7 U998/net52 n1112 VDD VDD pch W=0.41u L=0.04u
M_U998/MI27 U998/net46 n1110 U998/net49 VDD pch W=0.41u L=0.04u
M_U998/MI28 n1108 n1109 U998/net46 VDD pch W=0.41u L=0.04u
M_U999/MI18 n1109 n1114 U999/net27 VSS nch W=0.155u L=0.04u
M_U999/MI14 U999/net39 n1118 VSS VSS nch W=0.155u L=0.04u
M_U999/MI15 U999/net27 n1115 U999/net39 VSS nch W=0.155u L=0.04u
M_U999/MI16 U999/net27 n1116 U999/net39 VSS nch W=0.155u L=0.04u
M_U999/MI17 n1109 n1113 U999/net27 VSS nch W=0.155u L=0.04u
M_U999/MU25 U999/net39 n1117 VSS VSS nch W=0.155u L=0.04u
M_U999/MI8 n1109 n1118 U999/net46 VDD pch W=0.205u L=0.04u
M_U999/MI2 U999/net46 n1117 VDD VDD pch W=0.205u L=0.04u
M_U999/MI13 n1109 n1113 U999/net34 VDD pch W=0.205u L=0.04u
M_U999/MI12 U999/net34 n1114 VDD VDD pch W=0.205u L=0.04u
M_U999/MI9 n1109 n1116 U999/net37 VDD pch W=0.205u L=0.04u
M_U999/MI11 U999/net37 n1115 VDD VDD pch W=0.205u L=0.04u
M_U1000/M_u2 n1118 n1119 VSS VSS nch W=0.135u L=0.04u
M_U1000/M_u1 n1118 n1119 VDD VDD pch W=0.205u L=0.04u
M_U1001/MU20 n1116 n1124 VSS VSS nch W=0.155u L=0.04u
M_U1001/MI17-M_u10 n1116 n1122 U1001/XI17-net17 VSS nch W=0.155u L=0.04u
M_U1001/MI17-M_u11 U1001/XI17-net17 n1123 VSS VSS nch W=0.155u L=0.04u
M_U1001/MI10-M_u10 n1116 n1120 U1001/XI10-net17 VSS nch W=0.155u L=0.04u
M_U1001/MI10-M_u11 U1001/XI10-net17 n1121 VSS VSS nch W=0.155u L=0.04u
M_U1001/MI9 U1001/net30 n1120 n1116 VDD pch W=0.205u L=0.04u
M_U1001/MI8 U1001/net30 n1121 n1116 VDD pch W=0.205u L=0.04u
M_U1001/MU22 VDD n1124 U1001/net36 VDD pch W=0.205u L=0.04u
M_U1001/MI6 U1001/net36 n1123 U1001/net30 VDD pch W=0.205u L=0.04u
M_U1001/MI7 U1001/net36 n1122 U1001/net30 VDD pch W=0.205u L=0.04u
M_U1002/MI8-M_u3 n1124 U1002/net27 VDD VDD pch W=0.205u L=0.04u
M_U1002/M_u3 U1002/net11 n1125 U1002/net27 VDD pch W=0.205u L=0.04u
M_U1002/MI0 U1002/net11 n1126 U1002/net27 VDD pch W=0.205u L=0.04u
M_U1002/MI16-MI12 U1002/net11 n1127 U1002/XI16-net11 VDD pch W=0.205u L=0.04u
M_U1002/MI16-MI13 U1002/XI16-net11 n1128 VDD VDD pch W=0.205u L=0.04u
M_U1002/M_u12 U1002/net27 n1128 VSS VSS nch W=0.155u L=0.04u
M_U1002/M_u13 U1002/net27 n1127 VSS VSS nch W=0.155u L=0.04u
M_U1002/MI8-M_u2 n1124 U1002/net27 VSS VSS nch W=0.155u L=0.04u
M_U1002/MI12-M_u10 U1002/net27 n1125 U1002/XI12-net17 VSS nch W=0.155u L=0.04u
M_U1002/MI12-M_u11 U1002/XI12-net17 n1126 VSS VSS nch W=0.155u L=0.04u
M_U1003/MI8 U1003/net36 n1131 U1003/net24 VSS nch W=0.155u L=0.04u
M_U1003/MI9 U1003/net24 n1132 VSS VSS nch W=0.155u L=0.04u
M_U1003/M_u2 U1003/net33 n1129 U1003/net36 VSS nch W=0.155u L=0.04u
M_U1003/MI7 U1003/net33 n1130 U1003/net36 VSS nch W=0.155u L=0.04u
M_U1003/MI11-M_u2 n1127 U1003/net33 VSS VSS nch W=0.155u L=0.04u
M_U1003/MI11-M_u3 n1127 U1003/net33 VDD VDD pch W=0.205u L=0.04u
M_U1003/MI6 U1003/net33 n1130 U1003/net35 VDD pch W=0.205u L=0.04u
M_U1003/MI5 U1003/net35 n1129 VDD VDD pch W=0.205u L=0.04u
M_U1003/MI4 U1003/net33 n1132 VDD VDD pch W=0.205u L=0.04u
M_U1003/M_u12 U1003/net33 n1131 VDD VDD pch W=0.205u L=0.04u
M_U1004/MI8 n1132 n1133 U1004/net23 VDD pch W=0.205u L=0.04u
M_U1004/MI6 n1132 n1135 U1004/net23 VDD pch W=0.205u L=0.04u
M_U1004/MI7 n1132 n1134 U1004/net23 VDD pch W=0.205u L=0.04u
M_U1004/MU20 U1004/net23 n1136 VDD VDD pch W=0.205u L=0.04u
M_U1004/MI5 U1004/net23 n1137 VDD VDD pch W=0.205u L=0.04u
M_U1004/MI20-MI12 U1004/XI20-net13 n1135 VSS VSS nch W=0.155u L=0.04u
M_U1004/MI20-M_u10 n1132 n1133 U1004/XI20-net17 VSS nch W=0.155u L=0.04u
M_U1004/MI20-M_u11 U1004/XI20-net17 n1134 U1004/XI20-net13 VSS nch W=0.155u L=0.04u
M_U1004/MI17-M_u10 n1132 n1136 U1004/XI17-net17 VSS nch W=0.155u L=0.04u
M_U1004/MI17-M_u11 U1004/XI17-net17 n1137 VSS VSS nch W=0.155u L=0.04u
M_U1005/MU1 U1005/net8 n1140 U1005/net26 VSS nch W=0.155u L=0.04u
M_U1005/MI5 U1005/net26 n1141 VSS VSS nch W=0.155u L=0.04u
M_U1005/MI6 U1005/net29 U1005/net8 VSS VSS nch W=0.155u L=0.04u
M_U1005/MU9 U1005/net29 n1138 n1136 VSS nch W=0.155u L=0.04u
M_U1005/MU10 U1005/net29 n1139 n1136 VSS nch W=0.155u L=0.04u
M_U1005/MU3 U1005/net8 n1141 VDD VDD pch W=0.205u L=0.04u
M_U1005/MI1 U1005/net8 n1140 VDD VDD pch W=0.205u L=0.04u
M_U1005/MI2 n1136 U1005/net8 VDD VDD pch W=0.205u L=0.04u
M_U1005/MI4 n1136 n1138 U1005/net20 VDD pch W=0.205u L=0.04u
M_U1005/MI3 U1005/net20 n1139 VDD VDD pch W=0.205u L=0.04u
M_U1006/MI9 n1141 n1142 U1006/net14 VSS nch W=0.155u L=0.04u
M_U1006/MI11 U1006/net14 n1146 VSS VSS nch W=0.155u L=0.04u
M_U1006/MI12 U1006/net14 n1145 VSS VSS nch W=0.155u L=0.04u
M_U1006/MI3 n1141 n1144 U1006/net14 VSS nch W=0.155u L=0.04u
M_U1006/MI8 n1141 n1143 U1006/net14 VSS nch W=0.155u L=0.04u
M_U1006/MI16-MI12 n1141 n1146 U1006/XI16-net11 VDD pch W=0.205u L=0.04u
M_U1006/MI16-MI13 U1006/XI16-net11 n1145 VDD VDD pch W=0.205u L=0.04u
M_U1006/MI15-MI12 n1141 n1144 U1006/XI15-net11 VDD pch W=0.205u L=0.04u
M_U1006/MI15-MI13 U1006/XI15-net11 n1143 U1006/XI15-net18 VDD pch W=0.205u L=0.04u
M_U1006/MI15-MI15 U1006/XI15-net18 n1142 VDD VDD pch W=0.205u L=0.04u
M_U1007/M_u2 n1143 n1147 VSS VSS nch W=0.135u L=0.04u
M_U1007/M_u1 n1143 n1147 VDD VDD pch W=0.205u L=0.04u
M_U1008/MI8 U1008/net36 n1135 U1008/net24 VSS nch W=0.155u L=0.04u
M_U1008/MI9 U1008/net24 N89 VSS VSS nch W=0.155u L=0.04u
M_U1008/M_u2 n1131 n1133 U1008/net36 VSS nch W=0.155u L=0.04u
M_U1008/MI7 n1131 n1134 U1008/net36 VSS nch W=0.155u L=0.04u
M_U1008/MI6 n1131 n1134 U1008/net35 VDD pch W=0.205u L=0.04u
M_U1008/MI5 U1008/net35 n1133 VDD VDD pch W=0.205u L=0.04u
M_U1008/MI4 n1131 N89 VDD VDD pch W=0.205u L=0.04u
M_U1008/M_u12 n1131 n1135 VDD VDD pch W=0.205u L=0.04u
M_U1009/M_u3-M_u2 n1135 U1009/net6 VSS VSS nch W=0.155u L=0.04u
M_U1009/MU30-M_u5 U1009/net6 n1148 U1009/XU30-net23 VSS nch W=0.155u L=0.04u
M_U1009/MU30-MI0 U1009/XU30-net23 n1140 U1009/XU30-net26 VSS nch W=0.155u L=0.04u
M_U1009/MU30-MI1 U1009/XU30-net26 n1147 U1009/XU30-net29 VSS nch W=0.155u L=0.04u
M_U1009/MU30-MI2 U1009/XU30-net29 n1137 VSS VSS nch W=0.155u L=0.04u
M_U1009/M_u3-M_u3 n1135 U1009/net6 VDD VDD pch W=0.205u L=0.04u
M_U1009/MU30-M_u4 U1009/net6 n1137 VDD VDD pch W=0.205u L=0.04u
M_U1009/MU30-M_u3 U1009/net6 n1147 VDD VDD pch W=0.205u L=0.04u
M_U1009/MU30-M_u2 U1009/net6 n1140 VDD VDD pch W=0.205u L=0.04u
M_U1009/MU30-M_u1 U1009/net6 n1148 VDD VDD pch W=0.205u L=0.04u
M_U1010/MU1-M_u4 U1010/XU1-net6 n1130 VSS VSS nch W=0.155u L=0.04u
M_U1010/MU1-M_u3 n1137 n1129 U1010/XU1-net6 VSS nch W=0.155u L=0.04u
M_U1010/MU1-M_u2 n1137 n1130 VDD VDD pch W=0.155u L=0.04u
M_U1010/MU1-M_u1 n1137 n1129 VDD VDD pch W=0.155u L=0.04u
M_U1011/MU1-M_u4 U1011/XU1-net6 n1145 VSS VSS nch W=0.155u L=0.04u
M_U1011/MU1-M_u3 n1147 n1146 U1011/XU1-net6 VSS nch W=0.155u L=0.04u
M_U1011/MU1-M_u2 n1147 n1145 VDD VDD pch W=0.155u L=0.04u
M_U1011/MU1-M_u1 n1147 n1146 VDD VDD pch W=0.155u L=0.04u
M_U1012/MU1-M_u4 U1012/XU1-net6 n1139 VSS VSS nch W=0.155u L=0.04u
M_U1012/MU1-M_u3 n1140 n1138 U1012/XU1-net6 VSS nch W=0.155u L=0.04u
M_U1012/MU1-M_u2 n1140 n1139 VDD VDD pch W=0.155u L=0.04u
M_U1012/MU1-M_u1 n1140 n1138 VDD VDD pch W=0.155u L=0.04u
M_U1013/MU1-M_u4 U1013/XU1-net6 n1144 VSS VSS nch W=0.155u L=0.04u
M_U1013/MU1-M_u3 n1148 n1142 U1013/XU1-net6 VSS nch W=0.155u L=0.04u
M_U1013/MU1-M_u2 n1148 n1144 VDD VDD pch W=0.155u L=0.04u
M_U1013/MU1-M_u1 n1148 n1142 VDD VDD pch W=0.155u L=0.04u
M_U1014/M_u2 n1134 n1149 VSS VSS nch W=0.135u L=0.04u
M_U1014/M_u1 n1134 n1149 VDD VDD pch W=0.205u L=0.04u
M_U1015/MU10 U1015/net26 n1122 VSS VSS nch W=0.155u L=0.04u
M_U1015/MU9 U1015/net26 n1123 n1115 VSS nch W=0.155u L=0.04u
M_U1015/MU8 U1015/net26 n1150 n1115 VSS nch W=0.155u L=0.04u
M_U1015/MU6 n1115 n1123 U1015/net38 VSS nch W=0.155u L=0.04u
M_U1015/MU7 U1015/net38 n1150 VSS VSS nch W=0.155u L=0.04u
M_U1015/MU2 U1015/net16 n1150 VDD VDD pch W=0.205u L=0.04u
M_U1015/MU5 U1015/net20 n1123 n1115 VDD pch W=0.205u L=0.04u
M_U1015/MU3 n1115 n1123 U1015/net16 VDD pch W=0.205u L=0.04u
M_U1015/MU4 U1015/net20 n1150 n1115 VDD pch W=0.205u L=0.04u
M_U1015/MU1 U1015/net20 n1122 VDD VDD pch W=0.205u L=0.04u
M_U1016/MI22 U1016/net29 n1154 VSS VSS nch W=0.155u L=0.04u
M_U1016/MI21 n1150 n1153 U1016/net29 VSS nch W=0.155u L=0.04u
M_U1016/MI9 n1150 n1151 U1016/net23 VSS nch W=0.155u L=0.04u
M_U1016/MI20 U1016/net23 n1152 VSS VSS nch W=0.155u L=0.04u
M_U1016/MI18 U1016/net20 n1152 n1150 VDD pch W=0.205u L=0.04u
M_U1016/MI19 U1016/net20 n1151 n1150 VDD pch W=0.205u L=0.04u
M_U1016/MI17 VDD n1153 U1016/net20 VDD pch W=0.205u L=0.04u
M_U1016/M_u5 VDD n1154 U1016/net20 VDD pch W=0.205u L=0.04u
M_U1017/MU1-M_u2 n1152 U1017/net7 VSS VSS nch W=0.155u L=0.04u
M_U1017/M_u7-M_u4 U1017/net7 n1154 VSS VSS nch W=0.155u L=0.04u
M_U1017/M_u7-M_u3 U1017/net7 n1153 VSS VSS nch W=0.155u L=0.04u
M_U1017/MU1-M_u3 n1152 U1017/net7 VDD VDD pch W=0.205u L=0.04u
M_U1017/M_u7-M_u1 U1017/X_u7-net8 n1153 VDD VDD pch W=0.205u L=0.04u
M_U1017/M_u7-M_u2 U1017/net7 n1154 U1017/X_u7-net8 VDD pch W=0.205u L=0.04u
M_U1018/MI9 n1154 n1125 U1018/net14 VSS nch W=0.155u L=0.04u
M_U1018/MI11 U1018/net14 n1156 VSS VSS nch W=0.155u L=0.04u
M_U1018/MI12 U1018/net14 n1155 VSS VSS nch W=0.155u L=0.04u
M_U1018/MI3 n1154 n1126 U1018/net14 VSS nch W=0.155u L=0.04u
M_U1018/MI8 n1154 n1128 U1018/net14 VSS nch W=0.155u L=0.04u
M_U1018/MI16-MI12 n1154 n1156 U1018/XI16-net11 VDD pch W=0.205u L=0.04u
M_U1018/MI16-MI13 U1018/XI16-net11 n1155 VDD VDD pch W=0.205u L=0.04u
M_U1018/MI15-MI12 n1154 n1126 U1018/XI15-net11 VDD pch W=0.205u L=0.04u
M_U1018/MI15-MI13 U1018/XI15-net11 n1128 U1018/XI15-net18 VDD pch W=0.205u L=0.04u
M_U1018/MI15-MI15 U1018/XI15-net18 n1125 VDD VDD pch W=0.205u L=0.04u
M_U1019/M_u3-M_u2 n1128 U1019/net6 VSS VSS nch W=0.155u L=0.04u
M_U1019/M_u2-M_u4 U1019/X_u2-net6 n1156 VSS VSS nch W=0.155u L=0.04u
M_U1019/M_u2-M_u3 U1019/net6 n1155 U1019/X_u2-net6 VSS nch W=0.155u L=0.04u
M_U1019/M_u3-M_u3 n1128 U1019/net6 VDD VDD pch W=0.205u L=0.04u
M_U1019/M_u2-M_u2 U1019/net6 n1156 VDD VDD pch W=0.205u L=0.04u
M_U1019/M_u2-M_u1 U1019/net6 n1155 VDD VDD pch W=0.205u L=0.04u
M_U1020/M_u2 n1107 n1111 VSS VSS nch W=0.135u L=0.04u
M_U1020/M_u1 n1107 n1111 VDD VDD pch W=0.205u L=0.04u
M_U1021/MI1-M_u4 n1111 n1105 VSS VSS nch W=0.155u L=0.04u
M_U1021/MI1-M_u3 n1111 n1104 VSS VSS nch W=0.155u L=0.04u
M_U1021/MI1-M_u1 U1021/XI1-net8 n1104 VDD VDD pch W=0.205u L=0.04u
M_U1021/MI1-M_u2 n1111 n1105 U1021/XI1-net8 VDD pch W=0.205u L=0.04u
M_U1022/MU10 U1022/net26 n1159 VSS VSS nch W=0.155u L=0.04u
M_U1022/MU9 U1022/net26 n1157 n1106 VSS nch W=0.155u L=0.04u
M_U1022/MU8 U1022/net26 n1158 n1106 VSS nch W=0.155u L=0.04u
M_U1022/MU6 n1106 n1157 U1022/net38 VSS nch W=0.155u L=0.04u
M_U1022/MU7 U1022/net38 n1158 VSS VSS nch W=0.155u L=0.04u
M_U1022/MU2 U1022/net16 n1158 VDD VDD pch W=0.205u L=0.04u
M_U1022/MU5 U1022/net20 n1157 n1106 VDD pch W=0.205u L=0.04u
M_U1022/MU3 n1106 n1157 U1022/net16 VDD pch W=0.205u L=0.04u
M_U1022/MU4 U1022/net20 n1158 n1106 VDD pch W=0.205u L=0.04u
M_U1022/MU1 U1022/net20 n1159 VDD VDD pch W=0.205u L=0.04u
M_U1023/MI22 U1023/net29 n1163 VSS VSS nch W=0.155u L=0.04u
M_U1023/MI21 n1159 n1162 U1023/net29 VSS nch W=0.155u L=0.04u
M_U1023/MI9 n1159 n1160 U1023/net23 VSS nch W=0.155u L=0.04u
M_U1023/MI20 U1023/net23 n1161 VSS VSS nch W=0.155u L=0.04u
M_U1023/MI18 U1023/net20 n1161 n1159 VDD pch W=0.205u L=0.04u
M_U1023/MI19 U1023/net20 n1160 n1159 VDD pch W=0.205u L=0.04u
M_U1023/MI17 VDD n1162 U1023/net20 VDD pch W=0.205u L=0.04u
M_U1023/M_u5 VDD n1163 U1023/net20 VDD pch W=0.205u L=0.04u
M_U1024/M_u2 n1161 n1112 VSS VSS nch W=0.135u L=0.04u
M_U1024/M_u1 n1161 n1112 VDD VDD pch W=0.205u L=0.04u
M_U1025/MI1-M_u4 n1112 n1163 VSS VSS nch W=0.155u L=0.04u
M_U1025/MI1-M_u3 n1112 n1162 VSS VSS nch W=0.155u L=0.04u
M_U1025/MI1-M_u1 U1025/XI1-net8 n1162 VDD VDD pch W=0.205u L=0.04u
M_U1025/MI1-M_u2 n1112 n1163 U1025/XI1-net8 VDD pch W=0.205u L=0.04u
M_U1026/MI9 n1160 n1164 U1026/net14 VSS nch W=0.155u L=0.04u
M_U1026/MI11 U1026/net14 n1166 VSS VSS nch W=0.155u L=0.04u
M_U1026/MI12 U1026/net14 n1165 VSS VSS nch W=0.155u L=0.04u
M_U1026/MI3 n1160 n1119 U1026/net14 VSS nch W=0.155u L=0.04u
M_U1026/MI8 n1160 n1110 U1026/net14 VSS nch W=0.155u L=0.04u
M_U1026/MI16-MI12 n1160 n1166 U1026/XI16-net11 VDD pch W=0.205u L=0.04u
M_U1026/MI16-MI13 U1026/XI16-net11 n1165 VDD VDD pch W=0.205u L=0.04u
M_U1026/MI15-MI12 n1160 n1119 U1026/XI15-net11 VDD pch W=0.205u L=0.04u
M_U1026/MI15-MI13 U1026/XI15-net11 n1110 U1026/XI15-net18 VDD pch W=0.205u L=0.04u
M_U1026/MI15-MI15 U1026/XI15-net18 n1164 VDD VDD pch W=0.205u L=0.04u
M_U1027/M_u3-M_u2 n1110 U1027/net6 VSS VSS nch W=0.155u L=0.04u
M_U1027/M_u2-M_u4 U1027/X_u2-net6 n1166 VSS VSS nch W=0.155u L=0.04u
M_U1027/M_u2-M_u3 U1027/net6 n1165 U1027/X_u2-net6 VSS nch W=0.155u L=0.04u
M_U1027/M_u3-M_u3 n1110 U1027/net6 VDD VDD pch W=0.205u L=0.04u
M_U1027/M_u2-M_u2 U1027/net6 n1166 VDD VDD pch W=0.205u L=0.04u
M_U1027/M_u2-M_u1 U1027/net6 n1165 VDD VDD pch W=0.205u L=0.04u
M_U1028/MI15-M_u2 U1028/net19 N18 VSS VSS nch W=0.155u L=0.04u
M_U1028/MI21 n1158 N18 U1028/net40 VSS nch W=0.155u L=0.04u
M_U1028/MI12 n1158 U1028/net19 U1028/net36 VSS nch W=0.155u L=0.04u
M_U1028/MI20 U1028/net40 N194 VSS VSS nch W=0.31u L=0.04u
M_U1028/MI19 U1028/net36 N121 VSS VSS nch W=0.155u L=0.04u
M_U1028/MI15-M_u3 U1028/net19 N18 VDD VDD pch W=0.205u L=0.04u
M_U1028/MI25 n1158 U1028/net19 U1028/net26 VDD pch W=0.325u L=0.04u
M_U1028/MI24 U1028/net26 N194 VDD VDD pch W=0.41u L=0.04u
M_U1028/MI5 n1158 N18 U1028/net30 VDD pch W=0.325u L=0.04u
M_U1028/MI111 U1028/net30 N121 VDD VDD pch W=0.205u L=0.04u
M_U1029/MI12 U1029/net32 n1092 VSS VSS nch W=0.155u L=0.04u
M_U1029/MI11 U1029/net59 n1093 U1029/net32 VSS nch W=0.155u L=0.04u
M_U1029/MI6 U1029/net59 n1096 VSS VSS nch W=0.155u L=0.04u
M_U1029/MI8-M_u2 n1094 U1029/net59 VSS VSS nch W=0.155u L=0.04u
M_U1029/MI8-M_u3 n1094 U1029/net59 VDD VDD pch W=0.2u L=0.04u
M_U1029/MI10 U1029/net59 n1093 U1029/net22 VDD pch W=0.205u L=0.04u
M_U1029/MI9 U1029/net59 n1092 U1029/net22 VDD pch W=0.205u L=0.04u
M_U1029/M_u2 U1029/net22 n1096 VDD VDD pch W=0.2u L=0.04u
M_U1030/M_u2 n1093 n1167 VSS VSS nch W=0.135u L=0.04u
M_U1030/M_u1 n1093 n1167 VDD VDD pch W=0.205u L=0.04u
M_U1031/MU10 U1031/net26 n1170 VSS VSS nch W=0.155u L=0.04u
M_U1031/MU9 U1031/net26 n1168 n1167 VSS nch W=0.155u L=0.04u
M_U1031/MU8 U1031/net26 n1169 n1167 VSS nch W=0.155u L=0.04u
M_U1031/MU6 n1167 n1168 U1031/net38 VSS nch W=0.155u L=0.04u
M_U1031/MU7 U1031/net38 n1169 VSS VSS nch W=0.155u L=0.04u
M_U1031/MU2 U1031/net16 n1169 VDD VDD pch W=0.205u L=0.04u
M_U1031/MU5 U1031/net20 n1168 n1167 VDD pch W=0.205u L=0.04u
M_U1031/MU3 n1167 n1168 U1031/net16 VDD pch W=0.205u L=0.04u
M_U1031/MU4 U1031/net20 n1169 n1167 VDD pch W=0.205u L=0.04u
M_U1031/MU1 U1031/net20 n1170 VDD VDD pch W=0.205u L=0.04u
M_U1032/MI15-M_u2 U1032/net19 N18 VSS VSS nch W=0.155u L=0.04u
M_U1032/MI21 n1170 N18 U1032/net40 VSS nch W=0.155u L=0.04u
M_U1032/MI12 n1170 U1032/net19 U1032/net36 VSS nch W=0.155u L=0.04u
M_U1032/MI20 U1032/net40 N190 VSS VSS nch W=0.31u L=0.04u
M_U1032/MI19 U1032/net36 N50 VSS VSS nch W=0.155u L=0.04u
M_U1032/MI15-M_u3 U1032/net19 N18 VDD VDD pch W=0.205u L=0.04u
M_U1032/MI25 n1170 U1032/net19 U1032/net26 VDD pch W=0.325u L=0.04u
M_U1032/MI24 U1032/net26 N190 VDD VDD pch W=0.41u L=0.04u
M_U1032/MI5 n1170 N18 U1032/net30 VDD pch W=0.325u L=0.04u
M_U1032/MI111 U1032/net30 N50 VDD VDD pch W=0.205u L=0.04u
M_U1033/MI8 n1169 n1100 U1033/net23 VDD pch W=0.205u L=0.04u
M_U1033/MI6 n1169 n1099 U1033/net23 VDD pch W=0.205u L=0.04u
M_U1033/MI7 n1169 n1103 U1033/net23 VDD pch W=0.205u L=0.04u
M_U1033/MU20 U1033/net23 n1171 VDD VDD pch W=0.205u L=0.04u
M_U1033/MI5 U1033/net23 n1172 VDD VDD pch W=0.205u L=0.04u
M_U1033/MI20-MI12 U1033/XI20-net13 n1099 VSS VSS nch W=0.155u L=0.04u
M_U1033/MI20-M_u10 n1169 n1100 U1033/XI20-net17 VSS nch W=0.155u L=0.04u
M_U1033/MI20-M_u11 U1033/XI20-net17 n1103 U1033/XI20-net13 VSS nch W=0.155u L=0.04u
M_U1033/MI17-M_u10 n1169 n1171 U1033/XI17-net17 VSS nch W=0.155u L=0.04u
M_U1033/MI17-M_u11 U1033/XI17-net17 n1172 VSS VSS nch W=0.155u L=0.04u
M_U1034/M_u2 n1171 n1173 VSS VSS nch W=0.135u L=0.04u
M_U1034/M_u1 n1171 n1173 VDD VDD pch W=0.205u L=0.04u
M_U1035/MU1-M_u4 U1035/XU1-net6 n1173 VSS VSS nch W=0.155u L=0.04u
M_U1035/MU1-M_u3 n1103 n1174 U1035/XU1-net6 VSS nch W=0.155u L=0.04u
M_U1035/MU1-M_u2 n1103 n1173 VDD VDD pch W=0.155u L=0.04u
M_U1035/MU1-M_u1 n1103 n1174 VDD VDD pch W=0.155u L=0.04u
M_U1036/M_u2 n1100 n1175 VSS VSS nch W=0.135u L=0.04u
M_U1036/M_u1 n1100 n1175 VDD VDD pch W=0.205u L=0.04u
M_U1037/MI15-M_u2 U1037/net19 N18 VSS VSS nch W=0.155u L=0.04u
M_U1037/MI21 n1058 N18 U1037/net40 VSS nch W=0.155u L=0.04u
M_U1037/MI12 n1058 U1037/net19 U1037/net36 VSS nch W=0.155u L=0.04u
M_U1037/MI20 U1037/net40 n1176 VSS VSS nch W=0.31u L=0.04u
M_U1037/MI19 U1037/net36 N109 VSS VSS nch W=0.155u L=0.04u
M_U1037/MI15-M_u3 U1037/net19 N18 VDD VDD pch W=0.205u L=0.04u
M_U1037/MI25 n1058 U1037/net19 U1037/net26 VDD pch W=0.325u L=0.04u
M_U1037/MI24 U1037/net26 n1176 VDD VDD pch W=0.41u L=0.04u
M_U1037/MI5 n1058 N18 U1037/net30 VDD pch W=0.325u L=0.04u
M_U1037/MI111 U1037/net30 N109 VDD VDD pch W=0.205u L=0.04u
M_U1038/MI19 U1038/p2 n1180 VSS VSS nch W=0.155u L=0.04u
M_U1038/MI17 U1038/p0 n1178 U1038/p1 VSS nch W=0.155u L=0.04u
M_U1038/MI18 U1038/p1 n1179 U1038/p2 VSS nch W=0.155u L=0.04u
M_U1038/MU53 N10576 n1177 U1038/p0 VSS nch W=0.155u L=0.04u
M_U1038/MI14 N10576 n1179 VDD VDD pch W=0.205u L=0.04u
M_U1038/MI15 N10576 n1178 VDD VDD pch W=0.205u L=0.04u
M_U1038/MI16 N10576 n1177 VDD VDD pch W=0.205u L=0.04u
M_U1038/MI9 N10576 n1180 VDD VDD pch W=0.205u L=0.04u
M_U1039/MI15-M_u3 U1039/net28 U1039/net20 U1039/net64 VSS nch W=0.155u L=0.04u
M_U1039/MI8-M_u3 U1039/net24 U1039/net30 U1039/net32 VSS nch W=0.155u L=0.04u
M_U1039/MI17-M_u3 U1039/net28 U1039/net40 U1039/net24 VSS nch W=0.155u L=0.04u
M_U1039/MI11-M_u3 U1039/net40 n1183 U1039/net108 VSS nch W=0.155u L=0.04u
M_U1039/MI9-M_u3 U1039/net40 U1039/net106 U1039/net104 VSS nch W=0.155u L=0.04u
M_U1039/MI21 U1039/net24 n1181 U1039/net050 VSS nch W=0.155u L=0.04u
M_U1039/MI22 U1039/net050 U1039/net32 VSS VSS nch W=0.155u L=0.04u
M_U1039/MI19-M_u2 U1039/net20 U1039/net40 VSS VSS nch W=0.155u L=0.04u
M_U1039/MI13-M_u2 U1039/net106 n1183 VSS VSS nch W=0.155u L=0.04u
M_U1039/MI14-M_u2 U1039/net104 n1182 VSS VSS nch W=0.155u L=0.04u
M_U1039/M_u8-M_u2 U1039/net30 n1181 VSS VSS nch W=0.155u L=0.04u
M_U1039/MI12-M_u2 U1039/net108 U1039/net104 VSS VSS nch W=0.155u L=0.04u
M_U1039/MU20-M_u2 n1180 U1039/net28 VSS VSS nch W=0.155u L=0.04u
M_U1039/MI1-M_u2 U1039/net32 n1047 VSS VSS nch W=0.155u L=0.04u
M_U1039/MI16-M_u2 U1039/net64 U1039/net24 VSS VSS nch W=0.2u L=0.04u
M_U1039/MI15-M_u2 U1039/net28 U1039/net40 U1039/net64 VDD pch W=0.205u L=0.04u
M_U1039/MI8-M_u2 U1039/net24 n1181 U1039/net32 VDD pch W=0.205u L=0.04u
M_U1039/MI17-M_u2 U1039/net28 U1039/net20 U1039/net24 VDD pch W=0.205u L=0.04u
M_U1039/MI11-M_u2 U1039/net40 U1039/net106 U1039/net108 VDD pch W=0.205u L=0.04u
M_U1039/MI9-M_u2 U1039/net40 n1183 U1039/net104 VDD pch W=0.205u L=0.04u
M_U1039/MI19-M_u3 U1039/net20 U1039/net40 VDD VDD pch W=0.205u L=0.04u
M_U1039/MI13-M_u3 U1039/net106 n1183 VDD VDD pch W=0.205u L=0.04u
M_U1039/MI14-M_u3 U1039/net104 n1182 VDD VDD pch W=0.205u L=0.04u
M_U1039/M_u8-M_u3 U1039/net30 n1181 VDD VDD pch W=0.205u L=0.04u
M_U1039/MI12-M_u3 U1039/net108 U1039/net104 VDD VDD pch W=0.205u L=0.04u
M_U1039/MU20-M_u3 n1180 U1039/net28 VDD VDD pch W=0.205u L=0.04u
M_U1039/MI1-M_u3 U1039/net32 n1047 VDD VDD pch W=0.205u L=0.04u
M_U1039/MI16-M_u3 U1039/net64 U1039/net24 VDD VDD pch W=0.28u L=0.04u
M_U1039/MI20 U1039/net24 U1039/net30 U1039/net045 VDD pch W=0.205u L=0.04u
M_U1039/M_u2 U1039/net045 U1039/net32 VDD VDD pch W=0.205u L=0.04u
M_U1040/M_u2 n1183 N165 U1040/net15 VSS nch W=0.155u L=0.04u
M_U1040/M_u3 n1183 n1184 U1040/net15 VSS nch W=0.155u L=0.04u
M_U1040/M_u4 U1040/net15 n1050 VSS VSS nch W=0.155u L=0.04u
M_U1040/M_u9 n1183 n1050 VDD VDD pch W=0.205u L=0.04u
M_U1040/MI16-MI12 n1183 N165 U1040/XI16-net11 VDD pch W=0.205u L=0.04u
M_U1040/MI16-MI13 U1040/XI16-net11 n1184 VDD VDD pch W=0.205u L=0.04u
M_U1041/M_u2 n1182 N164 U1041/net15 VSS nch W=0.155u L=0.04u
M_U1041/M_u3 n1182 n1185 U1041/net15 VSS nch W=0.155u L=0.04u
M_U1041/M_u4 U1041/net15 n1050 VSS VSS nch W=0.155u L=0.04u
M_U1041/M_u9 n1182 n1050 VDD VDD pch W=0.205u L=0.04u
M_U1041/MI16-MI12 n1182 N164 U1041/XI16-net11 VDD pch W=0.205u L=0.04u
M_U1041/MI16-MI13 U1041/XI16-net11 n1185 VDD VDD pch W=0.205u L=0.04u
M_U1042/M_u2 n1047 N169 U1042/net15 VSS nch W=0.155u L=0.04u
M_U1042/M_u3 n1047 n1185 U1042/net15 VSS nch W=0.155u L=0.04u
M_U1042/M_u4 U1042/net15 n1050 VSS VSS nch W=0.155u L=0.04u
M_U1042/M_u9 n1047 n1050 VDD VDD pch W=0.205u L=0.04u
M_U1042/MI16-MI12 n1047 N169 U1042/XI16-net11 VDD pch W=0.205u L=0.04u
M_U1042/MI16-MI13 U1042/XI16-net11 n1185 VDD VDD pch W=0.205u L=0.04u
M_U1043/MI15-M_u3 U1043/net28 U1043/net20 U1043/net64 VSS nch W=0.155u L=0.04u
M_U1043/MI8-M_u3 U1043/net24 U1043/net30 U1043/net32 VSS nch W=0.155u L=0.04u
M_U1043/MI17-M_u3 U1043/net28 U1043/net40 U1043/net24 VSS nch W=0.155u L=0.04u
M_U1043/MI11-M_u3 U1043/net40 n1039 U1043/net108 VSS nch W=0.155u L=0.04u
M_U1043/MI9-M_u3 U1043/net40 U1043/net106 U1043/net104 VSS nch W=0.155u L=0.04u
M_U1043/MI21 U1043/net24 n1186 U1043/net050 VSS nch W=0.155u L=0.04u
M_U1043/MI22 U1043/net050 U1043/net32 VSS VSS nch W=0.155u L=0.04u
M_U1043/MI19-M_u2 U1043/net20 U1043/net40 VSS VSS nch W=0.155u L=0.04u
M_U1043/MI13-M_u2 U1043/net106 n1039 VSS VSS nch W=0.155u L=0.04u
M_U1043/MI14-M_u2 U1043/net104 n1037 VSS VSS nch W=0.155u L=0.04u
M_U1043/M_u8-M_u2 U1043/net30 n1186 VSS VSS nch W=0.155u L=0.04u
M_U1043/MI12-M_u2 U1043/net108 U1043/net104 VSS VSS nch W=0.155u L=0.04u
M_U1043/MU20-M_u2 n1181 U1043/net28 VSS VSS nch W=0.155u L=0.04u
M_U1043/MI1-M_u2 U1043/net32 n1033 VSS VSS nch W=0.155u L=0.04u
M_U1043/MI16-M_u2 U1043/net64 U1043/net24 VSS VSS nch W=0.2u L=0.04u
M_U1043/MI15-M_u2 U1043/net28 U1043/net40 U1043/net64 VDD pch W=0.205u L=0.04u
M_U1043/MI8-M_u2 U1043/net24 n1186 U1043/net32 VDD pch W=0.205u L=0.04u
M_U1043/MI17-M_u2 U1043/net28 U1043/net20 U1043/net24 VDD pch W=0.205u L=0.04u
M_U1043/MI11-M_u2 U1043/net40 U1043/net106 U1043/net108 VDD pch W=0.205u L=0.04u
M_U1043/MI9-M_u2 U1043/net40 n1039 U1043/net104 VDD pch W=0.205u L=0.04u
M_U1043/MI19-M_u3 U1043/net20 U1043/net40 VDD VDD pch W=0.205u L=0.04u
M_U1043/MI13-M_u3 U1043/net106 n1039 VDD VDD pch W=0.205u L=0.04u
M_U1043/MI14-M_u3 U1043/net104 n1037 VDD VDD pch W=0.205u L=0.04u
M_U1043/M_u8-M_u3 U1043/net30 n1186 VDD VDD pch W=0.205u L=0.04u
M_U1043/MI12-M_u3 U1043/net108 U1043/net104 VDD VDD pch W=0.205u L=0.04u
M_U1043/MU20-M_u3 n1181 U1043/net28 VDD VDD pch W=0.205u L=0.04u
M_U1043/MI1-M_u3 U1043/net32 n1033 VDD VDD pch W=0.205u L=0.04u
M_U1043/MI16-M_u3 U1043/net64 U1043/net24 VDD VDD pch W=0.28u L=0.04u
M_U1043/MI20 U1043/net24 U1043/net30 U1043/net045 VDD pch W=0.205u L=0.04u
M_U1043/M_u2 U1043/net045 U1043/net32 VDD VDD pch W=0.205u L=0.04u
M_U1044/MI2 n1039 N168 U1044/net27 VSS nch W=0.155u L=0.04u
M_U1044/MI10 U1044/net27 n1050 VSS VSS nch W=0.155u L=0.04u
M_U1044/MI11 n1039 n1185 VSS VSS nch W=0.155u L=0.04u
M_U1044/MI8 n1039 n1050 U1044/net13 VDD pch W=0.205u L=0.04u
M_U1044/M_u2 U1044/net13 n1185 VDD VDD pch W=0.205u L=0.04u
M_U1044/MI9 n1039 N168 U1044/net13 VDD pch W=0.205u L=0.04u
M_U1045/MI19 U1045/net14 n1185 U1045/net20 VSS nch W=0.155u L=0.04u
M_U1045/MI11 U1045/net14 N167 U1045/net20 VSS nch W=0.155u L=0.04u
M_U1045/MI20 U1045/net20 n1050 VSS VSS nch W=0.155u L=0.04u
M_U1045/MI8-M_u2 n1037 U1045/net14 VSS VSS nch W=0.155u L=0.04u
M_U1045/MI8-M_u3 n1037 U1045/net14 VDD VDD pch W=0.205u L=0.04u
M_U1045/M_u2 U1045/net14 n1050 VDD VDD pch W=0.205u L=0.04u
M_U1045/MI17 U1045/net24 n1185 VDD VDD pch W=0.205u L=0.04u
M_U1045/MI18 U1045/net14 N167 U1045/net24 VDD pch W=0.205u L=0.04u
M_U1046/MI2 n1033 N166 U1046/net27 VSS nch W=0.155u L=0.04u
M_U1046/MI10 U1046/net27 n1050 VSS VSS nch W=0.155u L=0.04u
M_U1046/MI11 n1033 n1185 VSS VSS nch W=0.155u L=0.04u
M_U1046/MI8 n1033 n1050 U1046/net13 VDD pch W=0.205u L=0.04u
M_U1046/M_u2 U1046/net13 n1185 VDD VDD pch W=0.205u L=0.04u
M_U1046/MI9 n1033 N166 U1046/net13 VDD pch W=0.205u L=0.04u
M_U1047/M_u4 n1186 n1044 VSS VSS nch W=0.155u L=0.04u
M_U1047/MI2 n1186 N170 VSS VSS nch W=0.155u L=0.04u
M_U1047/MI3 n1186 n1184 VSS VSS nch W=0.155u L=0.04u
M_U1047/M_u1 U1047/net25 n1044 VDD VDD pch W=0.41u L=0.04u
M_U1047/MI0 U1047/net28 N170 U1047/net25 VDD pch W=0.41u L=0.04u
M_U1047/MI1 n1186 n1184 U1047/net28 VDD pch W=0.41u L=0.04u
M_U1048/MI15-M_u3 U1048/net28 U1048/net20 U1048/net64 VSS nch W=0.155u L=0.04u
M_U1048/MI8-M_u3 U1048/net24 U1048/net30 U1048/net32 VSS nch W=0.155u L=0.04u
M_U1048/MI17-M_u3 U1048/net28 U1048/net40 U1048/net24 VSS nch W=0.155u L=0.04u
M_U1048/MI11-M_u3 U1048/net40 n1188 U1048/net108 VSS nch W=0.155u L=0.04u
M_U1048/MI9-M_u3 U1048/net40 U1048/net106 U1048/net104 VSS nch W=0.155u L=0.04u
M_U1048/MI21 U1048/net24 n1175 U1048/net050 VSS nch W=0.155u L=0.04u
M_U1048/MI22 U1048/net050 U1048/net32 VSS VSS nch W=0.155u L=0.04u
M_U1048/MI19-M_u2 U1048/net20 U1048/net40 VSS VSS nch W=0.155u L=0.04u
M_U1048/MI13-M_u2 U1048/net106 n1188 VSS VSS nch W=0.155u L=0.04u
M_U1048/MI14-M_u2 U1048/net104 n1187 VSS VSS nch W=0.155u L=0.04u
M_U1048/M_u8-M_u2 U1048/net30 n1175 VSS VSS nch W=0.155u L=0.04u
M_U1048/MI12-M_u2 U1048/net108 U1048/net104 VSS VSS nch W=0.155u L=0.04u
M_U1048/MU20-M_u2 n1179 U1048/net28 VSS VSS nch W=0.155u L=0.04u
M_U1048/MI1-M_u2 U1048/net32 n1165 VSS VSS nch W=0.155u L=0.04u
M_U1048/MI16-M_u2 U1048/net64 U1048/net24 VSS VSS nch W=0.2u L=0.04u
M_U1048/MI15-M_u2 U1048/net28 U1048/net40 U1048/net64 VDD pch W=0.205u L=0.04u
M_U1048/MI8-M_u2 U1048/net24 n1175 U1048/net32 VDD pch W=0.205u L=0.04u
M_U1048/MI17-M_u2 U1048/net28 U1048/net20 U1048/net24 VDD pch W=0.205u L=0.04u
M_U1048/MI11-M_u2 U1048/net40 U1048/net106 U1048/net108 VDD pch W=0.205u L=0.04u
M_U1048/MI9-M_u2 U1048/net40 n1188 U1048/net104 VDD pch W=0.205u L=0.04u
M_U1048/MI19-M_u3 U1048/net20 U1048/net40 VDD VDD pch W=0.205u L=0.04u
M_U1048/MI13-M_u3 U1048/net106 n1188 VDD VDD pch W=0.205u L=0.04u
M_U1048/MI14-M_u3 U1048/net104 n1187 VDD VDD pch W=0.205u L=0.04u
M_U1048/M_u8-M_u3 U1048/net30 n1175 VDD VDD pch W=0.205u L=0.04u
M_U1048/MI12-M_u3 U1048/net108 U1048/net104 VDD VDD pch W=0.205u L=0.04u
M_U1048/MU20-M_u3 n1179 U1048/net28 VDD VDD pch W=0.205u L=0.04u
M_U1048/MI1-M_u3 U1048/net32 n1165 VDD VDD pch W=0.205u L=0.04u
M_U1048/MI16-M_u3 U1048/net64 U1048/net24 VDD VDD pch W=0.28u L=0.04u
M_U1048/MI20 U1048/net24 U1048/net30 U1048/net045 VDD pch W=0.205u L=0.04u
M_U1048/M_u2 U1048/net045 U1048/net32 VDD VDD pch W=0.205u L=0.04u
M_U1049/MI15 U1049/net29 U1049/net21 U1049/net041 VSS nch W=0.155u L=0.04u
M_U1049/MU63 U1049/net035 U1049/net19 VSS VSS nch W=0.155u L=0.04u
M_U1049/MI14 U1049/net041 U1049/net13 VSS VSS nch W=0.155u L=0.04u
M_U1049/MI42 U1049/net25 n1102 U1049/net035 VSS nch W=0.155u L=0.04u
M_U1049/M_u6-M_u3 U1049/net19 U1049/net17 U1049/net25 VSS nch W=0.155u L=0.04u
M_U1049/MU18-M_u3 U1049/net13 U1049/net25 U1049/net29 VSS nch W=0.155u L=0.04u
M_U1049/MI1-M_u2 n1188 U1049/net29 VSS VSS nch W=0.155u L=0.04u
M_U1049/MI3-M_u2 U1049/net13 n1189 VSS VSS nch W=0.155u L=0.04u
M_U1049/MI7-M_u2 U1049/net17 n1102 VSS VSS nch W=0.155u L=0.04u
M_U1049/MI2-M_u2 U1049/net19 n1092 VSS VSS nch W=0.155u L=0.04u
M_U1049/MI6-M_u2 U1049/net21 U1049/net25 VSS VSS nch W=0.155u L=0.04u
M_U1049/MU62 U1049/net028 U1049/net19 VDD VDD pch W=0.205u L=0.04u
M_U1049/MI8 U1049/net25 U1049/net17 U1049/net028 VDD pch W=0.205u L=0.04u
M_U1049/MI12 U1049/net29 U1049/net25 U1049/net029 VDD pch W=0.205u L=0.04u
M_U1049/MI13 U1049/net029 U1049/net13 VDD VDD pch W=0.205u L=0.04u
M_U1049/M_u6-M_u2 U1049/net19 n1102 U1049/net25 VDD pch W=0.205u L=0.04u
M_U1049/MU18-M_u2 U1049/net13 U1049/net21 U1049/net29 VDD pch W=0.205u L=0.04u
M_U1049/MI1-M_u3 n1188 U1049/net29 VDD VDD pch W=0.205u L=0.04u
M_U1049/MI3-M_u3 U1049/net13 n1189 VDD VDD pch W=0.205u L=0.04u
M_U1049/MI7-M_u3 U1049/net17 n1102 VDD VDD pch W=0.205u L=0.04u
M_U1049/MI2-M_u3 U1049/net19 n1092 VDD VDD pch W=0.205u L=0.04u
M_U1049/MI6-M_u3 U1049/net21 U1049/net25 VDD VDD pch W=0.205u L=0.04u
M_U1050/MI15-M_u2 U1050/net19 N18 VSS VSS nch W=0.155u L=0.04u
M_U1050/MI21 n1189 N18 U1050/net40 VSS nch W=0.155u L=0.04u
M_U1050/MI12 n1189 U1050/net19 U1050/net36 VSS nch W=0.155u L=0.04u
M_U1050/MI20 U1050/net40 n1191 VSS VSS nch W=0.31u L=0.04u
M_U1050/MI19 U1050/net36 n1190 VSS VSS nch W=0.155u L=0.04u
M_U1050/MI15-M_u3 U1050/net19 N18 VDD VDD pch W=0.205u L=0.04u
M_U1050/MI25 n1189 U1050/net19 U1050/net26 VDD pch W=0.325u L=0.04u
M_U1050/MI24 U1050/net26 n1191 VDD VDD pch W=0.41u L=0.04u
M_U1050/MI5 n1189 N18 U1050/net30 VDD pch W=0.325u L=0.04u
M_U1050/MI111 U1050/net30 n1190 VDD VDD pch W=0.205u L=0.04u
M_U1051/M_u6-M_u3 U1051/net4 U1051/net10 U1051/net14 VSS nch W=0.155u L=0.04u
M_U1051/MI3-M_u3 U1051/net6 N197 U1051/net14 VSS nch W=0.155u L=0.04u
M_U1051/MI1-M_u2 U1051/net4 n1117 VSS VSS nch W=0.155u L=0.04u
M_U1051/M_u5-M_u2 U1051/net6 U1051/net4 VSS VSS nch W=0.155u L=0.04u
M_U1051/M_u4-M_u2 n1191 U1051/net14 VSS VSS nch W=0.155u L=0.04u
M_U1051/MI2-M_u2 U1051/net10 N197 VSS VSS nch W=0.155u L=0.04u
M_U1051/M_u6-M_u2 U1051/net4 N197 U1051/net14 VDD pch W=0.205u L=0.04u
M_U1051/MI3-M_u2 U1051/net6 U1051/net10 U1051/net14 VDD pch W=0.205u L=0.04u
M_U1051/MI1-M_u3 U1051/net4 n1117 VDD VDD pch W=0.205u L=0.04u
M_U1051/M_u5-M_u3 U1051/net6 U1051/net4 VDD VDD pch W=0.205u L=0.04u
M_U1051/M_u4-M_u3 n1191 U1051/net14 VDD VDD pch W=0.205u L=0.04u
M_U1051/MI2-M_u3 U1051/net10 N197 VDD VDD pch W=0.205u L=0.04u
M_U1052/M_u2 n1117 n1164 VSS VSS nch W=0.135u L=0.04u
M_U1052/M_u1 n1117 n1164 VDD VDD pch W=0.205u L=0.04u
M_U1053/M_u6-M_u3 U1053/net4 U1053/net10 U1053/net14 VSS nch W=0.155u L=0.04u
M_U1053/MI3-M_u3 U1053/net6 n1164 U1053/net14 VSS nch W=0.155u L=0.04u
M_U1053/MI1-M_u2 U1053/net4 n1192 VSS VSS nch W=0.155u L=0.04u
M_U1053/M_u5-M_u2 U1053/net6 U1053/net4 VSS VSS nch W=0.155u L=0.04u
M_U1053/M_u4-M_u2 n1190 U1053/net14 VSS VSS nch W=0.155u L=0.04u
M_U1053/MI2-M_u2 U1053/net10 n1164 VSS VSS nch W=0.155u L=0.04u
M_U1053/M_u6-M_u2 U1053/net4 n1164 U1053/net14 VDD pch W=0.205u L=0.04u
M_U1053/MI3-M_u2 U1053/net6 U1053/net10 U1053/net14 VDD pch W=0.205u L=0.04u
M_U1053/MI1-M_u3 U1053/net4 n1192 VDD VDD pch W=0.205u L=0.04u
M_U1053/M_u5-M_u3 U1053/net6 U1053/net4 VDD VDD pch W=0.205u L=0.04u
M_U1053/M_u4-M_u3 n1190 U1053/net14 VDD VDD pch W=0.205u L=0.04u
M_U1053/MI2-M_u3 U1053/net10 n1164 VDD VDD pch W=0.205u L=0.04u
M_U1054/MI15-M_u2 U1054/net19 N18 VSS VSS nch W=0.155u L=0.04u
M_U1054/MI21 n1164 N18 U1054/net40 VSS nch W=0.155u L=0.04u
M_U1054/MI12 n1164 U1054/net19 U1054/net36 VSS nch W=0.155u L=0.04u
M_U1054/MI20 U1054/net40 N187 VSS VSS nch W=0.31u L=0.04u
M_U1054/MI19 U1054/net36 N118 VSS VSS nch W=0.155u L=0.04u
M_U1054/MI15-M_u3 U1054/net19 N18 VDD VDD pch W=0.205u L=0.04u
M_U1054/MI25 n1164 U1054/net19 U1054/net26 VDD pch W=0.325u L=0.04u
M_U1054/MI24 U1054/net26 N187 VDD VDD pch W=0.41u L=0.04u
M_U1054/MI5 n1164 N18 U1054/net30 VDD pch W=0.325u L=0.04u
M_U1054/MI111 U1054/net30 N118 VDD VDD pch W=0.205u L=0.04u
M_U1055/MU29-M_u2 n1102 U1055/net28 VSS VSS nch W=0.155u L=0.04u
M_U1055/MI111 U1055/net47 N50 VSS VSS nch W=0.155u L=0.04u
M_U1055/MI5 U1055/net28 U1055/net6 U1055/net47 VSS nch W=0.155u L=0.04u
M_U1055/MI14 U1055/net44 N190 VSS VSS nch W=0.155u L=0.04u
M_U1055/MI13 U1055/net28 N18 U1055/net44 VSS nch W=0.155u L=0.04u
M_U1055/MU24 U1055/net6 N18 VSS VSS nch W=0.155u L=0.04u
M_U1055/MU29-M_u3 n1102 U1055/net28 VDD VDD pch W=0.205u L=0.04u
M_U1055/MI2 VDD N50 U1055/net47 VDD pch W=0.205u L=0.04u
M_U1055/MI4 U1055/net47 N18 U1055/net28 VDD pch W=0.205u L=0.04u
M_U1055/MI12 U1055/net44 U1055/net6 U1055/net28 VDD pch W=0.205u L=0.04u
M_U1055/MI10 VDD N190 U1055/net44 VDD pch W=0.205u L=0.04u
M_U1055/MU25 VDD N18 U1055/net6 VDD pch W=0.205u L=0.04u
M_U1056/MI15-M_u2 U1056/net19 N18 VSS VSS nch W=0.155u L=0.04u
M_U1056/MI21 n1092 N18 U1056/net40 VSS nch W=0.155u L=0.04u
M_U1056/MI12 n1092 U1056/net19 U1056/net36 VSS nch W=0.155u L=0.04u
M_U1056/MI20 U1056/net40 N189 VSS VSS nch W=0.31u L=0.04u
M_U1056/MI19 U1056/net36 N66 VSS VSS nch W=0.155u L=0.04u
M_U1056/MI15-M_u3 U1056/net19 N18 VDD VDD pch W=0.205u L=0.04u
M_U1056/MI25 n1092 U1056/net19 U1056/net26 VDD pch W=0.325u L=0.04u
M_U1056/MI24 U1056/net26 N189 VDD VDD pch W=0.41u L=0.04u
M_U1056/MI5 n1092 N18 U1056/net30 VDD pch W=0.325u L=0.04u
M_U1056/MI111 U1056/net30 N66 VDD VDD pch W=0.205u L=0.04u
M_U1057/MI15-M_u3 U1057/net28 U1057/net20 U1057/net64 VSS nch W=0.155u L=0.04u
M_U1057/MI8-M_u3 U1057/net24 U1057/net30 U1057/net32 VSS nch W=0.155u L=0.04u
M_U1057/MI17-M_u3 U1057/net28 U1057/net40 U1057/net24 VSS nch W=0.155u L=0.04u
M_U1057/MI11-M_u3 U1057/net40 n1114 U1057/net108 VSS nch W=0.155u L=0.04u
M_U1057/MI9-M_u3 U1057/net40 U1057/net106 U1057/net104 VSS nch W=0.155u L=0.04u
M_U1057/MI21 U1057/net24 n1172 U1057/net050 VSS nch W=0.155u L=0.04u
M_U1057/MI22 U1057/net050 U1057/net32 VSS VSS nch W=0.155u L=0.04u
M_U1057/MI19-M_u2 U1057/net20 U1057/net40 VSS VSS nch W=0.155u L=0.04u
M_U1057/MI13-M_u2 U1057/net106 n1114 VSS VSS nch W=0.155u L=0.04u
M_U1057/MI14-M_u2 U1057/net104 n1105 VSS VSS nch W=0.155u L=0.04u
M_U1057/M_u8-M_u2 U1057/net30 n1172 VSS VSS nch W=0.155u L=0.04u
M_U1057/MI12-M_u2 U1057/net108 U1057/net104 VSS VSS nch W=0.155u L=0.04u
M_U1057/MU20-M_u2 n1187 U1057/net28 VSS VSS nch W=0.155u L=0.04u
M_U1057/MI1-M_u2 U1057/net32 n1163 VSS VSS nch W=0.155u L=0.04u
M_U1057/MI16-M_u2 U1057/net64 U1057/net24 VSS VSS nch W=0.2u L=0.04u
M_U1057/MI15-M_u2 U1057/net28 U1057/net40 U1057/net64 VDD pch W=0.205u L=0.04u
M_U1057/MI8-M_u2 U1057/net24 n1172 U1057/net32 VDD pch W=0.205u L=0.04u
M_U1057/MI17-M_u2 U1057/net28 U1057/net20 U1057/net24 VDD pch W=0.205u L=0.04u
M_U1057/MI11-M_u2 U1057/net40 U1057/net106 U1057/net108 VDD pch W=0.205u L=0.04u
M_U1057/MI9-M_u2 U1057/net40 n1114 U1057/net104 VDD pch W=0.205u L=0.04u
M_U1057/MI19-M_u3 U1057/net20 U1057/net40 VDD VDD pch W=0.205u L=0.04u
M_U1057/MI13-M_u3 U1057/net106 n1114 VDD VDD pch W=0.205u L=0.04u
M_U1057/MI14-M_u3 U1057/net104 n1105 VDD VDD pch W=0.205u L=0.04u
M_U1057/M_u8-M_u3 U1057/net30 n1172 VDD VDD pch W=0.205u L=0.04u
M_U1057/MI12-M_u3 U1057/net108 U1057/net104 VDD VDD pch W=0.205u L=0.04u
M_U1057/MU20-M_u3 n1187 U1057/net28 VDD VDD pch W=0.205u L=0.04u
M_U1057/MI1-M_u3 U1057/net32 n1163 VDD VDD pch W=0.205u L=0.04u
M_U1057/MI16-M_u3 U1057/net64 U1057/net24 VDD VDD pch W=0.28u L=0.04u
M_U1057/MI20 U1057/net24 U1057/net30 U1057/net045 VDD pch W=0.205u L=0.04u
M_U1057/M_u2 U1057/net045 U1057/net32 VDD VDD pch W=0.205u L=0.04u
M_U1058/MU29-M_u2 n1114 U1058/net28 VSS VSS nch W=0.155u L=0.04u
M_U1058/MI111 U1058/net47 N121 VSS VSS nch W=0.155u L=0.04u
M_U1058/MI5 U1058/net28 U1058/net6 U1058/net47 VSS nch W=0.155u L=0.04u
M_U1058/MI14 U1058/net44 N194 VSS VSS nch W=0.155u L=0.04u
M_U1058/MI13 U1058/net28 N18 U1058/net44 VSS nch W=0.155u L=0.04u
M_U1058/MU24 U1058/net6 N18 VSS VSS nch W=0.155u L=0.04u
M_U1058/MU29-M_u3 n1114 U1058/net28 VDD VDD pch W=0.205u L=0.04u
M_U1058/MI2 VDD N121 U1058/net47 VDD pch W=0.205u L=0.04u
M_U1058/MI4 U1058/net47 N18 U1058/net28 VDD pch W=0.205u L=0.04u
M_U1058/MI12 U1058/net44 U1058/net6 U1058/net28 VDD pch W=0.205u L=0.04u
M_U1058/MI10 VDD N194 U1058/net44 VDD pch W=0.205u L=0.04u
M_U1058/MU25 VDD N18 U1058/net6 VDD pch W=0.205u L=0.04u
M_U1059/MU29-M_u2 n1105 U1059/net28 VSS VSS nch W=0.155u L=0.04u
M_U1059/MI111 U1059/net47 N193 VSS VSS nch W=0.155u L=0.04u
M_U1059/MI5 U1059/net28 U1059/net6 U1059/net47 VSS nch W=0.155u L=0.04u
M_U1059/MI14 U1059/net44 N47 VSS VSS nch W=0.155u L=0.04u
M_U1059/MI13 U1059/net28 n1184 U1059/net44 VSS nch W=0.155u L=0.04u
M_U1059/MU24 U1059/net6 n1184 VSS VSS nch W=0.155u L=0.04u
M_U1059/MU29-M_u3 n1105 U1059/net28 VDD VDD pch W=0.205u L=0.04u
M_U1059/MI2 VDD N193 U1059/net47 VDD pch W=0.205u L=0.04u
M_U1059/MI4 U1059/net47 n1184 U1059/net28 VDD pch W=0.205u L=0.04u
M_U1059/MI12 U1059/net44 U1059/net6 U1059/net28 VDD pch W=0.205u L=0.04u
M_U1059/MI10 VDD N47 U1059/net44 VDD pch W=0.205u L=0.04u
M_U1059/MU25 VDD n1184 U1059/net6 VDD pch W=0.205u L=0.04u
M_U1060/MU29-M_u2 n1163 U1060/net28 VSS VSS nch W=0.155u L=0.04u
M_U1060/MI111 U1060/net47 N195 VSS VSS nch W=0.155u L=0.04u
M_U1060/MI5 U1060/net28 U1060/net6 U1060/net47 VSS nch W=0.155u L=0.04u
M_U1060/MI14 U1060/net44 N94 VSS VSS nch W=0.155u L=0.04u
M_U1060/MI13 U1060/net28 n1184 U1060/net44 VSS nch W=0.155u L=0.04u
M_U1060/MU24 U1060/net6 n1184 VSS VSS nch W=0.155u L=0.04u
M_U1060/MU29-M_u3 n1163 U1060/net28 VDD VDD pch W=0.205u L=0.04u
M_U1060/MI2 VDD N195 U1060/net47 VDD pch W=0.205u L=0.04u
M_U1060/MI4 U1060/net47 n1184 U1060/net28 VDD pch W=0.205u L=0.04u
M_U1060/MI12 U1060/net44 U1060/net6 U1060/net28 VDD pch W=0.205u L=0.04u
M_U1060/MI10 VDD N94 U1060/net44 VDD pch W=0.205u L=0.04u
M_U1060/MU25 VDD n1184 U1060/net6 VDD pch W=0.205u L=0.04u
M_U1061/M_u2 n1172 n1174 VSS VSS nch W=0.135u L=0.04u
M_U1061/M_u1 n1172 n1174 VDD VDD pch W=0.205u L=0.04u
M_U1062/MI15-M_u2 U1062/net19 N18 VSS VSS nch W=0.155u L=0.04u
M_U1062/MI21 n1174 N18 U1062/net40 VSS nch W=0.155u L=0.04u
M_U1062/MI12 n1174 U1062/net19 U1062/net36 VSS nch W=0.155u L=0.04u
M_U1062/MI20 U1062/net40 N191 VSS VSS nch W=0.31u L=0.04u
M_U1062/MI19 U1062/net36 N32 VSS VSS nch W=0.155u L=0.04u
M_U1062/MI15-M_u3 U1062/net19 N18 VDD VDD pch W=0.205u L=0.04u
M_U1062/MI25 n1174 U1062/net19 U1062/net26 VDD pch W=0.325u L=0.04u
M_U1062/MI24 U1062/net26 N191 VDD VDD pch W=0.41u L=0.04u
M_U1062/MI5 n1174 N18 U1062/net30 VDD pch W=0.325u L=0.04u
M_U1062/MI111 U1062/net30 N32 VDD VDD pch W=0.205u L=0.04u
M_U1063/MI15-M_u2 U1063/net19 n1184 VSS VSS nch W=0.155u L=0.04u
M_U1063/MI21 n1165 n1184 U1063/net40 VSS nch W=0.155u L=0.04u
M_U1063/MI12 n1165 U1063/net19 U1063/net36 VSS nch W=0.155u L=0.04u
M_U1063/MI20 U1063/net40 N97 VSS VSS nch W=0.31u L=0.04u
M_U1063/MI19 U1063/net36 N196 VSS VSS nch W=0.155u L=0.04u
M_U1063/MI15-M_u3 U1063/net19 n1184 VDD VDD pch W=0.205u L=0.04u
M_U1063/MI25 n1165 U1063/net19 U1063/net26 VDD pch W=0.325u L=0.04u
M_U1063/MI24 U1063/net26 N97 VDD VDD pch W=0.41u L=0.04u
M_U1063/MI5 n1165 n1184 U1063/net30 VDD pch W=0.325u L=0.04u
M_U1063/MI111 U1063/net30 N196 VDD VDD pch W=0.205u L=0.04u
M_U1064/MI15-M_u2 U1064/net19 N18 VSS VSS nch W=0.155u L=0.04u
M_U1064/MI21 n1175 N18 U1064/net40 VSS nch W=0.155u L=0.04u
M_U1064/MI12 n1175 U1064/net19 U1064/net36 VSS nch W=0.155u L=0.04u
M_U1064/MI20 U1064/net40 N192 VSS VSS nch W=0.31u L=0.04u
M_U1064/MI19 U1064/net36 N35 VSS VSS nch W=0.155u L=0.04u
M_U1064/MI15-M_u3 U1064/net19 N18 VDD VDD pch W=0.205u L=0.04u
M_U1064/MI25 n1175 U1064/net19 U1064/net26 VDD pch W=0.325u L=0.04u
M_U1064/MI24 U1064/net26 N192 VDD VDD pch W=0.41u L=0.04u
M_U1064/MI5 n1175 N18 U1064/net30 VDD pch W=0.325u L=0.04u
M_U1064/MI111 U1064/net30 N35 VDD VDD pch W=0.205u L=0.04u
M_U1065/MI15-M_u3 U1065/net28 U1065/net20 U1065/net64 VSS nch W=0.155u L=0.04u
M_U1065/MI8-M_u3 U1065/net24 U1065/net30 U1065/net32 VSS nch W=0.155u L=0.04u
M_U1065/MI17-M_u3 U1065/net28 U1065/net40 U1065/net24 VSS nch W=0.155u L=0.04u
M_U1065/MI11-M_u3 U1065/net40 n1194 U1065/net108 VSS nch W=0.155u L=0.04u
M_U1065/MI9-M_u3 U1065/net40 U1065/net106 U1065/net104 VSS nch W=0.155u L=0.04u
M_U1065/MI21 U1065/net24 n1064 U1065/net050 VSS nch W=0.155u L=0.04u
M_U1065/MI22 U1065/net050 U1065/net32 VSS VSS nch W=0.155u L=0.04u
M_U1065/MI19-M_u2 U1065/net20 U1065/net40 VSS VSS nch W=0.155u L=0.04u
M_U1065/MI13-M_u2 U1065/net106 n1194 VSS VSS nch W=0.155u L=0.04u
M_U1065/MI14-M_u2 U1065/net104 n1091 VSS VSS nch W=0.155u L=0.04u
M_U1065/M_u8-M_u2 U1065/net30 n1064 VSS VSS nch W=0.155u L=0.04u
M_U1065/MI12-M_u2 U1065/net108 U1065/net104 VSS VSS nch W=0.155u L=0.04u
M_U1065/MU20-M_u2 n1178 U1065/net28 VSS VSS nch W=0.155u L=0.04u
M_U1065/MI1-M_u2 U1065/net32 n1193 VSS VSS nch W=0.155u L=0.04u
M_U1065/MI16-M_u2 U1065/net64 U1065/net24 VSS VSS nch W=0.2u L=0.04u
M_U1065/MI15-M_u2 U1065/net28 U1065/net40 U1065/net64 VDD pch W=0.205u L=0.04u
M_U1065/MI8-M_u2 U1065/net24 n1064 U1065/net32 VDD pch W=0.205u L=0.04u
M_U1065/MI17-M_u2 U1065/net28 U1065/net20 U1065/net24 VDD pch W=0.205u L=0.04u
M_U1065/MI11-M_u2 U1065/net40 U1065/net106 U1065/net108 VDD pch W=0.205u L=0.04u
M_U1065/MI9-M_u2 U1065/net40 n1194 U1065/net104 VDD pch W=0.205u L=0.04u
M_U1065/MI19-M_u3 U1065/net20 U1065/net40 VDD VDD pch W=0.205u L=0.04u
M_U1065/MI13-M_u3 U1065/net106 n1194 VDD VDD pch W=0.205u L=0.04u
M_U1065/MI14-M_u3 U1065/net104 n1091 VDD VDD pch W=0.205u L=0.04u
M_U1065/M_u8-M_u3 U1065/net30 n1064 VDD VDD pch W=0.205u L=0.04u
M_U1065/MI12-M_u3 U1065/net108 U1065/net104 VDD VDD pch W=0.205u L=0.04u
M_U1065/MU20-M_u3 n1178 U1065/net28 VDD VDD pch W=0.205u L=0.04u
M_U1065/MI1-M_u3 U1065/net32 n1193 VDD VDD pch W=0.205u L=0.04u
M_U1065/MI16-M_u3 U1065/net64 U1065/net24 VDD VDD pch W=0.28u L=0.04u
M_U1065/MI20 U1065/net24 U1065/net30 U1065/net045 VDD pch W=0.205u L=0.04u
M_U1065/M_u2 U1065/net045 U1065/net32 VDD VDD pch W=0.205u L=0.04u
M_U1066/MI15-M_u3 U1066/net28 U1066/net20 U1066/net64 VSS nch W=0.155u L=0.04u
M_U1066/MI8-M_u3 U1066/net24 U1066/net30 U1066/net32 VSS nch W=0.155u L=0.04u
M_U1066/MI17-M_u3 U1066/net28 U1066/net40 U1066/net24 VSS nch W=0.155u L=0.04u
M_U1066/MI11-M_u3 U1066/net40 n1063 U1066/net108 VSS nch W=0.155u L=0.04u
M_U1066/MI9-M_u3 U1066/net40 U1066/net106 U1066/net104 VSS nch W=0.155u L=0.04u
M_U1066/MI21 U1066/net24 n1057 U1066/net050 VSS nch W=0.155u L=0.04u
M_U1066/MI22 U1066/net050 U1066/net32 VSS VSS nch W=0.155u L=0.04u
M_U1066/MI19-M_u2 U1066/net20 U1066/net40 VSS VSS nch W=0.155u L=0.04u
M_U1066/MI13-M_u2 U1066/net106 n1063 VSS VSS nch W=0.155u L=0.04u
M_U1066/MI14-M_u2 U1066/net104 n1069 VSS VSS nch W=0.155u L=0.04u
M_U1066/M_u8-M_u2 U1066/net30 n1057 VSS VSS nch W=0.155u L=0.04u
M_U1066/MI12-M_u2 U1066/net108 U1066/net104 VSS VSS nch W=0.155u L=0.04u
M_U1066/MU20-M_u2 n1194 U1066/net28 VSS VSS nch W=0.155u L=0.04u
M_U1066/MI1-M_u2 U1066/net32 n1054 VSS VSS nch W=0.155u L=0.04u
M_U1066/MI16-M_u2 U1066/net64 U1066/net24 VSS VSS nch W=0.2u L=0.04u
M_U1066/MI15-M_u2 U1066/net28 U1066/net40 U1066/net64 VDD pch W=0.205u L=0.04u
M_U1066/MI8-M_u2 U1066/net24 n1057 U1066/net32 VDD pch W=0.205u L=0.04u
M_U1066/MI17-M_u2 U1066/net28 U1066/net20 U1066/net24 VDD pch W=0.205u L=0.04u
M_U1066/MI11-M_u2 U1066/net40 U1066/net106 U1066/net108 VDD pch W=0.205u L=0.04u
M_U1066/MI9-M_u2 U1066/net40 n1063 U1066/net104 VDD pch W=0.205u L=0.04u
M_U1066/MI19-M_u3 U1066/net20 U1066/net40 VDD VDD pch W=0.205u L=0.04u
M_U1066/MI13-M_u3 U1066/net106 n1063 VDD VDD pch W=0.205u L=0.04u
M_U1066/MI14-M_u3 U1066/net104 n1069 VDD VDD pch W=0.205u L=0.04u
M_U1066/M_u8-M_u3 U1066/net30 n1057 VDD VDD pch W=0.205u L=0.04u
M_U1066/MI12-M_u3 U1066/net108 U1066/net104 VDD VDD pch W=0.205u L=0.04u
M_U1066/MU20-M_u3 n1194 U1066/net28 VDD VDD pch W=0.205u L=0.04u
M_U1066/MI1-M_u3 U1066/net32 n1054 VDD VDD pch W=0.205u L=0.04u
M_U1066/MI16-M_u3 U1066/net64 U1066/net24 VDD VDD pch W=0.28u L=0.04u
M_U1066/MI20 U1066/net24 U1066/net30 U1066/net045 VDD pch W=0.205u L=0.04u
M_U1066/M_u2 U1066/net045 U1066/net32 VDD VDD pch W=0.205u L=0.04u
M_U1067/M_u2 n1063 N175 U1067/net15 VSS nch W=0.155u L=0.04u
M_U1067/M_u3 n1063 n1185 U1067/net15 VSS nch W=0.155u L=0.04u
M_U1067/M_u4 U1067/net15 n1050 VSS VSS nch W=0.155u L=0.04u
M_U1067/M_u9 n1063 n1050 VDD VDD pch W=0.205u L=0.04u
M_U1067/MI16-MI12 n1063 N175 U1067/XI16-net11 VDD pch W=0.205u L=0.04u
M_U1067/MI16-MI13 U1067/XI16-net11 n1185 VDD VDD pch W=0.205u L=0.04u
M_U1068/MI2 n1069 N177 U1068/net27 VSS nch W=0.155u L=0.04u
M_U1068/MI10 U1068/net27 n1050 VSS VSS nch W=0.155u L=0.04u
M_U1068/MI11 n1069 n1185 VSS VSS nch W=0.155u L=0.04u
M_U1068/MI8 n1069 n1050 U1068/net13 VDD pch W=0.205u L=0.04u
M_U1068/M_u2 U1068/net13 n1185 VDD VDD pch W=0.205u L=0.04u
M_U1068/MI9 n1069 N177 U1068/net13 VDD pch W=0.205u L=0.04u
M_U1069/M_u2 n1054 n1052 VSS VSS nch W=0.135u L=0.04u
M_U1069/M_u1 n1054 n1052 VDD VDD pch W=0.205u L=0.04u
M_U1070/M_u2 n1052 N173 U1070/net15 VSS nch W=0.155u L=0.04u
M_U1070/M_u3 n1052 n1185 U1070/net15 VSS nch W=0.155u L=0.04u
M_U1070/M_u4 U1070/net15 n1050 VSS VSS nch W=0.155u L=0.04u
M_U1070/M_u9 n1052 n1050 VDD VDD pch W=0.205u L=0.04u
M_U1070/MI16-MI12 n1052 N173 U1070/XI16-net11 VDD pch W=0.205u L=0.04u
M_U1070/MI16-MI13 U1070/XI16-net11 n1185 VDD VDD pch W=0.205u L=0.04u
M_U1071/M_u2 n1057 N174 U1071/net15 VSS nch W=0.155u L=0.04u
M_U1071/M_u3 n1057 n1185 U1071/net15 VSS nch W=0.155u L=0.04u
M_U1071/M_u4 U1071/net15 n1050 VSS VSS nch W=0.155u L=0.04u
M_U1071/M_u9 n1057 n1050 VDD VDD pch W=0.205u L=0.04u
M_U1071/MI16-MI12 n1057 N174 U1071/XI16-net11 VDD pch W=0.205u L=0.04u
M_U1071/MI16-MI13 U1071/XI16-net11 n1185 VDD VDD pch W=0.205u L=0.04u
M_U1072/MI15-M_u2 U1072/net19 N18 VSS VSS nch W=0.155u L=0.04u
M_U1072/MI21 n1091 N18 U1072/net40 VSS nch W=0.155u L=0.04u
M_U1072/MI12 n1091 U1072/net19 U1072/net36 VSS nch W=0.155u L=0.04u
M_U1072/MI20 U1072/net40 N178 VSS VSS nch W=0.31u L=0.04u
M_U1072/MI19 U1072/net36 N135 VSS VSS nch W=0.155u L=0.04u
M_U1072/MI15-M_u3 U1072/net19 N18 VDD VDD pch W=0.205u L=0.04u
M_U1072/MI25 n1091 U1072/net19 U1072/net26 VDD pch W=0.325u L=0.04u
M_U1072/MI24 U1072/net26 N178 VDD VDD pch W=0.41u L=0.04u
M_U1072/MI5 n1091 N18 U1072/net30 VDD pch W=0.325u L=0.04u
M_U1072/MI111 U1072/net30 N135 VDD VDD pch W=0.205u L=0.04u
M_U1073/MI15 U1073/net29 U1073/net21 U1073/net041 VSS nch W=0.155u L=0.04u
M_U1073/MU63 U1073/net035 U1073/net19 VSS VSS nch W=0.155u L=0.04u
M_U1073/MI14 U1073/net041 U1073/net13 VSS VSS nch W=0.155u L=0.04u
M_U1073/MI42 U1073/net25 n1087 U1073/net035 VSS nch W=0.155u L=0.04u
M_U1073/M_u6-M_u3 U1073/net19 U1073/net17 U1073/net25 VSS nch W=0.155u L=0.04u
M_U1073/MU18-M_u3 U1073/net13 U1073/net25 U1073/net29 VSS nch W=0.155u L=0.04u
M_U1073/MI1-M_u2 n1193 U1073/net29 VSS VSS nch W=0.155u L=0.04u
M_U1073/MI3-M_u2 U1073/net13 n1195 VSS VSS nch W=0.155u L=0.04u
M_U1073/MI7-M_u2 U1073/net17 n1087 VSS VSS nch W=0.155u L=0.04u
M_U1073/MI2-M_u2 U1073/net19 n1079 VSS VSS nch W=0.155u L=0.04u
M_U1073/MI6-M_u2 U1073/net21 U1073/net25 VSS VSS nch W=0.155u L=0.04u
M_U1073/MU62 U1073/net028 U1073/net19 VDD VDD pch W=0.205u L=0.04u
M_U1073/MI8 U1073/net25 U1073/net17 U1073/net028 VDD pch W=0.205u L=0.04u
M_U1073/MI12 U1073/net29 U1073/net25 U1073/net029 VDD pch W=0.205u L=0.04u
M_U1073/MI13 U1073/net029 U1073/net13 VDD VDD pch W=0.205u L=0.04u
M_U1073/M_u6-M_u2 U1073/net19 n1087 U1073/net25 VDD pch W=0.205u L=0.04u
M_U1073/MU18-M_u2 U1073/net13 U1073/net21 U1073/net29 VDD pch W=0.205u L=0.04u
M_U1073/MI1-M_u3 n1193 U1073/net29 VDD VDD pch W=0.205u L=0.04u
M_U1073/MI3-M_u3 U1073/net13 n1195 VDD VDD pch W=0.205u L=0.04u
M_U1073/MI7-M_u3 U1073/net17 n1087 VDD VDD pch W=0.205u L=0.04u
M_U1073/MI2-M_u3 U1073/net19 n1079 VDD VDD pch W=0.205u L=0.04u
M_U1073/MI6-M_u3 U1073/net21 U1073/net25 VDD VDD pch W=0.205u L=0.04u
M_U1074/MI15-M_u2 U1074/net19 N18 VSS VSS nch W=0.155u L=0.04u
M_U1074/MI21 n1195 N18 U1074/net40 VSS nch W=0.155u L=0.04u
M_U1074/MI12 n1195 U1074/net19 U1074/net36 VSS nch W=0.155u L=0.04u
M_U1074/MI20 U1074/net40 n1197 VSS VSS nch W=0.31u L=0.04u
M_U1074/MI19 U1074/net36 n1196 VSS VSS nch W=0.155u L=0.04u
M_U1074/MI15-M_u3 U1074/net19 N18 VDD VDD pch W=0.205u L=0.04u
M_U1074/MI25 n1195 U1074/net19 U1074/net26 VDD pch W=0.325u L=0.04u
M_U1074/MI24 U1074/net26 n1197 VDD VDD pch W=0.41u L=0.04u
M_U1074/MI5 n1195 N18 U1074/net30 VDD pch W=0.325u L=0.04u
M_U1074/MI111 U1074/net30 n1196 VDD VDD pch W=0.205u L=0.04u
M_U1075/M_u6-M_u3 U1075/net4 U1075/net10 U1075/net14 VSS nch W=0.155u L=0.04u
M_U1075/MI3-M_u3 U1075/net6 N181 U1075/net14 VSS nch W=0.155u L=0.04u
M_U1075/MI1-M_u2 U1075/net4 n1082 VSS VSS nch W=0.155u L=0.04u
M_U1075/M_u5-M_u2 U1075/net6 U1075/net4 VSS VSS nch W=0.155u L=0.04u
M_U1075/M_u4-M_u2 n1197 U1075/net14 VSS VSS nch W=0.155u L=0.04u
M_U1075/MI2-M_u2 U1075/net10 N181 VSS VSS nch W=0.155u L=0.04u
M_U1075/M_u6-M_u2 U1075/net4 N181 U1075/net14 VDD pch W=0.205u L=0.04u
M_U1075/MI3-M_u2 U1075/net6 U1075/net10 U1075/net14 VDD pch W=0.205u L=0.04u
M_U1075/MI1-M_u3 U1075/net4 n1082 VDD VDD pch W=0.205u L=0.04u
M_U1075/M_u5-M_u3 U1075/net6 U1075/net4 VDD VDD pch W=0.205u L=0.04u
M_U1075/M_u4-M_u3 n1197 U1075/net14 VDD VDD pch W=0.205u L=0.04u
M_U1075/MI2-M_u3 U1075/net10 N181 VDD VDD pch W=0.205u L=0.04u
M_U1076/M_u6-M_u3 U1076/net4 U1076/net10 U1076/net14 VSS nch W=0.155u L=0.04u
M_U1076/MI3-M_u3 U1076/net6 n1082 U1076/net14 VSS nch W=0.155u L=0.04u
M_U1076/MI1-M_u2 U1076/net4 N141 VSS VSS nch W=0.155u L=0.04u
M_U1076/M_u5-M_u2 U1076/net6 U1076/net4 VSS VSS nch W=0.155u L=0.04u
M_U1076/M_u4-M_u2 n1196 U1076/net14 VSS VSS nch W=0.155u L=0.04u
M_U1076/MI2-M_u2 U1076/net10 n1082 VSS VSS nch W=0.155u L=0.04u
M_U1076/M_u6-M_u2 U1076/net4 n1082 U1076/net14 VDD pch W=0.205u L=0.04u
M_U1076/MI3-M_u2 U1076/net6 U1076/net10 U1076/net14 VDD pch W=0.205u L=0.04u
M_U1076/MI1-M_u3 U1076/net4 N141 VDD VDD pch W=0.205u L=0.04u
M_U1076/M_u5-M_u3 U1076/net6 U1076/net4 VDD VDD pch W=0.205u L=0.04u
M_U1076/M_u4-M_u3 n1196 U1076/net14 VDD VDD pch W=0.205u L=0.04u
M_U1076/MI2-M_u3 U1076/net10 n1082 VDD VDD pch W=0.205u L=0.04u
M_U1077/MU29-M_u2 n1082 U1077/net28 VSS VSS nch W=0.155u L=0.04u
M_U1077/MI111 U1077/net47 N171 VSS VSS nch W=0.155u L=0.04u
M_U1077/MI5 U1077/net28 U1077/net6 U1077/net47 VSS nch W=0.155u L=0.04u
M_U1077/MI14 U1077/net44 N147 VSS VSS nch W=0.155u L=0.04u
M_U1077/MI13 U1077/net28 n1184 U1077/net44 VSS nch W=0.155u L=0.04u
M_U1077/MU24 U1077/net6 n1184 VSS VSS nch W=0.155u L=0.04u
M_U1077/MU29-M_u3 n1082 U1077/net28 VDD VDD pch W=0.205u L=0.04u
M_U1077/MI2 VDD N171 U1077/net47 VDD pch W=0.205u L=0.04u
M_U1077/MI4 U1077/net47 n1184 U1077/net28 VDD pch W=0.205u L=0.04u
M_U1077/MI12 U1077/net44 U1077/net6 U1077/net28 VDD pch W=0.205u L=0.04u
M_U1077/MI10 VDD N147 U1077/net44 VDD pch W=0.205u L=0.04u
M_U1077/MU25 VDD n1184 U1077/net6 VDD pch W=0.205u L=0.04u
M_U1078/MI15-M_u2 U1078/net19 N18 VSS VSS nch W=0.155u L=0.04u
M_U1078/MI21 n1087 N18 U1078/net40 VSS nch W=0.155u L=0.04u
M_U1078/MI12 n1087 U1078/net19 U1078/net36 VSS nch W=0.155u L=0.04u
M_U1078/MI20 U1078/net40 N180 VSS VSS nch W=0.31u L=0.04u
M_U1078/MI19 U1078/net36 N138 VSS VSS nch W=0.155u L=0.04u
M_U1078/MI15-M_u3 U1078/net19 N18 VDD VDD pch W=0.205u L=0.04u
M_U1078/MI25 n1087 U1078/net19 U1078/net26 VDD pch W=0.325u L=0.04u
M_U1078/MI24 U1078/net26 N180 VDD VDD pch W=0.41u L=0.04u
M_U1078/MI5 n1087 N18 U1078/net30 VDD pch W=0.325u L=0.04u
M_U1078/MI111 U1078/net30 N138 VDD VDD pch W=0.205u L=0.04u
M_U1079/MI15-M_u2 U1079/net19 N18 VSS VSS nch W=0.155u L=0.04u
M_U1079/MI21 n1079 N18 U1079/net40 VSS nch W=0.155u L=0.04u
M_U1079/MI12 n1079 U1079/net19 U1079/net36 VSS nch W=0.155u L=0.04u
M_U1079/MI20 U1079/net40 N179 VSS VSS nch W=0.31u L=0.04u
M_U1079/MI19 U1079/net36 N144 VSS VSS nch W=0.155u L=0.04u
M_U1079/MI15-M_u3 U1079/net19 N18 VDD VDD pch W=0.205u L=0.04u
M_U1079/MI25 n1079 U1079/net19 U1079/net26 VDD pch W=0.325u L=0.04u
M_U1079/MI24 U1079/net26 N179 VDD VDD pch W=0.41u L=0.04u
M_U1079/MI5 n1079 N18 U1079/net30 VDD pch W=0.325u L=0.04u
M_U1079/MI111 U1079/net30 N144 VDD VDD pch W=0.205u L=0.04u
M_U1080/M_u2 n1064 N176 U1080/net15 VSS nch W=0.155u L=0.04u
M_U1080/M_u3 n1064 n1185 U1080/net15 VSS nch W=0.155u L=0.04u
M_U1080/M_u4 U1080/net15 n1050 VSS VSS nch W=0.155u L=0.04u
M_U1080/M_u9 n1064 n1050 VDD VDD pch W=0.205u L=0.04u
M_U1080/MI16-MI12 n1064 N176 U1080/XI16-net11 VDD pch W=0.205u L=0.04u
M_U1080/MI16-MI13 U1080/XI16-net11 n1185 VDD VDD pch W=0.205u L=0.04u
M_U1081/MI15-M_u3 U1081/net28 U1081/net20 U1081/net64 VSS nch W=0.155u L=0.04u
M_U1081/MI8-M_u3 U1081/net24 U1081/net30 U1081/net32 VSS nch W=0.155u L=0.04u
M_U1081/MI17-M_u3 U1081/net28 U1081/net40 U1081/net24 VSS nch W=0.155u L=0.04u
M_U1081/MI11-M_u3 U1081/net40 n1199 U1081/net108 VSS nch W=0.155u L=0.04u
M_U1081/MI9-M_u3 U1081/net40 U1081/net106 U1081/net104 VSS nch W=0.155u L=0.04u
M_U1081/MI21 U1081/net24 n1126 U1081/net050 VSS nch W=0.155u L=0.04u
M_U1081/MI22 U1081/net050 U1081/net32 VSS VSS nch W=0.155u L=0.04u
M_U1081/MI19-M_u2 U1081/net20 U1081/net40 VSS VSS nch W=0.155u L=0.04u
M_U1081/MI13-M_u2 U1081/net106 n1199 VSS VSS nch W=0.155u L=0.04u
M_U1081/MI14-M_u2 U1081/net104 n1198 VSS VSS nch W=0.155u L=0.04u
M_U1081/M_u8-M_u2 U1081/net30 n1126 VSS VSS nch W=0.155u L=0.04u
M_U1081/MI12-M_u2 U1081/net108 U1081/net104 VSS VSS nch W=0.155u L=0.04u
M_U1081/MU20-M_u2 n1177 U1081/net28 VSS VSS nch W=0.155u L=0.04u
M_U1081/MI1-M_u2 U1081/net32 n1153 VSS VSS nch W=0.155u L=0.04u
M_U1081/MI16-M_u2 U1081/net64 U1081/net24 VSS VSS nch W=0.2u L=0.04u
M_U1081/MI15-M_u2 U1081/net28 U1081/net40 U1081/net64 VDD pch W=0.205u L=0.04u
M_U1081/MI8-M_u2 U1081/net24 n1126 U1081/net32 VDD pch W=0.205u L=0.04u
M_U1081/MI17-M_u2 U1081/net28 U1081/net20 U1081/net24 VDD pch W=0.205u L=0.04u
M_U1081/MI11-M_u2 U1081/net40 U1081/net106 U1081/net108 VDD pch W=0.205u L=0.04u
M_U1081/MI9-M_u2 U1081/net40 n1199 U1081/net104 VDD pch W=0.205u L=0.04u
M_U1081/MI19-M_u3 U1081/net20 U1081/net40 VDD VDD pch W=0.205u L=0.04u
M_U1081/MI13-M_u3 U1081/net106 n1199 VDD VDD pch W=0.205u L=0.04u
M_U1081/MI14-M_u3 U1081/net104 n1198 VDD VDD pch W=0.205u L=0.04u
M_U1081/M_u8-M_u3 U1081/net30 n1126 VDD VDD pch W=0.205u L=0.04u
M_U1081/MI12-M_u3 U1081/net108 U1081/net104 VDD VDD pch W=0.205u L=0.04u
M_U1081/MU20-M_u3 n1177 U1081/net28 VDD VDD pch W=0.205u L=0.04u
M_U1081/MI1-M_u3 U1081/net32 n1153 VDD VDD pch W=0.205u L=0.04u
M_U1081/MI16-M_u3 U1081/net64 U1081/net24 VDD VDD pch W=0.28u L=0.04u
M_U1081/MI20 U1081/net24 U1081/net30 U1081/net045 VDD pch W=0.205u L=0.04u
M_U1081/M_u2 U1081/net045 U1081/net32 VDD VDD pch W=0.205u L=0.04u
M_U1082/MI8-M_u3 U1082/net11 n1122 U1082/net17 VSS nch W=0.155u L=0.04u
M_U1082/MU11-M_u3 U1082/net5 U1082/net17 U1082/net21 VSS nch W=0.155u L=0.04u
M_U1082/MI5-M_u2 U1082/net5 n1200 VSS VSS nch W=0.155u L=0.04u
M_U1082/MU22-M_u2 n1199 U1082/net21 VSS VSS nch W=0.155u L=0.04u
M_U1082/M_u8-M_u2 U1082/net16 n1122 VSS VSS nch W=0.155u L=0.04u
M_U1082/MI4-M_u2 U1082/net11 n1155 VSS VSS nch W=0.155u L=0.04u
M_U1082/MI7-M_u2 U1082/net13 U1082/net17 VSS VSS nch W=0.155u L=0.04u
M_U1082/MI2-MU3 U1082/net17 U1082/net16 U1082/XI2-net16 VSS nch W=0.155u L=0.04u
M_U1082/MI2-MU4 U1082/XI2-net16 U1082/net11 VSS VSS nch W=0.155u L=0.04u
M_U1082/MU21-MU3 U1082/net21 U1082/net13 U1082/XU21-net16 VSS nch W=0.155u L=0.04u
M_U1082/MU21-MU4 U1082/XU21-net16 U1082/net5 VSS VSS nch W=0.155u L=0.04u
M_U1082/MI8-M_u2 U1082/net11 U1082/net16 U1082/net17 VDD pch W=0.205u L=0.04u
M_U1082/MU11-M_u2 U1082/net5 U1082/net13 U1082/net21 VDD pch W=0.205u L=0.04u
M_U1082/MI5-M_u3 U1082/net5 n1200 VDD VDD pch W=0.205u L=0.04u
M_U1082/MU22-M_u3 n1199 U1082/net21 VDD VDD pch W=0.205u L=0.04u
M_U1082/M_u8-M_u3 U1082/net16 n1122 VDD VDD pch W=0.205u L=0.04u
M_U1082/MI4-M_u3 U1082/net11 n1155 VDD VDD pch W=0.205u L=0.04u
M_U1082/MI7-M_u3 U1082/net13 U1082/net17 VDD VDD pch W=0.205u L=0.04u
M_U1082/MI2-MU2 U1082/net17 n1122 U1082/XI2-net6 VDD pch W=0.205u L=0.04u
M_U1082/MI2-MU1 U1082/XI2-net6 U1082/net11 VDD VDD pch W=0.205u L=0.04u
M_U1082/MU21-MU2 U1082/net21 U1082/net17 U1082/XU21-net6 VDD pch W=0.205u L=0.04u
M_U1082/MU21-MU1 U1082/XU21-net6 U1082/net5 VDD VDD pch W=0.205u L=0.04u
M_U1083/M_u2 n1200 n1201 U1083/net15 VSS nch W=0.155u L=0.04u
M_U1083/M_u3 n1200 n1184 U1083/net15 VSS nch W=0.155u L=0.04u
M_U1083/M_u4 U1083/net15 n1202 VSS VSS nch W=0.155u L=0.04u
M_U1083/M_u9 n1200 n1202 VDD VDD pch W=0.205u L=0.04u
M_U1083/MI16-MI12 n1200 n1201 U1083/XI16-net11 VDD pch W=0.205u L=0.04u
M_U1083/MI16-MI13 U1083/XI16-net11 n1184 VDD VDD pch W=0.205u L=0.04u
M_U1084/MI15-M_u2 U1084/net19 N44 VSS VSS nch W=0.155u L=0.04u
M_U1084/MI21 n1202 N44 U1084/net40 VSS nch W=0.155u L=0.04u
M_U1084/MI12 n1202 U1084/net19 U1084/net36 VSS nch W=0.155u L=0.04u
M_U1084/MI20 U1084/net40 n1203 VSS VSS nch W=0.31u L=0.04u
M_U1084/MI19 U1084/net36 n1133 VSS VSS nch W=0.155u L=0.04u
M_U1084/MI15-M_u3 U1084/net19 N44 VDD VDD pch W=0.205u L=0.04u
M_U1084/MI25 n1202 U1084/net19 U1084/net26 VDD pch W=0.325u L=0.04u
M_U1084/MI24 U1084/net26 n1203 VDD VDD pch W=0.41u L=0.04u
M_U1084/MI5 n1202 N44 U1084/net30 VDD pch W=0.325u L=0.04u
M_U1084/MI111 U1084/net30 n1133 VDD VDD pch W=0.205u L=0.04u
M_U1085/M_u3-M_u2 n1203 U1085/net6 VSS VSS nch W=0.155u L=0.04u
M_U1085/M_u2-M_u4 U1085/X_u2-net6 n1184 VSS VSS nch W=0.155u L=0.04u
M_U1085/M_u2-M_u3 U1085/net6 n1204 U1085/X_u2-net6 VSS nch W=0.155u L=0.04u
M_U1085/M_u3-M_u3 n1203 U1085/net6 VDD VDD pch W=0.205u L=0.04u
M_U1085/M_u2-M_u2 U1085/net6 n1184 VDD VDD pch W=0.205u L=0.04u
M_U1085/M_u2-M_u1 U1085/net6 n1204 VDD VDD pch W=0.205u L=0.04u
M_U1086/MI1-M_u4 n1133 n1204 VSS VSS nch W=0.155u L=0.04u
M_U1086/MI1-M_u3 n1133 N18 VSS VSS nch W=0.155u L=0.04u
M_U1086/MI1-M_u1 U1086/XI1-net8 N18 VDD VDD pch W=0.205u L=0.04u
M_U1086/MI1-M_u2 n1133 n1204 U1086/XI1-net8 VDD pch W=0.205u L=0.04u
M_U1087/M_u6-M_u3 U1087/net4 U1087/net10 U1087/net14 VSS nch W=0.155u L=0.04u
M_U1087/MI3-M_u3 U1087/net6 N208 U1087/net14 VSS nch W=0.155u L=0.04u
M_U1087/MI1-M_u2 U1087/net4 n1204 VSS VSS nch W=0.155u L=0.04u
M_U1087/M_u5-M_u2 U1087/net6 U1087/net4 VSS VSS nch W=0.155u L=0.04u
M_U1087/M_u4-M_u2 n1201 U1087/net14 VSS VSS nch W=0.155u L=0.04u
M_U1087/MI2-M_u2 U1087/net10 N208 VSS VSS nch W=0.155u L=0.04u
M_U1087/M_u6-M_u2 U1087/net4 N208 U1087/net14 VDD pch W=0.205u L=0.04u
M_U1087/MI3-M_u2 U1087/net6 U1087/net10 U1087/net14 VDD pch W=0.205u L=0.04u
M_U1087/MI1-M_u3 U1087/net4 n1204 VDD VDD pch W=0.205u L=0.04u
M_U1087/M_u5-M_u3 U1087/net6 U1087/net4 VDD VDD pch W=0.205u L=0.04u
M_U1087/M_u4-M_u3 n1201 U1087/net14 VDD VDD pch W=0.205u L=0.04u
M_U1087/MI2-M_u3 U1087/net10 N208 VDD VDD pch W=0.205u L=0.04u
M_U1088/MI15-M_u2 U1088/net19 N18 VSS VSS nch W=0.155u L=0.04u
M_U1088/MI21 n1204 N18 U1088/net40 VSS nch W=0.155u L=0.04u
M_U1088/MI12 n1204 U1088/net19 U1088/net36 VSS nch W=0.155u L=0.04u
M_U1088/MI20 U1088/net40 N198 VSS VSS nch W=0.31u L=0.04u
M_U1088/MI19 U1088/net36 N41 VSS VSS nch W=0.155u L=0.04u
M_U1088/MI15-M_u3 U1088/net19 N18 VDD VDD pch W=0.205u L=0.04u
M_U1088/MI25 n1204 U1088/net19 U1088/net26 VDD pch W=0.325u L=0.04u
M_U1088/MI24 U1088/net26 N198 VDD VDD pch W=0.41u L=0.04u
M_U1088/MI5 n1204 N18 U1088/net30 VDD pch W=0.325u L=0.04u
M_U1088/MI111 U1088/net30 N41 VDD VDD pch W=0.205u L=0.04u
M_U1089/MI15-M_u2 U1089/net19 N18 VSS VSS nch W=0.155u L=0.04u
M_U1089/MI21 n1122 N18 U1089/net40 VSS nch W=0.155u L=0.04u
M_U1089/MI12 n1122 U1089/net19 U1089/net36 VSS nch W=0.155u L=0.04u
M_U1089/MI20 U1089/net40 N200 VSS VSS nch W=0.31u L=0.04u
M_U1089/MI19 U1089/net36 N100 VSS VSS nch W=0.155u L=0.04u
M_U1089/MI15-M_u3 U1089/net19 N18 VDD VDD pch W=0.205u L=0.04u
M_U1089/MI25 n1122 U1089/net19 U1089/net26 VDD pch W=0.325u L=0.04u
M_U1089/MI24 U1089/net26 N200 VDD VDD pch W=0.41u L=0.04u
M_U1089/MI5 n1122 N18 U1089/net30 VDD pch W=0.325u L=0.04u
M_U1089/MI111 U1089/net30 N100 VDD VDD pch W=0.205u L=0.04u
M_U1090/MI15-M_u2 U1090/net19 n1184 VSS VSS nch W=0.155u L=0.04u
M_U1090/MI21 n1155 n1184 U1090/net40 VSS nch W=0.155u L=0.04u
M_U1090/MI12 n1155 U1090/net19 U1090/net36 VSS nch W=0.155u L=0.04u
M_U1090/MI20 U1090/net40 N127 VSS VSS nch W=0.31u L=0.04u
M_U1090/MI19 U1090/net36 N202 VSS VSS nch W=0.155u L=0.04u
M_U1090/MI15-M_u3 U1090/net19 n1184 VDD VDD pch W=0.205u L=0.04u
M_U1090/MI25 n1155 U1090/net19 U1090/net26 VDD pch W=0.325u L=0.04u
M_U1090/MI24 U1090/net26 N127 VDD VDD pch W=0.41u L=0.04u
M_U1090/MI5 n1155 n1184 U1090/net30 VDD pch W=0.325u L=0.04u
M_U1090/MI111 U1090/net30 N202 VDD VDD pch W=0.205u L=0.04u
M_U1091/MI15-M_u3 U1091/net28 U1091/net20 U1091/net64 VSS nch W=0.155u L=0.04u
M_U1091/MI8-M_u3 U1091/net24 U1091/net30 U1091/net32 VSS nch W=0.155u L=0.04u
M_U1091/MI17-M_u3 U1091/net28 U1091/net40 U1091/net24 VSS nch W=0.155u L=0.04u
M_U1091/MI11-M_u3 U1091/net40 n1142 U1091/net108 VSS nch W=0.155u L=0.04u
M_U1091/MI9-M_u3 U1091/net40 U1091/net106 U1091/net104 VSS nch W=0.155u L=0.04u
M_U1091/MI21 U1091/net24 n1146 U1091/net050 VSS nch W=0.155u L=0.04u
M_U1091/MI22 U1091/net050 U1091/net32 VSS VSS nch W=0.155u L=0.04u
M_U1091/MI19-M_u2 U1091/net20 U1091/net40 VSS VSS nch W=0.155u L=0.04u
M_U1091/MI13-M_u2 U1091/net106 n1142 VSS VSS nch W=0.155u L=0.04u
M_U1091/MI14-M_u2 U1091/net104 n1129 VSS VSS nch W=0.155u L=0.04u
M_U1091/M_u8-M_u2 U1091/net30 n1146 VSS VSS nch W=0.155u L=0.04u
M_U1091/MI12-M_u2 U1091/net108 U1091/net104 VSS VSS nch W=0.155u L=0.04u
M_U1091/MU20-M_u2 n1198 U1091/net28 VSS VSS nch W=0.155u L=0.04u
M_U1091/MI1-M_u2 U1091/net32 n1138 VSS VSS nch W=0.155u L=0.04u
M_U1091/MI16-M_u2 U1091/net64 U1091/net24 VSS VSS nch W=0.2u L=0.04u
M_U1091/MI15-M_u2 U1091/net28 U1091/net40 U1091/net64 VDD pch W=0.205u L=0.04u
M_U1091/MI8-M_u2 U1091/net24 n1146 U1091/net32 VDD pch W=0.205u L=0.04u
M_U1091/MI17-M_u2 U1091/net28 U1091/net20 U1091/net24 VDD pch W=0.205u L=0.04u
M_U1091/MI11-M_u2 U1091/net40 U1091/net106 U1091/net108 VDD pch W=0.205u L=0.04u
M_U1091/MI9-M_u2 U1091/net40 n1142 U1091/net104 VDD pch W=0.205u L=0.04u
M_U1091/MI19-M_u3 U1091/net20 U1091/net40 VDD VDD pch W=0.205u L=0.04u
M_U1091/MI13-M_u3 U1091/net106 n1142 VDD VDD pch W=0.205u L=0.04u
M_U1091/MI14-M_u3 U1091/net104 n1129 VDD VDD pch W=0.205u L=0.04u
M_U1091/M_u8-M_u3 U1091/net30 n1146 VDD VDD pch W=0.205u L=0.04u
M_U1091/MI12-M_u3 U1091/net108 U1091/net104 VDD VDD pch W=0.205u L=0.04u
M_U1091/MU20-M_u3 n1198 U1091/net28 VDD VDD pch W=0.205u L=0.04u
M_U1091/MI1-M_u3 U1091/net32 n1138 VDD VDD pch W=0.205u L=0.04u
M_U1091/MI16-M_u3 U1091/net64 U1091/net24 VDD VDD pch W=0.28u L=0.04u
M_U1091/MI20 U1091/net24 U1091/net30 U1091/net045 VDD pch W=0.205u L=0.04u
M_U1091/M_u2 U1091/net045 U1091/net32 VDD VDD pch W=0.205u L=0.04u
M_U1092/MI15-M_u2 U1092/net19 N18 VSS VSS nch W=0.155u L=0.04u
M_U1092/MI21 n1142 N18 U1092/net40 VSS nch W=0.155u L=0.04u
M_U1092/MI12 n1142 U1092/net19 U1092/net36 VSS nch W=0.155u L=0.04u
M_U1092/MI20 U1092/net40 N207 VSS VSS nch W=0.31u L=0.04u
M_U1092/MI19 U1092/net36 N29 VSS VSS nch W=0.155u L=0.04u
M_U1092/MI15-M_u3 U1092/net19 N18 VDD VDD pch W=0.205u L=0.04u
M_U1092/MI25 n1142 U1092/net19 U1092/net26 VDD pch W=0.325u L=0.04u
M_U1092/MI24 U1092/net26 N207 VDD VDD pch W=0.41u L=0.04u
M_U1092/MI5 n1142 N18 U1092/net30 VDD pch W=0.325u L=0.04u
M_U1092/MI111 U1092/net30 N29 VDD VDD pch W=0.205u L=0.04u
M_U1093/MI15-M_u2 U1093/net19 N18 VSS VSS nch W=0.155u L=0.04u
M_U1093/MI21 n1129 N18 U1093/net40 VSS nch W=0.155u L=0.04u
M_U1093/MI12 n1129 U1093/net19 U1093/net36 VSS nch W=0.155u L=0.04u
M_U1093/MI20 U1093/net40 N204 VSS VSS nch W=0.31u L=0.04u
M_U1093/MI19 U1093/net36 N103 VSS VSS nch W=0.155u L=0.04u
M_U1093/MI15-M_u3 U1093/net19 N18 VDD VDD pch W=0.205u L=0.04u
M_U1093/MI25 n1129 U1093/net19 U1093/net26 VDD pch W=0.325u L=0.04u
M_U1093/MI24 U1093/net26 N204 VDD VDD pch W=0.41u L=0.04u
M_U1093/MI5 n1129 N18 U1093/net30 VDD pch W=0.325u L=0.04u
M_U1093/MI111 U1093/net30 N103 VDD VDD pch W=0.205u L=0.04u
M_U1094/MI15-M_u2 U1094/net19 n1184 VSS VSS nch W=0.155u L=0.04u
M_U1094/MI21 n1138 n1184 U1094/net40 VSS nch W=0.155u L=0.04u
M_U1094/MI12 n1138 U1094/net19 U1094/net36 VSS nch W=0.155u L=0.04u
M_U1094/MI20 U1094/net40 N23 VSS VSS nch W=0.31u L=0.04u
M_U1094/MI19 U1094/net36 N205 VSS VSS nch W=0.155u L=0.04u
M_U1094/MI15-M_u3 U1094/net19 n1184 VDD VDD pch W=0.205u L=0.04u
M_U1094/MI25 n1138 U1094/net19 U1094/net26 VDD pch W=0.325u L=0.04u
M_U1094/MI24 U1094/net26 N23 VDD VDD pch W=0.41u L=0.04u
M_U1094/MI5 n1138 n1184 U1094/net30 VDD pch W=0.325u L=0.04u
M_U1094/MI111 U1094/net30 N205 VDD VDD pch W=0.205u L=0.04u
M_U1095/MI15-M_u2 U1095/net19 N18 VSS VSS nch W=0.155u L=0.04u
M_U1095/MI21 n1146 N18 U1095/net40 VSS nch W=0.155u L=0.04u
M_U1095/MI12 n1146 U1095/net19 U1095/net36 VSS nch W=0.155u L=0.04u
M_U1095/MI20 U1095/net40 N206 VSS VSS nch W=0.31u L=0.04u
M_U1095/MI19 U1095/net36 N26 VSS VSS nch W=0.155u L=0.04u
M_U1095/MI15-M_u3 U1095/net19 N18 VDD VDD pch W=0.205u L=0.04u
M_U1095/MI25 n1146 U1095/net19 U1095/net26 VDD pch W=0.325u L=0.04u
M_U1095/MI24 U1095/net26 N206 VDD VDD pch W=0.41u L=0.04u
M_U1095/MI5 n1146 N18 U1095/net30 VDD pch W=0.325u L=0.04u
M_U1095/MI111 U1095/net30 N26 VDD VDD pch W=0.205u L=0.04u
M_U1096/M_u2 n1153 n1120 VSS VSS nch W=0.135u L=0.04u
M_U1096/M_u1 n1153 n1120 VDD VDD pch W=0.205u L=0.04u
M_U1097/MI15-M_u2 U1097/net19 N18 VSS VSS nch W=0.155u L=0.04u
M_U1097/MI21 n1120 N18 U1097/net40 VSS nch W=0.155u L=0.04u
M_U1097/MI12 n1120 U1097/net19 U1097/net36 VSS nch W=0.155u L=0.04u
M_U1097/MI20 U1097/net40 N201 VSS VSS nch W=0.31u L=0.04u
M_U1097/MI19 U1097/net36 N124 VSS VSS nch W=0.155u L=0.04u
M_U1097/MI15-M_u3 U1097/net19 N18 VDD VDD pch W=0.205u L=0.04u
M_U1097/MI25 n1120 U1097/net19 U1097/net26 VDD pch W=0.325u L=0.04u
M_U1097/MI24 U1097/net26 N201 VDD VDD pch W=0.41u L=0.04u
M_U1097/MI5 n1120 N18 U1097/net30 VDD pch W=0.325u L=0.04u
M_U1097/MI111 U1097/net30 N124 VDD VDD pch W=0.205u L=0.04u
M_U1098/MI15-M_u2 U1098/net19 N18 VSS VSS nch W=0.155u L=0.04u
M_U1098/MI21 n1126 N18 U1098/net40 VSS nch W=0.155u L=0.04u
M_U1098/MI12 n1126 U1098/net19 U1098/net36 VSS nch W=0.155u L=0.04u
M_U1098/MI20 U1098/net40 N203 VSS VSS nch W=0.31u L=0.04u
M_U1098/MI19 U1098/net36 N130 VSS VSS nch W=0.155u L=0.04u
M_U1098/MI15-M_u3 U1098/net19 N18 VDD VDD pch W=0.205u L=0.04u
M_U1098/MI25 n1126 U1098/net19 U1098/net26 VDD pch W=0.325u L=0.04u
M_U1098/MI24 U1098/net26 N203 VDD VDD pch W=0.41u L=0.04u
M_U1098/MI5 n1126 N18 U1098/net30 VDD pch W=0.325u L=0.04u
M_U1098/MI111 U1098/net30 N130 VDD VDD pch W=0.205u L=0.04u
M_U1099/MI19 U1099/p2 n1208 VSS VSS nch W=0.155u L=0.04u
M_U1099/MI17 U1099/p0 n1206 U1099/p1 VSS nch W=0.155u L=0.04u
M_U1099/MI18 U1099/p1 n1207 U1099/p2 VSS nch W=0.155u L=0.04u
M_U1099/MU53 N10575 n1205 U1099/p0 VSS nch W=0.155u L=0.04u
M_U1099/MI14 N10575 n1207 VDD VDD pch W=0.205u L=0.04u
M_U1099/MI15 N10575 n1206 VDD VDD pch W=0.205u L=0.04u
M_U1099/MI16 N10575 n1205 VDD VDD pch W=0.205u L=0.04u
M_U1099/MI9 N10575 n1208 VDD VDD pch W=0.205u L=0.04u
M_U1100/M_u6-M_u3 U1100/net4 U1100/net10 U1100/net14 VSS nch W=0.155u L=0.04u
M_U1100/MI3-M_u3 U1100/net6 n1209 U1100/net14 VSS nch W=0.155u L=0.04u
M_U1100/MI1-M_u2 U1100/net4 n1210 VSS VSS nch W=0.155u L=0.04u
M_U1100/M_u5-M_u2 U1100/net6 U1100/net4 VSS VSS nch W=0.155u L=0.04u
M_U1100/M_u4-M_u2 n1208 U1100/net14 VSS VSS nch W=0.155u L=0.04u
M_U1100/MI2-M_u2 U1100/net10 n1209 VSS VSS nch W=0.155u L=0.04u
M_U1100/M_u6-M_u2 U1100/net4 n1209 U1100/net14 VDD pch W=0.205u L=0.04u
M_U1100/MI3-M_u2 U1100/net6 U1100/net10 U1100/net14 VDD pch W=0.205u L=0.04u
M_U1100/MI1-M_u3 U1100/net4 n1210 VDD VDD pch W=0.205u L=0.04u
M_U1100/M_u5-M_u3 U1100/net6 U1100/net4 VDD VDD pch W=0.205u L=0.04u
M_U1100/M_u4-M_u3 n1208 U1100/net14 VDD VDD pch W=0.205u L=0.04u
M_U1100/MI2-M_u3 U1100/net10 n1209 VDD VDD pch W=0.205u L=0.04u
M_U1101/MI15-M_u3 U1101/net28 U1101/net20 U1101/net64 VSS nch W=0.155u L=0.04u
M_U1101/MI8-M_u3 U1101/net24 U1101/net30 U1101/net32 VSS nch W=0.155u L=0.04u
M_U1101/MI17-M_u3 U1101/net28 U1101/net40 U1101/net24 VSS nch W=0.155u L=0.04u
M_U1101/MI11-M_u3 U1101/net40 n1031 U1101/net108 VSS nch W=0.155u L=0.04u
M_U1101/MI9-M_u3 U1101/net40 U1101/net106 U1101/net104 VSS nch W=0.155u L=0.04u
M_U1101/MI21 U1101/net24 n1036 U1101/net050 VSS nch W=0.155u L=0.04u
M_U1101/MI22 U1101/net050 U1101/net32 VSS VSS nch W=0.155u L=0.04u
M_U1101/MI19-M_u2 U1101/net20 U1101/net40 VSS VSS nch W=0.155u L=0.04u
M_U1101/MI13-M_u2 U1101/net106 n1031 VSS VSS nch W=0.155u L=0.04u
M_U1101/MI14-M_u2 U1101/net104 n1049 VSS VSS nch W=0.155u L=0.04u
M_U1101/M_u8-M_u2 U1101/net30 n1036 VSS VSS nch W=0.155u L=0.04u
M_U1101/MI12-M_u2 U1101/net108 U1101/net104 VSS VSS nch W=0.155u L=0.04u
M_U1101/MU20-M_u2 n1210 U1101/net28 VSS VSS nch W=0.155u L=0.04u
M_U1101/MI1-M_u2 U1101/net32 n1211 VSS VSS nch W=0.155u L=0.04u
M_U1101/MI16-M_u2 U1101/net64 U1101/net24 VSS VSS nch W=0.2u L=0.04u
M_U1101/MI15-M_u2 U1101/net28 U1101/net40 U1101/net64 VDD pch W=0.205u L=0.04u
M_U1101/MI8-M_u2 U1101/net24 n1036 U1101/net32 VDD pch W=0.205u L=0.04u
M_U1101/MI17-M_u2 U1101/net28 U1101/net20 U1101/net24 VDD pch W=0.205u L=0.04u
M_U1101/MI11-M_u2 U1101/net40 U1101/net106 U1101/net108 VDD pch W=0.205u L=0.04u
M_U1101/MI9-M_u2 U1101/net40 n1031 U1101/net104 VDD pch W=0.205u L=0.04u
M_U1101/MI19-M_u3 U1101/net20 U1101/net40 VDD VDD pch W=0.205u L=0.04u
M_U1101/MI13-M_u3 U1101/net106 n1031 VDD VDD pch W=0.205u L=0.04u
M_U1101/MI14-M_u3 U1101/net104 n1049 VDD VDD pch W=0.205u L=0.04u
M_U1101/M_u8-M_u3 U1101/net30 n1036 VDD VDD pch W=0.205u L=0.04u
M_U1101/MI12-M_u3 U1101/net108 U1101/net104 VDD VDD pch W=0.205u L=0.04u
M_U1101/MU20-M_u3 n1210 U1101/net28 VDD VDD pch W=0.205u L=0.04u
M_U1101/MI1-M_u3 U1101/net32 n1211 VDD VDD pch W=0.205u L=0.04u
M_U1101/MI16-M_u3 U1101/net64 U1101/net24 VDD VDD pch W=0.28u L=0.04u
M_U1101/MI20 U1101/net24 U1101/net30 U1101/net045 VDD pch W=0.205u L=0.04u
M_U1101/M_u2 U1101/net045 U1101/net32 VDD VDD pch W=0.205u L=0.04u
M_U1102/MI15-M_u2 U1102/net19 N18 VSS VSS nch W=0.155u L=0.04u
M_U1102/MI21 n1031 N18 U1102/net40 VSS nch W=0.155u L=0.04u
M_U1102/MI12 n1031 U1102/net19 U1102/net36 VSS nch W=0.155u L=0.04u
M_U1102/MI20 U1102/net40 n1212 VSS VSS nch W=0.31u L=0.04u
M_U1102/MI19 U1102/net36 N88 VSS VSS nch W=0.155u L=0.04u
M_U1102/MI15-M_u3 U1102/net19 N18 VDD VDD pch W=0.205u L=0.04u
M_U1102/MI25 n1031 U1102/net19 U1102/net26 VDD pch W=0.325u L=0.04u
M_U1102/MI24 U1102/net26 n1212 VDD VDD pch W=0.41u L=0.04u
M_U1102/MI5 n1031 N18 U1102/net30 VDD pch W=0.325u L=0.04u
M_U1102/MI111 U1102/net30 N88 VDD VDD pch W=0.205u L=0.04u
M_U1103/M_u2 n1049 n1045 VSS VSS nch W=0.135u L=0.04u
M_U1103/M_u1 n1049 n1045 VDD VDD pch W=0.205u L=0.04u
M_U1104/MI15-M_u2 U1104/net19 N18 VSS VSS nch W=0.155u L=0.04u
M_U1104/MI21 n1045 N18 U1104/net40 VSS nch W=0.155u L=0.04u
M_U1104/MI12 n1045 U1104/net19 U1104/net36 VSS nch W=0.155u L=0.04u
M_U1104/MI20 U1104/net40 n1213 VSS VSS nch W=0.31u L=0.04u
M_U1104/MI19 U1104/net36 N113 VSS VSS nch W=0.155u L=0.04u
M_U1104/MI15-M_u3 U1104/net19 N18 VDD VDD pch W=0.205u L=0.04u
M_U1104/MI25 n1045 U1104/net19 U1104/net26 VDD pch W=0.325u L=0.04u
M_U1104/MI24 U1104/net26 n1213 VDD VDD pch W=0.41u L=0.04u
M_U1104/MI5 n1045 N18 U1104/net30 VDD pch W=0.325u L=0.04u
M_U1104/MI111 U1104/net30 N113 VDD VDD pch W=0.205u L=0.04u
M_U1105/MI15-M_u2 U1105/net19 N18 VSS VSS nch W=0.155u L=0.04u
M_U1105/MI21 n1211 N18 U1105/net40 VSS nch W=0.155u L=0.04u
M_U1105/MI12 n1211 U1105/net19 U1105/net36 VSS nch W=0.155u L=0.04u
M_U1105/MI20 U1105/net40 n1214 VSS VSS nch W=0.31u L=0.04u
M_U1105/MI19 U1105/net36 N114 VSS VSS nch W=0.155u L=0.04u
M_U1105/MI15-M_u3 U1105/net19 N18 VDD VDD pch W=0.205u L=0.04u
M_U1105/MI25 n1211 U1105/net19 U1105/net26 VDD pch W=0.325u L=0.04u
M_U1105/MI24 U1105/net26 n1214 VDD VDD pch W=0.41u L=0.04u
M_U1105/MI5 n1211 N18 U1105/net30 VDD pch W=0.325u L=0.04u
M_U1105/MI111 U1105/net30 N114 VDD VDD pch W=0.205u L=0.04u
M_U1106/M_u2 n1214 N248 VSS VSS nch W=0.135u L=0.04u
M_U1106/M_u1 n1214 N248 VDD VDD pch W=0.205u L=0.04u
M_U1107/MU29-M_u2 n1036 U1107/net28 VSS VSS nch W=0.155u L=0.04u
M_U1107/MI111 U1107/net47 n1215 VSS VSS nch W=0.155u L=0.04u
M_U1107/MI5 U1107/net28 U1107/net6 U1107/net47 VSS nch W=0.155u L=0.04u
M_U1107/MI14 U1107/net44 N112 VSS VSS nch W=0.155u L=0.04u
M_U1107/MI13 U1107/net28 n1184 U1107/net44 VSS nch W=0.155u L=0.04u
M_U1107/MU24 U1107/net6 n1184 VSS VSS nch W=0.155u L=0.04u
M_U1107/MU29-M_u3 n1036 U1107/net28 VDD VDD pch W=0.205u L=0.04u
M_U1107/MI2 VDD n1215 U1107/net47 VDD pch W=0.205u L=0.04u
M_U1107/MI4 U1107/net47 n1184 U1107/net28 VDD pch W=0.205u L=0.04u
M_U1107/MI12 U1107/net44 U1107/net6 U1107/net28 VDD pch W=0.205u L=0.04u
M_U1107/MI10 VDD N112 U1107/net44 VDD pch W=0.205u L=0.04u
M_U1107/MU25 VDD n1184 U1107/net6 VDD pch W=0.205u L=0.04u
M_U1108/MI15-M_u3 U1108/net28 U1108/net20 U1108/net64 VSS nch W=0.155u L=0.04u
M_U1108/MI8-M_u3 U1108/net24 U1108/net30 U1108/net32 VSS nch W=0.155u L=0.04u
M_U1108/MI17-M_u3 U1108/net28 U1108/net40 U1108/net24 VSS nch W=0.155u L=0.04u
M_U1108/MI11-M_u3 U1108/net40 n1040 U1108/net108 VSS nch W=0.155u L=0.04u
M_U1108/MI9-M_u3 U1108/net40 U1108/net106 U1108/net104 VSS nch W=0.155u L=0.04u
M_U1108/MI21 U1108/net24 n1046 U1108/net050 VSS nch W=0.155u L=0.04u
M_U1108/MI22 U1108/net050 U1108/net32 VSS VSS nch W=0.155u L=0.04u
M_U1108/MI19-M_u2 U1108/net20 U1108/net40 VSS VSS nch W=0.155u L=0.04u
M_U1108/MI13-M_u2 U1108/net106 n1040 VSS VSS nch W=0.155u L=0.04u
M_U1108/MI14-M_u2 U1108/net104 n1217 VSS VSS nch W=0.155u L=0.04u
M_U1108/M_u8-M_u2 U1108/net30 n1046 VSS VSS nch W=0.155u L=0.04u
M_U1108/MI12-M_u2 U1108/net108 U1108/net104 VSS VSS nch W=0.155u L=0.04u
M_U1108/MU20-M_u2 n1209 U1108/net28 VSS VSS nch W=0.155u L=0.04u
M_U1108/MI1-M_u2 U1108/net32 n1216 VSS VSS nch W=0.155u L=0.04u
M_U1108/MI16-M_u2 U1108/net64 U1108/net24 VSS VSS nch W=0.2u L=0.04u
M_U1108/MI15-M_u2 U1108/net28 U1108/net40 U1108/net64 VDD pch W=0.205u L=0.04u
M_U1108/MI8-M_u2 U1108/net24 n1046 U1108/net32 VDD pch W=0.205u L=0.04u
M_U1108/MI17-M_u2 U1108/net28 U1108/net20 U1108/net24 VDD pch W=0.205u L=0.04u
M_U1108/MI11-M_u2 U1108/net40 U1108/net106 U1108/net108 VDD pch W=0.205u L=0.04u
M_U1108/MI9-M_u2 U1108/net40 n1040 U1108/net104 VDD pch W=0.205u L=0.04u
M_U1108/MI19-M_u3 U1108/net20 U1108/net40 VDD VDD pch W=0.205u L=0.04u
M_U1108/MI13-M_u3 U1108/net106 n1040 VDD VDD pch W=0.205u L=0.04u
M_U1108/MI14-M_u3 U1108/net104 n1217 VDD VDD pch W=0.205u L=0.04u
M_U1108/M_u8-M_u3 U1108/net30 n1046 VDD VDD pch W=0.205u L=0.04u
M_U1108/MI12-M_u3 U1108/net108 U1108/net104 VDD VDD pch W=0.205u L=0.04u
M_U1108/MU20-M_u3 n1209 U1108/net28 VDD VDD pch W=0.205u L=0.04u
M_U1108/MI1-M_u3 U1108/net32 n1216 VDD VDD pch W=0.205u L=0.04u
M_U1108/MI16-M_u3 U1108/net64 U1108/net24 VDD VDD pch W=0.28u L=0.04u
M_U1108/MI20 U1108/net24 U1108/net30 U1108/net045 VDD pch W=0.205u L=0.04u
M_U1108/M_u2 U1108/net045 U1108/net32 VDD VDD pch W=0.205u L=0.04u
M_U1109/MI15-M_u2 U1109/net19 N18 VSS VSS nch W=0.155u L=0.04u
M_U1109/MI21 n1040 N18 U1109/net40 VSS nch W=0.155u L=0.04u
M_U1109/MI12 n1040 U1109/net19 U1109/net36 VSS nch W=0.155u L=0.04u
M_U1109/MI20 U1109/net40 n1218 VSS VSS nch W=0.31u L=0.04u
M_U1109/MI19 U1109/net36 N87 VSS VSS nch W=0.155u L=0.04u
M_U1109/MI15-M_u3 U1109/net19 N18 VDD VDD pch W=0.205u L=0.04u
M_U1109/MI25 n1040 U1109/net19 U1109/net26 VDD pch W=0.325u L=0.04u
M_U1109/MI24 U1109/net26 n1218 VDD VDD pch W=0.41u L=0.04u
M_U1109/MI5 n1040 N18 U1109/net30 VDD pch W=0.325u L=0.04u
M_U1109/MI111 U1109/net30 N87 VDD VDD pch W=0.205u L=0.04u
M_U1110/M_u2 n1218 N106 VSS VSS nch W=0.135u L=0.04u
M_U1110/M_u1 n1218 N106 VDD VDD pch W=0.205u L=0.04u
M_U1111/MI15-M_u2 U1111/net19 N18 VSS VSS nch W=0.155u L=0.04u
M_U1111/MI21 n1217 N18 U1111/net40 VSS nch W=0.155u L=0.04u
M_U1111/MI12 n1217 U1111/net19 U1111/net36 VSS nch W=0.155u L=0.04u
M_U1111/MI20 U1111/net40 n1219 VSS VSS nch W=0.31u L=0.04u
M_U1111/MI19 U1111/net36 N245 VSS VSS nch W=0.155u L=0.04u
M_U1111/MI15-M_u3 U1111/net19 N18 VDD VDD pch W=0.205u L=0.04u
M_U1111/MI25 n1217 U1111/net19 U1111/net26 VDD pch W=0.325u L=0.04u
M_U1111/MI24 U1111/net26 n1219 VDD VDD pch W=0.41u L=0.04u
M_U1111/MI5 n1217 N18 U1111/net30 VDD pch W=0.325u L=0.04u
M_U1111/MI111 U1111/net30 N245 VDD VDD pch W=0.205u L=0.04u
M_U1112/MI15-M_u2 U1112/net19 N18 VSS VSS nch W=0.155u L=0.04u
M_U1112/MI21 n1216 N18 U1112/net40 VSS nch W=0.155u L=0.04u
M_U1112/MI12 n1216 U1112/net19 U1112/net36 VSS nch W=0.155u L=0.04u
M_U1112/MI20 U1112/net40 n1220 VSS VSS nch W=0.31u L=0.04u
M_U1112/MI19 U1112/net36 N271 VSS VSS nch W=0.155u L=0.04u
M_U1112/MI15-M_u3 U1112/net19 N18 VDD VDD pch W=0.205u L=0.04u
M_U1112/MI25 n1216 U1112/net19 U1112/net26 VDD pch W=0.325u L=0.04u
M_U1112/MI24 U1112/net26 n1220 VDD VDD pch W=0.41u L=0.04u
M_U1112/MI5 n1216 N18 U1112/net30 VDD pch W=0.325u L=0.04u
M_U1112/MI111 U1112/net30 N271 VDD VDD pch W=0.205u L=0.04u
M_U1113/MI15-M_u2 U1113/net19 N18 VSS VSS nch W=0.155u L=0.04u
M_U1113/MI21 n1046 N18 U1113/net40 VSS nch W=0.155u L=0.04u
M_U1113/MI12 n1046 U1113/net19 U1113/net36 VSS nch W=0.155u L=0.04u
M_U1113/MI20 U1113/net40 n1221 VSS VSS nch W=0.31u L=0.04u
M_U1113/MI19 U1113/net36 N111 VSS VSS nch W=0.155u L=0.04u
M_U1113/MI15-M_u3 U1113/net19 N18 VDD VDD pch W=0.205u L=0.04u
M_U1113/MI25 n1046 U1113/net19 U1113/net26 VDD pch W=0.325u L=0.04u
M_U1113/MI24 U1113/net26 n1221 VDD VDD pch W=0.41u L=0.04u
M_U1113/MI5 n1046 N18 U1113/net30 VDD pch W=0.325u L=0.04u
M_U1113/MI111 U1113/net30 N111 VDD VDD pch W=0.205u L=0.04u
M_U1114/MI15-M_u3 U1114/net28 U1114/net20 U1114/net64 VSS nch W=0.155u L=0.04u
M_U1114/MI8-M_u3 U1114/net24 U1114/net30 U1114/net32 VSS nch W=0.155u L=0.04u
M_U1114/MI17-M_u3 U1114/net28 U1114/net40 U1114/net24 VSS nch W=0.155u L=0.04u
M_U1114/MI11-M_u3 U1114/net40 n1223 U1114/net108 VSS nch W=0.155u L=0.04u
M_U1114/MI9-M_u3 U1114/net40 U1114/net106 U1114/net104 VSS nch W=0.155u L=0.04u
M_U1114/MI21 U1114/net24 n1222 U1114/net050 VSS nch W=0.155u L=0.04u
M_U1114/MI22 U1114/net050 U1114/net32 VSS VSS nch W=0.155u L=0.04u
M_U1114/MI19-M_u2 U1114/net20 U1114/net40 VSS VSS nch W=0.155u L=0.04u
M_U1114/MI13-M_u2 U1114/net106 n1223 VSS VSS nch W=0.155u L=0.04u
M_U1114/MI14-M_u2 U1114/net104 n1084 VSS VSS nch W=0.155u L=0.04u
M_U1114/M_u8-M_u2 U1114/net30 n1222 VSS VSS nch W=0.155u L=0.04u
M_U1114/MI12-M_u2 U1114/net108 U1114/net104 VSS VSS nch W=0.155u L=0.04u
M_U1114/MU20-M_u2 n1207 U1114/net28 VSS VSS nch W=0.155u L=0.04u
M_U1114/MI1-M_u2 U1114/net32 n1065 VSS VSS nch W=0.155u L=0.04u
M_U1114/MI16-M_u2 U1114/net64 U1114/net24 VSS VSS nch W=0.2u L=0.04u
M_U1114/MI15-M_u2 U1114/net28 U1114/net40 U1114/net64 VDD pch W=0.205u L=0.04u
M_U1114/MI8-M_u2 U1114/net24 n1222 U1114/net32 VDD pch W=0.205u L=0.04u
M_U1114/MI17-M_u2 U1114/net28 U1114/net20 U1114/net24 VDD pch W=0.205u L=0.04u
M_U1114/MI11-M_u2 U1114/net40 U1114/net106 U1114/net108 VDD pch W=0.205u L=0.04u
M_U1114/MI9-M_u2 U1114/net40 n1223 U1114/net104 VDD pch W=0.205u L=0.04u
M_U1114/MI19-M_u3 U1114/net20 U1114/net40 VDD VDD pch W=0.205u L=0.04u
M_U1114/MI13-M_u3 U1114/net106 n1223 VDD VDD pch W=0.205u L=0.04u
M_U1114/MI14-M_u3 U1114/net104 n1084 VDD VDD pch W=0.205u L=0.04u
M_U1114/M_u8-M_u3 U1114/net30 n1222 VDD VDD pch W=0.205u L=0.04u
M_U1114/MI12-M_u3 U1114/net108 U1114/net104 VDD VDD pch W=0.205u L=0.04u
M_U1114/MU20-M_u3 n1207 U1114/net28 VDD VDD pch W=0.205u L=0.04u
M_U1114/MI1-M_u3 U1114/net32 n1065 VDD VDD pch W=0.205u L=0.04u
M_U1114/MI16-M_u3 U1114/net64 U1114/net24 VDD VDD pch W=0.28u L=0.04u
M_U1114/MI20 U1114/net24 U1114/net30 U1114/net045 VDD pch W=0.205u L=0.04u
M_U1114/M_u2 U1114/net045 U1114/net32 VDD VDD pch W=0.205u L=0.04u
M_U1115/MI15-M_u3 U1115/net28 U1115/net20 U1115/net64 VSS nch W=0.155u L=0.04u
M_U1115/MI8-M_u3 U1115/net24 U1115/net30 U1115/net32 VSS nch W=0.155u L=0.04u
M_U1115/MI17-M_u3 U1115/net28 U1115/net40 U1115/net24 VSS nch W=0.155u L=0.04u
M_U1115/MI11-M_u3 U1115/net40 n1062 U1115/net108 VSS nch W=0.155u L=0.04u
M_U1115/MI9-M_u3 U1115/net40 U1115/net106 U1115/net104 VSS nch W=0.155u L=0.04u
M_U1115/MI21 U1115/net24 n1075 U1115/net050 VSS nch W=0.155u L=0.04u
M_U1115/MI22 U1115/net050 U1115/net32 VSS VSS nch W=0.155u L=0.04u
M_U1115/MI19-M_u2 U1115/net20 U1115/net40 VSS VSS nch W=0.155u L=0.04u
M_U1115/MI13-M_u2 U1115/net106 n1062 VSS VSS nch W=0.155u L=0.04u
M_U1115/MI14-M_u2 U1115/net104 n1070 VSS VSS nch W=0.155u L=0.04u
M_U1115/M_u8-M_u2 U1115/net30 n1075 VSS VSS nch W=0.155u L=0.04u
M_U1115/MI12-M_u2 U1115/net108 U1115/net104 VSS VSS nch W=0.155u L=0.04u
M_U1115/MU20-M_u2 n1223 U1115/net28 VSS VSS nch W=0.155u L=0.04u
M_U1115/MI1-M_u2 U1115/net32 n1056 VSS VSS nch W=0.155u L=0.04u
M_U1115/MI16-M_u2 U1115/net64 U1115/net24 VSS VSS nch W=0.2u L=0.04u
M_U1115/MI15-M_u2 U1115/net28 U1115/net40 U1115/net64 VDD pch W=0.205u L=0.04u
M_U1115/MI8-M_u2 U1115/net24 n1075 U1115/net32 VDD pch W=0.205u L=0.04u
M_U1115/MI17-M_u2 U1115/net28 U1115/net20 U1115/net24 VDD pch W=0.205u L=0.04u
M_U1115/MI11-M_u2 U1115/net40 U1115/net106 U1115/net108 VDD pch W=0.205u L=0.04u
M_U1115/MI9-M_u2 U1115/net40 n1062 U1115/net104 VDD pch W=0.205u L=0.04u
M_U1115/MI19-M_u3 U1115/net20 U1115/net40 VDD VDD pch W=0.205u L=0.04u
M_U1115/MI13-M_u3 U1115/net106 n1062 VDD VDD pch W=0.205u L=0.04u
M_U1115/MI14-M_u3 U1115/net104 n1070 VDD VDD pch W=0.205u L=0.04u
M_U1115/M_u8-M_u3 U1115/net30 n1075 VDD VDD pch W=0.205u L=0.04u
M_U1115/MI12-M_u3 U1115/net108 U1115/net104 VDD VDD pch W=0.205u L=0.04u
M_U1115/MU20-M_u3 n1223 U1115/net28 VDD VDD pch W=0.205u L=0.04u
M_U1115/MI1-M_u3 U1115/net32 n1056 VDD VDD pch W=0.205u L=0.04u
M_U1115/MI16-M_u3 U1115/net64 U1115/net24 VDD VDD pch W=0.28u L=0.04u
M_U1115/MI20 U1115/net24 U1115/net30 U1115/net045 VDD pch W=0.205u L=0.04u
M_U1115/M_u2 U1115/net045 U1115/net32 VDD VDD pch W=0.205u L=0.04u
M_U1116/MI15-M_u2 U1116/net19 N18 VSS VSS nch W=0.155u L=0.04u
M_U1116/MI21 n1062 N18 U1116/net40 VSS nch W=0.155u L=0.04u
M_U1116/MI12 n1062 U1116/net19 U1116/net36 VSS nch W=0.155u L=0.04u
M_U1116/MI20 U1116/net40 n1224 VSS VSS nch W=0.31u L=0.04u
M_U1116/MI19 U1116/net36 N86 VSS VSS nch W=0.155u L=0.04u
M_U1116/MI15-M_u3 U1116/net19 N18 VDD VDD pch W=0.205u L=0.04u
M_U1116/MI25 n1062 U1116/net19 U1116/net26 VDD pch W=0.325u L=0.04u
M_U1116/MI24 U1116/net26 n1224 VDD VDD pch W=0.41u L=0.04u
M_U1116/MI5 n1062 N18 U1116/net30 VDD pch W=0.325u L=0.04u
M_U1116/MI111 U1116/net30 N86 VDD VDD pch W=0.205u L=0.04u
M_U1117/MI15-M_u2 U1117/net19 N18 VSS VSS nch W=0.155u L=0.04u
M_U1117/MI21 n1070 N18 U1117/net40 VSS nch W=0.155u L=0.04u
M_U1117/MI12 n1070 U1117/net19 U1117/net36 VSS nch W=0.155u L=0.04u
M_U1117/MI20 U1117/net40 n1225 VSS VSS nch W=0.31u L=0.04u
M_U1117/MI19 U1117/net36 N64 VSS VSS nch W=0.155u L=0.04u
M_U1117/MI15-M_u3 U1117/net19 N18 VDD VDD pch W=0.205u L=0.04u
M_U1117/MI25 n1070 U1117/net19 U1117/net26 VDD pch W=0.325u L=0.04u
M_U1117/MI24 U1117/net26 n1225 VDD VDD pch W=0.41u L=0.04u
M_U1117/MI5 n1070 N18 U1117/net30 VDD pch W=0.325u L=0.04u
M_U1117/MI111 U1117/net30 N64 VDD VDD pch W=0.205u L=0.04u
M_U1118/MU29-M_u2 n1056 U1118/net28 VSS VSS nch W=0.155u L=0.04u
M_U1118/MI111 U1118/net47 n1226 VSS VSS nch W=0.155u L=0.04u
M_U1118/MI5 U1118/net28 U1118/net6 U1118/net47 VSS nch W=0.155u L=0.04u
M_U1118/MI14 U1118/net44 N110 VSS VSS nch W=0.155u L=0.04u
M_U1118/MI13 U1118/net28 n1184 U1118/net44 VSS nch W=0.155u L=0.04u
M_U1118/MU24 U1118/net6 n1184 VSS VSS nch W=0.155u L=0.04u
M_U1118/MU29-M_u3 n1056 U1118/net28 VDD VDD pch W=0.205u L=0.04u
M_U1118/MI2 VDD n1226 U1118/net47 VDD pch W=0.205u L=0.04u
M_U1118/MI4 U1118/net47 n1184 U1118/net28 VDD pch W=0.205u L=0.04u
M_U1118/MI12 U1118/net44 U1118/net6 U1118/net28 VDD pch W=0.205u L=0.04u
M_U1118/MI10 VDD N110 U1118/net44 VDD pch W=0.205u L=0.04u
M_U1118/MU25 VDD n1184 U1118/net6 VDD pch W=0.205u L=0.04u
M_U1119/MU29-M_u2 n1075 U1119/net28 VSS VSS nch W=0.155u L=0.04u
M_U1119/MI111 U1119/net47 n1227 VSS VSS nch W=0.155u L=0.04u
M_U1119/MI5 U1119/net28 U1119/net6 U1119/net47 VSS nch W=0.155u L=0.04u
M_U1119/MI14 U1119/net44 N85 VSS VSS nch W=0.155u L=0.04u
M_U1119/MI13 U1119/net28 n1184 U1119/net44 VSS nch W=0.155u L=0.04u
M_U1119/MU24 U1119/net6 n1184 VSS VSS nch W=0.155u L=0.04u
M_U1119/MU29-M_u3 n1075 U1119/net28 VDD VDD pch W=0.205u L=0.04u
M_U1119/MI2 VDD n1227 U1119/net47 VDD pch W=0.205u L=0.04u
M_U1119/MI4 U1119/net47 n1184 U1119/net28 VDD pch W=0.205u L=0.04u
M_U1119/MI12 U1119/net44 U1119/net6 U1119/net28 VDD pch W=0.205u L=0.04u
M_U1119/MI10 VDD N85 U1119/net44 VDD pch W=0.205u L=0.04u
M_U1119/MU25 VDD n1184 U1119/net6 VDD pch W=0.205u L=0.04u
M_U1120/MI15-M_u2 U1120/net19 n1184 VSS VSS nch W=0.155u L=0.04u
M_U1120/MI21 n1084 n1184 U1120/net40 VSS nch W=0.155u L=0.04u
M_U1120/MI12 n1084 U1120/net19 U1120/net36 VSS nch W=0.155u L=0.04u
M_U1120/MI20 U1120/net40 n1228 VSS VSS nch W=0.31u L=0.04u
M_U1120/MI19 U1120/net36 N277 VSS VSS nch W=0.155u L=0.04u
M_U1120/MI15-M_u3 U1120/net19 n1184 VDD VDD pch W=0.205u L=0.04u
M_U1120/MI25 n1084 U1120/net19 U1120/net26 VDD pch W=0.325u L=0.04u
M_U1120/MI24 U1120/net26 n1228 VDD VDD pch W=0.41u L=0.04u
M_U1120/MI5 n1084 n1184 U1120/net30 VDD pch W=0.325u L=0.04u
M_U1120/MI111 U1120/net30 N277 VDD VDD pch W=0.205u L=0.04u
M_U1121/M_u2 n1228 N65 VSS VSS nch W=0.135u L=0.04u
M_U1121/M_u1 n1228 N65 VDD VDD pch W=0.205u L=0.04u
M_U1122/MI15-M_u2 U1122/net19 N18 VSS VSS nch W=0.155u L=0.04u
M_U1122/MI21 n1065 N18 U1122/net40 VSS nch W=0.155u L=0.04u
M_U1122/MI12 n1065 U1122/net19 U1122/net36 VSS nch W=0.155u L=0.04u
M_U1122/MI20 U1122/net40 n1229 VSS VSS nch W=0.31u L=0.04u
M_U1122/MI19 U1122/net36 N63 VSS VSS nch W=0.155u L=0.04u
M_U1122/MI15-M_u3 U1122/net19 N18 VDD VDD pch W=0.205u L=0.04u
M_U1122/MI25 n1065 U1122/net19 U1122/net26 VDD pch W=0.325u L=0.04u
M_U1122/MI24 U1122/net26 n1229 VDD VDD pch W=0.41u L=0.04u
M_U1122/MI5 n1065 N18 U1122/net30 VDD pch W=0.325u L=0.04u
M_U1122/MI111 U1122/net30 N63 VDD VDD pch W=0.205u L=0.04u
M_U1123/MI15-M_u3 U1123/net28 U1123/net20 U1123/net64 VSS nch W=0.155u L=0.04u
M_U1123/MI8-M_u3 U1123/net24 U1123/net30 U1123/net32 VSS nch W=0.155u L=0.04u
M_U1123/MI17-M_u3 U1123/net28 U1123/net40 U1123/net24 VSS nch W=0.155u L=0.04u
M_U1123/MI11-M_u3 U1123/net40 n1231 U1123/net108 VSS nch W=0.155u L=0.04u
M_U1123/MI9-M_u3 U1123/net40 U1123/net106 U1123/net104 VSS nch W=0.155u L=0.04u
M_U1123/MI21 U1123/net24 n1088 U1123/net050 VSS nch W=0.155u L=0.04u
M_U1123/MI22 U1123/net050 U1123/net32 VSS VSS nch W=0.155u L=0.04u
M_U1123/MI19-M_u2 U1123/net20 U1123/net40 VSS VSS nch W=0.155u L=0.04u
M_U1123/MI13-M_u2 U1123/net106 n1231 VSS VSS nch W=0.155u L=0.04u
M_U1123/MI14-M_u2 U1123/net104 n1078 VSS VSS nch W=0.155u L=0.04u
M_U1123/M_u8-M_u2 U1123/net30 n1088 VSS VSS nch W=0.155u L=0.04u
M_U1123/MI12-M_u2 U1123/net108 U1123/net104 VSS VSS nch W=0.155u L=0.04u
M_U1123/MU20-M_u2 n1222 U1123/net28 VSS VSS nch W=0.155u L=0.04u
M_U1123/MI1-M_u2 U1123/net32 n1230 VSS VSS nch W=0.155u L=0.04u
M_U1123/MI16-M_u2 U1123/net64 U1123/net24 VSS VSS nch W=0.2u L=0.04u
M_U1123/MI15-M_u2 U1123/net28 U1123/net40 U1123/net64 VDD pch W=0.205u L=0.04u
M_U1123/MI8-M_u2 U1123/net24 n1088 U1123/net32 VDD pch W=0.205u L=0.04u
M_U1123/MI17-M_u2 U1123/net28 U1123/net20 U1123/net24 VDD pch W=0.205u L=0.04u
M_U1123/MI11-M_u2 U1123/net40 U1123/net106 U1123/net108 VDD pch W=0.205u L=0.04u
M_U1123/MI9-M_u2 U1123/net40 n1231 U1123/net104 VDD pch W=0.205u L=0.04u
M_U1123/MI19-M_u3 U1123/net20 U1123/net40 VDD VDD pch W=0.205u L=0.04u
M_U1123/MI13-M_u3 U1123/net106 n1231 VDD VDD pch W=0.205u L=0.04u
M_U1123/MI14-M_u3 U1123/net104 n1078 VDD VDD pch W=0.205u L=0.04u
M_U1123/M_u8-M_u3 U1123/net30 n1088 VDD VDD pch W=0.205u L=0.04u
M_U1123/MI12-M_u3 U1123/net108 U1123/net104 VDD VDD pch W=0.205u L=0.04u
M_U1123/MU20-M_u3 n1222 U1123/net28 VDD VDD pch W=0.205u L=0.04u
M_U1123/MI1-M_u3 U1123/net32 n1230 VDD VDD pch W=0.205u L=0.04u
M_U1123/MI16-M_u3 U1123/net64 U1123/net24 VDD VDD pch W=0.28u L=0.04u
M_U1123/MI20 U1123/net24 U1123/net30 U1123/net045 VDD pch W=0.205u L=0.04u
M_U1123/M_u2 U1123/net045 U1123/net32 VDD VDD pch W=0.205u L=0.04u
M_U1124/MI15-M_u2 U1124/net19 N18 VSS VSS nch W=0.155u L=0.04u
M_U1124/MI21 n1231 N18 U1124/net40 VSS nch W=0.155u L=0.04u
M_U1124/MI12 n1231 U1124/net19 U1124/net36 VSS nch W=0.155u L=0.04u
M_U1124/MI20 U1124/net40 N274 VSS VSS nch W=0.31u L=0.04u
M_U1124/MI19 U1124/net36 n1232 VSS VSS nch W=0.155u L=0.04u
M_U1124/MI15-M_u3 U1124/net19 N18 VDD VDD pch W=0.205u L=0.04u
M_U1124/MI25 n1231 U1124/net19 U1124/net26 VDD pch W=0.325u L=0.04u
M_U1124/MI24 U1124/net26 N274 VDD VDD pch W=0.41u L=0.04u
M_U1124/MI5 n1231 N18 U1124/net30 VDD pch W=0.325u L=0.04u
M_U1124/MI111 U1124/net30 n1232 VDD VDD pch W=0.205u L=0.04u
M_U1125/M_u2 n1232 N82 VSS VSS nch W=0.135u L=0.04u
M_U1125/M_u1 n1232 N82 VDD VDD pch W=0.205u L=0.04u
M_U1126/MI15-M_u2 U1126/net19 N18 VSS VSS nch W=0.155u L=0.04u
M_U1126/MI21 n1078 N18 U1126/net40 VSS nch W=0.155u L=0.04u
M_U1126/MI12 n1078 U1126/net19 U1126/net36 VSS nch W=0.155u L=0.04u
M_U1126/MI20 U1126/net40 n1233 VSS VSS nch W=0.31u L=0.04u
M_U1126/MI19 U1126/net36 N84 VSS VSS nch W=0.155u L=0.04u
M_U1126/MI15-M_u3 U1126/net19 N18 VDD VDD pch W=0.205u L=0.04u
M_U1126/MI25 n1078 U1126/net19 U1126/net26 VDD pch W=0.325u L=0.04u
M_U1126/MI24 U1126/net26 n1233 VDD VDD pch W=0.41u L=0.04u
M_U1126/MI5 n1078 N18 U1126/net30 VDD pch W=0.325u L=0.04u
M_U1126/MI111 U1126/net30 N84 VDD VDD pch W=0.205u L=0.04u
M_U1127/M_u2 n1233 N283 VSS VSS nch W=0.135u L=0.04u
M_U1127/M_u1 n1233 N283 VDD VDD pch W=0.205u L=0.04u
M_U1128/MI15-M_u2 U1128/net19 n1184 VSS VSS nch W=0.155u L=0.04u
M_U1128/MI21 n1230 n1184 U1128/net40 VSS nch W=0.155u L=0.04u
M_U1128/MI12 n1230 U1128/net19 U1128/net36 VSS nch W=0.155u L=0.04u
M_U1128/MI20 U1128/net40 N109 VSS VSS nch W=0.31u L=0.04u
M_U1128/MI19 U1128/net36 n1176 VSS VSS nch W=0.155u L=0.04u
M_U1128/MI15-M_u3 U1128/net19 n1184 VDD VDD pch W=0.205u L=0.04u
M_U1128/MI25 n1230 U1128/net19 U1128/net26 VDD pch W=0.325u L=0.04u
M_U1128/MI24 U1128/net26 N109 VDD VDD pch W=0.41u L=0.04u
M_U1128/MI5 n1230 n1184 U1128/net30 VDD pch W=0.325u L=0.04u
M_U1128/MI111 U1128/net30 n1176 VDD VDD pch W=0.205u L=0.04u
M_U1129/MI15-M_u2 U1129/net19 N18 VSS VSS nch W=0.155u L=0.04u
M_U1129/MI21 n1088 N18 U1129/net40 VSS nch W=0.155u L=0.04u
M_U1129/MI12 n1088 U1129/net19 U1129/net36 VSS nch W=0.155u L=0.04u
M_U1129/MI20 U1129/net40 n1234 VSS VSS nch W=0.31u L=0.04u
M_U1129/MI19 U1129/net36 N83 VSS VSS nch W=0.155u L=0.04u
M_U1129/MI15-M_u3 U1129/net19 N18 VDD VDD pch W=0.205u L=0.04u
M_U1129/MI25 n1088 U1129/net19 U1129/net26 VDD pch W=0.325u L=0.04u
M_U1129/MI24 U1129/net26 n1234 VDD VDD pch W=0.41u L=0.04u
M_U1129/MI5 n1088 N18 U1129/net30 VDD pch W=0.325u L=0.04u
M_U1129/MI111 U1129/net30 N83 VDD VDD pch W=0.205u L=0.04u
M_U1130/MI15-M_u3 U1130/net28 U1130/net20 U1130/net64 VSS nch W=0.155u L=0.04u
M_U1130/MI8-M_u3 U1130/net24 U1130/net30 U1130/net32 VSS nch W=0.155u L=0.04u
M_U1130/MI17-M_u3 U1130/net28 U1130/net40 U1130/net24 VSS nch W=0.155u L=0.04u
M_U1130/MI11-M_u3 U1130/net40 n1119 U1130/net108 VSS nch W=0.155u L=0.04u
M_U1130/MI9-M_u3 U1130/net40 U1130/net106 U1130/net104 VSS nch W=0.155u L=0.04u
M_U1130/MI21 U1130/net24 n1235 U1130/net050 VSS nch W=0.155u L=0.04u
M_U1130/MI22 U1130/net050 U1130/net32 VSS VSS nch W=0.155u L=0.04u
M_U1130/MI19-M_u2 U1130/net20 U1130/net40 VSS VSS nch W=0.155u L=0.04u
M_U1130/MI13-M_u2 U1130/net106 n1119 VSS VSS nch W=0.155u L=0.04u
M_U1130/MI14-M_u2 U1130/net104 n1236 VSS VSS nch W=0.155u L=0.04u
M_U1130/M_u8-M_u2 U1130/net30 n1235 VSS VSS nch W=0.155u L=0.04u
M_U1130/MI12-M_u2 U1130/net108 U1130/net104 VSS VSS nch W=0.155u L=0.04u
M_U1130/MU20-M_u2 n1206 U1130/net28 VSS VSS nch W=0.155u L=0.04u
M_U1130/MI1-M_u2 U1130/net32 n1099 VSS VSS nch W=0.155u L=0.04u
M_U1130/MI16-M_u2 U1130/net64 U1130/net24 VSS VSS nch W=0.2u L=0.04u
M_U1130/MI15-M_u2 U1130/net28 U1130/net40 U1130/net64 VDD pch W=0.205u L=0.04u
M_U1130/MI8-M_u2 U1130/net24 n1235 U1130/net32 VDD pch W=0.205u L=0.04u
M_U1130/MI17-M_u2 U1130/net28 U1130/net20 U1130/net24 VDD pch W=0.205u L=0.04u
M_U1130/MI11-M_u2 U1130/net40 U1130/net106 U1130/net108 VDD pch W=0.205u L=0.04u
M_U1130/MI9-M_u2 U1130/net40 n1119 U1130/net104 VDD pch W=0.205u L=0.04u
M_U1130/MI19-M_u3 U1130/net20 U1130/net40 VDD VDD pch W=0.205u L=0.04u
M_U1130/MI13-M_u3 U1130/net106 n1119 VDD VDD pch W=0.205u L=0.04u
M_U1130/MI14-M_u3 U1130/net104 n1236 VDD VDD pch W=0.205u L=0.04u
M_U1130/M_u8-M_u3 U1130/net30 n1235 VDD VDD pch W=0.205u L=0.04u
M_U1130/MI12-M_u3 U1130/net108 U1130/net104 VDD VDD pch W=0.205u L=0.04u
M_U1130/MU20-M_u3 n1206 U1130/net28 VDD VDD pch W=0.205u L=0.04u
M_U1130/MI1-M_u3 U1130/net32 n1099 VDD VDD pch W=0.205u L=0.04u
M_U1130/MI16-M_u3 U1130/net64 U1130/net24 VDD VDD pch W=0.28u L=0.04u
M_U1130/MI20 U1130/net24 U1130/net30 U1130/net045 VDD pch W=0.205u L=0.04u
M_U1130/M_u2 U1130/net045 U1130/net32 VDD VDD pch W=0.205u L=0.04u
M_U1131/MI15-M_u2 U1131/net19 N18 VSS VSS nch W=0.155u L=0.04u
M_U1131/MI21 n1119 N18 U1131/net40 VSS nch W=0.155u L=0.04u
M_U1131/MI12 n1119 U1131/net19 U1131/net36 VSS nch W=0.155u L=0.04u
M_U1131/MI20 U1131/net40 n1237 VSS VSS nch W=0.31u L=0.04u
M_U1131/MI19 U1131/net36 N77 VSS VSS nch W=0.155u L=0.04u
M_U1131/MI15-M_u3 U1131/net19 N18 VDD VDD pch W=0.205u L=0.04u
M_U1131/MI25 n1119 U1131/net19 U1131/net26 VDD pch W=0.325u L=0.04u
M_U1131/MI24 U1131/net26 n1237 VDD VDD pch W=0.41u L=0.04u
M_U1131/MI5 n1119 N18 U1131/net30 VDD pch W=0.325u L=0.04u
M_U1131/MI111 U1131/net30 N77 VDD VDD pch W=0.205u L=0.04u
M_U1132/MI15-M_u3 U1132/net28 U1132/net20 U1132/net64 VSS nch W=0.155u L=0.04u
M_U1132/MI8-M_u3 U1132/net24 U1132/net30 U1132/net32 VSS nch W=0.155u L=0.04u
M_U1132/MI17-M_u3 U1132/net28 U1132/net40 U1132/net24 VSS nch W=0.155u L=0.04u
M_U1132/MI11-M_u3 U1132/net40 n1162 U1132/net108 VSS nch W=0.155u L=0.04u
M_U1132/MI9-M_u3 U1132/net40 U1132/net106 U1132/net104 VSS nch W=0.155u L=0.04u
M_U1132/MI21 U1132/net24 n1166 U1132/net050 VSS nch W=0.155u L=0.04u
M_U1132/MI22 U1132/net050 U1132/net32 VSS VSS nch W=0.155u L=0.04u
M_U1132/MI19-M_u2 U1132/net20 U1132/net40 VSS VSS nch W=0.155u L=0.04u
M_U1132/MI13-M_u2 U1132/net106 n1162 VSS VSS nch W=0.155u L=0.04u
M_U1132/MI14-M_u2 U1132/net104 n1238 VSS VSS nch W=0.155u L=0.04u
M_U1132/M_u8-M_u2 U1132/net30 n1166 VSS VSS nch W=0.155u L=0.04u
M_U1132/MI12-M_u2 U1132/net108 U1132/net104 VSS VSS nch W=0.155u L=0.04u
M_U1132/MU20-M_u2 n1236 U1132/net28 VSS VSS nch W=0.155u L=0.04u
M_U1132/MI1-M_u2 U1132/net32 n1101 VSS VSS nch W=0.155u L=0.04u
M_U1132/MI16-M_u2 U1132/net64 U1132/net24 VSS VSS nch W=0.2u L=0.04u
M_U1132/MI15-M_u2 U1132/net28 U1132/net40 U1132/net64 VDD pch W=0.205u L=0.04u
M_U1132/MI8-M_u2 U1132/net24 n1166 U1132/net32 VDD pch W=0.205u L=0.04u
M_U1132/MI17-M_u2 U1132/net28 U1132/net20 U1132/net24 VDD pch W=0.205u L=0.04u
M_U1132/MI11-M_u2 U1132/net40 U1132/net106 U1132/net108 VDD pch W=0.205u L=0.04u
M_U1132/MI9-M_u2 U1132/net40 n1162 U1132/net104 VDD pch W=0.205u L=0.04u
M_U1132/MI19-M_u3 U1132/net20 U1132/net40 VDD VDD pch W=0.205u L=0.04u
M_U1132/MI13-M_u3 U1132/net106 n1162 VDD VDD pch W=0.205u L=0.04u
M_U1132/MI14-M_u3 U1132/net104 n1238 VDD VDD pch W=0.205u L=0.04u
M_U1132/M_u8-M_u3 U1132/net30 n1166 VDD VDD pch W=0.205u L=0.04u
M_U1132/MI12-M_u3 U1132/net108 U1132/net104 VDD VDD pch W=0.205u L=0.04u
M_U1132/MU20-M_u3 n1236 U1132/net28 VDD VDD pch W=0.205u L=0.04u
M_U1132/MI1-M_u3 U1132/net32 n1101 VDD VDD pch W=0.205u L=0.04u
M_U1132/MI16-M_u3 U1132/net64 U1132/net24 VDD VDD pch W=0.28u L=0.04u
M_U1132/MI20 U1132/net24 U1132/net30 U1132/net045 VDD pch W=0.205u L=0.04u
M_U1132/M_u2 U1132/net045 U1132/net32 VDD VDD pch W=0.205u L=0.04u
M_U1133/MI15-M_u2 U1133/net19 n1184 VSS VSS nch W=0.155u L=0.04u
M_U1133/MI21 n1162 n1184 U1133/net40 VSS nch W=0.155u L=0.04u
M_U1133/MI12 n1162 U1133/net19 U1133/net36 VSS nch W=0.155u L=0.04u
M_U1133/MI20 U1133/net40 n1239 VSS VSS nch W=0.31u L=0.04u
M_U1133/MI19 U1133/net36 N346 VSS VSS nch W=0.155u L=0.04u
M_U1133/MI15-M_u3 U1133/net19 n1184 VDD VDD pch W=0.205u L=0.04u
M_U1133/MI25 n1162 U1133/net19 U1133/net26 VDD pch W=0.325u L=0.04u
M_U1133/MI24 U1133/net26 n1239 VDD VDD pch W=0.41u L=0.04u
M_U1133/MI5 n1162 n1184 U1133/net30 VDD pch W=0.325u L=0.04u
M_U1133/MI111 U1133/net30 N346 VDD VDD pch W=0.205u L=0.04u
M_U1134/M_u2 n1239 N59 VSS VSS nch W=0.135u L=0.04u
M_U1134/M_u1 n1239 N59 VDD VDD pch W=0.205u L=0.04u
M_U1135/MI15-M_u2 U1135/net19 N18 VSS VSS nch W=0.155u L=0.04u
M_U1135/MI21 n1238 N18 U1135/net40 VSS nch W=0.155u L=0.04u
M_U1135/MI12 n1238 U1135/net19 U1135/net36 VSS nch W=0.155u L=0.04u
M_U1135/MI20 U1135/net40 N337 VSS VSS nch W=0.31u L=0.04u
M_U1135/MI19 U1135/net36 n1240 VSS VSS nch W=0.155u L=0.04u
M_U1135/MI15-M_u3 U1135/net19 N18 VDD VDD pch W=0.205u L=0.04u
M_U1135/MI25 n1238 U1135/net19 U1135/net26 VDD pch W=0.325u L=0.04u
M_U1135/MI24 U1135/net26 N337 VDD VDD pch W=0.41u L=0.04u
M_U1135/MI5 n1238 N18 U1135/net30 VDD pch W=0.325u L=0.04u
M_U1135/MI111 U1135/net30 n1240 VDD VDD pch W=0.205u L=0.04u
M_U1136/M_u2 n1240 N58 VSS VSS nch W=0.135u L=0.04u
M_U1136/M_u1 n1240 N58 VDD VDD pch W=0.205u L=0.04u
M_U1137/M_u2 n1101 n1168 VSS VSS nch W=0.135u L=0.04u
M_U1137/M_u1 n1101 n1168 VDD VDD pch W=0.205u L=0.04u
M_U1138/MI15-M_u2 U1138/net19 N18 VSS VSS nch W=0.155u L=0.04u
M_U1138/MI21 n1168 N18 U1138/net40 VSS nch W=0.155u L=0.04u
M_U1138/MI12 n1168 U1138/net19 U1138/net36 VSS nch W=0.155u L=0.04u
M_U1138/MI20 U1138/net40 n1241 VSS VSS nch W=0.31u L=0.04u
M_U1138/MI19 U1138/net36 N61 VSS VSS nch W=0.155u L=0.04u
M_U1138/MI15-M_u3 U1138/net19 N18 VDD VDD pch W=0.205u L=0.04u
M_U1138/MI25 n1168 U1138/net19 U1138/net26 VDD pch W=0.325u L=0.04u
M_U1138/MI24 U1138/net26 n1241 VDD VDD pch W=0.41u L=0.04u
M_U1138/MI5 n1168 N18 U1138/net30 VDD pch W=0.325u L=0.04u
M_U1138/MI111 U1138/net30 N61 VDD VDD pch W=0.205u L=0.04u
M_U1139/M_u2 n1241 N361 VSS VSS nch W=0.135u L=0.04u
M_U1139/M_u1 n1241 N361 VDD VDD pch W=0.205u L=0.04u
M_U1140/MI15-M_u2 U1140/net19 n1184 VSS VSS nch W=0.155u L=0.04u
M_U1140/MI21 n1166 n1184 U1140/net40 VSS nch W=0.155u L=0.04u
M_U1140/MI12 n1166 U1140/net19 U1140/net36 VSS nch W=0.155u L=0.04u
M_U1140/MI20 U1140/net40 N78 VSS VSS nch W=0.31u L=0.04u
M_U1140/MI19 U1140/net36 n1242 VSS VSS nch W=0.155u L=0.04u
M_U1140/MI15-M_u3 U1140/net19 n1184 VDD VDD pch W=0.205u L=0.04u
M_U1140/MI25 n1166 U1140/net19 U1140/net26 VDD pch W=0.325u L=0.04u
M_U1140/MI24 U1140/net26 N78 VDD VDD pch W=0.41u L=0.04u
M_U1140/MI5 n1166 n1184 U1140/net30 VDD pch W=0.325u L=0.04u
M_U1140/MI111 U1140/net30 n1242 VDD VDD pch W=0.205u L=0.04u
M_U1141/MI15-M_u2 U1141/net19 n1184 VSS VSS nch W=0.155u L=0.04u
M_U1141/MI21 n1099 n1184 U1141/net40 VSS nch W=0.155u L=0.04u
M_U1141/MI12 n1099 U1141/net19 U1141/net36 VSS nch W=0.155u L=0.04u
M_U1141/MI20 U1141/net40 n1243 VSS VSS nch W=0.31u L=0.04u
M_U1141/MI19 U1141/net36 N355 VSS VSS nch W=0.155u L=0.04u
M_U1141/MI15-M_u3 U1141/net19 n1184 VDD VDD pch W=0.205u L=0.04u
M_U1141/MI25 n1099 U1141/net19 U1141/net26 VDD pch W=0.325u L=0.04u
M_U1141/MI24 U1141/net26 n1243 VDD VDD pch W=0.41u L=0.04u
M_U1141/MI5 n1099 n1184 U1141/net30 VDD pch W=0.325u L=0.04u
M_U1141/MI111 U1141/net30 N355 VDD VDD pch W=0.205u L=0.04u
M_U1142/M_u2 n1243 N79 VSS VSS nch W=0.135u L=0.04u
M_U1142/M_u1 n1243 N79 VDD VDD pch W=0.205u L=0.04u
M_U1143/MI15-M_u3 U1143/net28 U1143/net20 U1143/net64 VSS nch W=0.155u L=0.04u
M_U1143/MI8-M_u3 U1143/net24 U1143/net30 U1143/net32 VSS nch W=0.155u L=0.04u
M_U1143/MI17-M_u3 U1143/net28 U1143/net40 U1143/net24 VSS nch W=0.155u L=0.04u
M_U1143/MI11-M_u3 U1143/net40 n1096 U1143/net108 VSS nch W=0.155u L=0.04u
M_U1143/MI9-M_u3 U1143/net40 U1143/net106 U1143/net104 VSS nch W=0.155u L=0.04u
M_U1143/MI21 U1143/net24 n1104 U1143/net050 VSS nch W=0.155u L=0.04u
M_U1143/MI22 U1143/net050 U1143/net32 VSS VSS nch W=0.155u L=0.04u
M_U1143/MI19-M_u2 U1143/net20 U1143/net40 VSS VSS nch W=0.155u L=0.04u
M_U1143/MI13-M_u2 U1143/net106 n1096 VSS VSS nch W=0.155u L=0.04u
M_U1143/MI14-M_u2 U1143/net104 n1113 VSS VSS nch W=0.155u L=0.04u
M_U1143/M_u8-M_u2 U1143/net30 n1104 VSS VSS nch W=0.155u L=0.04u
M_U1143/MI12-M_u2 U1143/net108 U1143/net104 VSS VSS nch W=0.155u L=0.04u
M_U1143/MU20-M_u2 n1235 U1143/net28 VSS VSS nch W=0.155u L=0.04u
M_U1143/MI1-M_u2 U1143/net32 n1173 VSS VSS nch W=0.155u L=0.04u
M_U1143/MI16-M_u2 U1143/net64 U1143/net24 VSS VSS nch W=0.2u L=0.04u
M_U1143/MI15-M_u2 U1143/net28 U1143/net40 U1143/net64 VDD pch W=0.205u L=0.04u
M_U1143/MI8-M_u2 U1143/net24 n1104 U1143/net32 VDD pch W=0.205u L=0.04u
M_U1143/MI17-M_u2 U1143/net28 U1143/net20 U1143/net24 VDD pch W=0.205u L=0.04u
M_U1143/MI11-M_u2 U1143/net40 U1143/net106 U1143/net108 VDD pch W=0.205u L=0.04u
M_U1143/MI9-M_u2 U1143/net40 n1096 U1143/net104 VDD pch W=0.205u L=0.04u
M_U1143/MI19-M_u3 U1143/net20 U1143/net40 VDD VDD pch W=0.205u L=0.04u
M_U1143/MI13-M_u3 U1143/net106 n1096 VDD VDD pch W=0.205u L=0.04u
M_U1143/MI14-M_u3 U1143/net104 n1113 VDD VDD pch W=0.205u L=0.04u
M_U1143/M_u8-M_u3 U1143/net30 n1104 VDD VDD pch W=0.205u L=0.04u
M_U1143/MI12-M_u3 U1143/net108 U1143/net104 VDD VDD pch W=0.205u L=0.04u
M_U1143/MU20-M_u3 n1235 U1143/net28 VDD VDD pch W=0.205u L=0.04u
M_U1143/MI1-M_u3 U1143/net32 n1173 VDD VDD pch W=0.205u L=0.04u
M_U1143/MI16-M_u3 U1143/net64 U1143/net24 VDD VDD pch W=0.28u L=0.04u
M_U1143/MI20 U1143/net24 U1143/net30 U1143/net045 VDD pch W=0.205u L=0.04u
M_U1143/M_u2 U1143/net045 U1143/net32 VDD VDD pch W=0.205u L=0.04u
M_U1144/MI15-M_u2 U1144/net19 N18 VSS VSS nch W=0.155u L=0.04u
M_U1144/MI21 n1096 N18 U1144/net40 VSS nch W=0.155u L=0.04u
M_U1144/MI12 n1096 U1144/net19 U1144/net36 VSS nch W=0.155u L=0.04u
M_U1144/MI20 U1144/net40 n1244 VSS VSS nch W=0.31u L=0.04u
M_U1144/MI19 U1144/net36 N62 VSS VSS nch W=0.155u L=0.04u
M_U1144/MI15-M_u3 U1144/net19 N18 VDD VDD pch W=0.205u L=0.04u
M_U1144/MI25 n1096 U1144/net19 U1144/net26 VDD pch W=0.325u L=0.04u
M_U1144/MI24 U1144/net26 n1244 VDD VDD pch W=0.41u L=0.04u
M_U1144/MI5 n1096 N18 U1144/net30 VDD pch W=0.325u L=0.04u
M_U1144/MI111 U1144/net30 N62 VDD VDD pch W=0.205u L=0.04u
M_U1145/M_u2 n1113 n1157 VSS VSS nch W=0.135u L=0.04u
M_U1145/M_u1 n1113 n1157 VDD VDD pch W=0.205u L=0.04u
M_U1146/MI15-M_u2 U1146/net19 N18 VSS VSS nch W=0.155u L=0.04u
M_U1146/MI21 n1157 N18 U1146/net40 VSS nch W=0.155u L=0.04u
M_U1146/MI12 n1157 U1146/net19 U1146/net36 VSS nch W=0.155u L=0.04u
M_U1146/MI20 U1146/net40 n1245 VSS VSS nch W=0.31u L=0.04u
M_U1146/MI19 U1146/net36 N81 VSS VSS nch W=0.155u L=0.04u
M_U1146/MI15-M_u3 U1146/net19 N18 VDD VDD pch W=0.205u L=0.04u
M_U1146/MI25 n1157 U1146/net19 U1146/net26 VDD pch W=0.325u L=0.04u
M_U1146/MI24 U1146/net26 n1245 VDD VDD pch W=0.41u L=0.04u
M_U1146/MI5 n1157 N18 U1146/net30 VDD pch W=0.325u L=0.04u
M_U1146/MI111 U1146/net30 N81 VDD VDD pch W=0.205u L=0.04u
M_U1147/MI15-M_u2 U1147/net19 N18 VSS VSS nch W=0.155u L=0.04u
M_U1147/MI21 n1173 N18 U1147/net40 VSS nch W=0.155u L=0.04u
M_U1147/MI12 n1173 U1147/net19 U1147/net36 VSS nch W=0.155u L=0.04u
M_U1147/MI20 U1147/net40 n1246 VSS VSS nch W=0.31u L=0.04u
M_U1147/MI19 U1147/net36 N60 VSS VSS nch W=0.155u L=0.04u
M_U1147/MI15-M_u3 U1147/net19 N18 VDD VDD pch W=0.205u L=0.04u
M_U1147/MI25 n1173 U1147/net19 U1147/net26 VDD pch W=0.325u L=0.04u
M_U1147/MI24 U1147/net26 n1246 VDD VDD pch W=0.41u L=0.04u
M_U1147/MI5 n1173 N18 U1147/net30 VDD pch W=0.325u L=0.04u
M_U1147/MI111 U1147/net30 N60 VDD VDD pch W=0.205u L=0.04u
M_U1148/MU29-M_u2 n1104 U1148/net28 VSS VSS nch W=0.155u L=0.04u
M_U1148/MI111 U1148/net47 n1247 VSS VSS nch W=0.155u L=0.04u
M_U1148/MI5 U1148/net28 U1148/net6 U1148/net47 VSS nch W=0.155u L=0.04u
M_U1148/MI14 U1148/net44 N80 VSS VSS nch W=0.155u L=0.04u
M_U1148/MI13 U1148/net28 n1184 U1148/net44 VSS nch W=0.155u L=0.04u
M_U1148/MU24 U1148/net6 n1184 VSS VSS nch W=0.155u L=0.04u
M_U1148/MU29-M_u3 n1104 U1148/net28 VDD VDD pch W=0.205u L=0.04u
M_U1148/MI2 VDD n1247 U1148/net47 VDD pch W=0.205u L=0.04u
M_U1148/MI4 U1148/net47 n1184 U1148/net28 VDD pch W=0.205u L=0.04u
M_U1148/MI12 U1148/net44 U1148/net6 U1148/net28 VDD pch W=0.205u L=0.04u
M_U1148/MI10 VDD N80 U1148/net44 VDD pch W=0.205u L=0.04u
M_U1148/MU25 VDD n1184 U1148/net6 VDD pch W=0.205u L=0.04u
M_U1149/MI15-M_u3 U1149/net28 U1149/net20 U1149/net64 VSS nch W=0.155u L=0.04u
M_U1149/MI8-M_u3 U1149/net24 U1149/net30 U1149/net32 VSS nch W=0.155u L=0.04u
M_U1149/MI17-M_u3 U1149/net28 U1149/net40 U1149/net24 VSS nch W=0.155u L=0.04u
M_U1149/MI11-M_u3 U1149/net40 n1249 U1149/net108 VSS nch W=0.155u L=0.04u
M_U1149/MI9-M_u3 U1149/net40 U1149/net106 U1149/net104 VSS nch W=0.155u L=0.04u
M_U1149/MI21 U1149/net24 n1125 U1149/net050 VSS nch W=0.155u L=0.04u
M_U1149/MI22 U1149/net050 U1149/net32 VSS VSS nch W=0.155u L=0.04u
M_U1149/MI19-M_u2 U1149/net20 U1149/net40 VSS VSS nch W=0.155u L=0.04u
M_U1149/MI13-M_u2 U1149/net106 n1249 VSS VSS nch W=0.155u L=0.04u
M_U1149/MI14-M_u2 U1149/net104 n1248 VSS VSS nch W=0.155u L=0.04u
M_U1149/M_u8-M_u2 U1149/net30 n1125 VSS VSS nch W=0.155u L=0.04u
M_U1149/MI12-M_u2 U1149/net108 U1149/net104 VSS VSS nch W=0.155u L=0.04u
M_U1149/MU20-M_u2 n1205 U1149/net28 VSS VSS nch W=0.155u L=0.04u
M_U1149/MI1-M_u2 U1149/net32 n1151 VSS VSS nch W=0.155u L=0.04u
M_U1149/MI16-M_u2 U1149/net64 U1149/net24 VSS VSS nch W=0.2u L=0.04u
M_U1149/MI15-M_u2 U1149/net28 U1149/net40 U1149/net64 VDD pch W=0.205u L=0.04u
M_U1149/MI8-M_u2 U1149/net24 n1125 U1149/net32 VDD pch W=0.205u L=0.04u
M_U1149/MI17-M_u2 U1149/net28 U1149/net20 U1149/net24 VDD pch W=0.205u L=0.04u
M_U1149/MI11-M_u2 U1149/net40 U1149/net106 U1149/net108 VDD pch W=0.205u L=0.04u
M_U1149/MI9-M_u2 U1149/net40 n1249 U1149/net104 VDD pch W=0.205u L=0.04u
M_U1149/MI19-M_u3 U1149/net20 U1149/net40 VDD VDD pch W=0.205u L=0.04u
M_U1149/MI13-M_u3 U1149/net106 n1249 VDD VDD pch W=0.205u L=0.04u
M_U1149/MI14-M_u3 U1149/net104 n1248 VDD VDD pch W=0.205u L=0.04u
M_U1149/M_u8-M_u3 U1149/net30 n1125 VDD VDD pch W=0.205u L=0.04u
M_U1149/MI12-M_u3 U1149/net108 U1149/net104 VDD VDD pch W=0.205u L=0.04u
M_U1149/MU20-M_u3 n1205 U1149/net28 VDD VDD pch W=0.205u L=0.04u
M_U1149/MI1-M_u3 U1149/net32 n1151 VDD VDD pch W=0.205u L=0.04u
M_U1149/MI16-M_u3 U1149/net64 U1149/net24 VDD VDD pch W=0.28u L=0.04u
M_U1149/MI20 U1149/net24 U1149/net30 U1149/net045 VDD pch W=0.205u L=0.04u
M_U1149/M_u2 U1149/net045 U1149/net32 VDD VDD pch W=0.205u L=0.04u
M_U1150/MI8-M_u3 U1150/net11 n1123 U1150/net17 VSS nch W=0.155u L=0.04u
M_U1150/MU11-M_u3 U1150/net5 U1150/net17 U1150/net21 VSS nch W=0.155u L=0.04u
M_U1150/MI5-M_u2 U1150/net5 n1250 VSS VSS nch W=0.155u L=0.04u
M_U1150/MU22-M_u2 n1249 U1150/net21 VSS VSS nch W=0.155u L=0.04u
M_U1150/M_u8-M_u2 U1150/net16 n1123 VSS VSS nch W=0.155u L=0.04u
M_U1150/MI4-M_u2 U1150/net11 n1156 VSS VSS nch W=0.155u L=0.04u
M_U1150/MI7-M_u2 U1150/net13 U1150/net17 VSS VSS nch W=0.155u L=0.04u
M_U1150/MI2-MU3 U1150/net17 U1150/net16 U1150/XI2-net16 VSS nch W=0.155u L=0.04u
M_U1150/MI2-MU4 U1150/XI2-net16 U1150/net11 VSS VSS nch W=0.155u L=0.04u
M_U1150/MU21-MU3 U1150/net21 U1150/net13 U1150/XU21-net16 VSS nch W=0.155u L=0.04u
M_U1150/MU21-MU4 U1150/XU21-net16 U1150/net5 VSS VSS nch W=0.155u L=0.04u
M_U1150/MI8-M_u2 U1150/net11 U1150/net16 U1150/net17 VDD pch W=0.205u L=0.04u
M_U1150/MU11-M_u2 U1150/net5 U1150/net13 U1150/net21 VDD pch W=0.205u L=0.04u
M_U1150/MI5-M_u3 U1150/net5 n1250 VDD VDD pch W=0.205u L=0.04u
M_U1150/MU22-M_u3 n1249 U1150/net21 VDD VDD pch W=0.205u L=0.04u
M_U1150/M_u8-M_u3 U1150/net16 n1123 VDD VDD pch W=0.205u L=0.04u
M_U1150/MI4-M_u3 U1150/net11 n1156 VDD VDD pch W=0.205u L=0.04u
M_U1150/MI7-M_u3 U1150/net13 U1150/net17 VDD VDD pch W=0.205u L=0.04u
M_U1150/MI2-MU2 U1150/net17 n1123 U1150/XI2-net6 VDD pch W=0.205u L=0.04u
M_U1150/MI2-MU1 U1150/XI2-net6 U1150/net11 VDD VDD pch W=0.205u L=0.04u
M_U1150/MU21-MU2 U1150/net21 U1150/net17 U1150/XU21-net6 VDD pch W=0.205u L=0.04u
M_U1150/MU21-MU1 U1150/XU21-net6 U1150/net5 VDD VDD pch W=0.205u L=0.04u
M_U1151/M_u2 n1250 n1251 U1151/net15 VSS nch W=0.155u L=0.04u
M_U1151/M_u3 n1250 n1184 U1151/net15 VSS nch W=0.155u L=0.04u
M_U1151/M_u4 U1151/net15 n1252 VSS VSS nch W=0.155u L=0.04u
M_U1151/M_u9 n1250 n1252 VDD VDD pch W=0.205u L=0.04u
M_U1151/MI16-MI12 n1250 n1251 U1151/XI16-net11 VDD pch W=0.205u L=0.04u
M_U1151/MI16-MI13 U1151/XI16-net11 n1184 VDD VDD pch W=0.205u L=0.04u
M_U1152/MI15-M_u2 U1152/net19 n1254 VSS VSS nch W=0.155u L=0.04u
M_U1152/MI21 n1252 n1254 U1152/net40 VSS nch W=0.155u L=0.04u
M_U1152/MI12 n1252 U1152/net19 U1152/net36 VSS nch W=0.155u L=0.04u
M_U1152/MI20 U1152/net40 n1253 VSS VSS nch W=0.31u L=0.04u
M_U1152/MI19 U1152/net36 n1149 VSS VSS nch W=0.155u L=0.04u
M_U1152/MI15-M_u3 U1152/net19 n1254 VDD VDD pch W=0.205u L=0.04u
M_U1152/MI25 n1252 U1152/net19 U1152/net26 VDD pch W=0.325u L=0.04u
M_U1152/MI24 U1152/net26 n1253 VDD VDD pch W=0.41u L=0.04u
M_U1152/MI5 n1252 n1254 U1152/net30 VDD pch W=0.325u L=0.04u
M_U1152/MI111 U1152/net30 n1149 VDD VDD pch W=0.205u L=0.04u
M_U1153/MU1-M_u4 n1253 N18 VSS VSS nch W=0.155u L=0.04u
M_U1153/MU1-M_u3 n1253 U1153/net4 VSS VSS nch W=0.155u L=0.04u
M_U1153/MU6-M_u2 U1153/net4 N70 VSS VSS nch W=0.155u L=0.04u
M_U1153/MU1-M_u1 U1153/XU1-net8 U1153/net4 VDD VDD pch W=0.205u L=0.04u
M_U1153/MU1-M_u2 n1253 N18 U1153/XU1-net8 VDD pch W=0.205u L=0.04u
M_U1153/MU6-M_u3 U1153/net4 N70 VDD VDD pch W=0.205u L=0.04u
M_U1154/MI1-M_u4 n1149 N70 VSS VSS nch W=0.155u L=0.04u
M_U1154/MI1-M_u3 n1149 N18 VSS VSS nch W=0.155u L=0.04u
M_U1154/MI1-M_u1 U1154/XI1-net8 N18 VDD VDD pch W=0.205u L=0.04u
M_U1154/MI1-M_u2 n1149 N70 U1154/XI1-net8 VDD pch W=0.205u L=0.04u
M_U1155/M_u6-M_u3 U1155/net4 U1155/net10 U1155/net14 VSS nch W=0.155u L=0.04u
M_U1155/MI3-M_u3 U1155/net6 n1254 U1155/net14 VSS nch W=0.155u L=0.04u
M_U1155/MI1-M_u2 U1155/net4 n1255 VSS VSS nch W=0.155u L=0.04u
M_U1155/M_u5-M_u2 U1155/net6 U1155/net4 VSS VSS nch W=0.155u L=0.04u
M_U1155/M_u4-M_u2 n1251 U1155/net14 VSS VSS nch W=0.155u L=0.04u
M_U1155/MI2-M_u2 U1155/net10 n1254 VSS VSS nch W=0.155u L=0.04u
M_U1155/M_u6-M_u2 U1155/net4 n1254 U1155/net14 VDD pch W=0.205u L=0.04u
M_U1155/MI3-M_u2 U1155/net6 U1155/net10 U1155/net14 VDD pch W=0.205u L=0.04u
M_U1155/MI1-M_u3 U1155/net4 n1255 VDD VDD pch W=0.205u L=0.04u
M_U1155/M_u5-M_u3 U1155/net6 U1155/net4 VDD VDD pch W=0.205u L=0.04u
M_U1155/M_u4-M_u3 n1251 U1155/net14 VDD VDD pch W=0.205u L=0.04u
M_U1155/MI2-M_u3 U1155/net10 n1254 VDD VDD pch W=0.205u L=0.04u
M_U1156/MI15-M_u2 U1156/net19 n1184 VSS VSS nch W=0.155u L=0.04u
M_U1156/MI21 n1254 n1184 U1156/net40 VSS nch W=0.155u L=0.04u
M_U1156/MI12 n1254 U1156/net19 U1156/net36 VSS nch W=0.155u L=0.04u
M_U1156/MI20 U1156/net40 N69 VSS VSS nch W=0.31u L=0.04u
M_U1156/MI19 U1156/net36 n1256 VSS VSS nch W=0.155u L=0.04u
M_U1156/MI15-M_u3 U1156/net19 n1184 VDD VDD pch W=0.205u L=0.04u
M_U1156/MI25 n1254 U1156/net19 U1156/net26 VDD pch W=0.325u L=0.04u
M_U1156/MI24 U1156/net26 N69 VDD VDD pch W=0.41u L=0.04u
M_U1156/MI5 n1254 n1184 U1156/net30 VDD pch W=0.325u L=0.04u
M_U1156/MI111 U1156/net30 n1256 VDD VDD pch W=0.205u L=0.04u
M_U1157/M_u2 n1256 N307 VSS VSS nch W=0.135u L=0.04u
M_U1157/M_u1 n1256 N307 VDD VDD pch W=0.205u L=0.04u
M_U1158/MI15-M_u2 U1158/net19 N18 VSS VSS nch W=0.155u L=0.04u
M_U1158/MI21 n1123 N18 U1158/net40 VSS nch W=0.155u L=0.04u
M_U1158/MI12 n1123 U1158/net19 U1158/net36 VSS nch W=0.155u L=0.04u
M_U1158/MI20 U1158/net40 n1257 VSS VSS nch W=0.31u L=0.04u
M_U1158/MI19 U1158/net36 N56 VSS VSS nch W=0.155u L=0.04u
M_U1158/MI15-M_u3 U1158/net19 N18 VDD VDD pch W=0.205u L=0.04u
M_U1158/MI25 n1123 U1158/net19 U1158/net26 VDD pch W=0.325u L=0.04u
M_U1158/MI24 U1158/net26 n1257 VDD VDD pch W=0.41u L=0.04u
M_U1158/MI5 n1123 N18 U1158/net30 VDD pch W=0.325u L=0.04u
M_U1158/MI111 U1158/net30 N56 VDD VDD pch W=0.205u L=0.04u
M_U1159/MI15-M_u2 U1159/net19 n1184 VSS VSS nch W=0.155u L=0.04u
M_U1159/MI21 n1156 n1184 U1159/net40 VSS nch W=0.155u L=0.04u
M_U1159/MI12 n1156 U1159/net19 U1159/net36 VSS nch W=0.155u L=0.04u
M_U1159/MI20 U1159/net40 N54 VSS VSS nch W=0.31u L=0.04u
M_U1159/MI19 U1159/net36 n1258 VSS VSS nch W=0.155u L=0.04u
M_U1159/MI15-M_u3 U1159/net19 n1184 VDD VDD pch W=0.205u L=0.04u
M_U1159/MI25 n1156 U1159/net19 U1159/net26 VDD pch W=0.325u L=0.04u
M_U1159/MI24 U1159/net26 N54 VDD VDD pch W=0.41u L=0.04u
M_U1159/MI5 n1156 n1184 U1159/net30 VDD pch W=0.325u L=0.04u
M_U1159/MI111 U1159/net30 n1258 VDD VDD pch W=0.205u L=0.04u
M_U1160/MI15-M_u3 U1160/net28 U1160/net20 U1160/net64 VSS nch W=0.155u L=0.04u
M_U1160/MI8-M_u3 U1160/net24 U1160/net30 U1160/net32 VSS nch W=0.155u L=0.04u
M_U1160/MI17-M_u3 U1160/net28 U1160/net40 U1160/net24 VSS nch W=0.155u L=0.04u
M_U1160/MI11-M_u3 U1160/net40 n1144 U1160/net108 VSS nch W=0.155u L=0.04u
M_U1160/MI9-M_u3 U1160/net40 U1160/net106 U1160/net104 VSS nch W=0.155u L=0.04u
M_U1160/MI21 U1160/net24 n1145 U1160/net050 VSS nch W=0.155u L=0.04u
M_U1160/MI22 U1160/net050 U1160/net32 VSS VSS nch W=0.155u L=0.04u
M_U1160/MI19-M_u2 U1160/net20 U1160/net40 VSS VSS nch W=0.155u L=0.04u
M_U1160/MI13-M_u2 U1160/net106 n1144 VSS VSS nch W=0.155u L=0.04u
M_U1160/MI14-M_u2 U1160/net104 n1130 VSS VSS nch W=0.155u L=0.04u
M_U1160/M_u8-M_u2 U1160/net30 n1145 VSS VSS nch W=0.155u L=0.04u
M_U1160/MI12-M_u2 U1160/net108 U1160/net104 VSS VSS nch W=0.155u L=0.04u
M_U1160/MU20-M_u2 n1248 U1160/net28 VSS VSS nch W=0.155u L=0.04u
M_U1160/MI1-M_u2 U1160/net32 n1139 VSS VSS nch W=0.155u L=0.04u
M_U1160/MI16-M_u2 U1160/net64 U1160/net24 VSS VSS nch W=0.2u L=0.04u
M_U1160/MI15-M_u2 U1160/net28 U1160/net40 U1160/net64 VDD pch W=0.205u L=0.04u
M_U1160/MI8-M_u2 U1160/net24 n1145 U1160/net32 VDD pch W=0.205u L=0.04u
M_U1160/MI17-M_u2 U1160/net28 U1160/net20 U1160/net24 VDD pch W=0.205u L=0.04u
M_U1160/MI11-M_u2 U1160/net40 U1160/net106 U1160/net108 VDD pch W=0.205u L=0.04u
M_U1160/MI9-M_u2 U1160/net40 n1144 U1160/net104 VDD pch W=0.205u L=0.04u
M_U1160/MI19-M_u3 U1160/net20 U1160/net40 VDD VDD pch W=0.205u L=0.04u
M_U1160/MI13-M_u3 U1160/net106 n1144 VDD VDD pch W=0.205u L=0.04u
M_U1160/MI14-M_u3 U1160/net104 n1130 VDD VDD pch W=0.205u L=0.04u
M_U1160/M_u8-M_u3 U1160/net30 n1145 VDD VDD pch W=0.205u L=0.04u
M_U1160/MI12-M_u3 U1160/net108 U1160/net104 VDD VDD pch W=0.205u L=0.04u
M_U1160/MU20-M_u3 n1248 U1160/net28 VDD VDD pch W=0.205u L=0.04u
M_U1160/MI1-M_u3 U1160/net32 n1139 VDD VDD pch W=0.205u L=0.04u
M_U1160/MI16-M_u3 U1160/net64 U1160/net24 VDD VDD pch W=0.28u L=0.04u
M_U1160/MI20 U1160/net24 U1160/net30 U1160/net045 VDD pch W=0.205u L=0.04u
M_U1160/M_u2 U1160/net045 U1160/net32 VDD VDD pch W=0.205u L=0.04u
M_U1161/MI15-M_u2 U1161/net19 N18 VSS VSS nch W=0.155u L=0.04u
M_U1161/MI21 n1144 N18 U1161/net40 VSS nch W=0.155u L=0.04u
M_U1161/MI12 n1144 U1161/net19 U1161/net36 VSS nch W=0.155u L=0.04u
M_U1161/MI20 U1161/net40 n1259 VSS VSS nch W=0.31u L=0.04u
M_U1161/MI19 U1161/net36 N74 VSS VSS nch W=0.155u L=0.04u
M_U1161/MI15-M_u3 U1161/net19 N18 VDD VDD pch W=0.205u L=0.04u
M_U1161/MI25 n1144 U1161/net19 U1161/net26 VDD pch W=0.325u L=0.04u
M_U1161/MI24 U1161/net26 n1259 VDD VDD pch W=0.41u L=0.04u
M_U1161/MI5 n1144 N18 U1161/net30 VDD pch W=0.325u L=0.04u
M_U1161/MI111 U1161/net30 N74 VDD VDD pch W=0.205u L=0.04u
M_U1162/MI15-M_u2 U1162/net19 N18 VSS VSS nch W=0.155u L=0.04u
M_U1162/MI21 n1130 N18 U1162/net40 VSS nch W=0.155u L=0.04u
M_U1162/MI12 n1130 U1162/net19 U1162/net36 VSS nch W=0.155u L=0.04u
M_U1162/MI20 U1162/net40 n1260 VSS VSS nch W=0.31u L=0.04u
M_U1162/MI19 U1162/net36 N73 VSS VSS nch W=0.155u L=0.04u
M_U1162/MI15-M_u3 U1162/net19 N18 VDD VDD pch W=0.205u L=0.04u
M_U1162/MI25 n1130 U1162/net19 U1162/net26 VDD pch W=0.325u L=0.04u
M_U1162/MI24 U1162/net26 n1260 VDD VDD pch W=0.41u L=0.04u
M_U1162/MI5 n1130 N18 U1162/net30 VDD pch W=0.325u L=0.04u
M_U1162/MI111 U1162/net30 N73 VDD VDD pch W=0.205u L=0.04u
M_U1163/M_u2 n1260 N322 VSS VSS nch W=0.135u L=0.04u
M_U1163/M_u1 n1260 N322 VDD VDD pch W=0.205u L=0.04u
M_U1164/MI15-M_u2 U1164/net19 n1184 VSS VSS nch W=0.155u L=0.04u
M_U1164/MI21 n1139 n1184 U1164/net40 VSS nch W=0.155u L=0.04u
M_U1164/MI12 n1139 U1164/net19 U1164/net36 VSS nch W=0.155u L=0.04u
M_U1164/MI20 U1164/net40 N75 VSS VSS nch W=0.31u L=0.04u
M_U1164/MI19 U1164/net36 n1261 VSS VSS nch W=0.155u L=0.04u
M_U1164/MI15-M_u3 U1164/net19 n1184 VDD VDD pch W=0.205u L=0.04u
M_U1164/MI25 n1139 U1164/net19 U1164/net26 VDD pch W=0.325u L=0.04u
M_U1164/MI24 U1164/net26 N75 VDD VDD pch W=0.41u L=0.04u
M_U1164/MI5 n1139 n1184 U1164/net30 VDD pch W=0.325u L=0.04u
M_U1164/MI111 U1164/net30 n1261 VDD VDD pch W=0.205u L=0.04u
M_U1165/M_u2 n1261 N319 VSS VSS nch W=0.135u L=0.04u
M_U1165/M_u1 n1261 N319 VDD VDD pch W=0.205u L=0.04u
M_U1166/MI15-M_u2 U1166/net19 N18 VSS VSS nch W=0.155u L=0.04u
M_U1166/MI21 n1145 N18 U1166/net40 VSS nch W=0.155u L=0.04u
M_U1166/MI12 n1145 U1166/net19 U1166/net36 VSS nch W=0.155u L=0.04u
M_U1166/MI20 U1166/net40 n1262 VSS VSS nch W=0.31u L=0.04u
M_U1166/MI19 U1166/net36 N76 VSS VSS nch W=0.155u L=0.04u
M_U1166/MI15-M_u3 U1166/net19 N18 VDD VDD pch W=0.205u L=0.04u
M_U1166/MI25 n1145 U1166/net19 U1166/net26 VDD pch W=0.325u L=0.04u
M_U1166/MI24 U1166/net26 n1262 VDD VDD pch W=0.41u L=0.04u
M_U1166/MI5 n1145 N18 U1166/net30 VDD pch W=0.325u L=0.04u
M_U1166/MI111 U1166/net30 N76 VDD VDD pch W=0.205u L=0.04u
M_U1167/M_u2 n1262 N316 VSS VSS nch W=0.135u L=0.04u
M_U1167/M_u1 n1262 N316 VDD VDD pch W=0.205u L=0.04u
M_U1168/M_u2 n1151 n1121 VSS VSS nch W=0.135u L=0.04u
M_U1168/M_u1 n1151 n1121 VDD VDD pch W=0.205u L=0.04u
M_U1169/MI15-M_u2 U1169/net19 N18 VSS VSS nch W=0.155u L=0.04u
M_U1169/MI21 n1121 N18 U1169/net40 VSS nch W=0.155u L=0.04u
M_U1169/MI12 n1121 U1169/net19 U1169/net36 VSS nch W=0.155u L=0.04u
M_U1169/MI20 U1169/net40 n1263 VSS VSS nch W=0.31u L=0.04u
M_U1169/MI19 U1169/net36 N55 VSS VSS nch W=0.155u L=0.04u
M_U1169/MI15-M_u3 U1169/net19 N18 VDD VDD pch W=0.205u L=0.04u
M_U1169/MI25 n1121 U1169/net19 U1169/net26 VDD pch W=0.325u L=0.04u
M_U1169/MI24 U1169/net26 n1263 VDD VDD pch W=0.41u L=0.04u
M_U1169/MI5 n1121 N18 U1169/net30 VDD pch W=0.325u L=0.04u
M_U1169/MI111 U1169/net30 N55 VDD VDD pch W=0.205u L=0.04u
M_U1170/M_u2 n1263 N331 VSS VSS nch W=0.135u L=0.04u
M_U1170/M_u1 n1263 N331 VDD VDD pch W=0.205u L=0.04u
M_U1171/MI15-M_u2 U1171/net19 N18 VSS VSS nch W=0.155u L=0.04u
M_U1171/MI21 n1125 N18 U1171/net40 VSS nch W=0.155u L=0.04u
M_U1171/MI12 n1125 U1171/net19 U1171/net36 VSS nch W=0.155u L=0.04u
M_U1171/MI20 U1171/net40 n1264 VSS VSS nch W=0.31u L=0.04u
M_U1171/MI19 U1171/net36 N53 VSS VSS nch W=0.155u L=0.04u
M_U1171/MI15-M_u3 U1171/net19 N18 VDD VDD pch W=0.205u L=0.04u
M_U1171/MI25 n1125 U1171/net19 U1171/net26 VDD pch W=0.325u L=0.04u
M_U1171/MI24 U1171/net26 n1264 VDD VDD pch W=0.41u L=0.04u
M_U1171/MI5 n1125 N18 U1171/net30 VDD pch W=0.325u L=0.04u
M_U1171/MI111 U1171/net30 N53 VDD VDD pch W=0.205u L=0.04u
M_U1172/MI19 U1172/p2 n1268 VSS VSS nch W=0.155u L=0.04u
M_U1172/MI17 U1172/p0 n1266 U1172/p1 VSS nch W=0.155u L=0.04u
M_U1172/MI18 U1172/p1 n1267 U1172/p2 VSS nch W=0.155u L=0.04u
M_U1172/MU53 N10574 n1265 U1172/p0 VSS nch W=0.155u L=0.04u
M_U1172/MI14 N10574 n1267 VDD VDD pch W=0.205u L=0.04u
M_U1172/MI15 N10574 n1266 VDD VDD pch W=0.205u L=0.04u
M_U1172/MI16 N10574 n1265 VDD VDD pch W=0.205u L=0.04u
M_U1172/MI9 N10574 n1268 VDD VDD pch W=0.205u L=0.04u
M_U1173/MI8-M_u3 U1173/net11 n1270 U1173/net17 VSS nch W=0.155u L=0.04u
M_U1173/MU11-M_u3 U1173/net5 U1173/net17 U1173/net21 VSS nch W=0.155u L=0.04u
M_U1173/MI5-M_u2 U1173/net5 n1271 VSS VSS nch W=0.155u L=0.04u
M_U1173/MU22-M_u2 n1268 U1173/net21 VSS VSS nch W=0.155u L=0.04u
M_U1173/M_u8-M_u2 U1173/net16 n1270 VSS VSS nch W=0.155u L=0.04u
M_U1173/MI4-M_u2 U1173/net11 n1269 VSS VSS nch W=0.155u L=0.04u
M_U1173/MI7-M_u2 U1173/net13 U1173/net17 VSS VSS nch W=0.155u L=0.04u
M_U1173/MI2-MU3 U1173/net17 U1173/net16 U1173/XI2-net16 VSS nch W=0.155u L=0.04u
M_U1173/MI2-MU4 U1173/XI2-net16 U1173/net11 VSS VSS nch W=0.155u L=0.04u
M_U1173/MU21-MU3 U1173/net21 U1173/net13 U1173/XU21-net16 VSS nch W=0.155u L=0.04u
M_U1173/MU21-MU4 U1173/XU21-net16 U1173/net5 VSS VSS nch W=0.155u L=0.04u
M_U1173/MI8-M_u2 U1173/net11 U1173/net16 U1173/net17 VDD pch W=0.205u L=0.04u
M_U1173/MU11-M_u2 U1173/net5 U1173/net13 U1173/net21 VDD pch W=0.205u L=0.04u
M_U1173/MI5-M_u3 U1173/net5 n1271 VDD VDD pch W=0.205u L=0.04u
M_U1173/MU22-M_u3 n1268 U1173/net21 VDD VDD pch W=0.205u L=0.04u
M_U1173/M_u8-M_u3 U1173/net16 n1270 VDD VDD pch W=0.205u L=0.04u
M_U1173/MI4-M_u3 U1173/net11 n1269 VDD VDD pch W=0.205u L=0.04u
M_U1173/MI7-M_u3 U1173/net13 U1173/net17 VDD VDD pch W=0.205u L=0.04u
M_U1173/MI2-MU2 U1173/net17 n1270 U1173/XI2-net6 VDD pch W=0.205u L=0.04u
M_U1173/MI2-MU1 U1173/XI2-net6 U1173/net11 VDD VDD pch W=0.205u L=0.04u
M_U1173/MU21-MU2 U1173/net21 U1173/net17 U1173/XU21-net6 VDD pch W=0.205u L=0.04u
M_U1173/MU21-MU1 U1173/XU21-net6 U1173/net5 VDD VDD pch W=0.205u L=0.04u
M_U1174/MI15-M_u3 U1174/net28 U1174/net20 U1174/net64 VSS nch W=0.155u L=0.04u
M_U1174/MI8-M_u3 U1174/net24 U1174/net30 U1174/net32 VSS nch W=0.155u L=0.04u
M_U1174/MI17-M_u3 U1174/net28 U1174/net40 U1174/net24 VSS nch W=0.155u L=0.04u
M_U1174/MI11-M_u3 U1174/net40 n1275 U1174/net108 VSS nch W=0.155u L=0.04u
M_U1174/MI9-M_u3 U1174/net40 U1174/net106 U1174/net104 VSS nch W=0.155u L=0.04u
M_U1174/MI21 U1174/net24 n1272 U1174/net050 VSS nch W=0.155u L=0.04u
M_U1174/MI22 U1174/net050 U1174/net32 VSS VSS nch W=0.155u L=0.04u
M_U1174/MI19-M_u2 U1174/net20 U1174/net40 VSS VSS nch W=0.155u L=0.04u
M_U1174/MI13-M_u2 U1174/net106 n1275 VSS VSS nch W=0.155u L=0.04u
M_U1174/MI14-M_u2 U1174/net104 n1274 VSS VSS nch W=0.155u L=0.04u
M_U1174/M_u8-M_u2 U1174/net30 n1272 VSS VSS nch W=0.155u L=0.04u
M_U1174/MI12-M_u2 U1174/net108 U1174/net104 VSS VSS nch W=0.155u L=0.04u
M_U1174/MU20-M_u2 n1270 U1174/net28 VSS VSS nch W=0.155u L=0.04u
M_U1174/MI1-M_u2 U1174/net32 n1273 VSS VSS nch W=0.155u L=0.04u
M_U1174/MI16-M_u2 U1174/net64 U1174/net24 VSS VSS nch W=0.2u L=0.04u
M_U1174/MI15-M_u2 U1174/net28 U1174/net40 U1174/net64 VDD pch W=0.205u L=0.04u
M_U1174/MI8-M_u2 U1174/net24 n1272 U1174/net32 VDD pch W=0.205u L=0.04u
M_U1174/MI17-M_u2 U1174/net28 U1174/net20 U1174/net24 VDD pch W=0.205u L=0.04u
M_U1174/MI11-M_u2 U1174/net40 U1174/net106 U1174/net108 VDD pch W=0.205u L=0.04u
M_U1174/MI9-M_u2 U1174/net40 n1275 U1174/net104 VDD pch W=0.205u L=0.04u
M_U1174/MI19-M_u3 U1174/net20 U1174/net40 VDD VDD pch W=0.205u L=0.04u
M_U1174/MI13-M_u3 U1174/net106 n1275 VDD VDD pch W=0.205u L=0.04u
M_U1174/MI14-M_u3 U1174/net104 n1274 VDD VDD pch W=0.205u L=0.04u
M_U1174/M_u8-M_u3 U1174/net30 n1272 VDD VDD pch W=0.205u L=0.04u
M_U1174/MI12-M_u3 U1174/net108 U1174/net104 VDD VDD pch W=0.205u L=0.04u
M_U1174/MU20-M_u3 n1270 U1174/net28 VDD VDD pch W=0.205u L=0.04u
M_U1174/MI1-M_u3 U1174/net32 n1273 VDD VDD pch W=0.205u L=0.04u
M_U1174/MI16-M_u3 U1174/net64 U1174/net24 VDD VDD pch W=0.28u L=0.04u
M_U1174/MI20 U1174/net24 U1174/net30 U1174/net045 VDD pch W=0.205u L=0.04u
M_U1174/M_u2 U1174/net045 U1174/net32 VDD VDD pch W=0.205u L=0.04u
M_U1175/MI15-M_u3 U1175/net28 U1175/net20 U1175/net64 VSS nch W=0.155u L=0.04u
M_U1175/MI8-M_u3 U1175/net24 U1175/net30 U1175/net32 VSS nch W=0.155u L=0.04u
M_U1175/MI17-M_u3 U1175/net28 U1175/net40 U1175/net24 VSS nch W=0.155u L=0.04u
M_U1175/MI11-M_u3 U1175/net40 n1279 U1175/net108 VSS nch W=0.155u L=0.04u
M_U1175/MI9-M_u3 U1175/net40 U1175/net106 U1175/net104 VSS nch W=0.155u L=0.04u
M_U1175/MI21 U1175/net24 n1276 U1175/net050 VSS nch W=0.155u L=0.04u
M_U1175/MI22 U1175/net050 U1175/net32 VSS VSS nch W=0.155u L=0.04u
M_U1175/MI19-M_u2 U1175/net20 U1175/net40 VSS VSS nch W=0.155u L=0.04u
M_U1175/MI13-M_u2 U1175/net106 n1279 VSS VSS nch W=0.155u L=0.04u
M_U1175/MI14-M_u2 U1175/net104 n1278 VSS VSS nch W=0.155u L=0.04u
M_U1175/M_u8-M_u2 U1175/net30 n1276 VSS VSS nch W=0.155u L=0.04u
M_U1175/MI12-M_u2 U1175/net108 U1175/net104 VSS VSS nch W=0.155u L=0.04u
M_U1175/MU20-M_u2 n1269 U1175/net28 VSS VSS nch W=0.155u L=0.04u
M_U1175/MI1-M_u2 U1175/net32 n1277 VSS VSS nch W=0.155u L=0.04u
M_U1175/MI16-M_u2 U1175/net64 U1175/net24 VSS VSS nch W=0.2u L=0.04u
M_U1175/MI15-M_u2 U1175/net28 U1175/net40 U1175/net64 VDD pch W=0.205u L=0.04u
M_U1175/MI8-M_u2 U1175/net24 n1276 U1175/net32 VDD pch W=0.205u L=0.04u
M_U1175/MI17-M_u2 U1175/net28 U1175/net20 U1175/net24 VDD pch W=0.205u L=0.04u
M_U1175/MI11-M_u2 U1175/net40 U1175/net106 U1175/net108 VDD pch W=0.205u L=0.04u
M_U1175/MI9-M_u2 U1175/net40 n1279 U1175/net104 VDD pch W=0.205u L=0.04u
M_U1175/MI19-M_u3 U1175/net20 U1175/net40 VDD VDD pch W=0.205u L=0.04u
M_U1175/MI13-M_u3 U1175/net106 n1279 VDD VDD pch W=0.205u L=0.04u
M_U1175/MI14-M_u3 U1175/net104 n1278 VDD VDD pch W=0.205u L=0.04u
M_U1175/M_u8-M_u3 U1175/net30 n1276 VDD VDD pch W=0.205u L=0.04u
M_U1175/MI12-M_u3 U1175/net108 U1175/net104 VDD VDD pch W=0.205u L=0.04u
M_U1175/MU20-M_u3 n1269 U1175/net28 VDD VDD pch W=0.205u L=0.04u
M_U1175/MI1-M_u3 U1175/net32 n1277 VDD VDD pch W=0.205u L=0.04u
M_U1175/MI16-M_u3 U1175/net64 U1175/net24 VDD VDD pch W=0.28u L=0.04u
M_U1175/MI20 U1175/net24 U1175/net30 U1175/net045 VDD pch W=0.205u L=0.04u
M_U1175/M_u2 U1175/net045 U1175/net32 VDD VDD pch W=0.205u L=0.04u
M_U1176/MI15-M_u2 U1176/net19 N18 VSS VSS nch W=0.155u L=0.04u
M_U1176/MI21 n1279 N18 U1176/net40 VSS nch W=0.155u L=0.04u
M_U1176/MI12 n1279 U1176/net19 U1176/net36 VSS nch W=0.155u L=0.04u
M_U1176/MI20 U1176/net40 n1281 VSS VSS nch W=0.31u L=0.04u
M_U1176/MI19 U1176/net36 n1280 VSS VSS nch W=0.155u L=0.04u
M_U1176/MI15-M_u3 U1176/net19 N18 VDD VDD pch W=0.205u L=0.04u
M_U1176/MI25 n1279 U1176/net19 U1176/net26 VDD pch W=0.325u L=0.04u
M_U1176/MI24 U1176/net26 n1281 VDD VDD pch W=0.41u L=0.04u
M_U1176/MI5 n1279 N18 U1176/net30 VDD pch W=0.325u L=0.04u
M_U1176/MI111 U1176/net30 n1280 VDD VDD pch W=0.205u L=0.04u
M_U1177/MI0-M_u3 U1177/net4 N161 U1177/net14 VSS nch W=0.155u L=0.04u
M_U1177/M_u7-M_u3 U1177/net6 U1177/net10 U1177/net14 VSS nch W=0.17u L=0.04u
M_U1177/M_u2-M_u2 U1177/net4 n1282 VSS VSS nch W=0.155u L=0.04u
M_U1177/M_u5-M_u2 U1177/net6 U1177/net4 VSS VSS nch W=0.17u L=0.04u
M_U1177/M_u4-M_u2 n1281 U1177/net14 VSS VSS nch W=0.155u L=0.04u
M_U1177/M_u8-M_u2 U1177/net10 N161 VSS VSS nch W=0.155u L=0.04u
M_U1177/MI0-M_u2 U1177/net4 U1177/net10 U1177/net14 VDD pch W=0.255u L=0.04u
M_U1177/M_u7-M_u2 U1177/net6 N161 U1177/net14 VDD pch W=0.28u L=0.04u
M_U1177/M_u2-M_u3 U1177/net4 n1282 VDD VDD pch W=0.205u L=0.04u
M_U1177/M_u5-M_u3 U1177/net6 U1177/net4 VDD VDD pch W=0.24u L=0.04u
M_U1177/M_u4-M_u3 n1281 U1177/net14 VDD VDD pch W=0.205u L=0.04u
M_U1177/M_u8-M_u3 U1177/net10 N161 VDD VDD pch W=0.205u L=0.04u
M_U1178/MI0-M_u3 U1178/net4 n1282 U1178/net14 VSS nch W=0.155u L=0.04u
M_U1178/M_u7-M_u3 U1178/net6 U1178/net10 U1178/net14 VSS nch W=0.17u L=0.04u
M_U1178/M_u2-M_u2 U1178/net4 N141 VSS VSS nch W=0.155u L=0.04u
M_U1178/M_u5-M_u2 U1178/net6 U1178/net4 VSS VSS nch W=0.17u L=0.04u
M_U1178/M_u4-M_u2 n1280 U1178/net14 VSS VSS nch W=0.155u L=0.04u
M_U1178/M_u8-M_u2 U1178/net10 n1282 VSS VSS nch W=0.155u L=0.04u
M_U1178/MI0-M_u2 U1178/net4 U1178/net10 U1178/net14 VDD pch W=0.255u L=0.04u
M_U1178/M_u7-M_u2 U1178/net6 n1282 U1178/net14 VDD pch W=0.28u L=0.04u
M_U1178/M_u2-M_u3 U1178/net4 N141 VDD VDD pch W=0.205u L=0.04u
M_U1178/M_u5-M_u3 U1178/net6 U1178/net4 VDD VDD pch W=0.24u L=0.04u
M_U1178/M_u4-M_u3 n1280 U1178/net14 VDD VDD pch W=0.205u L=0.04u
M_U1178/M_u8-M_u3 U1178/net10 n1282 VDD VDD pch W=0.205u L=0.04u
M_U1179/MI15 U1179/net29 U1179/net21 U1179/net041 VSS nch W=0.155u L=0.04u
M_U1179/MU63 U1179/net035 U1179/net19 VSS VSS nch W=0.155u L=0.04u
M_U1179/MI14 U1179/net041 U1179/net13 VSS VSS nch W=0.155u L=0.04u
M_U1179/MI42 U1179/net25 n1284 U1179/net035 VSS nch W=0.155u L=0.04u
M_U1179/M_u6-M_u3 U1179/net19 U1179/net17 U1179/net25 VSS nch W=0.155u L=0.04u
M_U1179/MU18-M_u3 U1179/net13 U1179/net25 U1179/net29 VSS nch W=0.155u L=0.04u
M_U1179/MI1-M_u2 n1267 U1179/net29 VSS VSS nch W=0.155u L=0.04u
M_U1179/MI3-M_u2 U1179/net13 n1285 VSS VSS nch W=0.155u L=0.04u
M_U1179/MI7-M_u2 U1179/net17 n1284 VSS VSS nch W=0.155u L=0.04u
M_U1179/MI2-M_u2 U1179/net19 n1283 VSS VSS nch W=0.155u L=0.04u
M_U1179/MI6-M_u2 U1179/net21 U1179/net25 VSS VSS nch W=0.155u L=0.04u
M_U1179/MU62 U1179/net028 U1179/net19 VDD VDD pch W=0.205u L=0.04u
M_U1179/MI8 U1179/net25 U1179/net17 U1179/net028 VDD pch W=0.205u L=0.04u
M_U1179/MI12 U1179/net29 U1179/net25 U1179/net029 VDD pch W=0.205u L=0.04u
M_U1179/MI13 U1179/net029 U1179/net13 VDD VDD pch W=0.205u L=0.04u
M_U1179/M_u6-M_u2 U1179/net19 n1284 U1179/net25 VDD pch W=0.205u L=0.04u
M_U1179/MU18-M_u2 U1179/net13 U1179/net21 U1179/net29 VDD pch W=0.205u L=0.04u
M_U1179/MI1-M_u3 n1267 U1179/net29 VDD VDD pch W=0.205u L=0.04u
M_U1179/MI3-M_u3 U1179/net13 n1285 VDD VDD pch W=0.205u L=0.04u
M_U1179/MI7-M_u3 U1179/net17 n1284 VDD VDD pch W=0.205u L=0.04u
M_U1179/MI2-M_u3 U1179/net19 n1283 VDD VDD pch W=0.205u L=0.04u
M_U1179/MI6-M_u3 U1179/net21 U1179/net25 VDD VDD pch W=0.205u L=0.04u
M_U1180/MI15-M_u3 U1180/net28 U1180/net20 U1180/net64 VSS nch W=0.155u L=0.04u
M_U1180/MI8-M_u3 U1180/net24 U1180/net30 U1180/net32 VSS nch W=0.155u L=0.04u
M_U1180/MI17-M_u3 U1180/net28 U1180/net40 U1180/net24 VSS nch W=0.155u L=0.04u
M_U1180/MI11-M_u3 U1180/net40 n1289 U1180/net108 VSS nch W=0.155u L=0.04u
M_U1180/MI9-M_u3 U1180/net40 U1180/net106 U1180/net104 VSS nch W=0.155u L=0.04u
M_U1180/MI21 U1180/net24 n1286 U1180/net050 VSS nch W=0.155u L=0.04u
M_U1180/MI22 U1180/net050 U1180/net32 VSS VSS nch W=0.155u L=0.04u
M_U1180/MI19-M_u2 U1180/net20 U1180/net40 VSS VSS nch W=0.155u L=0.04u
M_U1180/MI13-M_u2 U1180/net106 n1289 VSS VSS nch W=0.155u L=0.04u
M_U1180/MI14-M_u2 U1180/net104 n1288 VSS VSS nch W=0.155u L=0.04u
M_U1180/M_u8-M_u2 U1180/net30 n1286 VSS VSS nch W=0.155u L=0.04u
M_U1180/MI12-M_u2 U1180/net108 U1180/net104 VSS VSS nch W=0.155u L=0.04u
M_U1180/MU20-M_u2 n1284 U1180/net28 VSS VSS nch W=0.155u L=0.04u
M_U1180/MI1-M_u2 U1180/net32 n1287 VSS VSS nch W=0.155u L=0.04u
M_U1180/MI16-M_u2 U1180/net64 U1180/net24 VSS VSS nch W=0.2u L=0.04u
M_U1180/MI15-M_u2 U1180/net28 U1180/net40 U1180/net64 VDD pch W=0.205u L=0.04u
M_U1180/MI8-M_u2 U1180/net24 n1286 U1180/net32 VDD pch W=0.205u L=0.04u
M_U1180/MI17-M_u2 U1180/net28 U1180/net20 U1180/net24 VDD pch W=0.205u L=0.04u
M_U1180/MI11-M_u2 U1180/net40 U1180/net106 U1180/net108 VDD pch W=0.205u L=0.04u
M_U1180/MI9-M_u2 U1180/net40 n1289 U1180/net104 VDD pch W=0.205u L=0.04u
M_U1180/MI19-M_u3 U1180/net20 U1180/net40 VDD VDD pch W=0.205u L=0.04u
M_U1180/MI13-M_u3 U1180/net106 n1289 VDD VDD pch W=0.205u L=0.04u
M_U1180/MI14-M_u3 U1180/net104 n1288 VDD VDD pch W=0.205u L=0.04u
M_U1180/M_u8-M_u3 U1180/net30 n1286 VDD VDD pch W=0.205u L=0.04u
M_U1180/MI12-M_u3 U1180/net108 U1180/net104 VDD VDD pch W=0.205u L=0.04u
M_U1180/MU20-M_u3 n1284 U1180/net28 VDD VDD pch W=0.205u L=0.04u
M_U1180/MI1-M_u3 U1180/net32 n1287 VDD VDD pch W=0.205u L=0.04u
M_U1180/MI16-M_u3 U1180/net64 U1180/net24 VDD VDD pch W=0.28u L=0.04u
M_U1180/MI20 U1180/net24 U1180/net30 U1180/net045 VDD pch W=0.205u L=0.04u
M_U1180/M_u2 U1180/net045 U1180/net32 VDD VDD pch W=0.205u L=0.04u
M_U1181/M_u2 n1287 n1290 U1181/net15 VSS nch W=0.155u L=0.04u
M_U1181/M_u3 n1287 n1184 U1181/net15 VSS nch W=0.155u L=0.04u
M_U1181/M_u4 U1181/net15 n1291 VSS VSS nch W=0.155u L=0.04u
M_U1181/M_u9 n1287 n1291 VDD VDD pch W=0.205u L=0.04u
M_U1181/MI16-MI12 n1287 n1290 U1181/XI16-net11 VDD pch W=0.205u L=0.04u
M_U1181/MI16-MI13 U1181/XI16-net11 n1184 VDD VDD pch W=0.205u L=0.04u
M_U1182/MI15-M_u2 U1182/net19 N44 VSS VSS nch W=0.155u L=0.04u
M_U1182/MI21 n1291 N44 U1182/net40 VSS nch W=0.155u L=0.04u
M_U1182/MI12 n1291 U1182/net19 U1182/net36 VSS nch W=0.155u L=0.04u
M_U1182/MI20 U1182/net40 n1293 VSS VSS nch W=0.31u L=0.04u
M_U1182/MI19 U1182/net36 n1292 VSS VSS nch W=0.155u L=0.04u
M_U1182/MI15-M_u3 U1182/net19 N44 VDD VDD pch W=0.205u L=0.04u
M_U1182/MI25 n1291 U1182/net19 U1182/net26 VDD pch W=0.325u L=0.04u
M_U1182/MI24 U1182/net26 n1293 VDD VDD pch W=0.41u L=0.04u
M_U1182/MI5 n1291 N44 U1182/net30 VDD pch W=0.325u L=0.04u
M_U1182/MI111 U1182/net30 n1292 VDD VDD pch W=0.205u L=0.04u
M_U1183/M_u3-M_u2 n1293 U1183/net6 VSS VSS nch W=0.155u L=0.04u
M_U1183/M_u2-M_u4 U1183/X_u2-net6 n1184 VSS VSS nch W=0.155u L=0.04u
M_U1183/M_u2-M_u3 U1183/net6 n1294 U1183/X_u2-net6 VSS nch W=0.155u L=0.04u
M_U1183/M_u3-M_u3 n1293 U1183/net6 VDD VDD pch W=0.205u L=0.04u
M_U1183/M_u2-M_u2 U1183/net6 n1184 VDD VDD pch W=0.205u L=0.04u
M_U1183/M_u2-M_u1 U1183/net6 n1294 VDD VDD pch W=0.205u L=0.04u
M_U1184/M_u6-M_u3 U1184/net4 U1184/net10 U1184/net14 VSS nch W=0.155u L=0.04u
M_U1184/MI3-M_u3 U1184/net6 N239 U1184/net14 VSS nch W=0.155u L=0.04u
M_U1184/MI1-M_u2 U1184/net4 n1294 VSS VSS nch W=0.155u L=0.04u
M_U1184/M_u5-M_u2 U1184/net6 U1184/net4 VSS VSS nch W=0.155u L=0.04u
M_U1184/M_u4-M_u2 n1290 U1184/net14 VSS VSS nch W=0.155u L=0.04u
M_U1184/MI2-M_u2 U1184/net10 N239 VSS VSS nch W=0.155u L=0.04u
M_U1184/M_u6-M_u2 U1184/net4 N239 U1184/net14 VDD pch W=0.205u L=0.04u
M_U1184/MI3-M_u2 U1184/net6 U1184/net10 U1184/net14 VDD pch W=0.205u L=0.04u
M_U1184/MI1-M_u3 U1184/net4 n1294 VDD VDD pch W=0.205u L=0.04u
M_U1184/M_u5-M_u3 U1184/net6 U1184/net4 VDD VDD pch W=0.205u L=0.04u
M_U1184/M_u4-M_u3 n1290 U1184/net14 VDD VDD pch W=0.205u L=0.04u
M_U1184/MI2-M_u3 U1184/net10 N239 VDD VDD pch W=0.205u L=0.04u
M_U1185/MI15-M_u3 U1185/net28 U1185/net20 U1185/net64 VSS nch W=0.155u L=0.04u
M_U1185/MI8-M_u3 U1185/net24 U1185/net30 U1185/net32 VSS nch W=0.155u L=0.04u
M_U1185/MI17-M_u3 U1185/net28 U1185/net40 U1185/net24 VSS nch W=0.155u L=0.04u
M_U1185/MI11-M_u3 U1185/net40 n1298 U1185/net108 VSS nch W=0.155u L=0.04u
M_U1185/MI9-M_u3 U1185/net40 U1185/net106 U1185/net104 VSS nch W=0.155u L=0.04u
M_U1185/MI21 U1185/net24 n1295 U1185/net050 VSS nch W=0.155u L=0.04u
M_U1185/MI22 U1185/net050 U1185/net32 VSS VSS nch W=0.155u L=0.04u
M_U1185/MI19-M_u2 U1185/net20 U1185/net40 VSS VSS nch W=0.155u L=0.04u
M_U1185/MI13-M_u2 U1185/net106 n1298 VSS VSS nch W=0.155u L=0.04u
M_U1185/MI14-M_u2 U1185/net104 n1297 VSS VSS nch W=0.155u L=0.04u
M_U1185/M_u8-M_u2 U1185/net30 n1295 VSS VSS nch W=0.155u L=0.04u
M_U1185/MI12-M_u2 U1185/net108 U1185/net104 VSS VSS nch W=0.155u L=0.04u
M_U1185/MU20-M_u2 n1283 U1185/net28 VSS VSS nch W=0.155u L=0.04u
M_U1185/MI1-M_u2 U1185/net32 n1296 VSS VSS nch W=0.155u L=0.04u
M_U1185/MI16-M_u2 U1185/net64 U1185/net24 VSS VSS nch W=0.2u L=0.04u
M_U1185/MI15-M_u2 U1185/net28 U1185/net40 U1185/net64 VDD pch W=0.205u L=0.04u
M_U1185/MI8-M_u2 U1185/net24 n1295 U1185/net32 VDD pch W=0.205u L=0.04u
M_U1185/MI17-M_u2 U1185/net28 U1185/net20 U1185/net24 VDD pch W=0.205u L=0.04u
M_U1185/MI11-M_u2 U1185/net40 U1185/net106 U1185/net108 VDD pch W=0.205u L=0.04u
M_U1185/MI9-M_u2 U1185/net40 n1298 U1185/net104 VDD pch W=0.205u L=0.04u
M_U1185/MI19-M_u3 U1185/net20 U1185/net40 VDD VDD pch W=0.205u L=0.04u
M_U1185/MI13-M_u3 U1185/net106 n1298 VDD VDD pch W=0.205u L=0.04u
M_U1185/MI14-M_u3 U1185/net104 n1297 VDD VDD pch W=0.205u L=0.04u
M_U1185/M_u8-M_u3 U1185/net30 n1295 VDD VDD pch W=0.205u L=0.04u
M_U1185/MI12-M_u3 U1185/net108 U1185/net104 VDD VDD pch W=0.205u L=0.04u
M_U1185/MU20-M_u3 n1283 U1185/net28 VDD VDD pch W=0.205u L=0.04u
M_U1185/MI1-M_u3 U1185/net32 n1296 VDD VDD pch W=0.205u L=0.04u
M_U1185/MI16-M_u3 U1185/net64 U1185/net24 VDD VDD pch W=0.28u L=0.04u
M_U1185/MI20 U1185/net24 U1185/net30 U1185/net045 VDD pch W=0.205u L=0.04u
M_U1185/M_u2 U1185/net045 U1185/net32 VDD VDD pch W=0.205u L=0.04u
M_U1186/MI15-M_u3 U1186/net28 U1186/net20 U1186/net64 VSS nch W=0.155u L=0.04u
M_U1186/MI8-M_u3 U1186/net24 U1186/net30 U1186/net32 VSS nch W=0.155u L=0.04u
M_U1186/MI17-M_u3 U1186/net28 U1186/net40 U1186/net24 VSS nch W=0.155u L=0.04u
M_U1186/MI11-M_u3 U1186/net40 n1302 U1186/net108 VSS nch W=0.155u L=0.04u
M_U1186/MI9-M_u3 U1186/net40 U1186/net106 U1186/net104 VSS nch W=0.155u L=0.04u
M_U1186/MI21 U1186/net24 n1299 U1186/net050 VSS nch W=0.155u L=0.04u
M_U1186/MI22 U1186/net050 U1186/net32 VSS VSS nch W=0.155u L=0.04u
M_U1186/MI19-M_u2 U1186/net20 U1186/net40 VSS VSS nch W=0.155u L=0.04u
M_U1186/MI13-M_u2 U1186/net106 n1302 VSS VSS nch W=0.155u L=0.04u
M_U1186/MI14-M_u2 U1186/net104 n1301 VSS VSS nch W=0.155u L=0.04u
M_U1186/M_u8-M_u2 U1186/net30 n1299 VSS VSS nch W=0.155u L=0.04u
M_U1186/MI12-M_u2 U1186/net108 U1186/net104 VSS VSS nch W=0.155u L=0.04u
M_U1186/MU20-M_u2 n1266 U1186/net28 VSS VSS nch W=0.155u L=0.04u
M_U1186/MI1-M_u2 U1186/net32 n1300 VSS VSS nch W=0.155u L=0.04u
M_U1186/MI16-M_u2 U1186/net64 U1186/net24 VSS VSS nch W=0.2u L=0.04u
M_U1186/MI15-M_u2 U1186/net28 U1186/net40 U1186/net64 VDD pch W=0.205u L=0.04u
M_U1186/MI8-M_u2 U1186/net24 n1299 U1186/net32 VDD pch W=0.205u L=0.04u
M_U1186/MI17-M_u2 U1186/net28 U1186/net20 U1186/net24 VDD pch W=0.205u L=0.04u
M_U1186/MI11-M_u2 U1186/net40 U1186/net106 U1186/net108 VDD pch W=0.205u L=0.04u
M_U1186/MI9-M_u2 U1186/net40 n1302 U1186/net104 VDD pch W=0.205u L=0.04u
M_U1186/MI19-M_u3 U1186/net20 U1186/net40 VDD VDD pch W=0.205u L=0.04u
M_U1186/MI13-M_u3 U1186/net106 n1302 VDD VDD pch W=0.205u L=0.04u
M_U1186/MI14-M_u3 U1186/net104 n1301 VDD VDD pch W=0.205u L=0.04u
M_U1186/M_u8-M_u3 U1186/net30 n1299 VDD VDD pch W=0.205u L=0.04u
M_U1186/MI12-M_u3 U1186/net108 U1186/net104 VDD VDD pch W=0.205u L=0.04u
M_U1186/MU20-M_u3 n1266 U1186/net28 VDD VDD pch W=0.205u L=0.04u
M_U1186/MI1-M_u3 U1186/net32 n1300 VDD VDD pch W=0.205u L=0.04u
M_U1186/MI16-M_u3 U1186/net64 U1186/net24 VDD VDD pch W=0.28u L=0.04u
M_U1186/MI20 U1186/net24 U1186/net30 U1186/net045 VDD pch W=0.205u L=0.04u
M_U1186/M_u2 U1186/net045 U1186/net32 VDD VDD pch W=0.205u L=0.04u
M_U1187/M_u2 n1302 N212 U1187/net15 VSS nch W=0.155u L=0.04u
M_U1187/M_u3 n1302 n1184 U1187/net15 VSS nch W=0.155u L=0.04u
M_U1187/M_u4 U1187/net15 n1050 VSS VSS nch W=0.155u L=0.04u
M_U1187/M_u9 n1302 n1050 VDD VDD pch W=0.205u L=0.04u
M_U1187/MI16-MI12 n1302 N212 U1187/XI16-net11 VDD pch W=0.205u L=0.04u
M_U1187/MI16-MI13 U1187/XI16-net11 n1184 VDD VDD pch W=0.205u L=0.04u
M_U1188/MI15-M_u3 U1188/net28 U1188/net20 U1188/net64 VSS nch W=0.155u L=0.04u
M_U1188/MI8-M_u3 U1188/net24 U1188/net30 U1188/net32 VSS nch W=0.155u L=0.04u
M_U1188/MI17-M_u3 U1188/net28 U1188/net40 U1188/net24 VSS nch W=0.155u L=0.04u
M_U1188/MI11-M_u3 U1188/net40 n1306 U1188/net108 VSS nch W=0.155u L=0.04u
M_U1188/MI9-M_u3 U1188/net40 U1188/net106 U1188/net104 VSS nch W=0.155u L=0.04u
M_U1188/MI21 U1188/net24 n1303 U1188/net050 VSS nch W=0.155u L=0.04u
M_U1188/MI22 U1188/net050 U1188/net32 VSS VSS nch W=0.155u L=0.04u
M_U1188/MI19-M_u2 U1188/net20 U1188/net40 VSS VSS nch W=0.155u L=0.04u
M_U1188/MI13-M_u2 U1188/net106 n1306 VSS VSS nch W=0.155u L=0.04u
M_U1188/MI14-M_u2 U1188/net104 n1305 VSS VSS nch W=0.155u L=0.04u
M_U1188/M_u8-M_u2 U1188/net30 n1303 VSS VSS nch W=0.155u L=0.04u
M_U1188/MI12-M_u2 U1188/net108 U1188/net104 VSS VSS nch W=0.155u L=0.04u
M_U1188/MU20-M_u2 n1301 U1188/net28 VSS VSS nch W=0.155u L=0.04u
M_U1188/MI1-M_u2 U1188/net32 n1304 VSS VSS nch W=0.155u L=0.04u
M_U1188/MI16-M_u2 U1188/net64 U1188/net24 VSS VSS nch W=0.2u L=0.04u
M_U1188/MI15-M_u2 U1188/net28 U1188/net40 U1188/net64 VDD pch W=0.205u L=0.04u
M_U1188/MI8-M_u2 U1188/net24 n1303 U1188/net32 VDD pch W=0.205u L=0.04u
M_U1188/MI17-M_u2 U1188/net28 U1188/net20 U1188/net24 VDD pch W=0.205u L=0.04u
M_U1188/MI11-M_u2 U1188/net40 U1188/net106 U1188/net108 VDD pch W=0.205u L=0.04u
M_U1188/MI9-M_u2 U1188/net40 n1306 U1188/net104 VDD pch W=0.205u L=0.04u
M_U1188/MI19-M_u3 U1188/net20 U1188/net40 VDD VDD pch W=0.205u L=0.04u
M_U1188/MI13-M_u3 U1188/net106 n1306 VDD VDD pch W=0.205u L=0.04u
M_U1188/MI14-M_u3 U1188/net104 n1305 VDD VDD pch W=0.205u L=0.04u
M_U1188/M_u8-M_u3 U1188/net30 n1303 VDD VDD pch W=0.205u L=0.04u
M_U1188/MI12-M_u3 U1188/net108 U1188/net104 VDD VDD pch W=0.205u L=0.04u
M_U1188/MU20-M_u3 n1301 U1188/net28 VDD VDD pch W=0.205u L=0.04u
M_U1188/MI1-M_u3 U1188/net32 n1304 VDD VDD pch W=0.205u L=0.04u
M_U1188/MI16-M_u3 U1188/net64 U1188/net24 VDD VDD pch W=0.28u L=0.04u
M_U1188/MI20 U1188/net24 U1188/net30 U1188/net045 VDD pch W=0.205u L=0.04u
M_U1188/M_u2 U1188/net045 U1188/net32 VDD VDD pch W=0.205u L=0.04u
M_U1189/M_u2 n1300 N211 U1189/net15 VSS nch W=0.155u L=0.04u
M_U1189/M_u3 n1300 n1185 U1189/net15 VSS nch W=0.155u L=0.04u
M_U1189/M_u4 U1189/net15 n1050 VSS VSS nch W=0.155u L=0.04u
M_U1189/M_u9 n1300 n1050 VDD VDD pch W=0.205u L=0.04u
M_U1189/MI16-MI12 n1300 N211 U1189/XI16-net11 VDD pch W=0.205u L=0.04u
M_U1189/MI16-MI13 U1189/XI16-net11 n1185 VDD VDD pch W=0.205u L=0.04u
M_U1190/M_u4 n1299 n1185 VSS VSS nch W=0.155u L=0.04u
M_U1190/MI2 n1299 N209 VSS VSS nch W=0.155u L=0.04u
M_U1190/MI3 n1299 n1044 VSS VSS nch W=0.155u L=0.04u
M_U1190/M_u1 U1190/net25 n1185 VDD VDD pch W=0.41u L=0.04u
M_U1190/MI0 U1190/net28 N209 U1190/net25 VDD pch W=0.41u L=0.04u
M_U1190/MI1 n1299 n1044 U1190/net28 VDD pch W=0.41u L=0.04u
M_U1191/MI15 U1191/net29 U1191/net21 U1191/net041 VSS nch W=0.155u L=0.04u
M_U1191/MU63 U1191/net035 U1191/net19 VSS VSS nch W=0.155u L=0.04u
M_U1191/MI14 U1191/net041 U1191/net13 VSS VSS nch W=0.155u L=0.04u
M_U1191/MI42 U1191/net25 n1308 U1191/net035 VSS nch W=0.155u L=0.04u
M_U1191/M_u6-M_u3 U1191/net19 U1191/net17 U1191/net25 VSS nch W=0.155u L=0.04u
M_U1191/MU18-M_u3 U1191/net13 U1191/net25 U1191/net29 VSS nch W=0.155u L=0.04u
M_U1191/MI1-M_u2 n1265 U1191/net29 VSS VSS nch W=0.155u L=0.04u
M_U1191/MI3-M_u2 U1191/net13 n1309 VSS VSS nch W=0.155u L=0.04u
M_U1191/MI7-M_u2 U1191/net17 n1308 VSS VSS nch W=0.155u L=0.04u
M_U1191/MI2-M_u2 U1191/net19 n1307 VSS VSS nch W=0.155u L=0.04u
M_U1191/MI6-M_u2 U1191/net21 U1191/net25 VSS VSS nch W=0.155u L=0.04u
M_U1191/MU62 U1191/net028 U1191/net19 VDD VDD pch W=0.205u L=0.04u
M_U1191/MI8 U1191/net25 U1191/net17 U1191/net028 VDD pch W=0.205u L=0.04u
M_U1191/MI12 U1191/net29 U1191/net25 U1191/net029 VDD pch W=0.205u L=0.04u
M_U1191/MI13 U1191/net029 U1191/net13 VDD VDD pch W=0.205u L=0.04u
M_U1191/M_u6-M_u2 U1191/net19 n1308 U1191/net25 VDD pch W=0.205u L=0.04u
M_U1191/MU18-M_u2 U1191/net13 U1191/net21 U1191/net29 VDD pch W=0.205u L=0.04u
M_U1191/MI1-M_u3 n1265 U1191/net29 VDD VDD pch W=0.205u L=0.04u
M_U1191/MI3-M_u3 U1191/net13 n1309 VDD VDD pch W=0.205u L=0.04u
M_U1191/MI7-M_u3 U1191/net17 n1308 VDD VDD pch W=0.205u L=0.04u
M_U1191/MI2-M_u3 U1191/net19 n1307 VDD VDD pch W=0.205u L=0.04u
M_U1191/MI6-M_u3 U1191/net21 U1191/net25 VDD VDD pch W=0.205u L=0.04u
M_U1192/MI15-M_u3 U1192/net28 U1192/net20 U1192/net64 VSS nch W=0.155u L=0.04u
M_U1192/MI8-M_u3 U1192/net24 U1192/net30 U1192/net32 VSS nch W=0.155u L=0.04u
M_U1192/MI17-M_u3 U1192/net28 U1192/net40 U1192/net24 VSS nch W=0.155u L=0.04u
M_U1192/MI11-M_u3 U1192/net40 n1313 U1192/net108 VSS nch W=0.155u L=0.04u
M_U1192/MI9-M_u3 U1192/net40 U1192/net106 U1192/net104 VSS nch W=0.155u L=0.04u
M_U1192/MI21 U1192/net24 n1310 U1192/net050 VSS nch W=0.155u L=0.04u
M_U1192/MI22 U1192/net050 U1192/net32 VSS VSS nch W=0.155u L=0.04u
M_U1192/MI19-M_u2 U1192/net20 U1192/net40 VSS VSS nch W=0.155u L=0.04u
M_U1192/MI13-M_u2 U1192/net106 n1313 VSS VSS nch W=0.155u L=0.04u
M_U1192/MI14-M_u2 U1192/net104 n1312 VSS VSS nch W=0.155u L=0.04u
M_U1192/M_u8-M_u2 U1192/net30 n1310 VSS VSS nch W=0.155u L=0.04u
M_U1192/MI12-M_u2 U1192/net108 U1192/net104 VSS VSS nch W=0.155u L=0.04u
M_U1192/MU20-M_u2 n1309 U1192/net28 VSS VSS nch W=0.155u L=0.04u
M_U1192/MI1-M_u2 U1192/net32 n1311 VSS VSS nch W=0.155u L=0.04u
M_U1192/MI16-M_u2 U1192/net64 U1192/net24 VSS VSS nch W=0.2u L=0.04u
M_U1192/MI15-M_u2 U1192/net28 U1192/net40 U1192/net64 VDD pch W=0.205u L=0.04u
M_U1192/MI8-M_u2 U1192/net24 n1310 U1192/net32 VDD pch W=0.205u L=0.04u
M_U1192/MI17-M_u2 U1192/net28 U1192/net20 U1192/net24 VDD pch W=0.205u L=0.04u
M_U1192/MI11-M_u2 U1192/net40 U1192/net106 U1192/net108 VDD pch W=0.205u L=0.04u
M_U1192/MI9-M_u2 U1192/net40 n1313 U1192/net104 VDD pch W=0.205u L=0.04u
M_U1192/MI19-M_u3 U1192/net20 U1192/net40 VDD VDD pch W=0.205u L=0.04u
M_U1192/MI13-M_u3 U1192/net106 n1313 VDD VDD pch W=0.205u L=0.04u
M_U1192/MI14-M_u3 U1192/net104 n1312 VDD VDD pch W=0.205u L=0.04u
M_U1192/M_u8-M_u3 U1192/net30 n1310 VDD VDD pch W=0.205u L=0.04u
M_U1192/MI12-M_u3 U1192/net108 U1192/net104 VDD VDD pch W=0.205u L=0.04u
M_U1192/MU20-M_u3 n1309 U1192/net28 VDD VDD pch W=0.205u L=0.04u
M_U1192/MI1-M_u3 U1192/net32 n1311 VDD VDD pch W=0.205u L=0.04u
M_U1192/MI16-M_u3 U1192/net64 U1192/net24 VDD VDD pch W=0.28u L=0.04u
M_U1192/MI20 U1192/net24 U1192/net30 U1192/net045 VDD pch W=0.205u L=0.04u
M_U1192/M_u2 U1192/net045 U1192/net32 VDD VDD pch W=0.205u L=0.04u
M_U1193/MI15-M_u2 U1193/net19 N18 VSS VSS nch W=0.155u L=0.04u
M_U1193/MI21 n1313 N18 U1193/net40 VSS nch W=0.155u L=0.04u
M_U1193/MI12 n1313 U1193/net19 U1193/net36 VSS nch W=0.155u L=0.04u
M_U1193/MI20 U1193/net40 n1315 VSS VSS nch W=0.31u L=0.04u
M_U1193/MI19 U1193/net36 n1314 VSS VSS nch W=0.155u L=0.04u
M_U1193/MI15-M_u3 U1193/net19 N18 VDD VDD pch W=0.205u L=0.04u
M_U1193/MI25 n1313 U1193/net19 U1193/net26 VDD pch W=0.325u L=0.04u
M_U1193/MI24 U1193/net26 n1315 VDD VDD pch W=0.41u L=0.04u
M_U1193/MI5 n1313 N18 U1193/net30 VDD pch W=0.325u L=0.04u
M_U1193/MI111 U1193/net30 n1314 VDD VDD pch W=0.205u L=0.04u
M_U1194/M_u6-M_u3 U1194/net4 U1194/net10 U1194/net14 VSS nch W=0.155u L=0.04u
M_U1194/MI3-M_u3 U1194/net6 N227 U1194/net14 VSS nch W=0.155u L=0.04u
M_U1194/MI1-M_u2 U1194/net4 n1316 VSS VSS nch W=0.155u L=0.04u
M_U1194/M_u5-M_u2 U1194/net6 U1194/net4 VSS VSS nch W=0.155u L=0.04u
M_U1194/M_u4-M_u2 n1315 U1194/net14 VSS VSS nch W=0.155u L=0.04u
M_U1194/MI2-M_u2 U1194/net10 N227 VSS VSS nch W=0.155u L=0.04u
M_U1194/M_u6-M_u2 U1194/net4 N227 U1194/net14 VDD pch W=0.205u L=0.04u
M_U1194/MI3-M_u2 U1194/net6 U1194/net10 U1194/net14 VDD pch W=0.205u L=0.04u
M_U1194/MI1-M_u3 U1194/net4 n1316 VDD VDD pch W=0.205u L=0.04u
M_U1194/M_u5-M_u3 U1194/net6 U1194/net4 VDD VDD pch W=0.205u L=0.04u
M_U1194/M_u4-M_u3 n1315 U1194/net14 VDD VDD pch W=0.205u L=0.04u
M_U1194/MI2-M_u3 U1194/net10 N227 VDD VDD pch W=0.205u L=0.04u
M_U1195/M_u6-M_u3 U1195/net4 U1195/net10 U1195/net14 VSS nch W=0.155u L=0.04u
M_U1195/MI3-M_u3 U1195/net6 n1317 U1195/net14 VSS nch W=0.155u L=0.04u
M_U1195/MI1-M_u2 U1195/net4 n1192 VSS VSS nch W=0.155u L=0.04u
M_U1195/M_u5-M_u2 U1195/net6 U1195/net4 VSS VSS nch W=0.155u L=0.04u
M_U1195/M_u4-M_u2 n1314 U1195/net14 VSS VSS nch W=0.155u L=0.04u
M_U1195/MI2-M_u2 U1195/net10 n1317 VSS VSS nch W=0.155u L=0.04u
M_U1195/M_u6-M_u2 U1195/net4 n1317 U1195/net14 VDD pch W=0.205u L=0.04u
M_U1195/MI3-M_u2 U1195/net6 U1195/net10 U1195/net14 VDD pch W=0.205u L=0.04u
M_U1195/MI1-M_u3 U1195/net4 n1192 VDD VDD pch W=0.205u L=0.04u
M_U1195/M_u5-M_u3 U1195/net6 U1195/net4 VDD VDD pch W=0.205u L=0.04u
M_U1195/M_u4-M_u3 n1314 U1195/net14 VDD VDD pch W=0.205u L=0.04u
M_U1195/MI2-M_u3 U1195/net10 n1317 VDD VDD pch W=0.205u L=0.04u
M_U1196/M_u2 n1192 N115 VSS VSS nch W=0.135u L=0.04u
M_U1196/M_u1 n1192 N115 VDD VDD pch W=0.205u L=0.04u
M_U1197/MI15-M_u3 U1197/net28 U1197/net20 U1197/net64 VSS nch W=0.155u L=0.04u
M_U1197/MI8-M_u3 U1197/net24 U1197/net30 U1197/net32 VSS nch W=0.155u L=0.04u
M_U1197/MI17-M_u3 U1197/net28 U1197/net40 U1197/net24 VSS nch W=0.155u L=0.04u
M_U1197/MI11-M_u3 U1197/net40 n1321 U1197/net108 VSS nch W=0.155u L=0.04u
M_U1197/MI9-M_u3 U1197/net40 U1197/net106 U1197/net104 VSS nch W=0.155u L=0.04u
M_U1197/MI21 U1197/net24 n1318 U1197/net050 VSS nch W=0.155u L=0.04u
M_U1197/MI22 U1197/net050 U1197/net32 VSS VSS nch W=0.155u L=0.04u
M_U1197/MI19-M_u2 U1197/net20 U1197/net40 VSS VSS nch W=0.155u L=0.04u
M_U1197/MI13-M_u2 U1197/net106 n1321 VSS VSS nch W=0.155u L=0.04u
M_U1197/MI14-M_u2 U1197/net104 n1320 VSS VSS nch W=0.155u L=0.04u
M_U1197/M_u8-M_u2 U1197/net30 n1318 VSS VSS nch W=0.155u L=0.04u
M_U1197/MI12-M_u2 U1197/net108 U1197/net104 VSS VSS nch W=0.155u L=0.04u
M_U1197/MU20-M_u2 n1308 U1197/net28 VSS VSS nch W=0.155u L=0.04u
M_U1197/MI1-M_u2 U1197/net32 n1319 VSS VSS nch W=0.155u L=0.04u
M_U1197/MI16-M_u2 U1197/net64 U1197/net24 VSS VSS nch W=0.2u L=0.04u
M_U1197/MI15-M_u2 U1197/net28 U1197/net40 U1197/net64 VDD pch W=0.205u L=0.04u
M_U1197/MI8-M_u2 U1197/net24 n1318 U1197/net32 VDD pch W=0.205u L=0.04u
M_U1197/MI17-M_u2 U1197/net28 U1197/net20 U1197/net24 VDD pch W=0.205u L=0.04u
M_U1197/MI11-M_u2 U1197/net40 U1197/net106 U1197/net108 VDD pch W=0.205u L=0.04u
M_U1197/MI9-M_u2 U1197/net40 n1321 U1197/net104 VDD pch W=0.205u L=0.04u
M_U1197/MI19-M_u3 U1197/net20 U1197/net40 VDD VDD pch W=0.205u L=0.04u
M_U1197/MI13-M_u3 U1197/net106 n1321 VDD VDD pch W=0.205u L=0.04u
M_U1197/MI14-M_u3 U1197/net104 n1320 VDD VDD pch W=0.205u L=0.04u
M_U1197/M_u8-M_u3 U1197/net30 n1318 VDD VDD pch W=0.205u L=0.04u
M_U1197/MI12-M_u3 U1197/net108 U1197/net104 VDD VDD pch W=0.205u L=0.04u
M_U1197/MU20-M_u3 n1308 U1197/net28 VDD VDD pch W=0.205u L=0.04u
M_U1197/MI1-M_u3 U1197/net32 n1319 VDD VDD pch W=0.205u L=0.04u
M_U1197/MI16-M_u3 U1197/net64 U1197/net24 VDD VDD pch W=0.28u L=0.04u
M_U1197/MI20 U1197/net24 U1197/net30 U1197/net045 VDD pch W=0.205u L=0.04u
M_U1197/M_u2 U1197/net045 U1197/net32 VDD VDD pch W=0.205u L=0.04u
M_U1198/M_u6-M_u3 U1198/net4 U1198/net10 U1198/net14 VSS nch W=0.155u L=0.04u
M_U1198/MI3-M_u3 U1198/net6 n749 U1198/net14 VSS nch W=0.155u L=0.04u
M_U1198/MI1-M_u2 U1198/net4 n797 VSS VSS nch W=0.155u L=0.04u
M_U1198/M_u5-M_u2 U1198/net6 U1198/net4 VSS VSS nch W=0.155u L=0.04u
M_U1198/M_u4-M_u2 N10353 U1198/net14 VSS VSS nch W=0.155u L=0.04u
M_U1198/MI2-M_u2 U1198/net10 n749 VSS VSS nch W=0.155u L=0.04u
M_U1198/M_u6-M_u2 U1198/net4 n749 U1198/net14 VDD pch W=0.205u L=0.04u
M_U1198/MI3-M_u2 U1198/net6 U1198/net10 U1198/net14 VDD pch W=0.205u L=0.04u
M_U1198/MI1-M_u3 U1198/net4 n797 VDD VDD pch W=0.205u L=0.04u
M_U1198/M_u5-M_u3 U1198/net6 U1198/net4 VDD VDD pch W=0.205u L=0.04u
M_U1198/M_u4-M_u3 N10353 U1198/net14 VDD VDD pch W=0.205u L=0.04u
M_U1198/MI2-M_u3 U1198/net10 n749 VDD VDD pch W=0.205u L=0.04u
M_U1199/M_u6-M_u3 U1199/net4 U1199/net10 U1199/net14 VSS nch W=0.155u L=0.04u
M_U1199/MI3-M_u3 U1199/net6 n1322 U1199/net14 VSS nch W=0.155u L=0.04u
M_U1199/MI1-M_u2 U1199/net4 n1323 VSS VSS nch W=0.155u L=0.04u
M_U1199/M_u5-M_u2 U1199/net6 U1199/net4 VSS VSS nch W=0.155u L=0.04u
M_U1199/M_u4-M_u2 N10352 U1199/net14 VSS VSS nch W=0.155u L=0.04u
M_U1199/MI2-M_u2 U1199/net10 n1322 VSS VSS nch W=0.155u L=0.04u
M_U1199/M_u6-M_u2 U1199/net4 n1322 U1199/net14 VDD pch W=0.205u L=0.04u
M_U1199/MI3-M_u2 U1199/net6 U1199/net10 U1199/net14 VDD pch W=0.205u L=0.04u
M_U1199/MI1-M_u3 U1199/net4 n1323 VDD VDD pch W=0.205u L=0.04u
M_U1199/M_u5-M_u3 U1199/net6 U1199/net4 VDD VDD pch W=0.205u L=0.04u
M_U1199/M_u4-M_u3 N10352 U1199/net14 VDD VDD pch W=0.205u L=0.04u
M_U1199/MI2-M_u3 U1199/net10 n1322 VDD VDD pch W=0.205u L=0.04u
M_U1200/M_u2 n1323 n749 U1200/net15 VSS nch W=0.155u L=0.04u
M_U1200/M_u3 n1323 n796 U1200/net15 VSS nch W=0.155u L=0.04u
M_U1200/M_u4 U1200/net15 n1324 VSS VSS nch W=0.155u L=0.04u
M_U1200/M_u9 n1323 n1324 VDD VDD pch W=0.205u L=0.04u
M_U1200/MI16-MI12 n1323 n749 U1200/XI16-net11 VDD pch W=0.205u L=0.04u
M_U1200/MI16-MI13 U1200/XI16-net11 n796 VDD VDD pch W=0.205u L=0.04u
M_U1201/M_u6-M_u3 U1201/net4 U1201/net10 U1201/net14 VSS nch W=0.155u L=0.04u
M_U1201/MI3-M_u3 U1201/net6 n1325 U1201/net14 VSS nch W=0.155u L=0.04u
M_U1201/MI1-M_u2 U1201/net4 n1326 VSS VSS nch W=0.155u L=0.04u
M_U1201/M_u5-M_u2 U1201/net6 U1201/net4 VSS VSS nch W=0.155u L=0.04u
M_U1201/M_u4-M_u2 N10351 U1201/net14 VSS VSS nch W=0.155u L=0.04u
M_U1201/MI2-M_u2 U1201/net10 n1325 VSS VSS nch W=0.155u L=0.04u
M_U1201/M_u6-M_u2 U1201/net4 n1325 U1201/net14 VDD pch W=0.205u L=0.04u
M_U1201/MI3-M_u2 U1201/net6 U1201/net10 U1201/net14 VDD pch W=0.205u L=0.04u
M_U1201/MI1-M_u3 U1201/net4 n1326 VDD VDD pch W=0.205u L=0.04u
M_U1201/M_u5-M_u3 U1201/net6 U1201/net4 VDD VDD pch W=0.205u L=0.04u
M_U1201/M_u4-M_u3 N10351 U1201/net14 VDD VDD pch W=0.205u L=0.04u
M_U1201/MI2-M_u3 U1201/net10 n1325 VDD VDD pch W=0.205u L=0.04u
M_U1202/MI1-M_u4 U1202/net11 n749 VSS VSS nch W=0.155u L=0.04u
M_U1202/MI1-M_u3 U1202/net11 n795 VSS VSS nch W=0.155u L=0.04u
M_U1202/MU39-M_u4 n1325 n756 VSS VSS nch W=0.155u L=0.04u
M_U1202/MU39-M_u3 n1325 U1202/net11 VSS VSS nch W=0.155u L=0.04u
M_U1202/MI1-M_u1 U1202/XI1-net8 n795 VDD VDD pch W=0.205u L=0.04u
M_U1202/MI1-M_u2 U1202/net11 n749 U1202/XI1-net8 VDD pch W=0.205u L=0.04u
M_U1202/MU39-M_u1 U1202/XU39-net8 U1202/net11 VDD VDD pch W=0.205u L=0.04u
M_U1202/MU39-M_u2 n1325 n756 U1202/XU39-net8 VDD pch W=0.205u L=0.04u
M_U1203/MI2 n795 n1322 U1203/net27 VSS nch W=0.155u L=0.04u
M_U1203/MI10 U1203/net27 n1327 VSS VSS nch W=0.155u L=0.04u
M_U1203/MI11 n795 n756 VSS VSS nch W=0.155u L=0.04u
M_U1203/MI8 n795 n1327 U1203/net13 VDD pch W=0.205u L=0.04u
M_U1203/M_u2 U1203/net13 n756 VDD VDD pch W=0.205u L=0.04u
M_U1203/MI9 n795 n1322 U1203/net13 VDD pch W=0.205u L=0.04u
M_U1204/MI9 n756 N328 U1204/net10 VSS nch W=0.155u L=0.04u
M_U1204/M_u4 U1204/net10 n1324 VSS VSS nch W=0.155u L=0.04u
M_U1204/MI8 n756 n1285 U1204/net10 VSS nch W=0.155u L=0.04u
M_U1204/MI7 U1204/net10 n798 VSS VSS nch W=0.155u L=0.04u
M_U1204/MU24 U1204/net30 n1324 VDD VDD pch W=0.205u L=0.04u
M_U1204/MI6 n756 N328 U1204/net24 VDD pch W=0.205u L=0.04u
M_U1204/MI5 U1204/net24 n1285 VDD VDD pch W=0.205u L=0.04u
M_U1204/MI4 n756 n798 U1204/net30 VDD pch W=0.205u L=0.04u
M_U1205/MI15-M_u2 U1205/net19 n749 VSS VSS nch W=0.155u L=0.04u
M_U1205/MI21 N10350 n749 U1205/net40 VSS nch W=0.155u L=0.04u
M_U1205/MI12 N10350 U1205/net19 U1205/net36 VSS nch W=0.155u L=0.04u
M_U1205/MI20 U1205/net40 n751 VSS VSS nch W=0.31u L=0.04u
M_U1205/MI19 U1205/net36 n1328 VSS VSS nch W=0.155u L=0.04u
M_U1205/MI15-M_u3 U1205/net19 n749 VDD VDD pch W=0.205u L=0.04u
M_U1205/MI25 N10350 U1205/net19 U1205/net26 VDD pch W=0.325u L=0.04u
M_U1205/MI24 U1205/net26 n751 VDD VDD pch W=0.41u L=0.04u
M_U1205/MI5 N10350 n749 U1205/net30 VDD pch W=0.325u L=0.04u
M_U1205/MI111 U1205/net30 n1328 VDD VDD pch W=0.205u L=0.04u
M_U1206/M_u6-M_u3 U1206/net4 U1206/net10 U1206/net14 VSS nch W=0.155u L=0.04u
M_U1206/MI3-M_u3 U1206/net6 n1329 U1206/net14 VSS nch W=0.155u L=0.04u
M_U1206/MI1-M_u2 U1206/net4 n793 VSS VSS nch W=0.155u L=0.04u
M_U1206/M_u5-M_u2 U1206/net6 U1206/net4 VSS VSS nch W=0.155u L=0.04u
M_U1206/M_u4-M_u2 n751 U1206/net14 VSS VSS nch W=0.155u L=0.04u
M_U1206/MI2-M_u2 U1206/net10 n1329 VSS VSS nch W=0.155u L=0.04u
M_U1206/M_u6-M_u2 U1206/net4 n1329 U1206/net14 VDD pch W=0.205u L=0.04u
M_U1206/MI3-M_u2 U1206/net6 U1206/net10 U1206/net14 VDD pch W=0.205u L=0.04u
M_U1206/MI1-M_u3 U1206/net4 n793 VDD VDD pch W=0.205u L=0.04u
M_U1206/M_u5-M_u3 U1206/net6 U1206/net4 VDD VDD pch W=0.205u L=0.04u
M_U1206/M_u4-M_u3 n751 U1206/net14 VDD VDD pch W=0.205u L=0.04u
M_U1206/MI2-M_u3 U1206/net10 n1329 VDD VDD pch W=0.205u L=0.04u
M_U1207/M_u6-M_u3 U1207/net4 U1207/net10 U1207/net14 VSS nch W=0.155u L=0.04u
M_U1207/MI3-M_u3 U1207/net6 n1017 U1207/net14 VSS nch W=0.155u L=0.04u
M_U1207/MI1-M_u2 U1207/net4 n794 VSS VSS nch W=0.155u L=0.04u
M_U1207/M_u5-M_u2 U1207/net6 U1207/net4 VSS VSS nch W=0.155u L=0.04u
M_U1207/M_u4-M_u2 n1328 U1207/net14 VSS VSS nch W=0.155u L=0.04u
M_U1207/MI2-M_u2 U1207/net10 n1017 VSS VSS nch W=0.155u L=0.04u
M_U1207/M_u6-M_u2 U1207/net4 n1017 U1207/net14 VDD pch W=0.205u L=0.04u
M_U1207/MI3-M_u2 U1207/net6 U1207/net10 U1207/net14 VDD pch W=0.205u L=0.04u
M_U1207/MI1-M_u3 U1207/net4 n794 VDD VDD pch W=0.205u L=0.04u
M_U1207/M_u5-M_u3 U1207/net6 U1207/net4 VDD VDD pch W=0.205u L=0.04u
M_U1207/M_u4-M_u3 n1328 U1207/net14 VDD VDD pch W=0.205u L=0.04u
M_U1207/MI2-M_u3 U1207/net10 n1017 VDD VDD pch W=0.205u L=0.04u
M_U1208/MI2-M_u2 U1208/net13 n1330 VSS VSS nch W=0.155u L=0.04u
M_U1208/MI13 U1208/net16 U1208/net13 VSS VSS nch W=0.155u L=0.04u
M_U1208/MI12 n794 n1329 U1208/net16 VSS nch W=0.155u L=0.04u
M_U1208/MI2-M_u3 U1208/net13 n1330 VDD VDD pch W=0.205u L=0.04u
M_U1208/M_u16 VDD U1208/net13 n794 VDD pch W=0.205u L=0.04u
M_U1208/MI11 VDD n1329 n794 VDD pch W=0.205u L=0.04u
M_U1209/M_u6-M_u3 U1209/net4 U1209/net10 U1209/net14 VSS nch W=0.155u L=0.04u
M_U1209/MI3-M_u3 U1209/net6 n1331 U1209/net14 VSS nch W=0.155u L=0.04u
M_U1209/MI1-M_u2 U1209/net4 n789 VSS VSS nch W=0.155u L=0.04u
M_U1209/M_u5-M_u2 U1209/net6 U1209/net4 VSS VSS nch W=0.155u L=0.04u
M_U1209/M_u4-M_u2 N10112 U1209/net14 VSS VSS nch W=0.155u L=0.04u
M_U1209/MI2-M_u2 U1209/net10 n1331 VSS VSS nch W=0.155u L=0.04u
M_U1209/M_u6-M_u2 U1209/net4 n1331 U1209/net14 VDD pch W=0.205u L=0.04u
M_U1209/MI3-M_u2 U1209/net6 U1209/net10 U1209/net14 VDD pch W=0.205u L=0.04u
M_U1209/MI1-M_u3 U1209/net4 n789 VDD VDD pch W=0.205u L=0.04u
M_U1209/M_u5-M_u3 U1209/net6 U1209/net4 VDD VDD pch W=0.205u L=0.04u
M_U1209/M_u4-M_u3 N10112 U1209/net14 VDD VDD pch W=0.205u L=0.04u
M_U1209/MI2-M_u3 U1209/net10 n1331 VDD VDD pch W=0.205u L=0.04u
M_U1210/MI2 n1331 N367 U1210/net27 VSS nch W=0.155u L=0.04u
M_U1210/MI10 U1210/net27 n790 VSS VSS nch W=0.155u L=0.04u
M_U1210/MI11 n1331 n780 VSS VSS nch W=0.155u L=0.04u
M_U1210/MI8 n1331 n790 U1210/net13 VDD pch W=0.205u L=0.04u
M_U1210/M_u2 U1210/net13 n780 VDD VDD pch W=0.205u L=0.04u
M_U1210/MI9 n1331 N367 U1210/net13 VDD pch W=0.205u L=0.04u
M_U1211/M_u6-M_u3 U1211/net4 U1211/net10 U1211/net14 VSS nch W=0.155u L=0.04u
M_U1211/MI3-M_u3 U1211/net6 n1332 U1211/net14 VSS nch W=0.155u L=0.04u
M_U1211/MI1-M_u2 U1211/net4 n1333 VSS VSS nch W=0.155u L=0.04u
M_U1211/M_u5-M_u2 U1211/net6 U1211/net4 VSS VSS nch W=0.155u L=0.04u
M_U1211/M_u4-M_u2 N10111 U1211/net14 VSS VSS nch W=0.155u L=0.04u
M_U1211/MI2-M_u2 U1211/net10 n1332 VSS VSS nch W=0.155u L=0.04u
M_U1211/M_u6-M_u2 U1211/net4 n1332 U1211/net14 VDD pch W=0.205u L=0.04u
M_U1211/MI3-M_u2 U1211/net6 U1211/net10 U1211/net14 VDD pch W=0.205u L=0.04u
M_U1211/MI1-M_u3 U1211/net4 n1333 VDD VDD pch W=0.205u L=0.04u
M_U1211/M_u5-M_u3 U1211/net6 U1211/net4 VDD VDD pch W=0.205u L=0.04u
M_U1211/M_u4-M_u3 N10111 U1211/net14 VDD VDD pch W=0.205u L=0.04u
M_U1211/MI2-M_u3 U1211/net10 n1332 VDD VDD pch W=0.205u L=0.04u
M_U1212/MI1-M_u4 n1332 n1334 VSS VSS nch W=0.155u L=0.04u
M_U1212/MI1-M_u3 n1332 n773 VSS VSS nch W=0.155u L=0.04u
M_U1212/MI1-M_u1 U1212/XI1-net8 n773 VDD VDD pch W=0.205u L=0.04u
M_U1212/MI1-M_u2 n1332 n1334 U1212/XI1-net8 VDD pch W=0.205u L=0.04u
M_U1213/M_u6-M_u3 U1213/net4 U1213/net10 U1213/net14 VSS nch W=0.155u L=0.04u
M_U1213/MI3-M_u3 U1213/net6 n1335 U1213/net14 VSS nch W=0.155u L=0.04u
M_U1213/MI1-M_u2 U1213/net4 n787 VSS VSS nch W=0.155u L=0.04u
M_U1213/M_u5-M_u2 U1213/net6 U1213/net4 VSS VSS nch W=0.155u L=0.04u
M_U1213/M_u4-M_u2 N10110 U1213/net14 VSS VSS nch W=0.155u L=0.04u
M_U1213/MI2-M_u2 U1213/net10 n1335 VSS VSS nch W=0.155u L=0.04u
M_U1213/M_u6-M_u2 U1213/net4 n1335 U1213/net14 VDD pch W=0.205u L=0.04u
M_U1213/MI3-M_u2 U1213/net6 U1213/net10 U1213/net14 VDD pch W=0.205u L=0.04u
M_U1213/MI1-M_u3 U1213/net4 n787 VDD VDD pch W=0.205u L=0.04u
M_U1213/M_u5-M_u3 U1213/net6 U1213/net4 VDD VDD pch W=0.205u L=0.04u
M_U1213/M_u4-M_u3 N10110 U1213/net14 VDD VDD pch W=0.205u L=0.04u
M_U1213/MI2-M_u3 U1213/net10 n1335 VDD VDD pch W=0.205u L=0.04u
M_U1214/MI2 n1335 n1334 U1214/net27 VSS nch W=0.155u L=0.04u
M_U1214/MI10 U1214/net27 n774 VSS VSS nch W=0.155u L=0.04u
M_U1214/MI11 n1335 n775 VSS VSS nch W=0.155u L=0.04u
M_U1214/MI8 n1335 n774 U1214/net13 VDD pch W=0.205u L=0.04u
M_U1214/M_u2 U1214/net13 n775 VDD VDD pch W=0.205u L=0.04u
M_U1214/MI9 n1335 n1334 U1214/net13 VDD pch W=0.205u L=0.04u
M_U1215/MI8 U1215/net36 n788 U1215/net24 VSS nch W=0.155u L=0.04u
M_U1215/MI9 U1215/net24 n1336 VSS VSS nch W=0.155u L=0.04u
M_U1215/M_u2 n775 n1333 U1215/net36 VSS nch W=0.155u L=0.04u
M_U1215/MI7 n775 n786 U1215/net36 VSS nch W=0.155u L=0.04u
M_U1215/MI6 n775 n786 U1215/net35 VDD pch W=0.205u L=0.04u
M_U1215/MI5 U1215/net35 n1333 VDD VDD pch W=0.205u L=0.04u
M_U1215/MI4 n775 n1336 VDD VDD pch W=0.205u L=0.04u
M_U1215/M_u12 n775 n788 VDD VDD pch W=0.205u L=0.04u
M_U1216/M_u2 n1333 n774 VSS VSS nch W=0.135u L=0.04u
M_U1216/M_u1 n1333 n774 VDD VDD pch W=0.205u L=0.04u
M_U1217/MI0-M_u3 U1217/net4 n792 U1217/net14 VSS nch W=0.155u L=0.04u
M_U1217/M_u7-M_u3 U1217/net6 U1217/net10 U1217/net14 VSS nch W=0.17u L=0.04u
M_U1217/M_u2-M_u2 U1217/net4 n1337 VSS VSS nch W=0.155u L=0.04u
M_U1217/M_u5-M_u2 U1217/net6 U1217/net4 VSS VSS nch W=0.17u L=0.04u
M_U1217/M_u4-M_u2 N10109 U1217/net14 VSS VSS nch W=0.155u L=0.04u
M_U1217/M_u8-M_u2 U1217/net10 n792 VSS VSS nch W=0.155u L=0.04u
M_U1217/MI0-M_u2 U1217/net4 U1217/net10 U1217/net14 VDD pch W=0.255u L=0.04u
M_U1217/M_u7-M_u2 U1217/net6 n792 U1217/net14 VDD pch W=0.28u L=0.04u
M_U1217/M_u2-M_u3 U1217/net4 n1337 VDD VDD pch W=0.205u L=0.04u
M_U1217/M_u5-M_u3 U1217/net6 U1217/net4 VDD VDD pch W=0.24u L=0.04u
M_U1217/M_u4-M_u3 N10109 U1217/net14 VDD VDD pch W=0.205u L=0.04u
M_U1217/M_u8-M_u3 U1217/net10 n792 VDD VDD pch W=0.205u L=0.04u
M_U1218/MU1-M_u2 n1337 U1218/net7 VSS VSS nch W=0.155u L=0.04u
M_U1218/M_u7-M_u4 U1218/net7 n777 VSS VSS nch W=0.155u L=0.04u
M_U1218/M_u7-M_u3 U1218/net7 n1338 VSS VSS nch W=0.155u L=0.04u
M_U1218/MU1-M_u3 n1337 U1218/net7 VDD VDD pch W=0.205u L=0.04u
M_U1218/M_u7-M_u1 U1218/X_u7-net8 n1338 VDD VDD pch W=0.205u L=0.04u
M_U1218/M_u7-M_u2 U1218/net7 n777 U1218/X_u7-net8 VDD pch W=0.205u L=0.04u
M_U1219/MI14 n777 n788 U1219/net26 VSS nch W=0.155u L=0.04u
M_U1219/MI7 n777 n787 U1219/net26 VSS nch W=0.155u L=0.04u
M_U1219/MI6 U1219/net29 n1339 VSS VSS nch W=0.155u L=0.04u
M_U1219/M_u4 U1219/net26 n785 U1219/net29 VSS nch W=0.155u L=0.04u
M_U1219/MI5 U1219/net26 n786 U1219/net29 VSS nch W=0.155u L=0.04u
M_U1219/MI13 n777 n787 U1219/net43 VDD pch W=0.205u L=0.04u
M_U1219/MI11 n777 n786 U1219/net49 VDD pch W=0.205u L=0.04u
M_U1219/MI9 U1219/net49 n785 VDD VDD pch W=0.205u L=0.04u
M_U1219/MI12 U1219/net43 n788 VDD VDD pch W=0.205u L=0.04u
M_U1219/MU24 n777 n1339 VDD VDD pch W=0.205u L=0.04u
M_U1220/MI1-M_u4 n1339 n783 VSS VSS nch W=0.155u L=0.04u
M_U1220/MI1-M_u3 n1339 n784 VSS VSS nch W=0.155u L=0.04u
M_U1220/MI1-M_u1 U1220/XI1-net8 n784 VDD VDD pch W=0.205u L=0.04u
M_U1220/MI1-M_u2 n1339 n783 U1220/XI1-net8 VDD pch W=0.205u L=0.04u
M_U1221/MU1-M_u4 U1221/XU1-net6 n774 VSS VSS nch W=0.155u L=0.04u
M_U1221/MU1-M_u3 n788 n1340 U1221/XU1-net6 VSS nch W=0.155u L=0.04u
M_U1221/MU1-M_u2 n788 n774 VDD VDD pch W=0.155u L=0.04u
M_U1221/MU1-M_u1 n788 n1340 VDD VDD pch W=0.155u L=0.04u
M_U1222/M_u5 VSS n1005 U1222/net22 VSS nch W=0.155u L=0.04u
M_U1222/MI8 U1222/net22 n892 N10759 VSS nch W=0.155u L=0.04u
M_U1222/MI7 U1222/net22 n971 N10759 VSS nch W=0.155u L=0.04u
M_U1222/MI6 U1222/net22 n891 N10759 VSS nch W=0.155u L=0.04u
M_U1222/MI3 U1222/net38 n891 VDD VDD pch W=0.205u L=0.04u
M_U1222/MI4 U1222/net35 n971 U1222/net38 VDD pch W=0.205u L=0.04u
M_U1222/MI5 N10759 n892 U1222/net35 VDD pch W=0.205u L=0.04u
M_U1222/M_u11 N10759 n1005 VDD VDD pch W=0.205u L=0.04u
M_U1223/MI2 n1005 n1220 U1223/net27 VSS nch W=0.155u L=0.04u
M_U1223/MI10 U1223/net27 N38 VSS VSS nch W=0.155u L=0.04u
M_U1223/MI11 n1005 n974 VSS VSS nch W=0.155u L=0.04u
M_U1223/MI8 n1005 N38 U1223/net13 VDD pch W=0.205u L=0.04u
M_U1223/M_u2 U1223/net13 n974 VDD VDD pch W=0.205u L=0.04u
M_U1223/MI9 n1005 n1220 U1223/net13 VDD pch W=0.205u L=0.04u
M_U1224/M_u2 n974 n889 VSS VSS nch W=0.135u L=0.04u
M_U1224/M_u1 n974 n889 VDD VDD pch W=0.205u L=0.04u
M_U1225/M_u2 n1220 N267 VSS VSS nch W=0.135u L=0.04u
M_U1225/M_u1 n1220 N267 VDD VDD pch W=0.205u L=0.04u
M_U1226/MI0-M_u3 U1226/net4 N38 U1226/net14 VSS nch W=0.155u L=0.04u
M_U1226/M_u7-M_u3 U1226/net6 U1226/net10 U1226/net14 VSS nch W=0.17u L=0.04u
M_U1226/M_u2-M_u2 U1226/net4 n1341 VSS VSS nch W=0.155u L=0.04u
M_U1226/M_u5-M_u2 U1226/net6 U1226/net4 VSS VSS nch W=0.17u L=0.04u
M_U1226/M_u4-M_u2 n892 U1226/net14 VSS VSS nch W=0.155u L=0.04u
M_U1226/M_u8-M_u2 U1226/net10 N38 VSS VSS nch W=0.155u L=0.04u
M_U1226/MI0-M_u2 U1226/net4 U1226/net10 U1226/net14 VDD pch W=0.255u L=0.04u
M_U1226/M_u7-M_u2 U1226/net6 N38 U1226/net14 VDD pch W=0.28u L=0.04u
M_U1226/M_u2-M_u3 U1226/net4 n1341 VDD VDD pch W=0.205u L=0.04u
M_U1226/M_u5-M_u3 U1226/net6 U1226/net4 VDD VDD pch W=0.24u L=0.04u
M_U1226/M_u4-M_u3 n892 U1226/net14 VDD VDD pch W=0.205u L=0.04u
M_U1226/M_u8-M_u3 U1226/net10 N38 VDD VDD pch W=0.205u L=0.04u
M_U1227/MU1-M_u4 U1227/XU1-net6 N382 VSS VSS nch W=0.155u L=0.04u
M_U1227/MU1-M_u3 n1341 N267 U1227/XU1-net6 VSS nch W=0.155u L=0.04u
M_U1227/MU1-M_u2 n1341 N382 VDD VDD pch W=0.155u L=0.04u
M_U1227/MU1-M_u1 n1341 N267 VDD VDD pch W=0.155u L=0.04u
M_U1228/M_u2 n971 n973 VSS VSS nch W=0.135u L=0.04u
M_U1228/M_u1 n971 n973 VDD VDD pch W=0.205u L=0.04u
M_U1229/M_u2 n973 n874 U1229/net15 VSS nch W=0.155u L=0.04u
M_U1229/M_u3 n973 n993 U1229/net15 VSS nch W=0.155u L=0.04u
M_U1229/M_u4 U1229/net15 n1008 VSS VSS nch W=0.155u L=0.04u
M_U1229/M_u9 n973 n1008 VDD VDD pch W=0.205u L=0.04u
M_U1229/MI16-MI12 n973 n874 U1229/XI16-net11 VDD pch W=0.205u L=0.04u
M_U1229/MI16-MI13 U1229/XI16-net11 n993 VDD VDD pch W=0.205u L=0.04u
M_U1230/MI19 U1230/net14 n874 U1230/net20 VSS nch W=0.155u L=0.04u
M_U1230/MI11 U1230/net14 n868 U1230/net20 VSS nch W=0.155u L=0.04u
M_U1230/MI20 U1230/net20 n1342 VSS VSS nch W=0.155u L=0.04u
M_U1230/MI8-M_u2 n1008 U1230/net14 VSS VSS nch W=0.155u L=0.04u
M_U1230/MI8-M_u3 n1008 U1230/net14 VDD VDD pch W=0.205u L=0.04u
M_U1230/M_u2 U1230/net14 n1342 VDD VDD pch W=0.205u L=0.04u
M_U1230/MI17 U1230/net24 n874 VDD VDD pch W=0.205u L=0.04u
M_U1230/MI18 U1230/net14 n868 U1230/net24 VDD pch W=0.205u L=0.04u
M_U1231/MU20 n868 n1343 VSS VSS nch W=0.155u L=0.04u
M_U1231/MI17-M_u10 n868 n883 U1231/XI17-net17 VSS nch W=0.155u L=0.04u
M_U1231/MI17-M_u11 U1231/XI17-net17 n870 VSS VSS nch W=0.155u L=0.04u
M_U1231/MI10-M_u10 n868 n991 U1231/XI10-net17 VSS nch W=0.155u L=0.04u
M_U1231/MI10-M_u11 U1231/XI10-net17 n871 VSS VSS nch W=0.155u L=0.04u
M_U1231/MI9 U1231/net30 n991 n868 VDD pch W=0.205u L=0.04u
M_U1231/MI8 U1231/net30 n871 n868 VDD pch W=0.205u L=0.04u
M_U1231/MU22 VDD n1343 U1231/net36 VDD pch W=0.205u L=0.04u
M_U1231/MI6 U1231/net36 n870 U1231/net30 VDD pch W=0.205u L=0.04u
M_U1231/MI7 U1231/net36 n883 U1231/net30 VDD pch W=0.205u L=0.04u
M_U1232/M_u2 n1343 n1344 VSS VSS nch W=0.135u L=0.04u
M_U1232/M_u1 n1343 n1344 VDD VDD pch W=0.205u L=0.04u
M_U1233/M_u2 n870 n882 U1233/net15 VSS nch W=0.155u L=0.04u
M_U1233/M_u3 n870 n867 U1233/net15 VSS nch W=0.155u L=0.04u
M_U1233/M_u4 U1233/net15 n1345 VSS VSS nch W=0.155u L=0.04u
M_U1233/M_u9 n870 n1345 VDD VDD pch W=0.205u L=0.04u
M_U1233/MI16-MI12 n870 n882 U1233/XI16-net11 VDD pch W=0.205u L=0.04u
M_U1233/MI16-MI13 U1233/XI16-net11 n867 VDD VDD pch W=0.205u L=0.04u
M_U1234/MU1-M_u4 U1234/XU1-net6 n883 VSS VSS nch W=0.155u L=0.04u
M_U1234/MU1-M_u3 n993 n989 U1234/XU1-net6 VSS nch W=0.155u L=0.04u
M_U1234/MU1-M_u2 n993 n883 VDD VDD pch W=0.155u L=0.04u
M_U1234/MU1-M_u1 n993 n989 VDD VDD pch W=0.155u L=0.04u
M_U1235/M_u2 n883 n1007 VSS VSS nch W=0.135u L=0.04u
M_U1235/M_u1 n883 n1007 VDD VDD pch W=0.205u L=0.04u
M_U1236/MU1-M_u4 U1236/XU1-net6 n871 VSS VSS nch W=0.155u L=0.04u
M_U1236/MU1-M_u3 n1007 n869 U1236/XU1-net6 VSS nch W=0.155u L=0.04u
M_U1236/MU1-M_u2 n1007 n871 VDD VDD pch W=0.155u L=0.04u
M_U1236/MU1-M_u1 n1007 n869 VDD VDD pch W=0.155u L=0.04u
M_U1237/M_u2 n871 n873 VSS VSS nch W=0.135u L=0.04u
M_U1237/M_u1 n871 n873 VDD VDD pch W=0.205u L=0.04u
M_U1238/M_u2 n873 n1305 U1238/net15 VSS nch W=0.155u L=0.04u
M_U1238/M_u3 n873 n1215 U1238/net15 VSS nch W=0.155u L=0.04u
M_U1238/M_u4 U1238/net15 n1344 VSS VSS nch W=0.155u L=0.04u
M_U1238/M_u9 n873 n1344 VDD VDD pch W=0.205u L=0.04u
M_U1238/MI16-MI12 n873 n1305 U1238/XI16-net11 VDD pch W=0.205u L=0.04u
M_U1238/MI16-MI13 U1238/XI16-net11 n1215 VDD VDD pch W=0.205u L=0.04u
M_U1239/MU1-M_u4 U1239/XU1-net6 n1305 VSS VSS nch W=0.155u L=0.04u
M_U1239/MU1-M_u3 n1344 n1215 U1239/XU1-net6 VSS nch W=0.155u L=0.04u
M_U1239/MU1-M_u2 n1344 n1305 VDD VDD pch W=0.155u L=0.04u
M_U1239/MU1-M_u1 n1344 n1215 VDD VDD pch W=0.155u L=0.04u
M_U1240/M_u2 n1215 N257 VSS VSS nch W=0.135u L=0.04u
M_U1240/M_u1 n1215 N257 VDD VDD pch W=0.205u L=0.04u
M_U1241/MI12 U1241/net32 n1050 VSS VSS nch W=0.155u L=0.04u
M_U1241/MI11 U1241/net59 N214 U1241/net32 VSS nch W=0.155u L=0.04u
M_U1241/MI6 U1241/net59 n1185 VSS VSS nch W=0.155u L=0.04u
M_U1241/MI8-M_u2 n1305 U1241/net59 VSS VSS nch W=0.155u L=0.04u
M_U1241/MI8-M_u3 n1305 U1241/net59 VDD VDD pch W=0.2u L=0.04u
M_U1241/MI10 U1241/net59 N214 U1241/net22 VDD pch W=0.205u L=0.04u
M_U1241/MI9 U1241/net59 n1050 U1241/net22 VDD pch W=0.205u L=0.04u
M_U1241/M_u2 U1241/net22 n1185 VDD VDD pch W=0.2u L=0.04u
M_U1242/MI2 n869 n1306 U1242/net27 VSS nch W=0.155u L=0.04u
M_U1242/MI10 U1242/net27 N106 VSS VSS nch W=0.155u L=0.04u
M_U1242/MI11 n869 n991 VSS VSS nch W=0.155u L=0.04u
M_U1242/MI8 n869 N106 U1242/net13 VDD pch W=0.205u L=0.04u
M_U1242/M_u2 U1242/net13 n991 VDD VDD pch W=0.205u L=0.04u
M_U1242/MI9 n869 n1306 U1242/net13 VDD pch W=0.205u L=0.04u
M_U1243/MI1-M_u4 n991 n1306 VSS VSS nch W=0.155u L=0.04u
M_U1243/MI1-M_u3 n991 N106 VSS VSS nch W=0.155u L=0.04u
M_U1243/MI1-M_u1 U1243/XI1-net8 N106 VDD VDD pch W=0.205u L=0.04u
M_U1243/MI1-M_u2 n991 n1306 U1243/XI1-net8 VDD pch W=0.205u L=0.04u
M_U1244/M_u2 n1306 N215 U1244/net15 VSS nch W=0.155u L=0.04u
M_U1244/M_u3 n1306 n1185 U1244/net15 VSS nch W=0.155u L=0.04u
M_U1244/M_u4 U1244/net15 n1050 VSS VSS nch W=0.155u L=0.04u
M_U1244/M_u9 n1306 n1050 VDD VDD pch W=0.205u L=0.04u
M_U1244/MI16-MI12 n1306 N215 U1244/XI16-net11 VDD pch W=0.205u L=0.04u
M_U1244/MI16-MI13 U1244/XI16-net11 n1185 VDD VDD pch W=0.205u L=0.04u
M_U1245/MU1-M_u4 n989 n987 VSS VSS nch W=0.155u L=0.04u
M_U1245/MU1-M_u3 n989 U1245/net4 VSS VSS nch W=0.155u L=0.04u
M_U1245/MU6-M_u2 U1245/net4 n880 VSS VSS nch W=0.155u L=0.04u
M_U1245/MU1-M_u1 U1245/XU1-net8 U1245/net4 VDD VDD pch W=0.205u L=0.04u
M_U1245/MU1-M_u2 n989 n987 U1245/XU1-net8 VDD pch W=0.205u L=0.04u
M_U1245/MU6-M_u3 U1245/net4 n880 VDD VDD pch W=0.205u L=0.04u
M_U1246/MI8 U1246/net36 n1010 U1246/net24 VSS nch W=0.155u L=0.04u
M_U1246/MI9 U1246/net24 n1011 VSS VSS nch W=0.155u L=0.04u
M_U1246/M_u2 U1246/net33 n1004 U1246/net36 VSS nch W=0.155u L=0.04u
M_U1246/MI7 U1246/net33 n1009 U1246/net36 VSS nch W=0.155u L=0.04u
M_U1246/MI11-M_u2 n987 U1246/net33 VSS VSS nch W=0.155u L=0.04u
M_U1246/MI11-M_u3 n987 U1246/net33 VDD VDD pch W=0.205u L=0.04u
M_U1246/MI6 U1246/net33 n1009 U1246/net35 VDD pch W=0.205u L=0.04u
M_U1246/MI5 U1246/net35 n1004 VDD VDD pch W=0.205u L=0.04u
M_U1246/MI4 U1246/net33 n1011 VDD VDD pch W=0.205u L=0.04u
M_U1246/M_u12 U1246/net33 n1010 VDD VDD pch W=0.205u L=0.04u
M_U1247/MI8 n1011 n983 U1247/net23 VDD pch W=0.205u L=0.04u
M_U1247/MI6 n1011 n950 U1247/net23 VDD pch W=0.205u L=0.04u
M_U1247/MI7 n1011 n898 U1247/net23 VDD pch W=0.205u L=0.04u
M_U1247/MU20 U1247/net23 n1226 VDD VDD pch W=0.205u L=0.04u
M_U1247/MI5 U1247/net23 n1346 VDD VDD pch W=0.205u L=0.04u
M_U1247/MI20-MI12 U1247/XI20-net13 n950 VSS VSS nch W=0.155u L=0.04u
M_U1247/MI20-M_u10 n1011 n983 U1247/XI20-net17 VSS nch W=0.155u L=0.04u
M_U1247/MI20-M_u11 U1247/XI20-net17 n898 U1247/XI20-net13 VSS nch W=0.155u L=0.04u
M_U1247/MI17-M_u10 n1011 n1226 U1247/XI17-net17 VSS nch W=0.155u L=0.04u
M_U1247/MI17-M_u11 U1247/XI17-net17 n1346 VSS VSS nch W=0.155u L=0.04u
M_U1248/M_u2 n1346 n1272 VSS VSS nch W=0.135u L=0.04u
M_U1248/M_u1 n1346 n1272 VDD VDD pch W=0.205u L=0.04u
M_U1249/M_u2 n1226 N303 VSS VSS nch W=0.135u L=0.04u
M_U1249/M_u1 n1226 N303 VDD VDD pch W=0.205u L=0.04u
M_U1250/MI9 n898 N289 U1250/net10 VSS nch W=0.155u L=0.04u
M_U1250/M_u4 U1250/net10 n942 VSS VSS nch W=0.155u L=0.04u
M_U1250/MI8 n898 n1273 U1250/net10 VSS nch W=0.155u L=0.04u
M_U1250/MI7 U1250/net10 n1347 VSS VSS nch W=0.155u L=0.04u
M_U1250/MU24 U1250/net30 n942 VDD VDD pch W=0.205u L=0.04u
M_U1250/MI6 n898 N289 U1250/net24 VDD pch W=0.205u L=0.04u
M_U1250/MI5 U1250/net24 n1273 VDD VDD pch W=0.205u L=0.04u
M_U1250/MI4 n898 n1347 U1250/net30 VDD pch W=0.205u L=0.04u
M_U1251/M_u3 U1251/net11 n943 n1347 VDD pch W=0.205u L=0.04u
M_U1251/MI0 U1251/net11 n928 n1347 VDD pch W=0.205u L=0.04u
M_U1251/MI16-MI12 U1251/net11 n921 U1251/XI16-net11 VDD pch W=0.205u L=0.04u
M_U1251/MI16-MI13 U1251/XI16-net11 n922 VDD VDD pch W=0.205u L=0.04u
M_U1251/MI2 n1347 n922 VSS VSS nch W=0.155u L=0.04u
M_U1251/M_u13 n1347 n921 VSS VSS nch W=0.155u L=0.04u
M_U1251/MI12-M_u10 n1347 n943 U1251/XI12-net17 VSS nch W=0.155u L=0.04u
M_U1251/MI12-M_u11 U1251/XI12-net17 n928 VSS VSS nch W=0.155u L=0.04u
M_U1252/MI1-M_u4 n922 n1000 VSS VSS nch W=0.155u L=0.04u
M_U1252/MI1-M_u3 n922 n925 VSS VSS nch W=0.155u L=0.04u
M_U1252/MI1-M_u1 U1252/XI1-net8 n925 VDD VDD pch W=0.205u L=0.04u
M_U1252/MI1-M_u2 n922 n1000 U1252/XI1-net8 VDD pch W=0.205u L=0.04u
M_U1253/M_u2 n1000 n1348 VSS VSS nch W=0.135u L=0.04u
M_U1253/M_u1 n1000 n1348 VDD VDD pch W=0.205u L=0.04u
M_U1254/M_u2 n921 n1349 VSS VSS nch W=0.135u L=0.04u
M_U1254/M_u1 n921 n1349 VDD VDD pch W=0.205u L=0.04u
M_U1255/MU1-M_u4 U1255/XU1-net6 n924 VSS VSS nch W=0.155u L=0.04u
M_U1255/MU1-M_u3 n928 n1003 U1255/XU1-net6 VSS nch W=0.155u L=0.04u
M_U1255/MU1-M_u2 n928 n924 VDD VDD pch W=0.155u L=0.04u
M_U1255/MU1-M_u1 n928 n1003 VDD VDD pch W=0.155u L=0.04u
M_U1256/MU1-M_u4 U1256/XU1-net6 n938 VSS VSS nch W=0.155u L=0.04u
M_U1256/MU1-M_u3 n1003 n918 U1256/XU1-net6 VSS nch W=0.155u L=0.04u
M_U1256/MU1-M_u2 n1003 n938 VDD VDD pch W=0.155u L=0.04u
M_U1256/MU1-M_u1 n1003 n918 VDD VDD pch W=0.155u L=0.04u
M_U1257/MU1-M_u4 U1257/XU1-net6 n905 VSS VSS nch W=0.155u L=0.04u
M_U1257/MU1-M_u3 n1010 n950 U1257/XU1-net6 VSS nch W=0.155u L=0.04u
M_U1257/MU1-M_u2 n1010 n905 VDD VDD pch W=0.155u L=0.04u
M_U1257/MU1-M_u1 n1010 n950 VDD VDD pch W=0.155u L=0.04u
M_U1258/MU1 U1258/net8 n906 U1258/net26 VSS nch W=0.155u L=0.04u
M_U1258/MI5 U1258/net26 n903 VSS VSS nch W=0.155u L=0.04u
M_U1258/MI6 U1258/net29 U1258/net8 VSS VSS nch W=0.155u L=0.04u
M_U1258/MU9 U1258/net29 N299 n905 VSS nch W=0.155u L=0.04u
M_U1258/MU10 U1258/net29 n1274 n905 VSS nch W=0.155u L=0.04u
M_U1258/MU3 U1258/net8 n903 VDD VDD pch W=0.205u L=0.04u
M_U1258/MI1 U1258/net8 n906 VDD VDD pch W=0.205u L=0.04u
M_U1258/MI2 n905 U1258/net8 VDD VDD pch W=0.205u L=0.04u
M_U1258/MI4 n905 N299 U1258/net20 VDD pch W=0.205u L=0.04u
M_U1258/MI3 U1258/net20 n1274 VDD VDD pch W=0.205u L=0.04u
M_U1259/MI9 n906 N296 U1259/net10 VSS nch W=0.155u L=0.04u
M_U1259/M_u4 U1259/net10 n977 VSS VSS nch W=0.155u L=0.04u
M_U1259/MI8 n906 n1271 U1259/net10 VSS nch W=0.155u L=0.04u
M_U1259/MI7 U1259/net10 n978 VSS VSS nch W=0.155u L=0.04u
M_U1259/MU24 U1259/net30 n977 VDD VDD pch W=0.205u L=0.04u
M_U1259/MI6 n906 N296 U1259/net24 VDD pch W=0.205u L=0.04u
M_U1259/MI5 U1259/net24 n1271 VDD VDD pch W=0.205u L=0.04u
M_U1259/MI4 n906 n978 U1259/net30 VDD pch W=0.205u L=0.04u
M_U1260/MI0-M_u4 n1009 n950 U1260/XI0-net10 VSS nch W=0.155u L=0.04u
M_U1260/MI0-M_u5 U1260/XI0-net10 n983 U1260/XI0-net13 VSS nch W=0.155u L=0.04u
M_U1260/MI0-M_u6 U1260/XI0-net13 n896 VSS VSS nch W=0.155u L=0.04u
M_U1260/MI0-M_u3 n1009 n896 VDD VDD pch W=0.205u L=0.04u
M_U1260/MI0-M_u1 n1009 n950 VDD VDD pch W=0.205u L=0.04u
M_U1260/MI0-M_u2 n1009 n983 VDD VDD pch W=0.205u L=0.04u
M_U1261/M_u4 n896 n939 VSS VSS nch W=0.155u L=0.04u
M_U1261/MI2 n896 n923 VSS VSS nch W=0.155u L=0.04u
M_U1261/MI3 n896 n942 VSS VSS nch W=0.155u L=0.04u
M_U1261/M_u1 U1261/net25 n939 VDD VDD pch W=0.41u L=0.04u
M_U1261/MI0 U1261/net28 n923 U1261/net25 VDD pch W=0.41u L=0.04u
M_U1261/MI1 n896 n942 U1261/net28 VDD pch W=0.41u L=0.04u
M_U1262/MU1-M_u4 U1262/XU1-net6 n938 VSS VSS nch W=0.155u L=0.04u
M_U1262/MU1-M_u3 n939 n937 U1262/XU1-net6 VSS nch W=0.155u L=0.04u
M_U1262/MU1-M_u2 n939 n938 VDD VDD pch W=0.155u L=0.04u
M_U1262/MU1-M_u1 n939 n937 VDD VDD pch W=0.155u L=0.04u
M_U1263/M_u2 n938 n941 VSS VSS nch W=0.135u L=0.04u
M_U1263/M_u1 n938 n941 VDD VDD pch W=0.205u L=0.04u
M_U1264/M_u2 n941 n1350 U1264/net15 VSS nch W=0.155u L=0.04u
M_U1264/M_u3 n941 n1234 U1264/net15 VSS nch W=0.155u L=0.04u
M_U1264/M_u4 U1264/net15 n924 VSS VSS nch W=0.155u L=0.04u
M_U1264/M_u9 n941 n924 VDD VDD pch W=0.205u L=0.04u
M_U1264/MI16-MI12 n941 n1350 U1264/XI16-net11 VDD pch W=0.205u L=0.04u
M_U1264/MI16-MI13 U1264/XI16-net11 n1234 VDD VDD pch W=0.205u L=0.04u
M_U1265/MU1-M_u4 U1265/XU1-net6 n1234 VSS VSS nch W=0.155u L=0.04u
M_U1265/MU1-M_u3 n924 n1350 U1265/XU1-net6 VSS nch W=0.155u L=0.04u
M_U1265/MU1-M_u2 n924 n1234 VDD VDD pch W=0.155u L=0.04u
M_U1265/MU1-M_u1 n924 n1350 VDD VDD pch W=0.155u L=0.04u
M_U1266/M_u2 n1234 N280 VSS VSS nch W=0.135u L=0.04u
M_U1266/M_u1 n1234 N280 VDD VDD pch W=0.205u L=0.04u
M_U1267/M_u2 n1350 n1278 VSS VSS nch W=0.135u L=0.04u
M_U1267/M_u1 n1350 n1278 VDD VDD pch W=0.205u L=0.04u
M_U1268/MI15-M_u2 U1268/net19 N18 VSS VSS nch W=0.155u L=0.04u
M_U1268/MI21 n1278 N18 U1268/net40 VSS nch W=0.155u L=0.04u
M_U1268/MI12 n1278 U1268/net19 U1268/net36 VSS nch W=0.155u L=0.04u
M_U1268/MI20 U1268/net40 N160 VSS VSS nch W=0.31u L=0.04u
M_U1268/MI19 U1268/net36 N138 VSS VSS nch W=0.155u L=0.04u
M_U1268/MI15-M_u3 U1268/net19 N18 VDD VDD pch W=0.205u L=0.04u
M_U1268/MI25 n1278 U1268/net19 U1268/net26 VDD pch W=0.325u L=0.04u
M_U1268/MI24 U1268/net26 N160 VDD VDD pch W=0.41u L=0.04u
M_U1268/MI5 n1278 N18 U1268/net30 VDD pch W=0.325u L=0.04u
M_U1268/MI111 U1268/net30 N138 VDD VDD pch W=0.205u L=0.04u
M_U1269/M_u2 n937 n940 VSS VSS nch W=0.135u L=0.04u
M_U1269/M_u1 n937 n940 VDD VDD pch W=0.205u L=0.04u
M_U1270/MI2-M_u2 U1270/net13 n918 VSS VSS nch W=0.155u L=0.04u
M_U1270/MI13 U1270/net16 U1270/net13 VSS VSS nch W=0.155u L=0.04u
M_U1270/MI12 n940 n933 U1270/net16 VSS nch W=0.155u L=0.04u
M_U1270/MI2-M_u3 U1270/net13 n918 VDD VDD pch W=0.205u L=0.04u
M_U1270/M_u16 VDD U1270/net13 n940 VDD pch W=0.205u L=0.04u
M_U1270/MI11 VDD n933 n940 VDD pch W=0.205u L=0.04u
M_U1271/MU1-M_u4 U1271/XU1-net6 n1282 VSS VSS nch W=0.155u L=0.04u
M_U1271/MU1-M_u3 n933 N277 U1271/XU1-net6 VSS nch W=0.155u L=0.04u
M_U1271/MU1-M_u2 n933 n1282 VDD VDD pch W=0.155u L=0.04u
M_U1271/MU1-M_u1 n933 N277 VDD VDD pch W=0.155u L=0.04u
M_U1272/MI1-M_u4 n918 n1282 VSS VSS nch W=0.155u L=0.04u
M_U1272/MI1-M_u3 n918 N277 VSS VSS nch W=0.155u L=0.04u
M_U1272/MI1-M_u1 U1272/XI1-net8 N277 VDD VDD pch W=0.205u L=0.04u
M_U1272/MI1-M_u2 n918 n1282 U1272/XI1-net8 VDD pch W=0.205u L=0.04u
M_U1273/MI15-M_u2 U1273/net19 N18 VSS VSS nch W=0.155u L=0.04u
M_U1273/MI21 n1282 N18 U1273/net40 VSS nch W=0.155u L=0.04u
M_U1273/MI12 n1282 U1273/net19 U1273/net36 VSS nch W=0.155u L=0.04u
M_U1273/MI20 U1273/net40 N151 VSS VSS nch W=0.31u L=0.04u
M_U1273/MI19 U1273/net36 N147 VSS VSS nch W=0.155u L=0.04u
M_U1273/MI15-M_u3 U1273/net19 N18 VDD VDD pch W=0.205u L=0.04u
M_U1273/MI25 n1282 U1273/net19 U1273/net26 VDD pch W=0.325u L=0.04u
M_U1273/MI24 U1273/net26 N151 VDD VDD pch W=0.41u L=0.04u
M_U1273/MI5 n1282 N18 U1273/net30 VDD pch W=0.325u L=0.04u
M_U1273/MI111 U1273/net30 N147 VDD VDD pch W=0.205u L=0.04u
M_U1274/M_u2 n923 n943 VSS VSS nch W=0.135u L=0.04u
M_U1274/M_u1 n923 n943 VDD VDD pch W=0.205u L=0.04u
M_U1275/MI1-M_u4 n943 n997 VSS VSS nch W=0.155u L=0.04u
M_U1275/MI1-M_u3 n943 n925 VSS VSS nch W=0.155u L=0.04u
M_U1275/MI1-M_u1 U1275/XI1-net8 n925 VDD VDD pch W=0.205u L=0.04u
M_U1275/MI1-M_u2 n943 n997 U1275/XI1-net8 VDD pch W=0.205u L=0.04u
M_U1276/M_u2 n925 n1276 U1276/net15 VSS nch W=0.155u L=0.04u
M_U1276/M_u3 n925 n1227 U1276/net15 VSS nch W=0.155u L=0.04u
M_U1276/M_u4 U1276/net15 n1349 VSS VSS nch W=0.155u L=0.04u
M_U1276/M_u9 n925 n1349 VDD VDD pch W=0.205u L=0.04u
M_U1276/MI16-MI12 n925 n1276 U1276/XI16-net11 VDD pch W=0.205u L=0.04u
M_U1276/MI16-MI13 U1276/XI16-net11 n1227 VDD VDD pch W=0.205u L=0.04u
M_U1277/MU1-M_u4 U1277/XU1-net6 n1227 VSS VSS nch W=0.155u L=0.04u
M_U1277/MU1-M_u3 n1349 n1276 U1277/XU1-net6 VSS nch W=0.155u L=0.04u
M_U1277/MU1-M_u2 n1349 n1227 VDD VDD pch W=0.155u L=0.04u
M_U1277/MU1-M_u1 n1349 n1276 VDD VDD pch W=0.155u L=0.04u
M_U1278/M_u2 n1227 N286 VSS VSS nch W=0.135u L=0.04u
M_U1278/M_u1 n1227 N286 VDD VDD pch W=0.205u L=0.04u
M_U1279/MU29-M_u2 n1276 U1279/net28 VSS VSS nch W=0.155u L=0.04u
M_U1279/MI111 U1279/net47 N158 VSS VSS nch W=0.155u L=0.04u
M_U1279/MI5 U1279/net28 U1279/net6 U1279/net47 VSS nch W=0.155u L=0.04u
M_U1279/MI14 U1279/net44 N135 VSS VSS nch W=0.155u L=0.04u
M_U1279/MI13 U1279/net28 n1184 U1279/net44 VSS nch W=0.155u L=0.04u
M_U1279/MU24 U1279/net6 n1184 VSS VSS nch W=0.155u L=0.04u
M_U1279/MU29-M_u3 n1276 U1279/net28 VDD VDD pch W=0.205u L=0.04u
M_U1279/MI2 VDD N158 U1279/net47 VDD pch W=0.205u L=0.04u
M_U1279/MI4 U1279/net47 n1184 U1279/net28 VDD pch W=0.205u L=0.04u
M_U1279/MI12 U1279/net44 U1279/net6 U1279/net28 VDD pch W=0.205u L=0.04u
M_U1279/MI10 VDD N135 U1279/net44 VDD pch W=0.205u L=0.04u
M_U1279/MU25 VDD n1184 U1279/net6 VDD pch W=0.205u L=0.04u
M_U1280/M_u2 n997 n935 VSS VSS nch W=0.135u L=0.04u
M_U1280/M_u1 n997 n935 VDD VDD pch W=0.205u L=0.04u
M_U1281/MI2 n935 n1277 U1281/net27 VSS nch W=0.155u L=0.04u
M_U1281/MI10 U1281/net27 N283 VSS VSS nch W=0.155u L=0.04u
M_U1281/MI11 n935 n1348 VSS VSS nch W=0.155u L=0.04u
M_U1281/MI8 n935 N283 U1281/net13 VDD pch W=0.205u L=0.04u
M_U1281/M_u2 U1281/net13 n1348 VDD VDD pch W=0.205u L=0.04u
M_U1281/MI9 n935 n1277 U1281/net13 VDD pch W=0.205u L=0.04u
M_U1282/MI1-M_u4 n1348 n1277 VSS VSS nch W=0.155u L=0.04u
M_U1282/MI1-M_u3 n1348 N283 VSS VSS nch W=0.155u L=0.04u
M_U1282/MI1-M_u1 U1282/XI1-net8 N283 VDD VDD pch W=0.205u L=0.04u
M_U1282/MI1-M_u2 n1348 n1277 U1282/XI1-net8 VDD pch W=0.205u L=0.04u
M_U1283/MI15-M_u2 U1283/net19 N18 VSS VSS nch W=0.155u L=0.04u
M_U1283/MI21 n1277 N18 U1283/net40 VSS nch W=0.155u L=0.04u
M_U1283/MI12 n1277 U1283/net19 U1283/net36 VSS nch W=0.155u L=0.04u
M_U1283/MI20 U1283/net40 N159 VSS VSS nch W=0.31u L=0.04u
M_U1283/MI19 U1283/net36 N144 VSS VSS nch W=0.155u L=0.04u
M_U1283/MI15-M_u3 U1283/net19 N18 VDD VDD pch W=0.205u L=0.04u
M_U1283/MI25 n1277 U1283/net19 U1283/net26 VDD pch W=0.325u L=0.04u
M_U1283/MI24 U1283/net26 N159 VDD VDD pch W=0.41u L=0.04u
M_U1283/MI5 n1277 N18 U1283/net30 VDD pch W=0.325u L=0.04u
M_U1283/MI111 U1283/net30 N144 VDD VDD pch W=0.205u L=0.04u
M_U1284/M_u6-M_u3 U1284/net4 U1284/net10 U1284/net14 VSS nch W=0.155u L=0.04u
M_U1284/MI3-M_u3 U1284/net6 n1273 U1284/net14 VSS nch W=0.155u L=0.04u
M_U1284/MI1-M_u2 U1284/net4 n1225 VSS VSS nch W=0.155u L=0.04u
M_U1284/M_u5-M_u2 U1284/net6 U1284/net4 VSS VSS nch W=0.155u L=0.04u
M_U1284/M_u4-M_u2 n942 U1284/net14 VSS VSS nch W=0.155u L=0.04u
M_U1284/MI2-M_u2 U1284/net10 n1273 VSS VSS nch W=0.155u L=0.04u
M_U1284/M_u6-M_u2 U1284/net4 n1273 U1284/net14 VDD pch W=0.205u L=0.04u
M_U1284/MI3-M_u2 U1284/net6 U1284/net10 U1284/net14 VDD pch W=0.205u L=0.04u
M_U1284/MI1-M_u3 U1284/net4 n1225 VDD VDD pch W=0.205u L=0.04u
M_U1284/M_u5-M_u3 U1284/net6 U1284/net4 VDD VDD pch W=0.205u L=0.04u
M_U1284/M_u4-M_u3 n942 U1284/net14 VDD VDD pch W=0.205u L=0.04u
M_U1284/MI2-M_u3 U1284/net10 n1273 VDD VDD pch W=0.205u L=0.04u
M_U1285/M_u2 n1225 N289 VSS VSS nch W=0.135u L=0.04u
M_U1285/M_u1 n1225 N289 VDD VDD pch W=0.205u L=0.04u
M_U1286/M_u2 n1273 N157 U1286/net15 VSS nch W=0.155u L=0.04u
M_U1286/M_u3 n1273 n1185 U1286/net15 VSS nch W=0.155u L=0.04u
M_U1286/M_u4 U1286/net15 n1050 VSS VSS nch W=0.155u L=0.04u
M_U1286/M_u9 n1273 n1050 VDD VDD pch W=0.205u L=0.04u
M_U1286/MI16-MI12 n1273 N157 U1286/XI16-net11 VDD pch W=0.205u L=0.04u
M_U1286/MI16-MI13 U1286/XI16-net11 n1185 VDD VDD pch W=0.205u L=0.04u
M_U1287/M_u3-M_u2 n983 U1287/net6 VSS VSS nch W=0.155u L=0.04u
M_U1287/M_u2-M_u4 U1287/X_u2-net6 n903 VSS VSS nch W=0.155u L=0.04u
M_U1287/M_u2-M_u3 U1287/net6 n980 U1287/X_u2-net6 VSS nch W=0.155u L=0.04u
M_U1287/M_u3-M_u3 n983 U1287/net6 VDD VDD pch W=0.205u L=0.04u
M_U1287/M_u2-M_u2 U1287/net6 n903 VDD VDD pch W=0.205u L=0.04u
M_U1287/M_u2-M_u1 U1287/net6 n980 VDD VDD pch W=0.205u L=0.04u
M_U1288/MI0-M_u3 U1288/net4 n1274 U1288/net14 VSS nch W=0.155u L=0.04u
M_U1288/M_u7-M_u3 U1288/net6 U1288/net10 U1288/net14 VSS nch W=0.17u L=0.04u
M_U1288/M_u2-M_u2 U1288/net4 n1176 VSS VSS nch W=0.155u L=0.04u
M_U1288/M_u5-M_u2 U1288/net6 U1288/net4 VSS VSS nch W=0.17u L=0.04u
M_U1288/M_u4-M_u2 n903 U1288/net14 VSS VSS nch W=0.155u L=0.04u
M_U1288/M_u8-M_u2 U1288/net10 n1274 VSS VSS nch W=0.155u L=0.04u
M_U1288/MI0-M_u2 U1288/net4 U1288/net10 U1288/net14 VDD pch W=0.255u L=0.04u
M_U1288/M_u7-M_u2 U1288/net6 n1274 U1288/net14 VDD pch W=0.28u L=0.04u
M_U1288/M_u2-M_u3 U1288/net4 n1176 VDD VDD pch W=0.205u L=0.04u
M_U1288/M_u5-M_u3 U1288/net6 U1288/net4 VDD VDD pch W=0.24u L=0.04u
M_U1288/M_u4-M_u3 n903 U1288/net14 VDD VDD pch W=0.205u L=0.04u
M_U1288/M_u8-M_u3 U1288/net10 n1274 VDD VDD pch W=0.205u L=0.04u
M_U1289/M_u2 n1176 N299 VSS VSS nch W=0.135u L=0.04u
M_U1289/M_u1 n1176 N299 VDD VDD pch W=0.205u L=0.04u
M_U1290/MI2 n1274 N154 U1290/net27 VSS nch W=0.155u L=0.04u
M_U1290/MI10 U1290/net27 n1050 VSS VSS nch W=0.155u L=0.04u
M_U1290/MI11 n1274 n1185 VSS VSS nch W=0.155u L=0.04u
M_U1290/MI8 n1274 n1050 U1290/net13 VDD pch W=0.205u L=0.04u
M_U1290/M_u2 U1290/net13 n1185 VDD VDD pch W=0.205u L=0.04u
M_U1290/MI9 n1274 N154 U1290/net13 VDD pch W=0.205u L=0.04u
M_U1291/MI1-M_u4 n980 n949 VSS VSS nch W=0.155u L=0.04u
M_U1291/MI1-M_u3 n980 n978 VSS VSS nch W=0.155u L=0.04u
M_U1291/MI1-M_u1 U1291/XI1-net8 n978 VDD VDD pch W=0.205u L=0.04u
M_U1291/MI1-M_u2 n980 n949 U1291/XI1-net8 VDD pch W=0.205u L=0.04u
M_U1292/M_u6-M_u3 U1292/net4 U1292/net10 U1292/net14 VSS nch W=0.155u L=0.04u
M_U1292/MI3-M_u3 U1292/net6 n1271 U1292/net14 VSS nch W=0.155u L=0.04u
M_U1292/MI1-M_u2 U1292/net4 n1224 VSS VSS nch W=0.155u L=0.04u
M_U1292/M_u5-M_u2 U1292/net6 U1292/net4 VSS VSS nch W=0.155u L=0.04u
M_U1292/M_u4-M_u2 n978 U1292/net14 VSS VSS nch W=0.155u L=0.04u
M_U1292/MI2-M_u2 U1292/net10 n1271 VSS VSS nch W=0.155u L=0.04u
M_U1292/M_u6-M_u2 U1292/net4 n1271 U1292/net14 VDD pch W=0.205u L=0.04u
M_U1292/MI3-M_u2 U1292/net6 U1292/net10 U1292/net14 VDD pch W=0.205u L=0.04u
M_U1292/MI1-M_u3 U1292/net4 n1224 VDD VDD pch W=0.205u L=0.04u
M_U1292/M_u5-M_u3 U1292/net6 U1292/net4 VDD VDD pch W=0.205u L=0.04u
M_U1292/M_u4-M_u3 n978 U1292/net14 VDD VDD pch W=0.205u L=0.04u
M_U1292/MI2-M_u3 U1292/net10 n1271 VDD VDD pch W=0.205u L=0.04u
M_U1293/M_u2 n1224 N296 VSS VSS nch W=0.135u L=0.04u
M_U1293/M_u1 n1224 N296 VDD VDD pch W=0.205u L=0.04u
M_U1294/MI2 n1271 N155 U1294/net27 VSS nch W=0.155u L=0.04u
M_U1294/MI10 U1294/net27 n1050 VSS VSS nch W=0.155u L=0.04u
M_U1294/MI11 n1271 n1185 VSS VSS nch W=0.155u L=0.04u
M_U1294/MI8 n1271 n1050 U1294/net13 VDD pch W=0.205u L=0.04u
M_U1294/M_u2 U1294/net13 n1185 VDD VDD pch W=0.205u L=0.04u
M_U1294/MI9 n1271 N155 U1294/net13 VDD pch W=0.205u L=0.04u
M_U1295/MU1-M_u4 U1295/XU1-net6 n948 VSS VSS nch W=0.155u L=0.04u
M_U1295/MU1-M_u3 n949 n977 U1295/XU1-net6 VSS nch W=0.155u L=0.04u
M_U1295/MU1-M_u2 n949 n948 VDD VDD pch W=0.155u L=0.04u
M_U1295/MU1-M_u1 n949 n977 VDD VDD pch W=0.155u L=0.04u
M_U1296/MI2-M_u2 U1296/net13 n1275 VSS VSS nch W=0.155u L=0.04u
M_U1296/MI13 U1296/net16 U1296/net13 VSS VSS nch W=0.155u L=0.04u
M_U1296/MI12 n948 N293 U1296/net16 VSS nch W=0.155u L=0.04u
M_U1296/MI2-M_u3 U1296/net13 n1275 VDD VDD pch W=0.205u L=0.04u
M_U1296/M_u16 VDD U1296/net13 n948 VDD pch W=0.205u L=0.04u
M_U1296/MI11 VDD N293 n948 VDD pch W=0.205u L=0.04u
M_U1297/MU1-M_u4 U1297/XU1-net6 n1275 VSS VSS nch W=0.155u L=0.04u
M_U1297/MU1-M_u3 n977 n1229 U1297/XU1-net6 VSS nch W=0.155u L=0.04u
M_U1297/MU1-M_u2 n977 n1275 VDD VDD pch W=0.155u L=0.04u
M_U1297/MU1-M_u1 n977 n1229 VDD VDD pch W=0.155u L=0.04u
M_U1298/MI12 U1298/net32 n1050 VSS VSS nch W=0.155u L=0.04u
M_U1298/MI11 U1298/net59 N156 U1298/net32 VSS nch W=0.155u L=0.04u
M_U1298/MI6 U1298/net59 n1185 VSS VSS nch W=0.155u L=0.04u
M_U1298/MI8-M_u2 n1275 U1298/net59 VSS VSS nch W=0.155u L=0.04u
M_U1298/MI8-M_u3 n1275 U1298/net59 VDD VDD pch W=0.2u L=0.04u
M_U1298/MI10 U1298/net59 N156 U1298/net22 VDD pch W=0.205u L=0.04u
M_U1298/MI9 U1298/net59 n1050 U1298/net22 VDD pch W=0.205u L=0.04u
M_U1298/M_u2 U1298/net22 n1185 VDD VDD pch W=0.2u L=0.04u
M_U1299/M_u2 n1229 N293 VSS VSS nch W=0.135u L=0.04u
M_U1299/M_u1 n1229 N293 VDD VDD pch W=0.205u L=0.04u
M_U1300/M_u6-M_u3 U1300/net4 U1300/net10 U1300/net14 VSS nch W=0.155u L=0.04u
M_U1300/MI3-M_u3 U1300/net6 n1272 U1300/net14 VSS nch W=0.155u L=0.04u
M_U1300/MI1-M_u2 U1300/net4 N303 VSS VSS nch W=0.155u L=0.04u
M_U1300/M_u5-M_u2 U1300/net6 U1300/net4 VSS VSS nch W=0.155u L=0.04u
M_U1300/M_u4-M_u2 n950 U1300/net14 VSS VSS nch W=0.155u L=0.04u
M_U1300/MI2-M_u2 U1300/net10 n1272 VSS VSS nch W=0.155u L=0.04u
M_U1300/M_u6-M_u2 U1300/net4 n1272 U1300/net14 VDD pch W=0.205u L=0.04u
M_U1300/MI3-M_u2 U1300/net6 U1300/net10 U1300/net14 VDD pch W=0.205u L=0.04u
M_U1300/MI1-M_u3 U1300/net4 N303 VDD VDD pch W=0.205u L=0.04u
M_U1300/M_u5-M_u3 U1300/net6 U1300/net4 VDD VDD pch W=0.205u L=0.04u
M_U1300/M_u4-M_u3 n950 U1300/net14 VDD VDD pch W=0.205u L=0.04u
M_U1300/MI2-M_u3 U1300/net10 n1272 VDD VDD pch W=0.205u L=0.04u
M_U1301/M_u2 n1272 N153 U1301/net15 VSS nch W=0.155u L=0.04u
M_U1301/M_u3 n1272 n1185 U1301/net15 VSS nch W=0.155u L=0.04u
M_U1301/M_u4 U1301/net15 n1050 VSS VSS nch W=0.155u L=0.04u
M_U1301/M_u9 n1272 n1050 VDD VDD pch W=0.205u L=0.04u
M_U1301/MI16-MI12 n1272 N153 U1301/XI16-net11 VDD pch W=0.205u L=0.04u
M_U1301/MI16-MI13 U1301/XI16-net11 n1185 VDD VDD pch W=0.205u L=0.04u
M_U1302/M_u2 n1004 n995 VSS VSS nch W=0.135u L=0.04u
M_U1302/M_u1 n1004 n995 VDD VDD pch W=0.205u L=0.04u
M_U1303/MI14 n995 n1014 U1303/net26 VSS nch W=0.155u L=0.04u
M_U1303/MI7 n995 n964 U1303/net26 VSS nch W=0.155u L=0.04u
M_U1303/MI6 U1303/net29 n1015 VSS VSS nch W=0.155u L=0.04u
M_U1303/M_u4 U1303/net26 n811 U1303/net29 VSS nch W=0.155u L=0.04u
M_U1303/MI5 U1303/net26 n823 U1303/net29 VSS nch W=0.155u L=0.04u
M_U1303/MI13 n995 n964 U1303/net43 VDD pch W=0.205u L=0.04u
M_U1303/MI11 n995 n823 U1303/net49 VDD pch W=0.205u L=0.04u
M_U1303/MI9 U1303/net49 n811 VDD VDD pch W=0.205u L=0.04u
M_U1303/MI12 U1303/net43 n1014 VDD VDD pch W=0.205u L=0.04u
M_U1303/MU24 n995 n1015 VDD VDD pch W=0.205u L=0.04u
M_U1304/MI8 n1015 n1351 U1304/net23 VDD pch W=0.205u L=0.04u
M_U1304/MI6 n1015 n958 U1304/net23 VDD pch W=0.205u L=0.04u
M_U1304/MI7 n1015 n804 U1304/net23 VDD pch W=0.205u L=0.04u
M_U1304/MU20 U1304/net23 n1244 VDD VDD pch W=0.205u L=0.04u
M_U1304/MI5 U1304/net23 n1311 VDD VDD pch W=0.205u L=0.04u
M_U1304/MI20-MI12 U1304/XI20-net13 n958 VSS VSS nch W=0.155u L=0.04u
M_U1304/MI20-M_u10 n1015 n1351 U1304/XI20-net17 VSS nch W=0.155u L=0.04u
M_U1304/MI20-M_u11 U1304/XI20-net17 n804 U1304/XI20-net13 VSS nch W=0.155u L=0.04u
M_U1304/MI17-M_u10 n1015 n1244 U1304/XI17-net17 VSS nch W=0.155u L=0.04u
M_U1304/MI17-M_u11 U1304/XI17-net17 n1311 VSS VSS nch W=0.155u L=0.04u
M_U1305/M_u2 n804 n849 U1305/net15 VSS nch W=0.155u L=0.04u
M_U1305/M_u3 n804 n854 U1305/net15 VSS nch W=0.155u L=0.04u
M_U1305/M_u4 U1305/net15 n1352 VSS VSS nch W=0.155u L=0.04u
M_U1305/M_u9 n804 n1352 VDD VDD pch W=0.205u L=0.04u
M_U1305/MI16-MI12 n804 n849 U1305/XI16-net11 VDD pch W=0.205u L=0.04u
M_U1305/MI16-MI13 U1305/XI16-net11 n854 VDD VDD pch W=0.205u L=0.04u
M_U1306/MU20 n849 n1353 VSS VSS nch W=0.155u L=0.04u
M_U1306/MI17-M_u10 n849 n834 U1306/XI17-net17 VSS nch W=0.155u L=0.04u
M_U1306/MI17-M_u11 U1306/XI17-net17 n969 VSS VSS nch W=0.155u L=0.04u
M_U1306/MI10-M_u10 n849 n843 U1306/XI10-net17 VSS nch W=0.155u L=0.04u
M_U1306/MI10-M_u11 U1306/XI10-net17 n844 VSS VSS nch W=0.155u L=0.04u
M_U1306/MI9 U1306/net30 n843 n849 VDD pch W=0.205u L=0.04u
M_U1306/MI8 U1306/net30 n844 n849 VDD pch W=0.205u L=0.04u
M_U1306/MU22 VDD n1353 U1306/net36 VDD pch W=0.205u L=0.04u
M_U1306/MI6 U1306/net36 n969 U1306/net30 VDD pch W=0.205u L=0.04u
M_U1306/MI7 U1306/net36 n834 U1306/net30 VDD pch W=0.205u L=0.04u
M_U1307/M_u2 n1353 n1354 VSS VSS nch W=0.135u L=0.04u
M_U1307/M_u1 n1353 n1354 VDD VDD pch W=0.205u L=0.04u
M_U1308/M_u2 n834 n968 VSS VSS nch W=0.135u L=0.04u
M_U1308/M_u1 n834 n968 VDD VDD pch W=0.205u L=0.04u
M_U1309/M_u2 n843 n852 U1309/net15 VSS nch W=0.155u L=0.04u
M_U1309/M_u3 n843 n850 U1309/net15 VSS nch W=0.155u L=0.04u
M_U1309/M_u4 U1309/net15 n1355 VSS VSS nch W=0.155u L=0.04u
M_U1309/M_u9 n843 n1355 VDD VDD pch W=0.205u L=0.04u
M_U1309/MI16-MI12 n843 n852 U1309/XI16-net11 VDD pch W=0.205u L=0.04u
M_U1309/MI16-MI13 U1309/XI16-net11 n850 VDD VDD pch W=0.205u L=0.04u
M_U1310/M_u2 n823 n958 VSS VSS nch W=0.135u L=0.04u
M_U1310/M_u1 n823 n958 VDD VDD pch W=0.205u L=0.04u
M_U1311/M_u3 U1311/net11 n817 n811 VDD pch W=0.205u L=0.04u
M_U1311/MI0 U1311/net11 n1356 n811 VDD pch W=0.205u L=0.04u
M_U1311/MI16-MI12 U1311/net11 n814 U1311/XI16-net11 VDD pch W=0.205u L=0.04u
M_U1311/MI16-MI13 U1311/XI16-net11 n1021 VDD VDD pch W=0.205u L=0.04u
M_U1311/MI2 n811 n1021 VSS VSS nch W=0.155u L=0.04u
M_U1311/M_u13 n811 n814 VSS VSS nch W=0.155u L=0.04u
M_U1311/MI12-M_u10 n811 n817 U1311/XI12-net17 VSS nch W=0.155u L=0.04u
M_U1311/MI12-M_u11 U1311/XI12-net17 n1356 VSS VSS nch W=0.155u L=0.04u
M_U1312/M_u4 n814 n813 VSS VSS nch W=0.155u L=0.04u
M_U1312/MI2 n814 n954 VSS VSS nch W=0.155u L=0.04u
M_U1312/MI3 n814 n955 VSS VSS nch W=0.155u L=0.04u
M_U1312/M_u1 U1312/net25 n813 VDD VDD pch W=0.41u L=0.04u
M_U1312/MI0 U1312/net28 n954 U1312/net25 VDD pch W=0.41u L=0.04u
M_U1312/MI1 n814 n955 U1312/net28 VDD pch W=0.41u L=0.04u
M_U1313/M_u2 n813 n817 VSS VSS nch W=0.135u L=0.04u
M_U1313/M_u1 n813 n817 VDD VDD pch W=0.205u L=0.04u
M_U1314/MI1-M_u4 n1356 n1022 VSS VSS nch W=0.155u L=0.04u
M_U1314/MI1-M_u3 n1356 N358 VSS VSS nch W=0.155u L=0.04u
M_U1314/MI1-M_u1 U1314/XI1-net8 N358 VDD VDD pch W=0.205u L=0.04u
M_U1314/MI1-M_u2 n1356 n1022 U1314/XI1-net8 VDD pch W=0.205u L=0.04u
M_U1315/MI0-M_u4 n1014 n1351 U1315/XI0-net10 VSS nch W=0.155u L=0.04u
M_U1315/MI0-M_u5 U1315/XI0-net10 n958 U1315/XI0-net13 VSS nch W=0.155u L=0.04u
M_U1315/MI0-M_u6 U1315/XI0-net13 n802 VSS VSS nch W=0.155u L=0.04u
M_U1315/MI0-M_u3 n1014 n802 VDD VDD pch W=0.205u L=0.04u
M_U1315/MI0-M_u1 n1014 n1351 VDD VDD pch W=0.205u L=0.04u
M_U1315/MI0-M_u2 n1014 n958 VDD VDD pch W=0.205u L=0.04u
M_U1316/MU9-M_u6 n802 n840 VSS VSS nch W=0.155u L=0.04u
M_U1316/MU9-M_u5 n802 n854 VSS VSS nch W=0.155u L=0.04u
M_U1316/MU9-M_u4 n802 U1316/net12 VSS VSS nch W=0.155u L=0.04u
M_U1316/MU47-M_u2 U1316/net12 n844 VSS VSS nch W=0.155u L=0.04u
M_U1316/MU9-M_u1 U1316/XU9-net9 U1316/net12 VDD VDD pch W=0.41u L=0.04u
M_U1316/MU9-M_u2 U1316/XU9-net12 n854 U1316/XU9-net9 VDD pch W=0.41u L=0.04u
M_U1316/MU9-M_u3 n802 n840 U1316/XU9-net12 VDD pch W=0.41u L=0.04u
M_U1316/MU47-M_u3 U1316/net12 n844 VDD VDD pch W=0.31u L=0.04u
M_U1317/M_u2 n840 n842 VSS VSS nch W=0.135u L=0.04u
M_U1317/M_u1 n840 n842 VDD VDD pch W=0.205u L=0.04u
M_U1318/MI1-M_u4 n842 n851 VSS VSS nch W=0.155u L=0.04u
M_U1318/MI1-M_u3 n842 n852 VSS VSS nch W=0.155u L=0.04u
M_U1318/MI1-M_u1 U1318/XI1-net8 n852 VDD VDD pch W=0.205u L=0.04u
M_U1318/MI1-M_u2 n842 n851 U1318/XI1-net8 VDD pch W=0.205u L=0.04u
M_U1319/M_u2 n852 n1320 U1319/net15 VSS nch W=0.155u L=0.04u
M_U1319/M_u3 n852 n1242 U1319/net15 VSS nch W=0.155u L=0.04u
M_U1319/M_u4 U1319/net15 n1355 VSS VSS nch W=0.155u L=0.04u
M_U1319/M_u9 n852 n1355 VDD VDD pch W=0.205u L=0.04u
M_U1319/MI16-MI12 n852 n1320 U1319/XI16-net11 VDD pch W=0.205u L=0.04u
M_U1319/MI16-MI13 U1319/XI16-net11 n1242 VDD VDD pch W=0.205u L=0.04u
M_U1320/MU1-M_u4 U1320/XU1-net6 n1242 VSS VSS nch W=0.155u L=0.04u
M_U1320/MU1-M_u3 n1355 n1320 U1320/XU1-net6 VSS nch W=0.155u L=0.04u
M_U1320/MU1-M_u2 n1355 n1242 VDD VDD pch W=0.155u L=0.04u
M_U1320/MU1-M_u1 n1355 n1320 VDD VDD pch W=0.155u L=0.04u
M_U1321/M_u2 n1242 N343 VSS VSS nch W=0.135u L=0.04u
M_U1321/M_u1 n1242 N343 VDD VDD pch W=0.205u L=0.04u
M_U1322/MU29-M_u2 n1320 U1322/net28 VSS VSS nch W=0.155u L=0.04u
M_U1322/MI111 U1322/net47 N226 VSS VSS nch W=0.155u L=0.04u
M_U1322/MI5 U1322/net28 U1322/net6 U1322/net47 VSS nch W=0.155u L=0.04u
M_U1322/MI14 U1322/net44 N97 VSS VSS nch W=0.155u L=0.04u
M_U1322/MI13 U1322/net28 n1184 U1322/net44 VSS nch W=0.155u L=0.04u
M_U1322/MU24 U1322/net6 n1184 VSS VSS nch W=0.155u L=0.04u
M_U1322/MU29-M_u3 n1320 U1322/net28 VDD VDD pch W=0.205u L=0.04u
M_U1322/MI2 VDD N226 U1322/net47 VDD pch W=0.205u L=0.04u
M_U1322/MI4 U1322/net47 n1184 U1322/net28 VDD pch W=0.205u L=0.04u
M_U1322/MI12 U1322/net44 U1322/net6 U1322/net28 VDD pch W=0.205u L=0.04u
M_U1322/MI10 VDD N97 U1322/net44 VDD pch W=0.205u L=0.04u
M_U1322/MU25 VDD n1184 U1322/net6 VDD pch W=0.205u L=0.04u
M_U1323/MU1-M_u4 U1323/XU1-net6 n850 VSS VSS nch W=0.155u L=0.04u
M_U1323/MU1-M_u3 n851 n837 U1323/XU1-net6 VSS nch W=0.155u L=0.04u
M_U1323/MU1-M_u2 n851 n850 VDD VDD pch W=0.155u L=0.04u
M_U1323/MU1-M_u1 n851 n837 VDD VDD pch W=0.155u L=0.04u
M_U1324/MU1-M_u4 U1324/XU1-net6 n1237 VSS VSS nch W=0.155u L=0.04u
M_U1324/MU1-M_u3 n850 n1316 U1324/XU1-net6 VSS nch W=0.155u L=0.04u
M_U1324/MU1-M_u2 n850 n1237 VDD VDD pch W=0.155u L=0.04u
M_U1324/MU1-M_u1 n850 n1316 VDD VDD pch W=0.155u L=0.04u
M_U1325/M_u2 n1237 N340 VSS VSS nch W=0.135u L=0.04u
M_U1325/M_u1 n1237 N340 VDD VDD pch W=0.205u L=0.04u
M_U1326/M_u2 n1316 n1317 VSS VSS nch W=0.135u L=0.04u
M_U1326/M_u1 n1316 n1317 VDD VDD pch W=0.205u L=0.04u
M_U1327/MU1-M_u4 U1327/XU1-net6 n1317 VSS VSS nch W=0.155u L=0.04u
M_U1327/MU1-M_u3 n837 N340 U1327/XU1-net6 VSS nch W=0.155u L=0.04u
M_U1327/MU1-M_u2 n837 n1317 VDD VDD pch W=0.155u L=0.04u
M_U1327/MU1-M_u1 n837 N340 VDD VDD pch W=0.155u L=0.04u
M_U1328/MI15-M_u2 U1328/net19 N18 VSS VSS nch W=0.155u L=0.04u
M_U1328/MI21 n1317 N18 U1328/net40 VSS nch W=0.155u L=0.04u
M_U1328/MI12 n1317 U1328/net19 U1328/net36 VSS nch W=0.155u L=0.04u
M_U1328/MI20 U1328/net40 N217 VSS VSS nch W=0.31u L=0.04u
M_U1328/MI19 U1328/net36 N118 VSS VSS nch W=0.155u L=0.04u
M_U1328/MI15-M_u3 U1328/net19 N18 VDD VDD pch W=0.205u L=0.04u
M_U1328/MI25 n1317 U1328/net19 U1328/net26 VDD pch W=0.325u L=0.04u
M_U1328/MI24 U1328/net26 N217 VDD VDD pch W=0.41u L=0.04u
M_U1328/MI5 n1317 N18 U1328/net30 VDD pch W=0.325u L=0.04u
M_U1328/MI111 U1328/net30 N118 VDD VDD pch W=0.205u L=0.04u
M_U1329/M_u2 n854 n1321 U1329/net15 VSS nch W=0.155u L=0.04u
M_U1329/M_u3 n854 n1247 U1329/net15 VSS nch W=0.155u L=0.04u
M_U1329/M_u4 U1329/net15 n1352 VSS VSS nch W=0.155u L=0.04u
M_U1329/M_u9 n854 n1352 VDD VDD pch W=0.205u L=0.04u
M_U1329/MI16-MI12 n854 n1321 U1329/XI16-net11 VDD pch W=0.205u L=0.04u
M_U1329/MI16-MI13 U1329/XI16-net11 n1247 VDD VDD pch W=0.205u L=0.04u
M_U1330/MU1-M_u4 U1330/XU1-net6 n1247 VSS VSS nch W=0.155u L=0.04u
M_U1330/MU1-M_u3 n1352 n1321 U1330/XU1-net6 VSS nch W=0.155u L=0.04u
M_U1330/MU1-M_u2 n1352 n1247 VDD VDD pch W=0.155u L=0.04u
M_U1330/MU1-M_u1 n1352 n1321 VDD VDD pch W=0.155u L=0.04u
M_U1331/M_u2 n1247 N352 VSS VSS nch W=0.135u L=0.04u
M_U1331/M_u1 n1247 N352 VDD VDD pch W=0.205u L=0.04u
M_U1332/MU29-M_u2 n1321 U1332/net28 VSS VSS nch W=0.155u L=0.04u
M_U1332/MI111 U1332/net47 N223 VSS VSS nch W=0.155u L=0.04u
M_U1332/MI5 U1332/net28 U1332/net6 U1332/net47 VSS nch W=0.155u L=0.04u
M_U1332/MI14 U1332/net44 N47 VSS VSS nch W=0.155u L=0.04u
M_U1332/MI13 U1332/net28 n1184 U1332/net44 VSS nch W=0.155u L=0.04u
M_U1332/MU24 U1332/net6 n1184 VSS VSS nch W=0.155u L=0.04u
M_U1332/MU29-M_u3 n1321 U1332/net28 VDD VDD pch W=0.205u L=0.04u
M_U1332/MI2 VDD N223 U1332/net47 VDD pch W=0.205u L=0.04u
M_U1332/MI4 U1332/net47 n1184 U1332/net28 VDD pch W=0.205u L=0.04u
M_U1332/MI12 U1332/net44 U1332/net6 U1332/net28 VDD pch W=0.205u L=0.04u
M_U1332/MI10 VDD N47 U1332/net44 VDD pch W=0.205u L=0.04u
M_U1332/MU25 VDD n1184 U1332/net6 VDD pch W=0.205u L=0.04u
M_U1333/MI1-M_u4 n844 n839 VSS VSS nch W=0.155u L=0.04u
M_U1333/MI1-M_u3 n844 n968 VSS VSS nch W=0.155u L=0.04u
M_U1333/MI1-M_u1 U1333/XI1-net8 n968 VDD VDD pch W=0.205u L=0.04u
M_U1333/MI1-M_u2 n844 n839 U1333/XI1-net8 VDD pch W=0.205u L=0.04u
M_U1334/M_u2 n968 n1318 U1334/net15 VSS nch W=0.155u L=0.04u
M_U1334/M_u3 n968 n1245 U1334/net15 VSS nch W=0.155u L=0.04u
M_U1334/M_u4 U1334/net15 n1354 VSS VSS nch W=0.155u L=0.04u
M_U1334/M_u9 n968 n1354 VDD VDD pch W=0.205u L=0.04u
M_U1334/MI16-MI12 n968 n1318 U1334/XI16-net11 VDD pch W=0.205u L=0.04u
M_U1334/MI16-MI13 U1334/XI16-net11 n1245 VDD VDD pch W=0.205u L=0.04u
M_U1335/MU1-M_u4 U1335/XU1-net6 n1245 VSS VSS nch W=0.155u L=0.04u
M_U1335/MU1-M_u3 n1354 n1318 U1335/XU1-net6 VSS nch W=0.155u L=0.04u
M_U1335/MU1-M_u2 n1354 n1245 VDD VDD pch W=0.155u L=0.04u
M_U1335/MU1-M_u1 n1354 n1318 VDD VDD pch W=0.155u L=0.04u
M_U1336/M_u2 n1245 N349 VSS VSS nch W=0.135u L=0.04u
M_U1336/M_u1 n1245 N349 VDD VDD pch W=0.205u L=0.04u
M_U1337/MU29-M_u2 n1318 U1337/net28 VSS VSS nch W=0.155u L=0.04u
M_U1337/MI111 U1337/net47 N224 VSS VSS nch W=0.155u L=0.04u
M_U1337/MI5 U1337/net28 U1337/net6 U1337/net47 VSS nch W=0.155u L=0.04u
M_U1337/MI14 U1337/net44 N121 VSS VSS nch W=0.155u L=0.04u
M_U1337/MI13 U1337/net28 n1184 U1337/net44 VSS nch W=0.155u L=0.04u
M_U1337/MU24 U1337/net6 n1184 VSS VSS nch W=0.155u L=0.04u
M_U1337/MU29-M_u3 n1318 U1337/net28 VDD VDD pch W=0.205u L=0.04u
M_U1337/MI2 VDD N224 U1337/net47 VDD pch W=0.205u L=0.04u
M_U1337/MI4 U1337/net47 n1184 U1337/net28 VDD pch W=0.205u L=0.04u
M_U1337/MI12 U1337/net44 U1337/net6 U1337/net28 VDD pch W=0.205u L=0.04u
M_U1337/MI10 VDD N121 U1337/net44 VDD pch W=0.205u L=0.04u
M_U1337/MU25 VDD n1184 U1337/net6 VDD pch W=0.205u L=0.04u
M_U1338/M_u2 n839 n853 VSS VSS nch W=0.135u L=0.04u
M_U1338/M_u1 n839 n853 VDD VDD pch W=0.205u L=0.04u
M_U1339/MI2 n853 n1319 U1339/net27 VSS nch W=0.155u L=0.04u
M_U1339/MI10 U1339/net27 N346 VSS VSS nch W=0.155u L=0.04u
M_U1339/MI11 n853 n969 VSS VSS nch W=0.155u L=0.04u
M_U1339/MI8 n853 N346 U1339/net13 VDD pch W=0.205u L=0.04u
M_U1339/M_u2 U1339/net13 n969 VDD VDD pch W=0.205u L=0.04u
M_U1339/MI9 n853 n1319 U1339/net13 VDD pch W=0.205u L=0.04u
M_U1340/MI1-M_u4 n969 n1319 VSS VSS nch W=0.155u L=0.04u
M_U1340/MI1-M_u3 n969 N346 VSS VSS nch W=0.155u L=0.04u
M_U1340/MI1-M_u1 U1340/XI1-net8 N346 VDD VDD pch W=0.205u L=0.04u
M_U1340/MI1-M_u2 n969 n1319 U1340/XI1-net8 VDD pch W=0.205u L=0.04u
M_U1341/MI15-M_u2 U1341/net19 N18 VSS VSS nch W=0.155u L=0.04u
M_U1341/MI21 n1319 N18 U1341/net40 VSS nch W=0.155u L=0.04u
M_U1341/MI12 n1319 U1341/net19 U1341/net36 VSS nch W=0.155u L=0.04u
M_U1341/MI20 U1341/net40 N225 VSS VSS nch W=0.31u L=0.04u
M_U1341/MI19 U1341/net36 N94 VSS VSS nch W=0.155u L=0.04u
M_U1341/MI15-M_u3 U1341/net19 N18 VDD VDD pch W=0.205u L=0.04u
M_U1341/MI25 n1319 U1341/net19 U1341/net26 VDD pch W=0.325u L=0.04u
M_U1341/MI24 U1341/net26 N225 VDD VDD pch W=0.41u L=0.04u
M_U1341/MI5 n1319 N18 U1341/net30 VDD pch W=0.325u L=0.04u
M_U1341/MI111 U1341/net30 N94 VDD VDD pch W=0.205u L=0.04u
M_U1342/M_u6-M_u3 U1342/net4 U1342/net10 U1342/net14 VSS nch W=0.155u L=0.04u
M_U1342/MI3-M_u3 U1342/net6 n1311 U1342/net14 VSS nch W=0.155u L=0.04u
M_U1342/MI1-M_u2 U1342/net4 n1244 VSS VSS nch W=0.155u L=0.04u
M_U1342/M_u5-M_u2 U1342/net6 U1342/net4 VSS VSS nch W=0.155u L=0.04u
M_U1342/M_u4-M_u2 n958 U1342/net14 VSS VSS nch W=0.155u L=0.04u
M_U1342/MI2-M_u2 U1342/net10 n1311 VSS VSS nch W=0.155u L=0.04u
M_U1342/M_u6-M_u2 U1342/net4 n1311 U1342/net14 VDD pch W=0.205u L=0.04u
M_U1342/MI3-M_u2 U1342/net6 U1342/net10 U1342/net14 VDD pch W=0.205u L=0.04u
M_U1342/MI1-M_u3 U1342/net4 n1244 VDD VDD pch W=0.205u L=0.04u
M_U1342/M_u5-M_u3 U1342/net6 U1342/net4 VDD VDD pch W=0.205u L=0.04u
M_U1342/M_u4-M_u3 n958 U1342/net14 VDD VDD pch W=0.205u L=0.04u
M_U1342/MI2-M_u3 U1342/net10 n1311 VDD VDD pch W=0.205u L=0.04u
M_U1343/M_u2 n1244 N364 VSS VSS nch W=0.135u L=0.04u
M_U1343/M_u1 n1244 N364 VDD VDD pch W=0.205u L=0.04u
M_U1344/MU29-M_u2 n1311 U1344/net28 VSS VSS nch W=0.155u L=0.04u
M_U1344/MI111 U1344/net47 N219 VSS VSS nch W=0.155u L=0.04u
M_U1344/MI5 U1344/net28 U1344/net6 U1344/net47 VSS nch W=0.155u L=0.04u
M_U1344/MI14 U1344/net44 N66 VSS VSS nch W=0.155u L=0.04u
M_U1344/MI13 U1344/net28 n1184 U1344/net44 VSS nch W=0.155u L=0.04u
M_U1344/MU24 U1344/net6 n1184 VSS VSS nch W=0.155u L=0.04u
M_U1344/MU29-M_u3 n1311 U1344/net28 VDD VDD pch W=0.205u L=0.04u
M_U1344/MI2 VDD N219 U1344/net47 VDD pch W=0.205u L=0.04u
M_U1344/MI4 U1344/net47 n1184 U1344/net28 VDD pch W=0.205u L=0.04u
M_U1344/MI12 U1344/net44 U1344/net6 U1344/net28 VDD pch W=0.205u L=0.04u
M_U1344/MI10 VDD N66 U1344/net44 VDD pch W=0.205u L=0.04u
M_U1344/MU25 VDD n1184 U1344/net6 VDD pch W=0.205u L=0.04u
M_U1345/M_u2 n1351 n962 VSS VSS nch W=0.135u L=0.04u
M_U1345/M_u1 n1351 n962 VDD VDD pch W=0.205u L=0.04u
M_U1346/MU1-M_u4 U1346/XU1-net6 n817 VSS VSS nch W=0.155u L=0.04u
M_U1346/MU1-M_u3 n962 n957 U1346/XU1-net6 VSS nch W=0.155u L=0.04u
M_U1346/MU1-M_u2 n962 n817 VDD VDD pch W=0.155u L=0.04u
M_U1346/MU1-M_u1 n962 n957 VDD VDD pch W=0.155u L=0.04u
M_U1347/MI2 n817 n1312 U1347/net27 VSS nch W=0.155u L=0.04u
M_U1347/MI10 U1347/net27 N361 VSS VSS nch W=0.155u L=0.04u
M_U1347/MI11 n817 n1021 VSS VSS nch W=0.155u L=0.04u
M_U1347/MI8 n817 N361 U1347/net13 VDD pch W=0.205u L=0.04u
M_U1347/M_u2 U1347/net13 n1021 VDD VDD pch W=0.205u L=0.04u
M_U1347/MI9 n817 n1312 U1347/net13 VDD pch W=0.205u L=0.04u
M_U1348/MI1-M_u4 n1021 n1312 VSS VSS nch W=0.155u L=0.04u
M_U1348/MI1-M_u3 n1021 N361 VSS VSS nch W=0.155u L=0.04u
M_U1348/MI1-M_u1 U1348/XI1-net8 N361 VDD VDD pch W=0.205u L=0.04u
M_U1348/MI1-M_u2 n1021 n1312 U1348/XI1-net8 VDD pch W=0.205u L=0.04u
M_U1349/MI15-M_u2 U1349/net19 N18 VSS VSS nch W=0.155u L=0.04u
M_U1349/MI21 n1312 N18 U1349/net40 VSS nch W=0.155u L=0.04u
M_U1349/MI12 n1312 U1349/net19 U1349/net36 VSS nch W=0.155u L=0.04u
M_U1349/MI20 U1349/net40 N220 VSS VSS nch W=0.31u L=0.04u
M_U1349/MI19 U1349/net36 N50 VSS VSS nch W=0.155u L=0.04u
M_U1349/MI15-M_u3 U1349/net19 N18 VDD VDD pch W=0.205u L=0.04u
M_U1349/MI25 n1312 U1349/net19 U1349/net26 VDD pch W=0.325u L=0.04u
M_U1349/MI24 U1349/net26 N220 VDD VDD pch W=0.41u L=0.04u
M_U1349/MI5 n1312 N18 U1349/net30 VDD pch W=0.325u L=0.04u
M_U1349/MI111 U1349/net30 N50 VDD VDD pch W=0.205u L=0.04u
M_U1350/MI1-M_u4 n957 n822 VSS VSS nch W=0.155u L=0.04u
M_U1350/MI1-M_u3 n957 n955 VSS VSS nch W=0.155u L=0.04u
M_U1350/MI1-M_u1 U1350/XI1-net8 n955 VDD VDD pch W=0.205u L=0.04u
M_U1350/MI1-M_u2 n957 n822 U1350/XI1-net8 VDD pch W=0.205u L=0.04u
M_U1351/MI0-M_u3 U1351/net4 n1307 U1351/net14 VSS nch W=0.155u L=0.04u
M_U1351/M_u7-M_u3 U1351/net6 U1351/net10 U1351/net14 VSS nch W=0.17u L=0.04u
M_U1351/M_u2-M_u2 U1351/net4 n1246 VSS VSS nch W=0.155u L=0.04u
M_U1351/M_u5-M_u2 U1351/net6 U1351/net4 VSS VSS nch W=0.17u L=0.04u
M_U1351/M_u4-M_u2 n955 U1351/net14 VSS VSS nch W=0.155u L=0.04u
M_U1351/M_u8-M_u2 U1351/net10 n1307 VSS VSS nch W=0.155u L=0.04u
M_U1351/MI0-M_u2 U1351/net4 U1351/net10 U1351/net14 VDD pch W=0.255u L=0.04u
M_U1351/M_u7-M_u2 U1351/net6 n1307 U1351/net14 VDD pch W=0.28u L=0.04u
M_U1351/M_u2-M_u3 U1351/net4 n1246 VDD VDD pch W=0.205u L=0.04u
M_U1351/M_u5-M_u3 U1351/net6 U1351/net4 VDD VDD pch W=0.24u L=0.04u
M_U1351/M_u4-M_u3 n955 U1351/net14 VDD VDD pch W=0.205u L=0.04u
M_U1351/M_u8-M_u3 U1351/net10 n1307 VDD VDD pch W=0.205u L=0.04u
M_U1352/M_u2 n1246 N358 VSS VSS nch W=0.135u L=0.04u
M_U1352/M_u1 n1246 N358 VDD VDD pch W=0.205u L=0.04u
M_U1353/M_u2 n1307 n1022 VSS VSS nch W=0.135u L=0.04u
M_U1353/M_u1 n1307 n1022 VDD VDD pch W=0.205u L=0.04u
M_U1354/MI15-M_u2 U1354/net19 N18 VSS VSS nch W=0.155u L=0.04u
M_U1354/MI21 n1022 N18 U1354/net40 VSS nch W=0.155u L=0.04u
M_U1354/MI12 n1022 U1354/net19 U1354/net36 VSS nch W=0.155u L=0.04u
M_U1354/MI20 U1354/net40 N221 VSS VSS nch W=0.31u L=0.04u
M_U1354/MI19 U1354/net36 N32 VSS VSS nch W=0.155u L=0.04u
M_U1354/MI15-M_u3 U1354/net19 N18 VDD VDD pch W=0.205u L=0.04u
M_U1354/MI25 n1022 U1354/net19 U1354/net26 VDD pch W=0.325u L=0.04u
M_U1354/MI24 U1354/net26 N221 VDD VDD pch W=0.41u L=0.04u
M_U1354/MI5 n1022 N18 U1354/net30 VDD pch W=0.325u L=0.04u
M_U1354/MI111 U1354/net30 N32 VDD VDD pch W=0.205u L=0.04u
M_U1355/MU1-M_u4 U1355/XU1-net6 n954 VSS VSS nch W=0.155u L=0.04u
M_U1355/MU1-M_u3 n822 n826 U1355/XU1-net6 VSS nch W=0.155u L=0.04u
M_U1355/MU1-M_u2 n822 n954 VDD VDD pch W=0.155u L=0.04u
M_U1355/MU1-M_u1 n822 n826 VDD VDD pch W=0.155u L=0.04u
M_U1356/M_u2 n954 n816 VSS VSS nch W=0.135u L=0.04u
M_U1356/M_u1 n954 n816 VDD VDD pch W=0.205u L=0.04u
M_U1357/MI1-M_u4 n816 n1310 VSS VSS nch W=0.155u L=0.04u
M_U1357/MI1-M_u3 n816 N355 VSS VSS nch W=0.155u L=0.04u
M_U1357/MI1-M_u1 U1357/XI1-net8 N355 VDD VDD pch W=0.205u L=0.04u
M_U1357/MI1-M_u2 n816 n1310 U1357/XI1-net8 VDD pch W=0.205u L=0.04u
M_U1358/MU1-M_u4 U1358/XU1-net6 n1310 VSS VSS nch W=0.155u L=0.04u
M_U1358/MU1-M_u3 n826 N355 U1358/XU1-net6 VSS nch W=0.155u L=0.04u
M_U1358/MU1-M_u2 n826 n1310 VDD VDD pch W=0.155u L=0.04u
M_U1358/MU1-M_u1 n826 N355 VDD VDD pch W=0.155u L=0.04u
M_U1359/MI15-M_u2 U1359/net19 N18 VSS VSS nch W=0.155u L=0.04u
M_U1359/MI21 n1310 N18 U1359/net40 VSS nch W=0.155u L=0.04u
M_U1359/MI12 n1310 U1359/net19 U1359/net36 VSS nch W=0.155u L=0.04u
M_U1359/MI20 U1359/net40 N222 VSS VSS nch W=0.31u L=0.04u
M_U1359/MI19 U1359/net36 N35 VSS VSS nch W=0.155u L=0.04u
M_U1359/MI15-M_u3 U1359/net19 N18 VDD VDD pch W=0.205u L=0.04u
M_U1359/MI25 n1310 U1359/net19 U1359/net26 VDD pch W=0.325u L=0.04u
M_U1359/MI24 U1359/net26 N222 VDD VDD pch W=0.41u L=0.04u
M_U1359/MI5 n1310 N18 U1359/net30 VDD pch W=0.325u L=0.04u
M_U1359/MI111 U1359/net30 N35 VDD VDD pch W=0.205u L=0.04u
M_U1360/MI14 U1360/net32 n1018 U1360/net26 VSS nch W=0.155u L=0.04u
M_U1360/MI7 U1360/net32 n749 U1360/net26 VSS nch W=0.155u L=0.04u
M_U1360/MI6 U1360/net29 n1019 VSS VSS nch W=0.155u L=0.04u
M_U1360/M_u4 U1360/net26 n1329 U1360/net29 VSS nch W=0.155u L=0.04u
M_U1360/MI5 U1360/net26 n1017 U1360/net29 VSS nch W=0.155u L=0.04u
M_U1360/MI15-M_u2 n964 U1360/net32 VSS VSS nch W=0.155u L=0.04u
M_U1360/MI15-M_u3 n964 U1360/net32 VDD VDD pch W=0.205u L=0.04u
M_U1360/MI13 U1360/net32 n749 U1360/net43 VDD pch W=0.205u L=0.04u
M_U1360/MI11 U1360/net32 n1017 U1360/net49 VDD pch W=0.205u L=0.04u
M_U1360/MI9 U1360/net49 n1329 VDD VDD pch W=0.205u L=0.04u
M_U1360/MI12 U1360/net43 n1018 VDD VDD pch W=0.205u L=0.04u
M_U1360/MU24 U1360/net32 n1019 VDD VDD pch W=0.205u L=0.04u
M_U1361/M_u5 VSS n1357 U1361/net22 VSS nch W=0.155u L=0.04u
M_U1361/MI15 U1361/net22 n1285 U1361/net30 VSS nch W=0.155u L=0.04u
M_U1361/MI14 U1361/net22 N328 U1361/net30 VSS nch W=0.155u L=0.04u
M_U1361/MI13 U1361/net22 n1326 U1361/net30 VSS nch W=0.155u L=0.04u
M_U1361/MU1-M_u2 n1329 U1361/net30 VSS VSS nch W=0.155u L=0.04u
M_U1361/MU1-M_u3 n1329 U1361/net30 VDD VDD pch W=0.205u L=0.04u
M_U1361/MI3 U1361/net38 n1326 VDD VDD pch W=0.205u L=0.04u
M_U1361/MI9 U1361/net35 N328 U1361/net38 VDD pch W=0.205u L=0.04u
M_U1361/MI11 U1361/net30 n1285 U1361/net35 VDD pch W=0.205u L=0.04u
M_U1361/MI12 U1361/net30 n1357 VDD VDD pch W=0.205u L=0.04u
M_U1362/MI6 n1357 n1322 U1362/net19 VDD pch W=0.205u L=0.04u
M_U1362/MI4 n1357 n755 U1362/net19 VDD pch W=0.205u L=0.04u
M_U1362/MI5 n1357 n754 U1362/net19 VDD pch W=0.205u L=0.04u
M_U1362/MU20 U1362/net19 n1020 VDD VDD pch W=0.205u L=0.04u
M_U1362/MU14 n1357 n1020 VSS VSS nch W=0.155u L=0.04u
M_U1362/MI20-MI12 U1362/XI20-net13 n755 VSS VSS nch W=0.155u L=0.04u
M_U1362/MI20-M_u10 n1357 n1322 U1362/XI20-net17 VSS nch W=0.155u L=0.04u
M_U1362/MI20-M_u11 U1362/XI20-net17 n754 U1362/XI20-net13 VSS nch W=0.155u L=0.04u
M_U1363/M_u2 n1322 n798 VSS VSS nch W=0.135u L=0.04u
M_U1363/M_u1 n1322 n798 VDD VDD pch W=0.205u L=0.04u
M_U1364/MU1-M_u4 U1364/XU1-net6 n793 VSS VSS nch W=0.155u L=0.04u
M_U1364/MU1-M_u3 n1018 n1330 U1364/XU1-net6 VSS nch W=0.155u L=0.04u
M_U1364/MU1-M_u2 n1018 n793 VDD VDD pch W=0.155u L=0.04u
M_U1364/MU1-M_u1 n1018 n1330 VDD VDD pch W=0.155u L=0.04u
M_U1365/M_u2 n793 n1017 VSS VSS nch W=0.135u L=0.04u
M_U1365/M_u1 n793 n1017 VDD VDD pch W=0.205u L=0.04u
M_U1366/M_u2 n1017 n1358 U1366/net15 VSS nch W=0.155u L=0.04u
M_U1366/M_u3 n1017 n1257 U1366/net15 VSS nch W=0.155u L=0.04u
M_U1366/M_u4 U1366/net15 n1019 VSS VSS nch W=0.155u L=0.04u
M_U1366/M_u9 n1017 n1019 VDD VDD pch W=0.205u L=0.04u
M_U1366/MI16-MI12 n1017 n1358 U1366/XI16-net11 VDD pch W=0.205u L=0.04u
M_U1366/MI16-MI13 U1366/XI16-net11 n1257 VDD VDD pch W=0.205u L=0.04u
M_U1367/MU1-M_u4 U1367/XU1-net6 n1257 VSS VSS nch W=0.155u L=0.04u
M_U1367/MU1-M_u3 n1019 n1358 U1367/XU1-net6 VSS nch W=0.155u L=0.04u
M_U1367/MU1-M_u2 n1019 n1257 VDD VDD pch W=0.155u L=0.04u
M_U1367/MU1-M_u1 n1019 n1358 VDD VDD pch W=0.155u L=0.04u
M_U1368/M_u2 n1257 N334 VSS VSS nch W=0.135u L=0.04u
M_U1368/M_u1 n1257 N334 VDD VDD pch W=0.205u L=0.04u
M_U1369/M_u2 n1358 n1298 VSS VSS nch W=0.135u L=0.04u
M_U1369/M_u1 n1358 n1298 VDD VDD pch W=0.205u L=0.04u
M_U1370/MI15-M_u2 U1370/net19 N18 VSS VSS nch W=0.155u L=0.04u
M_U1370/MI21 n1298 N18 U1370/net40 VSS nch W=0.155u L=0.04u
M_U1370/MI12 n1298 U1370/net19 U1370/net36 VSS nch W=0.155u L=0.04u
M_U1370/MI20 U1370/net40 N231 VSS VSS nch W=0.31u L=0.04u
M_U1370/MI19 U1370/net36 N100 VSS VSS nch W=0.155u L=0.04u
M_U1370/MI15-M_u3 U1370/net19 N18 VDD VDD pch W=0.205u L=0.04u
M_U1370/MI25 n1298 U1370/net19 U1370/net26 VDD pch W=0.325u L=0.04u
M_U1370/MI24 U1370/net26 N231 VDD VDD pch W=0.41u L=0.04u
M_U1370/MI5 n1298 N18 U1370/net30 VDD pch W=0.325u L=0.04u
M_U1370/MI111 U1370/net30 N100 VDD VDD pch W=0.205u L=0.04u
M_U1371/M_u4 n1330 n797 VSS VSS nch W=0.155u L=0.04u
M_U1371/MI2 n1330 n1326 VSS VSS nch W=0.155u L=0.04u
M_U1371/MI3 n1330 n798 VSS VSS nch W=0.155u L=0.04u
M_U1371/M_u1 U1371/net25 n797 VDD VDD pch W=0.41u L=0.04u
M_U1371/MI0 U1371/net28 n1326 U1371/net25 VDD pch W=0.41u L=0.04u
M_U1371/MI1 n1330 n798 U1371/net28 VDD pch W=0.41u L=0.04u
M_U1372/M_u2 n797 n1327 VSS VSS nch W=0.135u L=0.04u
M_U1372/M_u1 n797 n1327 VDD VDD pch W=0.205u L=0.04u
M_U1373/MI1-M_u4 n1327 n796 VSS VSS nch W=0.155u L=0.04u
M_U1373/MI1-M_u3 n1327 n754 VSS VSS nch W=0.155u L=0.04u
M_U1373/MI1-M_u1 U1373/XI1-net8 n754 VDD VDD pch W=0.205u L=0.04u
M_U1373/MI1-M_u2 n1327 n796 U1373/XI1-net8 VDD pch W=0.205u L=0.04u
M_U1374/M_u2 n754 n1324 VSS VSS nch W=0.135u L=0.04u
M_U1374/M_u1 n754 n1324 VDD VDD pch W=0.205u L=0.04u
M_U1375/MU1-M_u4 U1375/XU1-net6 n1264 VSS VSS nch W=0.155u L=0.04u
M_U1375/MU1-M_u3 n1324 n1286 U1375/XU1-net6 VSS nch W=0.155u L=0.04u
M_U1375/MU1-M_u2 n1324 n1264 VDD VDD pch W=0.155u L=0.04u
M_U1375/MU1-M_u1 n1324 n1286 VDD VDD pch W=0.155u L=0.04u
M_U1376/MI1-M_u4 n796 n1264 VSS VSS nch W=0.155u L=0.04u
M_U1376/MI1-M_u3 n796 n1286 VSS VSS nch W=0.155u L=0.04u
M_U1376/MI1-M_u1 U1376/XI1-net8 n1286 VDD VDD pch W=0.205u L=0.04u
M_U1376/MI1-M_u2 n796 n1264 U1376/XI1-net8 VDD pch W=0.205u L=0.04u
M_U1377/MU29-M_u2 n1286 U1377/net28 VSS VSS nch W=0.155u L=0.04u
M_U1377/MI111 U1377/net47 N234 VSS VSS nch W=0.155u L=0.04u
M_U1377/MI5 U1377/net28 U1377/net6 U1377/net47 VSS nch W=0.155u L=0.04u
M_U1377/MI14 U1377/net44 N130 VSS VSS nch W=0.155u L=0.04u
M_U1377/MI13 U1377/net28 n1184 U1377/net44 VSS nch W=0.155u L=0.04u
M_U1377/MU24 U1377/net6 n1184 VSS VSS nch W=0.155u L=0.04u
M_U1377/MU29-M_u3 n1286 U1377/net28 VDD VDD pch W=0.205u L=0.04u
M_U1377/MI2 VDD N234 U1377/net47 VDD pch W=0.205u L=0.04u
M_U1377/MI4 U1377/net47 n1184 U1377/net28 VDD pch W=0.205u L=0.04u
M_U1377/MI12 U1377/net44 U1377/net6 U1377/net28 VDD pch W=0.205u L=0.04u
M_U1377/MI10 VDD N130 U1377/net44 VDD pch W=0.205u L=0.04u
M_U1377/MU25 VDD n1184 U1377/net6 VDD pch W=0.205u L=0.04u
M_U1378/M_u2 n1264 N325 VSS VSS nch W=0.135u L=0.04u
M_U1378/M_u1 n1264 N325 VDD VDD pch W=0.205u L=0.04u
M_U1379/M_u2 n1326 n755 VSS VSS nch W=0.135u L=0.04u
M_U1379/M_u1 n1326 n755 VDD VDD pch W=0.205u L=0.04u
M_U1380/MI2 n755 n1288 U1380/net27 VSS nch W=0.155u L=0.04u
M_U1380/MI10 U1380/net27 N331 VSS VSS nch W=0.155u L=0.04u
M_U1380/MI11 n755 n1020 VSS VSS nch W=0.155u L=0.04u
M_U1380/MI8 n755 N331 U1380/net13 VDD pch W=0.205u L=0.04u
M_U1380/M_u2 U1380/net13 n1020 VDD VDD pch W=0.205u L=0.04u
M_U1380/MI9 n755 n1288 U1380/net13 VDD pch W=0.205u L=0.04u
M_U1381/MI1-M_u4 n1020 n1288 VSS VSS nch W=0.155u L=0.04u
M_U1381/MI1-M_u3 n1020 N331 VSS VSS nch W=0.155u L=0.04u
M_U1381/MI1-M_u1 U1381/XI1-net8 N331 VDD VDD pch W=0.205u L=0.04u
M_U1381/MI1-M_u2 n1020 n1288 U1381/XI1-net8 VDD pch W=0.205u L=0.04u
M_U1382/MI15-M_u2 U1382/net19 N18 VSS VSS nch W=0.155u L=0.04u
M_U1382/MI21 n1288 N18 U1382/net40 VSS nch W=0.155u L=0.04u
M_U1382/MI12 n1288 U1382/net19 U1382/net36 VSS nch W=0.155u L=0.04u
M_U1382/MI20 U1382/net40 N232 VSS VSS nch W=0.31u L=0.04u
M_U1382/MI19 U1382/net36 N124 VSS VSS nch W=0.155u L=0.04u
M_U1382/MI15-M_u3 U1382/net19 N18 VDD VDD pch W=0.205u L=0.04u
M_U1382/MI25 n1288 U1382/net19 U1382/net26 VDD pch W=0.325u L=0.04u
M_U1382/MI24 U1382/net26 N232 VDD VDD pch W=0.41u L=0.04u
M_U1382/MI5 n1288 N18 U1382/net30 VDD pch W=0.325u L=0.04u
M_U1382/MI111 U1382/net30 N124 VDD VDD pch W=0.205u L=0.04u
M_U1383/M_u6-M_u3 U1383/net4 U1383/net10 U1383/net14 VSS nch W=0.155u L=0.04u
M_U1383/MI3-M_u3 U1383/net6 n1285 U1383/net14 VSS nch W=0.155u L=0.04u
M_U1383/MI1-M_u2 U1383/net4 n1258 VSS VSS nch W=0.155u L=0.04u
M_U1383/M_u5-M_u2 U1383/net6 U1383/net4 VSS VSS nch W=0.155u L=0.04u
M_U1383/M_u4-M_u2 n798 U1383/net14 VSS VSS nch W=0.155u L=0.04u
M_U1383/MI2-M_u2 U1383/net10 n1285 VSS VSS nch W=0.155u L=0.04u
M_U1383/M_u6-M_u2 U1383/net4 n1285 U1383/net14 VDD pch W=0.205u L=0.04u
M_U1383/MI3-M_u2 U1383/net6 U1383/net10 U1383/net14 VDD pch W=0.205u L=0.04u
M_U1383/MI1-M_u3 U1383/net4 n1258 VDD VDD pch W=0.205u L=0.04u
M_U1383/M_u5-M_u3 U1383/net6 U1383/net4 VDD VDD pch W=0.205u L=0.04u
M_U1383/M_u4-M_u3 n798 U1383/net14 VDD VDD pch W=0.205u L=0.04u
M_U1383/MI2-M_u3 U1383/net10 n1285 VDD VDD pch W=0.205u L=0.04u
M_U1384/M_u2 n1258 N328 VSS VSS nch W=0.135u L=0.04u
M_U1384/M_u1 n1258 N328 VDD VDD pch W=0.205u L=0.04u
M_U1385/MI15-M_u2 U1385/net19 N18 VSS VSS nch W=0.155u L=0.04u
M_U1385/MI21 n1285 N18 U1385/net40 VSS nch W=0.155u L=0.04u
M_U1385/MI12 n1285 U1385/net19 U1385/net36 VSS nch W=0.155u L=0.04u
M_U1385/MI20 U1385/net40 N233 VSS VSS nch W=0.31u L=0.04u
M_U1385/MI19 U1385/net36 N127 VSS VSS nch W=0.155u L=0.04u
M_U1385/MI15-M_u3 U1385/net19 N18 VDD VDD pch W=0.205u L=0.04u
M_U1385/MI25 n1285 U1385/net19 U1385/net26 VDD pch W=0.325u L=0.04u
M_U1385/MI24 U1385/net26 N233 VDD VDD pch W=0.41u L=0.04u
M_U1385/MI5 n1285 N18 U1385/net30 VDD pch W=0.325u L=0.04u
M_U1385/MI111 U1385/net30 N127 VDD VDD pch W=0.205u L=0.04u
M_U1386/M_u4 U1386/net29 n792 VSS VSS nch W=0.31u L=0.04u
M_U1386/MI13 U1386/net30 n1295 U1386/net29 VSS nch W=0.31u L=0.04u
M_U1386/MI14 U1386/net30 N322 U1386/net29 VSS nch W=0.31u L=0.04u
M_U1386/MI12 U1386/net29 n1359 VSS VSS nch W=0.31u L=0.04u
M_U1386/MU1-M_u2 n749 U1386/net30 VSS VSS nch W=0.31u L=0.04u
M_U1386/MU1-M_u3 n749 U1386/net30 VDD VDD pch W=0.41u L=0.04u
M_U1386/MU24 U1386/net25 n792 VDD VDD pch W=0.41u L=0.04u
M_U1386/MI11 U1386/net22 n1295 VDD VDD pch W=0.41u L=0.04u
M_U1386/MI8 U1386/net30 n1359 U1386/net25 VDD pch W=0.41u L=0.04u
M_U1386/MI9 U1386/net30 N322 U1386/net22 VDD pch W=0.41u L=0.04u
M_U1387/MI0-M_u3 U1387/net4 n1295 U1387/net14 VSS nch W=0.155u L=0.04u
M_U1387/M_u7-M_u3 U1387/net6 U1387/net10 U1387/net14 VSS nch W=0.17u L=0.04u
M_U1387/M_u2-M_u2 U1387/net4 N322 VSS VSS nch W=0.155u L=0.04u
M_U1387/M_u5-M_u2 U1387/net6 U1387/net4 VSS VSS nch W=0.17u L=0.04u
M_U1387/M_u4-M_u2 n792 U1387/net14 VSS VSS nch W=0.155u L=0.04u
M_U1387/M_u8-M_u2 U1387/net10 n1295 VSS VSS nch W=0.155u L=0.04u
M_U1387/MI0-M_u2 U1387/net4 U1387/net10 U1387/net14 VDD pch W=0.255u L=0.04u
M_U1387/M_u7-M_u2 U1387/net6 n1295 U1387/net14 VDD pch W=0.28u L=0.04u
M_U1387/M_u2-M_u3 U1387/net4 N322 VDD VDD pch W=0.205u L=0.04u
M_U1387/M_u5-M_u3 U1387/net6 U1387/net4 VDD VDD pch W=0.24u L=0.04u
M_U1387/M_u4-M_u3 n792 U1387/net14 VDD VDD pch W=0.205u L=0.04u
M_U1387/M_u8-M_u3 U1387/net10 n1295 VDD VDD pch W=0.205u L=0.04u
M_U1388/M_u3 U1388/net11 n776 n1359 VDD pch W=0.205u L=0.04u
M_U1388/MI0 U1388/net11 n773 n1359 VDD pch W=0.205u L=0.04u
M_U1388/MI16-MI12 U1388/net11 n1360 U1388/XI16-net11 VDD pch W=0.205u L=0.04u
M_U1388/MI16-MI13 U1388/XI16-net11 n1338 VDD VDD pch W=0.205u L=0.04u
M_U1388/MI2 n1359 n1338 VSS VSS nch W=0.155u L=0.04u
M_U1388/M_u13 n1359 n1360 VSS VSS nch W=0.155u L=0.04u
M_U1388/MI12-M_u10 n1359 n776 U1388/XI12-net17 VSS nch W=0.155u L=0.04u
M_U1388/MI12-M_u11 U1388/XI12-net17 n773 VSS VSS nch W=0.155u L=0.04u
M_U1389/MU1-M_u4 n1338 n785 VSS VSS nch W=0.155u L=0.04u
M_U1389/MU1-M_u3 n1338 U1389/net4 VSS VSS nch W=0.155u L=0.04u
M_U1389/MU6-M_u2 U1389/net4 n1334 VSS VSS nch W=0.155u L=0.04u
M_U1389/MU1-M_u1 U1389/XU1-net8 U1389/net4 VDD VDD pch W=0.205u L=0.04u
M_U1389/MU1-M_u2 n1338 n785 U1389/XU1-net8 VDD pch W=0.205u L=0.04u
M_U1389/MU6-M_u3 U1389/net4 n1334 VDD VDD pch W=0.205u L=0.04u
M_U1390/MU1-M_u4 n1334 n1361 VSS VSS nch W=0.155u L=0.04u
M_U1390/MU1-M_u3 n1334 U1390/net4 VSS VSS nch W=0.155u L=0.04u
M_U1390/MU6-M_u2 U1390/net4 n772 VSS VSS nch W=0.155u L=0.04u
M_U1390/MU1-M_u1 U1390/XU1-net8 U1390/net4 VDD VDD pch W=0.205u L=0.04u
M_U1390/MU1-M_u2 n1334 n1361 U1390/XU1-net8 VDD pch W=0.205u L=0.04u
M_U1390/MU6-M_u3 U1390/net4 n772 VDD VDD pch W=0.205u L=0.04u
M_U1391/MI1-M_u4 n772 n791 VSS VSS nch W=0.155u L=0.04u
M_U1391/MI1-M_u3 n772 n789 VSS VSS nch W=0.155u L=0.04u
M_U1391/MI1-M_u1 U1391/XI1-net8 n789 VDD VDD pch W=0.205u L=0.04u
M_U1391/MI1-M_u2 n772 n791 U1391/XI1-net8 VDD pch W=0.205u L=0.04u
M_U1392/MU1-M_u2 n1360 U1392/net7 VSS VSS nch W=0.155u L=0.04u
M_U1392/M_u7-M_u4 U1392/net7 n784 VSS VSS nch W=0.155u L=0.04u
M_U1392/M_u7-M_u3 U1392/net7 n783 VSS VSS nch W=0.155u L=0.04u
M_U1392/MU1-M_u3 n1360 U1392/net7 VDD VDD pch W=0.205u L=0.04u
M_U1392/M_u7-M_u1 U1392/X_u7-net8 n783 VDD VDD pch W=0.205u L=0.04u
M_U1392/M_u7-M_u2 U1392/net7 n784 U1392/X_u7-net8 VDD pch W=0.205u L=0.04u
M_U1393/MI1-M_u4 n783 n1336 VSS VSS nch W=0.155u L=0.04u
M_U1393/MI1-M_u3 n783 n787 VSS VSS nch W=0.155u L=0.04u
M_U1393/MI1-M_u1 U1393/XI1-net8 n787 VDD VDD pch W=0.205u L=0.04u
M_U1393/MI1-M_u2 n783 n1336 U1393/XI1-net8 VDD pch W=0.205u L=0.04u
M_U1394/M_u2 n787 n767 VSS VSS nch W=0.135u L=0.04u
M_U1394/M_u1 n787 n767 VDD VDD pch W=0.205u L=0.04u
M_U1395/M_u2 n1336 n1362 VSS VSS nch W=0.135u L=0.04u
M_U1395/M_u1 n1336 n1362 VDD VDD pch W=0.205u L=0.04u
M_U1396/MI2-M_u2 U1396/net13 n1340 VSS VSS nch W=0.155u L=0.04u
M_U1396/MI13 U1396/net16 U1396/net13 VSS VSS nch W=0.155u L=0.04u
M_U1396/MI12 n773 n786 U1396/net16 VSS nch W=0.155u L=0.04u
M_U1396/MI2-M_u3 U1396/net13 n1340 VDD VDD pch W=0.205u L=0.04u
M_U1396/M_u16 VDD U1396/net13 n773 VDD pch W=0.205u L=0.04u
M_U1396/MI11 VDD n786 n773 VDD pch W=0.205u L=0.04u
M_U1397/MI1-M_u4 n1340 n1363 VSS VSS nch W=0.155u L=0.04u
M_U1397/MI1-M_u3 n1340 n789 VSS VSS nch W=0.155u L=0.04u
M_U1397/MI1-M_u1 U1397/XI1-net8 n789 VDD VDD pch W=0.205u L=0.04u
M_U1397/MI1-M_u2 n1340 n1363 U1397/XI1-net8 VDD pch W=0.205u L=0.04u
M_U1398/M_u2 n789 n1289 U1398/net15 VSS nch W=0.155u L=0.04u
M_U1398/M_u3 n789 n1259 U1398/net15 VSS nch W=0.155u L=0.04u
M_U1398/M_u4 U1398/net15 n786 VSS VSS nch W=0.155u L=0.04u
M_U1398/M_u9 n789 n786 VDD VDD pch W=0.205u L=0.04u
M_U1398/MI16-MI12 n789 n1289 U1398/XI16-net11 VDD pch W=0.205u L=0.04u
M_U1398/MI16-MI13 U1398/XI16-net11 n1259 VDD VDD pch W=0.205u L=0.04u
M_U1399/MU1-M_u4 U1399/XU1-net6 n1259 VSS VSS nch W=0.155u L=0.04u
M_U1399/MU1-M_u3 n786 n1289 U1399/XU1-net6 VSS nch W=0.155u L=0.04u
M_U1399/MU1-M_u2 n786 n1259 VDD VDD pch W=0.155u L=0.04u
M_U1399/MU1-M_u1 n786 n1289 VDD VDD pch W=0.155u L=0.04u
M_U1400/M_u2 n1259 N313 VSS VSS nch W=0.135u L=0.04u
M_U1400/M_u1 n1259 N313 VDD VDD pch W=0.205u L=0.04u
M_U1401/MU29-M_u2 n1289 U1401/net28 VSS VSS nch W=0.155u L=0.04u
M_U1401/MI111 U1401/net47 N238 VSS VSS nch W=0.155u L=0.04u
M_U1401/MI5 U1401/net28 U1401/net6 U1401/net47 VSS nch W=0.155u L=0.04u
M_U1401/MI14 U1401/net44 N29 VSS VSS nch W=0.155u L=0.04u
M_U1401/MI13 U1401/net28 n1184 U1401/net44 VSS nch W=0.155u L=0.04u
M_U1401/MU24 U1401/net6 n1184 VSS VSS nch W=0.155u L=0.04u
M_U1401/MU29-M_u3 n1289 U1401/net28 VDD VDD pch W=0.205u L=0.04u
M_U1401/MI2 VDD N238 U1401/net47 VDD pch W=0.205u L=0.04u
M_U1401/MI4 U1401/net47 n1184 U1401/net28 VDD pch W=0.205u L=0.04u
M_U1401/MI12 U1401/net44 U1401/net6 U1401/net28 VDD pch W=0.205u L=0.04u
M_U1401/MI10 VDD N29 U1401/net44 VDD pch W=0.205u L=0.04u
M_U1401/MU25 VDD n1184 U1401/net6 VDD pch W=0.205u L=0.04u
M_U1402/M_u2 n776 n785 VSS VSS nch W=0.135u L=0.04u
M_U1402/M_u1 n776 n785 VDD VDD pch W=0.205u L=0.04u
M_U1403/MU1-M_u4 U1403/XU1-net6 n767 VSS VSS nch W=0.155u L=0.04u
M_U1403/MU1-M_u3 n785 n774 U1403/XU1-net6 VSS nch W=0.155u L=0.04u
M_U1403/MU1-M_u2 n785 n767 VDD VDD pch W=0.155u L=0.04u
M_U1403/MU1-M_u1 n785 n774 VDD VDD pch W=0.155u L=0.04u
M_U1404/MI2 n767 n1297 U1404/net27 VSS nch W=0.155u L=0.04u
M_U1404/MI10 U1404/net27 N319 VSS VSS nch W=0.155u L=0.04u
M_U1404/MI11 n767 n784 VSS VSS nch W=0.155u L=0.04u
M_U1404/MI8 n767 N319 U1404/net13 VDD pch W=0.205u L=0.04u
M_U1404/M_u2 U1404/net13 n784 VDD VDD pch W=0.205u L=0.04u
M_U1404/MI9 n767 n1297 U1404/net13 VDD pch W=0.205u L=0.04u
M_U1405/MI1-M_u4 n784 n1297 VSS VSS nch W=0.155u L=0.04u
M_U1405/MI1-M_u3 n784 N319 VSS VSS nch W=0.155u L=0.04u
M_U1405/MI1-M_u1 U1405/XI1-net8 N319 VDD VDD pch W=0.205u L=0.04u
M_U1405/MI1-M_u2 n784 n1297 U1405/XI1-net8 VDD pch W=0.205u L=0.04u
M_U1406/MI15-M_u2 U1406/net19 N18 VSS VSS nch W=0.155u L=0.04u
M_U1406/MI21 n1297 N18 U1406/net40 VSS nch W=0.155u L=0.04u
M_U1406/MI12 n1297 U1406/net19 U1406/net36 VSS nch W=0.155u L=0.04u
M_U1406/MI20 U1406/net40 N236 VSS VSS nch W=0.31u L=0.04u
M_U1406/MI19 U1406/net36 N23 VSS VSS nch W=0.155u L=0.04u
M_U1406/MI15-M_u3 U1406/net19 N18 VDD VDD pch W=0.205u L=0.04u
M_U1406/MI25 n1297 U1406/net19 U1406/net26 VDD pch W=0.325u L=0.04u
M_U1406/MI24 U1406/net26 N236 VDD VDD pch W=0.41u L=0.04u
M_U1406/MI5 n1297 N18 U1406/net30 VDD pch W=0.325u L=0.04u
M_U1406/MI111 U1406/net30 N23 VDD VDD pch W=0.205u L=0.04u
M_U1407/MI2 n774 n1296 U1407/net27 VSS nch W=0.155u L=0.04u
M_U1407/MI10 U1407/net27 N316 VSS VSS nch W=0.155u L=0.04u
M_U1407/MI11 n774 n1362 VSS VSS nch W=0.155u L=0.04u
M_U1407/MI8 n774 N316 U1407/net13 VDD pch W=0.205u L=0.04u
M_U1407/M_u2 U1407/net13 n1362 VDD VDD pch W=0.205u L=0.04u
M_U1407/MI9 n774 n1296 U1407/net13 VDD pch W=0.205u L=0.04u
M_U1408/MI1-M_u4 n1362 n1296 VSS VSS nch W=0.155u L=0.04u
M_U1408/MI1-M_u3 n1362 N316 VSS VSS nch W=0.155u L=0.04u
M_U1408/MI1-M_u1 U1408/XI1-net8 N316 VDD VDD pch W=0.205u L=0.04u
M_U1408/MI1-M_u2 n1362 n1296 U1408/XI1-net8 VDD pch W=0.205u L=0.04u
M_U1409/MI15-M_u2 U1409/net19 N18 VSS VSS nch W=0.155u L=0.04u
M_U1409/MI21 n1296 N18 U1409/net40 VSS nch W=0.155u L=0.04u
M_U1409/MI12 n1296 U1409/net19 U1409/net36 VSS nch W=0.155u L=0.04u
M_U1409/MI20 U1409/net40 N237 VSS VSS nch W=0.31u L=0.04u
M_U1409/MI19 U1409/net36 N26 VSS VSS nch W=0.155u L=0.04u
M_U1409/MI15-M_u3 U1409/net19 N18 VDD VDD pch W=0.205u L=0.04u
M_U1409/MI25 n1296 U1409/net19 U1409/net26 VDD pch W=0.325u L=0.04u
M_U1409/MI24 U1409/net26 N237 VDD VDD pch W=0.41u L=0.04u
M_U1409/MI5 n1296 N18 U1409/net30 VDD pch W=0.325u L=0.04u
M_U1409/MI111 U1409/net30 N26 VDD VDD pch W=0.205u L=0.04u
M_U1410/MI15-M_u2 U1410/net19 n1184 VSS VSS nch W=0.155u L=0.04u
M_U1410/MI21 n1295 n1184 U1410/net40 VSS nch W=0.155u L=0.04u
M_U1410/MI12 n1295 U1410/net19 U1410/net36 VSS nch W=0.155u L=0.04u
M_U1410/MI20 U1410/net40 N103 VSS VSS nch W=0.31u L=0.04u
M_U1410/MI19 U1410/net36 N235 VSS VSS nch W=0.155u L=0.04u
M_U1410/MI15-M_u3 U1410/net19 n1184 VDD VDD pch W=0.205u L=0.04u
M_U1410/MI25 n1295 U1410/net19 U1410/net26 VDD pch W=0.325u L=0.04u
M_U1410/MI24 U1410/net26 N103 VDD VDD pch W=0.41u L=0.04u
M_U1410/MI5 n1295 n1184 U1410/net30 VDD pch W=0.325u L=0.04u
M_U1410/MI111 U1410/net30 N235 VDD VDD pch W=0.205u L=0.04u
M_U1411/MI1-M_u4 n880 n881 VSS VSS nch W=0.155u L=0.04u
M_U1411/MI1-M_u3 n880 n882 VSS VSS nch W=0.155u L=0.04u
M_U1411/MI1-M_u1 U1411/XI1-net8 n882 VDD VDD pch W=0.205u L=0.04u
M_U1411/MI1-M_u2 n880 n881 U1411/XI1-net8 VDD pch W=0.205u L=0.04u
M_U1412/M_u2 n882 n1303 U1412/net15 VSS nch W=0.155u L=0.04u
M_U1412/M_u3 n882 n1221 U1412/net15 VSS nch W=0.155u L=0.04u
M_U1412/M_u4 U1412/net15 n1345 VSS VSS nch W=0.155u L=0.04u
M_U1412/M_u9 n882 n1345 VDD VDD pch W=0.205u L=0.04u
M_U1412/MI16-MI12 n882 n1303 U1412/XI16-net11 VDD pch W=0.205u L=0.04u
M_U1412/MI16-MI13 U1412/XI16-net11 n1221 VDD VDD pch W=0.205u L=0.04u
M_U1413/MU1-M_u4 U1413/XU1-net6 n1303 VSS VSS nch W=0.155u L=0.04u
M_U1413/MU1-M_u3 n1345 n1221 U1413/XU1-net6 VSS nch W=0.155u L=0.04u
M_U1413/MU1-M_u2 n1345 n1303 VDD VDD pch W=0.155u L=0.04u
M_U1413/MU1-M_u1 n1345 n1221 VDD VDD pch W=0.155u L=0.04u
M_U1414/M_u2 n1221 N254 VSS VSS nch W=0.135u L=0.04u
M_U1414/M_u1 n1221 N254 VDD VDD pch W=0.205u L=0.04u
M_U1415/MI12 U1415/net32 n1050 VSS VSS nch W=0.155u L=0.04u
M_U1415/MI11 U1415/net59 N216 U1415/net32 VSS nch W=0.155u L=0.04u
M_U1415/MI6 U1415/net59 n1185 VSS VSS nch W=0.155u L=0.04u
M_U1415/MI8-M_u2 n1303 U1415/net59 VSS VSS nch W=0.155u L=0.04u
M_U1415/MI8-M_u3 n1303 U1415/net59 VDD VDD pch W=0.2u L=0.04u
M_U1415/MI10 U1415/net59 N216 U1415/net22 VDD pch W=0.205u L=0.04u
M_U1415/MI9 U1415/net59 n1050 U1415/net22 VDD pch W=0.205u L=0.04u
M_U1415/M_u2 U1415/net22 n1185 VDD VDD pch W=0.2u L=0.04u
M_U1416/MI2-M_u2 U1416/net13 n877 VSS VSS nch W=0.155u L=0.04u
M_U1416/MI13 U1416/net16 U1416/net13 VSS VSS nch W=0.155u L=0.04u
M_U1416/MI12 n881 n867 U1416/net16 VSS nch W=0.155u L=0.04u
M_U1416/MI2-M_u3 U1416/net13 n877 VDD VDD pch W=0.205u L=0.04u
M_U1416/M_u16 VDD U1416/net13 n881 VDD pch W=0.205u L=0.04u
M_U1416/MI11 VDD n867 n881 VDD pch W=0.205u L=0.04u
M_U1417/MI2-M_u2 U1417/net13 n1364 VSS VSS nch W=0.155u L=0.04u
M_U1417/MI13 U1417/net16 U1417/net13 VSS VSS nch W=0.155u L=0.04u
M_U1417/MI12 n867 n1213 U1417/net16 VSS nch W=0.155u L=0.04u
M_U1417/MI2-M_u3 U1417/net13 n1364 VDD VDD pch W=0.205u L=0.04u
M_U1417/M_u16 VDD U1417/net13 n867 VDD pch W=0.205u L=0.04u
M_U1417/MI11 VDD n1213 n867 VDD pch W=0.205u L=0.04u
M_U1418/M_u2 n1213 N251 VSS VSS nch W=0.135u L=0.04u
M_U1418/M_u1 n1213 N251 VDD VDD pch W=0.205u L=0.04u
M_U1419/M_u3-M_u2 n877 U1419/net6 VSS VSS nch W=0.155u L=0.04u
M_U1419/M_u2-M_u4 U1419/X_u2-net6 N251 VSS VSS nch W=0.155u L=0.04u
M_U1419/M_u2-M_u3 U1419/net6 n1364 U1419/X_u2-net6 VSS nch W=0.155u L=0.04u
M_U1419/M_u3-M_u3 n877 U1419/net6 VDD VDD pch W=0.205u L=0.04u
M_U1419/M_u2-M_u2 U1419/net6 N251 VDD VDD pch W=0.205u L=0.04u
M_U1419/M_u2-M_u1 U1419/net6 n1364 VDD VDD pch W=0.205u L=0.04u
M_U1420/MI2 n1364 n1050 U1420/net27 VSS nch W=0.155u L=0.04u
M_U1420/MI10 U1420/net27 N209 VSS VSS nch W=0.155u L=0.04u
M_U1420/MI11 n1364 n1185 VSS VSS nch W=0.155u L=0.04u
M_U1420/MI8 n1364 N209 U1420/net13 VDD pch W=0.205u L=0.04u
M_U1420/M_u2 U1420/net13 n1185 VDD VDD pch W=0.205u L=0.04u
M_U1420/MI9 n1364 n1050 U1420/net13 VDD pch W=0.205u L=0.04u
M_U1421/M_u2 n874 n1304 U1421/net15 VSS nch W=0.155u L=0.04u
M_U1421/M_u3 n874 n1212 U1421/net15 VSS nch W=0.155u L=0.04u
M_U1421/M_u4 U1421/net15 n1342 VSS VSS nch W=0.155u L=0.04u
M_U1421/M_u9 n874 n1342 VDD VDD pch W=0.205u L=0.04u
M_U1421/MI16-MI12 n874 n1304 U1421/XI16-net11 VDD pch W=0.205u L=0.04u
M_U1421/MI16-MI13 U1421/XI16-net11 n1212 VDD VDD pch W=0.205u L=0.04u
M_U1422/MU1-M_u4 U1422/XU1-net6 n1212 VSS VSS nch W=0.155u L=0.04u
M_U1422/MU1-M_u3 n1342 n1304 U1422/XU1-net6 VSS nch W=0.155u L=0.04u
M_U1422/MU1-M_u2 n1342 n1212 VDD VDD pch W=0.155u L=0.04u
M_U1422/MU1-M_u1 n1342 n1304 VDD VDD pch W=0.155u L=0.04u
M_U1423/M_u2 n1212 N260 VSS VSS nch W=0.135u L=0.04u
M_U1423/M_u1 n1212 N260 VDD VDD pch W=0.205u L=0.04u
M_U1424/MI19 U1424/net14 n1185 U1424/net20 VSS nch W=0.155u L=0.04u
M_U1424/MI11 U1424/net14 N213 U1424/net20 VSS nch W=0.155u L=0.04u
M_U1424/MI20 U1424/net20 n1050 VSS VSS nch W=0.155u L=0.04u
M_U1424/MI8-M_u2 n1304 U1424/net14 VSS VSS nch W=0.155u L=0.04u
M_U1424/MI8-M_u3 n1304 U1424/net14 VDD VDD pch W=0.205u L=0.04u
M_U1424/M_u2 U1424/net14 n1050 VDD VDD pch W=0.205u L=0.04u
M_U1424/MI17 U1424/net24 n1185 VDD VDD pch W=0.205u L=0.04u
M_U1424/MI18 U1424/net14 N213 U1424/net24 VDD pch W=0.205u L=0.04u
M_U1425/MI1-M_u4 n1185 n1044 VSS VSS nch W=0.155u L=0.04u
M_U1425/MI1-M_u3 n1185 N18 VSS VSS nch W=0.155u L=0.04u
M_U1425/MI1-M_u1 U1425/XI1-net8 N18 VDD VDD pch W=0.205u L=0.04u
M_U1425/MI1-M_u2 n1185 n1044 U1425/XI1-net8 VDD pch W=0.205u L=0.04u
M_U1426/M_u2 n1044 n1050 VSS VSS nch W=0.135u L=0.04u
M_U1426/M_u1 n1044 n1050 VDD VDD pch W=0.205u L=0.04u
M_U1427/MU1-M_u4 U1427/XU1-net6 N12 VSS VSS nch W=0.155u L=0.04u
M_U1427/MU1-M_u3 n1050 N9 U1427/XU1-net6 VSS nch W=0.155u L=0.04u
M_U1427/MU1-M_u2 n1050 N12 VDD VDD pch W=0.155u L=0.04u
M_U1427/MU1-M_u1 n1050 N9 VDD VDD pch W=0.155u L=0.04u
M_U1428/MU1-M_u4 U1428/XU1-net6 n889 VSS VSS nch W=0.155u L=0.04u
M_U1428/MU1-M_u3 n891 n890 U1428/XU1-net6 VSS nch W=0.155u L=0.04u
M_U1428/MU1-M_u2 n891 n889 VDD VDD pch W=0.155u L=0.04u
M_U1428/MU1-M_u1 n891 n890 VDD VDD pch W=0.155u L=0.04u
M_U1429/M_u2 n889 n1219 U1429/net15 VSS nch W=0.155u L=0.04u
M_U1429/M_u3 n889 n1027 U1429/net15 VSS nch W=0.155u L=0.04u
M_U1429/M_u4 U1429/net15 N38 VSS VSS nch W=0.155u L=0.04u
M_U1429/M_u9 n889 N38 VDD VDD pch W=0.205u L=0.04u
M_U1429/MI16-MI12 n889 n1219 U1429/XI16-net11 VDD pch W=0.205u L=0.04u
M_U1429/MI16-MI13 U1429/XI16-net11 n1027 VDD VDD pch W=0.205u L=0.04u
M_U1430/M_u2 n1027 N382 VSS VSS nch W=0.135u L=0.04u
M_U1430/M_u1 n1027 N382 VDD VDD pch W=0.205u L=0.04u
M_U1431/M_u2 n1219 N263 VSS VSS nch W=0.135u L=0.04u
M_U1431/M_u1 n1219 N263 VDD VDD pch W=0.205u L=0.04u
M_U1432/MI0-M_u4 n890 N263 U1432/XI0-net10 VSS nch W=0.155u L=0.04u
M_U1432/MI0-M_u5 U1432/XI0-net10 n1024 U1432/XI0-net13 VSS nch W=0.155u L=0.04u
M_U1432/MI0-M_u6 U1432/XI0-net13 N382 VSS VSS nch W=0.155u L=0.04u
M_U1432/MI0-M_u3 n890 N382 VDD VDD pch W=0.205u L=0.04u
M_U1432/MI0-M_u1 n890 N263 VDD VDD pch W=0.205u L=0.04u
M_U1432/MI0-M_u2 n890 n1024 VDD VDD pch W=0.205u L=0.04u
M_U1433/M_u2 n1024 N38 VSS VSS nch W=0.135u L=0.04u
M_U1433/M_u1 n1024 N38 VDD VDD pch W=0.205u L=0.04u
M_U1434/M_u6-M_u3 U1434/net4 U1434/net10 U1434/net14 VSS nch W=0.155u L=0.04u
M_U1434/MI3-M_u3 U1434/net6 n791 U1434/net14 VSS nch W=0.155u L=0.04u
M_U1434/MI1-M_u2 U1434/net4 n1361 VSS VSS nch W=0.155u L=0.04u
M_U1434/M_u5-M_u2 U1434/net6 U1434/net4 VSS VSS nch W=0.155u L=0.04u
M_U1434/M_u4-M_u2 N10025 U1434/net14 VSS VSS nch W=0.155u L=0.04u
M_U1434/MI2-M_u2 U1434/net10 n791 VSS VSS nch W=0.155u L=0.04u
M_U1434/M_u6-M_u2 U1434/net4 n791 U1434/net14 VDD pch W=0.205u L=0.04u
M_U1434/MI3-M_u2 U1434/net6 U1434/net10 U1434/net14 VDD pch W=0.205u L=0.04u
M_U1434/MI1-M_u3 U1434/net4 n1361 VDD VDD pch W=0.205u L=0.04u
M_U1434/M_u5-M_u3 U1434/net6 U1434/net4 VDD VDD pch W=0.205u L=0.04u
M_U1434/M_u4-M_u3 N10025 U1434/net14 VDD VDD pch W=0.205u L=0.04u
M_U1434/MI2-M_u3 U1434/net10 n791 VDD VDD pch W=0.205u L=0.04u
M_U1435/M_u2 n1361 N367 VSS VSS nch W=0.135u L=0.04u
M_U1435/M_u1 n1361 N367 VDD VDD pch W=0.205u L=0.04u
M_U1436/M_u2 n791 n790 VSS VSS nch W=0.135u L=0.04u
M_U1436/M_u1 n791 n790 VDD VDD pch W=0.205u L=0.04u
M_U1437/MI1-M_u4 n790 n769 VSS VSS nch W=0.155u L=0.04u
M_U1437/MI1-M_u3 n790 n780 VSS VSS nch W=0.155u L=0.04u
M_U1437/MI1-M_u1 U1437/XI1-net8 n780 VDD VDD pch W=0.205u L=0.04u
M_U1437/MI1-M_u2 n790 n769 U1437/XI1-net8 VDD pch W=0.205u L=0.04u
M_U1438/M_u2 n780 n1363 VSS VSS nch W=0.135u L=0.04u
M_U1438/M_u1 n780 n1363 VDD VDD pch W=0.205u L=0.04u
M_U1439/MU1-M_u4 U1439/XU1-net6 n1255 VSS VSS nch W=0.155u L=0.04u
M_U1439/MU1-M_u3 n1363 n1292 U1439/XU1-net6 VSS nch W=0.155u L=0.04u
M_U1439/MU1-M_u2 n1363 n1255 VDD VDD pch W=0.155u L=0.04u
M_U1439/MU1-M_u1 n1363 n1292 VDD VDD pch W=0.155u L=0.04u
M_U1440/M_u4 n769 n1255 VSS VSS nch W=0.155u L=0.04u
M_U1440/MI2 n769 N18 VSS VSS nch W=0.155u L=0.04u
M_U1440/MI3 n769 n1292 VSS VSS nch W=0.155u L=0.04u
M_U1440/M_u1 U1440/net25 n1255 VDD VDD pch W=0.41u L=0.04u
M_U1440/MI0 U1440/net28 N18 U1440/net25 VDD pch W=0.41u L=0.04u
M_U1440/MI1 n769 n1292 U1440/net28 VDD pch W=0.41u L=0.04u
M_U1441/M_u2 n1255 N310 VSS VSS nch W=0.135u L=0.04u
M_U1441/M_u1 n1255 N310 VDD VDD pch W=0.205u L=0.04u
M_U1442/MI1-M_u4 n1292 n1294 VSS VSS nch W=0.155u L=0.04u
M_U1442/MI1-M_u3 n1292 N18 VSS VSS nch W=0.155u L=0.04u
M_U1442/MI1-M_u1 U1442/XI1-net8 N18 VDD VDD pch W=0.205u L=0.04u
M_U1442/MI1-M_u2 n1292 n1294 U1442/XI1-net8 VDD pch W=0.205u L=0.04u
M_U1443/MI15-M_u2 U1443/net19 N18 VSS VSS nch W=0.155u L=0.04u
M_U1443/MI21 n1294 N18 U1443/net40 VSS nch W=0.155u L=0.04u
M_U1443/MI12 n1294 U1443/net19 U1443/net36 VSS nch W=0.155u L=0.04u
M_U1443/MI20 U1443/net40 N229 VSS VSS nch W=0.31u L=0.04u
M_U1443/MI19 U1443/net36 N41 VSS VSS nch W=0.155u L=0.04u
M_U1443/MI15-M_u3 U1443/net19 N18 VDD VDD pch W=0.205u L=0.04u
M_U1443/MI25 n1294 U1443/net19 U1443/net26 VDD pch W=0.325u L=0.04u
M_U1443/MI24 U1443/net26 N229 VDD VDD pch W=0.41u L=0.04u
M_U1443/MI5 n1294 N18 U1443/net30 VDD pch W=0.325u L=0.04u
M_U1443/MI111 U1443/net30 N41 VDD VDD pch W=0.205u L=0.04u
.ENDS
