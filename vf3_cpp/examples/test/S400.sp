.SUBCKT s400 CK CLR FM OLATCH_G1L OLATCH_G2L OLATCH_R1L OLATCH_R2L TEST OLATCH_Y1L OLATCH_Y2L VDD VSS
M1 R2C NOR2_9/net6 VSS VSS nmos W=0.31u L=0.04u
M2 NOR2_9/X_u2-net6 n46 VSS VSS nmos W=0.31u L=0.04u
M3 NOR2_9/net6 n48 NOR2_9/X_u2-net6 VSS nmos W=0.31u L=0.04u
M4 R2C NOR2_9/net6 VDD VDD pmos W=0.41u L=0.04u
M5 NOR2_9/net6 n46 VDD VDD pmos W=0.41u L=0.04u
M6 NOR2_9/net6 n48 VDD VDD pmos W=0.41u L=0.04u
M7 Y1C NOR2_8/net6 VSS VSS nmos W=0.31u L=0.04u
M8 NOR2_8/X_u2-net6 n47 VSS VSS nmos W=0.31u L=0.04u
M9 NOR2_8/net6 n49 NOR2_8/X_u2-net6 VSS nmos W=0.31u L=0.04u
M10 Y1C NOR2_8/net6 VDD VDD pmos W=0.41u L=0.04u
M11 NOR2_8/net6 n47 VDD VDD pmos W=0.41u L=0.04u
M12 NOR2_8/net6 n49 VDD VDD pmos W=0.41u L=0.04u
M13 TCOMB_GA1 NOR2_7/net6 VSS VSS nmos W=0.31u L=0.04u
M14 NOR2_7/X_u2-net6 n50 VSS VSS nmos W=0.31u L=0.04u
M15 NOR2_7/net6 N33 NOR2_7/X_u2-net6 VSS nmos W=0.31u L=0.04u
M16 TCOMB_GA1 NOR2_7/net6 VDD VDD pmos W=0.41u L=0.04u
M17 NOR2_7/net6 n50 VDD VDD pmos W=0.41u L=0.04u
M18 NOR2_7/net6 N33 VDD VDD pmos W=0.41u L=0.04u
M19 TCOMB_YA2 NOR2_6/net6 VSS VSS nmos W=0.31u L=0.04u
M20 NOR2_6/X_u2-net6 N125 VSS VSS nmos W=0.31u L=0.04u
M21 NOR2_6/net6 N28 NOR2_6/X_u2-net6 VSS nmos W=0.31u L=0.04u
M22 TCOMB_YA2 NOR2_6/net6 VDD VDD pmos W=0.41u L=0.04u
M23 NOR2_6/net6 N125 VDD VDD pmos W=0.41u L=0.04u
M24 NOR2_6/net6 N28 VDD VDD pmos W=0.41u L=0.04u
M25 NOR3_19/net7 n16 NOR3_19/X_u4-net10 VSS nmos W=0.31u L=0.04u
M26 NOR3_19/X_u4-net10 N112 NOR3_19/X_u4-net13 VSS nmos W=0.31u L=0.04u
M27 NOR3_19/X_u4-net13 n55 VSS VSS nmos W=0.31u L=0.04u
M28 UC_11VD NOR3_19/net7 VSS VSS nmos W=0.31u L=0.04u
M29 NOR3_19/net7 n55 VDD VDD pmos W=0.41u L=0.04u
M30 NOR3_19/net7 n16 VDD VDD pmos W=0.41u L=0.04u
M31 NOR3_19/net7 N112 VDD VDD pmos W=0.41u L=0.04u
M32 UC_11VD NOR3_19/net7 VDD VDD pmos W=0.41u L=0.04u
M33 NOR3_18/net7 n16 NOR3_18/X_u4-net10 VSS nmos W=0.31u L=0.04u
M34 NOR3_18/X_u4-net10 N22 NOR3_18/X_u4-net13 VSS nmos W=0.31u L=0.04u
M35 NOR3_18/X_u4-net13 n55 VSS VSS nmos W=0.31u L=0.04u
M36 UC_10VD NOR3_18/net7 VSS VSS nmos W=0.31u L=0.04u
M37 NOR3_18/net7 n55 VDD VDD pmos W=0.41u L=0.04u
M38 NOR3_18/net7 n16 VDD VDD pmos W=0.41u L=0.04u
M39 NOR3_18/net7 N22 VDD VDD pmos W=0.41u L=0.04u
M40 UC_10VD NOR3_18/net7 VDD VDD pmos W=0.41u L=0.04u
M41 NOR3_17/net7 n16 NOR3_17/X_u4-net10 VSS nmos W=0.31u L=0.04u
M42 NOR3_17/X_u4-net10 N20 NOR3_17/X_u4-net13 VSS nmos W=0.31u L=0.04u
M43 NOR3_17/X_u4-net13 n55 VSS VSS nmos W=0.31u L=0.04u
M44 UC_9VD NOR3_17/net7 VSS VSS nmos W=0.31u L=0.04u
M45 NOR3_17/net7 n55 VDD VDD pmos W=0.41u L=0.04u
M46 NOR3_17/net7 n16 VDD VDD pmos W=0.41u L=0.04u
M47 NOR3_17/net7 N20 VDD VDD pmos W=0.41u L=0.04u
M48 UC_9VD NOR3_17/net7 VDD VDD pmos W=0.41u L=0.04u
M49 NOR3_16/net7 n16 NOR3_16/X_u4-net10 VSS nmos W=0.31u L=0.04u
M50 NOR3_16/X_u4-net10 N18 NOR3_16/X_u4-net13 VSS nmos W=0.31u L=0.04u
M51 NOR3_16/X_u4-net13 n55 VSS VSS nmos W=0.31u L=0.04u
M52 UC_8VD NOR3_16/net7 VSS VSS nmos W=0.31u L=0.04u
M53 NOR3_16/net7 n55 VDD VDD pmos W=0.41u L=0.04u
M54 NOR3_16/net7 n16 VDD VDD pmos W=0.41u L=0.04u
M55 NOR3_16/net7 N18 VDD VDD pmos W=0.41u L=0.04u
M56 UC_8VD NOR3_16/net7 VDD VDD pmos W=0.41u L=0.04u
M57 NOR3_13/net7 n16 NOR3_13/X_u4-net10 VSS nmos W=0.31u L=0.04u
M58 NOR3_13/X_u4-net10 N16 NOR3_13/X_u4-net13 VSS nmos W=0.31u L=0.04u
M59 NOR3_13/X_u4-net13 n45 VSS VSS nmos W=0.31u L=0.04u
M60 UC_19VD NOR3_13/net7 VSS VSS nmos W=0.31u L=0.04u
M61 NOR3_13/net7 n45 VDD VDD pmos W=0.41u L=0.04u
M62 NOR3_13/net7 n16 VDD VDD pmos W=0.41u L=0.04u
M63 NOR3_13/net7 N16 VDD VDD pmos W=0.41u L=0.04u
M64 UC_19VD NOR3_13/net7 VDD VDD pmos W=0.41u L=0.04u
M65 NOR3_12/net7 n16 NOR3_12/X_u4-net10 VSS nmos W=0.31u L=0.04u
M66 NOR3_12/X_u4-net10 N14 NOR3_12/X_u4-net13 VSS nmos W=0.31u L=0.04u
M67 NOR3_12/X_u4-net13 n45 VSS VSS nmos W=0.31u L=0.04u
M68 UC_18VD NOR3_12/net7 VSS VSS nmos W=0.31u L=0.04u
M69 NOR3_12/net7 n45 VDD VDD pmos W=0.41u L=0.04u
M70 NOR3_12/net7 n16 VDD VDD pmos W=0.41u L=0.04u
M71 NOR3_12/net7 N14 VDD VDD pmos W=0.41u L=0.04u
M72 UC_18VD NOR3_12/net7 VDD VDD pmos W=0.41u L=0.04u
M73 NOR3_11/net7 n16 NOR3_11/X_u4-net10 VSS nmos W=0.31u L=0.04u
M74 NOR3_11/X_u4-net10 N12 NOR3_11/X_u4-net13 VSS nmos W=0.31u L=0.04u
M75 NOR3_11/X_u4-net13 n45 VSS VSS nmos W=0.31u L=0.04u
M76 UC_17VD NOR3_11/net7 VSS VSS nmos W=0.31u L=0.04u
M77 NOR3_11/net7 n45 VDD VDD pmos W=0.41u L=0.04u
M78 NOR3_11/net7 n16 VDD VDD pmos W=0.41u L=0.04u
M79 NOR3_11/net7 N12 VDD VDD pmos W=0.41u L=0.04u
M80 UC_17VD NOR3_11/net7 VDD VDD pmos W=0.41u L=0.04u
M81 NOR3_10/net7 n16 NOR3_10/X_u4-net10 VSS nmos W=0.31u L=0.04u
M82 NOR3_10/X_u4-net10 N10 NOR3_10/X_u4-net13 VSS nmos W=0.31u L=0.04u
M83 NOR3_10/X_u4-net13 n45 VSS VSS nmos W=0.31u L=0.04u
M84 UC_16VD NOR3_10/net7 VSS VSS nmos W=0.31u L=0.04u
M85 NOR3_10/net7 n45 VDD VDD pmos W=0.41u L=0.04u
M86 NOR3_10/net7 n16 VDD VDD pmos W=0.41u L=0.04u
M87 NOR3_10/net7 N10 VDD VDD pmos W=0.41u L=0.04u
M88 UC_16VD NOR3_10/net7 VDD VDD pmos W=0.41u L=0.04u
M89 NOR3_6/net7 n16 NOR3_6/X_u4-net10 VSS nmos W=0.31u L=0.04u
M90 NOR3_6/X_u4-net10 N8 NOR3_6/X_u4-net13 VSS nmos W=0.31u L=0.04u
M91 NOR3_6/X_u4-net13 n44 VSS VSS nmos W=0.31u L=0.04u
M92 C3_Q0VD NOR3_6/net7 VSS VSS nmos W=0.31u L=0.04u
M93 NOR3_6/net7 n44 VDD VDD pmos W=0.41u L=0.04u
M94 NOR3_6/net7 n16 VDD VDD pmos W=0.41u L=0.04u
M95 NOR3_6/net7 N8 VDD VDD pmos W=0.41u L=0.04u
M96 C3_Q0VD NOR3_6/net7 VDD VDD pmos W=0.41u L=0.04u
M97 NOR3_5/net7 n16 NOR3_5/X_u4-net10 VSS nmos W=0.31u L=0.04u
M98 NOR3_5/X_u4-net10 N6 NOR3_5/X_u4-net13 VSS nmos W=0.31u L=0.04u
M99 NOR3_5/X_u4-net13 n44 VSS VSS nmos W=0.31u L=0.04u
M100 C3_Q1VD NOR3_5/net7 VSS VSS nmos W=0.31u L=0.04u
M101 NOR3_5/net7 n44 VDD VDD pmos W=0.41u L=0.04u
M102 NOR3_5/net7 n16 VDD VDD pmos W=0.41u L=0.04u
M103 NOR3_5/net7 N6 VDD VDD pmos W=0.41u L=0.04u
M104 C3_Q1VD NOR3_5/net7 VDD VDD pmos W=0.41u L=0.04u
M105 NOR3_4/net7 n16 NOR3_4/X_u4-net10 VSS nmos W=0.31u L=0.04u
M106 NOR3_4/X_u4-net10 N4 NOR3_4/X_u4-net13 VSS nmos W=0.31u L=0.04u
M107 NOR3_4/X_u4-net13 n44 VSS VSS nmos W=0.31u L=0.04u
M108 C3_Q2VD NOR3_4/net7 VSS VSS nmos W=0.31u L=0.04u
M109 NOR3_4/net7 n44 VDD VDD pmos W=0.41u L=0.04u
M110 NOR3_4/net7 n16 VDD VDD pmos W=0.41u L=0.04u
M111 NOR3_4/net7 N4 VDD VDD pmos W=0.41u L=0.04u
M112 C3_Q2VD NOR3_4/net7 VDD VDD pmos W=0.41u L=0.04u
M113 NOR3_3/net7 n16 NOR3_3/X_u4-net10 VSS nmos W=0.31u L=0.04u
M114 NOR3_3/X_u4-net10 N2 NOR3_3/X_u4-net13 VSS nmos W=0.31u L=0.04u
M115 NOR3_3/X_u4-net13 n44 VSS VSS nmos W=0.31u L=0.04u
M116 C3_Q3VD NOR3_3/net7 VSS VSS nmos W=0.31u L=0.04u
M117 NOR3_3/net7 n44 VDD VDD pmos W=0.41u L=0.04u
M118 NOR3_3/net7 n16 VDD VDD pmos W=0.41u L=0.04u
M119 NOR3_3/net7 N2 VDD VDD pmos W=0.41u L=0.04u
M120 C3_Q3VD NOR3_3/net7 VDD VDD pmos W=0.41u L=0.04u
M121 FMLVIINLATCHVCDAD AND2_1/net6 VSS VSS nmos W=0.31u L=0.04u
M122 AND2_1/X_u2-net6 N1 VSS VSS nmos W=0.31u L=0.04u
M123 AND2_1/net6 n16 AND2_1/X_u2-net6 VSS nmos W=0.31u L=0.04u
M124 FMLVIINLATCHVCDAD AND2_1/net6 VDD VDD pmos W=0.41u L=0.04u
M125 AND2_1/net6 N1 VDD VDD pmos W=0.41u L=0.04u
M126 AND2_1/net6 n16 VDD VDD pmos W=0.41u L=0.04u
M127 TESTLVIINLATCHVCDAD AND2_0/net6 VSS VSS nmos W=0.31u L=0.04u
M128 AND2_0/X_u2-net6 N0 VSS VSS nmos W=0.31u L=0.04u
M129 AND2_0/net6 n16 AND2_0/X_u2-net6 VSS nmos W=0.31u L=0.04u
M130 TESTLVIINLATCHVCDAD AND2_0/net6 VDD VDD pmos W=0.41u L=0.04u
M131 AND2_0/net6 N0 VDD VDD pmos W=0.41u L=0.04u
M132 AND2_0/net6 n16 VDD VDD pmos W=0.41u L=0.04u
M133 TCOMB_RA1 N34 VSS VSS nmos W=0.31u L=0.04u
M134 TCOMB_RA1 N34 VDD VDD pmos W=0.41u L=0.04u
M135 TCOMB_GA2 NOR4_2/net6 VSS VSS nmos W=0.31u L=0.04u
M136 NOR4_2/net6 n51 NOR4_2/XU30-net23 VSS nmos W=0.155u L=0.04u
M137 NOR4_2/XU30-net23 n53 NOR4_2/XU30-net26 VSS nmos W=0.155u L=0.04u
M138 NOR4_2/XU30-net26 n54 NOR4_2/XU30-net29 VSS nmos W=0.155u L=0.04u
M139 NOR4_2/XU30-net29 n52 VSS VSS nmos W=0.155u L=0.04u
M140 TCOMB_GA2 NOR4_2/net6 VDD VDD pmos W=0.41u L=0.04u
M141 NOR4_2/net6 n52 VDD VDD pmos W=0.205u L=0.04u
M142 NOR4_2/net6 n54 VDD VDD pmos W=0.205u L=0.04u
M143 NOR4_2/net6 n53 VDD VDD pmos W=0.205u L=0.04u
M144 NOR4_2/net6 n51 VDD VDD pmos W=0.205u L=0.04u
M145 TCOMB_FE_BF n12 VSS VSS nmos W=0.31u L=0.04u
M146 TCOMB_FE_BF n12 VDD VDD pmos W=0.41u L=0.04u
M147 n54 C3_Q1 U66/XI0-net10 VSS nmos W=0.155u L=0.04u
M148 U66/XI0-net10 n16 U66/XI0-net13 VSS nmos W=0.155u L=0.04u
M149 U66/XI0-net13 N125 VSS VSS nmos W=0.155u L=0.04u
M150 n54 N125 VDD VDD pmos W=0.205u L=0.04u
M151 n54 C3_Q1 VDD VDD pmos W=0.205u L=0.04u
M152 n54 n16 VDD VDD pmos W=0.205u L=0.04u
M153 U67/XU1-net6 n56 VSS VSS nmos W=0.155u L=0.04u
M154 n50 OLATCH_FEL U67/XU1-net6 VSS nmos W=0.155u L=0.04u
M155 n50 n56 VDD VDD pmos W=0.155u L=0.04u
M156 n50 OLATCH_FEL VDD VDD pmos W=0.155u L=0.04u
M157 U68/XU1-net6 n57 VSS VSS nmos W=0.155u L=0.04u
M158 n49 n12 U68/XU1-net6 VSS nmos W=0.155u L=0.04u
M159 n49 n57 VDD VDD pmos W=0.155u L=0.04u
M160 n49 n12 VDD VDD pmos W=0.155u L=0.04u
M161 U69/XU1-net6 n58 VSS VSS nmos W=0.155u L=0.04u
M162 n48 n12 U69/XU1-net6 VSS nmos W=0.155u L=0.04u
M163 n48 n58 VDD VDD pmos W=0.155u L=0.04u
M164 n48 n12 VDD VDD pmos W=0.155u L=0.04u
M165 n58 C3_Q1 U70/net15 VSS nmos W=0.155u L=0.04u
M166 n58 n52 U70/net15 VSS nmos W=0.155u L=0.04u
M167 U70/net15 n53 VSS VSS nmos W=0.155u L=0.04u
M168 n58 n53 VDD VDD pmos W=0.205u L=0.04u
M169 n58 C3_Q1 U70/XI16-net11 VDD pmos W=0.205u L=0.04u
M170 U70/XI16-net11 n52 VDD VDD pmos W=0.205u L=0.04u
M171 U71/XU1-net6 n59 VSS VSS nmos W=0.155u L=0.04u
M172 n47 n57 U71/XU1-net6 VSS nmos W=0.155u L=0.04u
M173 n47 n59 VDD VDD pmos W=0.155u L=0.04u
M174 n47 n57 VDD VDD pmos W=0.155u L=0.04u
M175 VSS n60 U72/net22 VSS nmos W=0.155u L=0.04u
M176 U72/net22 C3_Q1 n57 VSS nmos W=0.155u L=0.04u
M177 U72/net22 C3_Q2 n57 VSS nmos W=0.155u L=0.04u
M178 U72/net22 n52 n57 VSS nmos W=0.155u L=0.04u
M179 U72/net38 n52 VDD VDD pmos W=0.205u L=0.04u
M180 U72/net35 C3_Q2 U72/net38 VDD pmos W=0.205u L=0.04u
M181 n57 C3_Q1 U72/net35 VDD pmos W=0.205u L=0.04u
M182 n57 n60 VDD VDD pmos W=0.205u L=0.04u
M183 n60 n61 U73/net19 VDD pmos W=0.205u L=0.04u
M184 n60 n63 U73/net19 VDD pmos W=0.205u L=0.04u
M185 n60 n62 U73/net19 VDD pmos W=0.205u L=0.04u
M186 U73/net19 n64 VDD VDD pmos W=0.205u L=0.04u
M187 n60 n64 VSS VSS nmos W=0.155u L=0.04u
M188 U73/XI20-net13 n63 VSS VSS nmos W=0.155u L=0.04u
M189 n60 n61 U73/XI20-net17 VSS nmos W=0.155u L=0.04u
M190 U73/XI20-net17 n62 U73/XI20-net13 VSS nmos W=0.155u L=0.04u
M191 n62 C3_Q3 VSS VSS nmos W=0.135u L=0.04u
M192 n62 C3_Q3 VDD VDD pmos W=0.205u L=0.04u
M193 n52 n16 U75/XI0-net10 VSS nmos W=0.155u L=0.04u
M194 U75/XI0-net10 n65 U75/XI0-net13 VSS nmos W=0.155u L=0.04u
M195 U75/XI0-net13 C3_Q3 VSS VSS nmos W=0.155u L=0.04u
M196 n52 C3_Q3 VDD VDD pmos W=0.205u L=0.04u
M197 n52 n16 VDD VDD pmos W=0.205u L=0.04u
M198 n52 n65 VDD VDD pmos W=0.205u L=0.04u
M199 n46 n59 VSS VSS nmos W=0.135u L=0.04u
M200 n46 n59 VDD VDD pmos W=0.205u L=0.04u
M201 n59 UC_17 VSS VSS nmos W=0.155u L=0.04u
M202 n59 n12 VSS VSS nmos W=0.155u L=0.04u
M203 U77/XI1-net8 n12 VDD VDD pmos W=0.205u L=0.04u
M204 n59 UC_17 U77/XI1-net8 VDD pmos W=0.205u L=0.04u
M205 U78/net36 n67 U78/net24 VSS nmos W=0.155u L=0.04u
M206 U78/net24 C3_Q3 VSS VSS nmos W=0.155u L=0.04u
M207 n44 C3_Q1 U78/net36 VSS nmos W=0.155u L=0.04u
M208 n44 n66 U78/net36 VSS nmos W=0.155u L=0.04u
M209 n44 n66 U78/net35 VDD pmos W=0.205u L=0.04u
M210 U78/net35 C3_Q1 VDD VDD pmos W=0.205u L=0.04u
M211 n44 C3_Q3 VDD VDD pmos W=0.205u L=0.04u
M212 n44 n67 VDD VDD pmos W=0.205u L=0.04u
M213 U79/XU1-net6 n65 VSS VSS nmos W=0.155u L=0.04u
M214 n66 n68 U79/XU1-net6 VSS nmos W=0.155u L=0.04u
M215 n66 n65 VDD VDD pmos W=0.155u L=0.04u
M216 n66 n68 VDD VDD pmos W=0.155u L=0.04u
M217 n12 n61 U80/net27 VSS nmos W=0.155u L=0.04u
M218 U80/net27 n63 VSS VSS nmos W=0.155u L=0.04u
M219 n12 n64 VSS VSS nmos W=0.155u L=0.04u
M220 n12 n63 U80/net13 VDD pmos W=0.205u L=0.04u
M221 U80/net13 n64 VDD VDD pmos W=0.205u L=0.04u
M222 n12 n61 U80/net13 VDD pmos W=0.205u L=0.04u
M223 U81/net11 n68 VSS VSS nmos W=0.155u L=0.04u
M224 U81/net11 n56 VSS VSS nmos W=0.155u L=0.04u
M225 n64 n51 VSS VSS nmos W=0.155u L=0.04u
M226 n64 U81/net11 VSS VSS nmos W=0.155u L=0.04u
M227 U81/XI1-net8 n56 VDD VDD pmos W=0.205u L=0.04u
M228 U81/net11 n68 U81/XI1-net8 VDD pmos W=0.205u L=0.04u
M229 U81/XU39-net8 U81/net11 VDD VDD pmos W=0.205u L=0.04u
M230 n64 n51 U81/XU39-net8 VDD pmos W=0.205u L=0.04u
M231 U82/net14 FML VSS VSS nmos W=0.155u L=0.04u
M232 U82/net14 n65 VSS VSS nmos W=0.155u L=0.04u
M233 U82/net14 C3_Q1 VSS VSS nmos W=0.155u L=0.04u
M234 U82/net14 C3_Q3 VSS VSS nmos W=0.155u L=0.04u
M235 n56 U82/net14 VSS VSS nmos W=0.155u L=0.04u
M236 U82/net14 C3_Q3 U82/XU8-net7 VDD pmos W=0.205u L=0.04u
M237 U82/XU8-net7 C3_Q1 U82/XU8-net10 VDD pmos W=0.205u L=0.04u
M238 U82/XU8-net10 n65 U82/XU8-net13 VDD pmos W=0.205u L=0.04u
M239 U82/XU8-net13 FML VDD VDD pmos W=0.205u L=0.04u
M240 n56 U82/net14 VDD VDD pmos W=0.205u L=0.04u
M241 n61 n53 VSS VSS nmos W=0.135u L=0.04u
M242 n61 n53 VDD VDD pmos W=0.205u L=0.04u
M243 OLATCH_Y1L OLATCHVUC_6 VSS VSS nmos W=0.135u L=0.04u
M244 OLATCH_Y1L OLATCHVUC_6 VDD VDD pmos W=0.205u L=0.04u
M245 OLATCH_R2L OLATCHVUC_5 VSS VSS nmos W=0.135u L=0.04u
M246 OLATCH_R2L OLATCHVUC_5 VDD VDD pmos W=0.205u L=0.04u
M247 U86/net4 U86/net10 U86/net14 VSS nmos W=0.155u L=0.04u
M248 U86/net6 n45 U86/net14 VSS nmos W=0.155u L=0.04u
M249 U86/net4 n65 VSS VSS nmos W=0.155u L=0.04u
M250 U86/net6 U86/net4 VSS VSS nmos W=0.155u L=0.04u
M251 N8 U86/net14 VSS VSS nmos W=0.155u L=0.04u
M252 U86/net10 n45 VSS VSS nmos W=0.155u L=0.04u
M253 U86/net4 n45 U86/net14 VDD pmos W=0.205u L=0.04u
M254 U86/net6 U86/net10 U86/net14 VDD pmos W=0.205u L=0.04u
M255 U86/net4 n65 VDD VDD pmos W=0.205u L=0.04u
M256 U86/net6 U86/net4 VDD VDD pmos W=0.205u L=0.04u
M257 N8 U86/net14 VDD VDD pmos W=0.205u L=0.04u
M258 U86/net10 n45 VDD VDD pmos W=0.205u L=0.04u
M259 N6 n69 U87/net27 VSS nmos W=0.155u L=0.04u
M260 U87/net27 n70 VSS VSS nmos W=0.155u L=0.04u
M261 N6 n71 VSS VSS nmos W=0.155u L=0.04u
M262 N6 n70 U87/net13 VDD pmos W=0.205u L=0.04u
M263 U87/net13 n71 VDD VDD pmos W=0.205u L=0.04u
M264 N6 n69 U87/net13 VDD pmos W=0.205u L=0.04u
M265 n71 n72 VSS VSS nmos W=0.135u L=0.04u
M266 n71 n72 VDD VDD pmos W=0.205u L=0.04u
M267 U89/XU1-net6 n67 VSS VSS nmos W=0.155u L=0.04u
M268 n70 N125 U89/XU1-net6 VSS nmos W=0.155u L=0.04u
M269 n70 n67 VDD VDD pmos W=0.155u L=0.04u
M270 n70 N125 VDD VDD pmos W=0.155u L=0.04u
M271 N4 n68 U90/net27 VSS nmos W=0.155u L=0.04u
M272 U90/net27 n72 VSS VSS nmos W=0.155u L=0.04u
M273 N4 n73 VSS VSS nmos W=0.155u L=0.04u
M274 N4 n72 U90/net13 VDD pmos W=0.205u L=0.04u
M275 U90/net13 n73 VDD VDD pmos W=0.205u L=0.04u
M276 N4 n68 U90/net13 VDD pmos W=0.205u L=0.04u
M277 N34 n51 U91/net19 VDD pmos W=0.205u L=0.04u
M278 N34 n74 U91/net19 VDD pmos W=0.205u L=0.04u
M279 N34 n53 U91/net19 VDD pmos W=0.205u L=0.04u
M280 U91/net19 n75 VDD VDD pmos W=0.205u L=0.04u
M281 N34 n75 VSS VSS nmos W=0.155u L=0.04u
M282 U91/XI20-net13 n74 VSS VSS nmos W=0.155u L=0.04u
M283 N34 n51 U91/XI20-net17 VSS nmos W=0.155u L=0.04u
M284 U91/XI20-net17 n53 U91/XI20-net13 VSS nmos W=0.155u L=0.04u
M285 n75 n65 VSS VSS nmos W=0.155u L=0.04u
M286 n75 C3_Q1 VSS VSS nmos W=0.155u L=0.04u
M287 n75 C3_Q2 VSS VSS nmos W=0.155u L=0.04u
M288 n75 OLATCH_FEL VSS VSS nmos W=0.155u L=0.04u
M289 U92/net49 C3_Q1 U92/net52 VDD pmos W=0.41u L=0.04u
M290 U92/net52 n65 VDD VDD pmos W=0.41u L=0.04u
M291 U92/net46 C3_Q2 U92/net49 VDD pmos W=0.41u L=0.04u
M292 n75 OLATCH_FEL U92/net46 VDD pmos W=0.41u L=0.04u
M293 U93/XU1-net6 n16 VSS VSS nmos W=0.155u L=0.04u
M294 n74 C3_Q3 U93/XU1-net6 VSS nmos W=0.155u L=0.04u
M295 n74 n16 VDD VDD pmos W=0.155u L=0.04u
M296 n74 C3_Q3 VDD VDD pmos W=0.155u L=0.04u
M297 U94/XU1-net6 n16 VSS VSS nmos W=0.155u L=0.04u
M298 n51 OLATCH_FEL U94/XU1-net6 VSS nmos W=0.155u L=0.04u
M299 n51 n16 VDD VDD pmos W=0.155u L=0.04u
M300 n51 OLATCH_FEL VDD VDD pmos W=0.155u L=0.04u
M301 U95/net11 FML N33 VDD pmos W=0.205u L=0.04u
M302 U95/net11 C3_Q3 N33 VDD pmos W=0.205u L=0.04u
M303 U95/net11 n53 U95/XI16-net11 VDD pmos W=0.205u L=0.04u
M304 U95/XI16-net11 n63 VDD VDD pmos W=0.205u L=0.04u
M305 N33 n63 VSS VSS nmos W=0.155u L=0.04u
M306 N33 n53 VSS VSS nmos W=0.155u L=0.04u
M307 N33 FML U95/XI12-net17 VSS nmos W=0.155u L=0.04u
M308 U95/XI12-net17 C3_Q3 VSS VSS nmos W=0.155u L=0.04u
M309 U96/net7 FML U96/X_u4-net10 VSS nmos W=0.155u L=0.04u
M310 U96/X_u4-net10 n69 U96/X_u4-net13 VSS nmos W=0.155u L=0.04u
M311 U96/X_u4-net13 n65 VSS VSS nmos W=0.155u L=0.04u
M312 n63 U96/net7 VSS VSS nmos W=0.155u L=0.04u
M313 U96/net7 n65 VDD VDD pmos W=0.205u L=0.04u
M314 U96/net7 FML VDD VDD pmos W=0.205u L=0.04u
M315 U96/net7 n69 VDD VDD pmos W=0.205u L=0.04u
M316 n63 U96/net7 VDD VDD pmos W=0.205u L=0.04u
M317 n65 N125 VSS VSS nmos W=0.135u L=0.04u
M318 n65 N125 VDD VDD pmos W=0.205u L=0.04u
M319 U98/XU1-net6 n16 VSS VSS nmos W=0.155u L=0.04u
M320 n53 C3_Q2 U98/XU1-net6 VSS nmos W=0.155u L=0.04u
M321 n53 n16 VDD VDD pmos W=0.155u L=0.04u
M322 n53 C3_Q2 VDD VDD pmos W=0.155u L=0.04u
M323 n16 CLR VSS VSS nmos W=0.135u L=0.04u
M324 n16 CLR VDD VDD pmos W=0.205u L=0.04u
M325 N28 n69 VSS VSS nmos W=0.155u L=0.04u
M326 N28 C3_Q2 VSS VSS nmos W=0.155u L=0.04u
M327 N28 CLR VSS VSS nmos W=0.155u L=0.04u
M328 N28 OLATCH_FEL VSS VSS nmos W=0.155u L=0.04u
M329 U100/net49 C3_Q2 U100/net52 VDD pmos W=0.41u L=0.04u
M330 U100/net52 n69 VDD VDD pmos W=0.41u L=0.04u
M331 U100/net46 CLR U100/net49 VDD pmos W=0.41u L=0.04u
M332 N28 OLATCH_FEL U100/net46 VDD pmos W=0.41u L=0.04u
M333 n69 C3_Q1 VSS VSS nmos W=0.135u L=0.04u
M334 n69 C3_Q1 VDD VDD pmos W=0.205u L=0.04u
M335 U102/net4 U102/net10 U102/net14 VSS nmos W=0.155u L=0.04u
M336 U102/net6 UC_11 U102/net14 VSS nmos W=0.155u L=0.04u
M337 U102/net4 UC_10 VSS VSS nmos W=0.155u L=0.04u
M338 U102/net6 U102/net4 VSS VSS nmos W=0.155u L=0.04u
M339 N22 U102/net14 VSS VSS nmos W=0.155u L=0.04u
M340 U102/net10 UC_11 VSS VSS nmos W=0.155u L=0.04u
M341 U102/net4 UC_11 U102/net14 VDD pmos W=0.205u L=0.04u
M342 U102/net6 U102/net10 U102/net14 VDD pmos W=0.205u L=0.04u
M343 U102/net4 UC_10 VDD VDD pmos W=0.205u L=0.04u
M344 U102/net6 U102/net4 VDD VDD pmos W=0.205u L=0.04u
M345 N22 U102/net14 VDD VDD pmos W=0.205u L=0.04u
M346 U102/net10 UC_11 VDD VDD pmos W=0.205u L=0.04u
M347 N20 n77 VSS VSS nmos W=0.155u L=0.04u
M348 N20 U103/net4 VSS VSS nmos W=0.155u L=0.04u
M349 U103/net4 n76 VSS VSS nmos W=0.155u L=0.04u
M350 U103/XU1-net8 U103/net4 VDD VDD pmos W=0.205u L=0.04u
M351 N20 n77 U103/XU1-net8 VDD pmos W=0.205u L=0.04u
M352 U103/net4 n76 VDD VDD pmos W=0.205u L=0.04u
M353 n77 UC_10 U104/net27 VSS nmos W=0.155u L=0.04u
M354 U104/net27 UC_11 VSS VSS nmos W=0.155u L=0.04u
M355 n77 UC_9 VSS VSS nmos W=0.155u L=0.04u
M356 n77 UC_11 U104/net13 VDD pmos W=0.205u L=0.04u
M357 U104/net13 UC_9 VDD VDD pmos W=0.205u L=0.04u
M358 n77 UC_10 U104/net13 VDD pmos W=0.205u L=0.04u
M359 U105/net4 U105/net10 U105/net14 VSS nmos W=0.155u L=0.04u
M360 U105/net6 n73 U105/net14 VSS nmos W=0.155u L=0.04u
M361 U105/net4 C3_Q3 VSS VSS nmos W=0.155u L=0.04u
M362 U105/net6 U105/net4 VSS VSS nmos W=0.155u L=0.04u
M363 N2 U105/net14 VSS VSS nmos W=0.155u L=0.04u
M364 U105/net10 n73 VSS VSS nmos W=0.155u L=0.04u
M365 U105/net4 n73 U105/net14 VDD pmos W=0.205u L=0.04u
M366 U105/net6 U105/net10 U105/net14 VDD pmos W=0.205u L=0.04u
M367 U105/net4 C3_Q3 VDD VDD pmos W=0.205u L=0.04u
M368 U105/net6 U105/net4 VDD VDD pmos W=0.205u L=0.04u
M369 N2 U105/net14 VDD VDD pmos W=0.205u L=0.04u
M370 U105/net10 n73 VDD VDD pmos W=0.205u L=0.04u
M371 n73 n72 VSS VSS nmos W=0.155u L=0.04u
M372 n73 n68 VSS VSS nmos W=0.155u L=0.04u
M373 U106/XI1-net8 n68 VDD VDD pmos W=0.205u L=0.04u
M374 n73 n72 U106/XI1-net8 VDD pmos W=0.205u L=0.04u
M375 n68 C3_Q2 VSS VSS nmos W=0.135u L=0.04u
M376 n68 C3_Q2 VDD VDD pmos W=0.205u L=0.04u
M377 n72 C3_Q1 U108/XI0-net10 VSS nmos W=0.155u L=0.04u
M378 U108/XI0-net10 n67 U108/XI0-net13 VSS nmos W=0.155u L=0.04u
M379 U108/XI0-net13 N125 VSS VSS nmos W=0.155u L=0.04u
M380 n72 N125 VDD VDD pmos W=0.205u L=0.04u
M381 n72 C3_Q1 VDD VDD pmos W=0.205u L=0.04u
M382 n72 n67 VDD VDD pmos W=0.205u L=0.04u
M383 n67 n45 VSS VSS nmos W=0.135u L=0.04u
M384 n67 n45 VDD VDD pmos W=0.205u L=0.04u
M385 U110/net36 n79 U110/net24 VSS nmos W=0.155u L=0.04u
M386 U110/net24 UC_16 VSS VSS nmos W=0.155u L=0.04u
M387 n45 UC_17 U110/net36 VSS nmos W=0.155u L=0.04u
M388 n45 n78 U110/net36 VSS nmos W=0.155u L=0.04u
M389 n45 n78 U110/net35 VDD pmos W=0.205u L=0.04u
M390 U110/net35 UC_17 VDD VDD pmos W=0.205u L=0.04u
M391 n45 UC_16 VDD VDD pmos W=0.205u L=0.04u
M392 n45 n79 VDD VDD pmos W=0.205u L=0.04u
M393 n78 U111/net7 VSS VSS nmos W=0.155u L=0.04u
M394 U111/net7 UC_18 VSS VSS nmos W=0.155u L=0.04u
M395 U111/net7 UC_19 VSS VSS nmos W=0.155u L=0.04u
M396 n78 U111/net7 VDD VDD pmos W=0.205u L=0.04u
M397 U111/X_u7-net8 UC_19 VDD VDD pmos W=0.205u L=0.04u
M398 U111/net7 UC_18 U111/X_u7-net8 VDD pmos W=0.205u L=0.04u
M399 U112/net4 n76 U112/net14 VSS nmos W=0.155u L=0.04u
M400 U112/net6 U112/net10 U112/net14 VSS nmos W=0.17u L=0.04u
M401 U112/net4 UC_8 VSS VSS nmos W=0.155u L=0.04u
M402 U112/net6 U112/net4 VSS VSS nmos W=0.17u L=0.04u
M403 N18 U112/net14 VSS VSS nmos W=0.155u L=0.04u
M404 U112/net10 n76 VSS VSS nmos W=0.155u L=0.04u
M405 U112/net4 U112/net10 U112/net14 VDD pmos W=0.255u L=0.04u
M406 U112/net6 n76 U112/net14 VDD pmos W=0.28u L=0.04u
M407 U112/net4 UC_8 VDD VDD pmos W=0.205u L=0.04u
M408 U112/net6 U112/net4 VDD VDD pmos W=0.24u L=0.04u
M409 N18 U112/net14 VDD VDD pmos W=0.205u L=0.04u
M410 U112/net10 n76 VDD VDD pmos W=0.205u L=0.04u
M411 n76 UC_10 U113/XI0-net10 VSS nmos W=0.155u L=0.04u
M412 U113/XI0-net10 UC_11 U113/XI0-net13 VSS nmos W=0.155u L=0.04u
M413 U113/XI0-net13 UC_9 VSS VSS nmos W=0.155u L=0.04u
M414 n76 UC_9 VDD VDD pmos W=0.205u L=0.04u
M415 n76 UC_10 VDD VDD pmos W=0.205u L=0.04u
M416 n76 UC_11 VDD VDD pmos W=0.205u L=0.04u
M417 U114/net4 U114/net10 U114/net14 VSS nmos W=0.155u L=0.04u
M418 U114/net6 UC_19 U114/net14 VSS nmos W=0.155u L=0.04u
M419 U114/net4 n79 VSS VSS nmos W=0.155u L=0.04u
M420 U114/net6 U114/net4 VSS VSS nmos W=0.155u L=0.04u
M421 N16 U114/net14 VSS VSS nmos W=0.155u L=0.04u
M422 U114/net10 UC_19 VSS VSS nmos W=0.155u L=0.04u
M423 U114/net4 UC_19 U114/net14 VDD pmos W=0.205u L=0.04u
M424 U114/net6 U114/net10 U114/net14 VDD pmos W=0.205u L=0.04u
M425 U114/net4 n79 VDD VDD pmos W=0.205u L=0.04u
M426 U114/net6 U114/net4 VDD VDD pmos W=0.205u L=0.04u
M427 N16 U114/net14 VDD VDD pmos W=0.205u L=0.04u
M428 U114/net10 UC_19 VDD VDD pmos W=0.205u L=0.04u
M429 N14 n81 VSS VSS nmos W=0.155u L=0.04u
M430 N14 U115/net4 VSS VSS nmos W=0.155u L=0.04u
M431 U115/net4 n80 VSS VSS nmos W=0.155u L=0.04u
M432 U115/XU1-net8 U115/net4 VDD VDD pmos W=0.205u L=0.04u
M433 N14 n81 U115/XU1-net8 VDD pmos W=0.205u L=0.04u
M434 U115/net4 n80 VDD VDD pmos W=0.205u L=0.04u
M435 n81 UC_19 U116/net27 VSS nmos W=0.155u L=0.04u
M436 U116/net27 n79 VSS VSS nmos W=0.155u L=0.04u
M437 n81 UC_18 VSS VSS nmos W=0.155u L=0.04u
M438 n81 n79 U116/net13 VDD pmos W=0.205u L=0.04u
M439 U116/net13 UC_18 VDD VDD pmos W=0.205u L=0.04u
M440 n81 UC_19 U116/net13 VDD pmos W=0.205u L=0.04u
M441 N12 n82 U117/net27 VSS nmos W=0.155u L=0.04u
M442 U117/net27 n80 VSS VSS nmos W=0.155u L=0.04u
M443 N12 n83 VSS VSS nmos W=0.155u L=0.04u
M444 N12 n80 U117/net13 VDD pmos W=0.205u L=0.04u
M445 U117/net13 n83 VDD VDD pmos W=0.205u L=0.04u
M446 N12 n82 U117/net13 VDD pmos W=0.205u L=0.04u
M447 N112 UC_11 VSS VSS nmos W=0.135u L=0.04u
M448 N112 UC_11 VDD VDD pmos W=0.205u L=0.04u
M449 U119/net4 U119/net10 U119/net14 VSS nmos W=0.155u L=0.04u
M450 U119/net6 UC_16 U119/net14 VSS nmos W=0.155u L=0.04u
M451 U119/net4 n83 VSS VSS nmos W=0.155u L=0.04u
M452 U119/net6 U119/net4 VSS VSS nmos W=0.155u L=0.04u
M453 N10 U119/net14 VSS VSS nmos W=0.155u L=0.04u
M454 U119/net10 UC_16 VSS VSS nmos W=0.155u L=0.04u
M455 U119/net4 UC_16 U119/net14 VDD pmos W=0.205u L=0.04u
M456 U119/net6 U119/net10 U119/net14 VDD pmos W=0.205u L=0.04u
M457 U119/net4 n83 VDD VDD pmos W=0.205u L=0.04u
M458 U119/net6 U119/net4 VDD VDD pmos W=0.205u L=0.04u
M459 N10 U119/net14 VDD VDD pmos W=0.205u L=0.04u
M460 U119/net10 UC_16 VDD VDD pmos W=0.205u L=0.04u
M461 n83 n82 VSS VSS nmos W=0.155u L=0.04u
M462 n83 n80 VSS VSS nmos W=0.155u L=0.04u
M463 U120/XI1-net8 n80 VDD VDD pmos W=0.205u L=0.04u
M464 n83 n82 U120/XI1-net8 VDD pmos W=0.205u L=0.04u
M465 n80 UC_19 U121/XI0-net10 VSS nmos W=0.155u L=0.04u
M466 U121/XI0-net10 n79 U121/XI0-net13 VSS nmos W=0.155u L=0.04u
M467 U121/XI0-net13 UC_18 VSS VSS nmos W=0.155u L=0.04u
M468 n80 UC_18 VDD VDD pmos W=0.205u L=0.04u
M469 n80 UC_19 VDD VDD pmos W=0.205u L=0.04u
M470 n80 n79 VDD VDD pmos W=0.205u L=0.04u
M471 U122/net13 TESTL VSS VSS nmos W=0.155u L=0.04u
M472 U122/net16 U122/net13 VSS VSS nmos W=0.155u L=0.04u
M473 n79 n55 U122/net16 VSS nmos W=0.155u L=0.04u
M474 U122/net13 TESTL VDD VDD pmos W=0.205u L=0.04u
M475 VDD U122/net13 n79 VDD pmos W=0.205u L=0.04u
M476 VDD n55 n79 VDD pmos W=0.205u L=0.04u
M477 VSS UC_8 U123/net22 VSS nmos W=0.155u L=0.04u
M478 U123/net22 UC_11 n55 VSS nmos W=0.155u L=0.04u
M479 U123/net22 UC_9 n55 VSS nmos W=0.155u L=0.04u
M480 U123/net22 UC_10 n55 VSS nmos W=0.155u L=0.04u
M481 U123/net38 UC_10 VDD VDD pmos W=0.205u L=0.04u
M482 U123/net35 UC_9 U123/net38 VDD pmos W=0.205u L=0.04u
M483 n55 UC_11 U123/net35 VDD pmos W=0.205u L=0.04u
M484 n55 UC_8 VDD VDD pmos W=0.205u L=0.04u
M485 n82 UC_17 VSS VSS nmos W=0.135u L=0.04u
M486 n82 UC_17 VDD VDD pmos W=0.205u L=0.04u
M487 U125/net4 U125/net10 U125/net14 VSS nmos W=0.155u L=0.04u
M488 U125/net6 FML U125/net14 VSS nmos W=0.155u L=0.04u
M489 U125/net4 FM VSS VSS nmos W=0.155u L=0.04u
M490 U125/net6 U125/net4 VSS VSS nmos W=0.155u L=0.04u
M491 N1 U125/net14 VSS VSS nmos W=0.155u L=0.04u
M492 U125/net10 FML VSS VSS nmos W=0.155u L=0.04u
M493 U125/net4 FML U125/net14 VDD pmos W=0.205u L=0.04u
M494 U125/net6 U125/net10 U125/net14 VDD pmos W=0.205u L=0.04u
M495 U125/net4 FM VDD VDD pmos W=0.205u L=0.04u
M496 U125/net6 U125/net4 VDD VDD pmos W=0.205u L=0.04u
M497 N1 U125/net14 VDD VDD pmos W=0.205u L=0.04u
M498 U125/net10 FML VDD VDD pmos W=0.205u L=0.04u
M499 U126/net4 U126/net10 U126/net14 VSS nmos W=0.155u L=0.04u
M500 U126/net6 TESTL U126/net14 VSS nmos W=0.155u L=0.04u
M501 U126/net4 TEST VSS VSS nmos W=0.155u L=0.04u
M502 U126/net6 U126/net4 VSS VSS nmos W=0.155u L=0.04u
M503 N0 U126/net14 VSS VSS nmos W=0.155u L=0.04u
M504 U126/net10 TESTL VSS VSS nmos W=0.155u L=0.04u
M505 U126/net4 TESTL U126/net14 VDD pmos W=0.205u L=0.04u
M506 U126/net6 U126/net10 U126/net14 VDD pmos W=0.205u L=0.04u
M507 U126/net4 TEST VDD VDD pmos W=0.205u L=0.04u
M508 U126/net6 U126/net4 VDD VDD pmos W=0.205u L=0.04u
M509 N0 U126/net14 VDD VDD pmos W=0.205u L=0.04u
M510 U126/net10 TESTL VDD VDD pmos W=0.205u L=0.04u
.ENDS
