.SUBCKT c1908 N1 N4 N7 N10 N13 N16 N19 N22 N25 N28 N31 N34 N37 N40 N43 N46 N49 N53 N56 N60 N63 N66 N69 N72 N76 N79 N82 N85 N88 N91 N94 N99 N104 N2753 N2754 N2755 N2756 N2762 N2767 N2768 N2779 N2780 N2781 N2782 N2783 N2784 N2785 N2786 N2787 N2811 N2886 N2887 N2888 N2889 N2890 N2891 N2892 N2899 VDD VSS
M1 N2899 n177 VSS VSS nmos W=0.155u L=0.04u
M2 N2899 n178 VSS VSS nmos W=0.155u L=0.04u
M3 U184/XI1-net8 n178 VDD VDD pmos W=0.205u L=0.04u
M4 N2899 n177 U184/XI1-net8 VDD pmos W=0.205u L=0.04u
M5 U185/net29 U185/net21 U185/net041 VSS nmos W=0.155u L=0.04u
M6 U185/net035 U185/net19 VSS VSS nmos W=0.155u L=0.04u
M7 U185/net041 U185/net13 VSS VSS nmos W=0.155u L=0.04u
M8 U185/net25 n180 U185/net035 VSS nmos W=0.155u L=0.04u
M9 U185/net19 U185/net17 U185/net25 VSS nmos W=0.155u L=0.04u
M10 U185/net13 U185/net25 U185/net29 VSS nmos W=0.155u L=0.04u
M11 n178 U185/net29 VSS VSS nmos W=0.155u L=0.04u
M12 U185/net13 n181 VSS VSS nmos W=0.155u L=0.04u
M13 U185/net17 n180 VSS VSS nmos W=0.155u L=0.04u
M14 U185/net19 n179 VSS VSS nmos W=0.155u L=0.04u
M15 U185/net21 U185/net25 VSS VSS nmos W=0.155u L=0.04u
M16 U185/net028 U185/net19 VDD VDD pmos W=0.205u L=0.04u
M17 U185/net25 U185/net17 U185/net028 VDD pmos W=0.205u L=0.04u
M18 U185/net29 U185/net25 U185/net029 VDD pmos W=0.205u L=0.04u
M19 U185/net029 U185/net13 VDD VDD pmos W=0.205u L=0.04u
M20 U185/net19 n180 U185/net25 VDD pmos W=0.205u L=0.04u
M21 U185/net13 U185/net21 U185/net29 VDD pmos W=0.205u L=0.04u
M22 n178 U185/net29 VDD VDD pmos W=0.205u L=0.04u
M23 U185/net13 n181 VDD VDD pmos W=0.205u L=0.04u
M24 U185/net17 n180 VDD VDD pmos W=0.205u L=0.04u
M25 U185/net19 n179 VDD VDD pmos W=0.205u L=0.04u
M26 U185/net21 U185/net25 VDD VDD pmos W=0.205u L=0.04u
M27 U186/XU1-net6 N79 VSS VSS nmos W=0.155u L=0.04u
M28 n181 n182 U186/XU1-net6 VSS nmos W=0.155u L=0.04u
M29 n181 N79 VDD VDD pmos W=0.155u L=0.04u
M30 n181 n182 VDD VDD pmos W=0.155u L=0.04u
M31 U187/net29 U187/net21 U187/net041 VSS nmos W=0.155u L=0.04u
M32 U187/net035 U187/net19 VSS VSS nmos W=0.155u L=0.04u
M33 U187/net041 U187/net13 VSS VSS nmos W=0.155u L=0.04u
M34 U187/net25 n184 U187/net035 VSS nmos W=0.155u L=0.04u
M35 U187/net19 U187/net17 U187/net25 VSS nmos W=0.155u L=0.04u
M36 U187/net13 U187/net25 U187/net29 VSS nmos W=0.155u L=0.04u
M37 N2892 U187/net29 VSS VSS nmos W=0.155u L=0.04u
M38 U187/net13 n185 VSS VSS nmos W=0.155u L=0.04u
M39 U187/net17 n184 VSS VSS nmos W=0.155u L=0.04u
M40 U187/net19 n183 VSS VSS nmos W=0.155u L=0.04u
M41 U187/net21 U187/net25 VSS VSS nmos W=0.155u L=0.04u
M42 U187/net028 U187/net19 VDD VDD pmos W=0.205u L=0.04u
M43 U187/net25 U187/net17 U187/net028 VDD pmos W=0.205u L=0.04u
M44 U187/net29 U187/net25 U187/net029 VDD pmos W=0.205u L=0.04u
M45 U187/net029 U187/net13 VDD VDD pmos W=0.205u L=0.04u
M46 U187/net19 n184 U187/net25 VDD pmos W=0.205u L=0.04u
M47 U187/net13 U187/net21 U187/net29 VDD pmos W=0.205u L=0.04u
M48 N2892 U187/net29 VDD VDD pmos W=0.205u L=0.04u
M49 U187/net13 n185 VDD VDD pmos W=0.205u L=0.04u
M50 U187/net17 n184 VDD VDD pmos W=0.205u L=0.04u
M51 U187/net19 n183 VDD VDD pmos W=0.205u L=0.04u
M52 U187/net21 U187/net25 VDD VDD pmos W=0.205u L=0.04u
M53 U188/XU1-net6 n187 VSS VSS nmos W=0.155u L=0.04u
M54 n185 n186 U188/XU1-net6 VSS nmos W=0.155u L=0.04u
M55 n185 n187 VDD VDD pmos W=0.155u L=0.04u
M56 n185 n186 VDD VDD pmos W=0.155u L=0.04u
M57 n184 N104 U189/net27 VSS nmos W=0.155u L=0.04u
M58 U189/net27 n188 VSS VSS nmos W=0.155u L=0.04u
M59 n184 n189 VSS VSS nmos W=0.155u L=0.04u
M60 n184 n188 U189/net13 VDD pmos W=0.205u L=0.04u
M61 U189/net13 n189 VDD VDD pmos W=0.205u L=0.04u
M62 n184 N104 U189/net13 VDD pmos W=0.205u L=0.04u
M63 n183 n189 VSS VSS nmos W=0.155u L=0.04u
M64 n183 n190 VSS VSS nmos W=0.155u L=0.04u
M65 U190/XI1-net8 n190 VDD VDD pmos W=0.205u L=0.04u
M66 n183 n189 U190/XI1-net8 VDD pmos W=0.205u L=0.04u
M67 U191/net4 U191/net10 U191/net14 VSS nmos W=0.155u L=0.04u
M68 U191/net6 n191 U191/net14 VSS nmos W=0.155u L=0.04u
M69 U191/net4 n192 VSS VSS nmos W=0.155u L=0.04u
M70 U191/net6 U191/net4 VSS VSS nmos W=0.155u L=0.04u
M71 n190 U191/net14 VSS VSS nmos W=0.155u L=0.04u
M72 U191/net10 n191 VSS VSS nmos W=0.155u L=0.04u
M73 U191/net4 n191 U191/net14 VDD pmos W=0.205u L=0.04u
M74 U191/net6 U191/net10 U191/net14 VDD pmos W=0.205u L=0.04u
M75 U191/net4 n192 VDD VDD pmos W=0.205u L=0.04u
M76 U191/net6 U191/net4 VDD VDD pmos W=0.205u L=0.04u
M77 n190 U191/net14 VDD VDD pmos W=0.205u L=0.04u
M78 U191/net10 n191 VDD VDD pmos W=0.205u L=0.04u
M79 n189 n187 VSS VSS nmos W=0.155u L=0.04u
M80 n189 N91 VSS VSS nmos W=0.155u L=0.04u
M81 U192/XI1-net8 N91 VDD VDD pmos W=0.205u L=0.04u
M82 n189 n187 U192/XI1-net8 VDD pmos W=0.205u L=0.04u
M83 U193/net29 U193/net21 U193/net041 VSS nmos W=0.155u L=0.04u
M84 U193/net035 U193/net19 VSS VSS nmos W=0.155u L=0.04u
M85 U193/net041 U193/net13 VSS VSS nmos W=0.155u L=0.04u
M86 U193/net25 n194 U193/net035 VSS nmos W=0.155u L=0.04u
M87 U193/net19 U193/net17 U193/net25 VSS nmos W=0.155u L=0.04u
M88 U193/net13 U193/net25 U193/net29 VSS nmos W=0.155u L=0.04u
M89 N2891 U193/net29 VSS VSS nmos W=0.155u L=0.04u
M90 U193/net13 n195 VSS VSS nmos W=0.155u L=0.04u
M91 U193/net17 n194 VSS VSS nmos W=0.155u L=0.04u
M92 U193/net19 n193 VSS VSS nmos W=0.155u L=0.04u
M93 U193/net21 U193/net25 VSS VSS nmos W=0.155u L=0.04u
M94 U193/net028 U193/net19 VDD VDD pmos W=0.205u L=0.04u
M95 U193/net25 U193/net17 U193/net028 VDD pmos W=0.205u L=0.04u
M96 U193/net29 U193/net25 U193/net029 VDD pmos W=0.205u L=0.04u
M97 U193/net029 U193/net13 VDD VDD pmos W=0.205u L=0.04u
M98 U193/net19 n194 U193/net25 VDD pmos W=0.205u L=0.04u
M99 U193/net13 U193/net21 U193/net29 VDD pmos W=0.205u L=0.04u
M100 N2891 U193/net29 VDD VDD pmos W=0.205u L=0.04u
M101 U193/net13 n195 VDD VDD pmos W=0.205u L=0.04u
M102 U193/net17 n194 VDD VDD pmos W=0.205u L=0.04u
M103 U193/net19 n193 VDD VDD pmos W=0.205u L=0.04u
M104 U193/net21 U193/net25 VDD VDD pmos W=0.205u L=0.04u
M105 U194/XU1-net6 n196 VSS VSS nmos W=0.155u L=0.04u
M106 n195 n187 U194/XU1-net6 VSS nmos W=0.155u L=0.04u
M107 n195 n196 VDD VDD pmos W=0.155u L=0.04u
M108 n195 n187 VDD VDD pmos W=0.155u L=0.04u
M109 n194 n197 U195/net15 VSS nmos W=0.155u L=0.04u
M110 n194 n198 U195/net15 VSS nmos W=0.155u L=0.04u
M111 U195/net15 N104 VSS VSS nmos W=0.155u L=0.04u
M112 n194 N104 VDD VDD pmos W=0.205u L=0.04u
M113 n194 n197 U195/XI16-net11 VDD pmos W=0.205u L=0.04u
M114 U195/XI16-net11 n198 VDD VDD pmos W=0.205u L=0.04u
M115 n193 N104 U196/net27 VSS nmos W=0.155u L=0.04u
M116 U196/net27 n198 VSS VSS nmos W=0.155u L=0.04u
M117 n193 n199 VSS VSS nmos W=0.155u L=0.04u
M118 n193 n198 U196/net13 VDD pmos W=0.205u L=0.04u
M119 U196/net13 n199 VDD VDD pmos W=0.205u L=0.04u
M120 n193 N104 U196/net13 VDD pmos W=0.205u L=0.04u
M121 n198 N88 VSS VSS nmos W=0.135u L=0.04u
M122 n198 N88 VDD VDD pmos W=0.205u L=0.04u
M123 N2890 n177 VSS VSS nmos W=0.155u L=0.04u
M124 N2890 n200 VSS VSS nmos W=0.155u L=0.04u
M125 U198/XI1-net8 n200 VDD VDD pmos W=0.205u L=0.04u
M126 N2890 n177 U198/XI1-net8 VDD pmos W=0.205u L=0.04u
M127 U199/net4 U199/net10 U199/net14 VSS nmos W=0.155u L=0.04u
M128 U199/net6 n201 U199/net14 VSS nmos W=0.155u L=0.04u
M129 U199/net4 n202 VSS VSS nmos W=0.155u L=0.04u
M130 U199/net6 U199/net4 VSS VSS nmos W=0.155u L=0.04u
M131 n200 U199/net14 VSS VSS nmos W=0.155u L=0.04u
M132 U199/net10 n201 VSS VSS nmos W=0.155u L=0.04u
M133 U199/net4 n201 U199/net14 VDD pmos W=0.205u L=0.04u
M134 U199/net6 U199/net10 U199/net14 VDD pmos W=0.205u L=0.04u
M135 U199/net4 n202 VDD VDD pmos W=0.205u L=0.04u
M136 U199/net6 U199/net4 VDD VDD pmos W=0.205u L=0.04u
M137 n200 U199/net14 VDD VDD pmos W=0.205u L=0.04u
M138 U199/net10 n201 VDD VDD pmos W=0.205u L=0.04u
M139 U200/XU1-net6 n203 VSS VSS nmos W=0.155u L=0.04u
M140 n202 n182 U200/XU1-net6 VSS nmos W=0.155u L=0.04u
M141 n202 n203 VDD VDD pmos W=0.155u L=0.04u
M142 n202 n182 VDD VDD pmos W=0.155u L=0.04u
M143 N2889 n177 VSS VSS nmos W=0.155u L=0.04u
M144 N2889 n204 VSS VSS nmos W=0.155u L=0.04u
M145 U201/XI1-net8 n204 VDD VDD pmos W=0.205u L=0.04u
M146 N2889 n177 U201/XI1-net8 VDD pmos W=0.205u L=0.04u
M147 U202/net4 U202/net10 U202/net14 VSS nmos W=0.155u L=0.04u
M148 U202/net6 n205 U202/net14 VSS nmos W=0.155u L=0.04u
M149 U202/net4 n206 VSS VSS nmos W=0.155u L=0.04u
M150 U202/net6 U202/net4 VSS VSS nmos W=0.155u L=0.04u
M151 n204 U202/net14 VSS VSS nmos W=0.155u L=0.04u
M152 U202/net10 n205 VSS VSS nmos W=0.155u L=0.04u
M153 U202/net4 n205 U202/net14 VDD pmos W=0.205u L=0.04u
M154 U202/net6 U202/net10 U202/net14 VDD pmos W=0.205u L=0.04u
M155 U202/net4 n206 VDD VDD pmos W=0.205u L=0.04u
M156 U202/net6 U202/net4 VDD VDD pmos W=0.205u L=0.04u
M157 n204 U202/net14 VDD VDD pmos W=0.205u L=0.04u
M158 U202/net10 n205 VDD VDD pmos W=0.205u L=0.04u
M159 U203/XU1-net6 N85 VSS VSS nmos W=0.155u L=0.04u
M160 n206 n182 U203/XU1-net6 VSS nmos W=0.155u L=0.04u
M161 n206 N85 VDD VDD pmos W=0.155u L=0.04u
M162 n206 n182 VDD VDD pmos W=0.155u L=0.04u
M163 N2888 n177 VSS VSS nmos W=0.155u L=0.04u
M164 N2888 n207 VSS VSS nmos W=0.155u L=0.04u
M165 U204/XI1-net8 n207 VDD VDD pmos W=0.205u L=0.04u
M166 N2888 n177 U204/XI1-net8 VDD pmos W=0.205u L=0.04u
M167 U205/net4 U205/net10 U205/net14 VSS nmos W=0.155u L=0.04u
M168 U205/net6 n208 U205/net14 VSS nmos W=0.155u L=0.04u
M169 U205/net4 n209 VSS VSS nmos W=0.155u L=0.04u
M170 U205/net6 U205/net4 VSS VSS nmos W=0.155u L=0.04u
M171 n207 U205/net14 VSS VSS nmos W=0.155u L=0.04u
M172 U205/net10 n208 VSS VSS nmos W=0.155u L=0.04u
M173 U205/net4 n208 U205/net14 VDD pmos W=0.205u L=0.04u
M174 U205/net6 U205/net10 U205/net14 VDD pmos W=0.205u L=0.04u
M175 U205/net4 n209 VDD VDD pmos W=0.205u L=0.04u
M176 U205/net6 U205/net4 VDD VDD pmos W=0.205u L=0.04u
M177 n207 U205/net14 VDD VDD pmos W=0.205u L=0.04u
M178 U205/net10 n208 VDD VDD pmos W=0.205u L=0.04u
M179 U206/XU1-net6 N82 VSS VSS nmos W=0.155u L=0.04u
M180 n209 n182 U206/XU1-net6 VSS nmos W=0.155u L=0.04u
M181 n209 N82 VDD VDD pmos W=0.155u L=0.04u
M182 n209 n182 VDD VDD pmos W=0.155u L=0.04u
M183 N2887 n177 VSS VSS nmos W=0.155u L=0.04u
M184 N2887 n210 VSS VSS nmos W=0.155u L=0.04u
M185 U207/XI1-net8 n210 VDD VDD pmos W=0.205u L=0.04u
M186 N2887 n177 U207/XI1-net8 VDD pmos W=0.205u L=0.04u
M187 U208/net4 U208/net10 U208/net14 VSS nmos W=0.155u L=0.04u
M188 U208/net6 n211 U208/net14 VSS nmos W=0.155u L=0.04u
M189 U208/net4 n212 VSS VSS nmos W=0.155u L=0.04u
M190 U208/net6 U208/net4 VSS VSS nmos W=0.155u L=0.04u
M191 n210 U208/net14 VSS VSS nmos W=0.155u L=0.04u
M192 U208/net10 n211 VSS VSS nmos W=0.155u L=0.04u
M193 U208/net4 n211 U208/net14 VDD pmos W=0.205u L=0.04u
M194 U208/net6 U208/net10 U208/net14 VDD pmos W=0.205u L=0.04u
M195 U208/net4 n212 VDD VDD pmos W=0.205u L=0.04u
M196 U208/net6 U208/net4 VDD VDD pmos W=0.205u L=0.04u
M197 n210 U208/net14 VDD VDD pmos W=0.205u L=0.04u
M198 U208/net10 n211 VDD VDD pmos W=0.205u L=0.04u
M199 U209/XU1-net6 N76 VSS VSS nmos W=0.155u L=0.04u
M200 n212 n182 U209/XU1-net6 VSS nmos W=0.155u L=0.04u
M201 n212 N76 VDD VDD pmos W=0.155u L=0.04u
M202 n212 n182 VDD VDD pmos W=0.155u L=0.04u
M203 N2886 n177 VSS VSS nmos W=0.155u L=0.04u
M204 N2886 n213 VSS VSS nmos W=0.155u L=0.04u
M205 U210/XI1-net8 n213 VDD VDD pmos W=0.205u L=0.04u
M206 N2886 n177 U210/XI1-net8 VDD pmos W=0.205u L=0.04u
M207 U211/net4 U211/net10 U211/net14 VSS nmos W=0.155u L=0.04u
M208 U211/net6 n214 U211/net14 VSS nmos W=0.155u L=0.04u
M209 U211/net4 n215 VSS VSS nmos W=0.155u L=0.04u
M210 U211/net6 U211/net4 VSS VSS nmos W=0.155u L=0.04u
M211 n213 U211/net14 VSS VSS nmos W=0.155u L=0.04u
M212 U211/net10 n214 VSS VSS nmos W=0.155u L=0.04u
M213 U211/net4 n214 U211/net14 VDD pmos W=0.205u L=0.04u
M214 U211/net6 U211/net10 U211/net14 VDD pmos W=0.205u L=0.04u
M215 U211/net4 n215 VDD VDD pmos W=0.205u L=0.04u
M216 U211/net6 U211/net4 VDD VDD pmos W=0.205u L=0.04u
M217 n213 U211/net14 VDD VDD pmos W=0.205u L=0.04u
M218 U211/net10 n214 VDD VDD pmos W=0.205u L=0.04u
M219 U212/XU1-net6 n216 VSS VSS nmos W=0.155u L=0.04u
M220 n215 n182 U212/XU1-net6 VSS nmos W=0.155u L=0.04u
M221 n215 n216 VDD VDD pmos W=0.155u L=0.04u
M222 n215 n182 VDD VDD pmos W=0.155u L=0.04u
M223 n182 n217 VSS VSS nmos W=0.155u L=0.04u
M224 n182 n218 VSS VSS nmos W=0.155u L=0.04u
M225 U213/XI1-net8 n218 VDD VDD pmos W=0.205u L=0.04u
M226 n182 n217 U213/XI1-net8 VDD pmos W=0.205u L=0.04u
M227 n177 n187 VSS VSS nmos W=0.155u L=0.04u
M228 n177 N99 VSS VSS nmos W=0.155u L=0.04u
M229 U214/XI1-net8 N99 VDD VDD pmos W=0.205u L=0.04u
M230 n177 n187 U214/XI1-net8 VDD pmos W=0.205u L=0.04u
M231 U215/p2 n187 VSS VSS nmos W=0.155u L=0.04u
M232 U215/p0 n219 U215/p1 VSS nmos W=0.155u L=0.04u
M233 U215/p1 n220 U215/p2 VSS nmos W=0.155u L=0.04u
M234 N2811 n218 U215/p0 VSS nmos W=0.155u L=0.04u
M235 N2811 n220 VDD VDD pmos W=0.205u L=0.04u
M236 N2811 n219 VDD VDD pmos W=0.205u L=0.04u
M237 N2811 n218 VDD VDD pmos W=0.205u L=0.04u
M238 N2811 n187 VDD VDD pmos W=0.205u L=0.04u
M239 U216/net20 n221 VSS VSS nmos W=0.155u L=0.04u
M240 n220 n224 U216/p0 VSS nmos W=0.155u L=0.04u
M241 U216/p2 U216/net20 VSS VSS nmos W=0.155u L=0.04u
M242 U216/p1 n222 U216/p2 VSS nmos W=0.155u L=0.04u
M243 U216/p0 n223 U216/p1 VSS nmos W=0.155u L=0.04u
M244 U216/net20 n221 VDD VDD pmos W=0.205u L=0.04u
M245 n220 n222 VDD VDD pmos W=0.205u L=0.04u
M246 n220 n224 VDD VDD pmos W=0.205u L=0.04u
M247 n220 n223 VDD VDD pmos W=0.205u L=0.04u
M248 n220 U216/net20 VDD VDD pmos W=0.205u L=0.04u
M249 n224 n225 U217/net10 VSS nmos W=0.155u L=0.04u
M250 U217/net10 n228 VSS VSS nmos W=0.155u L=0.04u
M251 n224 n226 U217/net10 VSS nmos W=0.155u L=0.04u
M252 U217/net10 n227 VSS VSS nmos W=0.155u L=0.04u
M253 U217/net30 n228 VDD VDD pmos W=0.205u L=0.04u
M254 n224 n225 U217/net24 VDD pmos W=0.205u L=0.04u
M255 U217/net24 n226 VDD VDD pmos W=0.205u L=0.04u
M256 n224 n227 U217/net30 VDD pmos W=0.205u L=0.04u
M257 n227 n229 VSS VSS nmos W=0.155u L=0.04u
M258 n227 n230 VSS VSS nmos W=0.155u L=0.04u
M259 U218/XI1-net8 n230 VDD VDD pmos W=0.205u L=0.04u
M260 n227 n229 U218/XI1-net8 VDD pmos W=0.205u L=0.04u
M261 n225 n231 VSS VSS nmos W=0.155u L=0.04u
M262 n225 n232 VSS VSS nmos W=0.155u L=0.04u
M263 U219/XI1-net8 n232 VDD VDD pmos W=0.205u L=0.04u
M264 n225 n231 U219/XI1-net8 VDD pmos W=0.205u L=0.04u
M265 n219 n233 U220/XI0-net10 VSS nmos W=0.155u L=0.04u
M266 U220/XI0-net10 n234 U220/XI0-net13 VSS nmos W=0.155u L=0.04u
M267 U220/XI0-net13 n235 VSS VSS nmos W=0.155u L=0.04u
M268 n219 n235 VDD VDD pmos W=0.205u L=0.04u
M269 n219 n233 VDD VDD pmos W=0.205u L=0.04u
M270 n219 n234 VDD VDD pmos W=0.205u L=0.04u
M271 U221/net8 n223 U221/net26 VSS nmos W=0.155u L=0.04u
M272 U221/net26 n222 VSS VSS nmos W=0.155u L=0.04u
M273 U221/net29 U221/net8 VSS VSS nmos W=0.155u L=0.04u
M274 U221/net29 n236 n234 VSS nmos W=0.155u L=0.04u
M275 U221/net29 n221 n234 VSS nmos W=0.155u L=0.04u
M276 U221/net8 n222 VDD VDD pmos W=0.205u L=0.04u
M277 U221/net8 n223 VDD VDD pmos W=0.205u L=0.04u
M278 n234 U221/net8 VDD VDD pmos W=0.205u L=0.04u
M279 n234 n236 U221/net20 VDD pmos W=0.205u L=0.04u
M280 U221/net20 n221 VDD VDD pmos W=0.205u L=0.04u
M281 U222/net29 n238 VSS VSS nmos W=0.155u L=0.04u
M282 n236 n222 U222/net29 VSS nmos W=0.155u L=0.04u
M283 n236 n223 U222/net23 VSS nmos W=0.155u L=0.04u
M284 U222/net23 n237 VSS VSS nmos W=0.155u L=0.04u
M285 U222/net20 n237 n236 VDD pmos W=0.205u L=0.04u
M286 U222/net20 n223 n236 VDD pmos W=0.205u L=0.04u
M287 VDD n222 U222/net20 VDD pmos W=0.205u L=0.04u
M288 VDD n238 U222/net20 VDD pmos W=0.205u L=0.04u
M289 U223/XU1-net6 n240 VSS VSS nmos W=0.155u L=0.04u
M290 n238 n239 U223/XU1-net6 VSS nmos W=0.155u L=0.04u
M291 n238 n240 VDD VDD pmos W=0.155u L=0.04u
M292 n238 n239 VDD VDD pmos W=0.155u L=0.04u
M293 U224/XU1-net6 n242 VSS VSS nmos W=0.155u L=0.04u
M294 n237 n241 U224/XU1-net6 VSS nmos W=0.155u L=0.04u
M295 n237 n242 VDD VDD pmos W=0.155u L=0.04u
M296 n237 n241 VDD VDD pmos W=0.155u L=0.04u
M297 n218 n186 VSS VSS nmos W=0.155u L=0.04u
M298 n218 n196 VSS VSS nmos W=0.155u L=0.04u
M299 U225/XI1-net8 n196 VDD VDD pmos W=0.205u L=0.04u
M300 n218 n186 U225/XI1-net8 VDD pmos W=0.205u L=0.04u
M301 U226/p2 n246 VSS VSS nmos W=0.155u L=0.04u
M302 U226/p0 n244 U226/p1 VSS nmos W=0.155u L=0.04u
M303 U226/p1 n245 U226/p2 VSS nmos W=0.155u L=0.04u
M304 n196 n243 U226/p0 VSS nmos W=0.155u L=0.04u
M305 n196 n245 VDD VDD pmos W=0.205u L=0.04u
M306 n196 n244 VDD VDD pmos W=0.205u L=0.04u
M307 n196 n243 VDD VDD pmos W=0.205u L=0.04u
M308 n196 n246 VDD VDD pmos W=0.205u L=0.04u
M309 n246 n250 VSS VSS nmos W=0.155u L=0.04u
M310 n246 n249 VSS VSS nmos W=0.155u L=0.04u
M311 n246 n248 VSS VSS nmos W=0.155u L=0.04u
M312 n246 n247 VSS VSS nmos W=0.155u L=0.04u
M313 U227/net49 n249 U227/net52 VDD pmos W=0.41u L=0.04u
M314 U227/net52 n250 VDD VDD pmos W=0.41u L=0.04u
M315 U227/net46 n248 U227/net49 VDD pmos W=0.41u L=0.04u
M316 n246 n247 U227/net46 VDD pmos W=0.41u L=0.04u
M317 n245 n252 VSS VSS nmos W=0.155u L=0.04u
M318 n245 U228/net4 VSS VSS nmos W=0.155u L=0.04u
M319 U228/net4 n251 VSS VSS nmos W=0.155u L=0.04u
M320 U228/XU1-net8 U228/net4 VDD VDD pmos W=0.205u L=0.04u
M321 n245 n252 U228/XU1-net8 VDD pmos W=0.205u L=0.04u
M322 U228/net4 n251 VDD VDD pmos W=0.205u L=0.04u
M323 U229/p2 n256 VSS VSS nmos W=0.155u L=0.04u
M324 U229/p0 n254 U229/p1 VSS nmos W=0.155u L=0.04u
M325 U229/p1 n255 U229/p2 VSS nmos W=0.155u L=0.04u
M326 n186 n253 U229/p0 VSS nmos W=0.155u L=0.04u
M327 n186 n255 VDD VDD pmos W=0.205u L=0.04u
M328 n186 n254 VDD VDD pmos W=0.205u L=0.04u
M329 n186 n253 VDD VDD pmos W=0.205u L=0.04u
M330 n186 n256 VDD VDD pmos W=0.205u L=0.04u
M331 n256 n260 VSS VSS nmos W=0.155u L=0.04u
M332 n256 n259 VSS VSS nmos W=0.155u L=0.04u
M333 n256 n258 VSS VSS nmos W=0.155u L=0.04u
M334 n256 n257 VSS VSS nmos W=0.155u L=0.04u
M335 U230/net49 n259 U230/net52 VDD pmos W=0.41u L=0.04u
M336 U230/net52 n260 VDD VDD pmos W=0.41u L=0.04u
M337 U230/net46 n258 U230/net49 VDD pmos W=0.41u L=0.04u
M338 n256 n257 U230/net46 VDD pmos W=0.41u L=0.04u
M339 n255 n262 VSS VSS nmos W=0.155u L=0.04u
M340 n255 U231/net4 VSS VSS nmos W=0.155u L=0.04u
M341 U231/net4 n261 VSS VSS nmos W=0.155u L=0.04u
M342 U231/XU1-net8 U231/net4 VDD VDD pmos W=0.205u L=0.04u
M343 n255 n262 U231/XU1-net8 VDD pmos W=0.205u L=0.04u
M344 U231/net4 n261 VDD VDD pmos W=0.205u L=0.04u
M345 U232/net4 N40 U232/net14 VSS nmos W=0.155u L=0.04u
M346 U232/net6 U232/net10 U232/net14 VSS nmos W=0.17u L=0.04u
M347 U232/net4 n254 VSS VSS nmos W=0.155u L=0.04u
M348 U232/net6 U232/net4 VSS VSS nmos W=0.17u L=0.04u
M349 N2787 U232/net14 VSS VSS nmos W=0.155u L=0.04u
M350 U232/net10 N40 VSS VSS nmos W=0.155u L=0.04u
M351 U232/net4 U232/net10 U232/net14 VDD pmos W=0.255u L=0.04u
M352 U232/net6 N40 U232/net14 VDD pmos W=0.28u L=0.04u
M353 U232/net4 n254 VDD VDD pmos W=0.205u L=0.04u
M354 U232/net6 U232/net4 VDD VDD pmos W=0.24u L=0.04u
M355 N2787 U232/net14 VDD VDD pmos W=0.205u L=0.04u
M356 U232/net10 N40 VDD VDD pmos W=0.205u L=0.04u
M357 n254 n230 U233/XI0-net10 VSS nmos W=0.155u L=0.04u
M358 U233/XI0-net10 n263 U233/XI0-net13 VSS nmos W=0.155u L=0.04u
M359 U233/XI0-net13 n231 VSS VSS nmos W=0.155u L=0.04u
M360 n254 n231 VDD VDD pmos W=0.205u L=0.04u
M361 n254 n230 VDD VDD pmos W=0.205u L=0.04u
M362 n254 n263 VDD VDD pmos W=0.205u L=0.04u
M363 U234/net4 U234/net10 U234/net14 VSS nmos W=0.155u L=0.04u
M364 U234/net6 N37 U234/net14 VSS nmos W=0.155u L=0.04u
M365 U234/net4 n260 VSS VSS nmos W=0.155u L=0.04u
M366 U234/net6 U234/net4 VSS VSS nmos W=0.155u L=0.04u
M367 N2786 U234/net14 VSS VSS nmos W=0.155u L=0.04u
M368 U234/net10 N37 VSS VSS nmos W=0.155u L=0.04u
M369 U234/net4 N37 U234/net14 VDD pmos W=0.205u L=0.04u
M370 U234/net6 U234/net10 U234/net14 VDD pmos W=0.205u L=0.04u
M371 U234/net4 n260 VDD VDD pmos W=0.205u L=0.04u
M372 U234/net6 U234/net4 VDD VDD pmos W=0.205u L=0.04u
M373 N2786 U234/net14 VDD VDD pmos W=0.205u L=0.04u
M374 U234/net10 N37 VDD VDD pmos W=0.205u L=0.04u
M375 n260 U235/net6 VSS VSS nmos W=0.155u L=0.04u
M376 U235/net6 n233 U235/XU30-net23 VSS nmos W=0.155u L=0.04u
M377 U235/XU30-net23 n263 U235/XU30-net26 VSS nmos W=0.155u L=0.04u
M378 U235/XU30-net26 n264 U235/XU30-net29 VSS nmos W=0.155u L=0.04u
M379 U235/XU30-net29 n265 VSS VSS nmos W=0.155u L=0.04u
M380 n260 U235/net6 VDD VDD pmos W=0.205u L=0.04u
M381 U235/net6 n265 VDD VDD pmos W=0.205u L=0.04u
M382 U235/net6 n264 VDD VDD pmos W=0.205u L=0.04u
M383 U235/net6 n263 VDD VDD pmos W=0.205u L=0.04u
M384 U235/net6 n233 VDD VDD pmos W=0.205u L=0.04u
M385 U236/net4 U236/net10 U236/net14 VSS nmos W=0.155u L=0.04u
M386 U236/net6 N34 U236/net14 VSS nmos W=0.155u L=0.04u
M387 U236/net4 n259 VSS VSS nmos W=0.155u L=0.04u
M388 U236/net6 U236/net4 VSS VSS nmos W=0.155u L=0.04u
M389 N2785 U236/net14 VSS VSS nmos W=0.155u L=0.04u
M390 U236/net10 N34 VSS VSS nmos W=0.155u L=0.04u
M391 U236/net4 N34 U236/net14 VDD pmos W=0.205u L=0.04u
M392 U236/net6 U236/net10 U236/net14 VDD pmos W=0.205u L=0.04u
M393 U236/net4 n259 VDD VDD pmos W=0.205u L=0.04u
M394 U236/net6 U236/net4 VDD VDD pmos W=0.205u L=0.04u
M395 N2785 U236/net14 VDD VDD pmos W=0.205u L=0.04u
M396 U236/net10 N34 VDD VDD pmos W=0.205u L=0.04u
M397 U237/net7 n263 U237/X_u4-net10 VSS nmos W=0.155u L=0.04u
M398 U237/X_u4-net10 n232 U237/X_u4-net13 VSS nmos W=0.155u L=0.04u
M399 U237/X_u4-net13 n229 VSS VSS nmos W=0.155u L=0.04u
M400 n259 U237/net7 VSS VSS nmos W=0.155u L=0.04u
M401 U237/net7 n229 VDD VDD pmos W=0.205u L=0.04u
M402 U237/net7 n263 VDD VDD pmos W=0.205u L=0.04u
M403 U237/net7 n232 VDD VDD pmos W=0.205u L=0.04u
M404 n259 U237/net7 VDD VDD pmos W=0.205u L=0.04u
M405 U238/net4 U238/net10 U238/net14 VSS nmos W=0.155u L=0.04u
M406 U238/net6 N31 U238/net14 VSS nmos W=0.155u L=0.04u
M407 U238/net4 n258 VSS VSS nmos W=0.155u L=0.04u
M408 U238/net6 U238/net4 VSS VSS nmos W=0.155u L=0.04u
M409 N2784 U238/net14 VSS VSS nmos W=0.155u L=0.04u
M410 U238/net10 N31 VSS VSS nmos W=0.155u L=0.04u
M411 U238/net4 N31 U238/net14 VDD pmos W=0.205u L=0.04u
M412 U238/net6 U238/net10 U238/net14 VDD pmos W=0.205u L=0.04u
M413 U238/net4 n258 VDD VDD pmos W=0.205u L=0.04u
M414 U238/net6 U238/net4 VDD VDD pmos W=0.205u L=0.04u
M415 N2784 U238/net14 VDD VDD pmos W=0.205u L=0.04u
M416 U238/net10 N31 VDD VDD pmos W=0.205u L=0.04u
M417 U239/net7 n263 U239/X_u4-net10 VSS nmos W=0.155u L=0.04u
M418 U239/X_u4-net10 n232 U239/X_u4-net13 VSS nmos W=0.155u L=0.04u
M419 U239/X_u4-net13 n230 VSS VSS nmos W=0.155u L=0.04u
M420 n258 U239/net7 VSS VSS nmos W=0.155u L=0.04u
M421 U239/net7 n230 VDD VDD pmos W=0.205u L=0.04u
M422 U239/net7 n263 VDD VDD pmos W=0.205u L=0.04u
M423 U239/net7 n232 VDD VDD pmos W=0.205u L=0.04u
M424 n258 U239/net7 VDD VDD pmos W=0.205u L=0.04u
M425 n263 U240/net6 VSS VSS nmos W=0.155u L=0.04u
M426 U240/X_u2-net6 n266 VSS VSS nmos W=0.155u L=0.04u
M427 U240/net6 n223 U240/X_u2-net6 VSS nmos W=0.155u L=0.04u
M428 n263 U240/net6 VDD VDD pmos W=0.205u L=0.04u
M429 U240/net6 n266 VDD VDD pmos W=0.205u L=0.04u
M430 U240/net6 n223 VDD VDD pmos W=0.205u L=0.04u
M431 U241/net11 n267 VSS VSS nmos W=0.155u L=0.04u
M432 U241/net11 n268 VSS VSS nmos W=0.155u L=0.04u
M433 n223 n239 VSS VSS nmos W=0.155u L=0.04u
M434 n223 U241/net11 VSS VSS nmos W=0.155u L=0.04u
M435 U241/XI1-net8 n268 VDD VDD pmos W=0.205u L=0.04u
M436 U241/net11 n267 U241/XI1-net8 VDD pmos W=0.205u L=0.04u
M437 U241/XU39-net8 U241/net11 VDD VDD pmos W=0.205u L=0.04u
M438 n223 n239 U241/XU39-net8 VDD pmos W=0.205u L=0.04u
M439 U242/net4 U242/net10 U242/net14 VSS nmos W=0.155u L=0.04u
M440 U242/net6 N25 U242/net14 VSS nmos W=0.155u L=0.04u
M441 U242/net4 n262 VSS VSS nmos W=0.155u L=0.04u
M442 U242/net6 U242/net4 VSS VSS nmos W=0.155u L=0.04u
M443 N2783 U242/net14 VSS VSS nmos W=0.155u L=0.04u
M444 U242/net10 N25 VSS VSS nmos W=0.155u L=0.04u
M445 U242/net4 N25 U242/net14 VDD pmos W=0.205u L=0.04u
M446 U242/net6 U242/net10 U242/net14 VDD pmos W=0.205u L=0.04u
M447 U242/net4 n262 VDD VDD pmos W=0.205u L=0.04u
M448 U242/net6 U242/net4 VDD VDD pmos W=0.205u L=0.04u
M449 N2783 U242/net14 VDD VDD pmos W=0.205u L=0.04u
M450 U242/net10 N25 VDD VDD pmos W=0.205u L=0.04u
M451 n262 U243/net6 VSS VSS nmos W=0.155u L=0.04u
M452 U243/net6 n222 U243/XU30-net23 VSS nmos W=0.155u L=0.04u
M453 U243/XU30-net23 n231 U243/XU30-net26 VSS nmos W=0.155u L=0.04u
M454 U243/XU30-net26 n269 U243/XU30-net29 VSS nmos W=0.155u L=0.04u
M455 U243/XU30-net29 n230 VSS VSS nmos W=0.155u L=0.04u
M456 n262 U243/net6 VDD VDD pmos W=0.205u L=0.04u
M457 U243/net6 n230 VDD VDD pmos W=0.205u L=0.04u
M458 U243/net6 n269 VDD VDD pmos W=0.205u L=0.04u
M459 U243/net6 n231 VDD VDD pmos W=0.205u L=0.04u
M460 U243/net6 n222 VDD VDD pmos W=0.205u L=0.04u
M461 n269 n270 VSS VSS nmos W=0.155u L=0.04u
M462 n269 n240 VSS VSS nmos W=0.155u L=0.04u
M463 U244/XI1-net8 n240 VDD VDD pmos W=0.205u L=0.04u
M464 n269 n270 U244/XI1-net8 VDD pmos W=0.205u L=0.04u
M465 U245/net14 N91 U245/net20 VSS nmos W=0.155u L=0.04u
M466 U245/net14 n271 U245/net20 VSS nmos W=0.155u L=0.04u
M467 U245/net20 n221 VSS VSS nmos W=0.155u L=0.04u
M468 n270 U245/net14 VSS VSS nmos W=0.155u L=0.04u
M469 n270 U245/net14 VDD VDD pmos W=0.205u L=0.04u
M470 U245/net14 n221 VDD VDD pmos W=0.205u L=0.04u
M471 U245/net24 N91 VDD VDD pmos W=0.205u L=0.04u
M472 U245/net14 n271 U245/net24 VDD pmos W=0.205u L=0.04u
M473 U246/net4 U246/net10 U246/net14 VSS nmos W=0.155u L=0.04u
M474 U246/net6 N22 U246/net14 VSS nmos W=0.155u L=0.04u
M475 U246/net4 n252 VSS VSS nmos W=0.155u L=0.04u
M476 U246/net6 U246/net4 VSS VSS nmos W=0.155u L=0.04u
M477 N2782 U246/net14 VSS VSS nmos W=0.155u L=0.04u
M478 U246/net10 N22 VSS VSS nmos W=0.155u L=0.04u
M479 U246/net4 N22 U246/net14 VDD pmos W=0.205u L=0.04u
M480 U246/net6 U246/net10 U246/net14 VDD pmos W=0.205u L=0.04u
M481 U246/net4 n252 VDD VDD pmos W=0.205u L=0.04u
M482 U246/net6 U246/net4 VDD VDD pmos W=0.205u L=0.04u
M483 N2782 U246/net14 VDD VDD pmos W=0.205u L=0.04u
M484 U246/net10 N22 VDD VDD pmos W=0.205u L=0.04u
M485 n252 U247/net6 VSS VSS nmos W=0.155u L=0.04u
M486 U247/net6 n235 U247/XU30-net23 VSS nmos W=0.155u L=0.04u
M487 U247/XU30-net23 n272 U247/XU30-net26 VSS nmos W=0.155u L=0.04u
M488 U247/XU30-net26 n273 U247/XU30-net29 VSS nmos W=0.155u L=0.04u
M489 U247/XU30-net29 n222 VSS VSS nmos W=0.155u L=0.04u
M490 n252 U247/net6 VDD VDD pmos W=0.205u L=0.04u
M491 U247/net6 n222 VDD VDD pmos W=0.205u L=0.04u
M492 U247/net6 n273 VDD VDD pmos W=0.205u L=0.04u
M493 U247/net6 n272 VDD VDD pmos W=0.205u L=0.04u
M494 U247/net6 n235 VDD VDD pmos W=0.205u L=0.04u
M495 U248/net4 n251 U248/net14 VSS nmos W=0.155u L=0.04u
M496 U248/net6 U248/net10 U248/net14 VSS nmos W=0.17u L=0.04u
M497 U248/net4 N19 VSS VSS nmos W=0.155u L=0.04u
M498 U248/net6 U248/net4 VSS VSS nmos W=0.17u L=0.04u
M499 N2781 U248/net14 VSS VSS nmos W=0.155u L=0.04u
M500 U248/net10 n251 VSS VSS nmos W=0.155u L=0.04u
M501 U248/net4 U248/net10 U248/net14 VDD pmos W=0.255u L=0.04u
M502 U248/net6 n251 U248/net14 VDD pmos W=0.28u L=0.04u
M503 U248/net4 N19 VDD VDD pmos W=0.205u L=0.04u
M504 U248/net6 U248/net4 VDD VDD pmos W=0.24u L=0.04u
M505 N2781 U248/net14 VDD VDD pmos W=0.205u L=0.04u
M506 U248/net10 n251 VDD VDD pmos W=0.205u L=0.04u
M507 U249/p2 n233 VSS VSS nmos W=0.155u L=0.04u
M508 U249/p0 n222 U249/p1 VSS nmos W=0.155u L=0.04u
M509 U249/p1 n274 U249/p2 VSS nmos W=0.155u L=0.04u
M510 n251 n272 U249/p0 VSS nmos W=0.155u L=0.04u
M511 n251 n274 VDD VDD pmos W=0.205u L=0.04u
M512 n251 n222 VDD VDD pmos W=0.205u L=0.04u
M513 n251 n272 VDD VDD pmos W=0.205u L=0.04u
M514 n251 n233 VDD VDD pmos W=0.205u L=0.04u
M515 n274 n275 VSS VSS nmos W=0.155u L=0.04u
M516 n274 n276 VSS VSS nmos W=0.155u L=0.04u
M517 U250/XI1-net8 n276 VDD VDD pmos W=0.205u L=0.04u
M518 n274 n275 U250/XI1-net8 VDD pmos W=0.205u L=0.04u
M519 U251/net4 n243 U251/net14 VSS nmos W=0.155u L=0.04u
M520 U251/net6 U251/net10 U251/net14 VSS nmos W=0.17u L=0.04u
M521 U251/net4 N16 VSS VSS nmos W=0.155u L=0.04u
M522 U251/net6 U251/net4 VSS VSS nmos W=0.17u L=0.04u
M523 N2780 U251/net14 VSS VSS nmos W=0.155u L=0.04u
M524 U251/net10 n243 VSS VSS nmos W=0.155u L=0.04u
M525 U251/net4 U251/net10 U251/net14 VDD pmos W=0.255u L=0.04u
M526 U251/net6 n243 U251/net14 VDD pmos W=0.28u L=0.04u
M527 U251/net4 N16 VDD VDD pmos W=0.205u L=0.04u
M528 U251/net6 U251/net4 VDD VDD pmos W=0.24u L=0.04u
M529 N2780 U251/net14 VDD VDD pmos W=0.205u L=0.04u
M530 U251/net10 n243 VDD VDD pmos W=0.205u L=0.04u
M531 U252/XU1-net6 n229 VSS VSS nmos W=0.155u L=0.04u
M532 n243 n277 U252/XU1-net6 VSS nmos W=0.155u L=0.04u
M533 n243 n229 VDD VDD pmos W=0.155u L=0.04u
M534 n243 n277 VDD VDD pmos W=0.155u L=0.04u
M535 U253/net4 n244 U253/net14 VSS nmos W=0.155u L=0.04u
M536 U253/net6 U253/net10 U253/net14 VSS nmos W=0.17u L=0.04u
M537 U253/net4 N13 VSS VSS nmos W=0.155u L=0.04u
M538 U253/net6 U253/net4 VSS VSS nmos W=0.17u L=0.04u
M539 N2779 U253/net14 VSS VSS nmos W=0.155u L=0.04u
M540 U253/net10 n244 VSS VSS nmos W=0.155u L=0.04u
M541 U253/net4 U253/net10 U253/net14 VDD pmos W=0.255u L=0.04u
M542 U253/net6 n244 U253/net14 VDD pmos W=0.28u L=0.04u
M543 U253/net4 N13 VDD VDD pmos W=0.205u L=0.04u
M544 U253/net6 U253/net4 VDD VDD pmos W=0.24u L=0.04u
M545 N2779 U253/net14 VDD VDD pmos W=0.205u L=0.04u
M546 U253/net10 n244 VDD VDD pmos W=0.205u L=0.04u
M547 U254/XU1-net6 n230 VSS VSS nmos W=0.155u L=0.04u
M548 n244 n277 U254/XU1-net6 VSS nmos W=0.155u L=0.04u
M549 n244 n230 VDD VDD pmos W=0.155u L=0.04u
M550 n244 n277 VDD VDD pmos W=0.155u L=0.04u
M551 U255/net7 n222 U255/X_u4-net10 VSS nmos W=0.155u L=0.04u
M552 U255/X_u4-net10 n232 U255/X_u4-net13 VSS nmos W=0.155u L=0.04u
M553 U255/X_u4-net13 n272 VSS VSS nmos W=0.155u L=0.04u
M554 n277 U255/net7 VSS VSS nmos W=0.155u L=0.04u
M555 U255/net7 n272 VDD VDD pmos W=0.205u L=0.04u
M556 U255/net7 n222 VDD VDD pmos W=0.205u L=0.04u
M557 U255/net7 n232 VDD VDD pmos W=0.205u L=0.04u
M558 n277 U255/net7 VDD VDD pmos W=0.205u L=0.04u
M559 U256/net11 n278 VSS VSS nmos W=0.155u L=0.04u
M560 U256/net11 n279 VSS VSS nmos W=0.155u L=0.04u
M561 n222 n241 VSS VSS nmos W=0.155u L=0.04u
M562 n222 U256/net11 VSS VSS nmos W=0.155u L=0.04u
M563 U256/XI1-net8 n279 VDD VDD pmos W=0.205u L=0.04u
M564 U256/net11 n278 U256/XI1-net8 VDD pmos W=0.205u L=0.04u
M565 U256/XU39-net8 U256/net11 VDD VDD pmos W=0.205u L=0.04u
M566 n222 n241 U256/XU39-net8 VDD pmos W=0.205u L=0.04u
M567 U257/net4 n261 U257/net14 VSS nmos W=0.155u L=0.04u
M568 U257/net6 U257/net10 U257/net14 VSS nmos W=0.17u L=0.04u
M569 U257/net4 N46 VSS VSS nmos W=0.155u L=0.04u
M570 U257/net6 U257/net4 VSS VSS nmos W=0.17u L=0.04u
M571 N2768 U257/net14 VSS VSS nmos W=0.155u L=0.04u
M572 U257/net10 n261 VSS VSS nmos W=0.155u L=0.04u
M573 U257/net4 U257/net10 U257/net14 VDD pmos W=0.255u L=0.04u
M574 U257/net6 n261 U257/net14 VDD pmos W=0.28u L=0.04u
M575 U257/net4 N46 VDD VDD pmos W=0.205u L=0.04u
M576 U257/net6 U257/net4 VDD VDD pmos W=0.24u L=0.04u
M577 N2768 U257/net14 VDD VDD pmos W=0.205u L=0.04u
M578 U257/net10 n261 VDD VDD pmos W=0.205u L=0.04u
M579 U258/XU1-net6 n230 VSS VSS nmos W=0.155u L=0.04u
M580 n261 n280 U258/XU1-net6 VSS nmos W=0.155u L=0.04u
M581 n261 n230 VDD VDD pmos W=0.155u L=0.04u
M582 n261 n280 VDD VDD pmos W=0.155u L=0.04u
M583 U259/net4 U259/net10 U259/net14 VSS nmos W=0.155u L=0.04u
M584 U259/net6 N43 U259/net14 VSS nmos W=0.155u L=0.04u
M585 U259/net4 n257 VSS VSS nmos W=0.155u L=0.04u
M586 U259/net6 U259/net4 VSS VSS nmos W=0.155u L=0.04u
M587 N2767 U259/net14 VSS VSS nmos W=0.155u L=0.04u
M588 U259/net10 N43 VSS VSS nmos W=0.155u L=0.04u
M589 U259/net4 N43 U259/net14 VDD pmos W=0.205u L=0.04u
M590 U259/net6 U259/net10 U259/net14 VDD pmos W=0.205u L=0.04u
M591 U259/net4 n257 VDD VDD pmos W=0.205u L=0.04u
M592 U259/net6 U259/net4 VDD VDD pmos W=0.205u L=0.04u
M593 N2767 U259/net14 VDD VDD pmos W=0.205u L=0.04u
M594 U259/net10 N43 VDD VDD pmos W=0.205u L=0.04u
M595 n257 U260/net6 VSS VSS nmos W=0.155u L=0.04u
M596 U260/net6 n232 U260/XU30-net23 VSS nmos W=0.155u L=0.04u
M597 U260/XU30-net23 n266 U260/XU30-net26 VSS nmos W=0.155u L=0.04u
M598 U260/XU30-net26 n273 U260/XU30-net29 VSS nmos W=0.155u L=0.04u
M599 U260/XU30-net29 n281 VSS VSS nmos W=0.155u L=0.04u
M600 n257 U260/net6 VDD VDD pmos W=0.205u L=0.04u
M601 U260/net6 n281 VDD VDD pmos W=0.205u L=0.04u
M602 U260/net6 n273 VDD VDD pmos W=0.205u L=0.04u
M603 U260/net6 n266 VDD VDD pmos W=0.205u L=0.04u
M604 U260/net6 n232 VDD VDD pmos W=0.205u L=0.04u
M605 n273 n282 VSS VSS nmos W=0.155u L=0.04u
M606 n273 n283 VSS VSS nmos W=0.155u L=0.04u
M607 U261/XI1-net8 n283 VDD VDD pmos W=0.205u L=0.04u
M608 n273 n282 U261/XI1-net8 VDD pmos W=0.205u L=0.04u
M609 U262/net4 n253 U262/net14 VSS nmos W=0.155u L=0.04u
M610 U262/net6 U262/net10 U262/net14 VSS nmos W=0.17u L=0.04u
M611 U262/net4 N28 VSS VSS nmos W=0.155u L=0.04u
M612 U262/net6 U262/net4 VSS VSS nmos W=0.17u L=0.04u
M613 N2762 U262/net14 VSS VSS nmos W=0.155u L=0.04u
M614 U262/net10 n253 VSS VSS nmos W=0.155u L=0.04u
M615 U262/net4 U262/net10 U262/net14 VDD pmos W=0.255u L=0.04u
M616 U262/net6 n253 U262/net14 VDD pmos W=0.28u L=0.04u
M617 U262/net4 N28 VDD VDD pmos W=0.205u L=0.04u
M618 U262/net6 U262/net4 VDD VDD pmos W=0.24u L=0.04u
M619 N2762 U262/net14 VDD VDD pmos W=0.205u L=0.04u
M620 U262/net10 n253 VDD VDD pmos W=0.205u L=0.04u
M621 U263/XU1-net6 n229 VSS VSS nmos W=0.155u L=0.04u
M622 n253 n280 U263/XU1-net6 VSS nmos W=0.155u L=0.04u
M623 n253 n229 VDD VDD pmos W=0.155u L=0.04u
M624 n253 n280 VDD VDD pmos W=0.155u L=0.04u
M625 n280 U264/net6 VSS VSS nmos W=0.155u L=0.04u
M626 U264/net6 n266 U264/XU30-net23 VSS nmos W=0.155u L=0.04u
M627 U264/XU30-net23 n281 U264/XU30-net26 VSS nmos W=0.155u L=0.04u
M628 U264/XU30-net26 n264 U264/XU30-net29 VSS nmos W=0.155u L=0.04u
M629 U264/XU30-net29 n265 VSS VSS nmos W=0.155u L=0.04u
M630 n280 U264/net6 VDD VDD pmos W=0.205u L=0.04u
M631 U264/net6 n265 VDD VDD pmos W=0.205u L=0.04u
M632 U264/net6 n264 VDD VDD pmos W=0.205u L=0.04u
M633 U264/net6 n281 VDD VDD pmos W=0.205u L=0.04u
M634 U264/net6 n266 VDD VDD pmos W=0.205u L=0.04u
M635 n281 n240 VSS VSS nmos W=0.135u L=0.04u
M636 n281 n240 VDD VDD pmos W=0.205u L=0.04u
M637 n266 n242 VSS VSS nmos W=0.155u L=0.04u
M638 n266 U266/net4 VSS VSS nmos W=0.155u L=0.04u
M639 U266/net4 n284 VSS VSS nmos W=0.155u L=0.04u
M640 U266/XU1-net8 U266/net4 VDD VDD pmos W=0.205u L=0.04u
M641 n266 n242 U266/XU1-net8 VDD pmos W=0.205u L=0.04u
M642 U266/net4 n284 VDD VDD pmos W=0.205u L=0.04u
M643 n284 N91 U267/net15 VSS nmos W=0.155u L=0.04u
M644 n284 n271 U267/net15 VSS nmos W=0.155u L=0.04u
M645 U267/net15 n221 VSS VSS nmos W=0.155u L=0.04u
M646 n284 n221 VDD VDD pmos W=0.205u L=0.04u
M647 n284 N91 U267/XI16-net11 VDD pmos W=0.205u L=0.04u
M648 U267/XI16-net11 n271 VDD VDD pmos W=0.205u L=0.04u
M649 U268/net4 U268/net10 U268/net14 VSS nmos W=0.155u L=0.04u
M650 U268/net6 N10 U268/net14 VSS nmos W=0.155u L=0.04u
M651 U268/net4 n250 VSS VSS nmos W=0.155u L=0.04u
M652 U268/net6 U268/net4 VSS VSS nmos W=0.155u L=0.04u
M653 N2756 U268/net14 VSS VSS nmos W=0.155u L=0.04u
M654 U268/net10 N10 VSS VSS nmos W=0.155u L=0.04u
M655 U268/net4 N10 U268/net14 VDD pmos W=0.205u L=0.04u
M656 U268/net6 U268/net10 U268/net14 VDD pmos W=0.205u L=0.04u
M657 U268/net4 n250 VDD VDD pmos W=0.205u L=0.04u
M658 U268/net6 U268/net4 VDD VDD pmos W=0.205u L=0.04u
M659 N2756 U268/net14 VDD VDD pmos W=0.205u L=0.04u
M660 U268/net10 N10 VDD VDD pmos W=0.205u L=0.04u
M661 U269/net7 n231 U269/X_u4-net10 VSS nmos W=0.155u L=0.04u
M662 U269/X_u4-net10 n233 U269/X_u4-net13 VSS nmos W=0.155u L=0.04u
M663 U269/X_u4-net13 n285 VSS VSS nmos W=0.155u L=0.04u
M664 n250 U269/net7 VSS VSS nmos W=0.155u L=0.04u
M665 U269/net7 n285 VDD VDD pmos W=0.205u L=0.04u
M666 U269/net7 n231 VDD VDD pmos W=0.205u L=0.04u
M667 U269/net7 n233 VDD VDD pmos W=0.205u L=0.04u
M668 n250 U269/net7 VDD VDD pmos W=0.205u L=0.04u
M669 n231 n264 VSS VSS nmos W=0.155u L=0.04u
M670 n231 n275 VSS VSS nmos W=0.155u L=0.04u
M671 U270/XI1-net8 n275 VDD VDD pmos W=0.205u L=0.04u
M672 n231 n264 U270/XI1-net8 VDD pmos W=0.205u L=0.04u
M673 n264 n276 VSS VSS nmos W=0.135u L=0.04u
M674 n264 n276 VDD VDD pmos W=0.205u L=0.04u
M675 U272/net4 U272/net10 U272/net14 VSS nmos W=0.155u L=0.04u
M676 U272/net6 N7 U272/net14 VSS nmos W=0.155u L=0.04u
M677 U272/net4 n249 VSS VSS nmos W=0.155u L=0.04u
M678 U272/net6 U272/net4 VSS VSS nmos W=0.155u L=0.04u
M679 N2755 U272/net14 VSS VSS nmos W=0.155u L=0.04u
M680 U272/net10 N7 VSS VSS nmos W=0.155u L=0.04u
M681 U272/net4 N7 U272/net14 VDD pmos W=0.205u L=0.04u
M682 U272/net6 U272/net10 U272/net14 VDD pmos W=0.205u L=0.04u
M683 U272/net4 n249 VDD VDD pmos W=0.205u L=0.04u
M684 U272/net6 U272/net4 VDD VDD pmos W=0.205u L=0.04u
M685 N2755 U272/net14 VDD VDD pmos W=0.205u L=0.04u
M686 U272/net10 N7 VDD VDD pmos W=0.205u L=0.04u
M687 U273/net7 n285 U273/X_u4-net10 VSS nmos W=0.155u L=0.04u
M688 U273/X_u4-net10 n229 U273/X_u4-net13 VSS nmos W=0.155u L=0.04u
M689 U273/X_u4-net13 n235 VSS VSS nmos W=0.155u L=0.04u
M690 n249 U273/net7 VSS VSS nmos W=0.155u L=0.04u
M691 U273/net7 n235 VDD VDD pmos W=0.205u L=0.04u
M692 U273/net7 n285 VDD VDD pmos W=0.205u L=0.04u
M693 U273/net7 n229 VDD VDD pmos W=0.205u L=0.04u
M694 n249 U273/net7 VDD VDD pmos W=0.205u L=0.04u
M695 n229 n286 VSS VSS nmos W=0.155u L=0.04u
M696 n229 n282 VSS VSS nmos W=0.155u L=0.04u
M697 U274/XI1-net8 n282 VDD VDD pmos W=0.205u L=0.04u
M698 n229 n286 U274/XI1-net8 VDD pmos W=0.205u L=0.04u
M699 n286 n283 VSS VSS nmos W=0.135u L=0.04u
M700 n286 n283 VDD VDD pmos W=0.205u L=0.04u
M701 U276/net4 U276/net10 U276/net14 VSS nmos W=0.155u L=0.04u
M702 U276/net6 N4 U276/net14 VSS nmos W=0.155u L=0.04u
M703 U276/net4 n248 VSS VSS nmos W=0.155u L=0.04u
M704 U276/net6 U276/net4 VSS VSS nmos W=0.155u L=0.04u
M705 N2754 U276/net14 VSS VSS nmos W=0.155u L=0.04u
M706 U276/net10 N4 VSS VSS nmos W=0.155u L=0.04u
M707 U276/net4 N4 U276/net14 VDD pmos W=0.205u L=0.04u
M708 U276/net6 U276/net10 U276/net14 VDD pmos W=0.205u L=0.04u
M709 U276/net4 n248 VDD VDD pmos W=0.205u L=0.04u
M710 U276/net6 U276/net4 VDD VDD pmos W=0.205u L=0.04u
M711 N2754 U276/net14 VDD VDD pmos W=0.205u L=0.04u
M712 U276/net10 N4 VDD VDD pmos W=0.205u L=0.04u
M713 U277/net7 n285 U277/X_u4-net10 VSS nmos W=0.155u L=0.04u
M714 U277/X_u4-net10 n230 U277/X_u4-net13 VSS nmos W=0.155u L=0.04u
M715 U277/X_u4-net13 n235 VSS VSS nmos W=0.155u L=0.04u
M716 n248 U277/net7 VSS VSS nmos W=0.155u L=0.04u
M717 U277/net7 n235 VDD VDD pmos W=0.205u L=0.04u
M718 U277/net7 n285 VDD VDD pmos W=0.205u L=0.04u
M719 U277/net7 n230 VDD VDD pmos W=0.205u L=0.04u
M720 n248 U277/net7 VDD VDD pmos W=0.205u L=0.04u
M721 n235 n228 VSS VSS nmos W=0.135u L=0.04u
M722 n235 n228 VDD VDD pmos W=0.205u L=0.04u
M723 U279/XU1-net6 n275 VSS VSS nmos W=0.155u L=0.04u
M724 n228 n276 U279/XU1-net6 VSS nmos W=0.155u L=0.04u
M725 n228 n275 VDD VDD pmos W=0.155u L=0.04u
M726 n228 n276 VDD VDD pmos W=0.155u L=0.04u
M727 n230 n287 VSS VSS nmos W=0.155u L=0.04u
M728 n230 n283 VSS VSS nmos W=0.155u L=0.04u
M729 U280/XI1-net8 n283 VDD VDD pmos W=0.205u L=0.04u
M730 n230 n287 U280/XI1-net8 VDD pmos W=0.205u L=0.04u
M731 n287 n282 VSS VSS nmos W=0.135u L=0.04u
M732 n287 n282 VDD VDD pmos W=0.205u L=0.04u
M733 U282/net4 U282/net10 U282/net14 VSS nmos W=0.155u L=0.04u
M734 U282/net6 N1 U282/net14 VSS nmos W=0.155u L=0.04u
M735 U282/net4 n247 VSS VSS nmos W=0.155u L=0.04u
M736 U282/net6 U282/net4 VSS VSS nmos W=0.155u L=0.04u
M737 N2753 U282/net14 VSS VSS nmos W=0.155u L=0.04u
M738 U282/net10 N1 VSS VSS nmos W=0.155u L=0.04u
M739 U282/net4 N1 U282/net14 VDD pmos W=0.205u L=0.04u
M740 U282/net6 U282/net10 U282/net14 VDD pmos W=0.205u L=0.04u
M741 U282/net4 n247 VDD VDD pmos W=0.205u L=0.04u
M742 U282/net6 U282/net4 VDD VDD pmos W=0.205u L=0.04u
M743 N2753 U282/net14 VDD VDD pmos W=0.205u L=0.04u
M744 U282/net10 N1 VDD VDD pmos W=0.205u L=0.04u
M745 U283/net7 n233 U283/X_u4-net10 VSS nmos W=0.155u L=0.04u
M746 U283/X_u4-net10 n232 U283/X_u4-net13 VSS nmos W=0.155u L=0.04u
M747 U283/X_u4-net13 n285 VSS VSS nmos W=0.155u L=0.04u
M748 n247 U283/net7 VSS VSS nmos W=0.155u L=0.04u
M749 U283/net7 n285 VDD VDD pmos W=0.205u L=0.04u
M750 U283/net7 n233 VDD VDD pmos W=0.205u L=0.04u
M751 U283/net7 n232 VDD VDD pmos W=0.205u L=0.04u
M752 n247 U283/net7 VDD VDD pmos W=0.205u L=0.04u
M753 n285 n242 VSS VSS nmos W=0.155u L=0.04u
M754 n285 U284/net4 VSS VSS nmos W=0.155u L=0.04u
M755 U284/net4 n272 VSS VSS nmos W=0.155u L=0.04u
M756 U284/XU1-net8 U284/net4 VDD VDD pmos W=0.205u L=0.04u
M757 n285 n242 U284/XU1-net8 VDD pmos W=0.205u L=0.04u
M758 U284/net4 n272 VDD VDD pmos W=0.205u L=0.04u
M759 n242 n278 U285/net15 VSS nmos W=0.155u L=0.04u
M760 n242 n279 U285/net15 VSS nmos W=0.155u L=0.04u
M761 U285/net15 n241 VSS VSS nmos W=0.155u L=0.04u
M762 n242 n241 VDD VDD pmos W=0.205u L=0.04u
M763 n242 n278 U285/XI16-net11 VDD pmos W=0.205u L=0.04u
M764 U285/XI16-net11 n279 VDD VDD pmos W=0.205u L=0.04u
M765 U286/net4 U286/net10 U286/net14 VSS nmos W=0.155u L=0.04u
M766 U286/net6 n288 U286/net14 VSS nmos W=0.155u L=0.04u
M767 U286/net4 N76 VSS VSS nmos W=0.155u L=0.04u
M768 U286/net6 U286/net4 VSS VSS nmos W=0.155u L=0.04u
M769 n241 U286/net14 VSS VSS nmos W=0.155u L=0.04u
M770 U286/net10 n288 VSS VSS nmos W=0.155u L=0.04u
M771 U286/net4 n288 U286/net14 VDD pmos W=0.205u L=0.04u
M772 U286/net6 U286/net10 U286/net14 VDD pmos W=0.205u L=0.04u
M773 U286/net4 N76 VDD VDD pmos W=0.205u L=0.04u
M774 U286/net6 U286/net4 VDD VDD pmos W=0.205u L=0.04u
M775 n241 U286/net14 VDD VDD pmos W=0.205u L=0.04u
M776 U286/net10 n288 VDD VDD pmos W=0.205u L=0.04u
M777 n288 N94 VSS VSS nmos W=0.155u L=0.04u
M778 n288 U287/net4 VSS VSS nmos W=0.155u L=0.04u
M779 U287/net4 n211 VSS VSS nmos W=0.155u L=0.04u
M780 U287/XU1-net8 U287/net4 VDD VDD pmos W=0.205u L=0.04u
M781 n288 N94 U287/XU1-net8 VDD pmos W=0.205u L=0.04u
M782 U287/net4 n211 VDD VDD pmos W=0.205u L=0.04u
M783 U288/net11 n290 U288/net17 VSS nmos W=0.155u L=0.04u
M784 U288/net5 U288/net17 U288/net21 VSS nmos W=0.155u L=0.04u
M785 U288/net5 n191 VSS VSS nmos W=0.155u L=0.04u
M786 n211 U288/net21 VSS VSS nmos W=0.155u L=0.04u
M787 U288/net16 n290 VSS VSS nmos W=0.155u L=0.04u
M788 U288/net11 n289 VSS VSS nmos W=0.155u L=0.04u
M789 U288/net13 U288/net17 VSS VSS nmos W=0.155u L=0.04u
M790 U288/net17 U288/net16 U288/XI2-net16 VSS nmos W=0.155u L=0.04u
M791 U288/XI2-net16 U288/net11 VSS VSS nmos W=0.155u L=0.04u
M792 U288/net21 U288/net13 U288/XU21-net16 VSS nmos W=0.155u L=0.04u
M793 U288/XU21-net16 U288/net5 VSS VSS nmos W=0.155u L=0.04u
M794 U288/net11 U288/net16 U288/net17 VDD pmos W=0.205u L=0.04u
M795 U288/net5 U288/net13 U288/net21 VDD pmos W=0.205u L=0.04u
M796 U288/net5 n191 VDD VDD pmos W=0.205u L=0.04u
M797 n211 U288/net21 VDD VDD pmos W=0.205u L=0.04u
M798 U288/net16 n290 VDD VDD pmos W=0.205u L=0.04u
M799 U288/net11 n289 VDD VDD pmos W=0.205u L=0.04u
M800 U288/net13 U288/net17 VDD VDD pmos W=0.205u L=0.04u
M801 U288/net17 n290 U288/XI2-net6 VDD pmos W=0.205u L=0.04u
M802 U288/XI2-net6 U288/net11 VDD VDD pmos W=0.205u L=0.04u
M803 U288/net21 U288/net17 U288/XU21-net6 VDD pmos W=0.205u L=0.04u
M804 U288/XU21-net6 U288/net5 VDD VDD pmos W=0.205u L=0.04u
M805 U289/net29 U289/net21 U289/net041 VSS nmos W=0.155u L=0.04u
M806 U289/net035 U289/net19 VSS VSS nmos W=0.155u L=0.04u
M807 U289/net041 U289/net13 VSS VSS nmos W=0.155u L=0.04u
M808 U289/net25 N10 U289/net035 VSS nmos W=0.155u L=0.04u
M809 U289/net19 U289/net17 U289/net25 VSS nmos W=0.155u L=0.04u
M810 U289/net13 U289/net25 U289/net29 VSS nmos W=0.155u L=0.04u
M811 n290 U289/net29 VSS VSS nmos W=0.155u L=0.04u
M812 U289/net13 n291 VSS VSS nmos W=0.155u L=0.04u
M813 U289/net17 N10 VSS VSS nmos W=0.155u L=0.04u
M814 U289/net19 N40 VSS VSS nmos W=0.155u L=0.04u
M815 U289/net21 U289/net25 VSS VSS nmos W=0.155u L=0.04u
M816 U289/net028 U289/net19 VDD VDD pmos W=0.205u L=0.04u
M817 U289/net25 U289/net17 U289/net028 VDD pmos W=0.205u L=0.04u
M818 U289/net29 U289/net25 U289/net029 VDD pmos W=0.205u L=0.04u
M819 U289/net029 U289/net13 VDD VDD pmos W=0.205u L=0.04u
M820 U289/net19 N10 U289/net25 VDD pmos W=0.205u L=0.04u
M821 U289/net13 U289/net21 U289/net29 VDD pmos W=0.205u L=0.04u
M822 n290 U289/net29 VDD VDD pmos W=0.205u L=0.04u
M823 U289/net13 n291 VDD VDD pmos W=0.205u L=0.04u
M824 U289/net17 N10 VDD VDD pmos W=0.205u L=0.04u
M825 U289/net19 N40 VDD VDD pmos W=0.205u L=0.04u
M826 U289/net21 U289/net25 VDD VDD pmos W=0.205u L=0.04u
M827 n291 N104 VSS VSS nmos W=0.155u L=0.04u
M828 n291 n188 VSS VSS nmos W=0.155u L=0.04u
M829 U290/XI1-net8 n188 VDD VDD pmos W=0.205u L=0.04u
M830 n291 N104 U290/XI1-net8 VDD pmos W=0.205u L=0.04u
M831 n188 N66 VSS VSS nmos W=0.135u L=0.04u
M832 n188 N66 VDD VDD pmos W=0.205u L=0.04u
M833 n279 N60 VSS VSS nmos W=0.135u L=0.04u
M834 n279 N60 VDD VDD pmos W=0.205u L=0.04u
M835 n278 N94 VSS VSS nmos W=0.155u L=0.04u
M836 n278 n292 VSS VSS nmos W=0.155u L=0.04u
M837 U293/XI1-net8 n292 VDD VDD pmos W=0.205u L=0.04u
M838 n278 N94 U293/XI1-net8 VDD pmos W=0.205u L=0.04u
M839 n272 n240 VSS VSS nmos W=0.155u L=0.04u
M840 n272 U294/net4 VSS VSS nmos W=0.155u L=0.04u
M841 U294/net4 n293 VSS VSS nmos W=0.155u L=0.04u
M842 U294/XU1-net8 U294/net4 VDD VDD pmos W=0.205u L=0.04u
M843 n272 n240 U294/XU1-net8 VDD pmos W=0.205u L=0.04u
M844 U294/net4 n293 VDD VDD pmos W=0.205u L=0.04u
M845 n240 n267 U295/net15 VSS nmos W=0.155u L=0.04u
M846 n240 n268 U295/net15 VSS nmos W=0.155u L=0.04u
M847 U295/net15 n239 VSS VSS nmos W=0.155u L=0.04u
M848 n240 n239 VDD VDD pmos W=0.205u L=0.04u
M849 n240 n267 U295/XI16-net11 VDD pmos W=0.205u L=0.04u
M850 U295/XI16-net11 n268 VDD VDD pmos W=0.205u L=0.04u
M851 U296/net4 U296/net10 U296/net14 VSS nmos W=0.155u L=0.04u
M852 U296/net6 n294 U296/net14 VSS nmos W=0.155u L=0.04u
M853 U296/net4 n216 VSS VSS nmos W=0.155u L=0.04u
M854 U296/net6 U296/net4 VSS VSS nmos W=0.155u L=0.04u
M855 n239 U296/net14 VSS VSS nmos W=0.155u L=0.04u
M856 U296/net10 n294 VSS VSS nmos W=0.155u L=0.04u
M857 U296/net4 n294 U296/net14 VDD pmos W=0.205u L=0.04u
M858 U296/net6 U296/net10 U296/net14 VDD pmos W=0.205u L=0.04u
M859 U296/net4 n216 VDD VDD pmos W=0.205u L=0.04u
M860 U296/net6 U296/net4 VDD VDD pmos W=0.205u L=0.04u
M861 n239 U296/net14 VDD VDD pmos W=0.205u L=0.04u
M862 U296/net10 n294 VDD VDD pmos W=0.205u L=0.04u
M863 n216 n267 VSS VSS nmos W=0.155u L=0.04u
M864 n216 U297/net4 VSS VSS nmos W=0.155u L=0.04u
M865 U297/net4 N49 VSS VSS nmos W=0.155u L=0.04u
M866 U297/XU1-net8 U297/net4 VDD VDD pmos W=0.205u L=0.04u
M867 n216 n267 U297/XU1-net8 VDD pmos W=0.205u L=0.04u
M868 U297/net4 N49 VDD VDD pmos W=0.205u L=0.04u
M869 n294 N94 VSS VSS nmos W=0.155u L=0.04u
M870 n294 U298/net4 VSS VSS nmos W=0.155u L=0.04u
M871 U298/net4 n214 VSS VSS nmos W=0.155u L=0.04u
M872 U298/XU1-net8 U298/net4 VDD VDD pmos W=0.205u L=0.04u
M873 n294 N94 U298/XU1-net8 VDD pmos W=0.205u L=0.04u
M874 U298/net4 n214 VDD VDD pmos W=0.205u L=0.04u
M875 U299/net28 U299/net20 U299/net64 VSS nmos W=0.155u L=0.04u
M876 U299/net24 U299/net30 U299/net32 VSS nmos W=0.155u L=0.04u
M877 U299/net28 U299/net40 U299/net24 VSS nmos W=0.155u L=0.04u
M878 U299/net40 n199 U299/net108 VSS nmos W=0.155u L=0.04u
M879 U299/net40 U299/net106 U299/net104 VSS nmos W=0.155u L=0.04u
M880 U299/net24 N25 U299/net050 VSS nmos W=0.155u L=0.04u
M881 U299/net050 U299/net32 VSS VSS nmos W=0.155u L=0.04u
M882 U299/net20 U299/net40 VSS VSS nmos W=0.155u L=0.04u
M883 U299/net106 n199 VSS VSS nmos W=0.155u L=0.04u
M884 U299/net104 n296 VSS VSS nmos W=0.155u L=0.04u
M885 U299/net30 N25 VSS VSS nmos W=0.155u L=0.04u
M886 U299/net108 U299/net104 VSS VSS nmos W=0.155u L=0.04u
M887 n214 U299/net28 VSS VSS nmos W=0.155u L=0.04u
M888 U299/net32 n295 VSS VSS nmos W=0.155u L=0.04u
M889 U299/net64 U299/net24 VSS VSS nmos W=0.2u L=0.04u
M890 U299/net28 U299/net40 U299/net64 VDD pmos W=0.205u L=0.04u
M891 U299/net24 N25 U299/net32 VDD pmos W=0.205u L=0.04u
M892 U299/net28 U299/net20 U299/net24 VDD pmos W=0.205u L=0.04u
M893 U299/net40 U299/net106 U299/net108 VDD pmos W=0.205u L=0.04u
M894 U299/net40 n199 U299/net104 VDD pmos W=0.205u L=0.04u
M895 U299/net20 U299/net40 VDD VDD pmos W=0.205u L=0.04u
M896 U299/net106 n199 VDD VDD pmos W=0.205u L=0.04u
M897 U299/net104 n296 VDD VDD pmos W=0.205u L=0.04u
M898 U299/net30 N25 VDD VDD pmos W=0.205u L=0.04u
M899 U299/net108 U299/net104 VDD VDD pmos W=0.205u L=0.04u
M900 n214 U299/net28 VDD VDD pmos W=0.205u L=0.04u
M901 U299/net32 n295 VDD VDD pmos W=0.205u L=0.04u
M902 U299/net64 U299/net24 VDD VDD pmos W=0.28u L=0.04u
M903 U299/net24 U299/net30 U299/net045 VDD pmos W=0.205u L=0.04u
M904 U299/net045 U299/net32 VDD VDD pmos W=0.205u L=0.04u
M905 U300/net28 U300/net20 U300/net64 VSS nmos W=0.155u L=0.04u
M906 U300/net24 U300/net30 U300/net32 VSS nmos W=0.155u L=0.04u
M907 U300/net28 U300/net40 U300/net24 VSS nmos W=0.155u L=0.04u
M908 U300/net40 n298 U300/net108 VSS nmos W=0.155u L=0.04u
M909 U300/net40 U300/net106 U300/net104 VSS nmos W=0.155u L=0.04u
M910 U300/net24 N22 U300/net050 VSS nmos W=0.155u L=0.04u
M911 U300/net050 U300/net32 VSS VSS nmos W=0.155u L=0.04u
M912 U300/net20 U300/net40 VSS VSS nmos W=0.155u L=0.04u
M913 U300/net106 n298 VSS VSS nmos W=0.155u L=0.04u
M914 U300/net104 n289 VSS VSS nmos W=0.155u L=0.04u
M915 U300/net30 N22 VSS VSS nmos W=0.155u L=0.04u
M916 U300/net108 U300/net104 VSS VSS nmos W=0.155u L=0.04u
M917 n199 U300/net28 VSS VSS nmos W=0.155u L=0.04u
M918 U300/net32 n297 VSS VSS nmos W=0.155u L=0.04u
M919 U300/net64 U300/net24 VSS VSS nmos W=0.2u L=0.04u
M920 U300/net28 U300/net40 U300/net64 VDD pmos W=0.205u L=0.04u
M921 U300/net24 N22 U300/net32 VDD pmos W=0.205u L=0.04u
M922 U300/net28 U300/net20 U300/net24 VDD pmos W=0.205u L=0.04u
M923 U300/net40 U300/net106 U300/net108 VDD pmos W=0.205u L=0.04u
M924 U300/net40 n298 U300/net104 VDD pmos W=0.205u L=0.04u
M925 U300/net20 U300/net40 VDD VDD pmos W=0.205u L=0.04u
M926 U300/net106 n298 VDD VDD pmos W=0.205u L=0.04u
M927 U300/net104 n289 VDD VDD pmos W=0.205u L=0.04u
M928 U300/net30 N22 VDD VDD pmos W=0.205u L=0.04u
M929 U300/net108 U300/net104 VDD VDD pmos W=0.205u L=0.04u
M930 n199 U300/net28 VDD VDD pmos W=0.205u L=0.04u
M931 U300/net32 n297 VDD VDD pmos W=0.205u L=0.04u
M932 U300/net64 U300/net24 VDD VDD pmos W=0.28u L=0.04u
M933 U300/net24 U300/net30 U300/net045 VDD pmos W=0.205u L=0.04u
M934 U300/net045 U300/net32 VDD VDD pmos W=0.205u L=0.04u
M935 U301/net11 N4 U301/net17 VSS nmos W=0.155u L=0.04u
M936 U301/net5 U301/net17 U301/net21 VSS nmos W=0.155u L=0.04u
M937 U301/net5 N1 VSS VSS nmos W=0.155u L=0.04u
M938 n289 U301/net21 VSS VSS nmos W=0.155u L=0.04u
M939 U301/net16 N4 VSS VSS nmos W=0.155u L=0.04u
M940 U301/net11 N7 VSS VSS nmos W=0.155u L=0.04u
M941 U301/net13 U301/net17 VSS VSS nmos W=0.155u L=0.04u
M942 U301/net17 U301/net16 U301/XI2-net16 VSS nmos W=0.155u L=0.04u
M943 U301/XI2-net16 U301/net11 VSS VSS nmos W=0.155u L=0.04u
M944 U301/net21 U301/net13 U301/XU21-net16 VSS nmos W=0.155u L=0.04u
M945 U301/XU21-net16 U301/net5 VSS VSS nmos W=0.155u L=0.04u
M946 U301/net11 U301/net16 U301/net17 VDD pmos W=0.205u L=0.04u
M947 U301/net5 U301/net13 U301/net21 VDD pmos W=0.205u L=0.04u
M948 U301/net5 N1 VDD VDD pmos W=0.205u L=0.04u
M949 n289 U301/net21 VDD VDD pmos W=0.205u L=0.04u
M950 U301/net16 N4 VDD VDD pmos W=0.205u L=0.04u
M951 U301/net11 N7 VDD VDD pmos W=0.205u L=0.04u
M952 U301/net13 U301/net17 VDD VDD pmos W=0.205u L=0.04u
M953 U301/net17 N4 U301/XI2-net6 VDD pmos W=0.205u L=0.04u
M954 U301/XI2-net6 U301/net11 VDD VDD pmos W=0.205u L=0.04u
M955 U301/net21 U301/net17 U301/XU21-net6 VDD pmos W=0.205u L=0.04u
M956 U301/XU21-net6 U301/net5 VDD VDD pmos W=0.205u L=0.04u
M957 n297 N10 VSS VSS nmos W=0.135u L=0.04u
M958 n297 N10 VDD VDD pmos W=0.205u L=0.04u
M959 n295 N104 VSS VSS nmos W=0.155u L=0.04u
M960 n295 n197 VSS VSS nmos W=0.155u L=0.04u
M961 U303/XI1-net8 n197 VDD VDD pmos W=0.205u L=0.04u
M962 n295 N104 U303/XI1-net8 VDD pmos W=0.205u L=0.04u
M963 n197 N63 VSS VSS nmos W=0.135u L=0.04u
M964 n197 N63 VDD VDD pmos W=0.205u L=0.04u
M965 n268 N53 VSS VSS nmos W=0.135u L=0.04u
M966 n268 N53 VDD VDD pmos W=0.205u L=0.04u
M967 n267 N94 VSS VSS nmos W=0.155u L=0.04u
M968 n267 N72 VSS VSS nmos W=0.155u L=0.04u
M969 U306/XI1-net8 N72 VDD VDD pmos W=0.205u L=0.04u
M970 n267 N94 U306/XI1-net8 VDD pmos W=0.205u L=0.04u
M971 n293 N88 U307/net15 VSS nmos W=0.155u L=0.04u
M972 n293 n271 U307/net15 VSS nmos W=0.155u L=0.04u
M973 U307/net15 n221 VSS VSS nmos W=0.155u L=0.04u
M974 n293 n221 VDD VDD pmos W=0.205u L=0.04u
M975 n293 N88 U307/XI16-net11 VDD pmos W=0.205u L=0.04u
M976 U307/XI16-net11 n271 VDD VDD pmos W=0.205u L=0.04u
M977 U308/net36 n187 U308/net24 VSS nmos W=0.155u L=0.04u
M978 U308/net24 N99 VSS VSS nmos W=0.155u L=0.04u
M979 n221 n292 U308/net36 VSS nmos W=0.155u L=0.04u
M980 n221 n299 U308/net36 VSS nmos W=0.155u L=0.04u
M981 n221 n299 U308/net35 VDD pmos W=0.205u L=0.04u
M982 U308/net35 n292 VDD VDD pmos W=0.205u L=0.04u
M983 n221 N99 VDD VDD pmos W=0.205u L=0.04u
M984 n221 n187 VDD VDD pmos W=0.205u L=0.04u
M985 U309/net36 N104 U309/net24 VSS nmos W=0.155u L=0.04u
M986 U309/net24 N94 VSS VSS nmos W=0.155u L=0.04u
M987 n271 n292 U309/net36 VSS nmos W=0.155u L=0.04u
M988 n271 n299 U309/net36 VSS nmos W=0.155u L=0.04u
M989 n271 n299 U309/net35 VDD pmos W=0.205u L=0.04u
M990 U309/net35 n292 VDD VDD pmos W=0.205u L=0.04u
M991 n271 N94 VDD VDD pmos W=0.205u L=0.04u
M992 n271 N104 VDD VDD pmos W=0.205u L=0.04u
M993 n299 N72 VSS VSS nmos W=0.135u L=0.04u
M994 n299 N72 VDD VDD pmos W=0.205u L=0.04u
M995 n232 n265 VSS VSS nmos W=0.155u L=0.04u
M996 n232 n276 VSS VSS nmos W=0.155u L=0.04u
M997 U311/XI1-net8 n276 VDD VDD pmos W=0.205u L=0.04u
M998 n232 n265 U311/XI1-net8 VDD pmos W=0.205u L=0.04u
M999 U312/net4 n300 U312/net14 VSS nmos W=0.155u L=0.04u
M1000 U312/net6 U312/net10 U312/net14 VSS nmos W=0.17u L=0.04u
M1001 U312/net4 N79 VSS VSS nmos W=0.155u L=0.04u
M1002 U312/net6 U312/net4 VSS VSS nmos W=0.17u L=0.04u
M1003 n276 U312/net14 VSS VSS nmos W=0.155u L=0.04u
M1004 U312/net10 n300 VSS VSS nmos W=0.155u L=0.04u
M1005 U312/net4 U312/net10 U312/net14 VDD pmos W=0.255u L=0.04u
M1006 U312/net6 n300 U312/net14 VDD pmos W=0.28u L=0.04u
M1007 U312/net4 N79 VDD VDD pmos W=0.205u L=0.04u
M1008 U312/net6 U312/net4 VDD VDD pmos W=0.24u L=0.04u
M1009 n276 U312/net14 VDD VDD pmos W=0.205u L=0.04u
M1010 U312/net10 n300 VDD VDD pmos W=0.205u L=0.04u
M1011 n300 N94 VSS VSS nmos W=0.155u L=0.04u
M1012 n300 n301 VSS VSS nmos W=0.155u L=0.04u
M1013 U313/XI1-net8 n301 VDD VDD pmos W=0.205u L=0.04u
M1014 n300 N94 U313/XI1-net8 VDD pmos W=0.205u L=0.04u
M1015 U314/net4 n179 U314/net14 VSS nmos W=0.155u L=0.04u
M1016 U314/net6 U314/net10 U314/net14 VSS nmos W=0.17u L=0.04u
M1017 U314/net4 n180 VSS VSS nmos W=0.155u L=0.04u
M1018 U314/net6 U314/net4 VSS VSS nmos W=0.17u L=0.04u
M1019 n301 U314/net14 VSS VSS nmos W=0.155u L=0.04u
M1020 U314/net10 n179 VSS VSS nmos W=0.155u L=0.04u
M1021 U314/net4 U314/net10 U314/net14 VDD pmos W=0.255u L=0.04u
M1022 U314/net6 n179 U314/net14 VDD pmos W=0.28u L=0.04u
M1023 U314/net4 n180 VDD VDD pmos W=0.205u L=0.04u
M1024 U314/net6 U314/net4 VDD VDD pmos W=0.24u L=0.04u
M1025 n301 U314/net14 VDD VDD pmos W=0.205u L=0.04u
M1026 U314/net10 n179 VDD VDD pmos W=0.205u L=0.04u
M1027 U315/net4 N1 U315/net14 VSS nmos W=0.155u L=0.04u
M1028 U315/net6 U315/net10 U315/net14 VSS nmos W=0.17u L=0.04u
M1029 U315/net4 n302 VSS VSS nmos W=0.155u L=0.04u
M1030 U315/net6 U315/net4 VSS VSS nmos W=0.17u L=0.04u
M1031 n180 U315/net14 VSS VSS nmos W=0.155u L=0.04u
M1032 U315/net10 N1 VSS VSS nmos W=0.155u L=0.04u
M1033 U315/net4 U315/net10 U315/net14 VDD pmos W=0.255u L=0.04u
M1034 U315/net6 N1 U315/net14 VDD pmos W=0.28u L=0.04u
M1035 U315/net4 n302 VDD VDD pmos W=0.205u L=0.04u
M1036 U315/net6 U315/net4 VDD VDD pmos W=0.24u L=0.04u
M1037 n180 U315/net14 VDD VDD pmos W=0.205u L=0.04u
M1038 U315/net10 N1 VDD VDD pmos W=0.205u L=0.04u
M1039 U316/XU1-net6 n303 VSS VSS nmos W=0.155u L=0.04u
M1040 n302 N49 U316/XU1-net6 VSS nmos W=0.155u L=0.04u
M1041 n302 n303 VDD VDD pmos W=0.155u L=0.04u
M1042 n302 N49 VDD VDD pmos W=0.155u L=0.04u
M1043 U317/net4 U317/net10 U317/net14 VSS nmos W=0.155u L=0.04u
M1044 U317/net6 n191 U317/net14 VSS nmos W=0.155u L=0.04u
M1045 U317/net4 n298 VSS VSS nmos W=0.155u L=0.04u
M1046 U317/net6 U317/net4 VSS VSS nmos W=0.155u L=0.04u
M1047 n179 U317/net14 VSS VSS nmos W=0.155u L=0.04u
M1048 U317/net10 n191 VSS VSS nmos W=0.155u L=0.04u
M1049 U317/net4 n191 U317/net14 VDD pmos W=0.205u L=0.04u
M1050 U317/net6 U317/net10 U317/net14 VDD pmos W=0.205u L=0.04u
M1051 U317/net4 n298 VDD VDD pmos W=0.205u L=0.04u
M1052 U317/net6 U317/net4 VDD VDD pmos W=0.205u L=0.04u
M1053 n179 U317/net14 VDD VDD pmos W=0.205u L=0.04u
M1054 U317/net10 n191 VDD VDD pmos W=0.205u L=0.04u
M1055 U318/net29 U318/net21 U318/net041 VSS nmos W=0.155u L=0.04u
M1056 U318/net035 U318/net19 VSS VSS nmos W=0.155u L=0.04u
M1057 U318/net041 U318/net13 VSS VSS nmos W=0.155u L=0.04u
M1058 U318/net25 N16 U318/net035 VSS nmos W=0.155u L=0.04u
M1059 U318/net19 U318/net17 U318/net25 VSS nmos W=0.155u L=0.04u
M1060 U318/net13 U318/net25 U318/net29 VSS nmos W=0.155u L=0.04u
M1061 n298 U318/net29 VSS VSS nmos W=0.155u L=0.04u
M1062 U318/net13 N13 VSS VSS nmos W=0.155u L=0.04u
M1063 U318/net17 N16 VSS VSS nmos W=0.155u L=0.04u
M1064 U318/net19 N19 VSS VSS nmos W=0.155u L=0.04u
M1065 U318/net21 U318/net25 VSS VSS nmos W=0.155u L=0.04u
M1066 U318/net028 U318/net19 VDD VDD pmos W=0.205u L=0.04u
M1067 U318/net25 U318/net17 U318/net028 VDD pmos W=0.205u L=0.04u
M1068 U318/net29 U318/net25 U318/net029 VDD pmos W=0.205u L=0.04u
M1069 U318/net029 U318/net13 VDD VDD pmos W=0.205u L=0.04u
M1070 U318/net19 N16 U318/net25 VDD pmos W=0.205u L=0.04u
M1071 U318/net13 U318/net21 U318/net29 VDD pmos W=0.205u L=0.04u
M1072 n298 U318/net29 VDD VDD pmos W=0.205u L=0.04u
M1073 U318/net13 N13 VDD VDD pmos W=0.205u L=0.04u
M1074 U318/net17 N16 VDD VDD pmos W=0.205u L=0.04u
M1075 U318/net19 N19 VDD VDD pmos W=0.205u L=0.04u
M1076 U318/net21 U318/net25 VDD VDD pmos W=0.205u L=0.04u
M1077 U319/net28 U319/net20 U319/net64 VSS nmos W=0.155u L=0.04u
M1078 U319/net24 U319/net30 U319/net32 VSS nmos W=0.155u L=0.04u
M1079 U319/net28 U319/net40 U319/net24 VSS nmos W=0.155u L=0.04u
M1080 U319/net40 n296 U319/net108 VSS nmos W=0.155u L=0.04u
M1081 U319/net40 U319/net106 U319/net104 VSS nmos W=0.155u L=0.04u
M1082 U319/net24 N37 U319/net050 VSS nmos W=0.155u L=0.04u
M1083 U319/net050 U319/net32 VSS VSS nmos W=0.155u L=0.04u
M1084 U319/net20 U319/net40 VSS VSS nmos W=0.155u L=0.04u
M1085 U319/net106 n296 VSS VSS nmos W=0.155u L=0.04u
M1086 U319/net104 N31 VSS VSS nmos W=0.155u L=0.04u
M1087 U319/net30 N37 VSS VSS nmos W=0.155u L=0.04u
M1088 U319/net108 U319/net104 VSS VSS nmos W=0.155u L=0.04u
M1089 n191 U319/net28 VSS VSS nmos W=0.155u L=0.04u
M1090 U319/net32 N34 VSS VSS nmos W=0.155u L=0.04u
M1091 U319/net64 U319/net24 VSS VSS nmos W=0.2u L=0.04u
M1092 U319/net28 U319/net40 U319/net64 VDD pmos W=0.205u L=0.04u
M1093 U319/net24 N37 U319/net32 VDD pmos W=0.205u L=0.04u
M1094 U319/net28 U319/net20 U319/net24 VDD pmos W=0.205u L=0.04u
M1095 U319/net40 U319/net106 U319/net108 VDD pmos W=0.205u L=0.04u
M1096 U319/net40 n296 U319/net104 VDD pmos W=0.205u L=0.04u
M1097 U319/net20 U319/net40 VDD VDD pmos W=0.205u L=0.04u
M1098 U319/net106 n296 VDD VDD pmos W=0.205u L=0.04u
M1099 U319/net104 N31 VDD VDD pmos W=0.205u L=0.04u
M1100 U319/net30 N37 VDD VDD pmos W=0.205u L=0.04u
M1101 U319/net108 U319/net104 VDD VDD pmos W=0.205u L=0.04u
M1102 n191 U319/net28 VDD VDD pmos W=0.205u L=0.04u
M1103 U319/net32 N34 VDD VDD pmos W=0.205u L=0.04u
M1104 U319/net64 U319/net24 VDD VDD pmos W=0.28u L=0.04u
M1105 U319/net24 U319/net30 U319/net045 VDD pmos W=0.205u L=0.04u
M1106 U319/net045 U319/net32 VDD VDD pmos W=0.205u L=0.04u
M1107 U320/net29 U320/net21 U320/net041 VSS nmos W=0.155u L=0.04u
M1108 U320/net035 U320/net19 VSS VSS nmos W=0.155u L=0.04u
M1109 U320/net041 U320/net13 VSS VSS nmos W=0.155u L=0.04u
M1110 U320/net25 N43 U320/net035 VSS nmos W=0.155u L=0.04u
M1111 U320/net19 U320/net17 U320/net25 VSS nmos W=0.155u L=0.04u
M1112 U320/net13 U320/net25 U320/net29 VSS nmos W=0.155u L=0.04u
M1113 n296 U320/net29 VSS VSS nmos W=0.155u L=0.04u
M1114 U320/net13 N28 VSS VSS nmos W=0.155u L=0.04u
M1115 U320/net17 N43 VSS VSS nmos W=0.155u L=0.04u
M1116 U320/net19 N46 VSS VSS nmos W=0.155u L=0.04u
M1117 U320/net21 U320/net25 VSS VSS nmos W=0.155u L=0.04u
M1118 U320/net028 U320/net19 VDD VDD pmos W=0.205u L=0.04u
M1119 U320/net25 U320/net17 U320/net028 VDD pmos W=0.205u L=0.04u
M1120 U320/net29 U320/net25 U320/net029 VDD pmos W=0.205u L=0.04u
M1121 U320/net029 U320/net13 VDD VDD pmos W=0.205u L=0.04u
M1122 U320/net19 N43 U320/net25 VDD pmos W=0.205u L=0.04u
M1123 U320/net13 U320/net21 U320/net29 VDD pmos W=0.205u L=0.04u
M1124 n296 U320/net29 VDD VDD pmos W=0.205u L=0.04u
M1125 U320/net13 N28 VDD VDD pmos W=0.205u L=0.04u
M1126 U320/net17 N43 VDD VDD pmos W=0.205u L=0.04u
M1127 U320/net19 N46 VDD VDD pmos W=0.205u L=0.04u
M1128 U320/net21 U320/net25 VDD VDD pmos W=0.205u L=0.04u
M1129 n265 n275 VSS VSS nmos W=0.135u L=0.04u
M1130 n265 n275 VDD VDD pmos W=0.205u L=0.04u
M1131 U322/net4 n304 U322/net14 VSS nmos W=0.155u L=0.04u
M1132 U322/net6 U322/net10 U322/net14 VSS nmos W=0.17u L=0.04u
M1133 U322/net4 n203 VSS VSS nmos W=0.155u L=0.04u
M1134 U322/net6 U322/net4 VSS VSS nmos W=0.17u L=0.04u
M1135 n275 U322/net14 VSS VSS nmos W=0.155u L=0.04u
M1136 U322/net10 n304 VSS VSS nmos W=0.155u L=0.04u
M1137 U322/net4 U322/net10 U322/net14 VDD pmos W=0.255u L=0.04u
M1138 U322/net6 n304 U322/net14 VDD pmos W=0.28u L=0.04u
M1139 U322/net4 n203 VDD VDD pmos W=0.205u L=0.04u
M1140 U322/net6 U322/net4 VDD VDD pmos W=0.24u L=0.04u
M1141 n275 U322/net14 VDD VDD pmos W=0.205u L=0.04u
M1142 U322/net10 n304 VDD VDD pmos W=0.205u L=0.04u
M1143 n203 n217 U323/net27 VSS nmos W=0.155u L=0.04u
M1144 U323/net27 N69 VSS VSS nmos W=0.155u L=0.04u
M1145 n203 n305 VSS VSS nmos W=0.155u L=0.04u
M1146 n203 N69 U323/net13 VDD pmos W=0.205u L=0.04u
M1147 U323/net13 n305 VDD VDD pmos W=0.205u L=0.04u
M1148 n203 n217 U323/net13 VDD pmos W=0.205u L=0.04u
M1149 n217 N94 VSS VSS nmos W=0.135u L=0.04u
M1150 n217 N94 VDD VDD pmos W=0.205u L=0.04u
M1151 n304 N94 VSS VSS nmos W=0.155u L=0.04u
M1152 n304 U325/net4 VSS VSS nmos W=0.155u L=0.04u
M1153 U325/net4 n201 VSS VSS nmos W=0.155u L=0.04u
M1154 U325/XU1-net8 U325/net4 VDD VDD pmos W=0.205u L=0.04u
M1155 n304 N94 U325/XU1-net8 VDD pmos W=0.205u L=0.04u
M1156 U325/net4 n201 VDD VDD pmos W=0.205u L=0.04u
M1157 U326/net28 U326/net20 U326/net64 VSS nmos W=0.155u L=0.04u
M1158 U326/net24 U326/net30 U326/net32 VSS nmos W=0.155u L=0.04u
M1159 U326/net28 U326/net40 U326/net24 VSS nmos W=0.155u L=0.04u
M1160 U326/net40 n308 U326/net108 VSS nmos W=0.155u L=0.04u
M1161 U326/net40 U326/net106 U326/net104 VSS nmos W=0.155u L=0.04u
M1162 U326/net24 n306 U326/net050 VSS nmos W=0.155u L=0.04u
M1163 U326/net050 U326/net32 VSS VSS nmos W=0.155u L=0.04u
M1164 U326/net20 U326/net40 VSS VSS nmos W=0.155u L=0.04u
M1165 U326/net106 n308 VSS VSS nmos W=0.155u L=0.04u
M1166 U326/net104 n307 VSS VSS nmos W=0.155u L=0.04u
M1167 U326/net30 n306 VSS VSS nmos W=0.155u L=0.04u
M1168 U326/net108 U326/net104 VSS VSS nmos W=0.155u L=0.04u
M1169 n201 U326/net28 VSS VSS nmos W=0.155u L=0.04u
M1170 U326/net32 N10 VSS VSS nmos W=0.155u L=0.04u
M1171 U326/net64 U326/net24 VSS VSS nmos W=0.2u L=0.04u
M1172 U326/net28 U326/net40 U326/net64 VDD pmos W=0.205u L=0.04u
M1173 U326/net24 n306 U326/net32 VDD pmos W=0.205u L=0.04u
M1174 U326/net28 U326/net20 U326/net24 VDD pmos W=0.205u L=0.04u
M1175 U326/net40 U326/net106 U326/net108 VDD pmos W=0.205u L=0.04u
M1176 U326/net40 n308 U326/net104 VDD pmos W=0.205u L=0.04u
M1177 U326/net20 U326/net40 VDD VDD pmos W=0.205u L=0.04u
M1178 U326/net106 n308 VDD VDD pmos W=0.205u L=0.04u
M1179 U326/net104 n307 VDD VDD pmos W=0.205u L=0.04u
M1180 U326/net30 n306 VDD VDD pmos W=0.205u L=0.04u
M1181 U326/net108 U326/net104 VDD VDD pmos W=0.205u L=0.04u
M1182 n201 U326/net28 VDD VDD pmos W=0.205u L=0.04u
M1183 U326/net32 N10 VDD VDD pmos W=0.205u L=0.04u
M1184 U326/net64 U326/net24 VDD VDD pmos W=0.28u L=0.04u
M1185 U326/net24 U326/net30 U326/net045 VDD pmos W=0.205u L=0.04u
M1186 U326/net045 U326/net32 VDD VDD pmos W=0.205u L=0.04u
M1187 n307 N69 U327/XI0-net10 VSS nmos W=0.155u L=0.04u
M1188 U327/XI0-net10 n187 U327/XI0-net13 VSS nmos W=0.155u L=0.04u
M1189 U327/XI0-net13 N60 VSS VSS nmos W=0.155u L=0.04u
M1190 n307 N60 VDD VDD pmos W=0.205u L=0.04u
M1191 n307 N69 VDD VDD pmos W=0.205u L=0.04u
M1192 n307 n187 VDD VDD pmos W=0.205u L=0.04u
M1193 n187 N104 VSS VSS nmos W=0.135u L=0.04u
M1194 n187 N104 VDD VDD pmos W=0.205u L=0.04u
M1195 U329/net29 U329/net21 U329/net041 VSS nmos W=0.155u L=0.04u
M1196 U329/net035 U329/net19 VSS VSS nmos W=0.155u L=0.04u
M1197 U329/net041 U329/net13 VSS VSS nmos W=0.155u L=0.04u
M1198 U329/net25 N28 U329/net035 VSS nmos W=0.155u L=0.04u
M1199 U329/net19 U329/net17 U329/net25 VSS nmos W=0.155u L=0.04u
M1200 U329/net13 U329/net25 U329/net29 VSS nmos W=0.155u L=0.04u
M1201 n306 U329/net29 VSS VSS nmos W=0.155u L=0.04u
M1202 U329/net13 N19 VSS VSS nmos W=0.155u L=0.04u
M1203 U329/net17 N28 VSS VSS nmos W=0.155u L=0.04u
M1204 U329/net19 N37 VSS VSS nmos W=0.155u L=0.04u
M1205 U329/net21 U329/net25 VSS VSS nmos W=0.155u L=0.04u
M1206 U329/net028 U329/net19 VDD VDD pmos W=0.205u L=0.04u
M1207 U329/net25 U329/net17 U329/net028 VDD pmos W=0.205u L=0.04u
M1208 U329/net29 U329/net25 U329/net029 VDD pmos W=0.205u L=0.04u
M1209 U329/net029 U329/net13 VDD VDD pmos W=0.205u L=0.04u
M1210 U329/net19 N28 U329/net25 VDD pmos W=0.205u L=0.04u
M1211 U329/net13 U329/net21 U329/net29 VDD pmos W=0.205u L=0.04u
M1212 n306 U329/net29 VDD VDD pmos W=0.205u L=0.04u
M1213 U329/net13 N19 VDD VDD pmos W=0.205u L=0.04u
M1214 U329/net17 N28 VDD VDD pmos W=0.205u L=0.04u
M1215 U329/net19 N37 VDD VDD pmos W=0.205u L=0.04u
M1216 U329/net21 U329/net25 VDD VDD pmos W=0.205u L=0.04u
M1217 n233 n226 VSS VSS nmos W=0.135u L=0.04u
M1218 n233 n226 VDD VDD pmos W=0.205u L=0.04u
M1219 U331/XU1-net6 n282 VSS VSS nmos W=0.155u L=0.04u
M1220 n226 n283 U331/XU1-net6 VSS nmos W=0.155u L=0.04u
M1221 n226 n282 VDD VDD pmos W=0.155u L=0.04u
M1222 n226 n283 VDD VDD pmos W=0.155u L=0.04u
M1223 U332/net4 n309 U332/net14 VSS nmos W=0.155u L=0.04u
M1224 U332/net6 U332/net10 U332/net14 VSS nmos W=0.17u L=0.04u
M1225 U332/net4 N85 VSS VSS nmos W=0.155u L=0.04u
M1226 U332/net6 U332/net4 VSS VSS nmos W=0.17u L=0.04u
M1227 n282 U332/net14 VSS VSS nmos W=0.155u L=0.04u
M1228 U332/net10 n309 VSS VSS nmos W=0.155u L=0.04u
M1229 U332/net4 U332/net10 U332/net14 VDD pmos W=0.255u L=0.04u
M1230 U332/net6 n309 U332/net14 VDD pmos W=0.28u L=0.04u
M1231 U332/net4 N85 VDD VDD pmos W=0.205u L=0.04u
M1232 U332/net6 U332/net4 VDD VDD pmos W=0.24u L=0.04u
M1233 n282 U332/net14 VDD VDD pmos W=0.205u L=0.04u
M1234 U332/net10 n309 VDD VDD pmos W=0.205u L=0.04u
M1235 n309 N94 VSS VSS nmos W=0.155u L=0.04u
M1236 n309 U333/net4 VSS VSS nmos W=0.155u L=0.04u
M1237 U333/net4 n205 VSS VSS nmos W=0.155u L=0.04u
M1238 U333/XU1-net8 U333/net4 VDD VDD pmos W=0.205u L=0.04u
M1239 n309 N94 U333/XU1-net8 VDD pmos W=0.205u L=0.04u
M1240 U333/net4 n205 VDD VDD pmos W=0.205u L=0.04u
M1241 U334/net28 U334/net20 U334/net64 VSS nmos W=0.155u L=0.04u
M1242 U334/net24 U334/net30 U334/net32 VSS nmos W=0.155u L=0.04u
M1243 U334/net28 U334/net40 U334/net24 VSS nmos W=0.155u L=0.04u
M1244 U334/net40 n311 U334/net108 VSS nmos W=0.155u L=0.04u
M1245 U334/net40 U334/net106 U334/net104 VSS nmos W=0.155u L=0.04u
M1246 U334/net24 N22 U334/net050 VSS nmos W=0.155u L=0.04u
M1247 U334/net050 U334/net32 VSS VSS nmos W=0.155u L=0.04u
M1248 U334/net20 U334/net40 VSS VSS nmos W=0.155u L=0.04u
M1249 U334/net106 n311 VSS VSS nmos W=0.155u L=0.04u
M1250 U334/net104 N16 VSS VSS nmos W=0.155u L=0.04u
M1251 U334/net30 N22 VSS VSS nmos W=0.155u L=0.04u
M1252 U334/net108 U334/net104 VSS VSS nmos W=0.155u L=0.04u
M1253 n205 U334/net28 VSS VSS nmos W=0.155u L=0.04u
M1254 U334/net32 n310 VSS VSS nmos W=0.155u L=0.04u
M1255 U334/net64 U334/net24 VSS VSS nmos W=0.2u L=0.04u
M1256 U334/net28 U334/net40 U334/net64 VDD pmos W=0.205u L=0.04u
M1257 U334/net24 N22 U334/net32 VDD pmos W=0.205u L=0.04u
M1258 U334/net28 U334/net20 U334/net24 VDD pmos W=0.205u L=0.04u
M1259 U334/net40 U334/net106 U334/net108 VDD pmos W=0.205u L=0.04u
M1260 U334/net40 n311 U334/net104 VDD pmos W=0.205u L=0.04u
M1261 U334/net20 U334/net40 VDD VDD pmos W=0.205u L=0.04u
M1262 U334/net106 n311 VDD VDD pmos W=0.205u L=0.04u
M1263 U334/net104 N16 VDD VDD pmos W=0.205u L=0.04u
M1264 U334/net30 N22 VDD VDD pmos W=0.205u L=0.04u
M1265 U334/net108 U334/net104 VDD VDD pmos W=0.205u L=0.04u
M1266 n205 U334/net28 VDD VDD pmos W=0.205u L=0.04u
M1267 U334/net32 n310 VDD VDD pmos W=0.205u L=0.04u
M1268 U334/net64 U334/net24 VDD VDD pmos W=0.28u L=0.04u
M1269 U334/net24 U334/net30 U334/net045 VDD pmos W=0.205u L=0.04u
M1270 U334/net045 U334/net32 VDD VDD pmos W=0.205u L=0.04u
M1271 U335/net28 U335/net20 U335/net64 VSS nmos W=0.155u L=0.04u
M1272 U335/net24 U335/net30 U335/net32 VSS nmos W=0.155u L=0.04u
M1273 U335/net28 U335/net40 U335/net24 VSS nmos W=0.155u L=0.04u
M1274 U335/net40 N43 U335/net108 VSS nmos W=0.155u L=0.04u
M1275 U335/net40 U335/net106 U335/net104 VSS nmos W=0.155u L=0.04u
M1276 U335/net24 N34 U335/net050 VSS nmos W=0.155u L=0.04u
M1277 U335/net050 U335/net32 VSS VSS nmos W=0.155u L=0.04u
M1278 U335/net20 U335/net40 VSS VSS nmos W=0.155u L=0.04u
M1279 U335/net106 N43 VSS VSS nmos W=0.155u L=0.04u
M1280 U335/net104 N7 VSS VSS nmos W=0.155u L=0.04u
M1281 U335/net30 N34 VSS VSS nmos W=0.155u L=0.04u
M1282 U335/net108 U335/net104 VSS VSS nmos W=0.155u L=0.04u
M1283 n311 U335/net28 VSS VSS nmos W=0.155u L=0.04u
M1284 U335/net32 N28 VSS VSS nmos W=0.155u L=0.04u
M1285 U335/net64 U335/net24 VSS VSS nmos W=0.2u L=0.04u
M1286 U335/net28 U335/net40 U335/net64 VDD pmos W=0.205u L=0.04u
M1287 U335/net24 N34 U335/net32 VDD pmos W=0.205u L=0.04u
M1288 U335/net28 U335/net20 U335/net24 VDD pmos W=0.205u L=0.04u
M1289 U335/net40 U335/net106 U335/net108 VDD pmos W=0.205u L=0.04u
M1290 U335/net40 N43 U335/net104 VDD pmos W=0.205u L=0.04u
M1291 U335/net20 U335/net40 VDD VDD pmos W=0.205u L=0.04u
M1292 U335/net106 N43 VDD VDD pmos W=0.205u L=0.04u
M1293 U335/net104 N7 VDD VDD pmos W=0.205u L=0.04u
M1294 U335/net30 N34 VDD VDD pmos W=0.205u L=0.04u
M1295 U335/net108 U335/net104 VDD VDD pmos W=0.205u L=0.04u
M1296 n311 U335/net28 VDD VDD pmos W=0.205u L=0.04u
M1297 U335/net32 N28 VDD VDD pmos W=0.205u L=0.04u
M1298 U335/net64 U335/net24 VDD VDD pmos W=0.28u L=0.04u
M1299 U335/net24 U335/net30 U335/net045 VDD pmos W=0.205u L=0.04u
M1300 U335/net045 U335/net32 VDD VDD pmos W=0.205u L=0.04u
M1301 n310 n292 VSS VSS nmos W=0.155u L=0.04u
M1302 n310 N104 VSS VSS nmos W=0.155u L=0.04u
M1303 n310 n305 VSS VSS nmos W=0.155u L=0.04u
M1304 U336/net25 n292 VDD VDD pmos W=0.41u L=0.04u
M1305 U336/net28 N104 U336/net25 VDD pmos W=0.41u L=0.04u
M1306 n310 n305 U336/net28 VDD pmos W=0.41u L=0.04u
M1307 n292 N69 VSS VSS nmos W=0.135u L=0.04u
M1308 n292 N69 VDD VDD pmos W=0.205u L=0.04u
M1309 n305 N56 VSS VSS nmos W=0.135u L=0.04u
M1310 n305 N56 VDD VDD pmos W=0.205u L=0.04u
M1311 U339/net4 n312 U339/net14 VSS nmos W=0.155u L=0.04u
M1312 U339/net6 U339/net10 U339/net14 VSS nmos W=0.17u L=0.04u
M1313 U339/net4 N82 VSS VSS nmos W=0.155u L=0.04u
M1314 U339/net6 U339/net4 VSS VSS nmos W=0.17u L=0.04u
M1315 n283 U339/net14 VSS VSS nmos W=0.155u L=0.04u
M1316 U339/net10 n312 VSS VSS nmos W=0.155u L=0.04u
M1317 U339/net4 U339/net10 U339/net14 VDD pmos W=0.255u L=0.04u
M1318 U339/net6 n312 U339/net14 VDD pmos W=0.28u L=0.04u
M1319 U339/net4 N82 VDD VDD pmos W=0.205u L=0.04u
M1320 U339/net6 U339/net4 VDD VDD pmos W=0.24u L=0.04u
M1321 n283 U339/net14 VDD VDD pmos W=0.205u L=0.04u
M1322 U339/net10 n312 VDD VDD pmos W=0.205u L=0.04u
M1323 n312 N94 VSS VSS nmos W=0.155u L=0.04u
M1324 n312 U340/net4 VSS VSS nmos W=0.155u L=0.04u
M1325 U340/net4 n208 VSS VSS nmos W=0.155u L=0.04u
M1326 U340/XU1-net8 U340/net4 VDD VDD pmos W=0.205u L=0.04u
M1327 n312 N94 U340/XU1-net8 VDD pmos W=0.205u L=0.04u
M1328 U340/net4 n208 VDD VDD pmos W=0.205u L=0.04u
M1329 U341/net28 U341/net20 U341/net64 VSS nmos W=0.155u L=0.04u
M1330 U341/net24 U341/net30 U341/net32 VSS nmos W=0.155u L=0.04u
M1331 U341/net28 U341/net40 U341/net24 VSS nmos W=0.155u L=0.04u
M1332 U341/net40 n308 U341/net108 VSS nmos W=0.155u L=0.04u
M1333 U341/net40 U341/net106 U341/net104 VSS nmos W=0.155u L=0.04u
M1334 U341/net24 n313 U341/net050 VSS nmos W=0.155u L=0.04u
M1335 U341/net050 U341/net32 VSS VSS nmos W=0.155u L=0.04u
M1336 U341/net20 U341/net40 VSS VSS nmos W=0.155u L=0.04u
M1337 U341/net106 n308 VSS VSS nmos W=0.155u L=0.04u
M1338 U341/net104 n314 VSS VSS nmos W=0.155u L=0.04u
M1339 U341/net30 n313 VSS VSS nmos W=0.155u L=0.04u
M1340 U341/net108 U341/net104 VSS VSS nmos W=0.155u L=0.04u
M1341 n208 U341/net28 VSS VSS nmos W=0.155u L=0.04u
M1342 U341/net32 N13 VSS VSS nmos W=0.155u L=0.04u
M1343 U341/net64 U341/net24 VSS VSS nmos W=0.2u L=0.04u
M1344 U341/net28 U341/net40 U341/net64 VDD pmos W=0.205u L=0.04u
M1345 U341/net24 n313 U341/net32 VDD pmos W=0.205u L=0.04u
M1346 U341/net28 U341/net20 U341/net24 VDD pmos W=0.205u L=0.04u
M1347 U341/net40 U341/net106 U341/net108 VDD pmos W=0.205u L=0.04u
M1348 U341/net40 n308 U341/net104 VDD pmos W=0.205u L=0.04u
M1349 U341/net20 U341/net40 VDD VDD pmos W=0.205u L=0.04u
M1350 U341/net106 n308 VDD VDD pmos W=0.205u L=0.04u
M1351 U341/net104 n314 VDD VDD pmos W=0.205u L=0.04u
M1352 U341/net30 n313 VDD VDD pmos W=0.205u L=0.04u
M1353 U341/net108 U341/net104 VDD VDD pmos W=0.205u L=0.04u
M1354 n208 U341/net28 VDD VDD pmos W=0.205u L=0.04u
M1355 U341/net32 N13 VDD VDD pmos W=0.205u L=0.04u
M1356 U341/net64 U341/net24 VDD VDD pmos W=0.28u L=0.04u
M1357 U341/net24 U341/net30 U341/net045 VDD pmos W=0.205u L=0.04u
M1358 U341/net045 U341/net32 VDD VDD pmos W=0.205u L=0.04u
M1359 U342/net4 n192 U342/net14 VSS nmos W=0.155u L=0.04u
M1360 U342/net6 U342/net10 U342/net14 VSS nmos W=0.17u L=0.04u
M1361 U342/net4 N46 VSS VSS nmos W=0.155u L=0.04u
M1362 U342/net6 U342/net4 VSS VSS nmos W=0.17u L=0.04u
M1363 n308 U342/net14 VSS VSS nmos W=0.155u L=0.04u
M1364 U342/net10 n192 VSS VSS nmos W=0.155u L=0.04u
M1365 U342/net4 U342/net10 U342/net14 VDD pmos W=0.255u L=0.04u
M1366 U342/net6 n192 U342/net14 VDD pmos W=0.28u L=0.04u
M1367 U342/net4 N46 VDD VDD pmos W=0.205u L=0.04u
M1368 U342/net6 U342/net4 VDD VDD pmos W=0.24u L=0.04u
M1369 n308 U342/net14 VDD VDD pmos W=0.205u L=0.04u
M1370 U342/net10 n192 VDD VDD pmos W=0.205u L=0.04u
M1371 U343/net4 U343/net10 U343/net14 VSS nmos W=0.155u L=0.04u
M1372 U343/net6 N40 U343/net14 VSS nmos W=0.155u L=0.04u
M1373 U343/net4 N25 VSS VSS nmos W=0.155u L=0.04u
M1374 U343/net6 U343/net4 VSS VSS nmos W=0.155u L=0.04u
M1375 n192 U343/net14 VSS VSS nmos W=0.155u L=0.04u
M1376 U343/net10 N40 VSS VSS nmos W=0.155u L=0.04u
M1377 U343/net4 N40 U343/net14 VDD pmos W=0.205u L=0.04u
M1378 U343/net6 U343/net10 U343/net14 VDD pmos W=0.205u L=0.04u
M1379 U343/net4 N25 VDD VDD pmos W=0.205u L=0.04u
M1380 U343/net6 U343/net4 VDD VDD pmos W=0.205u L=0.04u
M1381 n192 U343/net14 VDD VDD pmos W=0.205u L=0.04u
M1382 U343/net10 N40 VDD VDD pmos W=0.205u L=0.04u
M1383 U344/XU1-net6 n303 VSS VSS nmos W=0.155u L=0.04u
M1384 n314 N53 U344/XU1-net6 VSS nmos W=0.155u L=0.04u
M1385 n314 n303 VDD VDD pmos W=0.155u L=0.04u
M1386 n314 N53 VDD VDD pmos W=0.155u L=0.04u
M1387 n303 N72 VSS VSS nmos W=0.155u L=0.04u
M1388 n303 N104 VSS VSS nmos W=0.155u L=0.04u
M1389 U345/XI1-net8 N104 VDD VDD pmos W=0.205u L=0.04u
M1390 n303 N72 U345/XI1-net8 VDD pmos W=0.205u L=0.04u
M1391 U346/net28 U346/net20 U346/net64 VSS nmos W=0.155u L=0.04u
M1392 U346/net24 U346/net30 U346/net32 VSS nmos W=0.155u L=0.04u
M1393 U346/net28 U346/net40 U346/net24 VSS nmos W=0.155u L=0.04u
M1394 U346/net40 N4 U346/net108 VSS nmos W=0.155u L=0.04u
M1395 U346/net40 U346/net106 U346/net104 VSS nmos W=0.155u L=0.04u
M1396 U346/net24 N31 U346/net050 VSS nmos W=0.155u L=0.04u
M1397 U346/net050 U346/net32 VSS VSS nmos W=0.155u L=0.04u
M1398 U346/net20 U346/net40 VSS VSS nmos W=0.155u L=0.04u
M1399 U346/net106 N4 VSS VSS nmos W=0.155u L=0.04u
M1400 U346/net104 N43 VSS VSS nmos W=0.155u L=0.04u
M1401 U346/net30 N31 VSS VSS nmos W=0.155u L=0.04u
M1402 U346/net108 U346/net104 VSS VSS nmos W=0.155u L=0.04u
M1403 n313 U346/net28 VSS VSS nmos W=0.155u L=0.04u
M1404 U346/net32 N22 VSS VSS nmos W=0.155u L=0.04u
M1405 U346/net64 U346/net24 VSS VSS nmos W=0.2u L=0.04u
M1406 U346/net28 U346/net40 U346/net64 VDD pmos W=0.205u L=0.04u
M1407 U346/net24 N31 U346/net32 VDD pmos W=0.205u L=0.04u
M1408 U346/net28 U346/net20 U346/net24 VDD pmos W=0.205u L=0.04u
M1409 U346/net40 U346/net106 U346/net108 VDD pmos W=0.205u L=0.04u
M1410 U346/net40 N4 U346/net104 VDD pmos W=0.205u L=0.04u
M1411 U346/net20 U346/net40 VDD VDD pmos W=0.205u L=0.04u
M1412 U346/net106 N4 VDD VDD pmos W=0.205u L=0.04u
M1413 U346/net104 N43 VDD VDD pmos W=0.205u L=0.04u
M1414 U346/net30 N31 VDD VDD pmos W=0.205u L=0.04u
M1415 U346/net108 U346/net104 VDD VDD pmos W=0.205u L=0.04u
M1416 n313 U346/net28 VDD VDD pmos W=0.205u L=0.04u
M1417 U346/net32 N22 VDD VDD pmos W=0.205u L=0.04u
M1418 U346/net64 U346/net24 VDD VDD pmos W=0.28u L=0.04u
M1419 U346/net24 U346/net30 U346/net045 VDD pmos W=0.205u L=0.04u
M1420 U346/net045 U346/net32 VDD VDD pmos W=0.205u L=0.04u
.ENDS
