.SUBCKT c1355 G1 G10 G11 G12 G13 N384 N385 N386 N387 N388 N389 N390 N391 N392 N393 N394 N395 N396 N397 N398 N399 N400 N401 N402 N403 N404 N405 N406 N407 N408 N409 N410 N411 N412 N413 N414 N415 G14 G15 G16 G17 G18 G19 G2 G20 G21 G22 G23 G24 G25 G26 G27 G28 G29 G3 G30 G31 G32 G33 G34 G35 G36 G37 G38 G39 G4 G40 G41 G5 G6 G7 G8 G9 VDD VSS
M1 U185/net4 U185/net10 U185/net14 VSS nmos W=0.155u L=0.04u
M2 U185/net6 G32 U185/net14 VSS nmos W=0.155u L=0.04u
M3 U185/net4 n153 VSS VSS nmos W=0.155u L=0.04u
M4 U185/net6 U185/net4 VSS VSS nmos W=0.155u L=0.04u
M5 N415 U185/net14 VSS VSS nmos W=0.155u L=0.04u
M6 U185/net10 G32 VSS VSS nmos W=0.155u L=0.04u
M7 U185/net4 G32 U185/net14 VDD pmos W=0.205u L=0.04u
M8 U185/net6 U185/net10 U185/net14 VDD pmos W=0.205u L=0.04u
M9 U185/net4 n153 VDD VDD pmos W=0.205u L=0.04u
M10 U185/net6 U185/net4 VDD VDD pmos W=0.205u L=0.04u
M11 N415 U185/net14 VDD VDD pmos W=0.205u L=0.04u
M12 U185/net10 G32 VDD VDD pmos W=0.205u L=0.04u
M13 U186/XU1-net6 n155 VSS VSS nmos W=0.155u L=0.04u
M14 n153 n154 U186/XU1-net6 VSS nmos W=0.155u L=0.04u
M15 n153 n155 VDD VDD pmos W=0.155u L=0.04u
M16 n153 n154 VDD VDD pmos W=0.155u L=0.04u
M17 U187/net4 U187/net10 U187/net14 VSS nmos W=0.155u L=0.04u
M18 U187/net6 G31 U187/net14 VSS nmos W=0.155u L=0.04u
M19 U187/net4 n156 VSS VSS nmos W=0.155u L=0.04u
M20 U187/net6 U187/net4 VSS VSS nmos W=0.155u L=0.04u
M21 N414 U187/net14 VSS VSS nmos W=0.155u L=0.04u
M22 U187/net10 G31 VSS VSS nmos W=0.155u L=0.04u
M23 U187/net4 G31 U187/net14 VDD pmos W=0.205u L=0.04u
M24 U187/net6 U187/net10 U187/net14 VDD pmos W=0.205u L=0.04u
M25 U187/net4 n156 VDD VDD pmos W=0.205u L=0.04u
M26 U187/net6 U187/net4 VDD VDD pmos W=0.205u L=0.04u
M27 N414 U187/net14 VDD VDD pmos W=0.205u L=0.04u
M28 U187/net10 G31 VDD VDD pmos W=0.205u L=0.04u
M29 U188/XU1-net6 n157 VSS VSS nmos W=0.155u L=0.04u
M30 n156 n154 U188/XU1-net6 VSS nmos W=0.155u L=0.04u
M31 n156 n157 VDD VDD pmos W=0.155u L=0.04u
M32 n156 n154 VDD VDD pmos W=0.155u L=0.04u
M33 U189/net4 U189/net10 U189/net14 VSS nmos W=0.155u L=0.04u
M34 U189/net6 G30 U189/net14 VSS nmos W=0.155u L=0.04u
M35 U189/net4 n158 VSS VSS nmos W=0.155u L=0.04u
M36 U189/net6 U189/net4 VSS VSS nmos W=0.155u L=0.04u
M37 N413 U189/net14 VSS VSS nmos W=0.155u L=0.04u
M38 U189/net10 G30 VSS VSS nmos W=0.155u L=0.04u
M39 U189/net4 G30 U189/net14 VDD pmos W=0.205u L=0.04u
M40 U189/net6 U189/net10 U189/net14 VDD pmos W=0.205u L=0.04u
M41 U189/net4 n158 VDD VDD pmos W=0.205u L=0.04u
M42 U189/net6 U189/net4 VDD VDD pmos W=0.205u L=0.04u
M43 N413 U189/net14 VDD VDD pmos W=0.205u L=0.04u
M44 U189/net10 G30 VDD VDD pmos W=0.205u L=0.04u
M45 U190/XU1-net6 n154 VSS VSS nmos W=0.155u L=0.04u
M46 n158 n159 U190/XU1-net6 VSS nmos W=0.155u L=0.04u
M47 n158 n154 VDD VDD pmos W=0.155u L=0.04u
M48 n158 n159 VDD VDD pmos W=0.155u L=0.04u
M49 U191/net4 U191/net10 U191/net14 VSS nmos W=0.155u L=0.04u
M50 U191/net6 G29 U191/net14 VSS nmos W=0.155u L=0.04u
M51 U191/net4 n160 VSS VSS nmos W=0.155u L=0.04u
M52 U191/net6 U191/net4 VSS VSS nmos W=0.155u L=0.04u
M53 N412 U191/net14 VSS VSS nmos W=0.155u L=0.04u
M54 U191/net10 G29 VSS VSS nmos W=0.155u L=0.04u
M55 U191/net4 G29 U191/net14 VDD pmos W=0.205u L=0.04u
M56 U191/net6 U191/net10 U191/net14 VDD pmos W=0.205u L=0.04u
M57 U191/net4 n160 VDD VDD pmos W=0.205u L=0.04u
M58 U191/net6 U191/net4 VDD VDD pmos W=0.205u L=0.04u
M59 N412 U191/net14 VDD VDD pmos W=0.205u L=0.04u
M60 U191/net10 G29 VDD VDD pmos W=0.205u L=0.04u
M61 U192/XU1-net6 n154 VSS VSS nmos W=0.155u L=0.04u
M62 n160 n161 U192/XU1-net6 VSS nmos W=0.155u L=0.04u
M63 n160 n154 VDD VDD pmos W=0.155u L=0.04u
M64 n160 n161 VDD VDD pmos W=0.155u L=0.04u
M65 n154 n164 VSS VSS nmos W=0.155u L=0.04u
M66 n154 n163 VSS VSS nmos W=0.155u L=0.04u
M67 n154 U193/net12 VSS VSS nmos W=0.155u L=0.04u
M68 U193/net12 n162 VSS VSS nmos W=0.155u L=0.04u
M69 U193/XU9-net9 U193/net12 VDD VDD pmos W=0.41u L=0.04u
M70 U193/XU9-net12 n163 U193/XU9-net9 VDD pmos W=0.41u L=0.04u
M71 n154 n164 U193/XU9-net12 VDD pmos W=0.41u L=0.04u
M72 U193/net12 n162 VDD VDD pmos W=0.31u L=0.04u
M73 U194/net4 U194/net10 U194/net14 VSS nmos W=0.155u L=0.04u
M74 U194/net6 G28 U194/net14 VSS nmos W=0.155u L=0.04u
M75 U194/net4 n165 VSS VSS nmos W=0.155u L=0.04u
M76 U194/net6 U194/net4 VSS VSS nmos W=0.155u L=0.04u
M77 N411 U194/net14 VSS VSS nmos W=0.155u L=0.04u
M78 U194/net10 G28 VSS VSS nmos W=0.155u L=0.04u
M79 U194/net4 G28 U194/net14 VDD pmos W=0.205u L=0.04u
M80 U194/net6 U194/net10 U194/net14 VDD pmos W=0.205u L=0.04u
M81 U194/net4 n165 VDD VDD pmos W=0.205u L=0.04u
M82 U194/net6 U194/net4 VDD VDD pmos W=0.205u L=0.04u
M83 N411 U194/net14 VDD VDD pmos W=0.205u L=0.04u
M84 U194/net10 G28 VDD VDD pmos W=0.205u L=0.04u
M85 U195/XU1-net6 n155 VSS VSS nmos W=0.155u L=0.04u
M86 n165 n166 U195/XU1-net6 VSS nmos W=0.155u L=0.04u
M87 n165 n155 VDD VDD pmos W=0.155u L=0.04u
M88 n165 n166 VDD VDD pmos W=0.155u L=0.04u
M89 U196/net4 U196/net10 U196/net14 VSS nmos W=0.155u L=0.04u
M90 U196/net6 G27 U196/net14 VSS nmos W=0.155u L=0.04u
M91 U196/net4 n167 VSS VSS nmos W=0.155u L=0.04u
M92 U196/net6 U196/net4 VSS VSS nmos W=0.155u L=0.04u
M93 N410 U196/net14 VSS VSS nmos W=0.155u L=0.04u
M94 U196/net10 G27 VSS VSS nmos W=0.155u L=0.04u
M95 U196/net4 G27 U196/net14 VDD pmos W=0.205u L=0.04u
M96 U196/net6 U196/net10 U196/net14 VDD pmos W=0.205u L=0.04u
M97 U196/net4 n167 VDD VDD pmos W=0.205u L=0.04u
M98 U196/net6 U196/net4 VDD VDD pmos W=0.205u L=0.04u
M99 N410 U196/net14 VDD VDD pmos W=0.205u L=0.04u
M100 U196/net10 G27 VDD VDD pmos W=0.205u L=0.04u
M101 U197/XU1-net6 n157 VSS VSS nmos W=0.155u L=0.04u
M102 n167 n166 U197/XU1-net6 VSS nmos W=0.155u L=0.04u
M103 n167 n157 VDD VDD pmos W=0.155u L=0.04u
M104 n167 n166 VDD VDD pmos W=0.155u L=0.04u
M105 U198/net4 U198/net10 U198/net14 VSS nmos W=0.155u L=0.04u
M106 U198/net6 G26 U198/net14 VSS nmos W=0.155u L=0.04u
M107 U198/net4 n168 VSS VSS nmos W=0.155u L=0.04u
M108 U198/net6 U198/net4 VSS VSS nmos W=0.155u L=0.04u
M109 N409 U198/net14 VSS VSS nmos W=0.155u L=0.04u
M110 U198/net10 G26 VSS VSS nmos W=0.155u L=0.04u
M111 U198/net4 G26 U198/net14 VDD pmos W=0.205u L=0.04u
M112 U198/net6 U198/net10 U198/net14 VDD pmos W=0.205u L=0.04u
M113 U198/net4 n168 VDD VDD pmos W=0.205u L=0.04u
M114 U198/net6 U198/net4 VDD VDD pmos W=0.205u L=0.04u
M115 N409 U198/net14 VDD VDD pmos W=0.205u L=0.04u
M116 U198/net10 G26 VDD VDD pmos W=0.205u L=0.04u
M117 U199/XU1-net6 n159 VSS VSS nmos W=0.155u L=0.04u
M118 n168 n166 U199/XU1-net6 VSS nmos W=0.155u L=0.04u
M119 n168 n159 VDD VDD pmos W=0.155u L=0.04u
M120 n168 n166 VDD VDD pmos W=0.155u L=0.04u
M121 U200/net4 U200/net10 U200/net14 VSS nmos W=0.155u L=0.04u
M122 U200/net6 G25 U200/net14 VSS nmos W=0.155u L=0.04u
M123 U200/net4 n169 VSS VSS nmos W=0.155u L=0.04u
M124 U200/net6 U200/net4 VSS VSS nmos W=0.155u L=0.04u
M125 N408 U200/net14 VSS VSS nmos W=0.155u L=0.04u
M126 U200/net10 G25 VSS VSS nmos W=0.155u L=0.04u
M127 U200/net4 G25 U200/net14 VDD pmos W=0.205u L=0.04u
M128 U200/net6 U200/net10 U200/net14 VDD pmos W=0.205u L=0.04u
M129 U200/net4 n169 VDD VDD pmos W=0.205u L=0.04u
M130 U200/net6 U200/net4 VDD VDD pmos W=0.205u L=0.04u
M131 N408 U200/net14 VDD VDD pmos W=0.205u L=0.04u
M132 U200/net10 G25 VDD VDD pmos W=0.205u L=0.04u
M133 U201/XU1-net6 n161 VSS VSS nmos W=0.155u L=0.04u
M134 n169 n166 U201/XU1-net6 VSS nmos W=0.155u L=0.04u
M135 n169 n161 VDD VDD pmos W=0.155u L=0.04u
M136 n169 n166 VDD VDD pmos W=0.155u L=0.04u
M137 n166 n171 VSS VSS nmos W=0.155u L=0.04u
M138 n166 n170 VSS VSS nmos W=0.155u L=0.04u
M139 n166 U202/net12 VSS VSS nmos W=0.155u L=0.04u
M140 U202/net12 n162 VSS VSS nmos W=0.155u L=0.04u
M141 U202/XU9-net9 U202/net12 VDD VDD pmos W=0.41u L=0.04u
M142 U202/XU9-net12 n170 U202/XU9-net9 VDD pmos W=0.41u L=0.04u
M143 n166 n171 U202/XU9-net12 VDD pmos W=0.41u L=0.04u
M144 U202/net12 n162 VDD VDD pmos W=0.31u L=0.04u
M145 n162 n174 VSS VSS nmos W=0.155u L=0.04u
M146 n162 n173 VSS VSS nmos W=0.155u L=0.04u
M147 n162 U203/net12 VSS VSS nmos W=0.155u L=0.04u
M148 U203/net12 n172 VSS VSS nmos W=0.155u L=0.04u
M149 U203/XU9-net9 U203/net12 VDD VDD pmos W=0.41u L=0.04u
M150 U203/XU9-net12 n173 U203/XU9-net9 VDD pmos W=0.41u L=0.04u
M151 n162 n174 U203/XU9-net12 VDD pmos W=0.41u L=0.04u
M152 U203/net12 n172 VDD VDD pmos W=0.31u L=0.04u
M153 U204/net4 U204/net10 U204/net14 VSS nmos W=0.155u L=0.04u
M154 U204/net6 G24 U204/net14 VSS nmos W=0.155u L=0.04u
M155 U204/net4 n175 VSS VSS nmos W=0.155u L=0.04u
M156 U204/net6 U204/net4 VSS VSS nmos W=0.155u L=0.04u
M157 N407 U204/net14 VSS VSS nmos W=0.155u L=0.04u
M158 U204/net10 G24 VSS VSS nmos W=0.155u L=0.04u
M159 U204/net4 G24 U204/net14 VDD pmos W=0.205u L=0.04u
M160 U204/net6 U204/net10 U204/net14 VDD pmos W=0.205u L=0.04u
M161 U204/net4 n175 VDD VDD pmos W=0.205u L=0.04u
M162 U204/net6 U204/net4 VDD VDD pmos W=0.205u L=0.04u
M163 N407 U204/net14 VDD VDD pmos W=0.205u L=0.04u
M164 U204/net10 G24 VDD VDD pmos W=0.205u L=0.04u
M165 U205/XU1-net6 n155 VSS VSS nmos W=0.155u L=0.04u
M166 n175 n176 U205/XU1-net6 VSS nmos W=0.155u L=0.04u
M167 n175 n155 VDD VDD pmos W=0.155u L=0.04u
M168 n175 n176 VDD VDD pmos W=0.155u L=0.04u
M169 U206/net4 U206/net10 U206/net14 VSS nmos W=0.155u L=0.04u
M170 U206/net6 G23 U206/net14 VSS nmos W=0.155u L=0.04u
M171 U206/net4 n177 VSS VSS nmos W=0.155u L=0.04u
M172 U206/net6 U206/net4 VSS VSS nmos W=0.155u L=0.04u
M173 N406 U206/net14 VSS VSS nmos W=0.155u L=0.04u
M174 U206/net10 G23 VSS VSS nmos W=0.155u L=0.04u
M175 U206/net4 G23 U206/net14 VDD pmos W=0.205u L=0.04u
M176 U206/net6 U206/net10 U206/net14 VDD pmos W=0.205u L=0.04u
M177 U206/net4 n177 VDD VDD pmos W=0.205u L=0.04u
M178 U206/net6 U206/net4 VDD VDD pmos W=0.205u L=0.04u
M179 N406 U206/net14 VDD VDD pmos W=0.205u L=0.04u
M180 U206/net10 G23 VDD VDD pmos W=0.205u L=0.04u
M181 U207/XU1-net6 n157 VSS VSS nmos W=0.155u L=0.04u
M182 n177 n176 U207/XU1-net6 VSS nmos W=0.155u L=0.04u
M183 n177 n157 VDD VDD pmos W=0.155u L=0.04u
M184 n177 n176 VDD VDD pmos W=0.155u L=0.04u
M185 U208/net4 U208/net10 U208/net14 VSS nmos W=0.155u L=0.04u
M186 U208/net6 G22 U208/net14 VSS nmos W=0.155u L=0.04u
M187 U208/net4 n178 VSS VSS nmos W=0.155u L=0.04u
M188 U208/net6 U208/net4 VSS VSS nmos W=0.155u L=0.04u
M189 N405 U208/net14 VSS VSS nmos W=0.155u L=0.04u
M190 U208/net10 G22 VSS VSS nmos W=0.155u L=0.04u
M191 U208/net4 G22 U208/net14 VDD pmos W=0.205u L=0.04u
M192 U208/net6 U208/net10 U208/net14 VDD pmos W=0.205u L=0.04u
M193 U208/net4 n178 VDD VDD pmos W=0.205u L=0.04u
M194 U208/net6 U208/net4 VDD VDD pmos W=0.205u L=0.04u
M195 N405 U208/net14 VDD VDD pmos W=0.205u L=0.04u
M196 U208/net10 G22 VDD VDD pmos W=0.205u L=0.04u
M197 U209/XU1-net6 n159 VSS VSS nmos W=0.155u L=0.04u
M198 n178 n176 U209/XU1-net6 VSS nmos W=0.155u L=0.04u
M199 n178 n159 VDD VDD pmos W=0.155u L=0.04u
M200 n178 n176 VDD VDD pmos W=0.155u L=0.04u
M201 U210/net4 U210/net10 U210/net14 VSS nmos W=0.155u L=0.04u
M202 U210/net6 G21 U210/net14 VSS nmos W=0.155u L=0.04u
M203 U210/net4 n179 VSS VSS nmos W=0.155u L=0.04u
M204 U210/net6 U210/net4 VSS VSS nmos W=0.155u L=0.04u
M205 N404 U210/net14 VSS VSS nmos W=0.155u L=0.04u
M206 U210/net10 G21 VSS VSS nmos W=0.155u L=0.04u
M207 U210/net4 G21 U210/net14 VDD pmos W=0.205u L=0.04u
M208 U210/net6 U210/net10 U210/net14 VDD pmos W=0.205u L=0.04u
M209 U210/net4 n179 VDD VDD pmos W=0.205u L=0.04u
M210 U210/net6 U210/net4 VDD VDD pmos W=0.205u L=0.04u
M211 N404 U210/net14 VDD VDD pmos W=0.205u L=0.04u
M212 U210/net10 G21 VDD VDD pmos W=0.205u L=0.04u
M213 U211/XU1-net6 n161 VSS VSS nmos W=0.155u L=0.04u
M214 n179 n176 U211/XU1-net6 VSS nmos W=0.155u L=0.04u
M215 n179 n161 VDD VDD pmos W=0.155u L=0.04u
M216 n179 n176 VDD VDD pmos W=0.155u L=0.04u
M217 n176 n164 VSS VSS nmos W=0.155u L=0.04u
M218 n176 n163 VSS VSS nmos W=0.155u L=0.04u
M219 n176 U212/net12 VSS VSS nmos W=0.155u L=0.04u
M220 U212/net12 n180 VSS VSS nmos W=0.155u L=0.04u
M221 U212/XU9-net9 U212/net12 VDD VDD pmos W=0.41u L=0.04u
M222 U212/XU9-net12 n163 U212/XU9-net9 VDD pmos W=0.41u L=0.04u
M223 n176 n164 U212/XU9-net12 VDD pmos W=0.41u L=0.04u
M224 U212/net12 n180 VDD VDD pmos W=0.31u L=0.04u
M225 n163 n170 VSS VSS nmos W=0.135u L=0.04u
M226 n163 n170 VDD VDD pmos W=0.205u L=0.04u
M227 U214/net4 U214/net10 U214/net14 VSS nmos W=0.155u L=0.04u
M228 U214/net6 G20 U214/net14 VSS nmos W=0.155u L=0.04u
M229 U214/net4 n181 VSS VSS nmos W=0.155u L=0.04u
M230 U214/net6 U214/net4 VSS VSS nmos W=0.155u L=0.04u
M231 N403 U214/net14 VSS VSS nmos W=0.155u L=0.04u
M232 U214/net10 G20 VSS VSS nmos W=0.155u L=0.04u
M233 U214/net4 G20 U214/net14 VDD pmos W=0.205u L=0.04u
M234 U214/net6 U214/net10 U214/net14 VDD pmos W=0.205u L=0.04u
M235 U214/net4 n181 VDD VDD pmos W=0.205u L=0.04u
M236 U214/net6 U214/net4 VDD VDD pmos W=0.205u L=0.04u
M237 N403 U214/net14 VDD VDD pmos W=0.205u L=0.04u
M238 U214/net10 G20 VDD VDD pmos W=0.205u L=0.04u
M239 U215/XU1-net6 n155 VSS VSS nmos W=0.155u L=0.04u
M240 n181 n182 U215/XU1-net6 VSS nmos W=0.155u L=0.04u
M241 n181 n155 VDD VDD pmos W=0.155u L=0.04u
M242 n181 n182 VDD VDD pmos W=0.155u L=0.04u
M243 U216/net4 U216/net10 U216/net14 VSS nmos W=0.155u L=0.04u
M244 U216/net6 G19 U216/net14 VSS nmos W=0.155u L=0.04u
M245 U216/net4 n183 VSS VSS nmos W=0.155u L=0.04u
M246 U216/net6 U216/net4 VSS VSS nmos W=0.155u L=0.04u
M247 N402 U216/net14 VSS VSS nmos W=0.155u L=0.04u
M248 U216/net10 G19 VSS VSS nmos W=0.155u L=0.04u
M249 U216/net4 G19 U216/net14 VDD pmos W=0.205u L=0.04u
M250 U216/net6 U216/net10 U216/net14 VDD pmos W=0.205u L=0.04u
M251 U216/net4 n183 VDD VDD pmos W=0.205u L=0.04u
M252 U216/net6 U216/net4 VDD VDD pmos W=0.205u L=0.04u
M253 N402 U216/net14 VDD VDD pmos W=0.205u L=0.04u
M254 U216/net10 G19 VDD VDD pmos W=0.205u L=0.04u
M255 U217/XU1-net6 n157 VSS VSS nmos W=0.155u L=0.04u
M256 n183 n182 U217/XU1-net6 VSS nmos W=0.155u L=0.04u
M257 n183 n157 VDD VDD pmos W=0.155u L=0.04u
M258 n183 n182 VDD VDD pmos W=0.155u L=0.04u
M259 U218/net4 U218/net10 U218/net14 VSS nmos W=0.155u L=0.04u
M260 U218/net6 G18 U218/net14 VSS nmos W=0.155u L=0.04u
M261 U218/net4 n184 VSS VSS nmos W=0.155u L=0.04u
M262 U218/net6 U218/net4 VSS VSS nmos W=0.155u L=0.04u
M263 N401 U218/net14 VSS VSS nmos W=0.155u L=0.04u
M264 U218/net10 G18 VSS VSS nmos W=0.155u L=0.04u
M265 U218/net4 G18 U218/net14 VDD pmos W=0.205u L=0.04u
M266 U218/net6 U218/net10 U218/net14 VDD pmos W=0.205u L=0.04u
M267 U218/net4 n184 VDD VDD pmos W=0.205u L=0.04u
M268 U218/net6 U218/net4 VDD VDD pmos W=0.205u L=0.04u
M269 N401 U218/net14 VDD VDD pmos W=0.205u L=0.04u
M270 U218/net10 G18 VDD VDD pmos W=0.205u L=0.04u
M271 U219/XU1-net6 n159 VSS VSS nmos W=0.155u L=0.04u
M272 n184 n182 U219/XU1-net6 VSS nmos W=0.155u L=0.04u
M273 n184 n159 VDD VDD pmos W=0.155u L=0.04u
M274 n184 n182 VDD VDD pmos W=0.155u L=0.04u
M275 U220/net4 U220/net10 U220/net14 VSS nmos W=0.155u L=0.04u
M276 U220/net6 G17 U220/net14 VSS nmos W=0.155u L=0.04u
M277 U220/net4 n185 VSS VSS nmos W=0.155u L=0.04u
M278 U220/net6 U220/net4 VSS VSS nmos W=0.155u L=0.04u
M279 N400 U220/net14 VSS VSS nmos W=0.155u L=0.04u
M280 U220/net10 G17 VSS VSS nmos W=0.155u L=0.04u
M281 U220/net4 G17 U220/net14 VDD pmos W=0.205u L=0.04u
M282 U220/net6 U220/net10 U220/net14 VDD pmos W=0.205u L=0.04u
M283 U220/net4 n185 VDD VDD pmos W=0.205u L=0.04u
M284 U220/net6 U220/net4 VDD VDD pmos W=0.205u L=0.04u
M285 N400 U220/net14 VDD VDD pmos W=0.205u L=0.04u
M286 U220/net10 G17 VDD VDD pmos W=0.205u L=0.04u
M287 U221/XU1-net6 n161 VSS VSS nmos W=0.155u L=0.04u
M288 n185 n182 U221/XU1-net6 VSS nmos W=0.155u L=0.04u
M289 n185 n161 VDD VDD pmos W=0.155u L=0.04u
M290 n185 n182 VDD VDD pmos W=0.155u L=0.04u
M291 n182 n170 VSS VSS nmos W=0.155u L=0.04u
M292 n182 n171 VSS VSS nmos W=0.155u L=0.04u
M293 n182 U222/net12 VSS VSS nmos W=0.155u L=0.04u
M294 U222/net12 n180 VSS VSS nmos W=0.155u L=0.04u
M295 U222/XU9-net9 U222/net12 VDD VDD pmos W=0.41u L=0.04u
M296 U222/XU9-net12 n171 U222/XU9-net9 VDD pmos W=0.41u L=0.04u
M297 n182 n170 U222/XU9-net12 VDD pmos W=0.41u L=0.04u
M298 U222/net12 n180 VDD VDD pmos W=0.31u L=0.04u
M299 n171 n164 VSS VSS nmos W=0.135u L=0.04u
M300 n171 n164 VDD VDD pmos W=0.205u L=0.04u
M301 U224/net7 n174 U224/X_u4-net10 VSS nmos W=0.155u L=0.04u
M302 U224/X_u4-net10 n172 U224/X_u4-net13 VSS nmos W=0.155u L=0.04u
M303 U224/X_u4-net13 n173 VSS VSS nmos W=0.155u L=0.04u
M304 n180 U224/net7 VSS VSS nmos W=0.155u L=0.04u
M305 U224/net7 n173 VDD VDD pmos W=0.205u L=0.04u
M306 U224/net7 n174 VDD VDD pmos W=0.205u L=0.04u
M307 U224/net7 n172 VDD VDD pmos W=0.205u L=0.04u
M308 n180 U224/net7 VDD VDD pmos W=0.205u L=0.04u
M309 n172 n155 U225/net14 VSS nmos W=0.155u L=0.04u
M310 U225/net14 n159 VSS VSS nmos W=0.155u L=0.04u
M311 U225/net14 n186 VSS VSS nmos W=0.155u L=0.04u
M312 n172 n161 U225/net14 VSS nmos W=0.155u L=0.04u
M313 n172 n157 U225/net14 VSS nmos W=0.155u L=0.04u
M314 n172 n159 U225/XI16-net11 VDD pmos W=0.205u L=0.04u
M315 U225/XI16-net11 n186 VDD VDD pmos W=0.205u L=0.04u
M316 n172 n161 U225/XI15-net11 VDD pmos W=0.205u L=0.04u
M317 U225/XI15-net11 n157 U225/XI15-net18 VDD pmos W=0.205u L=0.04u
M318 U225/XI15-net18 n155 VDD VDD pmos W=0.205u L=0.04u
M319 U226/net26 n189 VSS VSS nmos W=0.155u L=0.04u
M320 U226/net26 n187 n186 VSS nmos W=0.155u L=0.04u
M321 U226/net26 n188 n186 VSS nmos W=0.155u L=0.04u
M322 n186 n187 U226/net38 VSS nmos W=0.155u L=0.04u
M323 U226/net38 n188 VSS VSS nmos W=0.155u L=0.04u
M324 U226/net16 n188 VDD VDD pmos W=0.205u L=0.04u
M325 U226/net20 n187 n186 VDD pmos W=0.205u L=0.04u
M326 n186 n187 U226/net16 VDD pmos W=0.205u L=0.04u
M327 U226/net20 n188 n186 VDD pmos W=0.205u L=0.04u
M328 U226/net20 n189 VDD VDD pmos W=0.205u L=0.04u
M329 U227/net19 n192 VSS VSS nmos W=0.155u L=0.04u
M330 n189 n192 U227/net40 VSS nmos W=0.155u L=0.04u
M331 n189 U227/net19 U227/net36 VSS nmos W=0.155u L=0.04u
M332 U227/net40 n191 VSS VSS nmos W=0.31u L=0.04u
M333 U227/net36 n190 VSS VSS nmos W=0.155u L=0.04u
M334 U227/net19 n192 VDD VDD pmos W=0.205u L=0.04u
M335 n189 U227/net19 U227/net26 VDD pmos W=0.325u L=0.04u
M336 U227/net26 n191 VDD VDD pmos W=0.41u L=0.04u
M337 n189 n192 U227/net30 VDD pmos W=0.325u L=0.04u
M338 U227/net30 n190 VDD VDD pmos W=0.205u L=0.04u
M339 U228/net19 n195 VSS VSS nmos W=0.155u L=0.04u
M340 n188 n195 U228/net40 VSS nmos W=0.155u L=0.04u
M341 n188 U228/net19 U228/net36 VSS nmos W=0.155u L=0.04u
M342 U228/net40 n194 VSS VSS nmos W=0.31u L=0.04u
M343 U228/net36 n193 VSS VSS nmos W=0.155u L=0.04u
M344 U228/net19 n195 VDD VDD pmos W=0.205u L=0.04u
M345 n188 U228/net19 U228/net26 VDD pmos W=0.325u L=0.04u
M346 U228/net26 n194 VDD VDD pmos W=0.41u L=0.04u
M347 n188 n195 U228/net30 VDD pmos W=0.325u L=0.04u
M348 U228/net30 n193 VDD VDD pmos W=0.205u L=0.04u
M349 U229/net4 U229/net10 U229/net14 VSS nmos W=0.155u L=0.04u
M350 U229/net6 G16 U229/net14 VSS nmos W=0.155u L=0.04u
M351 U229/net4 n196 VSS VSS nmos W=0.155u L=0.04u
M352 U229/net6 U229/net4 VSS VSS nmos W=0.155u L=0.04u
M353 N399 U229/net14 VSS VSS nmos W=0.155u L=0.04u
M354 U229/net10 G16 VSS VSS nmos W=0.155u L=0.04u
M355 U229/net4 G16 U229/net14 VDD pmos W=0.205u L=0.04u
M356 U229/net6 U229/net10 U229/net14 VDD pmos W=0.205u L=0.04u
M357 U229/net4 n196 VDD VDD pmos W=0.205u L=0.04u
M358 U229/net6 U229/net4 VDD VDD pmos W=0.205u L=0.04u
M359 N399 U229/net14 VDD VDD pmos W=0.205u L=0.04u
M360 U229/net10 G16 VDD VDD pmos W=0.205u L=0.04u
M361 U230/XU1-net6 n170 VSS VSS nmos W=0.155u L=0.04u
M362 n196 n197 U230/XU1-net6 VSS nmos W=0.155u L=0.04u
M363 n196 n170 VDD VDD pmos W=0.155u L=0.04u
M364 n196 n197 VDD VDD pmos W=0.155u L=0.04u
M365 U231/net4 U231/net10 U231/net14 VSS nmos W=0.155u L=0.04u
M366 U231/net6 G15 U231/net14 VSS nmos W=0.155u L=0.04u
M367 U231/net4 n198 VSS VSS nmos W=0.155u L=0.04u
M368 U231/net6 U231/net4 VSS VSS nmos W=0.155u L=0.04u
M369 N398 U231/net14 VSS VSS nmos W=0.155u L=0.04u
M370 U231/net10 G15 VSS VSS nmos W=0.155u L=0.04u
M371 U231/net4 G15 U231/net14 VDD pmos W=0.205u L=0.04u
M372 U231/net6 U231/net10 U231/net14 VDD pmos W=0.205u L=0.04u
M373 U231/net4 n198 VDD VDD pmos W=0.205u L=0.04u
M374 U231/net6 U231/net4 VDD VDD pmos W=0.205u L=0.04u
M375 N398 U231/net14 VDD VDD pmos W=0.205u L=0.04u
M376 U231/net10 G15 VDD VDD pmos W=0.205u L=0.04u
M377 U232/XU1-net6 n164 VSS VSS nmos W=0.155u L=0.04u
M378 n198 n197 U232/XU1-net6 VSS nmos W=0.155u L=0.04u
M379 n198 n164 VDD VDD pmos W=0.155u L=0.04u
M380 n198 n197 VDD VDD pmos W=0.155u L=0.04u
M381 U233/net4 U233/net10 U233/net14 VSS nmos W=0.155u L=0.04u
M382 U233/net6 G14 U233/net14 VSS nmos W=0.155u L=0.04u
M383 U233/net4 n199 VSS VSS nmos W=0.155u L=0.04u
M384 U233/net6 U233/net4 VSS VSS nmos W=0.155u L=0.04u
M385 N397 U233/net14 VSS VSS nmos W=0.155u L=0.04u
M386 U233/net10 G14 VSS VSS nmos W=0.155u L=0.04u
M387 U233/net4 G14 U233/net14 VDD pmos W=0.205u L=0.04u
M388 U233/net6 U233/net10 U233/net14 VDD pmos W=0.205u L=0.04u
M389 U233/net4 n199 VDD VDD pmos W=0.205u L=0.04u
M390 U233/net6 U233/net4 VDD VDD pmos W=0.205u L=0.04u
M391 N397 U233/net14 VDD VDD pmos W=0.205u L=0.04u
M392 U233/net10 G14 VDD VDD pmos W=0.205u L=0.04u
M393 U234/XU1-net6 n200 VSS VSS nmos W=0.155u L=0.04u
M394 n199 n197 U234/XU1-net6 VSS nmos W=0.155u L=0.04u
M395 n199 n200 VDD VDD pmos W=0.155u L=0.04u
M396 n199 n197 VDD VDD pmos W=0.155u L=0.04u
M397 U235/net4 U235/net10 U235/net14 VSS nmos W=0.155u L=0.04u
M398 U235/net6 G13 U235/net14 VSS nmos W=0.155u L=0.04u
M399 U235/net4 n201 VSS VSS nmos W=0.155u L=0.04u
M400 U235/net6 U235/net4 VSS VSS nmos W=0.155u L=0.04u
M401 N396 U235/net14 VSS VSS nmos W=0.155u L=0.04u
M402 U235/net10 G13 VSS VSS nmos W=0.155u L=0.04u
M403 U235/net4 G13 U235/net14 VDD pmos W=0.205u L=0.04u
M404 U235/net6 U235/net10 U235/net14 VDD pmos W=0.205u L=0.04u
M405 U235/net4 n201 VDD VDD pmos W=0.205u L=0.04u
M406 U235/net6 U235/net4 VDD VDD pmos W=0.205u L=0.04u
M407 N396 U235/net14 VDD VDD pmos W=0.205u L=0.04u
M408 U235/net10 G13 VDD VDD pmos W=0.205u L=0.04u
M409 U236/XU1-net6 n173 VSS VSS nmos W=0.155u L=0.04u
M410 n201 n197 U236/XU1-net6 VSS nmos W=0.155u L=0.04u
M411 n201 n173 VDD VDD pmos W=0.155u L=0.04u
M412 n201 n197 VDD VDD pmos W=0.155u L=0.04u
M413 n197 n157 VSS VSS nmos W=0.155u L=0.04u
M414 n197 n203 VSS VSS nmos W=0.155u L=0.04u
M415 n197 U237/net12 VSS VSS nmos W=0.155u L=0.04u
M416 U237/net12 n202 VSS VSS nmos W=0.155u L=0.04u
M417 U237/XU9-net9 U237/net12 VDD VDD pmos W=0.41u L=0.04u
M418 U237/XU9-net12 n203 U237/XU9-net9 VDD pmos W=0.41u L=0.04u
M419 n197 n157 U237/XU9-net12 VDD pmos W=0.41u L=0.04u
M420 U237/net12 n202 VDD VDD pmos W=0.31u L=0.04u
M421 U238/net4 U238/net10 U238/net14 VSS nmos W=0.155u L=0.04u
M422 U238/net6 G12 U238/net14 VSS nmos W=0.155u L=0.04u
M423 U238/net4 n204 VSS VSS nmos W=0.155u L=0.04u
M424 U238/net6 U238/net4 VSS VSS nmos W=0.155u L=0.04u
M425 N395 U238/net14 VSS VSS nmos W=0.155u L=0.04u
M426 U238/net10 G12 VSS VSS nmos W=0.155u L=0.04u
M427 U238/net4 G12 U238/net14 VDD pmos W=0.205u L=0.04u
M428 U238/net6 U238/net10 U238/net14 VDD pmos W=0.205u L=0.04u
M429 U238/net4 n204 VDD VDD pmos W=0.205u L=0.04u
M430 U238/net6 U238/net4 VDD VDD pmos W=0.205u L=0.04u
M431 N395 U238/net14 VDD VDD pmos W=0.205u L=0.04u
M432 U238/net10 G12 VDD VDD pmos W=0.205u L=0.04u
M433 U239/XU1-net6 n170 VSS VSS nmos W=0.155u L=0.04u
M434 n204 n205 U239/XU1-net6 VSS nmos W=0.155u L=0.04u
M435 n204 n170 VDD VDD pmos W=0.155u L=0.04u
M436 n204 n205 VDD VDD pmos W=0.155u L=0.04u
M437 U240/net4 U240/net10 U240/net14 VSS nmos W=0.155u L=0.04u
M438 U240/net6 G11 U240/net14 VSS nmos W=0.155u L=0.04u
M439 U240/net4 n206 VSS VSS nmos W=0.155u L=0.04u
M440 U240/net6 U240/net4 VSS VSS nmos W=0.155u L=0.04u
M441 N394 U240/net14 VSS VSS nmos W=0.155u L=0.04u
M442 U240/net10 G11 VSS VSS nmos W=0.155u L=0.04u
M443 U240/net4 G11 U240/net14 VDD pmos W=0.205u L=0.04u
M444 U240/net6 U240/net10 U240/net14 VDD pmos W=0.205u L=0.04u
M445 U240/net4 n206 VDD VDD pmos W=0.205u L=0.04u
M446 U240/net6 U240/net4 VDD VDD pmos W=0.205u L=0.04u
M447 N394 U240/net14 VDD VDD pmos W=0.205u L=0.04u
M448 U240/net10 G11 VDD VDD pmos W=0.205u L=0.04u
M449 U241/XU1-net6 n164 VSS VSS nmos W=0.155u L=0.04u
M450 n206 n205 U241/XU1-net6 VSS nmos W=0.155u L=0.04u
M451 n206 n164 VDD VDD pmos W=0.155u L=0.04u
M452 n206 n205 VDD VDD pmos W=0.155u L=0.04u
M453 U242/net4 U242/net10 U242/net14 VSS nmos W=0.155u L=0.04u
M454 U242/net6 G10 U242/net14 VSS nmos W=0.155u L=0.04u
M455 U242/net4 n207 VSS VSS nmos W=0.155u L=0.04u
M456 U242/net6 U242/net4 VSS VSS nmos W=0.155u L=0.04u
M457 N393 U242/net14 VSS VSS nmos W=0.155u L=0.04u
M458 U242/net10 G10 VSS VSS nmos W=0.155u L=0.04u
M459 U242/net4 G10 U242/net14 VDD pmos W=0.205u L=0.04u
M460 U242/net6 U242/net10 U242/net14 VDD pmos W=0.205u L=0.04u
M461 U242/net4 n207 VDD VDD pmos W=0.205u L=0.04u
M462 U242/net6 U242/net4 VDD VDD pmos W=0.205u L=0.04u
M463 N393 U242/net14 VDD VDD pmos W=0.205u L=0.04u
M464 U242/net10 G10 VDD VDD pmos W=0.205u L=0.04u
M465 U243/XU1-net6 n200 VSS VSS nmos W=0.155u L=0.04u
M466 n207 n205 U243/XU1-net6 VSS nmos W=0.155u L=0.04u
M467 n207 n200 VDD VDD pmos W=0.155u L=0.04u
M468 n207 n205 VDD VDD pmos W=0.155u L=0.04u
M469 U244/net4 U244/net10 U244/net14 VSS nmos W=0.155u L=0.04u
M470 U244/net6 G9 U244/net14 VSS nmos W=0.155u L=0.04u
M471 U244/net4 n208 VSS VSS nmos W=0.155u L=0.04u
M472 U244/net6 U244/net4 VSS VSS nmos W=0.155u L=0.04u
M473 N392 U244/net14 VSS VSS nmos W=0.155u L=0.04u
M474 U244/net10 G9 VSS VSS nmos W=0.155u L=0.04u
M475 U244/net4 G9 U244/net14 VDD pmos W=0.205u L=0.04u
M476 U244/net6 U244/net10 U244/net14 VDD pmos W=0.205u L=0.04u
M477 U244/net4 n208 VDD VDD pmos W=0.205u L=0.04u
M478 U244/net6 U244/net4 VDD VDD pmos W=0.205u L=0.04u
M479 N392 U244/net14 VDD VDD pmos W=0.205u L=0.04u
M480 U244/net10 G9 VDD VDD pmos W=0.205u L=0.04u
M481 U245/XU1-net6 n173 VSS VSS nmos W=0.155u L=0.04u
M482 n208 n205 U245/XU1-net6 VSS nmos W=0.155u L=0.04u
M483 n208 n173 VDD VDD pmos W=0.155u L=0.04u
M484 n208 n205 VDD VDD pmos W=0.155u L=0.04u
M485 n205 n155 VSS VSS nmos W=0.155u L=0.04u
M486 n205 n209 VSS VSS nmos W=0.155u L=0.04u
M487 n205 U246/net12 VSS VSS nmos W=0.155u L=0.04u
M488 U246/net12 n202 VSS VSS nmos W=0.155u L=0.04u
M489 U246/XU9-net9 U246/net12 VDD VDD pmos W=0.41u L=0.04u
M490 U246/XU9-net12 n209 U246/XU9-net9 VDD pmos W=0.41u L=0.04u
M491 n205 n155 U246/XU9-net12 VDD pmos W=0.41u L=0.04u
M492 U246/net12 n202 VDD VDD pmos W=0.31u L=0.04u
M493 U247/net7 n187 U247/X_u4-net10 VSS nmos W=0.155u L=0.04u
M494 U247/X_u4-net10 n210 U247/X_u4-net13 VSS nmos W=0.155u L=0.04u
M495 U247/X_u4-net13 n159 VSS VSS nmos W=0.155u L=0.04u
M496 n202 U247/net7 VSS VSS nmos W=0.155u L=0.04u
M497 U247/net7 n159 VDD VDD pmos W=0.205u L=0.04u
M498 U247/net7 n187 VDD VDD pmos W=0.205u L=0.04u
M499 U247/net7 n210 VDD VDD pmos W=0.205u L=0.04u
M500 n202 U247/net7 VDD VDD pmos W=0.205u L=0.04u
M501 U248/net4 U248/net10 U248/net14 VSS nmos W=0.155u L=0.04u
M502 U248/net6 G8 U248/net14 VSS nmos W=0.155u L=0.04u
M503 U248/net4 n211 VSS VSS nmos W=0.155u L=0.04u
M504 U248/net6 U248/net4 VSS VSS nmos W=0.155u L=0.04u
M505 N391 U248/net14 VSS VSS nmos W=0.155u L=0.04u
M506 U248/net10 G8 VSS VSS nmos W=0.155u L=0.04u
M507 U248/net4 G8 U248/net14 VDD pmos W=0.205u L=0.04u
M508 U248/net6 U248/net10 U248/net14 VDD pmos W=0.205u L=0.04u
M509 U248/net4 n211 VDD VDD pmos W=0.205u L=0.04u
M510 U248/net6 U248/net4 VDD VDD pmos W=0.205u L=0.04u
M511 N391 U248/net14 VDD VDD pmos W=0.205u L=0.04u
M512 U248/net10 G8 VDD VDD pmos W=0.205u L=0.04u
M513 U249/XU1-net6 n170 VSS VSS nmos W=0.155u L=0.04u
M514 n211 n212 U249/XU1-net6 VSS nmos W=0.155u L=0.04u
M515 n211 n170 VDD VDD pmos W=0.155u L=0.04u
M516 n211 n212 VDD VDD pmos W=0.155u L=0.04u
M517 U250/net4 U250/net10 U250/net14 VSS nmos W=0.155u L=0.04u
M518 U250/net6 G7 U250/net14 VSS nmos W=0.155u L=0.04u
M519 U250/net4 n213 VSS VSS nmos W=0.155u L=0.04u
M520 U250/net6 U250/net4 VSS VSS nmos W=0.155u L=0.04u
M521 N390 U250/net14 VSS VSS nmos W=0.155u L=0.04u
M522 U250/net10 G7 VSS VSS nmos W=0.155u L=0.04u
M523 U250/net4 G7 U250/net14 VDD pmos W=0.205u L=0.04u
M524 U250/net6 U250/net10 U250/net14 VDD pmos W=0.205u L=0.04u
M525 U250/net4 n213 VDD VDD pmos W=0.205u L=0.04u
M526 U250/net6 U250/net4 VDD VDD pmos W=0.205u L=0.04u
M527 N390 U250/net14 VDD VDD pmos W=0.205u L=0.04u
M528 U250/net10 G7 VDD VDD pmos W=0.205u L=0.04u
M529 U251/XU1-net6 n164 VSS VSS nmos W=0.155u L=0.04u
M530 n213 n212 U251/XU1-net6 VSS nmos W=0.155u L=0.04u
M531 n213 n164 VDD VDD pmos W=0.155u L=0.04u
M532 n213 n212 VDD VDD pmos W=0.155u L=0.04u
M533 U252/net4 U252/net10 U252/net14 VSS nmos W=0.155u L=0.04u
M534 U252/net6 G6 U252/net14 VSS nmos W=0.155u L=0.04u
M535 U252/net4 n214 VSS VSS nmos W=0.155u L=0.04u
M536 U252/net6 U252/net4 VSS VSS nmos W=0.155u L=0.04u
M537 N389 U252/net14 VSS VSS nmos W=0.155u L=0.04u
M538 U252/net10 G6 VSS VSS nmos W=0.155u L=0.04u
M539 U252/net4 G6 U252/net14 VDD pmos W=0.205u L=0.04u
M540 U252/net6 U252/net10 U252/net14 VDD pmos W=0.205u L=0.04u
M541 U252/net4 n214 VDD VDD pmos W=0.205u L=0.04u
M542 U252/net6 U252/net4 VDD VDD pmos W=0.205u L=0.04u
M543 N389 U252/net14 VDD VDD pmos W=0.205u L=0.04u
M544 U252/net10 G6 VDD VDD pmos W=0.205u L=0.04u
M545 U253/XU1-net6 n200 VSS VSS nmos W=0.155u L=0.04u
M546 n214 n212 U253/XU1-net6 VSS nmos W=0.155u L=0.04u
M547 n214 n200 VDD VDD pmos W=0.155u L=0.04u
M548 n214 n212 VDD VDD pmos W=0.155u L=0.04u
M549 U254/net4 U254/net10 U254/net14 VSS nmos W=0.155u L=0.04u
M550 U254/net6 G5 U254/net14 VSS nmos W=0.155u L=0.04u
M551 U254/net4 n215 VSS VSS nmos W=0.155u L=0.04u
M552 U254/net6 U254/net4 VSS VSS nmos W=0.155u L=0.04u
M553 N388 U254/net14 VSS VSS nmos W=0.155u L=0.04u
M554 U254/net10 G5 VSS VSS nmos W=0.155u L=0.04u
M555 U254/net4 G5 U254/net14 VDD pmos W=0.205u L=0.04u
M556 U254/net6 U254/net10 U254/net14 VDD pmos W=0.205u L=0.04u
M557 U254/net4 n215 VDD VDD pmos W=0.205u L=0.04u
M558 U254/net6 U254/net4 VDD VDD pmos W=0.205u L=0.04u
M559 N388 U254/net14 VDD VDD pmos W=0.205u L=0.04u
M560 U254/net10 G5 VDD VDD pmos W=0.205u L=0.04u
M561 U255/XU1-net6 n173 VSS VSS nmos W=0.155u L=0.04u
M562 n215 n212 U255/XU1-net6 VSS nmos W=0.155u L=0.04u
M563 n215 n173 VDD VDD pmos W=0.155u L=0.04u
M564 n215 n212 VDD VDD pmos W=0.155u L=0.04u
M565 n212 n157 VSS VSS nmos W=0.155u L=0.04u
M566 n212 n203 VSS VSS nmos W=0.155u L=0.04u
M567 n212 U256/net12 VSS VSS nmos W=0.155u L=0.04u
M568 U256/net12 n216 VSS VSS nmos W=0.155u L=0.04u
M569 U256/XU9-net9 U256/net12 VDD VDD pmos W=0.41u L=0.04u
M570 U256/XU9-net12 n203 U256/XU9-net9 VDD pmos W=0.41u L=0.04u
M571 n212 n157 U256/XU9-net12 VDD pmos W=0.41u L=0.04u
M572 U256/net12 n216 VDD VDD pmos W=0.31u L=0.04u
M573 n203 n155 VSS VSS nmos W=0.135u L=0.04u
M574 n203 n155 VDD VDD pmos W=0.205u L=0.04u
M575 U258/net4 U258/net10 U258/net14 VSS nmos W=0.155u L=0.04u
M576 U258/net6 G4 U258/net14 VSS nmos W=0.155u L=0.04u
M577 U258/net4 n217 VSS VSS nmos W=0.155u L=0.04u
M578 U258/net6 U258/net4 VSS VSS nmos W=0.155u L=0.04u
M579 N387 U258/net14 VSS VSS nmos W=0.155u L=0.04u
M580 U258/net10 G4 VSS VSS nmos W=0.155u L=0.04u
M581 U258/net4 G4 U258/net14 VDD pmos W=0.205u L=0.04u
M582 U258/net6 U258/net10 U258/net14 VDD pmos W=0.205u L=0.04u
M583 U258/net4 n217 VDD VDD pmos W=0.205u L=0.04u
M584 U258/net6 U258/net4 VDD VDD pmos W=0.205u L=0.04u
M585 N387 U258/net14 VDD VDD pmos W=0.205u L=0.04u
M586 U258/net10 G4 VDD VDD pmos W=0.205u L=0.04u
M587 U259/XU1-net6 n170 VSS VSS nmos W=0.155u L=0.04u
M588 n217 n218 U259/XU1-net6 VSS nmos W=0.155u L=0.04u
M589 n217 n170 VDD VDD pmos W=0.155u L=0.04u
M590 n217 n218 VDD VDD pmos W=0.155u L=0.04u
M591 U260/net4 U260/net10 U260/net14 VSS nmos W=0.155u L=0.04u
M592 U260/net6 G3 U260/net14 VSS nmos W=0.155u L=0.04u
M593 U260/net4 n219 VSS VSS nmos W=0.155u L=0.04u
M594 U260/net6 U260/net4 VSS VSS nmos W=0.155u L=0.04u
M595 N386 U260/net14 VSS VSS nmos W=0.155u L=0.04u
M596 U260/net10 G3 VSS VSS nmos W=0.155u L=0.04u
M597 U260/net4 G3 U260/net14 VDD pmos W=0.205u L=0.04u
M598 U260/net6 U260/net10 U260/net14 VDD pmos W=0.205u L=0.04u
M599 U260/net4 n219 VDD VDD pmos W=0.205u L=0.04u
M600 U260/net6 U260/net4 VDD VDD pmos W=0.205u L=0.04u
M601 N386 U260/net14 VDD VDD pmos W=0.205u L=0.04u
M602 U260/net10 G3 VDD VDD pmos W=0.205u L=0.04u
M603 U261/XU1-net6 n164 VSS VSS nmos W=0.155u L=0.04u
M604 n219 n218 U261/XU1-net6 VSS nmos W=0.155u L=0.04u
M605 n219 n164 VDD VDD pmos W=0.155u L=0.04u
M606 n219 n218 VDD VDD pmos W=0.155u L=0.04u
M607 U262/net4 U262/net10 U262/net14 VSS nmos W=0.155u L=0.04u
M608 U262/net6 G2 U262/net14 VSS nmos W=0.155u L=0.04u
M609 U262/net4 n220 VSS VSS nmos W=0.155u L=0.04u
M610 U262/net6 U262/net4 VSS VSS nmos W=0.155u L=0.04u
M611 N385 U262/net14 VSS VSS nmos W=0.155u L=0.04u
M612 U262/net10 G2 VSS VSS nmos W=0.155u L=0.04u
M613 U262/net4 G2 U262/net14 VDD pmos W=0.205u L=0.04u
M614 U262/net6 U262/net10 U262/net14 VDD pmos W=0.205u L=0.04u
M615 U262/net4 n220 VDD VDD pmos W=0.205u L=0.04u
M616 U262/net6 U262/net4 VDD VDD pmos W=0.205u L=0.04u
M617 N385 U262/net14 VDD VDD pmos W=0.205u L=0.04u
M618 U262/net10 G2 VDD VDD pmos W=0.205u L=0.04u
M619 U263/XU1-net6 n200 VSS VSS nmos W=0.155u L=0.04u
M620 n220 n218 U263/XU1-net6 VSS nmos W=0.155u L=0.04u
M621 n220 n200 VDD VDD pmos W=0.155u L=0.04u
M622 n220 n218 VDD VDD pmos W=0.155u L=0.04u
M623 U264/net4 U264/net10 U264/net14 VSS nmos W=0.155u L=0.04u
M624 U264/net6 G1 U264/net14 VSS nmos W=0.155u L=0.04u
M625 U264/net4 n221 VSS VSS nmos W=0.155u L=0.04u
M626 U264/net6 U264/net4 VSS VSS nmos W=0.155u L=0.04u
M627 N384 U264/net14 VSS VSS nmos W=0.155u L=0.04u
M628 U264/net10 G1 VSS VSS nmos W=0.155u L=0.04u
M629 U264/net4 G1 U264/net14 VDD pmos W=0.205u L=0.04u
M630 U264/net6 U264/net10 U264/net14 VDD pmos W=0.205u L=0.04u
M631 U264/net4 n221 VDD VDD pmos W=0.205u L=0.04u
M632 U264/net6 U264/net4 VDD VDD pmos W=0.205u L=0.04u
M633 N384 U264/net14 VDD VDD pmos W=0.205u L=0.04u
M634 U264/net10 G1 VDD VDD pmos W=0.205u L=0.04u
M635 U265/XU1-net6 n173 VSS VSS nmos W=0.155u L=0.04u
M636 n221 n218 U265/XU1-net6 VSS nmos W=0.155u L=0.04u
M637 n221 n173 VDD VDD pmos W=0.155u L=0.04u
M638 n221 n218 VDD VDD pmos W=0.155u L=0.04u
M639 n218 n155 VSS VSS nmos W=0.155u L=0.04u
M640 n218 n209 VSS VSS nmos W=0.155u L=0.04u
M641 n218 U266/net12 VSS VSS nmos W=0.155u L=0.04u
M642 U266/net12 n216 VSS VSS nmos W=0.155u L=0.04u
M643 U266/XU9-net9 U266/net12 VDD VDD pmos W=0.41u L=0.04u
M644 U266/XU9-net12 n209 U266/XU9-net9 VDD pmos W=0.41u L=0.04u
M645 n218 n155 U266/XU9-net12 VDD pmos W=0.41u L=0.04u
M646 U266/net12 n216 VDD VDD pmos W=0.31u L=0.04u
M647 U267/net19 n195 VSS VSS nmos W=0.155u L=0.04u
M648 n155 n195 U267/net40 VSS nmos W=0.155u L=0.04u
M649 n155 U267/net19 U267/net36 VSS nmos W=0.155u L=0.04u
M650 U267/net40 n193 VSS VSS nmos W=0.31u L=0.04u
M651 U267/net36 n194 VSS VSS nmos W=0.155u L=0.04u
M652 U267/net19 n195 VDD VDD pmos W=0.205u L=0.04u
M653 n155 U267/net19 U267/net26 VDD pmos W=0.325u L=0.04u
M654 U267/net26 n193 VDD VDD pmos W=0.41u L=0.04u
M655 n155 n195 U267/net30 VDD pmos W=0.325u L=0.04u
M656 U267/net30 n194 VDD VDD pmos W=0.205u L=0.04u
M657 U268/net28 U268/net20 U268/net64 VSS nmos W=0.155u L=0.04u
M658 U268/net24 U268/net30 U268/net32 VSS nmos W=0.155u L=0.04u
M659 U268/net28 U268/net40 U268/net24 VSS nmos W=0.155u L=0.04u
M660 U268/net40 G28 U268/net108 VSS nmos W=0.155u L=0.04u
M661 U268/net40 U268/net106 U268/net104 VSS nmos W=0.155u L=0.04u
M662 U268/net24 G24 U268/net050 VSS nmos W=0.155u L=0.04u
M663 U268/net050 U268/net32 VSS VSS nmos W=0.155u L=0.04u
M664 U268/net20 U268/net40 VSS VSS nmos W=0.155u L=0.04u
M665 U268/net106 G28 VSS VSS nmos W=0.155u L=0.04u
M666 U268/net104 G32 VSS VSS nmos W=0.155u L=0.04u
M667 U268/net30 G24 VSS VSS nmos W=0.155u L=0.04u
M668 U268/net108 U268/net104 VSS VSS nmos W=0.155u L=0.04u
M669 n195 U268/net28 VSS VSS nmos W=0.155u L=0.04u
M670 U268/net32 G20 VSS VSS nmos W=0.155u L=0.04u
M671 U268/net64 U268/net24 VSS VSS nmos W=0.2u L=0.04u
M672 U268/net28 U268/net40 U268/net64 VDD pmos W=0.205u L=0.04u
M673 U268/net24 G24 U268/net32 VDD pmos W=0.205u L=0.04u
M674 U268/net28 U268/net20 U268/net24 VDD pmos W=0.205u L=0.04u
M675 U268/net40 U268/net106 U268/net108 VDD pmos W=0.205u L=0.04u
M676 U268/net40 G28 U268/net104 VDD pmos W=0.205u L=0.04u
M677 U268/net20 U268/net40 VDD VDD pmos W=0.205u L=0.04u
M678 U268/net106 G28 VDD VDD pmos W=0.205u L=0.04u
M679 U268/net104 G32 VDD VDD pmos W=0.205u L=0.04u
M680 U268/net30 G24 VDD VDD pmos W=0.205u L=0.04u
M681 U268/net108 U268/net104 VDD VDD pmos W=0.205u L=0.04u
M682 n195 U268/net28 VDD VDD pmos W=0.205u L=0.04u
M683 U268/net32 G20 VDD VDD pmos W=0.205u L=0.04u
M684 U268/net64 U268/net24 VDD VDD pmos W=0.28u L=0.04u
M685 U268/net24 U268/net30 U268/net045 VDD pmos W=0.205u L=0.04u
M686 U268/net045 U268/net32 VDD VDD pmos W=0.205u L=0.04u
M687 n193 n222 VSS VSS nmos W=0.155u L=0.04u
M688 n193 n223 VSS VSS nmos W=0.155u L=0.04u
M689 U269/XI1-net8 n223 VDD VDD pmos W=0.205u L=0.04u
M690 n193 n222 U269/XI1-net8 VDD pmos W=0.205u L=0.04u
M691 n222 n224 VSS VSS nmos W=0.135u L=0.04u
M692 n222 n224 VDD VDD pmos W=0.205u L=0.04u
M693 U271/XU1-net6 n224 VSS VSS nmos W=0.155u L=0.04u
M694 n194 n225 U271/XU1-net6 VSS nmos W=0.155u L=0.04u
M695 n194 n224 VDD VDD pmos W=0.155u L=0.04u
M696 n194 n225 VDD VDD pmos W=0.155u L=0.04u
M697 n224 G41 U272/XI0-net10 VSS nmos W=0.155u L=0.04u
M698 U272/XI0-net10 n226 U272/XI0-net13 VSS nmos W=0.155u L=0.04u
M699 U272/XI0-net13 G40 VSS VSS nmos W=0.155u L=0.04u
M700 n224 G40 VDD VDD pmos W=0.205u L=0.04u
M701 n224 G41 VDD VDD pmos W=0.205u L=0.04u
M702 n224 n226 VDD VDD pmos W=0.205u L=0.04u
M703 n225 n223 VSS VSS nmos W=0.135u L=0.04u
M704 n225 n223 VDD VDD pmos W=0.205u L=0.04u
M705 n223 G41 U274/net27 VSS nmos W=0.155u L=0.04u
M706 U274/net27 G40 VSS VSS nmos W=0.155u L=0.04u
M707 n223 n226 VSS VSS nmos W=0.155u L=0.04u
M708 n223 G40 U274/net13 VDD pmos W=0.205u L=0.04u
M709 U274/net13 n226 VDD VDD pmos W=0.205u L=0.04u
M710 n223 G41 U274/net13 VDD pmos W=0.205u L=0.04u
M711 U275/net4 U275/net10 U275/net14 VSS nmos W=0.155u L=0.04u
M712 U275/net6 n227 U275/net14 VSS nmos W=0.155u L=0.04u
M713 U275/net4 n228 VSS VSS nmos W=0.155u L=0.04u
M714 U275/net6 U275/net4 VSS VSS nmos W=0.155u L=0.04u
M715 n226 U275/net14 VSS VSS nmos W=0.155u L=0.04u
M716 U275/net10 n227 VSS VSS nmos W=0.155u L=0.04u
M717 U275/net4 n227 U275/net14 VDD pmos W=0.205u L=0.04u
M718 U275/net6 U275/net10 U275/net14 VDD pmos W=0.205u L=0.04u
M719 U275/net4 n228 VDD VDD pmos W=0.205u L=0.04u
M720 U275/net6 U275/net4 VDD VDD pmos W=0.205u L=0.04u
M721 n226 U275/net14 VDD VDD pmos W=0.205u L=0.04u
M722 U275/net10 n227 VDD VDD pmos W=0.205u L=0.04u
M723 n209 n157 VSS VSS nmos W=0.135u L=0.04u
M724 n209 n157 VDD VDD pmos W=0.205u L=0.04u
M725 U277/net19 n192 VSS VSS nmos W=0.155u L=0.04u
M726 n157 n192 U277/net40 VSS nmos W=0.155u L=0.04u
M727 n157 U277/net19 U277/net36 VSS nmos W=0.155u L=0.04u
M728 U277/net40 n190 VSS VSS nmos W=0.31u L=0.04u
M729 U277/net36 n191 VSS VSS nmos W=0.155u L=0.04u
M730 U277/net19 n192 VDD VDD pmos W=0.205u L=0.04u
M731 n157 U277/net19 U277/net26 VDD pmos W=0.325u L=0.04u
M732 U277/net26 n190 VDD VDD pmos W=0.41u L=0.04u
M733 n157 n192 U277/net30 VDD pmos W=0.325u L=0.04u
M734 U277/net30 n191 VDD VDD pmos W=0.205u L=0.04u
M735 U278/net28 U278/net20 U278/net64 VSS nmos W=0.155u L=0.04u
M736 U278/net24 U278/net30 U278/net32 VSS nmos W=0.155u L=0.04u
M737 U278/net28 U278/net40 U278/net24 VSS nmos W=0.155u L=0.04u
M738 U278/net40 G27 U278/net108 VSS nmos W=0.155u L=0.04u
M739 U278/net40 U278/net106 U278/net104 VSS nmos W=0.155u L=0.04u
M740 U278/net24 G23 U278/net050 VSS nmos W=0.155u L=0.04u
M741 U278/net050 U278/net32 VSS VSS nmos W=0.155u L=0.04u
M742 U278/net20 U278/net40 VSS VSS nmos W=0.155u L=0.04u
M743 U278/net106 G27 VSS VSS nmos W=0.155u L=0.04u
M744 U278/net104 G31 VSS VSS nmos W=0.155u L=0.04u
M745 U278/net30 G23 VSS VSS nmos W=0.155u L=0.04u
M746 U278/net108 U278/net104 VSS VSS nmos W=0.155u L=0.04u
M747 n192 U278/net28 VSS VSS nmos W=0.155u L=0.04u
M748 U278/net32 G19 VSS VSS nmos W=0.155u L=0.04u
M749 U278/net64 U278/net24 VSS VSS nmos W=0.2u L=0.04u
M750 U278/net28 U278/net40 U278/net64 VDD pmos W=0.205u L=0.04u
M751 U278/net24 G23 U278/net32 VDD pmos W=0.205u L=0.04u
M752 U278/net28 U278/net20 U278/net24 VDD pmos W=0.205u L=0.04u
M753 U278/net40 U278/net106 U278/net108 VDD pmos W=0.205u L=0.04u
M754 U278/net40 G27 U278/net104 VDD pmos W=0.205u L=0.04u
M755 U278/net20 U278/net40 VDD VDD pmos W=0.205u L=0.04u
M756 U278/net106 G27 VDD VDD pmos W=0.205u L=0.04u
M757 U278/net104 G31 VDD VDD pmos W=0.205u L=0.04u
M758 U278/net30 G23 VDD VDD pmos W=0.205u L=0.04u
M759 U278/net108 U278/net104 VDD VDD pmos W=0.205u L=0.04u
M760 n192 U278/net28 VDD VDD pmos W=0.205u L=0.04u
M761 U278/net32 G19 VDD VDD pmos W=0.205u L=0.04u
M762 U278/net64 U278/net24 VDD VDD pmos W=0.28u L=0.04u
M763 U278/net24 U278/net30 U278/net045 VDD pmos W=0.205u L=0.04u
M764 U278/net045 U278/net32 VDD VDD pmos W=0.205u L=0.04u
M765 n190 n229 VSS VSS nmos W=0.155u L=0.04u
M766 n190 n230 VSS VSS nmos W=0.155u L=0.04u
M767 U279/XI1-net8 n230 VDD VDD pmos W=0.205u L=0.04u
M768 n190 n229 U279/XI1-net8 VDD pmos W=0.205u L=0.04u
M769 n229 n231 VSS VSS nmos W=0.135u L=0.04u
M770 n229 n231 VDD VDD pmos W=0.205u L=0.04u
M771 U281/XU1-net6 n231 VSS VSS nmos W=0.155u L=0.04u
M772 n191 n232 U281/XU1-net6 VSS nmos W=0.155u L=0.04u
M773 n191 n231 VDD VDD pmos W=0.155u L=0.04u
M774 n191 n232 VDD VDD pmos W=0.155u L=0.04u
M775 n231 G39 U282/XI0-net10 VSS nmos W=0.155u L=0.04u
M776 U282/XI0-net10 n233 U282/XI0-net13 VSS nmos W=0.155u L=0.04u
M777 U282/XI0-net13 G41 VSS VSS nmos W=0.155u L=0.04u
M778 n231 G41 VDD VDD pmos W=0.205u L=0.04u
M779 n231 G39 VDD VDD pmos W=0.205u L=0.04u
M780 n231 n233 VDD VDD pmos W=0.205u L=0.04u
M781 n232 n230 VSS VSS nmos W=0.135u L=0.04u
M782 n232 n230 VDD VDD pmos W=0.205u L=0.04u
M783 n230 G39 U284/net27 VSS nmos W=0.155u L=0.04u
M784 U284/net27 G41 VSS VSS nmos W=0.155u L=0.04u
M785 n230 n233 VSS VSS nmos W=0.155u L=0.04u
M786 n230 G41 U284/net13 VDD pmos W=0.205u L=0.04u
M787 U284/net13 n233 VDD VDD pmos W=0.205u L=0.04u
M788 n230 G39 U284/net13 VDD pmos W=0.205u L=0.04u
M789 U285/net4 U285/net10 U285/net14 VSS nmos W=0.155u L=0.04u
M790 U285/net6 n234 U285/net14 VSS nmos W=0.155u L=0.04u
M791 U285/net4 n235 VSS VSS nmos W=0.155u L=0.04u
M792 U285/net6 U285/net4 VSS VSS nmos W=0.155u L=0.04u
M793 n233 U285/net14 VSS VSS nmos W=0.155u L=0.04u
M794 U285/net10 n234 VSS VSS nmos W=0.155u L=0.04u
M795 U285/net4 n234 U285/net14 VDD pmos W=0.205u L=0.04u
M796 U285/net6 U285/net10 U285/net14 VDD pmos W=0.205u L=0.04u
M797 U285/net4 n235 VDD VDD pmos W=0.205u L=0.04u
M798 U285/net6 U285/net4 VDD VDD pmos W=0.205u L=0.04u
M799 n233 U285/net14 VDD VDD pmos W=0.205u L=0.04u
M800 U285/net10 n234 VDD VDD pmos W=0.205u L=0.04u
M801 n216 n187 VSS VSS nmos W=0.155u L=0.04u
M802 n216 n159 VSS VSS nmos W=0.155u L=0.04u
M803 n216 U286/net12 VSS VSS nmos W=0.155u L=0.04u
M804 U286/net12 n210 VSS VSS nmos W=0.155u L=0.04u
M805 U286/XU9-net9 U286/net12 VDD VDD pmos W=0.41u L=0.04u
M806 U286/XU9-net12 n159 U286/XU9-net9 VDD pmos W=0.41u L=0.04u
M807 n216 n187 U286/XU9-net12 VDD pmos W=0.41u L=0.04u
M808 U286/net12 n210 VDD VDD pmos W=0.31u L=0.04u
M809 n187 n161 VSS VSS nmos W=0.135u L=0.04u
M810 n187 n161 VDD VDD pmos W=0.205u L=0.04u
M811 U288/net19 n238 VSS VSS nmos W=0.155u L=0.04u
M812 n161 n238 U288/net40 VSS nmos W=0.155u L=0.04u
M813 n161 U288/net19 U288/net36 VSS nmos W=0.155u L=0.04u
M814 U288/net40 n237 VSS VSS nmos W=0.31u L=0.04u
M815 U288/net36 n236 VSS VSS nmos W=0.155u L=0.04u
M816 U288/net19 n238 VDD VDD pmos W=0.205u L=0.04u
M817 n161 U288/net19 U288/net26 VDD pmos W=0.325u L=0.04u
M818 U288/net26 n237 VDD VDD pmos W=0.41u L=0.04u
M819 n161 n238 U288/net30 VDD pmos W=0.325u L=0.04u
M820 U288/net30 n236 VDD VDD pmos W=0.205u L=0.04u
M821 U289/net28 U289/net20 U289/net64 VSS nmos W=0.155u L=0.04u
M822 U289/net24 U289/net30 U289/net32 VSS nmos W=0.155u L=0.04u
M823 U289/net28 U289/net40 U289/net24 VSS nmos W=0.155u L=0.04u
M824 U289/net40 G25 U289/net108 VSS nmos W=0.155u L=0.04u
M825 U289/net40 U289/net106 U289/net104 VSS nmos W=0.155u L=0.04u
M826 U289/net24 G21 U289/net050 VSS nmos W=0.155u L=0.04u
M827 U289/net050 U289/net32 VSS VSS nmos W=0.155u L=0.04u
M828 U289/net20 U289/net40 VSS VSS nmos W=0.155u L=0.04u
M829 U289/net106 G25 VSS VSS nmos W=0.155u L=0.04u
M830 U289/net104 G29 VSS VSS nmos W=0.155u L=0.04u
M831 U289/net30 G21 VSS VSS nmos W=0.155u L=0.04u
M832 U289/net108 U289/net104 VSS VSS nmos W=0.155u L=0.04u
M833 n238 U289/net28 VSS VSS nmos W=0.155u L=0.04u
M834 U289/net32 G17 VSS VSS nmos W=0.155u L=0.04u
M835 U289/net64 U289/net24 VSS VSS nmos W=0.2u L=0.04u
M836 U289/net28 U289/net40 U289/net64 VDD pmos W=0.205u L=0.04u
M837 U289/net24 G21 U289/net32 VDD pmos W=0.205u L=0.04u
M838 U289/net28 U289/net20 U289/net24 VDD pmos W=0.205u L=0.04u
M839 U289/net40 U289/net106 U289/net108 VDD pmos W=0.205u L=0.04u
M840 U289/net40 G25 U289/net104 VDD pmos W=0.205u L=0.04u
M841 U289/net20 U289/net40 VDD VDD pmos W=0.205u L=0.04u
M842 U289/net106 G25 VDD VDD pmos W=0.205u L=0.04u
M843 U289/net104 G29 VDD VDD pmos W=0.205u L=0.04u
M844 U289/net30 G21 VDD VDD pmos W=0.205u L=0.04u
M845 U289/net108 U289/net104 VDD VDD pmos W=0.205u L=0.04u
M846 n238 U289/net28 VDD VDD pmos W=0.205u L=0.04u
M847 U289/net32 G17 VDD VDD pmos W=0.205u L=0.04u
M848 U289/net64 U289/net24 VDD VDD pmos W=0.28u L=0.04u
M849 U289/net24 U289/net30 U289/net045 VDD pmos W=0.205u L=0.04u
M850 U289/net045 U289/net32 VDD VDD pmos W=0.205u L=0.04u
M851 n237 n240 VSS VSS nmos W=0.155u L=0.04u
M852 n237 U290/net4 VSS VSS nmos W=0.155u L=0.04u
M853 U290/net4 n239 VSS VSS nmos W=0.155u L=0.04u
M854 U290/XU1-net8 U290/net4 VDD VDD pmos W=0.205u L=0.04u
M855 n237 n240 U290/XU1-net8 VDD pmos W=0.205u L=0.04u
M856 U290/net4 n239 VDD VDD pmos W=0.205u L=0.04u
M857 U291/net13 n240 VSS VSS nmos W=0.155u L=0.04u
M858 U291/net16 U291/net13 VSS VSS nmos W=0.155u L=0.04u
M859 n236 n239 U291/net16 VSS nmos W=0.155u L=0.04u
M860 U291/net13 n240 VDD VDD pmos W=0.205u L=0.04u
M861 VDD U291/net13 n236 VDD pmos W=0.205u L=0.04u
M862 VDD n239 n236 VDD pmos W=0.205u L=0.04u
M863 n239 G41 U292/XI0-net10 VSS nmos W=0.155u L=0.04u
M864 U292/XI0-net10 n241 U292/XI0-net13 VSS nmos W=0.155u L=0.04u
M865 U292/XI0-net13 G37 VSS VSS nmos W=0.155u L=0.04u
M866 n239 G37 VDD VDD pmos W=0.205u L=0.04u
M867 n239 G41 VDD VDD pmos W=0.205u L=0.04u
M868 n239 n241 VDD VDD pmos W=0.205u L=0.04u
M869 n240 G41 U293/net27 VSS nmos W=0.155u L=0.04u
M870 U293/net27 G37 VSS VSS nmos W=0.155u L=0.04u
M871 n240 n241 VSS VSS nmos W=0.155u L=0.04u
M872 n240 G37 U293/net13 VDD pmos W=0.205u L=0.04u
M873 U293/net13 n241 VDD VDD pmos W=0.205u L=0.04u
M874 n240 G41 U293/net13 VDD pmos W=0.205u L=0.04u
M875 U294/net4 U294/net10 U294/net14 VSS nmos W=0.155u L=0.04u
M876 U294/net6 n227 U294/net14 VSS nmos W=0.155u L=0.04u
M877 U294/net4 n234 VSS VSS nmos W=0.155u L=0.04u
M878 U294/net6 U294/net4 VSS VSS nmos W=0.155u L=0.04u
M879 n241 U294/net14 VSS VSS nmos W=0.155u L=0.04u
M880 U294/net10 n227 VSS VSS nmos W=0.155u L=0.04u
M881 U294/net4 n227 U294/net14 VDD pmos W=0.205u L=0.04u
M882 U294/net6 U294/net10 U294/net14 VDD pmos W=0.205u L=0.04u
M883 U294/net4 n234 VDD VDD pmos W=0.205u L=0.04u
M884 U294/net6 U294/net4 VDD VDD pmos W=0.205u L=0.04u
M885 n241 U294/net14 VDD VDD pmos W=0.205u L=0.04u
M886 U294/net10 n227 VDD VDD pmos W=0.205u L=0.04u
M887 U295/net28 U295/net20 U295/net64 VSS nmos W=0.155u L=0.04u
M888 U295/net24 U295/net30 U295/net32 VSS nmos W=0.155u L=0.04u
M889 U295/net28 U295/net40 U295/net24 VSS nmos W=0.155u L=0.04u
M890 U295/net40 G2 U295/net108 VSS nmos W=0.155u L=0.04u
M891 U295/net40 U295/net106 U295/net104 VSS nmos W=0.155u L=0.04u
M892 U295/net24 G4 U295/net050 VSS nmos W=0.155u L=0.04u
M893 U295/net050 U295/net32 VSS VSS nmos W=0.155u L=0.04u
M894 U295/net20 U295/net40 VSS VSS nmos W=0.155u L=0.04u
M895 U295/net106 G2 VSS VSS nmos W=0.155u L=0.04u
M896 U295/net104 G1 VSS VSS nmos W=0.155u L=0.04u
M897 U295/net30 G4 VSS VSS nmos W=0.155u L=0.04u
M898 U295/net108 U295/net104 VSS VSS nmos W=0.155u L=0.04u
M899 n234 U295/net28 VSS VSS nmos W=0.155u L=0.04u
M900 U295/net32 G3 VSS VSS nmos W=0.155u L=0.04u
M901 U295/net64 U295/net24 VSS VSS nmos W=0.2u L=0.04u
M902 U295/net28 U295/net40 U295/net64 VDD pmos W=0.205u L=0.04u
M903 U295/net24 G4 U295/net32 VDD pmos W=0.205u L=0.04u
M904 U295/net28 U295/net20 U295/net24 VDD pmos W=0.205u L=0.04u
M905 U295/net40 U295/net106 U295/net108 VDD pmos W=0.205u L=0.04u
M906 U295/net40 G2 U295/net104 VDD pmos W=0.205u L=0.04u
M907 U295/net20 U295/net40 VDD VDD pmos W=0.205u L=0.04u
M908 U295/net106 G2 VDD VDD pmos W=0.205u L=0.04u
M909 U295/net104 G1 VDD VDD pmos W=0.205u L=0.04u
M910 U295/net30 G4 VDD VDD pmos W=0.205u L=0.04u
M911 U295/net108 U295/net104 VDD VDD pmos W=0.205u L=0.04u
M912 n234 U295/net28 VDD VDD pmos W=0.205u L=0.04u
M913 U295/net32 G3 VDD VDD pmos W=0.205u L=0.04u
M914 U295/net64 U295/net24 VDD VDD pmos W=0.28u L=0.04u
M915 U295/net24 U295/net30 U295/net045 VDD pmos W=0.205u L=0.04u
M916 U295/net045 U295/net32 VDD VDD pmos W=0.205u L=0.04u
M917 U296/net28 U296/net20 U296/net64 VSS nmos W=0.155u L=0.04u
M918 U296/net24 U296/net30 U296/net32 VSS nmos W=0.155u L=0.04u
M919 U296/net28 U296/net40 U296/net24 VSS nmos W=0.155u L=0.04u
M920 U296/net40 G6 U296/net108 VSS nmos W=0.155u L=0.04u
M921 U296/net40 U296/net106 U296/net104 VSS nmos W=0.155u L=0.04u
M922 U296/net24 G8 U296/net050 VSS nmos W=0.155u L=0.04u
M923 U296/net050 U296/net32 VSS VSS nmos W=0.155u L=0.04u
M924 U296/net20 U296/net40 VSS VSS nmos W=0.155u L=0.04u
M925 U296/net106 G6 VSS VSS nmos W=0.155u L=0.04u
M926 U296/net104 G5 VSS VSS nmos W=0.155u L=0.04u
M927 U296/net30 G8 VSS VSS nmos W=0.155u L=0.04u
M928 U296/net108 U296/net104 VSS VSS nmos W=0.155u L=0.04u
M929 n227 U296/net28 VSS VSS nmos W=0.155u L=0.04u
M930 U296/net32 G7 VSS VSS nmos W=0.155u L=0.04u
M931 U296/net64 U296/net24 VSS VSS nmos W=0.2u L=0.04u
M932 U296/net28 U296/net40 U296/net64 VDD pmos W=0.205u L=0.04u
M933 U296/net24 G8 U296/net32 VDD pmos W=0.205u L=0.04u
M934 U296/net28 U296/net20 U296/net24 VDD pmos W=0.205u L=0.04u
M935 U296/net40 U296/net106 U296/net108 VDD pmos W=0.205u L=0.04u
M936 U296/net40 G6 U296/net104 VDD pmos W=0.205u L=0.04u
M937 U296/net20 U296/net40 VDD VDD pmos W=0.205u L=0.04u
M938 U296/net106 G6 VDD VDD pmos W=0.205u L=0.04u
M939 U296/net104 G5 VDD VDD pmos W=0.205u L=0.04u
M940 U296/net30 G8 VDD VDD pmos W=0.205u L=0.04u
M941 U296/net108 U296/net104 VDD VDD pmos W=0.205u L=0.04u
M942 n227 U296/net28 VDD VDD pmos W=0.205u L=0.04u
M943 U296/net32 G7 VDD VDD pmos W=0.205u L=0.04u
M944 U296/net64 U296/net24 VDD VDD pmos W=0.28u L=0.04u
M945 U296/net24 U296/net30 U296/net045 VDD pmos W=0.205u L=0.04u
M946 U296/net045 U296/net32 VDD VDD pmos W=0.205u L=0.04u
M947 U297/net19 n244 VSS VSS nmos W=0.155u L=0.04u
M948 n159 n244 U297/net40 VSS nmos W=0.155u L=0.04u
M949 n159 U297/net19 U297/net36 VSS nmos W=0.155u L=0.04u
M950 U297/net40 n243 VSS VSS nmos W=0.31u L=0.04u
M951 U297/net36 n242 VSS VSS nmos W=0.155u L=0.04u
M952 U297/net19 n244 VDD VDD pmos W=0.205u L=0.04u
M953 n159 U297/net19 U297/net26 VDD pmos W=0.325u L=0.04u
M954 U297/net26 n243 VDD VDD pmos W=0.41u L=0.04u
M955 n159 n244 U297/net30 VDD pmos W=0.325u L=0.04u
M956 U297/net30 n242 VDD VDD pmos W=0.205u L=0.04u
M957 U298/net28 U298/net20 U298/net64 VSS nmos W=0.155u L=0.04u
M958 U298/net24 U298/net30 U298/net32 VSS nmos W=0.155u L=0.04u
M959 U298/net28 U298/net40 U298/net24 VSS nmos W=0.155u L=0.04u
M960 U298/net40 G26 U298/net108 VSS nmos W=0.155u L=0.04u
M961 U298/net40 U298/net106 U298/net104 VSS nmos W=0.155u L=0.04u
M962 U298/net24 G22 U298/net050 VSS nmos W=0.155u L=0.04u
M963 U298/net050 U298/net32 VSS VSS nmos W=0.155u L=0.04u
M964 U298/net20 U298/net40 VSS VSS nmos W=0.155u L=0.04u
M965 U298/net106 G26 VSS VSS nmos W=0.155u L=0.04u
M966 U298/net104 G30 VSS VSS nmos W=0.155u L=0.04u
M967 U298/net30 G22 VSS VSS nmos W=0.155u L=0.04u
M968 U298/net108 U298/net104 VSS VSS nmos W=0.155u L=0.04u
M969 n244 U298/net28 VSS VSS nmos W=0.155u L=0.04u
M970 U298/net32 G18 VSS VSS nmos W=0.155u L=0.04u
M971 U298/net64 U298/net24 VSS VSS nmos W=0.2u L=0.04u
M972 U298/net28 U298/net40 U298/net64 VDD pmos W=0.205u L=0.04u
M973 U298/net24 G22 U298/net32 VDD pmos W=0.205u L=0.04u
M974 U298/net28 U298/net20 U298/net24 VDD pmos W=0.205u L=0.04u
M975 U298/net40 U298/net106 U298/net108 VDD pmos W=0.205u L=0.04u
M976 U298/net40 G26 U298/net104 VDD pmos W=0.205u L=0.04u
M977 U298/net20 U298/net40 VDD VDD pmos W=0.205u L=0.04u
M978 U298/net106 G26 VDD VDD pmos W=0.205u L=0.04u
M979 U298/net104 G30 VDD VDD pmos W=0.205u L=0.04u
M980 U298/net30 G22 VDD VDD pmos W=0.205u L=0.04u
M981 U298/net108 U298/net104 VDD VDD pmos W=0.205u L=0.04u
M982 n244 U298/net28 VDD VDD pmos W=0.205u L=0.04u
M983 U298/net32 G18 VDD VDD pmos W=0.205u L=0.04u
M984 U298/net64 U298/net24 VDD VDD pmos W=0.28u L=0.04u
M985 U298/net24 U298/net30 U298/net045 VDD pmos W=0.205u L=0.04u
M986 U298/net045 U298/net32 VDD VDD pmos W=0.205u L=0.04u
M987 n243 n246 VSS VSS nmos W=0.155u L=0.04u
M988 n243 U299/net4 VSS VSS nmos W=0.155u L=0.04u
M989 U299/net4 n245 VSS VSS nmos W=0.155u L=0.04u
M990 U299/XU1-net8 U299/net4 VDD VDD pmos W=0.205u L=0.04u
M991 n243 n246 U299/XU1-net8 VDD pmos W=0.205u L=0.04u
M992 U299/net4 n245 VDD VDD pmos W=0.205u L=0.04u
M993 U300/net13 n246 VSS VSS nmos W=0.155u L=0.04u
M994 U300/net16 U300/net13 VSS VSS nmos W=0.155u L=0.04u
M995 n242 n245 U300/net16 VSS nmos W=0.155u L=0.04u
M996 U300/net13 n246 VDD VDD pmos W=0.205u L=0.04u
M997 VDD U300/net13 n242 VDD pmos W=0.205u L=0.04u
M998 VDD n245 n242 VDD pmos W=0.205u L=0.04u
M999 n245 G41 U301/XI0-net10 VSS nmos W=0.155u L=0.04u
M1000 U301/XI0-net10 n247 U301/XI0-net13 VSS nmos W=0.155u L=0.04u
M1001 U301/XI0-net13 G38 VSS VSS nmos W=0.155u L=0.04u
M1002 n245 G38 VDD VDD pmos W=0.205u L=0.04u
M1003 n245 G41 VDD VDD pmos W=0.205u L=0.04u
M1004 n245 n247 VDD VDD pmos W=0.205u L=0.04u
M1005 n246 G41 U302/net27 VSS nmos W=0.155u L=0.04u
M1006 U302/net27 G38 VSS VSS nmos W=0.155u L=0.04u
M1007 n246 n247 VSS VSS nmos W=0.155u L=0.04u
M1008 n246 G38 U302/net13 VDD pmos W=0.205u L=0.04u
M1009 U302/net13 n247 VDD VDD pmos W=0.205u L=0.04u
M1010 n246 G41 U302/net13 VDD pmos W=0.205u L=0.04u
M1011 U303/net4 U303/net10 U303/net14 VSS nmos W=0.155u L=0.04u
M1012 U303/net6 n228 U303/net14 VSS nmos W=0.155u L=0.04u
M1013 U303/net4 n235 VSS VSS nmos W=0.155u L=0.04u
M1014 U303/net6 U303/net4 VSS VSS nmos W=0.155u L=0.04u
M1015 n247 U303/net14 VSS VSS nmos W=0.155u L=0.04u
M1016 U303/net10 n228 VSS VSS nmos W=0.155u L=0.04u
M1017 U303/net4 n228 U303/net14 VDD pmos W=0.205u L=0.04u
M1018 U303/net6 U303/net10 U303/net14 VDD pmos W=0.205u L=0.04u
M1019 U303/net4 n235 VDD VDD pmos W=0.205u L=0.04u
M1020 U303/net6 U303/net4 VDD VDD pmos W=0.205u L=0.04u
M1021 n247 U303/net14 VDD VDD pmos W=0.205u L=0.04u
M1022 U303/net10 n228 VDD VDD pmos W=0.205u L=0.04u
M1023 U304/net28 U304/net20 U304/net64 VSS nmos W=0.155u L=0.04u
M1024 U304/net24 U304/net30 U304/net32 VSS nmos W=0.155u L=0.04u
M1025 U304/net28 U304/net40 U304/net24 VSS nmos W=0.155u L=0.04u
M1026 U304/net40 G11 U304/net108 VSS nmos W=0.155u L=0.04u
M1027 U304/net40 U304/net106 U304/net104 VSS nmos W=0.155u L=0.04u
M1028 U304/net24 G9 U304/net050 VSS nmos W=0.155u L=0.04u
M1029 U304/net050 U304/net32 VSS VSS nmos W=0.155u L=0.04u
M1030 U304/net20 U304/net40 VSS VSS nmos W=0.155u L=0.04u
M1031 U304/net106 G11 VSS VSS nmos W=0.155u L=0.04u
M1032 U304/net104 G10 VSS VSS nmos W=0.155u L=0.04u
M1033 U304/net30 G9 VSS VSS nmos W=0.155u L=0.04u
M1034 U304/net108 U304/net104 VSS VSS nmos W=0.155u L=0.04u
M1035 n235 U304/net28 VSS VSS nmos W=0.155u L=0.04u
M1036 U304/net32 G12 VSS VSS nmos W=0.155u L=0.04u
M1037 U304/net64 U304/net24 VSS VSS nmos W=0.2u L=0.04u
M1038 U304/net28 U304/net40 U304/net64 VDD pmos W=0.205u L=0.04u
M1039 U304/net24 G9 U304/net32 VDD pmos W=0.205u L=0.04u
M1040 U304/net28 U304/net20 U304/net24 VDD pmos W=0.205u L=0.04u
M1041 U304/net40 U304/net106 U304/net108 VDD pmos W=0.205u L=0.04u
M1042 U304/net40 G11 U304/net104 VDD pmos W=0.205u L=0.04u
M1043 U304/net20 U304/net40 VDD VDD pmos W=0.205u L=0.04u
M1044 U304/net106 G11 VDD VDD pmos W=0.205u L=0.04u
M1045 U304/net104 G10 VDD VDD pmos W=0.205u L=0.04u
M1046 U304/net30 G9 VDD VDD pmos W=0.205u L=0.04u
M1047 U304/net108 U304/net104 VDD VDD pmos W=0.205u L=0.04u
M1048 n235 U304/net28 VDD VDD pmos W=0.205u L=0.04u
M1049 U304/net32 G12 VDD VDD pmos W=0.205u L=0.04u
M1050 U304/net64 U304/net24 VDD VDD pmos W=0.28u L=0.04u
M1051 U304/net24 U304/net30 U304/net045 VDD pmos W=0.205u L=0.04u
M1052 U304/net045 U304/net32 VDD VDD pmos W=0.205u L=0.04u
M1053 U305/net28 U305/net20 U305/net64 VSS nmos W=0.155u L=0.04u
M1054 U305/net24 U305/net30 U305/net32 VSS nmos W=0.155u L=0.04u
M1055 U305/net28 U305/net40 U305/net24 VSS nmos W=0.155u L=0.04u
M1056 U305/net40 G14 U305/net108 VSS nmos W=0.155u L=0.04u
M1057 U305/net40 U305/net106 U305/net104 VSS nmos W=0.155u L=0.04u
M1058 U305/net24 G16 U305/net050 VSS nmos W=0.155u L=0.04u
M1059 U305/net050 U305/net32 VSS VSS nmos W=0.155u L=0.04u
M1060 U305/net20 U305/net40 VSS VSS nmos W=0.155u L=0.04u
M1061 U305/net106 G14 VSS VSS nmos W=0.155u L=0.04u
M1062 U305/net104 G13 VSS VSS nmos W=0.155u L=0.04u
M1063 U305/net30 G16 VSS VSS nmos W=0.155u L=0.04u
M1064 U305/net108 U305/net104 VSS VSS nmos W=0.155u L=0.04u
M1065 n228 U305/net28 VSS VSS nmos W=0.155u L=0.04u
M1066 U305/net32 G15 VSS VSS nmos W=0.155u L=0.04u
M1067 U305/net64 U305/net24 VSS VSS nmos W=0.2u L=0.04u
M1068 U305/net28 U305/net40 U305/net64 VDD pmos W=0.205u L=0.04u
M1069 U305/net24 G16 U305/net32 VDD pmos W=0.205u L=0.04u
M1070 U305/net28 U305/net20 U305/net24 VDD pmos W=0.205u L=0.04u
M1071 U305/net40 U305/net106 U305/net108 VDD pmos W=0.205u L=0.04u
M1072 U305/net40 G14 U305/net104 VDD pmos W=0.205u L=0.04u
M1073 U305/net20 U305/net40 VDD VDD pmos W=0.205u L=0.04u
M1074 U305/net106 G14 VDD VDD pmos W=0.205u L=0.04u
M1075 U305/net104 G13 VDD VDD pmos W=0.205u L=0.04u
M1076 U305/net30 G16 VDD VDD pmos W=0.205u L=0.04u
M1077 U305/net108 U305/net104 VDD VDD pmos W=0.205u L=0.04u
M1078 n228 U305/net28 VDD VDD pmos W=0.205u L=0.04u
M1079 U305/net32 G15 VDD VDD pmos W=0.205u L=0.04u
M1080 U305/net64 U305/net24 VDD VDD pmos W=0.28u L=0.04u
M1081 U305/net24 U305/net30 U305/net045 VDD pmos W=0.205u L=0.04u
M1082 U305/net045 U305/net32 VDD VDD pmos W=0.205u L=0.04u
M1083 n210 n164 U306/net14 VSS nmos W=0.155u L=0.04u
M1084 U306/net14 n173 VSS VSS nmos W=0.155u L=0.04u
M1085 U306/net14 n248 VSS VSS nmos W=0.155u L=0.04u
M1086 n210 n200 U306/net14 VSS nmos W=0.155u L=0.04u
M1087 n210 n170 U306/net14 VSS nmos W=0.155u L=0.04u
M1088 n210 n173 U306/XI16-net11 VDD pmos W=0.205u L=0.04u
M1089 U306/XI16-net11 n248 VDD VDD pmos W=0.205u L=0.04u
M1090 n210 n200 U306/XI15-net11 VDD pmos W=0.205u L=0.04u
M1091 U306/XI15-net11 n170 U306/XI15-net18 VDD pmos W=0.205u L=0.04u
M1092 U306/XI15-net18 n164 VDD VDD pmos W=0.205u L=0.04u
M1093 U307/net19 n251 VSS VSS nmos W=0.155u L=0.04u
M1094 n173 n251 U307/net40 VSS nmos W=0.155u L=0.04u
M1095 n173 U307/net19 U307/net36 VSS nmos W=0.155u L=0.04u
M1096 U307/net40 n250 VSS VSS nmos W=0.31u L=0.04u
M1097 U307/net36 n249 VSS VSS nmos W=0.155u L=0.04u
M1098 U307/net19 n251 VDD VDD pmos W=0.205u L=0.04u
M1099 n173 U307/net19 U307/net26 VDD pmos W=0.325u L=0.04u
M1100 U307/net26 n250 VDD VDD pmos W=0.41u L=0.04u
M1101 n173 n251 U307/net30 VDD pmos W=0.325u L=0.04u
M1102 U307/net30 n249 VDD VDD pmos W=0.205u L=0.04u
M1103 U308/net28 U308/net20 U308/net64 VSS nmos W=0.155u L=0.04u
M1104 U308/net24 U308/net30 U308/net32 VSS nmos W=0.155u L=0.04u
M1105 U308/net28 U308/net40 U308/net24 VSS nmos W=0.155u L=0.04u
M1106 U308/net40 G5 U308/net108 VSS nmos W=0.155u L=0.04u
M1107 U308/net40 U308/net106 U308/net104 VSS nmos W=0.155u L=0.04u
M1108 U308/net24 G13 U308/net050 VSS nmos W=0.155u L=0.04u
M1109 U308/net050 U308/net32 VSS VSS nmos W=0.155u L=0.04u
M1110 U308/net20 U308/net40 VSS VSS nmos W=0.155u L=0.04u
M1111 U308/net106 G5 VSS VSS nmos W=0.155u L=0.04u
M1112 U308/net104 G9 VSS VSS nmos W=0.155u L=0.04u
M1113 U308/net30 G13 VSS VSS nmos W=0.155u L=0.04u
M1114 U308/net108 U308/net104 VSS VSS nmos W=0.155u L=0.04u
M1115 n251 U308/net28 VSS VSS nmos W=0.155u L=0.04u
M1116 U308/net32 G1 VSS VSS nmos W=0.155u L=0.04u
M1117 U308/net64 U308/net24 VSS VSS nmos W=0.2u L=0.04u
M1118 U308/net28 U308/net40 U308/net64 VDD pmos W=0.205u L=0.04u
M1119 U308/net24 G13 U308/net32 VDD pmos W=0.205u L=0.04u
M1120 U308/net28 U308/net20 U308/net24 VDD pmos W=0.205u L=0.04u
M1121 U308/net40 U308/net106 U308/net108 VDD pmos W=0.205u L=0.04u
M1122 U308/net40 G5 U308/net104 VDD pmos W=0.205u L=0.04u
M1123 U308/net20 U308/net40 VDD VDD pmos W=0.205u L=0.04u
M1124 U308/net106 G5 VDD VDD pmos W=0.205u L=0.04u
M1125 U308/net104 G9 VDD VDD pmos W=0.205u L=0.04u
M1126 U308/net30 G13 VDD VDD pmos W=0.205u L=0.04u
M1127 U308/net108 U308/net104 VDD VDD pmos W=0.205u L=0.04u
M1128 n251 U308/net28 VDD VDD pmos W=0.205u L=0.04u
M1129 U308/net32 G1 VDD VDD pmos W=0.205u L=0.04u
M1130 U308/net64 U308/net24 VDD VDD pmos W=0.28u L=0.04u
M1131 U308/net24 U308/net30 U308/net045 VDD pmos W=0.205u L=0.04u
M1132 U308/net045 U308/net32 VDD VDD pmos W=0.205u L=0.04u
M1133 n250 n253 VSS VSS nmos W=0.155u L=0.04u
M1134 n250 U309/net4 VSS VSS nmos W=0.155u L=0.04u
M1135 U309/net4 n252 VSS VSS nmos W=0.155u L=0.04u
M1136 U309/XU1-net8 U309/net4 VDD VDD pmos W=0.205u L=0.04u
M1137 n250 n253 U309/XU1-net8 VDD pmos W=0.205u L=0.04u
M1138 U309/net4 n252 VDD VDD pmos W=0.205u L=0.04u
M1139 U310/net13 n253 VSS VSS nmos W=0.155u L=0.04u
M1140 U310/net16 U310/net13 VSS VSS nmos W=0.155u L=0.04u
M1141 n249 n252 U310/net16 VSS nmos W=0.155u L=0.04u
M1142 U310/net13 n253 VDD VDD pmos W=0.205u L=0.04u
M1143 VDD U310/net13 n249 VDD pmos W=0.205u L=0.04u
M1144 VDD n252 n249 VDD pmos W=0.205u L=0.04u
M1145 n252 G41 U311/XI0-net10 VSS nmos W=0.155u L=0.04u
M1146 U311/XI0-net10 n254 U311/XI0-net13 VSS nmos W=0.155u L=0.04u
M1147 U311/XI0-net13 G33 VSS VSS nmos W=0.155u L=0.04u
M1148 n252 G33 VDD VDD pmos W=0.205u L=0.04u
M1149 n252 G41 VDD VDD pmos W=0.205u L=0.04u
M1150 n252 n254 VDD VDD pmos W=0.205u L=0.04u
M1151 n253 G41 U312/net27 VSS nmos W=0.155u L=0.04u
M1152 U312/net27 G33 VSS VSS nmos W=0.155u L=0.04u
M1153 n253 n254 VSS VSS nmos W=0.155u L=0.04u
M1154 n253 G33 U312/net13 VDD pmos W=0.205u L=0.04u
M1155 U312/net13 n254 VDD VDD pmos W=0.205u L=0.04u
M1156 n253 G41 U312/net13 VDD pmos W=0.205u L=0.04u
M1157 U313/net4 U313/net10 U313/net14 VSS nmos W=0.155u L=0.04u
M1158 U313/net6 n255 U313/net14 VSS nmos W=0.155u L=0.04u
M1159 U313/net4 n256 VSS VSS nmos W=0.155u L=0.04u
M1160 U313/net6 U313/net4 VSS VSS nmos W=0.155u L=0.04u
M1161 n254 U313/net14 VSS VSS nmos W=0.155u L=0.04u
M1162 U313/net10 n255 VSS VSS nmos W=0.155u L=0.04u
M1163 U313/net4 n255 U313/net14 VDD pmos W=0.205u L=0.04u
M1164 U313/net6 U313/net10 U313/net14 VDD pmos W=0.205u L=0.04u
M1165 U313/net4 n256 VDD VDD pmos W=0.205u L=0.04u
M1166 U313/net6 U313/net4 VDD VDD pmos W=0.205u L=0.04u
M1167 n254 U313/net14 VDD VDD pmos W=0.205u L=0.04u
M1168 U313/net10 n255 VDD VDD pmos W=0.205u L=0.04u
M1169 U314/net26 n258 VSS VSS nmos W=0.155u L=0.04u
M1170 U314/net26 n174 n248 VSS nmos W=0.155u L=0.04u
M1171 U314/net26 n257 n248 VSS nmos W=0.155u L=0.04u
M1172 n248 n174 U314/net38 VSS nmos W=0.155u L=0.04u
M1173 U314/net38 n257 VSS VSS nmos W=0.155u L=0.04u
M1174 U314/net16 n257 VDD VDD pmos W=0.205u L=0.04u
M1175 U314/net20 n174 n248 VDD pmos W=0.205u L=0.04u
M1176 n248 n174 U314/net16 VDD pmos W=0.205u L=0.04u
M1177 U314/net20 n257 n248 VDD pmos W=0.205u L=0.04u
M1178 U314/net20 n258 VDD VDD pmos W=0.205u L=0.04u
M1179 U315/net19 n261 VSS VSS nmos W=0.155u L=0.04u
M1180 n258 n261 U315/net40 VSS nmos W=0.155u L=0.04u
M1181 n258 U315/net19 U315/net36 VSS nmos W=0.155u L=0.04u
M1182 U315/net40 n260 VSS VSS nmos W=0.31u L=0.04u
M1183 U315/net36 n259 VSS VSS nmos W=0.155u L=0.04u
M1184 U315/net19 n261 VDD VDD pmos W=0.205u L=0.04u
M1185 n258 U315/net19 U315/net26 VDD pmos W=0.325u L=0.04u
M1186 U315/net26 n260 VDD VDD pmos W=0.41u L=0.04u
M1187 n258 n261 U315/net30 VDD pmos W=0.325u L=0.04u
M1188 U315/net30 n259 VDD VDD pmos W=0.205u L=0.04u
M1189 U316/net19 n264 VSS VSS nmos W=0.155u L=0.04u
M1190 n257 n264 U316/net40 VSS nmos W=0.155u L=0.04u
M1191 n257 U316/net19 U316/net36 VSS nmos W=0.155u L=0.04u
M1192 U316/net40 n263 VSS VSS nmos W=0.31u L=0.04u
M1193 U316/net36 n262 VSS VSS nmos W=0.155u L=0.04u
M1194 U316/net19 n264 VDD VDD pmos W=0.205u L=0.04u
M1195 n257 U316/net19 U316/net26 VDD pmos W=0.325u L=0.04u
M1196 U316/net26 n263 VDD VDD pmos W=0.41u L=0.04u
M1197 n257 n264 U316/net30 VDD pmos W=0.325u L=0.04u
M1198 U316/net30 n262 VDD VDD pmos W=0.205u L=0.04u
M1199 n174 n200 VSS VSS nmos W=0.135u L=0.04u
M1200 n174 n200 VDD VDD pmos W=0.205u L=0.04u
M1201 U318/net19 n267 VSS VSS nmos W=0.155u L=0.04u
M1202 n200 n267 U318/net40 VSS nmos W=0.155u L=0.04u
M1203 n200 U318/net19 U318/net36 VSS nmos W=0.155u L=0.04u
M1204 U318/net40 n266 VSS VSS nmos W=0.31u L=0.04u
M1205 U318/net36 n265 VSS VSS nmos W=0.155u L=0.04u
M1206 U318/net19 n267 VDD VDD pmos W=0.205u L=0.04u
M1207 n200 U318/net19 U318/net26 VDD pmos W=0.325u L=0.04u
M1208 U318/net26 n266 VDD VDD pmos W=0.41u L=0.04u
M1209 n200 n267 U318/net30 VDD pmos W=0.325u L=0.04u
M1210 U318/net30 n265 VDD VDD pmos W=0.205u L=0.04u
M1211 U319/net28 U319/net20 U319/net64 VSS nmos W=0.155u L=0.04u
M1212 U319/net24 U319/net30 U319/net32 VSS nmos W=0.155u L=0.04u
M1213 U319/net28 U319/net40 U319/net24 VSS nmos W=0.155u L=0.04u
M1214 U319/net40 G2 U319/net108 VSS nmos W=0.155u L=0.04u
M1215 U319/net40 U319/net106 U319/net104 VSS nmos W=0.155u L=0.04u
M1216 U319/net24 G14 U319/net050 VSS nmos W=0.155u L=0.04u
M1217 U319/net050 U319/net32 VSS VSS nmos W=0.155u L=0.04u
M1218 U319/net20 U319/net40 VSS VSS nmos W=0.155u L=0.04u
M1219 U319/net106 G2 VSS VSS nmos W=0.155u L=0.04u
M1220 U319/net104 G6 VSS VSS nmos W=0.155u L=0.04u
M1221 U319/net30 G14 VSS VSS nmos W=0.155u L=0.04u
M1222 U319/net108 U319/net104 VSS VSS nmos W=0.155u L=0.04u
M1223 n267 U319/net28 VSS VSS nmos W=0.155u L=0.04u
M1224 U319/net32 G10 VSS VSS nmos W=0.155u L=0.04u
M1225 U319/net64 U319/net24 VSS VSS nmos W=0.2u L=0.04u
M1226 U319/net28 U319/net40 U319/net64 VDD pmos W=0.205u L=0.04u
M1227 U319/net24 G14 U319/net32 VDD pmos W=0.205u L=0.04u
M1228 U319/net28 U319/net20 U319/net24 VDD pmos W=0.205u L=0.04u
M1229 U319/net40 U319/net106 U319/net108 VDD pmos W=0.205u L=0.04u
M1230 U319/net40 G2 U319/net104 VDD pmos W=0.205u L=0.04u
M1231 U319/net20 U319/net40 VDD VDD pmos W=0.205u L=0.04u
M1232 U319/net106 G2 VDD VDD pmos W=0.205u L=0.04u
M1233 U319/net104 G6 VDD VDD pmos W=0.205u L=0.04u
M1234 U319/net30 G14 VDD VDD pmos W=0.205u L=0.04u
M1235 U319/net108 U319/net104 VDD VDD pmos W=0.205u L=0.04u
M1236 n267 U319/net28 VDD VDD pmos W=0.205u L=0.04u
M1237 U319/net32 G10 VDD VDD pmos W=0.205u L=0.04u
M1238 U319/net64 U319/net24 VDD VDD pmos W=0.28u L=0.04u
M1239 U319/net24 U319/net30 U319/net045 VDD pmos W=0.205u L=0.04u
M1240 U319/net045 U319/net32 VDD VDD pmos W=0.205u L=0.04u
M1241 n266 n269 VSS VSS nmos W=0.155u L=0.04u
M1242 n266 U320/net4 VSS VSS nmos W=0.155u L=0.04u
M1243 U320/net4 n268 VSS VSS nmos W=0.155u L=0.04u
M1244 U320/XU1-net8 U320/net4 VDD VDD pmos W=0.205u L=0.04u
M1245 n266 n269 U320/XU1-net8 VDD pmos W=0.205u L=0.04u
M1246 U320/net4 n268 VDD VDD pmos W=0.205u L=0.04u
M1247 U321/net13 n269 VSS VSS nmos W=0.155u L=0.04u
M1248 U321/net16 U321/net13 VSS VSS nmos W=0.155u L=0.04u
M1249 n265 n268 U321/net16 VSS nmos W=0.155u L=0.04u
M1250 U321/net13 n269 VDD VDD pmos W=0.205u L=0.04u
M1251 VDD U321/net13 n265 VDD pmos W=0.205u L=0.04u
M1252 VDD n268 n265 VDD pmos W=0.205u L=0.04u
M1253 n268 G41 U322/XI0-net10 VSS nmos W=0.155u L=0.04u
M1254 U322/XI0-net10 n270 U322/XI0-net13 VSS nmos W=0.155u L=0.04u
M1255 U322/XI0-net13 G34 VSS VSS nmos W=0.155u L=0.04u
M1256 n268 G34 VDD VDD pmos W=0.205u L=0.04u
M1257 n268 G41 VDD VDD pmos W=0.205u L=0.04u
M1258 n268 n270 VDD VDD pmos W=0.205u L=0.04u
M1259 n269 G41 U323/net27 VSS nmos W=0.155u L=0.04u
M1260 U323/net27 G34 VSS VSS nmos W=0.155u L=0.04u
M1261 n269 n270 VSS VSS nmos W=0.155u L=0.04u
M1262 n269 G34 U323/net13 VDD pmos W=0.205u L=0.04u
M1263 U323/net13 n270 VDD VDD pmos W=0.205u L=0.04u
M1264 n269 G41 U323/net13 VDD pmos W=0.205u L=0.04u
M1265 U324/net4 U324/net10 U324/net14 VSS nmos W=0.155u L=0.04u
M1266 U324/net6 n271 U324/net14 VSS nmos W=0.155u L=0.04u
M1267 U324/net4 n272 VSS VSS nmos W=0.155u L=0.04u
M1268 U324/net6 U324/net4 VSS VSS nmos W=0.155u L=0.04u
M1269 n270 U324/net14 VSS VSS nmos W=0.155u L=0.04u
M1270 U324/net10 n271 VSS VSS nmos W=0.155u L=0.04u
M1271 U324/net4 n271 U324/net14 VDD pmos W=0.205u L=0.04u
M1272 U324/net6 U324/net10 U324/net14 VDD pmos W=0.205u L=0.04u
M1273 U324/net4 n272 VDD VDD pmos W=0.205u L=0.04u
M1274 U324/net6 U324/net4 VDD VDD pmos W=0.205u L=0.04u
M1275 n270 U324/net14 VDD VDD pmos W=0.205u L=0.04u
M1276 U324/net10 n271 VDD VDD pmos W=0.205u L=0.04u
M1277 U325/net19 n261 VSS VSS nmos W=0.155u L=0.04u
M1278 n170 n261 U325/net40 VSS nmos W=0.155u L=0.04u
M1279 n170 U325/net19 U325/net36 VSS nmos W=0.155u L=0.04u
M1280 U325/net40 n259 VSS VSS nmos W=0.31u L=0.04u
M1281 U325/net36 n260 VSS VSS nmos W=0.155u L=0.04u
M1282 U325/net19 n261 VDD VDD pmos W=0.205u L=0.04u
M1283 n170 U325/net19 U325/net26 VDD pmos W=0.325u L=0.04u
M1284 U325/net26 n259 VDD VDD pmos W=0.41u L=0.04u
M1285 n170 n261 U325/net30 VDD pmos W=0.325u L=0.04u
M1286 U325/net30 n260 VDD VDD pmos W=0.205u L=0.04u
M1287 U326/net28 U326/net20 U326/net64 VSS nmos W=0.155u L=0.04u
M1288 U326/net24 U326/net30 U326/net32 VSS nmos W=0.155u L=0.04u
M1289 U326/net28 U326/net40 U326/net24 VSS nmos W=0.155u L=0.04u
M1290 U326/net40 G4 U326/net108 VSS nmos W=0.155u L=0.04u
M1291 U326/net40 U326/net106 U326/net104 VSS nmos W=0.155u L=0.04u
M1292 U326/net24 G16 U326/net050 VSS nmos W=0.155u L=0.04u
M1293 U326/net050 U326/net32 VSS VSS nmos W=0.155u L=0.04u
M1294 U326/net20 U326/net40 VSS VSS nmos W=0.155u L=0.04u
M1295 U326/net106 G4 VSS VSS nmos W=0.155u L=0.04u
M1296 U326/net104 G8 VSS VSS nmos W=0.155u L=0.04u
M1297 U326/net30 G16 VSS VSS nmos W=0.155u L=0.04u
M1298 U326/net108 U326/net104 VSS VSS nmos W=0.155u L=0.04u
M1299 n261 U326/net28 VSS VSS nmos W=0.155u L=0.04u
M1300 U326/net32 G12 VSS VSS nmos W=0.155u L=0.04u
M1301 U326/net64 U326/net24 VSS VSS nmos W=0.2u L=0.04u
M1302 U326/net28 U326/net40 U326/net64 VDD pmos W=0.205u L=0.04u
M1303 U326/net24 G16 U326/net32 VDD pmos W=0.205u L=0.04u
M1304 U326/net28 U326/net20 U326/net24 VDD pmos W=0.205u L=0.04u
M1305 U326/net40 U326/net106 U326/net108 VDD pmos W=0.205u L=0.04u
M1306 U326/net40 G4 U326/net104 VDD pmos W=0.205u L=0.04u
M1307 U326/net20 U326/net40 VDD VDD pmos W=0.205u L=0.04u
M1308 U326/net106 G4 VDD VDD pmos W=0.205u L=0.04u
M1309 U326/net104 G8 VDD VDD pmos W=0.205u L=0.04u
M1310 U326/net30 G16 VDD VDD pmos W=0.205u L=0.04u
M1311 U326/net108 U326/net104 VDD VDD pmos W=0.205u L=0.04u
M1312 n261 U326/net28 VDD VDD pmos W=0.205u L=0.04u
M1313 U326/net32 G12 VDD VDD pmos W=0.205u L=0.04u
M1314 U326/net64 U326/net24 VDD VDD pmos W=0.28u L=0.04u
M1315 U326/net24 U326/net30 U326/net045 VDD pmos W=0.205u L=0.04u
M1316 U326/net045 U326/net32 VDD VDD pmos W=0.205u L=0.04u
M1317 n259 n273 VSS VSS nmos W=0.155u L=0.04u
M1318 n259 n274 VSS VSS nmos W=0.155u L=0.04u
M1319 U327/XI1-net8 n274 VDD VDD pmos W=0.205u L=0.04u
M1320 n259 n273 U327/XI1-net8 VDD pmos W=0.205u L=0.04u
M1321 n273 n275 VSS VSS nmos W=0.135u L=0.04u
M1322 n273 n275 VDD VDD pmos W=0.205u L=0.04u
M1323 U329/XU1-net6 n275 VSS VSS nmos W=0.155u L=0.04u
M1324 n260 n276 U329/XU1-net6 VSS nmos W=0.155u L=0.04u
M1325 n260 n275 VDD VDD pmos W=0.155u L=0.04u
M1326 n260 n276 VDD VDD pmos W=0.155u L=0.04u
M1327 n275 G41 U330/XI0-net10 VSS nmos W=0.155u L=0.04u
M1328 U330/XI0-net10 n277 U330/XI0-net13 VSS nmos W=0.155u L=0.04u
M1329 U330/XI0-net13 G36 VSS VSS nmos W=0.155u L=0.04u
M1330 n275 G36 VDD VDD pmos W=0.205u L=0.04u
M1331 n275 G41 VDD VDD pmos W=0.205u L=0.04u
M1332 n275 n277 VDD VDD pmos W=0.205u L=0.04u
M1333 n276 n274 VSS VSS nmos W=0.135u L=0.04u
M1334 n276 n274 VDD VDD pmos W=0.205u L=0.04u
M1335 n274 G41 U332/net27 VSS nmos W=0.155u L=0.04u
M1336 U332/net27 G36 VSS VSS nmos W=0.155u L=0.04u
M1337 n274 n277 VSS VSS nmos W=0.155u L=0.04u
M1338 n274 G36 U332/net13 VDD pmos W=0.205u L=0.04u
M1339 U332/net13 n277 VDD VDD pmos W=0.205u L=0.04u
M1340 n274 G41 U332/net13 VDD pmos W=0.205u L=0.04u
M1341 U333/net4 U333/net10 U333/net14 VSS nmos W=0.155u L=0.04u
M1342 U333/net6 n256 U333/net14 VSS nmos W=0.155u L=0.04u
M1343 U333/net4 n272 VSS VSS nmos W=0.155u L=0.04u
M1344 U333/net6 U333/net4 VSS VSS nmos W=0.155u L=0.04u
M1345 n277 U333/net14 VSS VSS nmos W=0.155u L=0.04u
M1346 U333/net10 n256 VSS VSS nmos W=0.155u L=0.04u
M1347 U333/net4 n256 U333/net14 VDD pmos W=0.205u L=0.04u
M1348 U333/net6 U333/net10 U333/net14 VDD pmos W=0.205u L=0.04u
M1349 U333/net4 n272 VDD VDD pmos W=0.205u L=0.04u
M1350 U333/net6 U333/net4 VDD VDD pmos W=0.205u L=0.04u
M1351 n277 U333/net14 VDD VDD pmos W=0.205u L=0.04u
M1352 U333/net10 n256 VDD VDD pmos W=0.205u L=0.04u
M1353 U334/net28 U334/net20 U334/net64 VSS nmos W=0.155u L=0.04u
M1354 U334/net24 U334/net30 U334/net32 VSS nmos W=0.155u L=0.04u
M1355 U334/net28 U334/net40 U334/net24 VSS nmos W=0.155u L=0.04u
M1356 U334/net40 G30 U334/net108 VSS nmos W=0.155u L=0.04u
M1357 U334/net40 U334/net106 U334/net104 VSS nmos W=0.155u L=0.04u
M1358 U334/net24 G32 U334/net050 VSS nmos W=0.155u L=0.04u
M1359 U334/net050 U334/net32 VSS VSS nmos W=0.155u L=0.04u
M1360 U334/net20 U334/net40 VSS VSS nmos W=0.155u L=0.04u
M1361 U334/net106 G30 VSS VSS nmos W=0.155u L=0.04u
M1362 U334/net104 G29 VSS VSS nmos W=0.155u L=0.04u
M1363 U334/net30 G32 VSS VSS nmos W=0.155u L=0.04u
M1364 U334/net108 U334/net104 VSS VSS nmos W=0.155u L=0.04u
M1365 n272 U334/net28 VSS VSS nmos W=0.155u L=0.04u
M1366 U334/net32 G31 VSS VSS nmos W=0.155u L=0.04u
M1367 U334/net64 U334/net24 VSS VSS nmos W=0.2u L=0.04u
M1368 U334/net28 U334/net40 U334/net64 VDD pmos W=0.205u L=0.04u
M1369 U334/net24 G32 U334/net32 VDD pmos W=0.205u L=0.04u
M1370 U334/net28 U334/net20 U334/net24 VDD pmos W=0.205u L=0.04u
M1371 U334/net40 U334/net106 U334/net108 VDD pmos W=0.205u L=0.04u
M1372 U334/net40 G30 U334/net104 VDD pmos W=0.205u L=0.04u
M1373 U334/net20 U334/net40 VDD VDD pmos W=0.205u L=0.04u
M1374 U334/net106 G30 VDD VDD pmos W=0.205u L=0.04u
M1375 U334/net104 G29 VDD VDD pmos W=0.205u L=0.04u
M1376 U334/net30 G32 VDD VDD pmos W=0.205u L=0.04u
M1377 U334/net108 U334/net104 VDD VDD pmos W=0.205u L=0.04u
M1378 n272 U334/net28 VDD VDD pmos W=0.205u L=0.04u
M1379 U334/net32 G31 VDD VDD pmos W=0.205u L=0.04u
M1380 U334/net64 U334/net24 VDD VDD pmos W=0.28u L=0.04u
M1381 U334/net24 U334/net30 U334/net045 VDD pmos W=0.205u L=0.04u
M1382 U334/net045 U334/net32 VDD VDD pmos W=0.205u L=0.04u
M1383 U335/net28 U335/net20 U335/net64 VSS nmos W=0.155u L=0.04u
M1384 U335/net24 U335/net30 U335/net32 VSS nmos W=0.155u L=0.04u
M1385 U335/net28 U335/net40 U335/net24 VSS nmos W=0.155u L=0.04u
M1386 U335/net40 G22 U335/net108 VSS nmos W=0.155u L=0.04u
M1387 U335/net40 U335/net106 U335/net104 VSS nmos W=0.155u L=0.04u
M1388 U335/net24 G24 U335/net050 VSS nmos W=0.155u L=0.04u
M1389 U335/net050 U335/net32 VSS VSS nmos W=0.155u L=0.04u
M1390 U335/net20 U335/net40 VSS VSS nmos W=0.155u L=0.04u
M1391 U335/net106 G22 VSS VSS nmos W=0.155u L=0.04u
M1392 U335/net104 G21 VSS VSS nmos W=0.155u L=0.04u
M1393 U335/net30 G24 VSS VSS nmos W=0.155u L=0.04u
M1394 U335/net108 U335/net104 VSS VSS nmos W=0.155u L=0.04u
M1395 n256 U335/net28 VSS VSS nmos W=0.155u L=0.04u
M1396 U335/net32 G23 VSS VSS nmos W=0.155u L=0.04u
M1397 U335/net64 U335/net24 VSS VSS nmos W=0.2u L=0.04u
M1398 U335/net28 U335/net40 U335/net64 VDD pmos W=0.205u L=0.04u
M1399 U335/net24 G24 U335/net32 VDD pmos W=0.205u L=0.04u
M1400 U335/net28 U335/net20 U335/net24 VDD pmos W=0.205u L=0.04u
M1401 U335/net40 U335/net106 U335/net108 VDD pmos W=0.205u L=0.04u
M1402 U335/net40 G22 U335/net104 VDD pmos W=0.205u L=0.04u
M1403 U335/net20 U335/net40 VDD VDD pmos W=0.205u L=0.04u
M1404 U335/net106 G22 VDD VDD pmos W=0.205u L=0.04u
M1405 U335/net104 G21 VDD VDD pmos W=0.205u L=0.04u
M1406 U335/net30 G24 VDD VDD pmos W=0.205u L=0.04u
M1407 U335/net108 U335/net104 VDD VDD pmos W=0.205u L=0.04u
M1408 n256 U335/net28 VDD VDD pmos W=0.205u L=0.04u
M1409 U335/net32 G23 VDD VDD pmos W=0.205u L=0.04u
M1410 U335/net64 U335/net24 VDD VDD pmos W=0.28u L=0.04u
M1411 U335/net24 U335/net30 U335/net045 VDD pmos W=0.205u L=0.04u
M1412 U335/net045 U335/net32 VDD VDD pmos W=0.205u L=0.04u
M1413 U336/net19 n264 VSS VSS nmos W=0.155u L=0.04u
M1414 n164 n264 U336/net40 VSS nmos W=0.155u L=0.04u
M1415 n164 U336/net19 U336/net36 VSS nmos W=0.155u L=0.04u
M1416 U336/net40 n262 VSS VSS nmos W=0.31u L=0.04u
M1417 U336/net36 n263 VSS VSS nmos W=0.155u L=0.04u
M1418 U336/net19 n264 VDD VDD pmos W=0.205u L=0.04u
M1419 n164 U336/net19 U336/net26 VDD pmos W=0.325u L=0.04u
M1420 U336/net26 n262 VDD VDD pmos W=0.41u L=0.04u
M1421 n164 n264 U336/net30 VDD pmos W=0.325u L=0.04u
M1422 U336/net30 n263 VDD VDD pmos W=0.205u L=0.04u
M1423 U337/net28 U337/net20 U337/net64 VSS nmos W=0.155u L=0.04u
M1424 U337/net24 U337/net30 U337/net32 VSS nmos W=0.155u L=0.04u
M1425 U337/net28 U337/net40 U337/net24 VSS nmos W=0.155u L=0.04u
M1426 U337/net40 G3 U337/net108 VSS nmos W=0.155u L=0.04u
M1427 U337/net40 U337/net106 U337/net104 VSS nmos W=0.155u L=0.04u
M1428 U337/net24 G15 U337/net050 VSS nmos W=0.155u L=0.04u
M1429 U337/net050 U337/net32 VSS VSS nmos W=0.155u L=0.04u
M1430 U337/net20 U337/net40 VSS VSS nmos W=0.155u L=0.04u
M1431 U337/net106 G3 VSS VSS nmos W=0.155u L=0.04u
M1432 U337/net104 G7 VSS VSS nmos W=0.155u L=0.04u
M1433 U337/net30 G15 VSS VSS nmos W=0.155u L=0.04u
M1434 U337/net108 U337/net104 VSS VSS nmos W=0.155u L=0.04u
M1435 n264 U337/net28 VSS VSS nmos W=0.155u L=0.04u
M1436 U337/net32 G11 VSS VSS nmos W=0.155u L=0.04u
M1437 U337/net64 U337/net24 VSS VSS nmos W=0.2u L=0.04u
M1438 U337/net28 U337/net40 U337/net64 VDD pmos W=0.205u L=0.04u
M1439 U337/net24 G15 U337/net32 VDD pmos W=0.205u L=0.04u
M1440 U337/net28 U337/net20 U337/net24 VDD pmos W=0.205u L=0.04u
M1441 U337/net40 U337/net106 U337/net108 VDD pmos W=0.205u L=0.04u
M1442 U337/net40 G3 U337/net104 VDD pmos W=0.205u L=0.04u
M1443 U337/net20 U337/net40 VDD VDD pmos W=0.205u L=0.04u
M1444 U337/net106 G3 VDD VDD pmos W=0.205u L=0.04u
M1445 U337/net104 G7 VDD VDD pmos W=0.205u L=0.04u
M1446 U337/net30 G15 VDD VDD pmos W=0.205u L=0.04u
M1447 U337/net108 U337/net104 VDD VDD pmos W=0.205u L=0.04u
M1448 n264 U337/net28 VDD VDD pmos W=0.205u L=0.04u
M1449 U337/net32 G11 VDD VDD pmos W=0.205u L=0.04u
M1450 U337/net64 U337/net24 VDD VDD pmos W=0.28u L=0.04u
M1451 U337/net24 U337/net30 U337/net045 VDD pmos W=0.205u L=0.04u
M1452 U337/net045 U337/net32 VDD VDD pmos W=0.205u L=0.04u
M1453 n262 n278 VSS VSS nmos W=0.155u L=0.04u
M1454 n262 n279 VSS VSS nmos W=0.155u L=0.04u
M1455 U338/XI1-net8 n279 VDD VDD pmos W=0.205u L=0.04u
M1456 n262 n278 U338/XI1-net8 VDD pmos W=0.205u L=0.04u
M1457 n278 n280 VSS VSS nmos W=0.135u L=0.04u
M1458 n278 n280 VDD VDD pmos W=0.205u L=0.04u
M1459 U340/XU1-net6 n280 VSS VSS nmos W=0.155u L=0.04u
M1460 n263 n281 U340/XU1-net6 VSS nmos W=0.155u L=0.04u
M1461 n263 n280 VDD VDD pmos W=0.155u L=0.04u
M1462 n263 n281 VDD VDD pmos W=0.155u L=0.04u
M1463 n280 G41 U341/XI0-net10 VSS nmos W=0.155u L=0.04u
M1464 U341/XI0-net10 n282 U341/XI0-net13 VSS nmos W=0.155u L=0.04u
M1465 U341/XI0-net13 G35 VSS VSS nmos W=0.155u L=0.04u
M1466 n280 G35 VDD VDD pmos W=0.205u L=0.04u
M1467 n280 G41 VDD VDD pmos W=0.205u L=0.04u
M1468 n280 n282 VDD VDD pmos W=0.205u L=0.04u
M1469 n281 n279 VSS VSS nmos W=0.135u L=0.04u
M1470 n281 n279 VDD VDD pmos W=0.205u L=0.04u
M1471 n279 G41 U343/net27 VSS nmos W=0.155u L=0.04u
M1472 U343/net27 G35 VSS VSS nmos W=0.155u L=0.04u
M1473 n279 n282 VSS VSS nmos W=0.155u L=0.04u
M1474 n279 G35 U343/net13 VDD pmos W=0.205u L=0.04u
M1475 U343/net13 n282 VDD VDD pmos W=0.205u L=0.04u
M1476 n279 G41 U343/net13 VDD pmos W=0.205u L=0.04u
M1477 U344/net4 U344/net10 U344/net14 VSS nmos W=0.155u L=0.04u
M1478 U344/net6 n255 U344/net14 VSS nmos W=0.155u L=0.04u
M1479 U344/net4 n271 VSS VSS nmos W=0.155u L=0.04u
M1480 U344/net6 U344/net4 VSS VSS nmos W=0.155u L=0.04u
M1481 n282 U344/net14 VSS VSS nmos W=0.155u L=0.04u
M1482 U344/net10 n255 VSS VSS nmos W=0.155u L=0.04u
M1483 U344/net4 n255 U344/net14 VDD pmos W=0.205u L=0.04u
M1484 U344/net6 U344/net10 U344/net14 VDD pmos W=0.205u L=0.04u
M1485 U344/net4 n271 VDD VDD pmos W=0.205u L=0.04u
M1486 U344/net6 U344/net4 VDD VDD pmos W=0.205u L=0.04u
M1487 n282 U344/net14 VDD VDD pmos W=0.205u L=0.04u
M1488 U344/net10 n255 VDD VDD pmos W=0.205u L=0.04u
M1489 U345/net28 U345/net20 U345/net64 VSS nmos W=0.155u L=0.04u
M1490 U345/net24 U345/net30 U345/net32 VSS nmos W=0.155u L=0.04u
M1491 U345/net28 U345/net40 U345/net24 VSS nmos W=0.155u L=0.04u
M1492 U345/net40 G26 U345/net108 VSS nmos W=0.155u L=0.04u
M1493 U345/net40 U345/net106 U345/net104 VSS nmos W=0.155u L=0.04u
M1494 U345/net24 G28 U345/net050 VSS nmos W=0.155u L=0.04u
M1495 U345/net050 U345/net32 VSS VSS nmos W=0.155u L=0.04u
M1496 U345/net20 U345/net40 VSS VSS nmos W=0.155u L=0.04u
M1497 U345/net106 G26 VSS VSS nmos W=0.155u L=0.04u
M1498 U345/net104 G25 VSS VSS nmos W=0.155u L=0.04u
M1499 U345/net30 G28 VSS VSS nmos W=0.155u L=0.04u
M1500 U345/net108 U345/net104 VSS VSS nmos W=0.155u L=0.04u
M1501 n271 U345/net28 VSS VSS nmos W=0.155u L=0.04u
M1502 U345/net32 G27 VSS VSS nmos W=0.155u L=0.04u
M1503 U345/net64 U345/net24 VSS VSS nmos W=0.2u L=0.04u
M1504 U345/net28 U345/net40 U345/net64 VDD pmos W=0.205u L=0.04u
M1505 U345/net24 G28 U345/net32 VDD pmos W=0.205u L=0.04u
M1506 U345/net28 U345/net20 U345/net24 VDD pmos W=0.205u L=0.04u
M1507 U345/net40 U345/net106 U345/net108 VDD pmos W=0.205u L=0.04u
M1508 U345/net40 G26 U345/net104 VDD pmos W=0.205u L=0.04u
M1509 U345/net20 U345/net40 VDD VDD pmos W=0.205u L=0.04u
M1510 U345/net106 G26 VDD VDD pmos W=0.205u L=0.04u
M1511 U345/net104 G25 VDD VDD pmos W=0.205u L=0.04u
M1512 U345/net30 G28 VDD VDD pmos W=0.205u L=0.04u
M1513 U345/net108 U345/net104 VDD VDD pmos W=0.205u L=0.04u
M1514 n271 U345/net28 VDD VDD pmos W=0.205u L=0.04u
M1515 U345/net32 G27 VDD VDD pmos W=0.205u L=0.04u
M1516 U345/net64 U345/net24 VDD VDD pmos W=0.28u L=0.04u
M1517 U345/net24 U345/net30 U345/net045 VDD pmos W=0.205u L=0.04u
M1518 U345/net045 U345/net32 VDD VDD pmos W=0.205u L=0.04u
M1519 U346/net28 U346/net20 U346/net64 VSS nmos W=0.155u L=0.04u
M1520 U346/net24 U346/net30 U346/net32 VSS nmos W=0.155u L=0.04u
M1521 U346/net28 U346/net40 U346/net24 VSS nmos W=0.155u L=0.04u
M1522 U346/net40 G18 U346/net108 VSS nmos W=0.155u L=0.04u
M1523 U346/net40 U346/net106 U346/net104 VSS nmos W=0.155u L=0.04u
M1524 U346/net24 G20 U346/net050 VSS nmos W=0.155u L=0.04u
M1525 U346/net050 U346/net32 VSS VSS nmos W=0.155u L=0.04u
M1526 U346/net20 U346/net40 VSS VSS nmos W=0.155u L=0.04u
M1527 U346/net106 G18 VSS VSS nmos W=0.155u L=0.04u
M1528 U346/net104 G17 VSS VSS nmos W=0.155u L=0.04u
M1529 U346/net30 G20 VSS VSS nmos W=0.155u L=0.04u
M1530 U346/net108 U346/net104 VSS VSS nmos W=0.155u L=0.04u
M1531 n255 U346/net28 VSS VSS nmos W=0.155u L=0.04u
M1532 U346/net32 G19 VSS VSS nmos W=0.155u L=0.04u
M1533 U346/net64 U346/net24 VSS VSS nmos W=0.2u L=0.04u
M1534 U346/net28 U346/net40 U346/net64 VDD pmos W=0.205u L=0.04u
M1535 U346/net24 G20 U346/net32 VDD pmos W=0.205u L=0.04u
M1536 U346/net28 U346/net20 U346/net24 VDD pmos W=0.205u L=0.04u
M1537 U346/net40 U346/net106 U346/net108 VDD pmos W=0.205u L=0.04u
M1538 U346/net40 G18 U346/net104 VDD pmos W=0.205u L=0.04u
M1539 U346/net20 U346/net40 VDD VDD pmos W=0.205u L=0.04u
M1540 U346/net106 G18 VDD VDD pmos W=0.205u L=0.04u
M1541 U346/net104 G17 VDD VDD pmos W=0.205u L=0.04u
M1542 U346/net30 G20 VDD VDD pmos W=0.205u L=0.04u
M1543 U346/net108 U346/net104 VDD VDD pmos W=0.205u L=0.04u
M1544 n255 U346/net28 VDD VDD pmos W=0.205u L=0.04u
M1545 U346/net32 G19 VDD VDD pmos W=0.205u L=0.04u
M1546 U346/net64 U346/net24 VDD VDD pmos W=0.28u L=0.04u
M1547 U346/net24 U346/net30 U346/net045 VDD pmos W=0.205u L=0.04u
M1548 U346/net045 U346/net32 VDD VDD pmos W=0.205u L=0.04u
.ENDS
