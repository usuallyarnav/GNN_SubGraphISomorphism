.SUBCKT c880 N1 N8 N13 N17 N26 N29 N36 N42 N51 N55 N59 N68 N72 N73 N74 N75 N80 N85 N86 N87 N88 N89 N90 N91 N96 N101 N106 N111 N116 N121 N126 N130 N135 N138 N143 N146 N149 N152 N153 N156 N159 N165 N171 N177 N183 N189 N195 N201 N207 N210 N219 N228 N237 N246 N255 N259 N260 N261 N267 N268 N290 N291 N292 N297 N0 N344 N420 N421 N422 N356 N392 N447 N448 N449 N24 N660 N661 N850 N863 N864 N865 N866 N874 N878 N879 N880 VDD VSS
M1 U146/net36 n137 U146/net24 VSS nmos W=0.155u L=0.04u
M2 U146/net24 n138 VSS VSS nmos W=0.155u L=0.04u
M3 N880 n135 U146/net36 VSS nmos W=0.155u L=0.04u
M4 N880 n136 U146/net36 VSS nmos W=0.155u L=0.04u
M5 N880 n136 U146/net35 VDD pmos W=0.205u L=0.04u
M6 U146/net35 n135 VDD VDD pmos W=0.205u L=0.04u
M7 N880 n138 VDD VDD pmos W=0.205u L=0.04u
M8 N880 n137 VDD VDD pmos W=0.205u L=0.04u
M9 n138 N96 U147/net27 VSS nmos W=0.155u L=0.04u
M10 U147/net27 N210 VSS VSS nmos W=0.155u L=0.04u
M11 n138 n139 VSS VSS nmos W=0.155u L=0.04u
M12 n138 N210 U147/net13 VDD pmos W=0.205u L=0.04u
M13 U147/net13 n139 VDD VDD pmos W=0.205u L=0.04u
M14 n138 N96 U147/net13 VDD pmos W=0.205u L=0.04u
M15 U148/net19 n142 VSS VSS nmos W=0.155u L=0.04u
M16 n139 n142 U148/net40 VSS nmos W=0.155u L=0.04u
M17 n139 U148/net19 U148/net36 VSS nmos W=0.155u L=0.04u
M18 U148/net40 n141 VSS VSS nmos W=0.31u L=0.04u
M19 U148/net36 n140 VSS VSS nmos W=0.155u L=0.04u
M20 U148/net19 n142 VDD VDD pmos W=0.205u L=0.04u
M21 n139 U148/net19 U148/net26 VDD pmos W=0.325u L=0.04u
M22 U148/net26 n141 VDD VDD pmos W=0.41u L=0.04u
M23 n139 n142 U148/net30 VDD pmos W=0.325u L=0.04u
M24 U148/net30 n140 VDD VDD pmos W=0.205u L=0.04u
M25 U149/net13 n143 VSS VSS nmos W=0.155u L=0.04u
M26 U149/net16 U149/net13 VSS VSS nmos W=0.155u L=0.04u
M27 n141 N228 U149/net16 VSS nmos W=0.155u L=0.04u
M28 U149/net13 n143 VDD VDD pmos W=0.205u L=0.04u
M29 VDD U149/net13 n141 VDD pmos W=0.205u L=0.04u
M30 VDD N228 n141 VDD pmos W=0.205u L=0.04u
M31 n137 n144 U150/net23 VDD pmos W=0.205u L=0.04u
M32 n137 N219 U150/net23 VDD pmos W=0.205u L=0.04u
M33 n137 n145 U150/net23 VDD pmos W=0.205u L=0.04u
M34 U150/net23 N246 VDD VDD pmos W=0.205u L=0.04u
M35 U150/net23 n146 VDD VDD pmos W=0.205u L=0.04u
M36 U150/XI20-net13 N219 VSS VSS nmos W=0.155u L=0.04u
M37 n137 n144 U150/XI20-net17 VSS nmos W=0.155u L=0.04u
M38 U150/XI20-net17 n145 U150/XI20-net13 VSS nmos W=0.155u L=0.04u
M39 n137 N246 U150/XI17-net17 VSS nmos W=0.155u L=0.04u
M40 U150/XI17-net17 n146 VSS VSS nmos W=0.155u L=0.04u
M41 n145 n147 U151/net26 VSS nmos W=0.155u L=0.04u
M42 n145 n143 U151/net26 VSS nmos W=0.155u L=0.04u
M43 U151/net29 n150 VSS VSS nmos W=0.155u L=0.04u
M44 U151/net26 n148 U151/net29 VSS nmos W=0.155u L=0.04u
M45 U151/net26 n149 U151/net29 VSS nmos W=0.155u L=0.04u
M46 n145 n143 U151/net43 VDD pmos W=0.205u L=0.04u
M47 n145 n149 U151/net49 VDD pmos W=0.205u L=0.04u
M48 U151/net49 n148 VDD VDD pmos W=0.205u L=0.04u
M49 U151/net43 n147 VDD VDD pmos W=0.205u L=0.04u
M50 n145 n150 VDD VDD pmos W=0.205u L=0.04u
M51 n144 n151 U152/net15 VSS nmos W=0.155u L=0.04u
M52 n144 n152 U152/net15 VSS nmos W=0.155u L=0.04u
M53 U152/net15 n142 VSS VSS nmos W=0.155u L=0.04u
M54 n144 n142 VDD VDD pmos W=0.205u L=0.04u
M55 n144 n151 U152/XI16-net11 VDD pmos W=0.205u L=0.04u
M56 U152/XI16-net11 n152 VDD VDD pmos W=0.205u L=0.04u
M57 N879 n154 U153/net26 VSS nmos W=0.155u L=0.04u
M58 N879 n153 U153/net26 VSS nmos W=0.155u L=0.04u
M59 U153/net29 n157 VSS VSS nmos W=0.155u L=0.04u
M60 U153/net26 n155 U153/net29 VSS nmos W=0.155u L=0.04u
M61 U153/net26 n156 U153/net29 VSS nmos W=0.155u L=0.04u
M62 N879 n153 U153/net43 VDD pmos W=0.205u L=0.04u
M63 N879 n156 U153/net49 VDD pmos W=0.205u L=0.04u
M64 U153/net49 n155 VDD VDD pmos W=0.205u L=0.04u
M65 U153/net43 n154 VDD VDD pmos W=0.205u L=0.04u
M66 N879 n157 VDD VDD pmos W=0.205u L=0.04u
M67 n157 n160 U154/XI21-net17 VSS nmos W=0.155u L=0.04u
M68 U154/XI21-net17 N219 VSS VSS nmos W=0.155u L=0.04u
M69 n157 n158 U154/XI6-net17 VSS nmos W=0.155u L=0.04u
M70 U154/XI6-net17 N228 VSS VSS nmos W=0.155u L=0.04u
M71 n157 N165 U154/XI20-net17 VSS nmos W=0.155u L=0.04u
M72 U154/XI20-net17 n159 VSS VSS nmos W=0.155u L=0.04u
M73 VDD n160 U154/net22 VDD pmos W=0.205u L=0.04u
M74 VDD N219 U154/net22 VDD pmos W=0.205u L=0.04u
M75 U154/net16 n158 n157 VDD pmos W=0.205u L=0.04u
M76 U154/net16 N228 n157 VDD pmos W=0.205u L=0.04u
M77 U154/net22 N165 U154/net16 VDD pmos W=0.205u L=0.04u
M78 U154/net22 n159 U154/net16 VDD pmos W=0.205u L=0.04u
M79 U155/net4 n161 U155/net14 VSS nmos W=0.155u L=0.04u
M80 U155/net6 U155/net10 U155/net14 VSS nmos W=0.17u L=0.04u
M81 U155/net4 n158 VSS VSS nmos W=0.155u L=0.04u
M82 U155/net6 U155/net4 VSS VSS nmos W=0.17u L=0.04u
M83 n160 U155/net14 VSS VSS nmos W=0.155u L=0.04u
M84 U155/net10 n161 VSS VSS nmos W=0.155u L=0.04u
M85 U155/net4 U155/net10 U155/net14 VDD pmos W=0.255u L=0.04u
M86 U155/net6 n161 U155/net14 VDD pmos W=0.28u L=0.04u
M87 U155/net4 n158 VDD VDD pmos W=0.205u L=0.04u
M88 U155/net6 U155/net4 VDD VDD pmos W=0.24u L=0.04u
M89 n160 U155/net14 VDD VDD pmos W=0.205u L=0.04u
M90 U155/net10 n161 VDD VDD pmos W=0.205u L=0.04u
M91 n161 n152 VSS VSS nmos W=0.155u L=0.04u
M92 n161 n151 VSS VSS nmos W=0.155u L=0.04u
M93 n161 n147 VSS VSS nmos W=0.155u L=0.04u
M94 U156/net25 n152 VDD VDD pmos W=0.41u L=0.04u
M95 U156/net28 n151 U156/net25 VDD pmos W=0.41u L=0.04u
M96 n161 n147 U156/net28 VDD pmos W=0.41u L=0.04u
M97 n159 n153 U157/net15 VSS nmos W=0.155u L=0.04u
M98 n159 n140 U157/net15 VSS nmos W=0.155u L=0.04u
M99 U157/net15 n136 VSS VSS nmos W=0.155u L=0.04u
M100 n159 n136 VDD VDD pmos W=0.205u L=0.04u
M101 n159 n153 U157/XI16-net11 VDD pmos W=0.205u L=0.04u
M102 U157/XI16-net11 n140 VDD VDD pmos W=0.205u L=0.04u
M103 U158/net14 n162 U158/net20 VSS nmos W=0.155u L=0.04u
M104 U158/net14 n153 U158/net20 VSS nmos W=0.155u L=0.04u
M105 U158/net20 n163 VSS VSS nmos W=0.155u L=0.04u
M106 n158 U158/net14 VSS VSS nmos W=0.155u L=0.04u
M107 n158 U158/net14 VDD VDD pmos W=0.205u L=0.04u
M108 U158/net14 n163 VDD VDD pmos W=0.205u L=0.04u
M109 U158/net24 n162 VDD VDD pmos W=0.205u L=0.04u
M110 U158/net14 n153 U158/net24 VDD pmos W=0.205u L=0.04u
M111 N878 n154 U159/net26 VSS nmos W=0.155u L=0.04u
M112 N878 n164 U159/net26 VSS nmos W=0.155u L=0.04u
M113 U159/net29 n166 VSS VSS nmos W=0.155u L=0.04u
M114 U159/net26 n155 U159/net29 VSS nmos W=0.155u L=0.04u
M115 U159/net26 n165 U159/net29 VSS nmos W=0.155u L=0.04u
M116 N878 n164 U159/net43 VDD pmos W=0.205u L=0.04u
M117 N878 n165 U159/net49 VDD pmos W=0.205u L=0.04u
M118 U159/net49 n155 VDD VDD pmos W=0.205u L=0.04u
M119 U159/net43 n154 VDD VDD pmos W=0.205u L=0.04u
M120 N878 n166 VDD VDD pmos W=0.205u L=0.04u
M121 n166 n169 U160/XI21-net17 VSS nmos W=0.155u L=0.04u
M122 U160/XI21-net17 N219 VSS VSS nmos W=0.155u L=0.04u
M123 n166 n167 U160/XI6-net17 VSS nmos W=0.155u L=0.04u
M124 U160/XI6-net17 N228 VSS VSS nmos W=0.155u L=0.04u
M125 n166 N159 U160/XI20-net17 VSS nmos W=0.155u L=0.04u
M126 U160/XI20-net17 n168 VSS VSS nmos W=0.155u L=0.04u
M127 VDD n169 U160/net22 VDD pmos W=0.205u L=0.04u
M128 VDD N219 U160/net22 VDD pmos W=0.205u L=0.04u
M129 U160/net16 n167 n166 VDD pmos W=0.205u L=0.04u
M130 U160/net16 N228 n166 VDD pmos W=0.205u L=0.04u
M131 U160/net22 N159 U160/net16 VDD pmos W=0.205u L=0.04u
M132 U160/net22 n168 U160/net16 VDD pmos W=0.205u L=0.04u
M133 U161/net4 n167 U161/net14 VSS nmos W=0.155u L=0.04u
M134 U161/net6 U161/net10 U161/net14 VSS nmos W=0.17u L=0.04u
M135 U161/net4 n170 VSS VSS nmos W=0.155u L=0.04u
M136 U161/net6 U161/net4 VSS VSS nmos W=0.17u L=0.04u
M137 n169 U161/net14 VSS VSS nmos W=0.155u L=0.04u
M138 U161/net10 n167 VSS VSS nmos W=0.155u L=0.04u
M139 U161/net4 U161/net10 U161/net14 VDD pmos W=0.255u L=0.04u
M140 U161/net6 n167 U161/net14 VDD pmos W=0.28u L=0.04u
M141 U161/net4 n170 VDD VDD pmos W=0.205u L=0.04u
M142 U161/net6 U161/net4 VDD VDD pmos W=0.24u L=0.04u
M143 n169 U161/net14 VDD VDD pmos W=0.205u L=0.04u
M144 U161/net10 n167 VDD VDD pmos W=0.205u L=0.04u
M145 n168 n164 U162/net15 VSS nmos W=0.155u L=0.04u
M146 n168 n140 U162/net15 VSS nmos W=0.155u L=0.04u
M147 U162/net15 n136 VSS VSS nmos W=0.155u L=0.04u
M148 n168 n136 VDD VDD pmos W=0.205u L=0.04u
M149 n168 n164 U162/XI16-net11 VDD pmos W=0.205u L=0.04u
M150 U162/XI16-net11 n140 VDD VDD pmos W=0.205u L=0.04u
M151 U163/net11 n164 VSS VSS nmos W=0.155u L=0.04u
M152 U163/net11 n171 VSS VSS nmos W=0.155u L=0.04u
M153 n167 n172 VSS VSS nmos W=0.155u L=0.04u
M154 n167 U163/net11 VSS VSS nmos W=0.155u L=0.04u
M155 U163/XI1-net8 n171 VDD VDD pmos W=0.205u L=0.04u
M156 U163/net11 n164 U163/XI1-net8 VDD pmos W=0.205u L=0.04u
M157 U163/XU39-net8 U163/net11 VDD VDD pmos W=0.205u L=0.04u
M158 n167 n172 U163/XU39-net8 VDD pmos W=0.205u L=0.04u
M159 n155 N210 VSS VSS nmos W=0.135u L=0.04u
M160 n155 N210 VDD VDD pmos W=0.205u L=0.04u
M161 n154 N246 VSS VSS nmos W=0.135u L=0.04u
M162 n154 N246 VDD VDD pmos W=0.205u L=0.04u
M163 U166/net36 n175 U166/net24 VSS nmos W=0.155u L=0.04u
M164 U166/net24 n176 VSS VSS nmos W=0.155u L=0.04u
M165 N874 n173 U166/net36 VSS nmos W=0.155u L=0.04u
M166 N874 n174 U166/net36 VSS nmos W=0.155u L=0.04u
M167 N874 n174 U166/net35 VDD pmos W=0.205u L=0.04u
M168 U166/net35 n173 VDD VDD pmos W=0.205u L=0.04u
M169 N874 n176 VDD VDD pmos W=0.205u L=0.04u
M170 N874 n175 VDD VDD pmos W=0.205u L=0.04u
M171 n176 n178 U167/XI21-net17 VSS nmos W=0.155u L=0.04u
M172 U167/XI21-net17 N177 VSS VSS nmos W=0.155u L=0.04u
M173 n176 N210 U167/XI6-net17 VSS nmos W=0.155u L=0.04u
M174 U167/XI6-net17 N101 VSS VSS nmos W=0.155u L=0.04u
M175 n176 N246 U167/XI20-net17 VSS nmos W=0.155u L=0.04u
M176 U167/XI20-net17 n177 VSS VSS nmos W=0.155u L=0.04u
M177 VDD n178 U167/net22 VDD pmos W=0.205u L=0.04u
M178 VDD N177 U167/net22 VDD pmos W=0.205u L=0.04u
M179 U167/net16 N210 n176 VDD pmos W=0.205u L=0.04u
M180 U167/net16 N101 n176 VDD pmos W=0.205u L=0.04u
M181 U167/net22 N246 U167/net16 VDD pmos W=0.205u L=0.04u
M182 U167/net22 n177 U167/net16 VDD pmos W=0.205u L=0.04u
M183 U168/net17 n150 VSS VSS nmos W=0.155u L=0.04u
M184 U168/net17 n140 VSS VSS nmos W=0.155u L=0.04u
M185 U168/net63 N219 VSS VSS nmos W=0.155u L=0.04u
M186 n175 U168/net17 VSS VSS nmos W=0.155u L=0.04u
M187 n175 n179 U168/net63 VSS nmos W=0.155u L=0.04u
M188 n175 N219 U168/net31 VDD pmos W=0.205u L=0.04u
M189 U168/net39 n150 VDD VDD pmos W=0.195u L=0.04u
M190 U168/net31 U168/net17 VDD VDD pmos W=0.195u L=0.04u
M191 n175 n179 U168/net31 VDD pmos W=0.195u L=0.04u
M192 U168/net17 n140 U168/net39 VDD pmos W=0.195u L=0.04u
M193 U169/net4 U169/net10 U169/net14 VSS nmos W=0.155u L=0.04u
M194 U169/net6 n148 U169/net14 VSS nmos W=0.155u L=0.04u
M195 U169/net4 n174 VSS VSS nmos W=0.155u L=0.04u
M196 U169/net6 U169/net4 VSS VSS nmos W=0.155u L=0.04u
M197 n179 U169/net14 VSS VSS nmos W=0.155u L=0.04u
M198 U169/net10 n148 VSS VSS nmos W=0.155u L=0.04u
M199 U169/net4 n148 U169/net14 VDD pmos W=0.205u L=0.04u
M200 U169/net6 U169/net10 U169/net14 VDD pmos W=0.205u L=0.04u
M201 U169/net4 n174 VDD VDD pmos W=0.205u L=0.04u
M202 U169/net6 U169/net4 VDD VDD pmos W=0.205u L=0.04u
M203 n179 U169/net14 VDD VDD pmos W=0.205u L=0.04u
M204 U169/net10 n148 VDD VDD pmos W=0.205u L=0.04u
M205 U170/net13 n149 VSS VSS nmos W=0.155u L=0.04u
M206 U170/net16 U170/net13 VSS VSS nmos W=0.155u L=0.04u
M207 n174 n150 U170/net16 VSS nmos W=0.155u L=0.04u
M208 U170/net13 n149 VDD VDD pmos W=0.205u L=0.04u
M209 VDD U170/net13 n174 VDD pmos W=0.205u L=0.04u
M210 VDD n150 n174 VDD pmos W=0.205u L=0.04u
M211 N866 n164 U171/net10 VSS nmos W=0.155u L=0.04u
M212 U171/net10 n172 VSS VSS nmos W=0.155u L=0.04u
M213 N866 n171 U171/net10 VSS nmos W=0.155u L=0.04u
M214 U171/net10 n170 VSS VSS nmos W=0.155u L=0.04u
M215 U171/net30 n172 VDD VDD pmos W=0.205u L=0.04u
M216 N866 n164 U171/net24 VDD pmos W=0.205u L=0.04u
M217 U171/net24 n171 VDD VDD pmos W=0.205u L=0.04u
M218 N866 n170 U171/net30 VDD pmos W=0.205u L=0.04u
M219 n172 U172/net6 VSS VSS nmos W=0.155u L=0.04u
M220 U172/X_u2-net6 n171 VSS VSS nmos W=0.155u L=0.04u
M221 U172/net6 n164 U172/X_u2-net6 VSS nmos W=0.155u L=0.04u
M222 n172 U172/net6 VDD VDD pmos W=0.205u L=0.04u
M223 U172/net6 n171 VDD VDD pmos W=0.205u L=0.04u
M224 U172/net6 n164 VDD VDD pmos W=0.205u L=0.04u
M225 n170 n181 VSS VSS nmos W=0.155u L=0.04u
M226 n170 n180 U173/XI17-net17 VSS nmos W=0.155u L=0.04u
M227 U173/XI17-net17 N165 VSS VSS nmos W=0.155u L=0.04u
M228 n170 n163 U173/XI10-net17 VSS nmos W=0.155u L=0.04u
M229 U173/XI10-net17 n152 VSS VSS nmos W=0.155u L=0.04u
M230 U173/net30 n163 n170 VDD pmos W=0.205u L=0.04u
M231 U173/net30 n152 n170 VDD pmos W=0.205u L=0.04u
M232 VDD n181 U173/net36 VDD pmos W=0.205u L=0.04u
M233 U173/net36 N165 U173/net30 VDD pmos W=0.205u L=0.04u
M234 U173/net36 n180 U173/net30 VDD pmos W=0.205u L=0.04u
M235 U174/net14 n147 U174/net20 VSS nmos W=0.155u L=0.04u
M236 U174/net14 n151 U174/net20 VSS nmos W=0.155u L=0.04u
M237 U174/net20 n163 VSS VSS nmos W=0.155u L=0.04u
M238 n181 U174/net14 VSS VSS nmos W=0.155u L=0.04u
M239 n181 U174/net14 VDD VDD pmos W=0.205u L=0.04u
M240 U174/net14 n163 VDD VDD pmos W=0.205u L=0.04u
M241 U174/net24 n147 VDD VDD pmos W=0.205u L=0.04u
M242 U174/net14 n151 U174/net24 VDD pmos W=0.205u L=0.04u
M243 n147 n142 VSS VSS nmos W=0.135u L=0.04u
M244 n147 n142 VDD VDD pmos W=0.205u L=0.04u
M245 U176/XU1-net6 n146 VSS VSS nmos W=0.155u L=0.04u
M246 n142 N171 U176/XU1-net6 VSS nmos W=0.155u L=0.04u
M247 n142 n146 VDD VDD pmos W=0.155u L=0.04u
M248 n142 N171 VDD VDD pmos W=0.155u L=0.04u
M249 n151 n149 VSS VSS nmos W=0.155u L=0.04u
M250 n151 n143 VSS VSS nmos W=0.155u L=0.04u
M251 n151 n148 VSS VSS nmos W=0.155u L=0.04u
M252 U177/net25 n149 VDD VDD pmos W=0.41u L=0.04u
M253 U177/net28 n143 U177/net25 VDD pmos W=0.41u L=0.04u
M254 n151 n148 U177/net28 VDD pmos W=0.41u L=0.04u
M255 n149 n177 VSS VSS nmos W=0.155u L=0.04u
M256 n149 N177 VSS VSS nmos W=0.155u L=0.04u
M257 U178/XI1-net8 N177 VDD VDD pmos W=0.205u L=0.04u
M258 n149 n177 U178/XI1-net8 VDD pmos W=0.205u L=0.04u
M259 U179/net14 n183 U179/net20 VSS nmos W=0.155u L=0.04u
M260 U179/net14 n182 U179/net20 VSS nmos W=0.155u L=0.04u
M261 U179/net20 n184 VSS VSS nmos W=0.155u L=0.04u
M262 n148 U179/net14 VSS VSS nmos W=0.155u L=0.04u
M263 n148 U179/net14 VDD VDD pmos W=0.205u L=0.04u
M264 U179/net14 n184 VDD VDD pmos W=0.205u L=0.04u
M265 U179/net24 n183 VDD VDD pmos W=0.205u L=0.04u
M266 U179/net14 n182 U179/net24 VDD pmos W=0.205u L=0.04u
M267 n182 N183 VSS VSS nmos W=0.155u L=0.04u
M268 n182 n185 VSS VSS nmos W=0.155u L=0.04u
M269 U180/XI1-net8 n185 VDD VDD pmos W=0.205u L=0.04u
M270 n182 N183 U180/XI1-net8 VDD pmos W=0.205u L=0.04u
M271 n152 n150 VSS VSS nmos W=0.155u L=0.04u
M272 n152 n143 VSS VSS nmos W=0.155u L=0.04u
M273 U181/XI1-net8 n143 VDD VDD pmos W=0.205u L=0.04u
M274 n152 n150 U181/XI1-net8 VDD pmos W=0.205u L=0.04u
M275 n143 n146 VSS VSS nmos W=0.155u L=0.04u
M276 n143 N171 VSS VSS nmos W=0.155u L=0.04u
M277 U182/XI1-net8 N171 VDD VDD pmos W=0.205u L=0.04u
M278 n143 n146 U182/XI1-net8 VDD pmos W=0.205u L=0.04u
M279 U183/net36 n188 U183/net24 VSS nmos W=0.155u L=0.04u
M280 U183/net24 n189 VSS VSS nmos W=0.155u L=0.04u
M281 n146 n186 U183/net36 VSS nmos W=0.155u L=0.04u
M282 n146 n187 U183/net36 VSS nmos W=0.155u L=0.04u
M283 n146 n187 U183/net35 VDD pmos W=0.205u L=0.04u
M284 U183/net35 n186 VDD VDD pmos W=0.205u L=0.04u
M285 n146 n189 VDD VDD pmos W=0.205u L=0.04u
M286 n146 n188 VDD VDD pmos W=0.205u L=0.04u
M287 U184/net29 N17 VSS VSS nmos W=0.155u L=0.04u
M288 n189 N138 U184/net29 VSS nmos W=0.155u L=0.04u
M289 n189 N101 U184/net23 VSS nmos W=0.155u L=0.04u
M290 U184/net23 n190 VSS VSS nmos W=0.155u L=0.04u
M291 U184/net20 n190 n189 VDD pmos W=0.205u L=0.04u
M292 U184/net20 N101 n189 VDD pmos W=0.205u L=0.04u
M293 VDD N138 U184/net20 VDD pmos W=0.205u L=0.04u
M294 VDD N17 U184/net20 VDD pmos W=0.205u L=0.04u
M295 U185/XU1-net6 n177 VSS VSS nmos W=0.155u L=0.04u
M296 n150 N177 U185/XU1-net6 VSS nmos W=0.155u L=0.04u
M297 n150 n177 VDD VDD pmos W=0.155u L=0.04u
M298 n150 N177 VDD VDD pmos W=0.155u L=0.04u
M299 U186/net36 n188 U186/net24 VSS nmos W=0.155u L=0.04u
M300 U186/net24 n192 VSS VSS nmos W=0.155u L=0.04u
M301 n177 n186 U186/net36 VSS nmos W=0.155u L=0.04u
M302 n177 n191 U186/net36 VSS nmos W=0.155u L=0.04u
M303 n177 n191 U186/net35 VDD pmos W=0.205u L=0.04u
M304 U186/net35 n186 VDD VDD pmos W=0.205u L=0.04u
M305 n177 n192 VDD VDD pmos W=0.205u L=0.04u
M306 n177 n188 VDD VDD pmos W=0.205u L=0.04u
M307 U187/net29 N138 VSS VSS nmos W=0.155u L=0.04u
M308 n192 N152 U187/net29 VSS nmos W=0.155u L=0.04u
M309 n192 N106 U187/net23 VSS nmos W=0.155u L=0.04u
M310 U187/net23 n190 VSS VSS nmos W=0.155u L=0.04u
M311 U187/net20 n190 n192 VDD pmos W=0.205u L=0.04u
M312 U187/net20 N106 n192 VDD pmos W=0.205u L=0.04u
M313 VDD N152 U187/net20 VDD pmos W=0.205u L=0.04u
M314 VDD N138 U187/net20 VDD pmos W=0.205u L=0.04u
M315 U188/XU1-net6 n162 VSS VSS nmos W=0.155u L=0.04u
M316 n163 n153 U188/XU1-net6 VSS nmos W=0.155u L=0.04u
M317 n163 n162 VDD VDD pmos W=0.155u L=0.04u
M318 n163 n153 VDD VDD pmos W=0.155u L=0.04u
M319 n162 N165 VSS VSS nmos W=0.135u L=0.04u
M320 n162 N165 VDD VDD pmos W=0.205u L=0.04u
M321 n153 n180 VSS VSS nmos W=0.135u L=0.04u
M322 n153 n180 VDD VDD pmos W=0.205u L=0.04u
M323 U191/net36 n188 U191/net24 VSS nmos W=0.155u L=0.04u
M324 U191/net24 n194 VSS VSS nmos W=0.155u L=0.04u
M325 n180 n186 U191/net36 VSS nmos W=0.155u L=0.04u
M326 n180 n193 U191/net36 VSS nmos W=0.155u L=0.04u
M327 n180 n193 U191/net35 VDD pmos W=0.205u L=0.04u
M328 U191/net35 n186 VDD VDD pmos W=0.205u L=0.04u
M329 n180 n194 VDD VDD pmos W=0.205u L=0.04u
M330 n180 n188 VDD VDD pmos W=0.205u L=0.04u
M331 U192/net29 N51 VSS VSS nmos W=0.155u L=0.04u
M332 n194 N138 U192/net29 VSS nmos W=0.155u L=0.04u
M333 n194 N96 U192/net23 VSS nmos W=0.155u L=0.04u
M334 U192/net23 n190 VSS VSS nmos W=0.155u L=0.04u
M335 U192/net20 n190 n194 VDD pmos W=0.205u L=0.04u
M336 U192/net20 N96 n194 VDD pmos W=0.205u L=0.04u
M337 VDD N138 U192/net20 VDD pmos W=0.205u L=0.04u
M338 VDD N51 U192/net20 VDD pmos W=0.205u L=0.04u
M339 n164 n195 VSS VSS nmos W=0.155u L=0.04u
M340 n164 N8 U193/XI17-net17 VSS nmos W=0.155u L=0.04u
M341 U193/XI17-net17 N138 VSS VSS nmos W=0.155u L=0.04u
M342 n164 n190 U193/XI10-net17 VSS nmos W=0.155u L=0.04u
M343 U193/XI10-net17 N91 VSS VSS nmos W=0.155u L=0.04u
M344 U193/net30 n190 n164 VDD pmos W=0.205u L=0.04u
M345 U193/net30 N91 n164 VDD pmos W=0.205u L=0.04u
M346 VDD n195 U193/net36 VDD pmos W=0.205u L=0.04u
M347 U193/net36 N138 U193/net30 VDD pmos W=0.205u L=0.04u
M348 U193/net36 N8 U193/net30 VDD pmos W=0.205u L=0.04u
M349 n195 n196 U194/net27 VSS nmos W=0.155u L=0.04u
M350 U194/net27 n188 VSS VSS nmos W=0.155u L=0.04u
M351 n195 n186 VSS VSS nmos W=0.155u L=0.04u
M352 n195 n188 U194/net13 VDD pmos W=0.205u L=0.04u
M353 U194/net13 n186 VDD VDD pmos W=0.205u L=0.04u
M354 n195 n196 U194/net13 VDD pmos W=0.205u L=0.04u
M355 n186 N55 U195/net19 VDD pmos W=0.205u L=0.04u
M356 n186 N447 U195/net19 VDD pmos W=0.205u L=0.04u
M357 n186 n197 U195/net19 VDD pmos W=0.205u L=0.04u
M358 U195/net19 n198 VDD VDD pmos W=0.205u L=0.04u
M359 n186 n198 VSS VSS nmos W=0.155u L=0.04u
M360 U195/XI20-net13 N447 VSS VSS nmos W=0.155u L=0.04u
M361 n186 N55 U195/XI20-net17 VSS nmos W=0.155u L=0.04u
M362 U195/XI20-net17 n197 U195/XI20-net13 VSS nmos W=0.155u L=0.04u
M363 n198 n188 VSS VSS nmos W=0.135u L=0.04u
M364 n198 n188 VDD VDD pmos W=0.205u L=0.04u
M365 n188 n199 U197/XI0-net10 VSS nmos W=0.155u L=0.04u
M366 U197/XI0-net10 n165 U197/XI0-net13 VSS nmos W=0.155u L=0.04u
M367 U197/XI0-net13 N17 VSS VSS nmos W=0.155u L=0.04u
M368 n188 N17 VDD VDD pmos W=0.205u L=0.04u
M369 n188 n199 VDD VDD pmos W=0.205u L=0.04u
M370 n188 n165 VDD VDD pmos W=0.205u L=0.04u
M371 U198/net36 n201 U198/net24 VSS nmos W=0.155u L=0.04u
M372 U198/net24 n202 VSS VSS nmos W=0.155u L=0.04u
M373 N865 n200 U198/net36 VSS nmos W=0.155u L=0.04u
M374 N865 n136 U198/net36 VSS nmos W=0.155u L=0.04u
M375 N865 n136 U198/net35 VDD pmos W=0.205u L=0.04u
M376 U198/net35 n200 VDD VDD pmos W=0.205u L=0.04u
M377 N865 n202 VDD VDD pmos W=0.205u L=0.04u
M378 N865 n201 VDD VDD pmos W=0.205u L=0.04u
M379 n202 n203 VSS VSS nmos W=0.155u L=0.04u
M380 n202 N260 U199/XI17-net17 VSS nmos W=0.155u L=0.04u
M381 U199/XI17-net17 N255 VSS VSS nmos W=0.155u L=0.04u
M382 n202 N210 U199/XI10-net17 VSS nmos W=0.155u L=0.04u
M383 U199/XI10-net17 N116 VSS VSS nmos W=0.155u L=0.04u
M384 U199/net30 N210 n202 VDD pmos W=0.205u L=0.04u
M385 U199/net30 N116 n202 VDD pmos W=0.205u L=0.04u
M386 VDD n203 U199/net36 VDD pmos W=0.205u L=0.04u
M387 U199/net36 N255 U199/net30 VDD pmos W=0.205u L=0.04u
M388 U199/net36 N260 U199/net30 VDD pmos W=0.205u L=0.04u
M389 U200/net19 n205 VSS VSS nmos W=0.155u L=0.04u
M390 n203 n205 U200/net40 VSS nmos W=0.155u L=0.04u
M391 n203 U200/net19 U200/net36 VSS nmos W=0.155u L=0.04u
M392 U200/net40 n204 VSS VSS nmos W=0.31u L=0.04u
M393 U200/net36 n140 VSS VSS nmos W=0.155u L=0.04u
M394 U200/net19 n205 VDD VDD pmos W=0.205u L=0.04u
M395 n203 U200/net19 U200/net26 VDD pmos W=0.325u L=0.04u
M396 U200/net26 n204 VDD VDD pmos W=0.41u L=0.04u
M397 n203 n205 U200/net30 VDD pmos W=0.325u L=0.04u
M398 U200/net30 n140 VDD VDD pmos W=0.205u L=0.04u
M399 U201/net13 n206 VSS VSS nmos W=0.155u L=0.04u
M400 U201/net16 U201/net13 VSS VSS nmos W=0.155u L=0.04u
M401 n204 N228 U201/net16 VSS nmos W=0.155u L=0.04u
M402 U201/net13 n206 VDD VDD pmos W=0.205u L=0.04u
M403 VDD U201/net13 n204 VDD pmos W=0.205u L=0.04u
M404 VDD N228 n204 VDD pmos W=0.205u L=0.04u
M405 n201 n207 U202/net23 VDD pmos W=0.205u L=0.04u
M406 n201 N219 U202/net23 VDD pmos W=0.205u L=0.04u
M407 n201 n208 U202/net23 VDD pmos W=0.205u L=0.04u
M408 U202/net23 N246 VDD VDD pmos W=0.205u L=0.04u
M409 U202/net23 n209 VDD VDD pmos W=0.205u L=0.04u
M410 U202/XI20-net13 N219 VSS VSS nmos W=0.155u L=0.04u
M411 n201 n207 U202/XI20-net17 VSS nmos W=0.155u L=0.04u
M412 U202/XI20-net17 n208 U202/XI20-net13 VSS nmos W=0.155u L=0.04u
M413 n201 N246 U202/XI17-net17 VSS nmos W=0.155u L=0.04u
M414 U202/XI17-net17 n209 VSS VSS nmos W=0.155u L=0.04u
M415 U203/net36 n211 U203/net24 VSS nmos W=0.155u L=0.04u
M416 U203/net24 n212 VSS VSS nmos W=0.155u L=0.04u
M417 n208 n206 U203/net36 VSS nmos W=0.155u L=0.04u
M418 n208 n210 U203/net36 VSS nmos W=0.155u L=0.04u
M419 n208 n210 U203/net35 VDD pmos W=0.205u L=0.04u
M420 U203/net35 n206 VDD VDD pmos W=0.205u L=0.04u
M421 n208 n212 VDD VDD pmos W=0.205u L=0.04u
M422 n208 n211 VDD VDD pmos W=0.205u L=0.04u
M423 n207 n213 U204/net15 VSS nmos W=0.155u L=0.04u
M424 n207 n214 U204/net15 VSS nmos W=0.155u L=0.04u
M425 U204/net15 n205 VSS VSS nmos W=0.155u L=0.04u
M426 n207 n205 VDD VDD pmos W=0.205u L=0.04u
M427 n207 n213 U204/XI16-net11 VDD pmos W=0.205u L=0.04u
M428 U204/XI16-net11 n214 VDD VDD pmos W=0.205u L=0.04u
M429 n200 N195 VSS VSS nmos W=0.135u L=0.04u
M430 n200 N195 VDD VDD pmos W=0.205u L=0.04u
M431 U206/net36 n216 U206/net24 VSS nmos W=0.155u L=0.04u
M432 U206/net24 n217 VSS VSS nmos W=0.155u L=0.04u
M433 N864 n173 U206/net36 VSS nmos W=0.155u L=0.04u
M434 N864 n215 U206/net36 VSS nmos W=0.155u L=0.04u
M435 N864 n215 U206/net35 VDD pmos W=0.205u L=0.04u
M436 U206/net35 n173 VDD VDD pmos W=0.205u L=0.04u
M437 N864 n217 VDD VDD pmos W=0.205u L=0.04u
M438 N864 n216 VDD VDD pmos W=0.205u L=0.04u
M439 n217 N210 U207/XI21-net17 VSS nmos W=0.155u L=0.04u
M440 U207/XI21-net17 N111 VSS VSS nmos W=0.155u L=0.04u
M441 n217 N259 U207/XI6-net17 VSS nmos W=0.155u L=0.04u
M442 U207/XI6-net17 N255 VSS VSS nmos W=0.155u L=0.04u
M443 n217 N246 U207/XI20-net17 VSS nmos W=0.155u L=0.04u
M444 U207/XI20-net17 n218 VSS VSS nmos W=0.155u L=0.04u
M445 VDD N210 U207/net22 VDD pmos W=0.205u L=0.04u
M446 VDD N111 U207/net22 VDD pmos W=0.205u L=0.04u
M447 U207/net16 N259 n217 VDD pmos W=0.205u L=0.04u
M448 U207/net16 N255 n217 VDD pmos W=0.205u L=0.04u
M449 U207/net22 N246 U207/net16 VDD pmos W=0.205u L=0.04u
M450 U207/net22 n218 U207/net16 VDD pmos W=0.205u L=0.04u
M451 U208/net29 N219 VSS VSS nmos W=0.155u L=0.04u
M452 n216 n220 U208/net29 VSS nmos W=0.155u L=0.04u
M453 n216 N189 U208/net23 VSS nmos W=0.155u L=0.04u
M454 U208/net23 n219 VSS VSS nmos W=0.155u L=0.04u
M455 U208/net20 n219 n216 VDD pmos W=0.205u L=0.04u
M456 U208/net20 N189 n216 VDD pmos W=0.205u L=0.04u
M457 VDD n220 U208/net20 VDD pmos W=0.205u L=0.04u
M458 VDD N219 U208/net20 VDD pmos W=0.205u L=0.04u
M459 U209/net4 U209/net10 U209/net14 VSS nmos W=0.155u L=0.04u
M460 U209/net6 n221 U209/net14 VSS nmos W=0.155u L=0.04u
M461 U209/net4 n215 VSS VSS nmos W=0.155u L=0.04u
M462 U209/net6 U209/net4 VSS VSS nmos W=0.155u L=0.04u
M463 n220 U209/net14 VSS VSS nmos W=0.155u L=0.04u
M464 U209/net10 n221 VSS VSS nmos W=0.155u L=0.04u
M465 U209/net4 n221 U209/net14 VDD pmos W=0.205u L=0.04u
M466 U209/net6 U209/net10 U209/net14 VDD pmos W=0.205u L=0.04u
M467 U209/net4 n215 VDD VDD pmos W=0.205u L=0.04u
M468 U209/net6 U209/net4 VDD VDD pmos W=0.205u L=0.04u
M469 n220 U209/net14 VDD VDD pmos W=0.205u L=0.04u
M470 U209/net10 n221 VDD VDD pmos W=0.205u L=0.04u
M471 U210/XU35-net6 N237 VSS VSS nmos W=0.155u L=0.04u
M472 U210/net5 n218 U210/XU35-net6 VSS nmos W=0.155u L=0.04u
M473 U210/XU36-net6 U210/net5 VSS VSS nmos W=0.155u L=0.04u
M474 n219 n136 U210/XU36-net6 VSS nmos W=0.155u L=0.04u
M475 U210/net5 N237 VDD VDD pmos W=0.205u L=0.04u
M476 U210/net5 n218 VDD VDD pmos W=0.205u L=0.04u
M477 n219 U210/net5 VDD VDD pmos W=0.205u L=0.04u
M478 n219 n136 VDD VDD pmos W=0.205u L=0.04u
M479 U211/net32 N189 VSS VSS nmos W=0.155u L=0.04u
M480 U211/net59 n218 U211/net32 VSS nmos W=0.155u L=0.04u
M481 U211/net59 n222 VSS VSS nmos W=0.155u L=0.04u
M482 n215 U211/net59 VSS VSS nmos W=0.155u L=0.04u
M483 n215 U211/net59 VDD VDD pmos W=0.2u L=0.04u
M484 U211/net59 n218 U211/net22 VDD pmos W=0.205u L=0.04u
M485 U211/net59 N189 U211/net22 VDD pmos W=0.205u L=0.04u
M486 U211/net22 n222 VDD VDD pmos W=0.2u L=0.04u
M487 n173 N228 VSS VSS nmos W=0.135u L=0.04u
M488 n173 N228 VDD VDD pmos W=0.205u L=0.04u
M489 U213/net36 n223 U213/net24 VSS nmos W=0.155u L=0.04u
M490 U213/net24 n224 VSS VSS nmos W=0.155u L=0.04u
M491 N863 n140 U213/net36 VSS nmos W=0.155u L=0.04u
M492 N863 n184 U213/net36 VSS nmos W=0.155u L=0.04u
M493 N863 n184 U213/net35 VDD pmos W=0.205u L=0.04u
M494 U213/net35 n140 VDD VDD pmos W=0.205u L=0.04u
M495 N863 n224 VDD VDD pmos W=0.205u L=0.04u
M496 N863 n223 VDD VDD pmos W=0.205u L=0.04u
M497 n224 n178 U214/XI21-net17 VSS nmos W=0.155u L=0.04u
M498 U214/XI21-net17 N183 VSS VSS nmos W=0.155u L=0.04u
M499 n224 N210 U214/XI6-net17 VSS nmos W=0.155u L=0.04u
M500 U214/XI6-net17 N106 VSS VSS nmos W=0.155u L=0.04u
M501 n224 N246 U214/XI20-net17 VSS nmos W=0.155u L=0.04u
M502 U214/XI20-net17 n185 VSS VSS nmos W=0.155u L=0.04u
M503 VDD n178 U214/net22 VDD pmos W=0.205u L=0.04u
M504 VDD N183 U214/net22 VDD pmos W=0.205u L=0.04u
M505 U214/net16 N210 n224 VDD pmos W=0.205u L=0.04u
M506 U214/net16 N106 n224 VDD pmos W=0.205u L=0.04u
M507 U214/net22 N246 U214/net16 VDD pmos W=0.205u L=0.04u
M508 U214/net22 n185 U214/net16 VDD pmos W=0.205u L=0.04u
M509 U215/net29 N228 VSS VSS nmos W=0.155u L=0.04u
M510 n223 n226 U215/net29 VSS nmos W=0.155u L=0.04u
M511 n223 n225 U215/net23 VSS nmos W=0.155u L=0.04u
M512 U215/net23 N219 VSS VSS nmos W=0.155u L=0.04u
M513 U215/net20 N219 n223 VDD pmos W=0.205u L=0.04u
M514 U215/net20 n225 n223 VDD pmos W=0.205u L=0.04u
M515 VDD n226 U215/net20 VDD pmos W=0.205u L=0.04u
M516 VDD N228 U215/net20 VDD pmos W=0.205u L=0.04u
M517 U216/net4 n183 U216/net14 VSS nmos W=0.155u L=0.04u
M518 U216/net6 U216/net10 U216/net14 VSS nmos W=0.17u L=0.04u
M519 U216/net4 n226 VSS VSS nmos W=0.155u L=0.04u
M520 U216/net6 U216/net4 VSS VSS nmos W=0.17u L=0.04u
M521 n225 U216/net14 VSS VSS nmos W=0.155u L=0.04u
M522 U216/net10 n183 VSS VSS nmos W=0.155u L=0.04u
M523 U216/net4 U216/net10 U216/net14 VDD pmos W=0.255u L=0.04u
M524 U216/net6 n183 U216/net14 VDD pmos W=0.28u L=0.04u
M525 U216/net4 n226 VDD VDD pmos W=0.205u L=0.04u
M526 U216/net6 U216/net4 VDD VDD pmos W=0.24u L=0.04u
M527 n225 U216/net14 VDD VDD pmos W=0.205u L=0.04u
M528 U216/net10 n183 VDD VDD pmos W=0.205u L=0.04u
M529 U217/net14 n185 U217/net20 VSS nmos W=0.155u L=0.04u
M530 U217/net14 N183 U217/net20 VSS nmos W=0.155u L=0.04u
M531 U217/net20 n184 VSS VSS nmos W=0.155u L=0.04u
M532 n226 U217/net14 VSS VSS nmos W=0.155u L=0.04u
M533 n226 U217/net14 VDD VDD pmos W=0.205u L=0.04u
M534 U217/net14 n184 VDD VDD pmos W=0.205u L=0.04u
M535 U217/net24 n185 VDD VDD pmos W=0.205u L=0.04u
M536 U217/net14 N183 U217/net24 VDD pmos W=0.205u L=0.04u
M537 U218/net17 n221 VSS VSS nmos W=0.155u L=0.04u
M538 U218/net17 n222 VSS VSS nmos W=0.155u L=0.04u
M539 U218/net63 N189 VSS VSS nmos W=0.155u L=0.04u
M540 n183 U218/net17 VSS VSS nmos W=0.155u L=0.04u
M541 n183 n218 U218/net63 VSS nmos W=0.155u L=0.04u
M542 n183 N189 U218/net31 VDD pmos W=0.205u L=0.04u
M543 U218/net39 n221 VDD VDD pmos W=0.195u L=0.04u
M544 U218/net31 U218/net17 VDD VDD pmos W=0.195u L=0.04u
M545 n183 n218 U218/net31 VDD pmos W=0.195u L=0.04u
M546 U218/net17 n222 U218/net39 VDD pmos W=0.195u L=0.04u
M547 n221 n214 VSS VSS nmos W=0.155u L=0.04u
M548 n221 n210 VSS VSS nmos W=0.155u L=0.04u
M549 n221 n213 VSS VSS nmos W=0.155u L=0.04u
M550 U219/net25 n214 VDD VDD pmos W=0.41u L=0.04u
M551 U219/net28 n210 U219/net25 VDD pmos W=0.41u L=0.04u
M552 n221 n213 U219/net28 VDD pmos W=0.41u L=0.04u
M553 n214 n211 VSS VSS nmos W=0.155u L=0.04u
M554 n214 n206 VSS VSS nmos W=0.155u L=0.04u
M555 U220/XI1-net8 n206 VDD VDD pmos W=0.205u L=0.04u
M556 n214 n211 U220/XI1-net8 VDD pmos W=0.205u L=0.04u
M557 n210 n205 VSS VSS nmos W=0.135u L=0.04u
M558 n210 n205 VDD VDD pmos W=0.205u L=0.04u
M559 U222/XU1-net6 n209 VSS VSS nmos W=0.155u L=0.04u
M560 n205 N195 U222/XU1-net6 VSS nmos W=0.155u L=0.04u
M561 n205 n209 VDD VDD pmos W=0.155u L=0.04u
M562 n205 N195 VDD VDD pmos W=0.155u L=0.04u
M563 n213 n212 VSS VSS nmos W=0.155u L=0.04u
M564 n213 n206 VSS VSS nmos W=0.155u L=0.04u
M565 U223/XI1-net8 n206 VDD VDD pmos W=0.205u L=0.04u
M566 n213 n212 U223/XI1-net8 VDD pmos W=0.205u L=0.04u
M567 n206 n209 VSS VSS nmos W=0.155u L=0.04u
M568 n206 N195 VSS VSS nmos W=0.155u L=0.04u
M569 U224/XI1-net8 N195 VDD VDD pmos W=0.205u L=0.04u
M570 n206 n209 U224/XI1-net8 VDD pmos W=0.205u L=0.04u
M571 n209 n187 U225/net26 VSS nmos W=0.155u L=0.04u
M572 n209 n227 U225/net26 VSS nmos W=0.155u L=0.04u
M573 U225/net29 n230 VSS VSS nmos W=0.155u L=0.04u
M574 U225/net26 n228 U225/net29 VSS nmos W=0.155u L=0.04u
M575 U225/net26 n229 U225/net29 VSS nmos W=0.155u L=0.04u
M576 n209 n227 U225/net43 VDD pmos W=0.205u L=0.04u
M577 n209 n229 U225/net49 VDD pmos W=0.205u L=0.04u
M578 U225/net49 n228 VDD VDD pmos W=0.205u L=0.04u
M579 U225/net43 n187 VDD VDD pmos W=0.205u L=0.04u
M580 n209 n230 VDD VDD pmos W=0.205u L=0.04u
M581 n187 N149 VSS VSS nmos W=0.135u L=0.04u
M582 n187 N149 VDD VDD pmos W=0.205u L=0.04u
M583 n222 n218 VSS VSS nmos W=0.155u L=0.04u
M584 n222 N189 VSS VSS nmos W=0.155u L=0.04u
M585 U227/XI1-net8 N189 VDD VDD pmos W=0.205u L=0.04u
M586 n222 n218 U227/XI1-net8 VDD pmos W=0.205u L=0.04u
M587 n218 n231 U228/net26 VSS nmos W=0.155u L=0.04u
M588 n218 n228 U228/net26 VSS nmos W=0.155u L=0.04u
M589 U228/net29 n230 VSS VSS nmos W=0.155u L=0.04u
M590 U228/net26 n227 U228/net29 VSS nmos W=0.155u L=0.04u
M591 U228/net26 n193 U228/net29 VSS nmos W=0.155u L=0.04u
M592 n218 n228 U228/net43 VDD pmos W=0.205u L=0.04u
M593 n218 n193 U228/net49 VDD pmos W=0.205u L=0.04u
M594 U228/net49 n227 VDD VDD pmos W=0.205u L=0.04u
M595 U228/net43 n231 VDD VDD pmos W=0.205u L=0.04u
M596 n218 n230 VDD VDD pmos W=0.205u L=0.04u
M597 n193 N146 VSS VSS nmos W=0.135u L=0.04u
M598 n193 N146 VDD VDD pmos W=0.205u L=0.04u
M599 U230/XU1-net6 n185 VSS VSS nmos W=0.155u L=0.04u
M600 n184 N183 U230/XU1-net6 VSS nmos W=0.155u L=0.04u
M601 n184 n185 VDD VDD pmos W=0.155u L=0.04u
M602 n184 N183 VDD VDD pmos W=0.155u L=0.04u
M603 n185 n232 U231/net26 VSS nmos W=0.155u L=0.04u
M604 n185 n228 U231/net26 VSS nmos W=0.155u L=0.04u
M605 U231/net29 n230 VSS VSS nmos W=0.155u L=0.04u
M606 U231/net26 n227 U231/net29 VSS nmos W=0.155u L=0.04u
M607 U231/net26 n196 U231/net29 VSS nmos W=0.155u L=0.04u
M608 n185 n228 U231/net43 VDD pmos W=0.205u L=0.04u
M609 n185 n196 U231/net49 VDD pmos W=0.205u L=0.04u
M610 U231/net49 n227 VDD VDD pmos W=0.205u L=0.04u
M611 U231/net43 n232 VDD VDD pmos W=0.205u L=0.04u
M612 n185 n230 VDD VDD pmos W=0.205u L=0.04u
M613 n196 N143 VSS VSS nmos W=0.135u L=0.04u
M614 n196 N143 VDD VDD pmos W=0.205u L=0.04u
M615 N850 n233 U233/XI0-net10 VSS nmos W=0.155u L=0.04u
M616 U233/XI0-net10 n234 U233/XI0-net13 VSS nmos W=0.155u L=0.04u
M617 U233/XI0-net13 n235 VSS VSS nmos W=0.155u L=0.04u
M618 N850 n235 VDD VDD pmos W=0.205u L=0.04u
M619 N850 n233 VDD VDD pmos W=0.205u L=0.04u
M620 N850 n234 VDD VDD pmos W=0.205u L=0.04u
M621 n235 N210 U234/XI21-net17 VSS nmos W=0.155u L=0.04u
M622 U234/XI21-net17 N121 VSS VSS nmos W=0.155u L=0.04u
M623 n235 N267 U234/XI6-net17 VSS nmos W=0.155u L=0.04u
M624 U234/XI6-net17 N255 VSS VSS nmos W=0.155u L=0.04u
M625 n235 n178 U234/XI20-net17 VSS nmos W=0.155u L=0.04u
M626 U234/XI20-net17 N201 VSS VSS nmos W=0.155u L=0.04u
M627 VDD N210 U234/net22 VDD pmos W=0.205u L=0.04u
M628 VDD N121 U234/net22 VDD pmos W=0.205u L=0.04u
M629 U234/net16 N267 n235 VDD pmos W=0.205u L=0.04u
M630 U234/net16 N255 n235 VDD pmos W=0.205u L=0.04u
M631 U234/net22 n178 U234/net16 VDD pmos W=0.205u L=0.04u
M632 U234/net22 N201 U234/net16 VDD pmos W=0.205u L=0.04u
M633 n178 n136 VSS VSS nmos W=0.135u L=0.04u
M634 n178 n136 VDD VDD pmos W=0.205u L=0.04u
M635 U236/net20 n236 VSS VSS nmos W=0.155u L=0.04u
M636 n136 n237 U236/p0 VSS nmos W=0.155u L=0.04u
M637 U236/p2 U236/net20 VSS VSS nmos W=0.155u L=0.04u
M638 U236/p1 N73 U236/p2 VSS nmos W=0.155u L=0.04u
M639 U236/p0 N72 U236/p1 VSS nmos W=0.155u L=0.04u
M640 U236/net20 n236 VDD VDD pmos W=0.205u L=0.04u
M641 n136 N73 VDD VDD pmos W=0.205u L=0.04u
M642 n136 n237 VDD VDD pmos W=0.205u L=0.04u
M643 n136 N72 VDD VDD pmos W=0.205u L=0.04u
M644 n136 U236/net20 VDD VDD pmos W=0.205u L=0.04u
M645 n237 n238 VSS VSS nmos W=0.155u L=0.04u
M646 n237 n239 VSS VSS nmos W=0.155u L=0.04u
M647 U237/XI1-net8 n239 VDD VDD pmos W=0.205u L=0.04u
M648 n237 n238 U237/XI1-net8 VDD pmos W=0.205u L=0.04u
M649 U238/net29 N228 VSS VSS nmos W=0.155u L=0.04u
M650 n234 n241 U238/net29 VSS nmos W=0.155u L=0.04u
M651 n234 n240 U238/net23 VSS nmos W=0.155u L=0.04u
M652 U238/net23 N219 VSS VSS nmos W=0.155u L=0.04u
M653 U238/net20 N219 n234 VDD pmos W=0.205u L=0.04u
M654 U238/net20 n240 n234 VDD pmos W=0.205u L=0.04u
M655 VDD n241 U238/net20 VDD pmos W=0.205u L=0.04u
M656 VDD N228 U238/net20 VDD pmos W=0.205u L=0.04u
M657 U239/net17 n241 VSS VSS nmos W=0.155u L=0.04u
M658 U239/net17 N261 VSS VSS nmos W=0.155u L=0.04u
M659 U239/net63 n212 VSS VSS nmos W=0.155u L=0.04u
M660 n240 U239/net17 VSS VSS nmos W=0.155u L=0.04u
M661 n240 n242 U239/net63 VSS nmos W=0.155u L=0.04u
M662 n240 n212 U239/net31 VDD pmos W=0.205u L=0.04u
M663 U239/net39 n241 VDD VDD pmos W=0.195u L=0.04u
M664 U239/net31 U239/net17 VDD VDD pmos W=0.195u L=0.04u
M665 n240 n242 U239/net31 VDD pmos W=0.195u L=0.04u
M666 U239/net17 N261 U239/net39 VDD pmos W=0.195u L=0.04u
M667 U240/net14 n243 U240/net20 VSS nmos W=0.155u L=0.04u
M668 U240/net14 N201 U240/net20 VSS nmos W=0.155u L=0.04u
M669 U240/net20 n212 VSS VSS nmos W=0.155u L=0.04u
M670 n241 U240/net14 VSS VSS nmos W=0.155u L=0.04u
M671 n241 U240/net14 VDD VDD pmos W=0.205u L=0.04u
M672 U240/net14 n212 VDD VDD pmos W=0.205u L=0.04u
M673 U240/net24 n243 VDD VDD pmos W=0.205u L=0.04u
M674 U240/net14 N201 U240/net24 VDD pmos W=0.205u L=0.04u
M675 n242 n211 VSS VSS nmos W=0.135u L=0.04u
M676 n242 n211 VDD VDD pmos W=0.205u L=0.04u
M677 n211 N201 U242/net15 VSS nmos W=0.155u L=0.04u
M678 n211 n243 U242/net15 VSS nmos W=0.155u L=0.04u
M679 U242/net15 N261 VSS VSS nmos W=0.155u L=0.04u
M680 n211 N261 VDD VDD pmos W=0.205u L=0.04u
M681 n211 N201 U242/XI16-net11 VDD pmos W=0.205u L=0.04u
M682 U242/XI16-net11 n243 VDD VDD pmos W=0.205u L=0.04u
M683 U243/net17 n212 VSS VSS nmos W=0.155u L=0.04u
M684 U243/net17 n140 VSS VSS nmos W=0.155u L=0.04u
M685 U243/net63 n243 VSS VSS nmos W=0.155u L=0.04u
M686 n233 U243/net17 VSS VSS nmos W=0.155u L=0.04u
M687 n233 N246 U243/net63 VSS nmos W=0.155u L=0.04u
M688 n233 n243 U243/net31 VDD pmos W=0.205u L=0.04u
M689 U243/net39 n212 VDD VDD pmos W=0.195u L=0.04u
M690 U243/net31 U243/net17 VDD VDD pmos W=0.195u L=0.04u
M691 n233 N246 U243/net31 VDD pmos W=0.195u L=0.04u
M692 U243/net17 n140 U243/net39 VDD pmos W=0.195u L=0.04u
M693 U244/XU1-net6 n243 VSS VSS nmos W=0.155u L=0.04u
M694 n212 N201 U244/XU1-net6 VSS nmos W=0.155u L=0.04u
M695 n212 n243 VDD VDD pmos W=0.155u L=0.04u
M696 n212 N201 VDD VDD pmos W=0.155u L=0.04u
M697 n140 N237 VSS VSS nmos W=0.135u L=0.04u
M698 n140 N237 VDD VDD pmos W=0.205u L=0.04u
M699 n243 n244 U246/net26 VSS nmos W=0.155u L=0.04u
M700 n243 n228 U246/net26 VSS nmos W=0.155u L=0.04u
M701 U246/net29 n230 VSS VSS nmos W=0.155u L=0.04u
M702 U246/net26 n227 U246/net29 VSS nmos W=0.155u L=0.04u
M703 U246/net26 n191 U246/net29 VSS nmos W=0.155u L=0.04u
M704 n243 n228 U246/net43 VDD pmos W=0.205u L=0.04u
M705 n243 n191 U246/net49 VDD pmos W=0.205u L=0.04u
M706 U246/net49 n227 VDD VDD pmos W=0.205u L=0.04u
M707 U246/net43 n244 VDD VDD pmos W=0.205u L=0.04u
M708 n243 n230 VDD VDD pmos W=0.205u L=0.04u
M709 n230 n199 U247/XI0-net10 VSS nmos W=0.155u L=0.04u
M710 U247/XI0-net10 n165 U247/XI0-net13 VSS nmos W=0.155u L=0.04u
M711 U247/XI0-net13 N55 VSS VSS nmos W=0.155u L=0.04u
M712 n230 N55 VDD VDD pmos W=0.205u L=0.04u
M713 n230 n199 VDD VDD pmos W=0.205u L=0.04u
M714 n230 n165 VDD VDD pmos W=0.205u L=0.04u
M715 n165 N268 VSS VSS nmos W=0.135u L=0.04u
M716 n165 N268 VDD VDD pmos W=0.205u L=0.04u
M717 n199 n248 VSS VSS nmos W=0.155u L=0.04u
M718 n199 n247 VSS VSS nmos W=0.155u L=0.04u
M719 n199 n246 VSS VSS nmos W=0.155u L=0.04u
M720 n199 n245 VSS VSS nmos W=0.155u L=0.04u
M721 U249/net49 n247 U249/net52 VDD pmos W=0.41u L=0.04u
M722 U249/net52 n248 VDD VDD pmos W=0.41u L=0.04u
M723 U249/net46 n246 U249/net49 VDD pmos W=0.41u L=0.04u
M724 n199 n245 U249/net46 VDD pmos W=0.41u L=0.04u
M725 n191 N153 VSS VSS nmos W=0.135u L=0.04u
M726 n191 N153 VDD VDD pmos W=0.205u L=0.04u
M727 n227 N17 U251/net19 VDD pmos W=0.205u L=0.04u
M728 n227 N447 U251/net19 VDD pmos W=0.205u L=0.04u
M729 n227 n197 U251/net19 VDD pmos W=0.205u L=0.04u
M730 U251/net19 n249 VDD VDD pmos W=0.205u L=0.04u
M731 n227 n249 VSS VSS nmos W=0.155u L=0.04u
M732 U251/XI20-net13 N447 VSS VSS nmos W=0.155u L=0.04u
M733 n227 N17 U251/XI20-net17 VSS nmos W=0.155u L=0.04u
M734 U251/XI20-net17 n197 U251/XI20-net13 VSS nmos W=0.155u L=0.04u
M735 n244 N126 VSS VSS nmos W=0.135u L=0.04u
M736 n244 N126 VDD VDD pmos W=0.205u L=0.04u
M737 n228 n190 VSS VSS nmos W=0.135u L=0.04u
M738 n228 n190 VDD VDD pmos W=0.205u L=0.04u
M739 U254/net15 n252 VSS VSS nmos W=0.155u L=0.04u
M740 U254/net15 n251 VSS VSS nmos W=0.155u L=0.04u
M741 n190 n248 U254/net15 VSS nmos W=0.155u L=0.04u
M742 n190 n250 U254/net15 VSS nmos W=0.155u L=0.04u
M743 U254/net15 n253 VSS VSS nmos W=0.155u L=0.04u
M744 n190 n197 U254/net15 VSS nmos W=0.155u L=0.04u
M745 n190 n253 U254/XI1-net11 VDD pmos W=0.205u L=0.04u
M746 U254/XI1-net11 n252 U254/XI1-net18 VDD pmos W=0.205u L=0.04u
M747 U254/XI1-net18 n251 VDD VDD pmos W=0.205u L=0.04u
M748 n190 n248 U254/XI7-net11 VDD pmos W=0.205u L=0.04u
M749 U254/XI7-net11 n250 U254/XI7-net18 VDD pmos W=0.205u L=0.04u
M750 U254/XI7-net18 n197 VDD VDD pmos W=0.205u L=0.04u
M751 VSS N1 U255/net22 VSS nmos W=0.155u L=0.04u
M752 U255/net22 n238 n253 VSS nmos W=0.155u L=0.04u
M753 U255/net22 n246 n253 VSS nmos W=0.155u L=0.04u
M754 U255/net22 n239 n253 VSS nmos W=0.155u L=0.04u
M755 U255/net38 n239 VDD VDD pmos W=0.205u L=0.04u
M756 U255/net35 n246 U255/net38 VDD pmos W=0.205u L=0.04u
M757 n253 n238 U255/net35 VDD pmos W=0.205u L=0.04u
M758 n253 N1 VDD VDD pmos W=0.205u L=0.04u
M759 n252 N51 VSS VSS nmos W=0.135u L=0.04u
M760 n252 N51 VDD VDD pmos W=0.205u L=0.04u
M761 U257/XU1-net6 N17 VSS VSS nmos W=0.155u L=0.04u
M762 n251 N8 U257/XU1-net6 VSS nmos W=0.155u L=0.04u
M763 n251 N17 VDD VDD pmos W=0.155u L=0.04u
M764 n251 N8 VDD VDD pmos W=0.155u L=0.04u
M765 U258/net4 N42 U258/net14 VSS nmos W=0.155u L=0.04u
M766 U258/net6 U258/net10 U258/net14 VSS nmos W=0.17u L=0.04u
M767 U258/net4 N17 VSS VSS nmos W=0.155u L=0.04u
M768 U258/net6 U258/net4 VSS VSS nmos W=0.17u L=0.04u
M769 n250 U258/net14 VSS VSS nmos W=0.155u L=0.04u
M770 U258/net10 N42 VSS VSS nmos W=0.155u L=0.04u
M771 U258/net4 U258/net10 U258/net14 VDD pmos W=0.255u L=0.04u
M772 U258/net6 N42 U258/net14 VDD pmos W=0.28u L=0.04u
M773 U258/net4 N17 VDD VDD pmos W=0.205u L=0.04u
M774 U258/net6 U258/net4 VDD VDD pmos W=0.24u L=0.04u
M775 n250 U258/net14 VDD VDD pmos W=0.205u L=0.04u
M776 U258/net10 N42 VDD VDD pmos W=0.205u L=0.04u
M777 U259/XU1-net6 N156 VSS VSS nmos W=0.155u L=0.04u
M778 n197 N59 U259/XU1-net6 VSS nmos W=0.155u L=0.04u
M779 n197 N156 VDD VDD pmos W=0.155u L=0.04u
M780 n197 N59 VDD VDD pmos W=0.155u L=0.04u
M781 U260/net28 U260/net20 U260/net64 VSS nmos W=0.155u L=0.04u
M782 U260/net24 U260/net30 U260/net32 VSS nmos W=0.155u L=0.04u
M783 U260/net28 U260/net40 U260/net24 VSS nmos W=0.155u L=0.04u
M784 U260/net40 n255 U260/net108 VSS nmos W=0.155u L=0.04u
M785 U260/net40 U260/net106 U260/net104 VSS nmos W=0.155u L=0.04u
M786 U260/net24 N207 U260/net050 VSS nmos W=0.155u L=0.04u
M787 U260/net050 U260/net32 VSS VSS nmos W=0.155u L=0.04u
M788 U260/net20 U260/net40 VSS VSS nmos W=0.155u L=0.04u
M789 U260/net106 n255 VSS VSS nmos W=0.155u L=0.04u
M790 U260/net104 n254 VSS VSS nmos W=0.155u L=0.04u
M791 U260/net30 N207 VSS VSS nmos W=0.155u L=0.04u
M792 U260/net108 U260/net104 VSS VSS nmos W=0.155u L=0.04u
M793 N661 U260/net28 VSS VSS nmos W=0.155u L=0.04u
M794 U260/net32 N201 VSS VSS nmos W=0.155u L=0.04u
M795 U260/net64 U260/net24 VSS VSS nmos W=0.2u L=0.04u
M796 U260/net28 U260/net40 U260/net64 VDD pmos W=0.205u L=0.04u
M797 U260/net24 N207 U260/net32 VDD pmos W=0.205u L=0.04u
M798 U260/net28 U260/net20 U260/net24 VDD pmos W=0.205u L=0.04u
M799 U260/net40 U260/net106 U260/net108 VDD pmos W=0.205u L=0.04u
M800 U260/net40 n255 U260/net104 VDD pmos W=0.205u L=0.04u
M801 U260/net20 U260/net40 VDD VDD pmos W=0.205u L=0.04u
M802 U260/net106 n255 VDD VDD pmos W=0.205u L=0.04u
M803 U260/net104 n254 VDD VDD pmos W=0.205u L=0.04u
M804 U260/net30 N207 VDD VDD pmos W=0.205u L=0.04u
M805 U260/net108 U260/net104 VDD VDD pmos W=0.205u L=0.04u
M806 N661 U260/net28 VDD VDD pmos W=0.205u L=0.04u
M807 U260/net32 N201 VDD VDD pmos W=0.205u L=0.04u
M808 U260/net64 U260/net24 VDD VDD pmos W=0.28u L=0.04u
M809 U260/net24 U260/net30 U260/net045 VDD pmos W=0.205u L=0.04u
M810 U260/net045 U260/net32 VDD VDD pmos W=0.205u L=0.04u
M811 U261/net28 U261/net20 U261/net64 VSS nmos W=0.155u L=0.04u
M812 U261/net24 U261/net30 U261/net32 VSS nmos W=0.155u L=0.04u
M813 U261/net28 U261/net40 U261/net24 VSS nmos W=0.155u L=0.04u
M814 U261/net40 N165 U261/net108 VSS nmos W=0.155u L=0.04u
M815 U261/net40 U261/net106 U261/net104 VSS nmos W=0.155u L=0.04u
M816 U261/net24 n171 U261/net050 VSS nmos W=0.155u L=0.04u
M817 U261/net050 U261/net32 VSS VSS nmos W=0.155u L=0.04u
M818 U261/net20 U261/net40 VSS VSS nmos W=0.155u L=0.04u
M819 U261/net106 N165 VSS VSS nmos W=0.155u L=0.04u
M820 U261/net104 n135 VSS VSS nmos W=0.155u L=0.04u
M821 U261/net30 n171 VSS VSS nmos W=0.155u L=0.04u
M822 U261/net108 U261/net104 VSS VSS nmos W=0.155u L=0.04u
M823 n255 U261/net28 VSS VSS nmos W=0.155u L=0.04u
M824 U261/net32 N130 VSS VSS nmos W=0.155u L=0.04u
M825 U261/net64 U261/net24 VSS VSS nmos W=0.2u L=0.04u
M826 U261/net28 U261/net40 U261/net64 VDD pmos W=0.205u L=0.04u
M827 U261/net24 n171 U261/net32 VDD pmos W=0.205u L=0.04u
M828 U261/net28 U261/net20 U261/net24 VDD pmos W=0.205u L=0.04u
M829 U261/net40 U261/net106 U261/net108 VDD pmos W=0.205u L=0.04u
M830 U261/net40 N165 U261/net104 VDD pmos W=0.205u L=0.04u
M831 U261/net20 U261/net40 VDD VDD pmos W=0.205u L=0.04u
M832 U261/net106 N165 VDD VDD pmos W=0.205u L=0.04u
M833 U261/net104 n135 VDD VDD pmos W=0.205u L=0.04u
M834 U261/net30 n171 VDD VDD pmos W=0.205u L=0.04u
M835 U261/net108 U261/net104 VDD VDD pmos W=0.205u L=0.04u
M836 n255 U261/net28 VDD VDD pmos W=0.205u L=0.04u
M837 U261/net32 N130 VDD VDD pmos W=0.205u L=0.04u
M838 U261/net64 U261/net24 VDD VDD pmos W=0.28u L=0.04u
M839 U261/net24 U261/net30 U261/net045 VDD pmos W=0.205u L=0.04u
M840 U261/net045 U261/net32 VDD VDD pmos W=0.205u L=0.04u
M841 n135 N171 VSS VSS nmos W=0.135u L=0.04u
M842 n135 N171 VDD VDD pmos W=0.205u L=0.04u
M843 n171 N159 VSS VSS nmos W=0.135u L=0.04u
M844 n171 N159 VDD VDD pmos W=0.205u L=0.04u
M845 U264/net28 U264/net20 U264/net64 VSS nmos W=0.155u L=0.04u
M846 U264/net24 U264/net30 U264/net32 VSS nmos W=0.155u L=0.04u
M847 U264/net28 U264/net40 U264/net24 VSS nmos W=0.155u L=0.04u
M848 U264/net40 N189 U264/net108 VSS nmos W=0.155u L=0.04u
M849 U264/net40 U264/net106 U264/net104 VSS nmos W=0.155u L=0.04u
M850 U264/net24 N183 U264/net050 VSS nmos W=0.155u L=0.04u
M851 U264/net050 U264/net32 VSS VSS nmos W=0.155u L=0.04u
M852 U264/net20 U264/net40 VSS VSS nmos W=0.155u L=0.04u
M853 U264/net106 N189 VSS VSS nmos W=0.155u L=0.04u
M854 U264/net104 N195 VSS VSS nmos W=0.155u L=0.04u
M855 U264/net30 N183 VSS VSS nmos W=0.155u L=0.04u
M856 U264/net108 U264/net104 VSS VSS nmos W=0.155u L=0.04u
M857 n254 U264/net28 VSS VSS nmos W=0.155u L=0.04u
M858 U264/net32 N177 VSS VSS nmos W=0.155u L=0.04u
M859 U264/net64 U264/net24 VSS VSS nmos W=0.2u L=0.04u
M860 U264/net28 U264/net40 U264/net64 VDD pmos W=0.205u L=0.04u
M861 U264/net24 N183 U264/net32 VDD pmos W=0.205u L=0.04u
M862 U264/net28 U264/net20 U264/net24 VDD pmos W=0.205u L=0.04u
M863 U264/net40 U264/net106 U264/net108 VDD pmos W=0.205u L=0.04u
M864 U264/net40 N189 U264/net104 VDD pmos W=0.205u L=0.04u
M865 U264/net20 U264/net40 VDD VDD pmos W=0.205u L=0.04u
M866 U264/net106 N189 VDD VDD pmos W=0.205u L=0.04u
M867 U264/net104 N195 VDD VDD pmos W=0.205u L=0.04u
M868 U264/net30 N183 VDD VDD pmos W=0.205u L=0.04u
M869 U264/net108 U264/net104 VDD VDD pmos W=0.205u L=0.04u
M870 n254 U264/net28 VDD VDD pmos W=0.205u L=0.04u
M871 U264/net32 N177 VDD VDD pmos W=0.205u L=0.04u
M872 U264/net64 U264/net24 VDD VDD pmos W=0.28u L=0.04u
M873 U264/net24 U264/net30 U264/net045 VDD pmos W=0.205u L=0.04u
M874 U264/net045 U264/net32 VDD VDD pmos W=0.205u L=0.04u
M875 U265/net28 U265/net20 U265/net64 VSS nmos W=0.155u L=0.04u
M876 U265/net24 U265/net30 U265/net32 VSS nmos W=0.155u L=0.04u
M877 U265/net28 U265/net40 U265/net24 VSS nmos W=0.155u L=0.04u
M878 U265/net40 n257 U265/net108 VSS nmos W=0.155u L=0.04u
M879 U265/net40 U265/net106 U265/net104 VSS nmos W=0.155u L=0.04u
M880 U265/net24 N135 U265/net050 VSS nmos W=0.155u L=0.04u
M881 U265/net050 U265/net32 VSS VSS nmos W=0.155u L=0.04u
M882 U265/net20 U265/net40 VSS VSS nmos W=0.155u L=0.04u
M883 U265/net106 n257 VSS VSS nmos W=0.155u L=0.04u
M884 U265/net104 n256 VSS VSS nmos W=0.155u L=0.04u
M885 U265/net30 N135 VSS VSS nmos W=0.155u L=0.04u
M886 U265/net108 U265/net104 VSS VSS nmos W=0.155u L=0.04u
M887 N660 U265/net28 VSS VSS nmos W=0.155u L=0.04u
M888 U265/net32 N126 VSS VSS nmos W=0.155u L=0.04u
M889 U265/net64 U265/net24 VSS VSS nmos W=0.2u L=0.04u
M890 U265/net28 U265/net40 U265/net64 VDD pmos W=0.205u L=0.04u
M891 U265/net24 N135 U265/net32 VDD pmos W=0.205u L=0.04u
M892 U265/net28 U265/net20 U265/net24 VDD pmos W=0.205u L=0.04u
M893 U265/net40 U265/net106 U265/net108 VDD pmos W=0.205u L=0.04u
M894 U265/net40 n257 U265/net104 VDD pmos W=0.205u L=0.04u
M895 U265/net20 U265/net40 VDD VDD pmos W=0.205u L=0.04u
M896 U265/net106 n257 VDD VDD pmos W=0.205u L=0.04u
M897 U265/net104 n256 VDD VDD pmos W=0.205u L=0.04u
M898 U265/net30 N135 VDD VDD pmos W=0.205u L=0.04u
M899 U265/net108 U265/net104 VDD VDD pmos W=0.205u L=0.04u
M900 N660 U265/net28 VDD VDD pmos W=0.205u L=0.04u
M901 U265/net32 N126 VDD VDD pmos W=0.205u L=0.04u
M902 U265/net64 U265/net24 VDD VDD pmos W=0.28u L=0.04u
M903 U265/net24 U265/net30 U265/net045 VDD pmos W=0.205u L=0.04u
M904 U265/net045 U265/net32 VDD VDD pmos W=0.205u L=0.04u
M905 U266/net28 U266/net20 U266/net64 VSS nmos W=0.155u L=0.04u
M906 U266/net24 U266/net30 U266/net32 VSS nmos W=0.155u L=0.04u
M907 U266/net28 U266/net40 U266/net24 VSS nmos W=0.155u L=0.04u
M908 U266/net40 n232 U266/net108 VSS nmos W=0.155u L=0.04u
M909 U266/net40 U266/net106 U266/net104 VSS nmos W=0.155u L=0.04u
M910 U266/net24 N106 U266/net050 VSS nmos W=0.155u L=0.04u
M911 U266/net050 U266/net32 VSS VSS nmos W=0.155u L=0.04u
M912 U266/net20 U266/net40 VSS VSS nmos W=0.155u L=0.04u
M913 U266/net106 n232 VSS VSS nmos W=0.155u L=0.04u
M914 U266/net104 n231 VSS VSS nmos W=0.155u L=0.04u
M915 U266/net30 N106 VSS VSS nmos W=0.155u L=0.04u
M916 U266/net108 U266/net104 VSS VSS nmos W=0.155u L=0.04u
M917 n257 U266/net28 VSS VSS nmos W=0.155u L=0.04u
M918 U266/net32 N101 VSS VSS nmos W=0.155u L=0.04u
M919 U266/net64 U266/net24 VSS VSS nmos W=0.2u L=0.04u
M920 U266/net28 U266/net40 U266/net64 VDD pmos W=0.205u L=0.04u
M921 U266/net24 N106 U266/net32 VDD pmos W=0.205u L=0.04u
M922 U266/net28 U266/net20 U266/net24 VDD pmos W=0.205u L=0.04u
M923 U266/net40 U266/net106 U266/net108 VDD pmos W=0.205u L=0.04u
M924 U266/net40 n232 U266/net104 VDD pmos W=0.205u L=0.04u
M925 U266/net20 U266/net40 VDD VDD pmos W=0.205u L=0.04u
M926 U266/net106 n232 VDD VDD pmos W=0.205u L=0.04u
M927 U266/net104 n231 VDD VDD pmos W=0.205u L=0.04u
M928 U266/net30 N106 VDD VDD pmos W=0.205u L=0.04u
M929 U266/net108 U266/net104 VDD VDD pmos W=0.205u L=0.04u
M930 n257 U266/net28 VDD VDD pmos W=0.205u L=0.04u
M931 U266/net32 N101 VDD VDD pmos W=0.205u L=0.04u
M932 U266/net64 U266/net24 VDD VDD pmos W=0.28u L=0.04u
M933 U266/net24 U266/net30 U266/net045 VDD pmos W=0.205u L=0.04u
M934 U266/net045 U266/net32 VDD VDD pmos W=0.205u L=0.04u
M935 n232 N111 VSS VSS nmos W=0.135u L=0.04u
M936 n232 N111 VDD VDD pmos W=0.205u L=0.04u
M937 n231 N116 VSS VSS nmos W=0.135u L=0.04u
M938 n231 N116 VDD VDD pmos W=0.205u L=0.04u
M939 U269/net28 U269/net20 U269/net64 VSS nmos W=0.155u L=0.04u
M940 U269/net24 U269/net30 U269/net32 VSS nmos W=0.155u L=0.04u
M941 U269/net28 U269/net40 U269/net24 VSS nmos W=0.155u L=0.04u
M942 U269/net40 n156 U269/net108 VSS nmos W=0.155u L=0.04u
M943 U269/net40 U269/net106 U269/net104 VSS nmos W=0.155u L=0.04u
M944 U269/net24 N130 U269/net050 VSS nmos W=0.155u L=0.04u
M945 U269/net050 U269/net32 VSS VSS nmos W=0.155u L=0.04u
M946 U269/net20 U269/net40 VSS VSS nmos W=0.155u L=0.04u
M947 U269/net106 n156 VSS VSS nmos W=0.155u L=0.04u
M948 U269/net104 N96 VSS VSS nmos W=0.155u L=0.04u
M949 U269/net30 N130 VSS VSS nmos W=0.155u L=0.04u
M950 U269/net108 U269/net104 VSS VSS nmos W=0.155u L=0.04u
M951 n256 U269/net28 VSS VSS nmos W=0.155u L=0.04u
M952 U269/net32 n229 VSS VSS nmos W=0.155u L=0.04u
M953 U269/net64 U269/net24 VSS VSS nmos W=0.2u L=0.04u
M954 U269/net28 U269/net40 U269/net64 VDD pmos W=0.205u L=0.04u
M955 U269/net24 N130 U269/net32 VDD pmos W=0.205u L=0.04u
M956 U269/net28 U269/net20 U269/net24 VDD pmos W=0.205u L=0.04u
M957 U269/net40 U269/net106 U269/net108 VDD pmos W=0.205u L=0.04u
M958 U269/net40 n156 U269/net104 VDD pmos W=0.205u L=0.04u
M959 U269/net20 U269/net40 VDD VDD pmos W=0.205u L=0.04u
M960 U269/net106 n156 VDD VDD pmos W=0.205u L=0.04u
M961 U269/net104 N96 VDD VDD pmos W=0.205u L=0.04u
M962 U269/net30 N130 VDD VDD pmos W=0.205u L=0.04u
M963 U269/net108 U269/net104 VDD VDD pmos W=0.205u L=0.04u
M964 n256 U269/net28 VDD VDD pmos W=0.205u L=0.04u
M965 U269/net32 n229 VDD VDD pmos W=0.205u L=0.04u
M966 U269/net64 U269/net24 VDD VDD pmos W=0.28u L=0.04u
M967 U269/net24 U269/net30 U269/net045 VDD pmos W=0.205u L=0.04u
M968 U269/net045 U269/net32 VDD VDD pmos W=0.205u L=0.04u
M969 n156 N91 VSS VSS nmos W=0.135u L=0.04u
M970 n156 N91 VDD VDD pmos W=0.205u L=0.04u
M971 n229 N121 VSS VSS nmos W=0.135u L=0.04u
M972 n229 N121 VDD VDD pmos W=0.205u L=0.04u
M973 N449 n238 VSS VSS nmos W=0.155u L=0.04u
M974 N449 n236 VSS VSS nmos W=0.155u L=0.04u
M975 N449 U272/net12 VSS VSS nmos W=0.155u L=0.04u
M976 U272/net12 N74 VSS VSS nmos W=0.155u L=0.04u
M977 U272/XU9-net9 U272/net12 VDD VDD pmos W=0.41u L=0.04u
M978 U272/XU9-net12 n236 U272/XU9-net9 VDD pmos W=0.41u L=0.04u
M979 N449 n238 U272/XU9-net12 VDD pmos W=0.41u L=0.04u
M980 U272/net12 N74 VDD VDD pmos W=0.31u L=0.04u
M981 n238 N59 VSS VSS nmos W=0.135u L=0.04u
M982 n238 N59 VDD VDD pmos W=0.205u L=0.04u
M983 N448 n247 VSS VSS nmos W=0.155u L=0.04u
M984 N448 n236 VSS VSS nmos W=0.155u L=0.04u
M985 U274/XI1-net8 n236 VDD VDD pmos W=0.205u L=0.04u
M986 N448 n247 U274/XI1-net8 VDD pmos W=0.205u L=0.04u
M987 U275/p2 N8 VSS VSS nmos W=0.155u L=0.04u
M988 U275/p0 N13 U275/p1 VSS nmos W=0.155u L=0.04u
M989 U275/p1 n258 U275/p2 VSS nmos W=0.155u L=0.04u
M990 n236 N68 U275/p0 VSS nmos W=0.155u L=0.04u
M991 n236 n258 VDD VDD pmos W=0.205u L=0.04u
M992 n236 N13 VDD VDD pmos W=0.205u L=0.04u
M993 n236 N68 VDD VDD pmos W=0.205u L=0.04u
M994 n236 N8 VDD VDD pmos W=0.205u L=0.04u
M995 n258 n249 VSS VSS nmos W=0.155u L=0.04u
M996 n258 U276/net4 VSS VSS nmos W=0.155u L=0.04u
M997 U276/net4 N55 VSS VSS nmos W=0.155u L=0.04u
M998 U276/XU1-net8 U276/net4 VDD VDD pmos W=0.205u L=0.04u
M999 n258 n249 U276/XU1-net8 VDD pmos W=0.205u L=0.04u
M1000 U276/net4 N55 VDD VDD pmos W=0.205u L=0.04u
M1001 n249 N1 VSS VSS nmos W=0.135u L=0.04u
M1002 n249 N1 VDD VDD pmos W=0.205u L=0.04u
M1003 N447 n248 VSS VSS nmos W=0.135u L=0.04u
M1004 N447 n248 VDD VDD pmos W=0.205u L=0.04u
M1005 n248 N26 U279/XI0-net10 VSS nmos W=0.155u L=0.04u
M1006 U279/XI0-net10 N1 U279/XI0-net13 VSS nmos W=0.155u L=0.04u
M1007 U279/XI0-net13 N51 VSS VSS nmos W=0.155u L=0.04u
M1008 n248 N51 VDD VDD pmos W=0.205u L=0.04u
M1009 n248 N26 VDD VDD pmos W=0.205u L=0.04u
M1010 n248 N1 VDD VDD pmos W=0.205u L=0.04u
M1011 N422 N42 U280/XI0-net10 VSS nmos W=0.155u L=0.04u
M1012 U280/XI0-net10 N59 U280/XI0-net13 VSS nmos W=0.155u L=0.04u
M1013 U280/XI0-net13 N36 VSS VSS nmos W=0.155u L=0.04u
M1014 N422 N36 VDD VDD pmos W=0.205u L=0.04u
M1015 N422 N42 VDD VDD pmos W=0.205u L=0.04u
M1016 N422 N59 VDD VDD pmos W=0.205u L=0.04u
M1017 N421 N59 U281/XI0-net10 VSS nmos W=0.155u L=0.04u
M1018 U281/XI0-net10 N80 U281/XI0-net13 VSS nmos W=0.155u L=0.04u
M1019 U281/XI0-net13 N36 VSS VSS nmos W=0.155u L=0.04u
M1020 N421 N36 VDD VDD pmos W=0.205u L=0.04u
M1021 N421 N59 VDD VDD pmos W=0.205u L=0.04u
M1022 N421 N80 VDD VDD pmos W=0.205u L=0.04u
M1023 N420 N80 U282/XI0-net10 VSS nmos W=0.155u L=0.04u
M1024 U282/XI0-net10 N75 U282/XI0-net13 VSS nmos W=0.155u L=0.04u
M1025 U282/XI0-net13 N59 VSS VSS nmos W=0.155u L=0.04u
M1026 N420 N59 VDD VDD pmos W=0.205u L=0.04u
M1027 N420 N80 VDD VDD pmos W=0.205u L=0.04u
M1028 N420 N75 VDD VDD pmos W=0.205u L=0.04u
M1029 U283/XU1-net6 n259 VSS VSS nmos W=0.155u L=0.04u
M1030 N392 N292 U283/XU1-net6 VSS nmos W=0.155u L=0.04u
M1031 N392 n259 VDD VDD pmos W=0.155u L=0.04u
M1032 N392 N292 VDD VDD pmos W=0.155u L=0.04u
M1033 N356 n260 VSS VSS nmos W=0.155u L=0.04u
M1034 N356 U284/net4 VSS VSS nmos W=0.155u L=0.04u
M1035 U284/net4 N90 VSS VSS nmos W=0.155u L=0.04u
M1036 U284/XU1-net8 U284/net4 VDD VDD pmos W=0.205u L=0.04u
M1037 N356 n260 U284/XU1-net8 VDD pmos W=0.205u L=0.04u
M1038 U284/net4 N90 VDD VDD pmos W=0.205u L=0.04u
M1039 U285/net13 N292 VSS VSS nmos W=0.155u L=0.04u
M1040 U285/net16 U285/net13 VSS VSS nmos W=0.155u L=0.04u
M1041 N344 n259 U285/net16 VSS nmos W=0.155u L=0.04u
M1042 U285/net13 N292 VDD VDD pmos W=0.205u L=0.04u
M1043 VDD U285/net13 N344 VDD pmos W=0.205u L=0.04u
M1044 VDD n259 N344 VDD pmos W=0.205u L=0.04u
M1045 n259 U286/net6 VSS VSS nmos W=0.155u L=0.04u
M1046 U286/net6 N13 U286/XU30-net23 VSS nmos W=0.155u L=0.04u
M1047 U286/XU30-net23 N17 U286/XU30-net26 VSS nmos W=0.155u L=0.04u
M1048 U286/XU30-net26 N26 U286/XU30-net29 VSS nmos W=0.155u L=0.04u
M1049 U286/XU30-net29 N1 VSS VSS nmos W=0.155u L=0.04u
M1050 n259 U286/net6 VDD VDD pmos W=0.205u L=0.04u
M1051 U286/net6 N1 VDD VDD pmos W=0.205u L=0.04u
M1052 U286/net6 N26 VDD VDD pmos W=0.205u L=0.04u
M1053 U286/net6 N17 VDD VDD pmos W=0.205u L=0.04u
M1054 U286/net6 N13 VDD VDD pmos W=0.205u L=0.04u
M1055 N297 U287/net6 VSS VSS nmos W=0.155u L=0.04u
M1056 U287/X_u2-net6 N85 VSS VSS nmos W=0.155u L=0.04u
M1057 U287/net6 N86 U287/X_u2-net6 VSS nmos W=0.155u L=0.04u
M1058 N297 U287/net6 VDD VDD pmos W=0.205u L=0.04u
M1059 U287/net6 N85 VDD VDD pmos W=0.205u L=0.04u
M1060 U287/net6 N86 VDD VDD pmos W=0.205u L=0.04u
M1061 N292 n261 VSS VSS nmos W=0.155u L=0.04u
M1062 N292 n247 VSS VSS nmos W=0.155u L=0.04u
M1063 N292 n239 VSS VSS nmos W=0.155u L=0.04u
M1064 U288/net25 n261 VDD VDD pmos W=0.41u L=0.04u
M1065 U288/net28 n247 U288/net25 VDD pmos W=0.41u L=0.04u
M1066 N292 n239 U288/net28 VDD pmos W=0.41u L=0.04u
M1067 N291 n245 VSS VSS nmos W=0.155u L=0.04u
M1068 N291 n247 VSS VSS nmos W=0.155u L=0.04u
M1069 N291 n261 VSS VSS nmos W=0.155u L=0.04u
M1070 U289/net25 n245 VDD VDD pmos W=0.41u L=0.04u
M1071 U289/net28 n247 U289/net25 VDD pmos W=0.41u L=0.04u
M1072 N291 n261 U289/net28 VDD pmos W=0.41u L=0.04u
M1073 n245 N80 VSS VSS nmos W=0.135u L=0.04u
M1074 n245 N80 VDD VDD pmos W=0.205u L=0.04u
M1075 n261 N36 VSS VSS nmos W=0.135u L=0.04u
M1076 n261 N36 VDD VDD pmos W=0.205u L=0.04u
M1077 N290 n246 VSS VSS nmos W=0.155u L=0.04u
M1078 N290 n247 VSS VSS nmos W=0.155u L=0.04u
M1079 N290 n239 VSS VSS nmos W=0.155u L=0.04u
M1080 U292/net25 n246 VDD VDD pmos W=0.41u L=0.04u
M1081 U292/net28 n247 U292/net25 VDD pmos W=0.41u L=0.04u
M1082 N290 n239 U292/net28 VDD pmos W=0.41u L=0.04u
M1083 n246 N75 VSS VSS nmos W=0.135u L=0.04u
M1084 n246 N75 VDD VDD pmos W=0.205u L=0.04u
M1085 n247 N29 VSS VSS nmos W=0.135u L=0.04u
M1086 n247 N29 VDD VDD pmos W=0.205u L=0.04u
M1087 n239 N42 VSS VSS nmos W=0.135u L=0.04u
M1088 n239 N42 VDD VDD pmos W=0.205u L=0.04u
M1089 N24 n260 VSS VSS nmos W=0.155u L=0.04u
M1090 N24 U296/net4 VSS VSS nmos W=0.155u L=0.04u
M1091 U296/net4 N89 VSS VSS nmos W=0.155u L=0.04u
M1092 U296/XU1-net8 U296/net4 VDD VDD pmos W=0.205u L=0.04u
M1093 N24 n260 U296/XU1-net8 VDD pmos W=0.205u L=0.04u
M1094 U296/net4 N89 VDD VDD pmos W=0.205u L=0.04u
M1095 n260 N87 VSS VSS nmos W=0.155u L=0.04u
M1096 n260 N88 VSS VSS nmos W=0.155u L=0.04u
M1097 U297/XI1-net8 N88 VDD VDD pmos W=0.205u L=0.04u
M1098 n260 N87 U297/XI1-net8 VDD pmos W=0.205u L=0.04u
M1099 N0 U298/net6 VSS VSS nmos W=0.155u L=0.04u
M1100 U298/net6 N1 U298/XU30-net23 VSS nmos W=0.155u L=0.04u
M1101 U298/XU30-net23 N17 U298/XU30-net26 VSS nmos W=0.155u L=0.04u
M1102 U298/XU30-net26 N8 U298/XU30-net29 VSS nmos W=0.155u L=0.04u
M1103 U298/XU30-net29 N13 VSS VSS nmos W=0.155u L=0.04u
M1104 N0 U298/net6 VDD VDD pmos W=0.205u L=0.04u
M1105 U298/net6 N13 VDD VDD pmos W=0.205u L=0.04u
M1106 U298/net6 N8 VDD VDD pmos W=0.205u L=0.04u
M1107 U298/net6 N17 VDD VDD pmos W=0.205u L=0.04u
M1108 U298/net6 N1 VDD VDD pmos W=0.205u L=0.04u
.ENDS
