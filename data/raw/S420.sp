.SUBCKT s420 CK C_0 C_1 C_10 C_11 C_12 C_13 C_14 C_15 C_16 C_2 C_3 C_4 C_5 C_6 C_7 C_8 C_9 P_0 Z VDD VSS
M1 I308 NOR2_6/net6 VSS VSS nmos W=0.31u L=0.04u
M2 NOR2_6/X_u2-net6 n51 VSS VSS nmos W=0.31u L=0.04u
M3 NOR2_6/net6 n50 NOR2_6/X_u2-net6 VSS nmos W=0.31u L=0.04u
M4 I308 NOR2_6/net6 VDD VDD pmos W=0.41u L=0.04u
M5 NOR2_6/net6 n51 VDD VDD pmos W=0.41u L=0.04u
M6 NOR2_6/net6 n50 VDD VDD pmos W=0.41u L=0.04u
M7 I210 NOR2_4/net6 VSS VSS nmos W=0.31u L=0.04u
M8 NOR2_4/X_u2-net6 n49 VSS VSS nmos W=0.31u L=0.04u
M9 NOR2_4/net6 n48 NOR2_4/X_u2-net6 VSS nmos W=0.31u L=0.04u
M10 I210 NOR2_4/net6 VDD VDD pmos W=0.41u L=0.04u
M11 NOR2_4/net6 n49 VDD VDD pmos W=0.41u L=0.04u
M12 NOR2_4/net6 n48 VDD VDD pmos W=0.41u L=0.04u
M13 I112 NOR2_2/net6 VSS VSS nmos W=0.31u L=0.04u
M14 NOR2_2/X_u2-net6 n11 VSS VSS nmos W=0.31u L=0.04u
M15 NOR2_2/net6 n47 NOR2_2/X_u2-net6 VSS nmos W=0.31u L=0.04u
M16 I112 NOR2_2/net6 VDD VDD pmos W=0.41u L=0.04u
M17 NOR2_2/net6 n11 VDD VDD pmos W=0.41u L=0.04u
M18 NOR2_2/net6 n47 VDD VDD pmos W=0.41u L=0.04u
M19 I14 NOR2_0/net6 VSS VSS nmos W=0.31u L=0.04u
M20 NOR2_0/X_u2-net6 n52 VSS VSS nmos W=0.31u L=0.04u
M21 NOR2_0/net6 n53 NOR2_0/X_u2-net6 VSS nmos W=0.31u L=0.04u
M22 I14 NOR2_0/net6 VDD VDD pmos W=0.41u L=0.04u
M23 NOR2_0/net6 n52 VDD VDD pmos W=0.41u L=0.04u
M24 NOR2_0/net6 n53 VDD VDD pmos W=0.41u L=0.04u
M25 I309 OR2_7/net7 VSS VSS nmos W=0.31u L=0.04u
M26 OR2_7/net7 I378_3 VSS VSS nmos W=0.155u L=0.04u
M27 OR2_7/net7 I378_4 VSS VSS nmos W=0.155u L=0.04u
M28 I309 OR2_7/net7 VDD VDD pmos W=0.41u L=0.04u
M29 OR2_7/X_u7-net8 I378_4 VDD VDD pmos W=0.41u L=0.04u
M30 OR2_7/net7 I378_3 OR2_7/X_u7-net8 VDD pmos W=0.41u L=0.04u
M31 I211 OR2_5/net7 VSS VSS nmos W=0.31u L=0.04u
M32 OR2_5/net7 I284_3 VSS VSS nmos W=0.155u L=0.04u
M33 OR2_5/net7 I284_4 VSS VSS nmos W=0.155u L=0.04u
M34 I211 OR2_5/net7 VDD VDD pmos W=0.41u L=0.04u
M35 OR2_5/X_u7-net8 I284_4 VDD VDD pmos W=0.41u L=0.04u
M36 OR2_5/net7 I284_3 OR2_5/X_u7-net8 VDD pmos W=0.41u L=0.04u
M37 I209 OR2_4/net7 VSS VSS nmos W=0.31u L=0.04u
M38 OR2_4/net7 I269_3 VSS VSS nmos W=0.155u L=0.04u
M39 OR2_4/net7 I269_4 VSS VSS nmos W=0.155u L=0.04u
M40 I209 OR2_4/net7 VDD VDD pmos W=0.41u L=0.04u
M41 OR2_4/X_u7-net8 I269_4 VDD VDD pmos W=0.41u L=0.04u
M42 OR2_4/net7 I269_3 OR2_4/X_u7-net8 VDD pmos W=0.41u L=0.04u
M43 I113 OR2_3/net7 VSS VSS nmos W=0.31u L=0.04u
M44 OR2_3/net7 I186_3 VSS VSS nmos W=0.155u L=0.04u
M45 OR2_3/net7 I186_4 VSS VSS nmos W=0.155u L=0.04u
M46 I113 OR2_3/net7 VDD VDD pmos W=0.41u L=0.04u
M47 OR2_3/X_u7-net8 I186_4 VDD VDD pmos W=0.41u L=0.04u
M48 OR2_3/net7 I186_3 OR2_3/X_u7-net8 VDD pmos W=0.41u L=0.04u
M49 I111 OR2_2/net7 VSS VSS nmos W=0.31u L=0.04u
M50 OR2_2/net7 I171_3 VSS VSS nmos W=0.155u L=0.04u
M51 OR2_2/net7 I171_4 VSS VSS nmos W=0.155u L=0.04u
M52 I111 OR2_2/net7 VDD VDD pmos W=0.41u L=0.04u
M53 OR2_2/X_u7-net8 I171_4 VDD VDD pmos W=0.41u L=0.04u
M54 OR2_2/net7 I171_3 OR2_2/X_u7-net8 VDD pmos W=0.41u L=0.04u
M55 I15 OR2_1/net7 VSS VSS nmos W=0.31u L=0.04u
M56 OR2_1/net7 I88_3 VSS VSS nmos W=0.155u L=0.04u
M57 OR2_1/net7 I88_4 VSS VSS nmos W=0.155u L=0.04u
M58 I15 OR2_1/net7 VDD VDD pmos W=0.41u L=0.04u
M59 OR2_1/X_u7-net8 I88_4 VDD VDD pmos W=0.41u L=0.04u
M60 OR2_1/net7 I88_3 OR2_1/X_u7-net8 VDD pmos W=0.41u L=0.04u
M61 I13 OR2_0/net7 VSS VSS nmos W=0.31u L=0.04u
M62 OR2_0/net7 I73_3 VSS VSS nmos W=0.155u L=0.04u
M63 OR2_0/net7 I73_4 VSS VSS nmos W=0.155u L=0.04u
M64 I13 OR2_0/net7 VDD VDD pmos W=0.41u L=0.04u
M65 OR2_0/X_u7-net8 I73_4 VDD VDD pmos W=0.41u L=0.04u
M66 OR2_0/net7 I73_3 OR2_0/X_u7-net8 VDD pmos W=0.41u L=0.04u
M67 I307 N13 VSS VSS nmos W=0.31u L=0.04u
M68 I307 N13 VDD VDD pmos W=0.41u L=0.04u
M69 I306 N12 VSS VSS nmos W=0.31u L=0.04u
M70 I306 N12 VDD VDD pmos W=0.41u L=0.04u
M71 I12 N0 VSS VSS nmos W=0.31u L=0.04u
M72 I12 N0 VDD VDD pmos W=0.41u L=0.04u
M73 I110 N4 VSS VSS nmos W=0.31u L=0.04u
M74 I110 N4 VDD VDD pmos W=0.41u L=0.04u
M75 I208 N8 VSS VSS nmos W=0.31u L=0.04u
M76 I208 N8 VDD VDD pmos W=0.41u L=0.04u
M77 U67/net32 X_1 VSS VSS nmos W=0.155u L=0.04u
M78 U67/net59 P_0 U67/net32 VSS nmos W=0.155u L=0.04u
M79 U67/net59 X_2 VSS VSS nmos W=0.155u L=0.04u
M80 n53 U67/net59 VSS VSS nmos W=0.155u L=0.04u
M81 n53 U67/net59 VDD VDD pmos W=0.2u L=0.04u
M82 U67/net59 P_0 U67/net22 VDD pmos W=0.205u L=0.04u
M83 U67/net59 X_1 U67/net22 VDD pmos W=0.205u L=0.04u
M84 U67/net22 X_2 VDD VDD pmos W=0.2u L=0.04u
M85 n50 n54 U68/net15 VSS nmos W=0.155u L=0.04u
M86 n50 n55 U68/net15 VSS nmos W=0.155u L=0.04u
M87 U68/net15 n56 VSS VSS nmos W=0.155u L=0.04u
M88 n50 n56 VDD VDD pmos W=0.205u L=0.04u
M89 n50 n54 U68/XI16-net11 VDD pmos W=0.205u L=0.04u
M90 U68/XI16-net11 n55 VDD VDD pmos W=0.205u L=0.04u
M91 n48 n57 U69/net15 VSS nmos W=0.155u L=0.04u
M92 n48 n58 U69/net15 VSS nmos W=0.155u L=0.04u
M93 U69/net15 n59 VSS VSS nmos W=0.155u L=0.04u
M94 n48 n59 VDD VDD pmos W=0.205u L=0.04u
M95 n48 n57 U69/XI16-net11 VDD pmos W=0.205u L=0.04u
M96 U69/XI16-net11 n58 VDD VDD pmos W=0.205u L=0.04u
M97 n47 n60 U70/net15 VSS nmos W=0.155u L=0.04u
M98 n47 n61 U70/net15 VSS nmos W=0.155u L=0.04u
M99 U70/net15 n62 VSS VSS nmos W=0.155u L=0.04u
M100 n47 n62 VDD VDD pmos W=0.205u L=0.04u
M101 n47 n60 U70/XI16-net11 VDD pmos W=0.205u L=0.04u
M102 U70/XI16-net11 n61 VDD VDD pmos W=0.205u L=0.04u
M103 Z n63 U71/net10 VSS nmos W=0.155u L=0.04u
M104 U71/net10 n66 VSS VSS nmos W=0.155u L=0.04u
M105 Z n64 U71/net10 VSS nmos W=0.155u L=0.04u
M106 U71/net10 n65 VSS VSS nmos W=0.155u L=0.04u
M107 U71/net30 n66 VDD VDD pmos W=0.205u L=0.04u
M108 Z n63 U71/net24 VDD pmos W=0.205u L=0.04u
M109 U71/net24 n64 VDD VDD pmos W=0.205u L=0.04u
M110 Z n65 U71/net30 VDD pmos W=0.205u L=0.04u
M111 U72/PG2 C_2 VSS VSS nmos W=0.31u L=0.04u
M112 U72/net55 C_3 VSS VSS nmos W=0.31u L=0.04u
M113 U72/net51 X_3 VSS VSS nmos W=0.155u L=0.04u
M114 U72/net53 n67 VSS VSS nmos W=0.155u L=0.04u
M115 U72/net29 X_2 VSS VSS nmos W=0.155u L=0.04u
M116 U72/net53 U72/net51 U72/PG1 VSS nmos W=0.155u L=0.04u
M117 U72/net55 X_3 U72/PG1 VSS nmos W=0.21u L=0.04u
M118 U72/PG2 X_2 n66 VSS nmos W=0.22u L=0.04u
M119 U72/PG1 U72/net29 n66 VSS nmos W=0.155u L=0.04u
M120 U72/PG2 C_2 VDD VDD pmos W=0.41u L=0.04u
M121 U72/net55 C_3 VDD VDD pmos W=0.41u L=0.04u
M122 U72/net51 X_3 VDD VDD pmos W=0.205u L=0.04u
M123 U72/net53 n67 VDD VDD pmos W=0.28u L=0.04u
M124 U72/net29 X_2 VDD VDD pmos W=0.205u L=0.04u
M125 U72/net53 X_3 U72/PG1 VDD pmos W=0.27u L=0.04u
M126 U72/net55 U72/net51 U72/PG1 VDD pmos W=0.285u L=0.04u
M127 U72/PG2 U72/net29 n66 VDD pmos W=0.205u L=0.04u
M128 U72/PG1 X_2 n66 VDD pmos W=0.28u L=0.04u
M129 n67 U73/net6 VSS VSS nmos W=0.155u L=0.04u
M130 U73/X_u2-net6 X_4 VSS VSS nmos W=0.155u L=0.04u
M131 U73/net6 C_4 U73/X_u2-net6 VSS nmos W=0.155u L=0.04u
M132 n67 U73/net6 VDD VDD pmos W=0.205u L=0.04u
M133 U73/net6 X_4 VDD VDD pmos W=0.205u L=0.04u
M134 U73/net6 C_4 VDD VDD pmos W=0.205u L=0.04u
M135 n64 P_0 VSS VSS nmos W=0.135u L=0.04u
M136 n64 P_0 VDD VDD pmos W=0.205u L=0.04u
M137 n63 C_0 VSS VSS nmos W=0.155u L=0.04u
M138 n63 U75/net4 VSS VSS nmos W=0.155u L=0.04u
M139 U75/net4 n68 VSS VSS nmos W=0.155u L=0.04u
M140 U75/XU1-net8 U75/net4 VDD VDD pmos W=0.205u L=0.04u
M141 n63 C_0 U75/XU1-net8 VDD pmos W=0.205u L=0.04u
M142 U75/net4 n68 VDD VDD pmos W=0.205u L=0.04u
M143 U76/net19 X_1 VSS VSS nmos W=0.155u L=0.04u
M144 n68 X_1 U76/net40 VSS nmos W=0.155u L=0.04u
M145 n68 U76/net19 U76/net36 VSS nmos W=0.155u L=0.04u
M146 U76/net40 C_1 VSS VSS nmos W=0.31u L=0.04u
M147 U76/net36 n69 VSS VSS nmos W=0.155u L=0.04u
M148 U76/net19 X_1 VDD VDD pmos W=0.205u L=0.04u
M149 n68 U76/net19 U76/net26 VDD pmos W=0.325u L=0.04u
M150 U76/net26 C_1 VDD VDD pmos W=0.41u L=0.04u
M151 n68 X_1 U76/net30 VDD pmos W=0.325u L=0.04u
M152 U76/net30 n69 VDD VDD pmos W=0.205u L=0.04u
M153 n69 n70 VSS VSS nmos W=0.155u L=0.04u
M154 n69 X_2 VSS VSS nmos W=0.155u L=0.04u
M155 n69 X_3 VSS VSS nmos W=0.155u L=0.04u
M156 n69 X_4 VSS VSS nmos W=0.155u L=0.04u
M157 U77/net49 X_2 U77/net52 VDD pmos W=0.41u L=0.04u
M158 U77/net52 n70 VDD VDD pmos W=0.41u L=0.04u
M159 U77/net46 X_3 U77/net49 VDD pmos W=0.41u L=0.04u
M160 n69 X_4 U77/net46 VDD pmos W=0.41u L=0.04u
M161 U78/PG2 C_5 VSS VSS nmos W=0.31u L=0.04u
M162 U78/net55 C_6 VSS VSS nmos W=0.31u L=0.04u
M163 U78/net51 X_6 VSS VSS nmos W=0.155u L=0.04u
M164 U78/net53 n71 VSS VSS nmos W=0.155u L=0.04u
M165 U78/net29 X_5 VSS VSS nmos W=0.155u L=0.04u
M166 U78/net53 U78/net51 U78/PG1 VSS nmos W=0.155u L=0.04u
M167 U78/net55 X_6 U78/PG1 VSS nmos W=0.21u L=0.04u
M168 U78/PG2 X_5 n70 VSS nmos W=0.22u L=0.04u
M169 U78/PG1 U78/net29 n70 VSS nmos W=0.155u L=0.04u
M170 U78/PG2 C_5 VDD VDD pmos W=0.41u L=0.04u
M171 U78/net55 C_6 VDD VDD pmos W=0.41u L=0.04u
M172 U78/net51 X_6 VDD VDD pmos W=0.205u L=0.04u
M173 U78/net53 n71 VDD VDD pmos W=0.28u L=0.04u
M174 U78/net29 X_5 VDD VDD pmos W=0.205u L=0.04u
M175 U78/net53 X_6 U78/PG1 VDD pmos W=0.27u L=0.04u
M176 U78/net55 U78/net51 U78/PG1 VDD pmos W=0.285u L=0.04u
M177 U78/PG2 U78/net29 n70 VDD pmos W=0.205u L=0.04u
M178 U78/PG1 X_5 n70 VDD pmos W=0.28u L=0.04u
M179 U79/PG2 C_7 VSS VSS nmos W=0.155u L=0.04u
M180 U79/net55 C_8 VSS VSS nmos W=0.155u L=0.04u
M181 U79/net51 X_8 VSS VSS nmos W=0.155u L=0.04u
M182 n71 U79/OUT VSS VSS nmos W=0.155u L=0.04u
M183 U79/net53 n72 VSS VSS nmos W=0.155u L=0.04u
M184 U79/net29 X_7 VSS VSS nmos W=0.155u L=0.04u
M185 U79/net53 U79/net51 U79/PG1 VSS nmos W=0.155u L=0.04u
M186 U79/net55 X_8 U79/PG1 VSS nmos W=0.155u L=0.04u
M187 U79/PG2 X_7 U79/OUT VSS nmos W=0.155u L=0.04u
M188 U79/PG1 U79/net29 U79/OUT VSS nmos W=0.155u L=0.04u
M189 U79/PG2 C_7 VDD VDD pmos W=0.205u L=0.04u
M190 U79/net55 C_8 VDD VDD pmos W=0.21u L=0.04u
M191 U79/net51 X_8 VDD VDD pmos W=0.205u L=0.04u
M192 n71 U79/OUT VDD VDD pmos W=0.205u L=0.04u
M193 U79/net53 n72 VDD VDD pmos W=0.205u L=0.04u
M194 U79/net29 X_7 VDD VDD pmos W=0.205u L=0.04u
M195 U79/net53 X_8 U79/PG1 VDD pmos W=0.205u L=0.04u
M196 U79/net55 U79/net51 U79/PG1 VDD pmos W=0.21u L=0.04u
M197 U79/PG2 U79/net29 U79/OUT VDD pmos W=0.205u L=0.04u
M198 U79/PG1 X_7 U79/OUT VDD pmos W=0.205u L=0.04u
M199 U80/PG2 C_9 VSS VSS nmos W=0.155u L=0.04u
M200 U80/net55 C_10 VSS VSS nmos W=0.155u L=0.04u
M201 U80/net51 X_10 VSS VSS nmos W=0.155u L=0.04u
M202 n72 U80/OUT VSS VSS nmos W=0.155u L=0.04u
M203 U80/net53 n73 VSS VSS nmos W=0.155u L=0.04u
M204 U80/net29 X_9 VSS VSS nmos W=0.155u L=0.04u
M205 U80/net53 U80/net51 U80/PG1 VSS nmos W=0.155u L=0.04u
M206 U80/net55 X_10 U80/PG1 VSS nmos W=0.155u L=0.04u
M207 U80/PG2 X_9 U80/OUT VSS nmos W=0.155u L=0.04u
M208 U80/PG1 U80/net29 U80/OUT VSS nmos W=0.155u L=0.04u
M209 U80/PG2 C_9 VDD VDD pmos W=0.205u L=0.04u
M210 U80/net55 C_10 VDD VDD pmos W=0.21u L=0.04u
M211 U80/net51 X_10 VDD VDD pmos W=0.205u L=0.04u
M212 n72 U80/OUT VDD VDD pmos W=0.205u L=0.04u
M213 U80/net53 n73 VDD VDD pmos W=0.205u L=0.04u
M214 U80/net29 X_9 VDD VDD pmos W=0.205u L=0.04u
M215 U80/net53 X_10 U80/PG1 VDD pmos W=0.205u L=0.04u
M216 U80/net55 U80/net51 U80/PG1 VDD pmos W=0.21u L=0.04u
M217 U80/PG2 U80/net29 U80/OUT VDD pmos W=0.205u L=0.04u
M218 U80/PG1 X_9 U80/OUT VDD pmos W=0.205u L=0.04u
M219 U81/net32 X_11 VSS VSS nmos W=0.155u L=0.04u
M220 U81/net59 C_11 U81/net32 VSS nmos W=0.155u L=0.04u
M221 U81/net59 n74 VSS VSS nmos W=0.155u L=0.04u
M222 n73 U81/net59 VSS VSS nmos W=0.155u L=0.04u
M223 n73 U81/net59 VDD VDD pmos W=0.2u L=0.04u
M224 U81/net59 C_11 U81/net22 VDD pmos W=0.205u L=0.04u
M225 U81/net59 X_11 U81/net22 VDD pmos W=0.205u L=0.04u
M226 U81/net22 n74 VDD VDD pmos W=0.2u L=0.04u
M227 U82/net19 X_12 VSS VSS nmos W=0.155u L=0.04u
M228 n74 X_12 U82/net40 VSS nmos W=0.155u L=0.04u
M229 n74 U82/net19 U82/net36 VSS nmos W=0.155u L=0.04u
M230 U82/net40 n76 VSS VSS nmos W=0.31u L=0.04u
M231 U82/net36 n75 VSS VSS nmos W=0.155u L=0.04u
M232 U82/net19 X_12 VDD VDD pmos W=0.205u L=0.04u
M233 n74 U82/net19 U82/net26 VDD pmos W=0.325u L=0.04u
M234 U82/net26 n76 VDD VDD pmos W=0.41u L=0.04u
M235 n74 X_12 U82/net30 VDD pmos W=0.325u L=0.04u
M236 U82/net30 n75 VDD VDD pmos W=0.205u L=0.04u
M237 U83/XU1-net6 n77 VSS VSS nmos W=0.155u L=0.04u
M238 n76 C_12 U83/XU1-net6 VSS nmos W=0.155u L=0.04u
M239 n76 n77 VDD VDD pmos W=0.155u L=0.04u
M240 n76 C_12 VDD VDD pmos W=0.155u L=0.04u
M241 U84/XU1-net6 n77 VSS VSS nmos W=0.155u L=0.04u
M242 n75 n78 U84/XU1-net6 VSS nmos W=0.155u L=0.04u
M243 n75 n77 VDD VDD pmos W=0.155u L=0.04u
M244 n75 n78 VDD VDD pmos W=0.155u L=0.04u
M245 U85/PG2 C_13 VSS VSS nmos W=0.155u L=0.04u
M246 U85/net55 C_14 VSS VSS nmos W=0.155u L=0.04u
M247 U85/net51 X_14 VSS VSS nmos W=0.155u L=0.04u
M248 n78 U85/OUT VSS VSS nmos W=0.155u L=0.04u
M249 U85/net53 n79 VSS VSS nmos W=0.155u L=0.04u
M250 U85/net29 X_13 VSS VSS nmos W=0.155u L=0.04u
M251 U85/net53 U85/net51 U85/PG1 VSS nmos W=0.155u L=0.04u
M252 U85/net55 X_14 U85/PG1 VSS nmos W=0.155u L=0.04u
M253 U85/PG2 X_13 U85/OUT VSS nmos W=0.155u L=0.04u
M254 U85/PG1 U85/net29 U85/OUT VSS nmos W=0.155u L=0.04u
M255 U85/PG2 C_13 VDD VDD pmos W=0.205u L=0.04u
M256 U85/net55 C_14 VDD VDD pmos W=0.21u L=0.04u
M257 U85/net51 X_14 VDD VDD pmos W=0.205u L=0.04u
M258 n78 U85/OUT VDD VDD pmos W=0.205u L=0.04u
M259 U85/net53 n79 VDD VDD pmos W=0.205u L=0.04u
M260 U85/net29 X_13 VDD VDD pmos W=0.205u L=0.04u
M261 U85/net53 X_14 U85/PG1 VDD pmos W=0.205u L=0.04u
M262 U85/net55 U85/net51 U85/PG1 VDD pmos W=0.21u L=0.04u
M263 U85/PG2 U85/net29 U85/OUT VDD pmos W=0.205u L=0.04u
M264 U85/PG1 X_13 U85/OUT VDD pmos W=0.205u L=0.04u
M265 U86/net19 X_15 VSS VSS nmos W=0.155u L=0.04u
M266 n79 X_15 U86/net40 VSS nmos W=0.155u L=0.04u
M267 n79 U86/net19 U86/net36 VSS nmos W=0.155u L=0.04u
M268 U86/net40 n81 VSS VSS nmos W=0.31u L=0.04u
M269 U86/net36 n80 VSS VSS nmos W=0.155u L=0.04u
M270 U86/net19 X_15 VDD VDD pmos W=0.205u L=0.04u
M271 n79 U86/net19 U86/net26 VDD pmos W=0.325u L=0.04u
M272 U86/net26 n81 VDD VDD pmos W=0.41u L=0.04u
M273 n79 X_15 U86/net30 VDD pmos W=0.325u L=0.04u
M274 U86/net30 n80 VDD VDD pmos W=0.205u L=0.04u
M275 n81 C_15 VSS VSS nmos W=0.135u L=0.04u
M276 n81 C_15 VDD VDD pmos W=0.205u L=0.04u
M277 U88/XU1-net6 C_16 VSS VSS nmos W=0.155u L=0.04u
M278 n80 X_16 U88/XU1-net6 VSS nmos W=0.155u L=0.04u
M279 n80 C_16 VDD VDD pmos W=0.155u L=0.04u
M280 n80 X_16 VDD VDD pmos W=0.155u L=0.04u
M281 N8 X_12 U89/net15 VSS nmos W=0.155u L=0.04u
M282 N8 n82 U89/net15 VSS nmos W=0.155u L=0.04u
M283 U89/net15 n54 VSS VSS nmos W=0.155u L=0.04u
M284 N8 n54 VDD VDD pmos W=0.205u L=0.04u
M285 N8 X_12 U89/XI16-net11 VDD pmos W=0.205u L=0.04u
M286 U89/XI16-net11 n82 VDD VDD pmos W=0.205u L=0.04u
M287 N4 X_8 U90/net15 VSS nmos W=0.155u L=0.04u
M288 N4 n83 U90/net15 VSS nmos W=0.155u L=0.04u
M289 U90/net15 n57 VSS VSS nmos W=0.155u L=0.04u
M290 N4 n57 VDD VDD pmos W=0.205u L=0.04u
M291 N4 X_8 U90/XI16-net11 VDD pmos W=0.205u L=0.04u
M292 U90/XI16-net11 n83 VDD VDD pmos W=0.205u L=0.04u
M293 U91/net4 U91/net10 U91/net14 VSS nmos W=0.155u L=0.04u
M294 U91/net6 n51 U91/net14 VSS nmos W=0.155u L=0.04u
M295 U91/net4 X_15 VSS VSS nmos W=0.155u L=0.04u
M296 U91/net6 U91/net4 VSS VSS nmos W=0.155u L=0.04u
M297 N13 U91/net14 VSS VSS nmos W=0.155u L=0.04u
M298 U91/net10 n51 VSS VSS nmos W=0.155u L=0.04u
M299 U91/net4 n51 U91/net14 VDD pmos W=0.205u L=0.04u
M300 U91/net6 U91/net10 U91/net14 VDD pmos W=0.205u L=0.04u
M301 U91/net4 X_15 VDD VDD pmos W=0.205u L=0.04u
M302 U91/net6 U91/net4 VDD VDD pmos W=0.205u L=0.04u
M303 N13 U91/net14 VDD VDD pmos W=0.205u L=0.04u
M304 U91/net10 n51 VDD VDD pmos W=0.205u L=0.04u
M305 n51 n84 VSS VSS nmos W=0.135u L=0.04u
M306 n51 n84 VDD VDD pmos W=0.205u L=0.04u
M307 U93/net4 U93/net10 U93/net14 VSS nmos W=0.155u L=0.04u
M308 U93/net6 X_16 U93/net14 VSS nmos W=0.155u L=0.04u
M309 U93/net4 n85 VSS VSS nmos W=0.155u L=0.04u
M310 U93/net6 U93/net4 VSS VSS nmos W=0.155u L=0.04u
M311 N12 U93/net14 VSS VSS nmos W=0.155u L=0.04u
M312 U93/net10 X_16 VSS VSS nmos W=0.155u L=0.04u
M313 U93/net4 X_16 U93/net14 VDD pmos W=0.205u L=0.04u
M314 U93/net6 U93/net10 U93/net14 VDD pmos W=0.205u L=0.04u
M315 U93/net4 n85 VDD VDD pmos W=0.205u L=0.04u
M316 U93/net6 U93/net4 VDD VDD pmos W=0.205u L=0.04u
M317 N12 U93/net14 VDD VDD pmos W=0.205u L=0.04u
M318 U93/net10 X_16 VDD VDD pmos W=0.205u L=0.04u
M319 U94/XU1-net6 n84 VSS VSS nmos W=0.155u L=0.04u
M320 n85 X_15 U94/XU1-net6 VSS nmos W=0.155u L=0.04u
M321 n85 n84 VDD VDD pmos W=0.155u L=0.04u
M322 n85 X_15 VDD VDD pmos W=0.155u L=0.04u
M323 n84 n56 VSS VSS nmos W=0.155u L=0.04u
M324 n84 n54 VSS VSS nmos W=0.155u L=0.04u
M325 n84 n55 VSS VSS nmos W=0.155u L=0.04u
M326 U95/net25 n56 VDD VDD pmos W=0.41u L=0.04u
M327 U95/net28 n54 U95/net25 VDD pmos W=0.41u L=0.04u
M328 n84 n55 U95/net28 VDD pmos W=0.41u L=0.04u
M329 n56 X_14 VSS VSS nmos W=0.135u L=0.04u
M330 n56 X_14 VDD VDD pmos W=0.205u L=0.04u
M331 N0 X_4 U97/net15 VSS nmos W=0.155u L=0.04u
M332 N0 n86 U97/net15 VSS nmos W=0.155u L=0.04u
M333 U97/net15 n60 VSS VSS nmos W=0.155u L=0.04u
M334 N0 n60 VDD VDD pmos W=0.205u L=0.04u
M335 N0 X_4 U97/XI16-net11 VDD pmos W=0.205u L=0.04u
M336 U97/XI16-net11 n86 VDD VDD pmos W=0.205u L=0.04u
M337 I88_4 n65 VSS VSS nmos W=0.135u L=0.04u
M338 I88_4 n65 VDD VDD pmos W=0.205u L=0.04u
M339 U99/XU1-net6 n87 VSS VSS nmos W=0.155u L=0.04u
M340 n65 P_0 U99/XU1-net6 VSS nmos W=0.155u L=0.04u
M341 n65 n87 VDD VDD pmos W=0.155u L=0.04u
M342 n65 P_0 VDD VDD pmos W=0.155u L=0.04u
M343 I88_3 P_0 VSS VSS nmos W=0.155u L=0.04u
M344 I88_3 n87 VSS VSS nmos W=0.155u L=0.04u
M345 U100/XI1-net8 n87 VDD VDD pmos W=0.205u L=0.04u
M346 I88_3 P_0 U100/XI1-net8 VDD pmos W=0.205u L=0.04u
M347 n87 X_1 VSS VSS nmos W=0.135u L=0.04u
M348 n87 X_1 VDD VDD pmos W=0.205u L=0.04u
M349 I73_4 n88 VSS VSS nmos W=0.155u L=0.04u
M350 I73_4 U102/net4 VSS VSS nmos W=0.155u L=0.04u
M351 U102/net4 n52 VSS VSS nmos W=0.155u L=0.04u
M352 U102/XU1-net8 U102/net4 VDD VDD pmos W=0.205u L=0.04u
M353 I73_4 n88 U102/XU1-net8 VDD pmos W=0.205u L=0.04u
M354 U102/net4 n52 VDD VDD pmos W=0.205u L=0.04u
M355 I73_3 X_3 VSS VSS nmos W=0.155u L=0.04u
M356 I73_3 n52 VSS VSS nmos W=0.155u L=0.04u
M357 U103/XI1-net8 n52 VDD VDD pmos W=0.205u L=0.04u
M358 I73_3 X_3 U103/XI1-net8 VDD pmos W=0.205u L=0.04u
M359 I378_4 X_13 VSS VSS nmos W=0.155u L=0.04u
M360 I378_4 n54 VSS VSS nmos W=0.155u L=0.04u
M361 U104/XI1-net8 n54 VDD VDD pmos W=0.205u L=0.04u
M362 I378_4 X_13 U104/XI1-net8 VDD pmos W=0.205u L=0.04u
M363 I378_3 n55 VSS VSS nmos W=0.155u L=0.04u
M364 I378_3 U105/net4 VSS VSS nmos W=0.155u L=0.04u
M365 U105/net4 n54 VSS VSS nmos W=0.155u L=0.04u
M366 U105/XU1-net8 U105/net4 VDD VDD pmos W=0.205u L=0.04u
M367 I378_3 n55 U105/XU1-net8 VDD pmos W=0.205u L=0.04u
M368 U105/net4 n54 VDD VDD pmos W=0.205u L=0.04u
M369 n55 X_13 VSS VSS nmos W=0.135u L=0.04u
M370 n55 X_13 VDD VDD pmos W=0.205u L=0.04u
M371 U107/XU1-net6 n82 VSS VSS nmos W=0.155u L=0.04u
M372 n54 X_12 U107/XU1-net6 VSS nmos W=0.155u L=0.04u
M373 n54 n82 VDD VDD pmos W=0.155u L=0.04u
M374 n54 X_12 VDD VDD pmos W=0.155u L=0.04u
M375 n82 n77 VSS VSS nmos W=0.155u L=0.04u
M376 n82 n49 VSS VSS nmos W=0.155u L=0.04u
M377 U108/XI1-net8 n49 VDD VDD pmos W=0.205u L=0.04u
M378 n82 n77 U108/XI1-net8 VDD pmos W=0.205u L=0.04u
M379 I284_4 X_9 VSS VSS nmos W=0.155u L=0.04u
M380 I284_4 n57 VSS VSS nmos W=0.155u L=0.04u
M381 U109/XI1-net8 n57 VDD VDD pmos W=0.205u L=0.04u
M382 I284_4 X_9 U109/XI1-net8 VDD pmos W=0.205u L=0.04u
M383 I284_3 n58 VSS VSS nmos W=0.155u L=0.04u
M384 I284_3 U110/net4 VSS VSS nmos W=0.155u L=0.04u
M385 U110/net4 n57 VSS VSS nmos W=0.155u L=0.04u
M386 U110/XU1-net8 U110/net4 VDD VDD pmos W=0.205u L=0.04u
M387 I284_3 n58 U110/XU1-net8 VDD pmos W=0.205u L=0.04u
M388 U110/net4 n57 VDD VDD pmos W=0.205u L=0.04u
M389 I269_4 n89 VSS VSS nmos W=0.155u L=0.04u
M390 I269_4 n77 VSS VSS nmos W=0.155u L=0.04u
M391 U111/XI1-net8 n77 VDD VDD pmos W=0.205u L=0.04u
M392 I269_4 n89 U111/XI1-net8 VDD pmos W=0.205u L=0.04u
M393 n77 X_11 VSS VSS nmos W=0.135u L=0.04u
M394 n77 X_11 VDD VDD pmos W=0.205u L=0.04u
M395 I269_3 X_11 VSS VSS nmos W=0.155u L=0.04u
M396 I269_3 n49 VSS VSS nmos W=0.155u L=0.04u
M397 U113/XI1-net8 n49 VDD VDD pmos W=0.205u L=0.04u
M398 I269_3 X_11 U113/XI1-net8 VDD pmos W=0.205u L=0.04u
M399 n49 n89 VSS VSS nmos W=0.135u L=0.04u
M400 n49 n89 VDD VDD pmos W=0.205u L=0.04u
M401 n89 n58 VSS VSS nmos W=0.155u L=0.04u
M402 n89 n57 VSS VSS nmos W=0.155u L=0.04u
M403 n89 n59 VSS VSS nmos W=0.155u L=0.04u
M404 U115/net25 n58 VDD VDD pmos W=0.41u L=0.04u
M405 U115/net28 n57 U115/net25 VDD pmos W=0.41u L=0.04u
M406 n89 n59 U115/net28 VDD pmos W=0.41u L=0.04u
M407 n58 X_9 VSS VSS nmos W=0.135u L=0.04u
M408 n58 X_9 VDD VDD pmos W=0.205u L=0.04u
M409 U117/XU1-net6 n83 VSS VSS nmos W=0.155u L=0.04u
M410 n57 X_8 U117/XU1-net6 VSS nmos W=0.155u L=0.04u
M411 n57 n83 VDD VDD pmos W=0.155u L=0.04u
M412 n57 X_8 VDD VDD pmos W=0.155u L=0.04u
M413 n83 n90 VSS VSS nmos W=0.155u L=0.04u
M414 n83 n11 VSS VSS nmos W=0.155u L=0.04u
M415 U118/XI1-net8 n11 VDD VDD pmos W=0.205u L=0.04u
M416 n83 n90 U118/XI1-net8 VDD pmos W=0.205u L=0.04u
M417 n59 X_10 VSS VSS nmos W=0.135u L=0.04u
M418 n59 X_10 VDD VDD pmos W=0.205u L=0.04u
M419 I186_4 X_5 VSS VSS nmos W=0.155u L=0.04u
M420 I186_4 n60 VSS VSS nmos W=0.155u L=0.04u
M421 U120/XI1-net8 n60 VDD VDD pmos W=0.205u L=0.04u
M422 I186_4 X_5 U120/XI1-net8 VDD pmos W=0.205u L=0.04u
M423 I186_3 n61 VSS VSS nmos W=0.155u L=0.04u
M424 I186_3 U121/net4 VSS VSS nmos W=0.155u L=0.04u
M425 U121/net4 n60 VSS VSS nmos W=0.155u L=0.04u
M426 U121/XU1-net8 U121/net4 VDD VDD pmos W=0.205u L=0.04u
M427 I186_3 n61 U121/XU1-net8 VDD pmos W=0.205u L=0.04u
M428 U121/net4 n60 VDD VDD pmos W=0.205u L=0.04u
M429 I171_4 n91 VSS VSS nmos W=0.155u L=0.04u
M430 I171_4 n90 VSS VSS nmos W=0.155u L=0.04u
M431 U122/XI1-net8 n90 VDD VDD pmos W=0.205u L=0.04u
M432 I171_4 n91 U122/XI1-net8 VDD pmos W=0.205u L=0.04u
M433 n90 X_7 VSS VSS nmos W=0.135u L=0.04u
M434 n90 X_7 VDD VDD pmos W=0.205u L=0.04u
M435 I171_3 X_7 VSS VSS nmos W=0.155u L=0.04u
M436 I171_3 n11 VSS VSS nmos W=0.155u L=0.04u
M437 U124/XI1-net8 n11 VDD VDD pmos W=0.205u L=0.04u
M438 I171_3 X_7 U124/XI1-net8 VDD pmos W=0.205u L=0.04u
M439 n11 n91 VSS VSS nmos W=0.135u L=0.04u
M440 n11 n91 VDD VDD pmos W=0.205u L=0.04u
M441 n91 n62 VSS VSS nmos W=0.155u L=0.04u
M442 n91 n60 VSS VSS nmos W=0.155u L=0.04u
M443 n91 n61 VSS VSS nmos W=0.155u L=0.04u
M444 U126/net25 n62 VDD VDD pmos W=0.41u L=0.04u
M445 U126/net28 n60 U126/net25 VDD pmos W=0.41u L=0.04u
M446 n91 n61 U126/net28 VDD pmos W=0.41u L=0.04u
M447 n62 X_6 VSS VSS nmos W=0.135u L=0.04u
M448 n62 X_6 VDD VDD pmos W=0.205u L=0.04u
M449 U128/XU1-net6 n86 VSS VSS nmos W=0.155u L=0.04u
M450 n60 X_4 U128/XU1-net6 VSS nmos W=0.155u L=0.04u
M451 n60 n86 VDD VDD pmos W=0.155u L=0.04u
M452 n60 X_4 VDD VDD pmos W=0.155u L=0.04u
M453 n86 n88 VSS VSS nmos W=0.155u L=0.04u
M454 n86 n52 VSS VSS nmos W=0.155u L=0.04u
M455 U129/XI1-net8 n52 VDD VDD pmos W=0.205u L=0.04u
M456 n86 n88 U129/XI1-net8 VDD pmos W=0.205u L=0.04u
M457 n52 X_1 U130/XI0-net10 VSS nmos W=0.155u L=0.04u
M458 U130/XI0-net10 P_0 U130/XI0-net13 VSS nmos W=0.155u L=0.04u
M459 U130/XI0-net13 X_2 VSS VSS nmos W=0.155u L=0.04u
M460 n52 X_2 VDD VDD pmos W=0.205u L=0.04u
M461 n52 X_1 VDD VDD pmos W=0.205u L=0.04u
M462 n52 P_0 VDD VDD pmos W=0.205u L=0.04u
M463 n88 X_3 VSS VSS nmos W=0.135u L=0.04u
M464 n88 X_3 VDD VDD pmos W=0.205u L=0.04u
M465 n61 X_5 VSS VSS nmos W=0.135u L=0.04u
M466 n61 X_5 VDD VDD pmos W=0.205u L=0.04u
.ENDS
