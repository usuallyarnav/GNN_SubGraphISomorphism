.SUBCKT c499 N1 N5 N9 N13 N17 N21 N25 N29 N33 N37 N41 N45 N49 N53 N57 N61 N65 N69 N73 N77 N81 N85 N89 N93 N97 N101 N105 N109 N113 N117 N121 N125 N129 N130 N131 N132 N133 N134 N135 N136 N137 N724 N725 N726 N727 N728 N729 N730 N731 N732 N733 N734 N735 N736 N737 N738 N739 N740 N741 N742 N743 N744 N745 N746 N747 N748 N749 N750 N751 N752 N753 N754 N755 VDD VSS
M1 U129/net4 n97 U129/net14 VSS nmos W=0.155u L=0.04u
M2 U129/net6 U129/net10 U129/net14 VSS nmos W=0.17u L=0.04u
M3 U129/net4 N125 VSS VSS nmos W=0.155u L=0.04u
M4 U129/net6 U129/net4 VSS VSS nmos W=0.17u L=0.04u
M5 N755 U129/net14 VSS VSS nmos W=0.155u L=0.04u
M6 U129/net10 n97 VSS VSS nmos W=0.155u L=0.04u
M7 U129/net4 U129/net10 U129/net14 VDD pmos W=0.255u L=0.04u
M8 U129/net6 n97 U129/net14 VDD pmos W=0.28u L=0.04u
M9 U129/net4 N125 VDD VDD pmos W=0.205u L=0.04u
M10 U129/net6 U129/net4 VDD VDD pmos W=0.24u L=0.04u
M11 N755 U129/net14 VDD VDD pmos W=0.205u L=0.04u
M12 U129/net10 n97 VDD VDD pmos W=0.205u L=0.04u
M13 U130/XU1-net6 n99 VSS VSS nmos W=0.155u L=0.04u
M14 n97 n98 U130/XU1-net6 VSS nmos W=0.155u L=0.04u
M15 n97 n99 VDD VDD pmos W=0.155u L=0.04u
M16 n97 n98 VDD VDD pmos W=0.155u L=0.04u
M17 U131/net4 n100 U131/net14 VSS nmos W=0.155u L=0.04u
M18 U131/net6 U131/net10 U131/net14 VSS nmos W=0.17u L=0.04u
M19 U131/net4 N121 VSS VSS nmos W=0.155u L=0.04u
M20 U131/net6 U131/net4 VSS VSS nmos W=0.17u L=0.04u
M21 N754 U131/net14 VSS VSS nmos W=0.155u L=0.04u
M22 U131/net10 n100 VSS VSS nmos W=0.155u L=0.04u
M23 U131/net4 U131/net10 U131/net14 VDD pmos W=0.255u L=0.04u
M24 U131/net6 n100 U131/net14 VDD pmos W=0.28u L=0.04u
M25 U131/net4 N121 VDD VDD pmos W=0.205u L=0.04u
M26 U131/net6 U131/net4 VDD VDD pmos W=0.24u L=0.04u
M27 N754 U131/net14 VDD VDD pmos W=0.205u L=0.04u
M28 U131/net10 n100 VDD VDD pmos W=0.205u L=0.04u
M29 U132/XU1-net6 n101 VSS VSS nmos W=0.155u L=0.04u
M30 n100 n98 U132/XU1-net6 VSS nmos W=0.155u L=0.04u
M31 n100 n101 VDD VDD pmos W=0.155u L=0.04u
M32 n100 n98 VDD VDD pmos W=0.155u L=0.04u
M33 U133/net4 n102 U133/net14 VSS nmos W=0.155u L=0.04u
M34 U133/net6 U133/net10 U133/net14 VSS nmos W=0.17u L=0.04u
M35 U133/net4 N117 VSS VSS nmos W=0.155u L=0.04u
M36 U133/net6 U133/net4 VSS VSS nmos W=0.17u L=0.04u
M37 N753 U133/net14 VSS VSS nmos W=0.155u L=0.04u
M38 U133/net10 n102 VSS VSS nmos W=0.155u L=0.04u
M39 U133/net4 U133/net10 U133/net14 VDD pmos W=0.255u L=0.04u
M40 U133/net6 n102 U133/net14 VDD pmos W=0.28u L=0.04u
M41 U133/net4 N117 VDD VDD pmos W=0.205u L=0.04u
M42 U133/net6 U133/net4 VDD VDD pmos W=0.24u L=0.04u
M43 N753 U133/net14 VDD VDD pmos W=0.205u L=0.04u
M44 U133/net10 n102 VDD VDD pmos W=0.205u L=0.04u
M45 U134/XU1-net6 n103 VSS VSS nmos W=0.155u L=0.04u
M46 n102 n98 U134/XU1-net6 VSS nmos W=0.155u L=0.04u
M47 n102 n103 VDD VDD pmos W=0.155u L=0.04u
M48 n102 n98 VDD VDD pmos W=0.155u L=0.04u
M49 U135/net4 n104 U135/net14 VSS nmos W=0.155u L=0.04u
M50 U135/net6 U135/net10 U135/net14 VSS nmos W=0.17u L=0.04u
M51 U135/net4 N113 VSS VSS nmos W=0.155u L=0.04u
M52 U135/net6 U135/net4 VSS VSS nmos W=0.17u L=0.04u
M53 N752 U135/net14 VSS VSS nmos W=0.155u L=0.04u
M54 U135/net10 n104 VSS VSS nmos W=0.155u L=0.04u
M55 U135/net4 U135/net10 U135/net14 VDD pmos W=0.255u L=0.04u
M56 U135/net6 n104 U135/net14 VDD pmos W=0.28u L=0.04u
M57 U135/net4 N113 VDD VDD pmos W=0.205u L=0.04u
M58 U135/net6 U135/net4 VDD VDD pmos W=0.24u L=0.04u
M59 N752 U135/net14 VDD VDD pmos W=0.205u L=0.04u
M60 U135/net10 n104 VDD VDD pmos W=0.205u L=0.04u
M61 U136/XU1-net6 n105 VSS VSS nmos W=0.155u L=0.04u
M62 n104 n98 U136/XU1-net6 VSS nmos W=0.155u L=0.04u
M63 n104 n105 VDD VDD pmos W=0.155u L=0.04u
M64 n104 n98 VDD VDD pmos W=0.155u L=0.04u
M65 n98 U137/net6 VSS VSS nmos W=0.155u L=0.04u
M66 U137/net6 n106 U137/XU30-net23 VSS nmos W=0.155u L=0.04u
M67 U137/XU30-net23 n107 U137/XU30-net26 VSS nmos W=0.155u L=0.04u
M68 U137/XU30-net26 n108 U137/XU30-net29 VSS nmos W=0.155u L=0.04u
M69 U137/XU30-net29 n109 VSS VSS nmos W=0.155u L=0.04u
M70 n98 U137/net6 VDD VDD pmos W=0.205u L=0.04u
M71 U137/net6 n109 VDD VDD pmos W=0.205u L=0.04u
M72 U137/net6 n108 VDD VDD pmos W=0.205u L=0.04u
M73 U137/net6 n107 VDD VDD pmos W=0.205u L=0.04u
M74 U137/net6 n106 VDD VDD pmos W=0.205u L=0.04u
M75 U138/net4 n110 U138/net14 VSS nmos W=0.155u L=0.04u
M76 U138/net6 U138/net10 U138/net14 VSS nmos W=0.17u L=0.04u
M77 U138/net4 N109 VSS VSS nmos W=0.155u L=0.04u
M78 U138/net6 U138/net4 VSS VSS nmos W=0.17u L=0.04u
M79 N751 U138/net14 VSS VSS nmos W=0.155u L=0.04u
M80 U138/net10 n110 VSS VSS nmos W=0.155u L=0.04u
M81 U138/net4 U138/net10 U138/net14 VDD pmos W=0.255u L=0.04u
M82 U138/net6 n110 U138/net14 VDD pmos W=0.28u L=0.04u
M83 U138/net4 N109 VDD VDD pmos W=0.205u L=0.04u
M84 U138/net6 U138/net4 VDD VDD pmos W=0.24u L=0.04u
M85 N751 U138/net14 VDD VDD pmos W=0.205u L=0.04u
M86 U138/net10 n110 VDD VDD pmos W=0.205u L=0.04u
M87 U139/XU1-net6 n99 VSS VSS nmos W=0.155u L=0.04u
M88 n110 n111 U139/XU1-net6 VSS nmos W=0.155u L=0.04u
M89 n110 n99 VDD VDD pmos W=0.155u L=0.04u
M90 n110 n111 VDD VDD pmos W=0.155u L=0.04u
M91 U140/net4 n112 U140/net14 VSS nmos W=0.155u L=0.04u
M92 U140/net6 U140/net10 U140/net14 VSS nmos W=0.17u L=0.04u
M93 U140/net4 N105 VSS VSS nmos W=0.155u L=0.04u
M94 U140/net6 U140/net4 VSS VSS nmos W=0.17u L=0.04u
M95 N750 U140/net14 VSS VSS nmos W=0.155u L=0.04u
M96 U140/net10 n112 VSS VSS nmos W=0.155u L=0.04u
M97 U140/net4 U140/net10 U140/net14 VDD pmos W=0.255u L=0.04u
M98 U140/net6 n112 U140/net14 VDD pmos W=0.28u L=0.04u
M99 U140/net4 N105 VDD VDD pmos W=0.205u L=0.04u
M100 U140/net6 U140/net4 VDD VDD pmos W=0.24u L=0.04u
M101 N750 U140/net14 VDD VDD pmos W=0.205u L=0.04u
M102 U140/net10 n112 VDD VDD pmos W=0.205u L=0.04u
M103 U141/XU1-net6 n101 VSS VSS nmos W=0.155u L=0.04u
M104 n112 n111 U141/XU1-net6 VSS nmos W=0.155u L=0.04u
M105 n112 n101 VDD VDD pmos W=0.155u L=0.04u
M106 n112 n111 VDD VDD pmos W=0.155u L=0.04u
M107 U142/net4 n113 U142/net14 VSS nmos W=0.155u L=0.04u
M108 U142/net6 U142/net10 U142/net14 VSS nmos W=0.17u L=0.04u
M109 U142/net4 N101 VSS VSS nmos W=0.155u L=0.04u
M110 U142/net6 U142/net4 VSS VSS nmos W=0.17u L=0.04u
M111 N749 U142/net14 VSS VSS nmos W=0.155u L=0.04u
M112 U142/net10 n113 VSS VSS nmos W=0.155u L=0.04u
M113 U142/net4 U142/net10 U142/net14 VDD pmos W=0.255u L=0.04u
M114 U142/net6 n113 U142/net14 VDD pmos W=0.28u L=0.04u
M115 U142/net4 N101 VDD VDD pmos W=0.205u L=0.04u
M116 U142/net6 U142/net4 VDD VDD pmos W=0.24u L=0.04u
M117 N749 U142/net14 VDD VDD pmos W=0.205u L=0.04u
M118 U142/net10 n113 VDD VDD pmos W=0.205u L=0.04u
M119 U143/XU1-net6 n103 VSS VSS nmos W=0.155u L=0.04u
M120 n113 n111 U143/XU1-net6 VSS nmos W=0.155u L=0.04u
M121 n113 n103 VDD VDD pmos W=0.155u L=0.04u
M122 n113 n111 VDD VDD pmos W=0.155u L=0.04u
M123 U144/net4 n114 U144/net14 VSS nmos W=0.155u L=0.04u
M124 U144/net6 U144/net10 U144/net14 VSS nmos W=0.17u L=0.04u
M125 U144/net4 N97 VSS VSS nmos W=0.155u L=0.04u
M126 U144/net6 U144/net4 VSS VSS nmos W=0.17u L=0.04u
M127 N748 U144/net14 VSS VSS nmos W=0.155u L=0.04u
M128 U144/net10 n114 VSS VSS nmos W=0.155u L=0.04u
M129 U144/net4 U144/net10 U144/net14 VDD pmos W=0.255u L=0.04u
M130 U144/net6 n114 U144/net14 VDD pmos W=0.28u L=0.04u
M131 U144/net4 N97 VDD VDD pmos W=0.205u L=0.04u
M132 U144/net6 U144/net4 VDD VDD pmos W=0.24u L=0.04u
M133 N748 U144/net14 VDD VDD pmos W=0.205u L=0.04u
M134 U144/net10 n114 VDD VDD pmos W=0.205u L=0.04u
M135 U145/XU1-net6 n105 VSS VSS nmos W=0.155u L=0.04u
M136 n114 n111 U145/XU1-net6 VSS nmos W=0.155u L=0.04u
M137 n114 n105 VDD VDD pmos W=0.155u L=0.04u
M138 n114 n111 VDD VDD pmos W=0.155u L=0.04u
M139 n111 U146/net6 VSS VSS nmos W=0.155u L=0.04u
M140 U146/net6 n115 U146/XU30-net23 VSS nmos W=0.155u L=0.04u
M141 U146/XU30-net23 n109 U146/XU30-net26 VSS nmos W=0.155u L=0.04u
M142 U146/XU30-net26 n116 U146/XU30-net29 VSS nmos W=0.155u L=0.04u
M143 U146/XU30-net29 n117 VSS VSS nmos W=0.155u L=0.04u
M144 n111 U146/net6 VDD VDD pmos W=0.205u L=0.04u
M145 U146/net6 n117 VDD VDD pmos W=0.205u L=0.04u
M146 U146/net6 n116 VDD VDD pmos W=0.205u L=0.04u
M147 U146/net6 n109 VDD VDD pmos W=0.205u L=0.04u
M148 U146/net6 n115 VDD VDD pmos W=0.205u L=0.04u
M149 n117 n118 VSS VSS nmos W=0.155u L=0.04u
M150 n117 n119 VSS VSS nmos W=0.155u L=0.04u
M151 U147/XI1-net8 n119 VDD VDD pmos W=0.205u L=0.04u
M152 n117 n118 U147/XI1-net8 VDD pmos W=0.205u L=0.04u
M153 U148/net4 n120 U148/net14 VSS nmos W=0.155u L=0.04u
M154 U148/net6 U148/net10 U148/net14 VSS nmos W=0.17u L=0.04u
M155 U148/net4 N93 VSS VSS nmos W=0.155u L=0.04u
M156 U148/net6 U148/net4 VSS VSS nmos W=0.17u L=0.04u
M157 N747 U148/net14 VSS VSS nmos W=0.155u L=0.04u
M158 U148/net10 n120 VSS VSS nmos W=0.155u L=0.04u
M159 U148/net4 U148/net10 U148/net14 VDD pmos W=0.255u L=0.04u
M160 U148/net6 n120 U148/net14 VDD pmos W=0.28u L=0.04u
M161 U148/net4 N93 VDD VDD pmos W=0.205u L=0.04u
M162 U148/net6 U148/net4 VDD VDD pmos W=0.24u L=0.04u
M163 N747 U148/net14 VDD VDD pmos W=0.205u L=0.04u
M164 U148/net10 n120 VDD VDD pmos W=0.205u L=0.04u
M165 U149/XU1-net6 n99 VSS VSS nmos W=0.155u L=0.04u
M166 n120 n121 U149/XU1-net6 VSS nmos W=0.155u L=0.04u
M167 n120 n99 VDD VDD pmos W=0.155u L=0.04u
M168 n120 n121 VDD VDD pmos W=0.155u L=0.04u
M169 U150/net4 n122 U150/net14 VSS nmos W=0.155u L=0.04u
M170 U150/net6 U150/net10 U150/net14 VSS nmos W=0.17u L=0.04u
M171 U150/net4 N89 VSS VSS nmos W=0.155u L=0.04u
M172 U150/net6 U150/net4 VSS VSS nmos W=0.17u L=0.04u
M173 N746 U150/net14 VSS VSS nmos W=0.155u L=0.04u
M174 U150/net10 n122 VSS VSS nmos W=0.155u L=0.04u
M175 U150/net4 U150/net10 U150/net14 VDD pmos W=0.255u L=0.04u
M176 U150/net6 n122 U150/net14 VDD pmos W=0.28u L=0.04u
M177 U150/net4 N89 VDD VDD pmos W=0.205u L=0.04u
M178 U150/net6 U150/net4 VDD VDD pmos W=0.24u L=0.04u
M179 N746 U150/net14 VDD VDD pmos W=0.205u L=0.04u
M180 U150/net10 n122 VDD VDD pmos W=0.205u L=0.04u
M181 U151/XU1-net6 n101 VSS VSS nmos W=0.155u L=0.04u
M182 n122 n121 U151/XU1-net6 VSS nmos W=0.155u L=0.04u
M183 n122 n101 VDD VDD pmos W=0.155u L=0.04u
M184 n122 n121 VDD VDD pmos W=0.155u L=0.04u
M185 U152/net4 n123 U152/net14 VSS nmos W=0.155u L=0.04u
M186 U152/net6 U152/net10 U152/net14 VSS nmos W=0.17u L=0.04u
M187 U152/net4 N85 VSS VSS nmos W=0.155u L=0.04u
M188 U152/net6 U152/net4 VSS VSS nmos W=0.17u L=0.04u
M189 N745 U152/net14 VSS VSS nmos W=0.155u L=0.04u
M190 U152/net10 n123 VSS VSS nmos W=0.155u L=0.04u
M191 U152/net4 U152/net10 U152/net14 VDD pmos W=0.255u L=0.04u
M192 U152/net6 n123 U152/net14 VDD pmos W=0.28u L=0.04u
M193 U152/net4 N85 VDD VDD pmos W=0.205u L=0.04u
M194 U152/net6 U152/net4 VDD VDD pmos W=0.24u L=0.04u
M195 N745 U152/net14 VDD VDD pmos W=0.205u L=0.04u
M196 U152/net10 n123 VDD VDD pmos W=0.205u L=0.04u
M197 U153/XU1-net6 n103 VSS VSS nmos W=0.155u L=0.04u
M198 n123 n121 U153/XU1-net6 VSS nmos W=0.155u L=0.04u
M199 n123 n103 VDD VDD pmos W=0.155u L=0.04u
M200 n123 n121 VDD VDD pmos W=0.155u L=0.04u
M201 U154/net4 n124 U154/net14 VSS nmos W=0.155u L=0.04u
M202 U154/net6 U154/net10 U154/net14 VSS nmos W=0.17u L=0.04u
M203 U154/net4 N81 VSS VSS nmos W=0.155u L=0.04u
M204 U154/net6 U154/net4 VSS VSS nmos W=0.17u L=0.04u
M205 N744 U154/net14 VSS VSS nmos W=0.155u L=0.04u
M206 U154/net10 n124 VSS VSS nmos W=0.155u L=0.04u
M207 U154/net4 U154/net10 U154/net14 VDD pmos W=0.255u L=0.04u
M208 U154/net6 n124 U154/net14 VDD pmos W=0.28u L=0.04u
M209 U154/net4 N81 VDD VDD pmos W=0.205u L=0.04u
M210 U154/net6 U154/net4 VDD VDD pmos W=0.24u L=0.04u
M211 N744 U154/net14 VDD VDD pmos W=0.205u L=0.04u
M212 U154/net10 n124 VDD VDD pmos W=0.205u L=0.04u
M213 U155/XU1-net6 n105 VSS VSS nmos W=0.155u L=0.04u
M214 n124 n121 U155/XU1-net6 VSS nmos W=0.155u L=0.04u
M215 n124 n105 VDD VDD pmos W=0.155u L=0.04u
M216 n124 n121 VDD VDD pmos W=0.155u L=0.04u
M217 n121 U156/net6 VSS VSS nmos W=0.155u L=0.04u
M218 U156/net6 n119 U156/XU30-net23 VSS nmos W=0.155u L=0.04u
M219 U156/XU30-net23 n109 U156/XU30-net26 VSS nmos W=0.155u L=0.04u
M220 U156/XU30-net26 n118 U156/XU30-net29 VSS nmos W=0.155u L=0.04u
M221 U156/XU30-net29 n125 VSS VSS nmos W=0.155u L=0.04u
M222 n121 U156/net6 VDD VDD pmos W=0.205u L=0.04u
M223 U156/net6 n125 VDD VDD pmos W=0.205u L=0.04u
M224 U156/net6 n118 VDD VDD pmos W=0.205u L=0.04u
M225 U156/net6 n109 VDD VDD pmos W=0.205u L=0.04u
M226 U156/net6 n119 VDD VDD pmos W=0.205u L=0.04u
M227 n125 n116 VSS VSS nmos W=0.155u L=0.04u
M228 n125 n115 VSS VSS nmos W=0.155u L=0.04u
M229 U157/XI1-net8 n115 VDD VDD pmos W=0.205u L=0.04u
M230 n125 n116 U157/XI1-net8 VDD pmos W=0.205u L=0.04u
M231 U158/net4 n126 U158/net14 VSS nmos W=0.155u L=0.04u
M232 U158/net6 U158/net10 U158/net14 VSS nmos W=0.17u L=0.04u
M233 U158/net4 N77 VSS VSS nmos W=0.155u L=0.04u
M234 U158/net6 U158/net4 VSS VSS nmos W=0.17u L=0.04u
M235 N743 U158/net14 VSS VSS nmos W=0.155u L=0.04u
M236 U158/net10 n126 VSS VSS nmos W=0.155u L=0.04u
M237 U158/net4 U158/net10 U158/net14 VDD pmos W=0.255u L=0.04u
M238 U158/net6 n126 U158/net14 VDD pmos W=0.28u L=0.04u
M239 U158/net4 N77 VDD VDD pmos W=0.205u L=0.04u
M240 U158/net6 U158/net4 VDD VDD pmos W=0.24u L=0.04u
M241 N743 U158/net14 VDD VDD pmos W=0.205u L=0.04u
M242 U158/net10 n126 VDD VDD pmos W=0.205u L=0.04u
M243 U159/XU1-net6 n99 VSS VSS nmos W=0.155u L=0.04u
M244 n126 n127 U159/XU1-net6 VSS nmos W=0.155u L=0.04u
M245 n126 n99 VDD VDD pmos W=0.155u L=0.04u
M246 n126 n127 VDD VDD pmos W=0.155u L=0.04u
M247 U160/net4 n128 U160/net14 VSS nmos W=0.155u L=0.04u
M248 U160/net6 U160/net10 U160/net14 VSS nmos W=0.17u L=0.04u
M249 U160/net4 N73 VSS VSS nmos W=0.155u L=0.04u
M250 U160/net6 U160/net4 VSS VSS nmos W=0.17u L=0.04u
M251 N742 U160/net14 VSS VSS nmos W=0.155u L=0.04u
M252 U160/net10 n128 VSS VSS nmos W=0.155u L=0.04u
M253 U160/net4 U160/net10 U160/net14 VDD pmos W=0.255u L=0.04u
M254 U160/net6 n128 U160/net14 VDD pmos W=0.28u L=0.04u
M255 U160/net4 N73 VDD VDD pmos W=0.205u L=0.04u
M256 U160/net6 U160/net4 VDD VDD pmos W=0.24u L=0.04u
M257 N742 U160/net14 VDD VDD pmos W=0.205u L=0.04u
M258 U160/net10 n128 VDD VDD pmos W=0.205u L=0.04u
M259 U161/XU1-net6 n101 VSS VSS nmos W=0.155u L=0.04u
M260 n128 n127 U161/XU1-net6 VSS nmos W=0.155u L=0.04u
M261 n128 n101 VDD VDD pmos W=0.155u L=0.04u
M262 n128 n127 VDD VDD pmos W=0.155u L=0.04u
M263 U162/net4 n129 U162/net14 VSS nmos W=0.155u L=0.04u
M264 U162/net6 U162/net10 U162/net14 VSS nmos W=0.17u L=0.04u
M265 U162/net4 N69 VSS VSS nmos W=0.155u L=0.04u
M266 U162/net6 U162/net4 VSS VSS nmos W=0.17u L=0.04u
M267 N741 U162/net14 VSS VSS nmos W=0.155u L=0.04u
M268 U162/net10 n129 VSS VSS nmos W=0.155u L=0.04u
M269 U162/net4 U162/net10 U162/net14 VDD pmos W=0.255u L=0.04u
M270 U162/net6 n129 U162/net14 VDD pmos W=0.28u L=0.04u
M271 U162/net4 N69 VDD VDD pmos W=0.205u L=0.04u
M272 U162/net6 U162/net4 VDD VDD pmos W=0.24u L=0.04u
M273 N741 U162/net14 VDD VDD pmos W=0.205u L=0.04u
M274 U162/net10 n129 VDD VDD pmos W=0.205u L=0.04u
M275 U163/XU1-net6 n103 VSS VSS nmos W=0.155u L=0.04u
M276 n129 n127 U163/XU1-net6 VSS nmos W=0.155u L=0.04u
M277 n129 n103 VDD VDD pmos W=0.155u L=0.04u
M278 n129 n127 VDD VDD pmos W=0.155u L=0.04u
M279 U164/net4 n130 U164/net14 VSS nmos W=0.155u L=0.04u
M280 U164/net6 U164/net10 U164/net14 VSS nmos W=0.17u L=0.04u
M281 U164/net4 N65 VSS VSS nmos W=0.155u L=0.04u
M282 U164/net6 U164/net4 VSS VSS nmos W=0.17u L=0.04u
M283 N740 U164/net14 VSS VSS nmos W=0.155u L=0.04u
M284 U164/net10 n130 VSS VSS nmos W=0.155u L=0.04u
M285 U164/net4 U164/net10 U164/net14 VDD pmos W=0.255u L=0.04u
M286 U164/net6 n130 U164/net14 VDD pmos W=0.28u L=0.04u
M287 U164/net4 N65 VDD VDD pmos W=0.205u L=0.04u
M288 U164/net6 U164/net4 VDD VDD pmos W=0.24u L=0.04u
M289 N740 U164/net14 VDD VDD pmos W=0.205u L=0.04u
M290 U164/net10 n130 VDD VDD pmos W=0.205u L=0.04u
M291 U165/XU1-net6 n105 VSS VSS nmos W=0.155u L=0.04u
M292 n130 n127 U165/XU1-net6 VSS nmos W=0.155u L=0.04u
M293 n130 n105 VDD VDD pmos W=0.155u L=0.04u
M294 n130 n127 VDD VDD pmos W=0.155u L=0.04u
M295 n127 U166/net6 VSS VSS nmos W=0.155u L=0.04u
M296 U166/net6 n131 U166/XU30-net23 VSS nmos W=0.155u L=0.04u
M297 U166/XU30-net23 n132 U166/XU30-net26 VSS nmos W=0.155u L=0.04u
M298 U166/XU30-net26 n133 U166/XU30-net29 VSS nmos W=0.155u L=0.04u
M299 U166/XU30-net29 n109 VSS VSS nmos W=0.155u L=0.04u
M300 n127 U166/net6 VDD VDD pmos W=0.205u L=0.04u
M301 U166/net6 n109 VDD VDD pmos W=0.205u L=0.04u
M302 U166/net6 n133 VDD VDD pmos W=0.205u L=0.04u
M303 U166/net6 n132 VDD VDD pmos W=0.205u L=0.04u
M304 U166/net6 n131 VDD VDD pmos W=0.205u L=0.04u
M305 U167/net15 n135 VSS VSS nmos W=0.155u L=0.04u
M306 U167/net15 n99 VSS VSS nmos W=0.155u L=0.04u
M307 n109 n105 U167/net15 VSS nmos W=0.155u L=0.04u
M308 n109 n134 U167/net15 VSS nmos W=0.155u L=0.04u
M309 U167/net15 n103 VSS VSS nmos W=0.155u L=0.04u
M310 n109 n101 U167/net15 VSS nmos W=0.155u L=0.04u
M311 n109 n103 U167/XI1-net11 VDD pmos W=0.205u L=0.04u
M312 U167/XI1-net11 n135 U167/XI1-net18 VDD pmos W=0.205u L=0.04u
M313 U167/XI1-net18 n99 VDD VDD pmos W=0.205u L=0.04u
M314 n109 n105 U167/XI7-net11 VDD pmos W=0.205u L=0.04u
M315 U167/XI7-net11 n134 U167/XI7-net18 VDD pmos W=0.205u L=0.04u
M316 U167/XI7-net18 n101 VDD VDD pmos W=0.205u L=0.04u
M317 U168/net4 n136 U168/net14 VSS nmos W=0.155u L=0.04u
M318 U168/net6 U168/net10 U168/net14 VSS nmos W=0.17u L=0.04u
M319 U168/net4 N61 VSS VSS nmos W=0.155u L=0.04u
M320 U168/net6 U168/net4 VSS VSS nmos W=0.17u L=0.04u
M321 N739 U168/net14 VSS VSS nmos W=0.155u L=0.04u
M322 U168/net10 n136 VSS VSS nmos W=0.155u L=0.04u
M323 U168/net4 U168/net10 U168/net14 VDD pmos W=0.255u L=0.04u
M324 U168/net6 n136 U168/net14 VDD pmos W=0.28u L=0.04u
M325 U168/net4 N61 VDD VDD pmos W=0.205u L=0.04u
M326 U168/net6 U168/net4 VDD VDD pmos W=0.24u L=0.04u
M327 N739 U168/net14 VDD VDD pmos W=0.205u L=0.04u
M328 U168/net10 n136 VDD VDD pmos W=0.205u L=0.04u
M329 U169/XU1-net6 n119 VSS VSS nmos W=0.155u L=0.04u
M330 n136 n137 U169/XU1-net6 VSS nmos W=0.155u L=0.04u
M331 n136 n119 VDD VDD pmos W=0.155u L=0.04u
M332 n136 n137 VDD VDD pmos W=0.155u L=0.04u
M333 U170/net4 n138 U170/net14 VSS nmos W=0.155u L=0.04u
M334 U170/net6 U170/net10 U170/net14 VSS nmos W=0.17u L=0.04u
M335 U170/net4 N57 VSS VSS nmos W=0.155u L=0.04u
M336 U170/net6 U170/net4 VSS VSS nmos W=0.17u L=0.04u
M337 N738 U170/net14 VSS VSS nmos W=0.155u L=0.04u
M338 U170/net10 n138 VSS VSS nmos W=0.155u L=0.04u
M339 U170/net4 U170/net10 U170/net14 VDD pmos W=0.255u L=0.04u
M340 U170/net6 n138 U170/net14 VDD pmos W=0.28u L=0.04u
M341 U170/net4 N57 VDD VDD pmos W=0.205u L=0.04u
M342 U170/net6 U170/net4 VDD VDD pmos W=0.24u L=0.04u
M343 N738 U170/net14 VDD VDD pmos W=0.205u L=0.04u
M344 U170/net10 n138 VDD VDD pmos W=0.205u L=0.04u
M345 U171/XU1-net6 n116 VSS VSS nmos W=0.155u L=0.04u
M346 n138 n137 U171/XU1-net6 VSS nmos W=0.155u L=0.04u
M347 n138 n116 VDD VDD pmos W=0.155u L=0.04u
M348 n138 n137 VDD VDD pmos W=0.155u L=0.04u
M349 U172/net4 n139 U172/net14 VSS nmos W=0.155u L=0.04u
M350 U172/net6 U172/net10 U172/net14 VSS nmos W=0.17u L=0.04u
M351 U172/net4 N53 VSS VSS nmos W=0.155u L=0.04u
M352 U172/net6 U172/net4 VSS VSS nmos W=0.17u L=0.04u
M353 N737 U172/net14 VSS VSS nmos W=0.155u L=0.04u
M354 U172/net10 n139 VSS VSS nmos W=0.155u L=0.04u
M355 U172/net4 U172/net10 U172/net14 VDD pmos W=0.255u L=0.04u
M356 U172/net6 n139 U172/net14 VDD pmos W=0.28u L=0.04u
M357 U172/net4 N53 VDD VDD pmos W=0.205u L=0.04u
M358 U172/net6 U172/net4 VDD VDD pmos W=0.24u L=0.04u
M359 N737 U172/net14 VDD VDD pmos W=0.205u L=0.04u
M360 U172/net10 n139 VDD VDD pmos W=0.205u L=0.04u
M361 U173/XU1-net6 n115 VSS VSS nmos W=0.155u L=0.04u
M362 n139 n137 U173/XU1-net6 VSS nmos W=0.155u L=0.04u
M363 n139 n115 VDD VDD pmos W=0.155u L=0.04u
M364 n139 n137 VDD VDD pmos W=0.155u L=0.04u
M365 U174/net4 n140 U174/net14 VSS nmos W=0.155u L=0.04u
M366 U174/net6 U174/net10 U174/net14 VSS nmos W=0.17u L=0.04u
M367 U174/net4 N49 VSS VSS nmos W=0.155u L=0.04u
M368 U174/net6 U174/net4 VSS VSS nmos W=0.17u L=0.04u
M369 N736 U174/net14 VSS VSS nmos W=0.155u L=0.04u
M370 U174/net10 n140 VSS VSS nmos W=0.155u L=0.04u
M371 U174/net4 U174/net10 U174/net14 VDD pmos W=0.255u L=0.04u
M372 U174/net6 n140 U174/net14 VDD pmos W=0.28u L=0.04u
M373 U174/net4 N49 VDD VDD pmos W=0.205u L=0.04u
M374 U174/net6 U174/net4 VDD VDD pmos W=0.24u L=0.04u
M375 N736 U174/net14 VDD VDD pmos W=0.205u L=0.04u
M376 U174/net10 n140 VDD VDD pmos W=0.205u L=0.04u
M377 U175/XU1-net6 n118 VSS VSS nmos W=0.155u L=0.04u
M378 n140 n137 U175/XU1-net6 VSS nmos W=0.155u L=0.04u
M379 n140 n118 VDD VDD pmos W=0.155u L=0.04u
M380 n140 n137 VDD VDD pmos W=0.155u L=0.04u
M381 n137 U176/net6 VSS VSS nmos W=0.155u L=0.04u
M382 U176/net6 n141 U176/XU30-net23 VSS nmos W=0.155u L=0.04u
M383 U176/XU30-net23 n134 U176/XU30-net26 VSS nmos W=0.155u L=0.04u
M384 U176/XU30-net26 n142 U176/XU30-net29 VSS nmos W=0.155u L=0.04u
M385 U176/XU30-net29 n143 VSS VSS nmos W=0.155u L=0.04u
M386 n137 U176/net6 VDD VDD pmos W=0.205u L=0.04u
M387 U176/net6 n143 VDD VDD pmos W=0.205u L=0.04u
M388 U176/net6 n142 VDD VDD pmos W=0.205u L=0.04u
M389 U176/net6 n134 VDD VDD pmos W=0.205u L=0.04u
M390 U176/net6 n141 VDD VDD pmos W=0.205u L=0.04u
M391 n134 n144 VSS VSS nmos W=0.155u L=0.04u
M392 n134 n145 VSS VSS nmos W=0.155u L=0.04u
M393 U177/XI1-net8 n145 VDD VDD pmos W=0.205u L=0.04u
M394 n134 n144 U177/XI1-net8 VDD pmos W=0.205u L=0.04u
M395 U178/net4 n146 U178/net14 VSS nmos W=0.155u L=0.04u
M396 U178/net6 U178/net10 U178/net14 VSS nmos W=0.17u L=0.04u
M397 U178/net4 N45 VSS VSS nmos W=0.155u L=0.04u
M398 U178/net6 U178/net4 VSS VSS nmos W=0.17u L=0.04u
M399 N735 U178/net14 VSS VSS nmos W=0.155u L=0.04u
M400 U178/net10 n146 VSS VSS nmos W=0.155u L=0.04u
M401 U178/net4 U178/net10 U178/net14 VDD pmos W=0.255u L=0.04u
M402 U178/net6 n146 U178/net14 VDD pmos W=0.28u L=0.04u
M403 U178/net4 N45 VDD VDD pmos W=0.205u L=0.04u
M404 U178/net6 U178/net4 VDD VDD pmos W=0.24u L=0.04u
M405 N735 U178/net14 VDD VDD pmos W=0.205u L=0.04u
M406 U178/net10 n146 VDD VDD pmos W=0.205u L=0.04u
M407 U179/XU1-net6 n119 VSS VSS nmos W=0.155u L=0.04u
M408 n146 n147 U179/XU1-net6 VSS nmos W=0.155u L=0.04u
M409 n146 n119 VDD VDD pmos W=0.155u L=0.04u
M410 n146 n147 VDD VDD pmos W=0.155u L=0.04u
M411 U180/net4 n148 U180/net14 VSS nmos W=0.155u L=0.04u
M412 U180/net6 U180/net10 U180/net14 VSS nmos W=0.17u L=0.04u
M413 U180/net4 N41 VSS VSS nmos W=0.155u L=0.04u
M414 U180/net6 U180/net4 VSS VSS nmos W=0.17u L=0.04u
M415 N734 U180/net14 VSS VSS nmos W=0.155u L=0.04u
M416 U180/net10 n148 VSS VSS nmos W=0.155u L=0.04u
M417 U180/net4 U180/net10 U180/net14 VDD pmos W=0.255u L=0.04u
M418 U180/net6 n148 U180/net14 VDD pmos W=0.28u L=0.04u
M419 U180/net4 N41 VDD VDD pmos W=0.205u L=0.04u
M420 U180/net6 U180/net4 VDD VDD pmos W=0.24u L=0.04u
M421 N734 U180/net14 VDD VDD pmos W=0.205u L=0.04u
M422 U180/net10 n148 VDD VDD pmos W=0.205u L=0.04u
M423 U181/XU1-net6 n116 VSS VSS nmos W=0.155u L=0.04u
M424 n148 n147 U181/XU1-net6 VSS nmos W=0.155u L=0.04u
M425 n148 n116 VDD VDD pmos W=0.155u L=0.04u
M426 n148 n147 VDD VDD pmos W=0.155u L=0.04u
M427 U182/net4 n149 U182/net14 VSS nmos W=0.155u L=0.04u
M428 U182/net6 U182/net10 U182/net14 VSS nmos W=0.17u L=0.04u
M429 U182/net4 N37 VSS VSS nmos W=0.155u L=0.04u
M430 U182/net6 U182/net4 VSS VSS nmos W=0.17u L=0.04u
M431 N733 U182/net14 VSS VSS nmos W=0.155u L=0.04u
M432 U182/net10 n149 VSS VSS nmos W=0.155u L=0.04u
M433 U182/net4 U182/net10 U182/net14 VDD pmos W=0.255u L=0.04u
M434 U182/net6 n149 U182/net14 VDD pmos W=0.28u L=0.04u
M435 U182/net4 N37 VDD VDD pmos W=0.205u L=0.04u
M436 U182/net6 U182/net4 VDD VDD pmos W=0.24u L=0.04u
M437 N733 U182/net14 VDD VDD pmos W=0.205u L=0.04u
M438 U182/net10 n149 VDD VDD pmos W=0.205u L=0.04u
M439 U183/XU1-net6 n115 VSS VSS nmos W=0.155u L=0.04u
M440 n149 n147 U183/XU1-net6 VSS nmos W=0.155u L=0.04u
M441 n149 n115 VDD VDD pmos W=0.155u L=0.04u
M442 n149 n147 VDD VDD pmos W=0.155u L=0.04u
M443 U184/net4 n150 U184/net14 VSS nmos W=0.155u L=0.04u
M444 U184/net6 U184/net10 U184/net14 VSS nmos W=0.17u L=0.04u
M445 U184/net4 N33 VSS VSS nmos W=0.155u L=0.04u
M446 U184/net6 U184/net4 VSS VSS nmos W=0.17u L=0.04u
M447 N732 U184/net14 VSS VSS nmos W=0.155u L=0.04u
M448 U184/net10 n150 VSS VSS nmos W=0.155u L=0.04u
M449 U184/net4 U184/net10 U184/net14 VDD pmos W=0.255u L=0.04u
M450 U184/net6 n150 U184/net14 VDD pmos W=0.28u L=0.04u
M451 U184/net4 N33 VDD VDD pmos W=0.205u L=0.04u
M452 U184/net6 U184/net4 VDD VDD pmos W=0.24u L=0.04u
M453 N732 U184/net14 VDD VDD pmos W=0.205u L=0.04u
M454 U184/net10 n150 VDD VDD pmos W=0.205u L=0.04u
M455 U185/XU1-net6 n118 VSS VSS nmos W=0.155u L=0.04u
M456 n150 n147 U185/XU1-net6 VSS nmos W=0.155u L=0.04u
M457 n150 n118 VDD VDD pmos W=0.155u L=0.04u
M458 n150 n147 VDD VDD pmos W=0.155u L=0.04u
M459 n147 U186/net6 VSS VSS nmos W=0.155u L=0.04u
M460 U186/net6 n101 U186/XU30-net23 VSS nmos W=0.155u L=0.04u
M461 U186/XU30-net23 n143 U186/XU30-net26 VSS nmos W=0.155u L=0.04u
M462 U186/XU30-net26 n103 U186/XU30-net29 VSS nmos W=0.155u L=0.04u
M463 U186/XU30-net29 n151 VSS VSS nmos W=0.155u L=0.04u
M464 n147 U186/net6 VDD VDD pmos W=0.205u L=0.04u
M465 U186/net6 n151 VDD VDD pmos W=0.205u L=0.04u
M466 U186/net6 n103 VDD VDD pmos W=0.205u L=0.04u
M467 U186/net6 n143 VDD VDD pmos W=0.205u L=0.04u
M468 U186/net6 n101 VDD VDD pmos W=0.205u L=0.04u
M469 n151 n99 VSS VSS nmos W=0.155u L=0.04u
M470 n151 n105 VSS VSS nmos W=0.155u L=0.04u
M471 U187/XI1-net8 n105 VDD VDD pmos W=0.205u L=0.04u
M472 n151 n99 U187/XI1-net8 VDD pmos W=0.205u L=0.04u
M473 U188/net4 n152 U188/net14 VSS nmos W=0.155u L=0.04u
M474 U188/net6 U188/net10 U188/net14 VSS nmos W=0.17u L=0.04u
M475 U188/net4 N29 VSS VSS nmos W=0.155u L=0.04u
M476 U188/net6 U188/net4 VSS VSS nmos W=0.17u L=0.04u
M477 N731 U188/net14 VSS VSS nmos W=0.155u L=0.04u
M478 U188/net10 n152 VSS VSS nmos W=0.155u L=0.04u
M479 U188/net4 U188/net10 U188/net14 VDD pmos W=0.255u L=0.04u
M480 U188/net6 n152 U188/net14 VDD pmos W=0.28u L=0.04u
M481 U188/net4 N29 VDD VDD pmos W=0.205u L=0.04u
M482 U188/net6 U188/net4 VDD VDD pmos W=0.24u L=0.04u
M483 N731 U188/net14 VDD VDD pmos W=0.205u L=0.04u
M484 U188/net10 n152 VDD VDD pmos W=0.205u L=0.04u
M485 U189/XU1-net6 n119 VSS VSS nmos W=0.155u L=0.04u
M486 n152 n153 U189/XU1-net6 VSS nmos W=0.155u L=0.04u
M487 n152 n119 VDD VDD pmos W=0.155u L=0.04u
M488 n152 n153 VDD VDD pmos W=0.155u L=0.04u
M489 U190/net4 n154 U190/net14 VSS nmos W=0.155u L=0.04u
M490 U190/net6 U190/net10 U190/net14 VSS nmos W=0.17u L=0.04u
M491 U190/net4 N25 VSS VSS nmos W=0.155u L=0.04u
M492 U190/net6 U190/net4 VSS VSS nmos W=0.17u L=0.04u
M493 N730 U190/net14 VSS VSS nmos W=0.155u L=0.04u
M494 U190/net10 n154 VSS VSS nmos W=0.155u L=0.04u
M495 U190/net4 U190/net10 U190/net14 VDD pmos W=0.255u L=0.04u
M496 U190/net6 n154 U190/net14 VDD pmos W=0.28u L=0.04u
M497 U190/net4 N25 VDD VDD pmos W=0.205u L=0.04u
M498 U190/net6 U190/net4 VDD VDD pmos W=0.24u L=0.04u
M499 N730 U190/net14 VDD VDD pmos W=0.205u L=0.04u
M500 U190/net10 n154 VDD VDD pmos W=0.205u L=0.04u
M501 U191/XU1-net6 n116 VSS VSS nmos W=0.155u L=0.04u
M502 n154 n153 U191/XU1-net6 VSS nmos W=0.155u L=0.04u
M503 n154 n116 VDD VDD pmos W=0.155u L=0.04u
M504 n154 n153 VDD VDD pmos W=0.155u L=0.04u
M505 U192/net4 n155 U192/net14 VSS nmos W=0.155u L=0.04u
M506 U192/net6 U192/net10 U192/net14 VSS nmos W=0.17u L=0.04u
M507 U192/net4 N21 VSS VSS nmos W=0.155u L=0.04u
M508 U192/net6 U192/net4 VSS VSS nmos W=0.17u L=0.04u
M509 N729 U192/net14 VSS VSS nmos W=0.155u L=0.04u
M510 U192/net10 n155 VSS VSS nmos W=0.155u L=0.04u
M511 U192/net4 U192/net10 U192/net14 VDD pmos W=0.255u L=0.04u
M512 U192/net6 n155 U192/net14 VDD pmos W=0.28u L=0.04u
M513 U192/net4 N21 VDD VDD pmos W=0.205u L=0.04u
M514 U192/net6 U192/net4 VDD VDD pmos W=0.24u L=0.04u
M515 N729 U192/net14 VDD VDD pmos W=0.205u L=0.04u
M516 U192/net10 n155 VDD VDD pmos W=0.205u L=0.04u
M517 U193/XU1-net6 n115 VSS VSS nmos W=0.155u L=0.04u
M518 n155 n153 U193/XU1-net6 VSS nmos W=0.155u L=0.04u
M519 n155 n115 VDD VDD pmos W=0.155u L=0.04u
M520 n155 n153 VDD VDD pmos W=0.155u L=0.04u
M521 U194/net4 n156 U194/net14 VSS nmos W=0.155u L=0.04u
M522 U194/net6 U194/net10 U194/net14 VSS nmos W=0.17u L=0.04u
M523 U194/net4 N17 VSS VSS nmos W=0.155u L=0.04u
M524 U194/net6 U194/net4 VSS VSS nmos W=0.17u L=0.04u
M525 N728 U194/net14 VSS VSS nmos W=0.155u L=0.04u
M526 U194/net10 n156 VSS VSS nmos W=0.155u L=0.04u
M527 U194/net4 U194/net10 U194/net14 VDD pmos W=0.255u L=0.04u
M528 U194/net6 n156 U194/net14 VDD pmos W=0.28u L=0.04u
M529 U194/net4 N17 VDD VDD pmos W=0.205u L=0.04u
M530 U194/net6 U194/net4 VDD VDD pmos W=0.24u L=0.04u
M531 N728 U194/net14 VDD VDD pmos W=0.205u L=0.04u
M532 U194/net10 n156 VDD VDD pmos W=0.205u L=0.04u
M533 U195/XU1-net6 n118 VSS VSS nmos W=0.155u L=0.04u
M534 n156 n153 U195/XU1-net6 VSS nmos W=0.155u L=0.04u
M535 n156 n118 VDD VDD pmos W=0.155u L=0.04u
M536 n156 n153 VDD VDD pmos W=0.155u L=0.04u
M537 n153 U196/net6 VSS VSS nmos W=0.155u L=0.04u
M538 U196/net6 n105 U196/XU30-net23 VSS nmos W=0.155u L=0.04u
M539 U196/XU30-net23 n143 U196/XU30-net26 VSS nmos W=0.155u L=0.04u
M540 U196/XU30-net26 n99 U196/XU30-net29 VSS nmos W=0.155u L=0.04u
M541 U196/XU30-net29 n157 VSS VSS nmos W=0.155u L=0.04u
M542 n153 U196/net6 VDD VDD pmos W=0.205u L=0.04u
M543 U196/net6 n157 VDD VDD pmos W=0.205u L=0.04u
M544 U196/net6 n99 VDD VDD pmos W=0.205u L=0.04u
M545 U196/net6 n143 VDD VDD pmos W=0.205u L=0.04u
M546 U196/net6 n105 VDD VDD pmos W=0.205u L=0.04u
M547 n157 n101 VSS VSS nmos W=0.155u L=0.04u
M548 n157 n103 VSS VSS nmos W=0.155u L=0.04u
M549 U197/XI1-net8 n103 VDD VDD pmos W=0.205u L=0.04u
M550 n157 n101 U197/XI1-net8 VDD pmos W=0.205u L=0.04u
M551 n103 n144 VSS VSS nmos W=0.135u L=0.04u
M552 n103 n144 VDD VDD pmos W=0.205u L=0.04u
M553 n101 n141 VSS VSS nmos W=0.135u L=0.04u
M554 n101 n141 VDD VDD pmos W=0.205u L=0.04u
M555 n99 n145 VSS VSS nmos W=0.135u L=0.04u
M556 n99 n145 VDD VDD pmos W=0.205u L=0.04u
M557 n105 n142 VSS VSS nmos W=0.135u L=0.04u
M558 n105 n142 VDD VDD pmos W=0.205u L=0.04u
M559 U202/net4 n158 U202/net14 VSS nmos W=0.155u L=0.04u
M560 U202/net6 U202/net10 U202/net14 VSS nmos W=0.17u L=0.04u
M561 U202/net4 N13 VSS VSS nmos W=0.155u L=0.04u
M562 U202/net6 U202/net4 VSS VSS nmos W=0.17u L=0.04u
M563 N727 U202/net14 VSS VSS nmos W=0.155u L=0.04u
M564 U202/net10 n158 VSS VSS nmos W=0.155u L=0.04u
M565 U202/net4 U202/net10 U202/net14 VDD pmos W=0.255u L=0.04u
M566 U202/net6 n158 U202/net14 VDD pmos W=0.28u L=0.04u
M567 U202/net4 N13 VDD VDD pmos W=0.205u L=0.04u
M568 U202/net6 U202/net4 VDD VDD pmos W=0.24u L=0.04u
M569 N727 U202/net14 VDD VDD pmos W=0.205u L=0.04u
M570 U202/net10 n158 VDD VDD pmos W=0.205u L=0.04u
M571 U203/XU1-net6 n119 VSS VSS nmos W=0.155u L=0.04u
M572 n158 n159 U203/XU1-net6 VSS nmos W=0.155u L=0.04u
M573 n158 n119 VDD VDD pmos W=0.155u L=0.04u
M574 n158 n159 VDD VDD pmos W=0.155u L=0.04u
M575 U204/net4 n160 U204/net14 VSS nmos W=0.155u L=0.04u
M576 U204/net6 U204/net10 U204/net14 VSS nmos W=0.17u L=0.04u
M577 U204/net4 N9 VSS VSS nmos W=0.155u L=0.04u
M578 U204/net6 U204/net4 VSS VSS nmos W=0.17u L=0.04u
M579 N726 U204/net14 VSS VSS nmos W=0.155u L=0.04u
M580 U204/net10 n160 VSS VSS nmos W=0.155u L=0.04u
M581 U204/net4 U204/net10 U204/net14 VDD pmos W=0.255u L=0.04u
M582 U204/net6 n160 U204/net14 VDD pmos W=0.28u L=0.04u
M583 U204/net4 N9 VDD VDD pmos W=0.205u L=0.04u
M584 U204/net6 U204/net4 VDD VDD pmos W=0.24u L=0.04u
M585 N726 U204/net14 VDD VDD pmos W=0.205u L=0.04u
M586 U204/net10 n160 VDD VDD pmos W=0.205u L=0.04u
M587 U205/XU1-net6 n116 VSS VSS nmos W=0.155u L=0.04u
M588 n160 n159 U205/XU1-net6 VSS nmos W=0.155u L=0.04u
M589 n160 n116 VDD VDD pmos W=0.155u L=0.04u
M590 n160 n159 VDD VDD pmos W=0.155u L=0.04u
M591 U206/net4 n161 U206/net14 VSS nmos W=0.155u L=0.04u
M592 U206/net6 U206/net10 U206/net14 VSS nmos W=0.17u L=0.04u
M593 U206/net4 N5 VSS VSS nmos W=0.155u L=0.04u
M594 U206/net6 U206/net4 VSS VSS nmos W=0.17u L=0.04u
M595 N725 U206/net14 VSS VSS nmos W=0.155u L=0.04u
M596 U206/net10 n161 VSS VSS nmos W=0.155u L=0.04u
M597 U206/net4 U206/net10 U206/net14 VDD pmos W=0.255u L=0.04u
M598 U206/net6 n161 U206/net14 VDD pmos W=0.28u L=0.04u
M599 U206/net4 N5 VDD VDD pmos W=0.205u L=0.04u
M600 U206/net6 U206/net4 VDD VDD pmos W=0.24u L=0.04u
M601 N725 U206/net14 VDD VDD pmos W=0.205u L=0.04u
M602 U206/net10 n161 VDD VDD pmos W=0.205u L=0.04u
M603 U207/XU1-net6 n115 VSS VSS nmos W=0.155u L=0.04u
M604 n161 n159 U207/XU1-net6 VSS nmos W=0.155u L=0.04u
M605 n161 n115 VDD VDD pmos W=0.155u L=0.04u
M606 n161 n159 VDD VDD pmos W=0.155u L=0.04u
M607 U208/net4 n162 U208/net14 VSS nmos W=0.155u L=0.04u
M608 U208/net6 U208/net10 U208/net14 VSS nmos W=0.17u L=0.04u
M609 U208/net4 N1 VSS VSS nmos W=0.155u L=0.04u
M610 U208/net6 U208/net4 VSS VSS nmos W=0.17u L=0.04u
M611 N724 U208/net14 VSS VSS nmos W=0.155u L=0.04u
M612 U208/net10 n162 VSS VSS nmos W=0.155u L=0.04u
M613 U208/net4 U208/net10 U208/net14 VDD pmos W=0.255u L=0.04u
M614 U208/net6 n162 U208/net14 VDD pmos W=0.28u L=0.04u
M615 U208/net4 N1 VDD VDD pmos W=0.205u L=0.04u
M616 U208/net6 U208/net4 VDD VDD pmos W=0.24u L=0.04u
M617 N724 U208/net14 VDD VDD pmos W=0.205u L=0.04u
M618 U208/net10 n162 VDD VDD pmos W=0.205u L=0.04u
M619 U209/XU1-net6 n118 VSS VSS nmos W=0.155u L=0.04u
M620 n162 n159 U209/XU1-net6 VSS nmos W=0.155u L=0.04u
M621 n162 n118 VDD VDD pmos W=0.155u L=0.04u
M622 n162 n159 VDD VDD pmos W=0.155u L=0.04u
M623 n159 U210/net6 VSS VSS nmos W=0.155u L=0.04u
M624 U210/net6 n145 U210/XU30-net23 VSS nmos W=0.155u L=0.04u
M625 U210/XU30-net23 n135 U210/XU30-net26 VSS nmos W=0.155u L=0.04u
M626 U210/XU30-net26 n144 U210/XU30-net29 VSS nmos W=0.155u L=0.04u
M627 U210/XU30-net29 n143 VSS VSS nmos W=0.155u L=0.04u
M628 n159 U210/net6 VDD VDD pmos W=0.205u L=0.04u
M629 U210/net6 n143 VDD VDD pmos W=0.205u L=0.04u
M630 U210/net6 n144 VDD VDD pmos W=0.205u L=0.04u
M631 U210/net6 n135 VDD VDD pmos W=0.205u L=0.04u
M632 U210/net6 n145 VDD VDD pmos W=0.205u L=0.04u
M633 U211/net15 n132 VSS VSS nmos W=0.155u L=0.04u
M634 U211/net15 n115 VSS VSS nmos W=0.155u L=0.04u
M635 n143 n118 U211/net15 VSS nmos W=0.155u L=0.04u
M636 n143 n107 U211/net15 VSS nmos W=0.155u L=0.04u
M637 U211/net15 n119 VSS VSS nmos W=0.155u L=0.04u
M638 n143 n116 U211/net15 VSS nmos W=0.155u L=0.04u
M639 n143 n119 U211/XI1-net11 VDD pmos W=0.205u L=0.04u
M640 U211/XI1-net11 n132 U211/XI1-net18 VDD pmos W=0.205u L=0.04u
M641 U211/XI1-net18 n115 VDD VDD pmos W=0.205u L=0.04u
M642 n143 n118 U211/XI7-net11 VDD pmos W=0.205u L=0.04u
M643 U211/XI7-net11 n107 U211/XI7-net18 VDD pmos W=0.205u L=0.04u
M644 U211/XI7-net18 n116 VDD VDD pmos W=0.205u L=0.04u
M645 n119 n133 VSS VSS nmos W=0.135u L=0.04u
M646 n119 n133 VDD VDD pmos W=0.205u L=0.04u
M647 n132 n108 VSS VSS nmos W=0.155u L=0.04u
M648 n132 n106 VSS VSS nmos W=0.155u L=0.04u
M649 U213/XI1-net8 n106 VDD VDD pmos W=0.205u L=0.04u
M650 n132 n108 U213/XI1-net8 VDD pmos W=0.205u L=0.04u
M651 n115 n131 VSS VSS nmos W=0.135u L=0.04u
M652 n115 n131 VDD VDD pmos W=0.205u L=0.04u
M653 n118 n108 VSS VSS nmos W=0.135u L=0.04u
M654 n118 n108 VDD VDD pmos W=0.205u L=0.04u
M655 U216/net28 U216/net20 U216/net64 VSS nmos W=0.155u L=0.04u
M656 U216/net24 U216/net30 U216/net32 VSS nmos W=0.155u L=0.04u
M657 U216/net28 U216/net40 U216/net24 VSS nmos W=0.155u L=0.04u
M658 U216/net40 n166 U216/net108 VSS nmos W=0.155u L=0.04u
M659 U216/net40 U216/net106 U216/net104 VSS nmos W=0.155u L=0.04u
M660 U216/net24 n163 U216/net050 VSS nmos W=0.155u L=0.04u
M661 U216/net050 U216/net32 VSS VSS nmos W=0.155u L=0.04u
M662 U216/net20 U216/net40 VSS VSS nmos W=0.155u L=0.04u
M663 U216/net106 n166 VSS VSS nmos W=0.155u L=0.04u
M664 U216/net104 n165 VSS VSS nmos W=0.155u L=0.04u
M665 U216/net30 n163 VSS VSS nmos W=0.155u L=0.04u
M666 U216/net108 U216/net104 VSS VSS nmos W=0.155u L=0.04u
M667 n108 U216/net28 VSS VSS nmos W=0.155u L=0.04u
M668 U216/net32 n164 VSS VSS nmos W=0.155u L=0.04u
M669 U216/net64 U216/net24 VSS VSS nmos W=0.2u L=0.04u
M670 U216/net28 U216/net40 U216/net64 VDD pmos W=0.205u L=0.04u
M671 U216/net24 n163 U216/net32 VDD pmos W=0.205u L=0.04u
M672 U216/net28 U216/net20 U216/net24 VDD pmos W=0.205u L=0.04u
M673 U216/net40 U216/net106 U216/net108 VDD pmos W=0.205u L=0.04u
M674 U216/net40 n166 U216/net104 VDD pmos W=0.205u L=0.04u
M675 U216/net20 U216/net40 VDD VDD pmos W=0.205u L=0.04u
M676 U216/net106 n166 VDD VDD pmos W=0.205u L=0.04u
M677 U216/net104 n165 VDD VDD pmos W=0.205u L=0.04u
M678 U216/net30 n163 VDD VDD pmos W=0.205u L=0.04u
M679 U216/net108 U216/net104 VDD VDD pmos W=0.205u L=0.04u
M680 n108 U216/net28 VDD VDD pmos W=0.205u L=0.04u
M681 U216/net32 n164 VDD VDD pmos W=0.205u L=0.04u
M682 U216/net64 U216/net24 VDD VDD pmos W=0.28u L=0.04u
M683 U216/net24 U216/net30 U216/net045 VDD pmos W=0.205u L=0.04u
M684 U216/net045 U216/net32 VDD VDD pmos W=0.205u L=0.04u
M685 U217/net28 U217/net20 U217/net64 VSS nmos W=0.155u L=0.04u
M686 U217/net24 U217/net30 U217/net32 VSS nmos W=0.155u L=0.04u
M687 U217/net28 U217/net40 U217/net24 VSS nmos W=0.155u L=0.04u
M688 U217/net40 N33 U217/net108 VSS nmos W=0.155u L=0.04u
M689 U217/net40 U217/net106 U217/net104 VSS nmos W=0.155u L=0.04u
M690 U217/net24 N17 U217/net050 VSS nmos W=0.155u L=0.04u
M691 U217/net050 U217/net32 VSS VSS nmos W=0.155u L=0.04u
M692 U217/net20 U217/net40 VSS VSS nmos W=0.155u L=0.04u
M693 U217/net106 N33 VSS VSS nmos W=0.155u L=0.04u
M694 U217/net104 N49 VSS VSS nmos W=0.155u L=0.04u
M695 U217/net30 N17 VSS VSS nmos W=0.155u L=0.04u
M696 U217/net108 U217/net104 VSS VSS nmos W=0.155u L=0.04u
M697 n166 U217/net28 VSS VSS nmos W=0.155u L=0.04u
M698 U217/net32 N1 VSS VSS nmos W=0.155u L=0.04u
M699 U217/net64 U217/net24 VSS VSS nmos W=0.2u L=0.04u
M700 U217/net28 U217/net40 U217/net64 VDD pmos W=0.205u L=0.04u
M701 U217/net24 N17 U217/net32 VDD pmos W=0.205u L=0.04u
M702 U217/net28 U217/net20 U217/net24 VDD pmos W=0.205u L=0.04u
M703 U217/net40 U217/net106 U217/net108 VDD pmos W=0.205u L=0.04u
M704 U217/net40 N33 U217/net104 VDD pmos W=0.205u L=0.04u
M705 U217/net20 U217/net40 VDD VDD pmos W=0.205u L=0.04u
M706 U217/net106 N33 VDD VDD pmos W=0.205u L=0.04u
M707 U217/net104 N49 VDD VDD pmos W=0.205u L=0.04u
M708 U217/net30 N17 VDD VDD pmos W=0.205u L=0.04u
M709 U217/net108 U217/net104 VDD VDD pmos W=0.205u L=0.04u
M710 n166 U217/net28 VDD VDD pmos W=0.205u L=0.04u
M711 U217/net32 N1 VDD VDD pmos W=0.205u L=0.04u
M712 U217/net64 U217/net24 VDD VDD pmos W=0.28u L=0.04u
M713 U217/net24 U217/net30 U217/net045 VDD pmos W=0.205u L=0.04u
M714 U217/net045 U217/net32 VDD VDD pmos W=0.205u L=0.04u
M715 U218/XU1-net6 N137 VSS VSS nmos W=0.155u L=0.04u
M716 n165 N129 U218/XU1-net6 VSS nmos W=0.155u L=0.04u
M717 n165 N137 VDD VDD pmos W=0.155u L=0.04u
M718 n165 N129 VDD VDD pmos W=0.155u L=0.04u
M719 n107 n131 VSS VSS nmos W=0.155u L=0.04u
M720 n107 n133 VSS VSS nmos W=0.155u L=0.04u
M721 U219/XI1-net8 n133 VDD VDD pmos W=0.205u L=0.04u
M722 n107 n131 U219/XI1-net8 VDD pmos W=0.205u L=0.04u
M723 U220/net28 U220/net20 U220/net64 VSS nmos W=0.155u L=0.04u
M724 U220/net24 U220/net30 U220/net32 VSS nmos W=0.155u L=0.04u
M725 U220/net28 U220/net40 U220/net24 VSS nmos W=0.155u L=0.04u
M726 U220/net40 n169 U220/net108 VSS nmos W=0.155u L=0.04u
M727 U220/net40 U220/net106 U220/net104 VSS nmos W=0.155u L=0.04u
M728 U220/net24 n164 U220/net050 VSS nmos W=0.155u L=0.04u
M729 U220/net050 U220/net32 VSS VSS nmos W=0.155u L=0.04u
M730 U220/net20 U220/net40 VSS VSS nmos W=0.155u L=0.04u
M731 U220/net106 n169 VSS VSS nmos W=0.155u L=0.04u
M732 U220/net104 n168 VSS VSS nmos W=0.155u L=0.04u
M733 U220/net30 n164 VSS VSS nmos W=0.155u L=0.04u
M734 U220/net108 U220/net104 VSS VSS nmos W=0.155u L=0.04u
M735 n133 U220/net28 VSS VSS nmos W=0.155u L=0.04u
M736 U220/net32 n167 VSS VSS nmos W=0.155u L=0.04u
M737 U220/net64 U220/net24 VSS VSS nmos W=0.2u L=0.04u
M738 U220/net28 U220/net40 U220/net64 VDD pmos W=0.205u L=0.04u
M739 U220/net24 n164 U220/net32 VDD pmos W=0.205u L=0.04u
M740 U220/net28 U220/net20 U220/net24 VDD pmos W=0.205u L=0.04u
M741 U220/net40 U220/net106 U220/net108 VDD pmos W=0.205u L=0.04u
M742 U220/net40 n169 U220/net104 VDD pmos W=0.205u L=0.04u
M743 U220/net20 U220/net40 VDD VDD pmos W=0.205u L=0.04u
M744 U220/net106 n169 VDD VDD pmos W=0.205u L=0.04u
M745 U220/net104 n168 VDD VDD pmos W=0.205u L=0.04u
M746 U220/net30 n164 VDD VDD pmos W=0.205u L=0.04u
M747 U220/net108 U220/net104 VDD VDD pmos W=0.205u L=0.04u
M748 n133 U220/net28 VDD VDD pmos W=0.205u L=0.04u
M749 U220/net32 n167 VDD VDD pmos W=0.205u L=0.04u
M750 U220/net64 U220/net24 VDD VDD pmos W=0.28u L=0.04u
M751 U220/net24 U220/net30 U220/net045 VDD pmos W=0.205u L=0.04u
M752 U220/net045 U220/net32 VDD VDD pmos W=0.205u L=0.04u
M753 U221/net28 U221/net20 U221/net64 VSS nmos W=0.155u L=0.04u
M754 U221/net24 U221/net30 U221/net32 VSS nmos W=0.155u L=0.04u
M755 U221/net28 U221/net40 U221/net24 VSS nmos W=0.155u L=0.04u
M756 U221/net40 N45 U221/net108 VSS nmos W=0.155u L=0.04u
M757 U221/net40 U221/net106 U221/net104 VSS nmos W=0.155u L=0.04u
M758 U221/net24 N29 U221/net050 VSS nmos W=0.155u L=0.04u
M759 U221/net050 U221/net32 VSS VSS nmos W=0.155u L=0.04u
M760 U221/net20 U221/net40 VSS VSS nmos W=0.155u L=0.04u
M761 U221/net106 N45 VSS VSS nmos W=0.155u L=0.04u
M762 U221/net104 N61 VSS VSS nmos W=0.155u L=0.04u
M763 U221/net30 N29 VSS VSS nmos W=0.155u L=0.04u
M764 U221/net108 U221/net104 VSS VSS nmos W=0.155u L=0.04u
M765 n169 U221/net28 VSS VSS nmos W=0.155u L=0.04u
M766 U221/net32 N13 VSS VSS nmos W=0.155u L=0.04u
M767 U221/net64 U221/net24 VSS VSS nmos W=0.2u L=0.04u
M768 U221/net28 U221/net40 U221/net64 VDD pmos W=0.205u L=0.04u
M769 U221/net24 N29 U221/net32 VDD pmos W=0.205u L=0.04u
M770 U221/net28 U221/net20 U221/net24 VDD pmos W=0.205u L=0.04u
M771 U221/net40 U221/net106 U221/net108 VDD pmos W=0.205u L=0.04u
M772 U221/net40 N45 U221/net104 VDD pmos W=0.205u L=0.04u
M773 U221/net20 U221/net40 VDD VDD pmos W=0.205u L=0.04u
M774 U221/net106 N45 VDD VDD pmos W=0.205u L=0.04u
M775 U221/net104 N61 VDD VDD pmos W=0.205u L=0.04u
M776 U221/net30 N29 VDD VDD pmos W=0.205u L=0.04u
M777 U221/net108 U221/net104 VDD VDD pmos W=0.205u L=0.04u
M778 n169 U221/net28 VDD VDD pmos W=0.205u L=0.04u
M779 U221/net32 N13 VDD VDD pmos W=0.205u L=0.04u
M780 U221/net64 U221/net24 VDD VDD pmos W=0.28u L=0.04u
M781 U221/net24 U221/net30 U221/net045 VDD pmos W=0.205u L=0.04u
M782 U221/net045 U221/net32 VDD VDD pmos W=0.205u L=0.04u
M783 U222/XU1-net6 N137 VSS VSS nmos W=0.155u L=0.04u
M784 n168 N132 U222/XU1-net6 VSS nmos W=0.155u L=0.04u
M785 n168 N137 VDD VDD pmos W=0.155u L=0.04u
M786 n168 N132 VDD VDD pmos W=0.155u L=0.04u
M787 U223/net28 U223/net20 U223/net64 VSS nmos W=0.155u L=0.04u
M788 U223/net24 U223/net30 U223/net32 VSS nmos W=0.155u L=0.04u
M789 U223/net28 U223/net40 U223/net24 VSS nmos W=0.155u L=0.04u
M790 U223/net40 N85 U223/net108 VSS nmos W=0.155u L=0.04u
M791 U223/net40 U223/net106 U223/net104 VSS nmos W=0.155u L=0.04u
M792 U223/net24 N93 U223/net050 VSS nmos W=0.155u L=0.04u
M793 U223/net050 U223/net32 VSS VSS nmos W=0.155u L=0.04u
M794 U223/net20 U223/net40 VSS VSS nmos W=0.155u L=0.04u
M795 U223/net106 N85 VSS VSS nmos W=0.155u L=0.04u
M796 U223/net104 N81 VSS VSS nmos W=0.155u L=0.04u
M797 U223/net30 N93 VSS VSS nmos W=0.155u L=0.04u
M798 U223/net108 U223/net104 VSS VSS nmos W=0.155u L=0.04u
M799 n164 U223/net28 VSS VSS nmos W=0.155u L=0.04u
M800 U223/net32 N89 VSS VSS nmos W=0.155u L=0.04u
M801 U223/net64 U223/net24 VSS VSS nmos W=0.2u L=0.04u
M802 U223/net28 U223/net40 U223/net64 VDD pmos W=0.205u L=0.04u
M803 U223/net24 N93 U223/net32 VDD pmos W=0.205u L=0.04u
M804 U223/net28 U223/net20 U223/net24 VDD pmos W=0.205u L=0.04u
M805 U223/net40 U223/net106 U223/net108 VDD pmos W=0.205u L=0.04u
M806 U223/net40 N85 U223/net104 VDD pmos W=0.205u L=0.04u
M807 U223/net20 U223/net40 VDD VDD pmos W=0.205u L=0.04u
M808 U223/net106 N85 VDD VDD pmos W=0.205u L=0.04u
M809 U223/net104 N81 VDD VDD pmos W=0.205u L=0.04u
M810 U223/net30 N93 VDD VDD pmos W=0.205u L=0.04u
M811 U223/net108 U223/net104 VDD VDD pmos W=0.205u L=0.04u
M812 n164 U223/net28 VDD VDD pmos W=0.205u L=0.04u
M813 U223/net32 N89 VDD VDD pmos W=0.205u L=0.04u
M814 U223/net64 U223/net24 VDD VDD pmos W=0.28u L=0.04u
M815 U223/net24 U223/net30 U223/net045 VDD pmos W=0.205u L=0.04u
M816 U223/net045 U223/net32 VDD VDD pmos W=0.205u L=0.04u
M817 U224/net28 U224/net20 U224/net64 VSS nmos W=0.155u L=0.04u
M818 U224/net24 U224/net30 U224/net32 VSS nmos W=0.155u L=0.04u
M819 U224/net28 U224/net40 U224/net24 VSS nmos W=0.155u L=0.04u
M820 U224/net40 n172 U224/net108 VSS nmos W=0.155u L=0.04u
M821 U224/net40 U224/net106 U224/net104 VSS nmos W=0.155u L=0.04u
M822 U224/net24 n170 U224/net050 VSS nmos W=0.155u L=0.04u
M823 U224/net050 U224/net32 VSS VSS nmos W=0.155u L=0.04u
M824 U224/net20 U224/net40 VSS VSS nmos W=0.155u L=0.04u
M825 U224/net106 n172 VSS VSS nmos W=0.155u L=0.04u
M826 U224/net104 n171 VSS VSS nmos W=0.155u L=0.04u
M827 U224/net30 n170 VSS VSS nmos W=0.155u L=0.04u
M828 U224/net108 U224/net104 VSS VSS nmos W=0.155u L=0.04u
M829 n131 U224/net28 VSS VSS nmos W=0.155u L=0.04u
M830 U224/net32 n167 VSS VSS nmos W=0.155u L=0.04u
M831 U224/net64 U224/net24 VSS VSS nmos W=0.2u L=0.04u
M832 U224/net28 U224/net40 U224/net64 VDD pmos W=0.205u L=0.04u
M833 U224/net24 n170 U224/net32 VDD pmos W=0.205u L=0.04u
M834 U224/net28 U224/net20 U224/net24 VDD pmos W=0.205u L=0.04u
M835 U224/net40 U224/net106 U224/net108 VDD pmos W=0.205u L=0.04u
M836 U224/net40 n172 U224/net104 VDD pmos W=0.205u L=0.04u
M837 U224/net20 U224/net40 VDD VDD pmos W=0.205u L=0.04u
M838 U224/net106 n172 VDD VDD pmos W=0.205u L=0.04u
M839 U224/net104 n171 VDD VDD pmos W=0.205u L=0.04u
M840 U224/net30 n170 VDD VDD pmos W=0.205u L=0.04u
M841 U224/net108 U224/net104 VDD VDD pmos W=0.205u L=0.04u
M842 n131 U224/net28 VDD VDD pmos W=0.205u L=0.04u
M843 U224/net32 n167 VDD VDD pmos W=0.205u L=0.04u
M844 U224/net64 U224/net24 VDD VDD pmos W=0.28u L=0.04u
M845 U224/net24 U224/net30 U224/net045 VDD pmos W=0.205u L=0.04u
M846 U224/net045 U224/net32 VDD VDD pmos W=0.205u L=0.04u
M847 U225/net28 U225/net20 U225/net64 VSS nmos W=0.155u L=0.04u
M848 U225/net24 U225/net30 U225/net32 VSS nmos W=0.155u L=0.04u
M849 U225/net28 U225/net40 U225/net24 VSS nmos W=0.155u L=0.04u
M850 U225/net40 N5 U225/net108 VSS nmos W=0.155u L=0.04u
M851 U225/net40 U225/net106 U225/net104 VSS nmos W=0.155u L=0.04u
M852 U225/net24 N37 U225/net050 VSS nmos W=0.155u L=0.04u
M853 U225/net050 U225/net32 VSS VSS nmos W=0.155u L=0.04u
M854 U225/net20 U225/net40 VSS VSS nmos W=0.155u L=0.04u
M855 U225/net106 N5 VSS VSS nmos W=0.155u L=0.04u
M856 U225/net104 N53 VSS VSS nmos W=0.155u L=0.04u
M857 U225/net30 N37 VSS VSS nmos W=0.155u L=0.04u
M858 U225/net108 U225/net104 VSS VSS nmos W=0.155u L=0.04u
M859 n172 U225/net28 VSS VSS nmos W=0.155u L=0.04u
M860 U225/net32 N21 VSS VSS nmos W=0.155u L=0.04u
M861 U225/net64 U225/net24 VSS VSS nmos W=0.2u L=0.04u
M862 U225/net28 U225/net40 U225/net64 VDD pmos W=0.205u L=0.04u
M863 U225/net24 N37 U225/net32 VDD pmos W=0.205u L=0.04u
M864 U225/net28 U225/net20 U225/net24 VDD pmos W=0.205u L=0.04u
M865 U225/net40 U225/net106 U225/net108 VDD pmos W=0.205u L=0.04u
M866 U225/net40 N5 U225/net104 VDD pmos W=0.205u L=0.04u
M867 U225/net20 U225/net40 VDD VDD pmos W=0.205u L=0.04u
M868 U225/net106 N5 VDD VDD pmos W=0.205u L=0.04u
M869 U225/net104 N53 VDD VDD pmos W=0.205u L=0.04u
M870 U225/net30 N37 VDD VDD pmos W=0.205u L=0.04u
M871 U225/net108 U225/net104 VDD VDD pmos W=0.205u L=0.04u
M872 n172 U225/net28 VDD VDD pmos W=0.205u L=0.04u
M873 U225/net32 N21 VDD VDD pmos W=0.205u L=0.04u
M874 U225/net64 U225/net24 VDD VDD pmos W=0.28u L=0.04u
M875 U225/net24 U225/net30 U225/net045 VDD pmos W=0.205u L=0.04u
M876 U225/net045 U225/net32 VDD VDD pmos W=0.205u L=0.04u
M877 U226/XU1-net6 N137 VSS VSS nmos W=0.155u L=0.04u
M878 n171 N130 U226/XU1-net6 VSS nmos W=0.155u L=0.04u
M879 n171 N137 VDD VDD pmos W=0.155u L=0.04u
M880 n171 N130 VDD VDD pmos W=0.155u L=0.04u
M881 U227/net28 U227/net20 U227/net64 VSS nmos W=0.155u L=0.04u
M882 U227/net24 U227/net30 U227/net32 VSS nmos W=0.155u L=0.04u
M883 U227/net28 U227/net40 U227/net24 VSS nmos W=0.155u L=0.04u
M884 U227/net40 N117 U227/net108 VSS nmos W=0.155u L=0.04u
M885 U227/net40 U227/net106 U227/net104 VSS nmos W=0.155u L=0.04u
M886 U227/net24 N125 U227/net050 VSS nmos W=0.155u L=0.04u
M887 U227/net050 U227/net32 VSS VSS nmos W=0.155u L=0.04u
M888 U227/net20 U227/net40 VSS VSS nmos W=0.155u L=0.04u
M889 U227/net106 N117 VSS VSS nmos W=0.155u L=0.04u
M890 U227/net104 N113 VSS VSS nmos W=0.155u L=0.04u
M891 U227/net30 N125 VSS VSS nmos W=0.155u L=0.04u
M892 U227/net108 U227/net104 VSS VSS nmos W=0.155u L=0.04u
M893 n167 U227/net28 VSS VSS nmos W=0.155u L=0.04u
M894 U227/net32 N121 VSS VSS nmos W=0.155u L=0.04u
M895 U227/net64 U227/net24 VSS VSS nmos W=0.2u L=0.04u
M896 U227/net28 U227/net40 U227/net64 VDD pmos W=0.205u L=0.04u
M897 U227/net24 N125 U227/net32 VDD pmos W=0.205u L=0.04u
M898 U227/net28 U227/net20 U227/net24 VDD pmos W=0.205u L=0.04u
M899 U227/net40 U227/net106 U227/net108 VDD pmos W=0.205u L=0.04u
M900 U227/net40 N117 U227/net104 VDD pmos W=0.205u L=0.04u
M901 U227/net20 U227/net40 VDD VDD pmos W=0.205u L=0.04u
M902 U227/net106 N117 VDD VDD pmos W=0.205u L=0.04u
M903 U227/net104 N113 VDD VDD pmos W=0.205u L=0.04u
M904 U227/net30 N125 VDD VDD pmos W=0.205u L=0.04u
M905 U227/net108 U227/net104 VDD VDD pmos W=0.205u L=0.04u
M906 n167 U227/net28 VDD VDD pmos W=0.205u L=0.04u
M907 U227/net32 N121 VDD VDD pmos W=0.205u L=0.04u
M908 U227/net64 U227/net24 VDD VDD pmos W=0.28u L=0.04u
M909 U227/net24 U227/net30 U227/net045 VDD pmos W=0.205u L=0.04u
M910 U227/net045 U227/net32 VDD VDD pmos W=0.205u L=0.04u
M911 n116 n106 VSS VSS nmos W=0.135u L=0.04u
M912 n116 n106 VDD VDD pmos W=0.205u L=0.04u
M913 U229/net28 U229/net20 U229/net64 VSS nmos W=0.155u L=0.04u
M914 U229/net24 U229/net30 U229/net32 VSS nmos W=0.155u L=0.04u
M915 U229/net28 U229/net40 U229/net24 VSS nmos W=0.155u L=0.04u
M916 U229/net40 n174 U229/net108 VSS nmos W=0.155u L=0.04u
M917 U229/net40 U229/net106 U229/net104 VSS nmos W=0.155u L=0.04u
M918 U229/net24 n163 U229/net050 VSS nmos W=0.155u L=0.04u
M919 U229/net050 U229/net32 VSS VSS nmos W=0.155u L=0.04u
M920 U229/net20 U229/net40 VSS VSS nmos W=0.155u L=0.04u
M921 U229/net106 n174 VSS VSS nmos W=0.155u L=0.04u
M922 U229/net104 n173 VSS VSS nmos W=0.155u L=0.04u
M923 U229/net30 n163 VSS VSS nmos W=0.155u L=0.04u
M924 U229/net108 U229/net104 VSS VSS nmos W=0.155u L=0.04u
M925 n106 U229/net28 VSS VSS nmos W=0.155u L=0.04u
M926 U229/net32 n170 VSS VSS nmos W=0.155u L=0.04u
M927 U229/net64 U229/net24 VSS VSS nmos W=0.2u L=0.04u
M928 U229/net28 U229/net40 U229/net64 VDD pmos W=0.205u L=0.04u
M929 U229/net24 n163 U229/net32 VDD pmos W=0.205u L=0.04u
M930 U229/net28 U229/net20 U229/net24 VDD pmos W=0.205u L=0.04u
M931 U229/net40 U229/net106 U229/net108 VDD pmos W=0.205u L=0.04u
M932 U229/net40 n174 U229/net104 VDD pmos W=0.205u L=0.04u
M933 U229/net20 U229/net40 VDD VDD pmos W=0.205u L=0.04u
M934 U229/net106 n174 VDD VDD pmos W=0.205u L=0.04u
M935 U229/net104 n173 VDD VDD pmos W=0.205u L=0.04u
M936 U229/net30 n163 VDD VDD pmos W=0.205u L=0.04u
M937 U229/net108 U229/net104 VDD VDD pmos W=0.205u L=0.04u
M938 n106 U229/net28 VDD VDD pmos W=0.205u L=0.04u
M939 U229/net32 n170 VDD VDD pmos W=0.205u L=0.04u
M940 U229/net64 U229/net24 VDD VDD pmos W=0.28u L=0.04u
M941 U229/net24 U229/net30 U229/net045 VDD pmos W=0.205u L=0.04u
M942 U229/net045 U229/net32 VDD VDD pmos W=0.205u L=0.04u
M943 U230/net28 U230/net20 U230/net64 VSS nmos W=0.155u L=0.04u
M944 U230/net24 U230/net30 U230/net32 VSS nmos W=0.155u L=0.04u
M945 U230/net28 U230/net40 U230/net24 VSS nmos W=0.155u L=0.04u
M946 U230/net40 N57 U230/net108 VSS nmos W=0.155u L=0.04u
M947 U230/net40 U230/net106 U230/net104 VSS nmos W=0.155u L=0.04u
M948 U230/net24 N41 U230/net050 VSS nmos W=0.155u L=0.04u
M949 U230/net050 U230/net32 VSS VSS nmos W=0.155u L=0.04u
M950 U230/net20 U230/net40 VSS VSS nmos W=0.155u L=0.04u
M951 U230/net106 N57 VSS VSS nmos W=0.155u L=0.04u
M952 U230/net104 N9 VSS VSS nmos W=0.155u L=0.04u
M953 U230/net30 N41 VSS VSS nmos W=0.155u L=0.04u
M954 U230/net108 U230/net104 VSS VSS nmos W=0.155u L=0.04u
M955 n174 U230/net28 VSS VSS nmos W=0.155u L=0.04u
M956 U230/net32 N25 VSS VSS nmos W=0.155u L=0.04u
M957 U230/net64 U230/net24 VSS VSS nmos W=0.2u L=0.04u
M958 U230/net28 U230/net40 U230/net64 VDD pmos W=0.205u L=0.04u
M959 U230/net24 N41 U230/net32 VDD pmos W=0.205u L=0.04u
M960 U230/net28 U230/net20 U230/net24 VDD pmos W=0.205u L=0.04u
M961 U230/net40 U230/net106 U230/net108 VDD pmos W=0.205u L=0.04u
M962 U230/net40 N57 U230/net104 VDD pmos W=0.205u L=0.04u
M963 U230/net20 U230/net40 VDD VDD pmos W=0.205u L=0.04u
M964 U230/net106 N57 VDD VDD pmos W=0.205u L=0.04u
M965 U230/net104 N9 VDD VDD pmos W=0.205u L=0.04u
M966 U230/net30 N41 VDD VDD pmos W=0.205u L=0.04u
M967 U230/net108 U230/net104 VDD VDD pmos W=0.205u L=0.04u
M968 n174 U230/net28 VDD VDD pmos W=0.205u L=0.04u
M969 U230/net32 N25 VDD VDD pmos W=0.205u L=0.04u
M970 U230/net64 U230/net24 VDD VDD pmos W=0.28u L=0.04u
M971 U230/net24 U230/net30 U230/net045 VDD pmos W=0.205u L=0.04u
M972 U230/net045 U230/net32 VDD VDD pmos W=0.205u L=0.04u
M973 U231/XU1-net6 N137 VSS VSS nmos W=0.155u L=0.04u
M974 n173 N131 U231/XU1-net6 VSS nmos W=0.155u L=0.04u
M975 n173 N137 VDD VDD pmos W=0.155u L=0.04u
M976 n173 N131 VDD VDD pmos W=0.155u L=0.04u
M977 U232/net28 U232/net20 U232/net64 VSS nmos W=0.155u L=0.04u
M978 U232/net24 U232/net30 U232/net32 VSS nmos W=0.155u L=0.04u
M979 U232/net28 U232/net40 U232/net24 VSS nmos W=0.155u L=0.04u
M980 U232/net40 N105 U232/net108 VSS nmos W=0.155u L=0.04u
M981 U232/net40 U232/net106 U232/net104 VSS nmos W=0.155u L=0.04u
M982 U232/net24 N97 U232/net050 VSS nmos W=0.155u L=0.04u
M983 U232/net050 U232/net32 VSS VSS nmos W=0.155u L=0.04u
M984 U232/net20 U232/net40 VSS VSS nmos W=0.155u L=0.04u
M985 U232/net106 N105 VSS VSS nmos W=0.155u L=0.04u
M986 U232/net104 N101 VSS VSS nmos W=0.155u L=0.04u
M987 U232/net30 N97 VSS VSS nmos W=0.155u L=0.04u
M988 U232/net108 U232/net104 VSS VSS nmos W=0.155u L=0.04u
M989 n170 U232/net28 VSS VSS nmos W=0.155u L=0.04u
M990 U232/net32 N109 VSS VSS nmos W=0.155u L=0.04u
M991 U232/net64 U232/net24 VSS VSS nmos W=0.2u L=0.04u
M992 U232/net28 U232/net40 U232/net64 VDD pmos W=0.205u L=0.04u
M993 U232/net24 N97 U232/net32 VDD pmos W=0.205u L=0.04u
M994 U232/net28 U232/net20 U232/net24 VDD pmos W=0.205u L=0.04u
M995 U232/net40 U232/net106 U232/net108 VDD pmos W=0.205u L=0.04u
M996 U232/net40 N105 U232/net104 VDD pmos W=0.205u L=0.04u
M997 U232/net20 U232/net40 VDD VDD pmos W=0.205u L=0.04u
M998 U232/net106 N105 VDD VDD pmos W=0.205u L=0.04u
M999 U232/net104 N101 VDD VDD pmos W=0.205u L=0.04u
M1000 U232/net30 N97 VDD VDD pmos W=0.205u L=0.04u
M1001 U232/net108 U232/net104 VDD VDD pmos W=0.205u L=0.04u
M1002 n170 U232/net28 VDD VDD pmos W=0.205u L=0.04u
M1003 U232/net32 N109 VDD VDD pmos W=0.205u L=0.04u
M1004 U232/net64 U232/net24 VDD VDD pmos W=0.28u L=0.04u
M1005 U232/net24 U232/net30 U232/net045 VDD pmos W=0.205u L=0.04u
M1006 U232/net045 U232/net32 VDD VDD pmos W=0.205u L=0.04u
M1007 U233/net28 U233/net20 U233/net64 VSS nmos W=0.155u L=0.04u
M1008 U233/net24 U233/net30 U233/net32 VSS nmos W=0.155u L=0.04u
M1009 U233/net28 U233/net40 U233/net24 VSS nmos W=0.155u L=0.04u
M1010 U233/net40 N69 U233/net108 VSS nmos W=0.155u L=0.04u
M1011 U233/net40 U233/net106 U233/net104 VSS nmos W=0.155u L=0.04u
M1012 U233/net24 N77 U233/net050 VSS nmos W=0.155u L=0.04u
M1013 U233/net050 U233/net32 VSS VSS nmos W=0.155u L=0.04u
M1014 U233/net20 U233/net40 VSS VSS nmos W=0.155u L=0.04u
M1015 U233/net106 N69 VSS VSS nmos W=0.155u L=0.04u
M1016 U233/net104 N65 VSS VSS nmos W=0.155u L=0.04u
M1017 U233/net30 N77 VSS VSS nmos W=0.155u L=0.04u
M1018 U233/net108 U233/net104 VSS VSS nmos W=0.155u L=0.04u
M1019 n163 U233/net28 VSS VSS nmos W=0.155u L=0.04u
M1020 U233/net32 N73 VSS VSS nmos W=0.155u L=0.04u
M1021 U233/net64 U233/net24 VSS VSS nmos W=0.2u L=0.04u
M1022 U233/net28 U233/net40 U233/net64 VDD pmos W=0.205u L=0.04u
M1023 U233/net24 N77 U233/net32 VDD pmos W=0.205u L=0.04u
M1024 U233/net28 U233/net20 U233/net24 VDD pmos W=0.205u L=0.04u
M1025 U233/net40 U233/net106 U233/net108 VDD pmos W=0.205u L=0.04u
M1026 U233/net40 N69 U233/net104 VDD pmos W=0.205u L=0.04u
M1027 U233/net20 U233/net40 VDD VDD pmos W=0.205u L=0.04u
M1028 U233/net106 N69 VDD VDD pmos W=0.205u L=0.04u
M1029 U233/net104 N65 VDD VDD pmos W=0.205u L=0.04u
M1030 U233/net30 N77 VDD VDD pmos W=0.205u L=0.04u
M1031 U233/net108 U233/net104 VDD VDD pmos W=0.205u L=0.04u
M1032 n163 U233/net28 VDD VDD pmos W=0.205u L=0.04u
M1033 U233/net32 N73 VDD VDD pmos W=0.205u L=0.04u
M1034 U233/net64 U233/net24 VDD VDD pmos W=0.28u L=0.04u
M1035 U233/net24 U233/net30 U233/net045 VDD pmos W=0.205u L=0.04u
M1036 U233/net045 U233/net32 VDD VDD pmos W=0.205u L=0.04u
M1037 U234/net28 U234/net20 U234/net64 VSS nmos W=0.155u L=0.04u
M1038 U234/net24 U234/net30 U234/net32 VSS nmos W=0.155u L=0.04u
M1039 U234/net28 U234/net40 U234/net24 VSS nmos W=0.155u L=0.04u
M1040 U234/net40 n178 U234/net108 VSS nmos W=0.155u L=0.04u
M1041 U234/net40 U234/net106 U234/net104 VSS nmos W=0.155u L=0.04u
M1042 U234/net24 n175 U234/net050 VSS nmos W=0.155u L=0.04u
M1043 U234/net050 U234/net32 VSS VSS nmos W=0.155u L=0.04u
M1044 U234/net20 U234/net40 VSS VSS nmos W=0.155u L=0.04u
M1045 U234/net106 n178 VSS VSS nmos W=0.155u L=0.04u
M1046 U234/net104 n177 VSS VSS nmos W=0.155u L=0.04u
M1047 U234/net30 n175 VSS VSS nmos W=0.155u L=0.04u
M1048 U234/net108 U234/net104 VSS VSS nmos W=0.155u L=0.04u
M1049 n144 U234/net28 VSS VSS nmos W=0.155u L=0.04u
M1050 U234/net32 n176 VSS VSS nmos W=0.155u L=0.04u
M1051 U234/net64 U234/net24 VSS VSS nmos W=0.2u L=0.04u
M1052 U234/net28 U234/net40 U234/net64 VDD pmos W=0.205u L=0.04u
M1053 U234/net24 n175 U234/net32 VDD pmos W=0.205u L=0.04u
M1054 U234/net28 U234/net20 U234/net24 VDD pmos W=0.205u L=0.04u
M1055 U234/net40 U234/net106 U234/net108 VDD pmos W=0.205u L=0.04u
M1056 U234/net40 n178 U234/net104 VDD pmos W=0.205u L=0.04u
M1057 U234/net20 U234/net40 VDD VDD pmos W=0.205u L=0.04u
M1058 U234/net106 n178 VDD VDD pmos W=0.205u L=0.04u
M1059 U234/net104 n177 VDD VDD pmos W=0.205u L=0.04u
M1060 U234/net30 n175 VDD VDD pmos W=0.205u L=0.04u
M1061 U234/net108 U234/net104 VDD VDD pmos W=0.205u L=0.04u
M1062 n144 U234/net28 VDD VDD pmos W=0.205u L=0.04u
M1063 U234/net32 n176 VDD VDD pmos W=0.205u L=0.04u
M1064 U234/net64 U234/net24 VDD VDD pmos W=0.28u L=0.04u
M1065 U234/net24 U234/net30 U234/net045 VDD pmos W=0.205u L=0.04u
M1066 U234/net045 U234/net32 VDD VDD pmos W=0.205u L=0.04u
M1067 U235/net28 U235/net20 U235/net64 VSS nmos W=0.155u L=0.04u
M1068 U235/net24 U235/net30 U235/net32 VSS nmos W=0.155u L=0.04u
M1069 U235/net28 U235/net40 U235/net24 VSS nmos W=0.155u L=0.04u
M1070 U235/net40 N69 U235/net108 VSS nmos W=0.155u L=0.04u
M1071 U235/net40 U235/net106 U235/net104 VSS nmos W=0.155u L=0.04u
M1072 U235/net24 N117 U235/net050 VSS nmos W=0.155u L=0.04u
M1073 U235/net050 U235/net32 VSS VSS nmos W=0.155u L=0.04u
M1074 U235/net20 U235/net40 VSS VSS nmos W=0.155u L=0.04u
M1075 U235/net106 N69 VSS VSS nmos W=0.155u L=0.04u
M1076 U235/net104 N85 VSS VSS nmos W=0.155u L=0.04u
M1077 U235/net30 N117 VSS VSS nmos W=0.155u L=0.04u
M1078 U235/net108 U235/net104 VSS VSS nmos W=0.155u L=0.04u
M1079 n178 U235/net28 VSS VSS nmos W=0.155u L=0.04u
M1080 U235/net32 N101 VSS VSS nmos W=0.155u L=0.04u
M1081 U235/net64 U235/net24 VSS VSS nmos W=0.2u L=0.04u
M1082 U235/net28 U235/net40 U235/net64 VDD pmos W=0.205u L=0.04u
M1083 U235/net24 N117 U235/net32 VDD pmos W=0.205u L=0.04u
M1084 U235/net28 U235/net20 U235/net24 VDD pmos W=0.205u L=0.04u
M1085 U235/net40 U235/net106 U235/net108 VDD pmos W=0.205u L=0.04u
M1086 U235/net40 N69 U235/net104 VDD pmos W=0.205u L=0.04u
M1087 U235/net20 U235/net40 VDD VDD pmos W=0.205u L=0.04u
M1088 U235/net106 N69 VDD VDD pmos W=0.205u L=0.04u
M1089 U235/net104 N85 VDD VDD pmos W=0.205u L=0.04u
M1090 U235/net30 N117 VDD VDD pmos W=0.205u L=0.04u
M1091 U235/net108 U235/net104 VDD VDD pmos W=0.205u L=0.04u
M1092 n178 U235/net28 VDD VDD pmos W=0.205u L=0.04u
M1093 U235/net32 N101 VDD VDD pmos W=0.205u L=0.04u
M1094 U235/net64 U235/net24 VDD VDD pmos W=0.28u L=0.04u
M1095 U235/net24 U235/net30 U235/net045 VDD pmos W=0.205u L=0.04u
M1096 U235/net045 U235/net32 VDD VDD pmos W=0.205u L=0.04u
M1097 U236/XU1-net6 N137 VSS VSS nmos W=0.155u L=0.04u
M1098 n177 N134 U236/XU1-net6 VSS nmos W=0.155u L=0.04u
M1099 n177 N137 VDD VDD pmos W=0.155u L=0.04u
M1100 n177 N134 VDD VDD pmos W=0.155u L=0.04u
M1101 n135 n142 VSS VSS nmos W=0.155u L=0.04u
M1102 n135 n141 VSS VSS nmos W=0.155u L=0.04u
M1103 U237/XI1-net8 n141 VDD VDD pmos W=0.205u L=0.04u
M1104 n135 n142 U237/XI1-net8 VDD pmos W=0.205u L=0.04u
M1105 U238/net28 U238/net20 U238/net64 VSS nmos W=0.155u L=0.04u
M1106 U238/net24 U238/net30 U238/net32 VSS nmos W=0.155u L=0.04u
M1107 U238/net28 U238/net40 U238/net24 VSS nmos W=0.155u L=0.04u
M1108 U238/net40 n181 U238/net108 VSS nmos W=0.155u L=0.04u
M1109 U238/net40 U238/net106 U238/net104 VSS nmos W=0.155u L=0.04u
M1110 U238/net24 n179 U238/net050 VSS nmos W=0.155u L=0.04u
M1111 U238/net050 U238/net32 VSS VSS nmos W=0.155u L=0.04u
M1112 U238/net20 U238/net40 VSS VSS nmos W=0.155u L=0.04u
M1113 U238/net106 n181 VSS VSS nmos W=0.155u L=0.04u
M1114 U238/net104 n180 VSS VSS nmos W=0.155u L=0.04u
M1115 U238/net30 n179 VSS VSS nmos W=0.155u L=0.04u
M1116 U238/net108 U238/net104 VSS VSS nmos W=0.155u L=0.04u
M1117 n141 U238/net28 VSS VSS nmos W=0.155u L=0.04u
M1118 U238/net32 n176 VSS VSS nmos W=0.155u L=0.04u
M1119 U238/net64 U238/net24 VSS VSS nmos W=0.2u L=0.04u
M1120 U238/net28 U238/net40 U238/net64 VDD pmos W=0.205u L=0.04u
M1121 U238/net24 n179 U238/net32 VDD pmos W=0.205u L=0.04u
M1122 U238/net28 U238/net20 U238/net24 VDD pmos W=0.205u L=0.04u
M1123 U238/net40 U238/net106 U238/net108 VDD pmos W=0.205u L=0.04u
M1124 U238/net40 n181 U238/net104 VDD pmos W=0.205u L=0.04u
M1125 U238/net20 U238/net40 VDD VDD pmos W=0.205u L=0.04u
M1126 U238/net106 n181 VDD VDD pmos W=0.205u L=0.04u
M1127 U238/net104 n180 VDD VDD pmos W=0.205u L=0.04u
M1128 U238/net30 n179 VDD VDD pmos W=0.205u L=0.04u
M1129 U238/net108 U238/net104 VDD VDD pmos W=0.205u L=0.04u
M1130 n141 U238/net28 VDD VDD pmos W=0.205u L=0.04u
M1131 U238/net32 n176 VDD VDD pmos W=0.205u L=0.04u
M1132 U238/net64 U238/net24 VDD VDD pmos W=0.28u L=0.04u
M1133 U238/net24 U238/net30 U238/net045 VDD pmos W=0.205u L=0.04u
M1134 U238/net045 U238/net32 VDD VDD pmos W=0.205u L=0.04u
M1135 U239/net28 U239/net20 U239/net64 VSS nmos W=0.155u L=0.04u
M1136 U239/net24 U239/net30 U239/net32 VSS nmos W=0.155u L=0.04u
M1137 U239/net28 U239/net40 U239/net24 VSS nmos W=0.155u L=0.04u
M1138 U239/net40 N73 U239/net108 VSS nmos W=0.155u L=0.04u
M1139 U239/net40 U239/net106 U239/net104 VSS nmos W=0.155u L=0.04u
M1140 U239/net24 N121 U239/net050 VSS nmos W=0.155u L=0.04u
M1141 U239/net050 U239/net32 VSS VSS nmos W=0.155u L=0.04u
M1142 U239/net20 U239/net40 VSS VSS nmos W=0.155u L=0.04u
M1143 U239/net106 N73 VSS VSS nmos W=0.155u L=0.04u
M1144 U239/net104 N89 VSS VSS nmos W=0.155u L=0.04u
M1145 U239/net30 N121 VSS VSS nmos W=0.155u L=0.04u
M1146 U239/net108 U239/net104 VSS VSS nmos W=0.155u L=0.04u
M1147 n181 U239/net28 VSS VSS nmos W=0.155u L=0.04u
M1148 U239/net32 N105 VSS VSS nmos W=0.155u L=0.04u
M1149 U239/net64 U239/net24 VSS VSS nmos W=0.2u L=0.04u
M1150 U239/net28 U239/net40 U239/net64 VDD pmos W=0.205u L=0.04u
M1151 U239/net24 N121 U239/net32 VDD pmos W=0.205u L=0.04u
M1152 U239/net28 U239/net20 U239/net24 VDD pmos W=0.205u L=0.04u
M1153 U239/net40 U239/net106 U239/net108 VDD pmos W=0.205u L=0.04u
M1154 U239/net40 N73 U239/net104 VDD pmos W=0.205u L=0.04u
M1155 U239/net20 U239/net40 VDD VDD pmos W=0.205u L=0.04u
M1156 U239/net106 N73 VDD VDD pmos W=0.205u L=0.04u
M1157 U239/net104 N89 VDD VDD pmos W=0.205u L=0.04u
M1158 U239/net30 N121 VDD VDD pmos W=0.205u L=0.04u
M1159 U239/net108 U239/net104 VDD VDD pmos W=0.205u L=0.04u
M1160 n181 U239/net28 VDD VDD pmos W=0.205u L=0.04u
M1161 U239/net32 N105 VDD VDD pmos W=0.205u L=0.04u
M1162 U239/net64 U239/net24 VDD VDD pmos W=0.28u L=0.04u
M1163 U239/net24 U239/net30 U239/net045 VDD pmos W=0.205u L=0.04u
M1164 U239/net045 U239/net32 VDD VDD pmos W=0.205u L=0.04u
M1165 U240/XU1-net6 N135 VSS VSS nmos W=0.155u L=0.04u
M1166 n180 N137 U240/XU1-net6 VSS nmos W=0.155u L=0.04u
M1167 n180 N135 VDD VDD pmos W=0.155u L=0.04u
M1168 n180 N137 VDD VDD pmos W=0.155u L=0.04u
M1169 U241/net28 U241/net20 U241/net64 VSS nmos W=0.155u L=0.04u
M1170 U241/net24 U241/net30 U241/net32 VSS nmos W=0.155u L=0.04u
M1171 U241/net28 U241/net40 U241/net24 VSS nmos W=0.155u L=0.04u
M1172 U241/net40 N37 U241/net108 VSS nmos W=0.155u L=0.04u
M1173 U241/net40 U241/net106 U241/net104 VSS nmos W=0.155u L=0.04u
M1174 U241/net24 N45 U241/net050 VSS nmos W=0.155u L=0.04u
M1175 U241/net050 U241/net32 VSS VSS nmos W=0.155u L=0.04u
M1176 U241/net20 U241/net40 VSS VSS nmos W=0.155u L=0.04u
M1177 U241/net106 N37 VSS VSS nmos W=0.155u L=0.04u
M1178 U241/net104 N33 VSS VSS nmos W=0.155u L=0.04u
M1179 U241/net30 N45 VSS VSS nmos W=0.155u L=0.04u
M1180 U241/net108 U241/net104 VSS VSS nmos W=0.155u L=0.04u
M1181 n176 U241/net28 VSS VSS nmos W=0.155u L=0.04u
M1182 U241/net32 N41 VSS VSS nmos W=0.155u L=0.04u
M1183 U241/net64 U241/net24 VSS VSS nmos W=0.2u L=0.04u
M1184 U241/net28 U241/net40 U241/net64 VDD pmos W=0.205u L=0.04u
M1185 U241/net24 N45 U241/net32 VDD pmos W=0.205u L=0.04u
M1186 U241/net28 U241/net20 U241/net24 VDD pmos W=0.205u L=0.04u
M1187 U241/net40 U241/net106 U241/net108 VDD pmos W=0.205u L=0.04u
M1188 U241/net40 N37 U241/net104 VDD pmos W=0.205u L=0.04u
M1189 U241/net20 U241/net40 VDD VDD pmos W=0.205u L=0.04u
M1190 U241/net106 N37 VDD VDD pmos W=0.205u L=0.04u
M1191 U241/net104 N33 VDD VDD pmos W=0.205u L=0.04u
M1192 U241/net30 N45 VDD VDD pmos W=0.205u L=0.04u
M1193 U241/net108 U241/net104 VDD VDD pmos W=0.205u L=0.04u
M1194 n176 U241/net28 VDD VDD pmos W=0.205u L=0.04u
M1195 U241/net32 N41 VDD VDD pmos W=0.205u L=0.04u
M1196 U241/net64 U241/net24 VDD VDD pmos W=0.28u L=0.04u
M1197 U241/net24 U241/net30 U241/net045 VDD pmos W=0.205u L=0.04u
M1198 U241/net045 U241/net32 VDD VDD pmos W=0.205u L=0.04u
M1199 U242/net28 U242/net20 U242/net64 VSS nmos W=0.155u L=0.04u
M1200 U242/net24 U242/net30 U242/net32 VSS nmos W=0.155u L=0.04u
M1201 U242/net28 U242/net40 U242/net24 VSS nmos W=0.155u L=0.04u
M1202 U242/net40 n184 U242/net108 VSS nmos W=0.155u L=0.04u
M1203 U242/net40 U242/net106 U242/net104 VSS nmos W=0.155u L=0.04u
M1204 U242/net24 n182 U242/net050 VSS nmos W=0.155u L=0.04u
M1205 U242/net050 U242/net32 VSS VSS nmos W=0.155u L=0.04u
M1206 U242/net20 U242/net40 VSS VSS nmos W=0.155u L=0.04u
M1207 U242/net106 n184 VSS VSS nmos W=0.155u L=0.04u
M1208 U242/net104 n183 VSS VSS nmos W=0.155u L=0.04u
M1209 U242/net30 n182 VSS VSS nmos W=0.155u L=0.04u
M1210 U242/net108 U242/net104 VSS VSS nmos W=0.155u L=0.04u
M1211 n142 U242/net28 VSS VSS nmos W=0.155u L=0.04u
M1212 U242/net32 n179 VSS VSS nmos W=0.155u L=0.04u
M1213 U242/net64 U242/net24 VSS VSS nmos W=0.2u L=0.04u
M1214 U242/net28 U242/net40 U242/net64 VDD pmos W=0.205u L=0.04u
M1215 U242/net24 n182 U242/net32 VDD pmos W=0.205u L=0.04u
M1216 U242/net28 U242/net20 U242/net24 VDD pmos W=0.205u L=0.04u
M1217 U242/net40 U242/net106 U242/net108 VDD pmos W=0.205u L=0.04u
M1218 U242/net40 n184 U242/net104 VDD pmos W=0.205u L=0.04u
M1219 U242/net20 U242/net40 VDD VDD pmos W=0.205u L=0.04u
M1220 U242/net106 n184 VDD VDD pmos W=0.205u L=0.04u
M1221 U242/net104 n183 VDD VDD pmos W=0.205u L=0.04u
M1222 U242/net30 n182 VDD VDD pmos W=0.205u L=0.04u
M1223 U242/net108 U242/net104 VDD VDD pmos W=0.205u L=0.04u
M1224 n142 U242/net28 VDD VDD pmos W=0.205u L=0.04u
M1225 U242/net32 n179 VDD VDD pmos W=0.205u L=0.04u
M1226 U242/net64 U242/net24 VDD VDD pmos W=0.28u L=0.04u
M1227 U242/net24 U242/net30 U242/net045 VDD pmos W=0.205u L=0.04u
M1228 U242/net045 U242/net32 VDD VDD pmos W=0.205u L=0.04u
M1229 U243/net28 U243/net20 U243/net64 VSS nmos W=0.155u L=0.04u
M1230 U243/net24 U243/net30 U243/net32 VSS nmos W=0.155u L=0.04u
M1231 U243/net28 U243/net40 U243/net24 VSS nmos W=0.155u L=0.04u
M1232 U243/net40 N81 U243/net108 VSS nmos W=0.155u L=0.04u
M1233 U243/net40 U243/net106 U243/net104 VSS nmos W=0.155u L=0.04u
M1234 U243/net24 N65 U243/net050 VSS nmos W=0.155u L=0.04u
M1235 U243/net050 U243/net32 VSS VSS nmos W=0.155u L=0.04u
M1236 U243/net20 U243/net40 VSS VSS nmos W=0.155u L=0.04u
M1237 U243/net106 N81 VSS VSS nmos W=0.155u L=0.04u
M1238 U243/net104 N97 VSS VSS nmos W=0.155u L=0.04u
M1239 U243/net30 N65 VSS VSS nmos W=0.155u L=0.04u
M1240 U243/net108 U243/net104 VSS VSS nmos W=0.155u L=0.04u
M1241 n184 U243/net28 VSS VSS nmos W=0.155u L=0.04u
M1242 U243/net32 N113 VSS VSS nmos W=0.155u L=0.04u
M1243 U243/net64 U243/net24 VSS VSS nmos W=0.2u L=0.04u
M1244 U243/net28 U243/net40 U243/net64 VDD pmos W=0.205u L=0.04u
M1245 U243/net24 N65 U243/net32 VDD pmos W=0.205u L=0.04u
M1246 U243/net28 U243/net20 U243/net24 VDD pmos W=0.205u L=0.04u
M1247 U243/net40 U243/net106 U243/net108 VDD pmos W=0.205u L=0.04u
M1248 U243/net40 N81 U243/net104 VDD pmos W=0.205u L=0.04u
M1249 U243/net20 U243/net40 VDD VDD pmos W=0.205u L=0.04u
M1250 U243/net106 N81 VDD VDD pmos W=0.205u L=0.04u
M1251 U243/net104 N97 VDD VDD pmos W=0.205u L=0.04u
M1252 U243/net30 N65 VDD VDD pmos W=0.205u L=0.04u
M1253 U243/net108 U243/net104 VDD VDD pmos W=0.205u L=0.04u
M1254 n184 U243/net28 VDD VDD pmos W=0.205u L=0.04u
M1255 U243/net32 N113 VDD VDD pmos W=0.205u L=0.04u
M1256 U243/net64 U243/net24 VDD VDD pmos W=0.28u L=0.04u
M1257 U243/net24 U243/net30 U243/net045 VDD pmos W=0.205u L=0.04u
M1258 U243/net045 U243/net32 VDD VDD pmos W=0.205u L=0.04u
M1259 U244/XU1-net6 N137 VSS VSS nmos W=0.155u L=0.04u
M1260 n183 N133 U244/XU1-net6 VSS nmos W=0.155u L=0.04u
M1261 n183 N137 VDD VDD pmos W=0.155u L=0.04u
M1262 n183 N133 VDD VDD pmos W=0.155u L=0.04u
M1263 U245/net28 U245/net20 U245/net64 VSS nmos W=0.155u L=0.04u
M1264 U245/net24 U245/net30 U245/net32 VSS nmos W=0.155u L=0.04u
M1265 U245/net28 U245/net40 U245/net24 VSS nmos W=0.155u L=0.04u
M1266 U245/net40 N13 U245/net108 VSS nmos W=0.155u L=0.04u
M1267 U245/net40 U245/net106 U245/net104 VSS nmos W=0.155u L=0.04u
M1268 U245/net24 N9 U245/net050 VSS nmos W=0.155u L=0.04u
M1269 U245/net050 U245/net32 VSS VSS nmos W=0.155u L=0.04u
M1270 U245/net20 U245/net40 VSS VSS nmos W=0.155u L=0.04u
M1271 U245/net106 N13 VSS VSS nmos W=0.155u L=0.04u
M1272 U245/net104 N1 VSS VSS nmos W=0.155u L=0.04u
M1273 U245/net30 N9 VSS VSS nmos W=0.155u L=0.04u
M1274 U245/net108 U245/net104 VSS VSS nmos W=0.155u L=0.04u
M1275 n179 U245/net28 VSS VSS nmos W=0.155u L=0.04u
M1276 U245/net32 N5 VSS VSS nmos W=0.155u L=0.04u
M1277 U245/net64 U245/net24 VSS VSS nmos W=0.2u L=0.04u
M1278 U245/net28 U245/net40 U245/net64 VDD pmos W=0.205u L=0.04u
M1279 U245/net24 N9 U245/net32 VDD pmos W=0.205u L=0.04u
M1280 U245/net28 U245/net20 U245/net24 VDD pmos W=0.205u L=0.04u
M1281 U245/net40 U245/net106 U245/net108 VDD pmos W=0.205u L=0.04u
M1282 U245/net40 N13 U245/net104 VDD pmos W=0.205u L=0.04u
M1283 U245/net20 U245/net40 VDD VDD pmos W=0.205u L=0.04u
M1284 U245/net106 N13 VDD VDD pmos W=0.205u L=0.04u
M1285 U245/net104 N1 VDD VDD pmos W=0.205u L=0.04u
M1286 U245/net30 N9 VDD VDD pmos W=0.205u L=0.04u
M1287 U245/net108 U245/net104 VDD VDD pmos W=0.205u L=0.04u
M1288 n179 U245/net28 VDD VDD pmos W=0.205u L=0.04u
M1289 U245/net32 N5 VDD VDD pmos W=0.205u L=0.04u
M1290 U245/net64 U245/net24 VDD VDD pmos W=0.28u L=0.04u
M1291 U245/net24 U245/net30 U245/net045 VDD pmos W=0.205u L=0.04u
M1292 U245/net045 U245/net32 VDD VDD pmos W=0.205u L=0.04u
M1293 U246/net28 U246/net20 U246/net64 VSS nmos W=0.155u L=0.04u
M1294 U246/net24 U246/net30 U246/net32 VSS nmos W=0.155u L=0.04u
M1295 U246/net28 U246/net40 U246/net24 VSS nmos W=0.155u L=0.04u
M1296 U246/net40 n186 U246/net108 VSS nmos W=0.155u L=0.04u
M1297 U246/net40 U246/net106 U246/net104 VSS nmos W=0.155u L=0.04u
M1298 U246/net24 n182 U246/net050 VSS nmos W=0.155u L=0.04u
M1299 U246/net050 U246/net32 VSS VSS nmos W=0.155u L=0.04u
M1300 U246/net20 U246/net40 VSS VSS nmos W=0.155u L=0.04u
M1301 U246/net106 n186 VSS VSS nmos W=0.155u L=0.04u
M1302 U246/net104 n185 VSS VSS nmos W=0.155u L=0.04u
M1303 U246/net30 n182 VSS VSS nmos W=0.155u L=0.04u
M1304 U246/net108 U246/net104 VSS VSS nmos W=0.155u L=0.04u
M1305 n145 U246/net28 VSS VSS nmos W=0.155u L=0.04u
M1306 U246/net32 n175 VSS VSS nmos W=0.155u L=0.04u
M1307 U246/net64 U246/net24 VSS VSS nmos W=0.2u L=0.04u
M1308 U246/net28 U246/net40 U246/net64 VDD pmos W=0.205u L=0.04u
M1309 U246/net24 n182 U246/net32 VDD pmos W=0.205u L=0.04u
M1310 U246/net28 U246/net20 U246/net24 VDD pmos W=0.205u L=0.04u
M1311 U246/net40 U246/net106 U246/net108 VDD pmos W=0.205u L=0.04u
M1312 U246/net40 n186 U246/net104 VDD pmos W=0.205u L=0.04u
M1313 U246/net20 U246/net40 VDD VDD pmos W=0.205u L=0.04u
M1314 U246/net106 n186 VDD VDD pmos W=0.205u L=0.04u
M1315 U246/net104 n185 VDD VDD pmos W=0.205u L=0.04u
M1316 U246/net30 n182 VDD VDD pmos W=0.205u L=0.04u
M1317 U246/net108 U246/net104 VDD VDD pmos W=0.205u L=0.04u
M1318 n145 U246/net28 VDD VDD pmos W=0.205u L=0.04u
M1319 U246/net32 n175 VDD VDD pmos W=0.205u L=0.04u
M1320 U246/net64 U246/net24 VDD VDD pmos W=0.28u L=0.04u
M1321 U246/net24 U246/net30 U246/net045 VDD pmos W=0.205u L=0.04u
M1322 U246/net045 U246/net32 VDD VDD pmos W=0.205u L=0.04u
M1323 U247/net28 U247/net20 U247/net64 VSS nmos W=0.155u L=0.04u
M1324 U247/net24 U247/net30 U247/net32 VSS nmos W=0.155u L=0.04u
M1325 U247/net28 U247/net40 U247/net24 VSS nmos W=0.155u L=0.04u
M1326 U247/net40 N77 U247/net108 VSS nmos W=0.155u L=0.04u
M1327 U247/net40 U247/net106 U247/net104 VSS nmos W=0.155u L=0.04u
M1328 U247/net24 N125 U247/net050 VSS nmos W=0.155u L=0.04u
M1329 U247/net050 U247/net32 VSS VSS nmos W=0.155u L=0.04u
M1330 U247/net20 U247/net40 VSS VSS nmos W=0.155u L=0.04u
M1331 U247/net106 N77 VSS VSS nmos W=0.155u L=0.04u
M1332 U247/net104 N93 VSS VSS nmos W=0.155u L=0.04u
M1333 U247/net30 N125 VSS VSS nmos W=0.155u L=0.04u
M1334 U247/net108 U247/net104 VSS VSS nmos W=0.155u L=0.04u
M1335 n186 U247/net28 VSS VSS nmos W=0.155u L=0.04u
M1336 U247/net32 N109 VSS VSS nmos W=0.155u L=0.04u
M1337 U247/net64 U247/net24 VSS VSS nmos W=0.2u L=0.04u
M1338 U247/net28 U247/net40 U247/net64 VDD pmos W=0.205u L=0.04u
M1339 U247/net24 N125 U247/net32 VDD pmos W=0.205u L=0.04u
M1340 U247/net28 U247/net20 U247/net24 VDD pmos W=0.205u L=0.04u
M1341 U247/net40 U247/net106 U247/net108 VDD pmos W=0.205u L=0.04u
M1342 U247/net40 N77 U247/net104 VDD pmos W=0.205u L=0.04u
M1343 U247/net20 U247/net40 VDD VDD pmos W=0.205u L=0.04u
M1344 U247/net106 N77 VDD VDD pmos W=0.205u L=0.04u
M1345 U247/net104 N93 VDD VDD pmos W=0.205u L=0.04u
M1346 U247/net30 N125 VDD VDD pmos W=0.205u L=0.04u
M1347 U247/net108 U247/net104 VDD VDD pmos W=0.205u L=0.04u
M1348 n186 U247/net28 VDD VDD pmos W=0.205u L=0.04u
M1349 U247/net32 N109 VDD VDD pmos W=0.205u L=0.04u
M1350 U247/net64 U247/net24 VDD VDD pmos W=0.28u L=0.04u
M1351 U247/net24 U247/net30 U247/net045 VDD pmos W=0.205u L=0.04u
M1352 U247/net045 U247/net32 VDD VDD pmos W=0.205u L=0.04u
M1353 U248/XU1-net6 N137 VSS VSS nmos W=0.155u L=0.04u
M1354 n185 N136 U248/XU1-net6 VSS nmos W=0.155u L=0.04u
M1355 n185 N137 VDD VDD pmos W=0.155u L=0.04u
M1356 n185 N136 VDD VDD pmos W=0.155u L=0.04u
M1357 U249/net28 U249/net20 U249/net64 VSS nmos W=0.155u L=0.04u
M1358 U249/net24 U249/net30 U249/net32 VSS nmos W=0.155u L=0.04u
M1359 U249/net28 U249/net40 U249/net24 VSS nmos W=0.155u L=0.04u
M1360 U249/net40 N53 U249/net108 VSS nmos W=0.155u L=0.04u
M1361 U249/net40 U249/net106 U249/net104 VSS nmos W=0.155u L=0.04u
M1362 U249/net24 N61 U249/net050 VSS nmos W=0.155u L=0.04u
M1363 U249/net050 U249/net32 VSS VSS nmos W=0.155u L=0.04u
M1364 U249/net20 U249/net40 VSS VSS nmos W=0.155u L=0.04u
M1365 U249/net106 N53 VSS VSS nmos W=0.155u L=0.04u
M1366 U249/net104 N49 VSS VSS nmos W=0.155u L=0.04u
M1367 U249/net30 N61 VSS VSS nmos W=0.155u L=0.04u
M1368 U249/net108 U249/net104 VSS VSS nmos W=0.155u L=0.04u
M1369 n175 U249/net28 VSS VSS nmos W=0.155u L=0.04u
M1370 U249/net32 N57 VSS VSS nmos W=0.155u L=0.04u
M1371 U249/net64 U249/net24 VSS VSS nmos W=0.2u L=0.04u
M1372 U249/net28 U249/net40 U249/net64 VDD pmos W=0.205u L=0.04u
M1373 U249/net24 N61 U249/net32 VDD pmos W=0.205u L=0.04u
M1374 U249/net28 U249/net20 U249/net24 VDD pmos W=0.205u L=0.04u
M1375 U249/net40 U249/net106 U249/net108 VDD pmos W=0.205u L=0.04u
M1376 U249/net40 N53 U249/net104 VDD pmos W=0.205u L=0.04u
M1377 U249/net20 U249/net40 VDD VDD pmos W=0.205u L=0.04u
M1378 U249/net106 N53 VDD VDD pmos W=0.205u L=0.04u
M1379 U249/net104 N49 VDD VDD pmos W=0.205u L=0.04u
M1380 U249/net30 N61 VDD VDD pmos W=0.205u L=0.04u
M1381 U249/net108 U249/net104 VDD VDD pmos W=0.205u L=0.04u
M1382 n175 U249/net28 VDD VDD pmos W=0.205u L=0.04u
M1383 U249/net32 N57 VDD VDD pmos W=0.205u L=0.04u
M1384 U249/net64 U249/net24 VDD VDD pmos W=0.28u L=0.04u
M1385 U249/net24 U249/net30 U249/net045 VDD pmos W=0.205u L=0.04u
M1386 U249/net045 U249/net32 VDD VDD pmos W=0.205u L=0.04u
M1387 U250/net28 U250/net20 U250/net64 VSS nmos W=0.155u L=0.04u
M1388 U250/net24 U250/net30 U250/net32 VSS nmos W=0.155u L=0.04u
M1389 U250/net28 U250/net40 U250/net24 VSS nmos W=0.155u L=0.04u
M1390 U250/net40 N21 U250/net108 VSS nmos W=0.155u L=0.04u
M1391 U250/net40 U250/net106 U250/net104 VSS nmos W=0.155u L=0.04u
M1392 U250/net24 N29 U250/net050 VSS nmos W=0.155u L=0.04u
M1393 U250/net050 U250/net32 VSS VSS nmos W=0.155u L=0.04u
M1394 U250/net20 U250/net40 VSS VSS nmos W=0.155u L=0.04u
M1395 U250/net106 N21 VSS VSS nmos W=0.155u L=0.04u
M1396 U250/net104 N17 VSS VSS nmos W=0.155u L=0.04u
M1397 U250/net30 N29 VSS VSS nmos W=0.155u L=0.04u
M1398 U250/net108 U250/net104 VSS VSS nmos W=0.155u L=0.04u
M1399 n182 U250/net28 VSS VSS nmos W=0.155u L=0.04u
M1400 U250/net32 N25 VSS VSS nmos W=0.155u L=0.04u
M1401 U250/net64 U250/net24 VSS VSS nmos W=0.2u L=0.04u
M1402 U250/net28 U250/net40 U250/net64 VDD pmos W=0.205u L=0.04u
M1403 U250/net24 N29 U250/net32 VDD pmos W=0.205u L=0.04u
M1404 U250/net28 U250/net20 U250/net24 VDD pmos W=0.205u L=0.04u
M1405 U250/net40 U250/net106 U250/net108 VDD pmos W=0.205u L=0.04u
M1406 U250/net40 N21 U250/net104 VDD pmos W=0.205u L=0.04u
M1407 U250/net20 U250/net40 VDD VDD pmos W=0.205u L=0.04u
M1408 U250/net106 N21 VDD VDD pmos W=0.205u L=0.04u
M1409 U250/net104 N17 VDD VDD pmos W=0.205u L=0.04u
M1410 U250/net30 N29 VDD VDD pmos W=0.205u L=0.04u
M1411 U250/net108 U250/net104 VDD VDD pmos W=0.205u L=0.04u
M1412 n182 U250/net28 VDD VDD pmos W=0.205u L=0.04u
M1413 U250/net32 N25 VDD VDD pmos W=0.205u L=0.04u
M1414 U250/net64 U250/net24 VDD VDD pmos W=0.28u L=0.04u
M1415 U250/net24 U250/net30 U250/net045 VDD pmos W=0.205u L=0.04u
M1416 U250/net045 U250/net32 VDD VDD pmos W=0.205u L=0.04u
.ENDS
