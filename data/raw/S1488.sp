.SUBCKT s1488 CK CLR v0 v1 Av13_D_10B Av13_D_11B Av13_D_12B Av13_D_13B Av13_D_14B Av13_D_15B Av13_D_16B Av13_D_17B Av13_D_18B Av13_D_19B Av13_D_20B Av13_D_21B Av13_D_22B Av13_D_23B Av13_D_24B Av13_D_6B Av13_D_7B Av13_D_8B Av13_D_9B v2 v3 v4 v5 v6 VDD VSS
M1 v13_D_2C AND2_229/net6 VSS VSS nmos W=0.31u L=0.04u
M2 AND2_229/X_u2-net6 CLR VSS VSS nmos W=0.31u L=0.04u
M3 AND2_229/net6 Av13_D_2B AND2_229/X_u2-net6 VSS nmos W=0.31u L=0.04u
M4 v13_D_2C AND2_229/net6 VDD VDD pmos W=0.41u L=0.04u
M5 AND2_229/net6 CLR VDD VDD pmos W=0.41u L=0.04u
M6 AND2_229/net6 Av13_D_2B VDD VDD pmos W=0.41u L=0.04u
M7 v13_D_4C AND2_228/net6 VSS VSS nmos W=0.31u L=0.04u
M8 AND2_228/X_u2-net6 CLR VSS VSS nmos W=0.31u L=0.04u
M9 AND2_228/net6 Av13_D_4B AND2_228/X_u2-net6 VSS nmos W=0.31u L=0.04u
M10 v13_D_4C AND2_228/net6 VDD VDD pmos W=0.41u L=0.04u
M11 AND2_228/net6 CLR VDD VDD pmos W=0.41u L=0.04u
M12 AND2_228/net6 Av13_D_4B VDD VDD pmos W=0.41u L=0.04u
M13 v13_D_5C AND2_227/net6 VSS VSS nmos W=0.31u L=0.04u
M14 AND2_227/X_u2-net6 CLR VSS VSS nmos W=0.31u L=0.04u
M15 AND2_227/net6 Av13_D_5B AND2_227/X_u2-net6 VSS nmos W=0.31u L=0.04u
M16 v13_D_5C AND2_227/net6 VDD VDD pmos W=0.41u L=0.04u
M17 AND2_227/net6 CLR VDD VDD pmos W=0.41u L=0.04u
M18 AND2_227/net6 Av13_D_5B VDD VDD pmos W=0.41u L=0.04u
M19 v13_D_1C AND2_226/net6 VSS VSS nmos W=0.31u L=0.04u
M20 AND2_226/X_u2-net6 CLR VSS VSS nmos W=0.31u L=0.04u
M21 AND2_226/net6 Av13_D_1B AND2_226/X_u2-net6 VSS nmos W=0.31u L=0.04u
M22 v13_D_1C AND2_226/net6 VDD VDD pmos W=0.41u L=0.04u
M23 AND2_226/net6 CLR VDD VDD pmos W=0.41u L=0.04u
M24 AND2_226/net6 Av13_D_1B VDD VDD pmos W=0.41u L=0.04u
M25 v13_D_3C AND2_225/net6 VSS VSS nmos W=0.31u L=0.04u
M26 AND2_225/X_u2-net6 CLR VSS VSS nmos W=0.31u L=0.04u
M27 AND2_225/net6 Av13_D_3B AND2_225/X_u2-net6 VSS nmos W=0.31u L=0.04u
M28 v13_D_3C AND2_225/net6 VDD VDD pmos W=0.41u L=0.04u
M29 AND2_225/net6 CLR VDD VDD pmos W=0.41u L=0.04u
M30 AND2_225/net6 Av13_D_3B VDD VDD pmos W=0.41u L=0.04u
M31 v13_D_0C AND2_224/net6 VSS VSS nmos W=0.31u L=0.04u
M32 AND2_224/X_u2-net6 CLR VSS VSS nmos W=0.31u L=0.04u
M33 AND2_224/net6 Av13_D_0B AND2_224/X_u2-net6 VSS nmos W=0.31u L=0.04u
M34 v13_D_0C AND2_224/net6 VDD VDD pmos W=0.41u L=0.04u
M35 AND2_224/net6 CLR VDD VDD pmos W=0.41u L=0.04u
M36 AND2_224/net6 Av13_D_0B VDD VDD pmos W=0.41u L=0.04u
M37 Av13_D_9B v12 U274/net10 VSS nmos W=0.155u L=0.04u
M38 U274/net10 n257 VSS VSS nmos W=0.155u L=0.04u
M39 Av13_D_9B n255 U274/net10 VSS nmos W=0.155u L=0.04u
M40 U274/net10 n256 VSS VSS nmos W=0.155u L=0.04u
M41 U274/net30 n257 VDD VDD pmos W=0.205u L=0.04u
M42 Av13_D_9B v12 U274/net24 VDD pmos W=0.205u L=0.04u
M43 U274/net24 n255 VDD VDD pmos W=0.205u L=0.04u
M44 Av13_D_9B n256 U274/net30 VDD pmos W=0.205u L=0.04u
M45 VSS n259 U275/net22 VSS nmos W=0.155u L=0.04u
M46 U275/net22 n258 U275/net30 VSS nmos W=0.155u L=0.04u
M47 U275/net22 v7 U275/net30 VSS nmos W=0.155u L=0.04u
M48 U275/net22 v2 U275/net30 VSS nmos W=0.155u L=0.04u
M49 n256 U275/net30 VSS VSS nmos W=0.155u L=0.04u
M50 n256 U275/net30 VDD VDD pmos W=0.205u L=0.04u
M51 U275/net38 v2 VDD VDD pmos W=0.205u L=0.04u
M52 U275/net35 v7 U275/net38 VDD pmos W=0.205u L=0.04u
M53 U275/net30 n258 U275/net35 VDD pmos W=0.205u L=0.04u
M54 U275/net30 n259 VDD VDD pmos W=0.205u L=0.04u
M55 U276/net29 n263 VSS VSS nmos W=0.155u L=0.04u
M56 n255 n262 U276/net29 VSS nmos W=0.155u L=0.04u
M57 n255 n260 U276/net23 VSS nmos W=0.155u L=0.04u
M58 U276/net23 n261 VSS VSS nmos W=0.155u L=0.04u
M59 U276/net20 n261 n255 VDD pmos W=0.205u L=0.04u
M60 U276/net20 n260 n255 VDD pmos W=0.205u L=0.04u
M61 VDD n262 U276/net20 VDD pmos W=0.205u L=0.04u
M62 VDD n263 U276/net20 VDD pmos W=0.205u L=0.04u
M63 U277/p2 n266 VSS VSS nmos W=0.155u L=0.04u
M64 U277/p0 n264 U277/p1 VSS nmos W=0.155u L=0.04u
M65 U277/p1 n265 U277/p2 VSS nmos W=0.155u L=0.04u
M66 Av13_D_8B n259 U277/p0 VSS nmos W=0.155u L=0.04u
M67 Av13_D_8B n265 VDD VDD pmos W=0.205u L=0.04u
M68 Av13_D_8B n264 VDD VDD pmos W=0.205u L=0.04u
M69 Av13_D_8B n259 VDD VDD pmos W=0.205u L=0.04u
M70 Av13_D_8B n266 VDD VDD pmos W=0.205u L=0.04u
M71 U278/net11 n267 n266 VDD pmos W=0.205u L=0.04u
M72 U278/net11 n268 n266 VDD pmos W=0.205u L=0.04u
M73 U278/net11 n269 U278/XI16-net11 VDD pmos W=0.205u L=0.04u
M74 U278/XI16-net11 n270 VDD VDD pmos W=0.205u L=0.04u
M75 n266 n270 VSS VSS nmos W=0.155u L=0.04u
M76 n266 n269 VSS VSS nmos W=0.155u L=0.04u
M77 n266 n267 U278/XI12-net17 VSS nmos W=0.155u L=0.04u
M78 U278/XI12-net17 n268 VSS VSS nmos W=0.155u L=0.04u
M79 n270 n271 U279/net19 VDD pmos W=0.205u L=0.04u
M80 n270 n273 U279/net19 VDD pmos W=0.205u L=0.04u
M81 n270 n272 U279/net19 VDD pmos W=0.205u L=0.04u
M82 U279/net19 v7 VDD VDD pmos W=0.205u L=0.04u
M83 n270 v7 VSS VSS nmos W=0.155u L=0.04u
M84 U279/XI20-net13 n273 VSS VSS nmos W=0.155u L=0.04u
M85 n270 n271 U279/XI20-net17 VSS nmos W=0.155u L=0.04u
M86 U279/XI20-net17 n272 U279/XI20-net13 VSS nmos W=0.155u L=0.04u
M87 U280/net11 n274 n273 VDD pmos W=0.205u L=0.04u
M88 U280/net11 n275 n273 VDD pmos W=0.205u L=0.04u
M89 U280/net11 n276 U280/XI16-net11 VDD pmos W=0.205u L=0.04u
M90 U280/XI16-net11 n262 VDD VDD pmos W=0.205u L=0.04u
M91 n273 n262 VSS VSS nmos W=0.155u L=0.04u
M92 n273 n276 VSS VSS nmos W=0.155u L=0.04u
M93 n273 n274 U280/XI12-net17 VSS nmos W=0.155u L=0.04u
M94 U280/XI12-net17 n275 VSS VSS nmos W=0.155u L=0.04u
M95 U281/net19 n279 VSS VSS nmos W=0.155u L=0.04u
M96 n272 n279 U281/net40 VSS nmos W=0.155u L=0.04u
M97 n272 U281/net19 U281/net36 VSS nmos W=0.155u L=0.04u
M98 U281/net40 n278 VSS VSS nmos W=0.31u L=0.04u
M99 U281/net36 n277 VSS VSS nmos W=0.155u L=0.04u
M100 U281/net19 n279 VDD VDD pmos W=0.205u L=0.04u
M101 n272 U281/net19 U281/net26 VDD pmos W=0.325u L=0.04u
M102 U281/net26 n278 VDD VDD pmos W=0.41u L=0.04u
M103 n272 n279 U281/net30 VDD pmos W=0.325u L=0.04u
M104 U281/net30 n277 VDD VDD pmos W=0.205u L=0.04u
M105 n278 v12 VSS VSS nmos W=0.155u L=0.04u
M106 n278 n280 VSS VSS nmos W=0.155u L=0.04u
M107 U282/XI1-net8 n280 VDD VDD pmos W=0.205u L=0.04u
M108 n278 v12 U282/XI1-net8 VDD pmos W=0.205u L=0.04u
M109 U283/net29 n257 VSS VSS nmos W=0.155u L=0.04u
M110 n271 n282 U283/net29 VSS nmos W=0.155u L=0.04u
M111 n271 v9 U283/net23 VSS nmos W=0.155u L=0.04u
M112 U283/net23 n281 VSS VSS nmos W=0.155u L=0.04u
M113 U283/net20 n281 n271 VDD pmos W=0.205u L=0.04u
M114 U283/net20 v9 n271 VDD pmos W=0.205u L=0.04u
M115 VDD n282 U283/net20 VDD pmos W=0.205u L=0.04u
M116 VDD n257 U283/net20 VDD pmos W=0.205u L=0.04u
M117 n269 n283 U284/net14 VSS nmos W=0.155u L=0.04u
M118 U284/net14 n287 VSS VSS nmos W=0.155u L=0.04u
M119 U284/net14 n286 VSS VSS nmos W=0.155u L=0.04u
M120 n269 n285 U284/net14 VSS nmos W=0.155u L=0.04u
M121 n269 n284 U284/net14 VSS nmos W=0.155u L=0.04u
M122 n269 n287 U284/XI16-net11 VDD pmos W=0.205u L=0.04u
M123 U284/XI16-net11 n286 VDD VDD pmos W=0.205u L=0.04u
M124 n269 n285 U284/XI15-net11 VDD pmos W=0.205u L=0.04u
M125 U284/XI15-net11 n284 U284/XI15-net18 VDD pmos W=0.205u L=0.04u
M126 U284/XI15-net18 n283 VDD VDD pmos W=0.205u L=0.04u
M127 n286 v9 U285/net27 VSS nmos W=0.155u L=0.04u
M128 U285/net27 n279 VSS VSS nmos W=0.155u L=0.04u
M129 n286 n288 VSS VSS nmos W=0.155u L=0.04u
M130 n286 n279 U285/net13 VDD pmos W=0.205u L=0.04u
M131 U285/net13 n288 VDD VDD pmos W=0.205u L=0.04u
M132 n286 v9 U285/net13 VDD pmos W=0.205u L=0.04u
M133 U286/XU1-net6 n289 VSS VSS nmos W=0.155u L=0.04u
M134 n268 n285 U286/XU1-net6 VSS nmos W=0.155u L=0.04u
M135 n268 n289 VDD VDD pmos W=0.155u L=0.04u
M136 n268 n285 VDD VDD pmos W=0.155u L=0.04u
M137 VSS n291 U287/net22 VSS nmos W=0.155u L=0.04u
M138 U287/net22 n279 U287/net30 VSS nmos W=0.155u L=0.04u
M139 U287/net22 n290 U287/net30 VSS nmos W=0.155u L=0.04u
M140 U287/net22 n289 U287/net30 VSS nmos W=0.155u L=0.04u
M141 n265 U287/net30 VSS VSS nmos W=0.155u L=0.04u
M142 n265 U287/net30 VDD VDD pmos W=0.205u L=0.04u
M143 U287/net38 n289 VDD VDD pmos W=0.205u L=0.04u
M144 U287/net35 n290 U287/net38 VDD pmos W=0.205u L=0.04u
M145 U287/net30 n279 U287/net35 VDD pmos W=0.205u L=0.04u
M146 U287/net30 n291 VDD VDD pmos W=0.205u L=0.04u
M147 U288/net36 n293 U288/net24 VSS nmos W=0.155u L=0.04u
M148 U288/net24 n294 VSS VSS nmos W=0.155u L=0.04u
M149 Av13_D_7B n290 U288/net36 VSS nmos W=0.155u L=0.04u
M150 Av13_D_7B n292 U288/net36 VSS nmos W=0.155u L=0.04u
M151 Av13_D_7B n292 U288/net35 VDD pmos W=0.205u L=0.04u
M152 U288/net35 n290 VDD VDD pmos W=0.205u L=0.04u
M153 Av13_D_7B n294 VDD VDD pmos W=0.205u L=0.04u
M154 Av13_D_7B n293 VDD VDD pmos W=0.205u L=0.04u
M155 U289/net17 n296 VSS VSS nmos W=0.155u L=0.04u
M156 U289/net17 n289 VSS VSS nmos W=0.155u L=0.04u
M157 U289/net63 n295 VSS VSS nmos W=0.155u L=0.04u
M158 n294 U289/net17 VSS VSS nmos W=0.155u L=0.04u
M159 n294 v7 U289/net63 VSS nmos W=0.155u L=0.04u
M160 n294 n295 U289/net31 VDD pmos W=0.205u L=0.04u
M161 U289/net39 n296 VDD VDD pmos W=0.195u L=0.04u
M162 U289/net31 U289/net17 VDD VDD pmos W=0.195u L=0.04u
M163 n294 v7 U289/net31 VDD pmos W=0.195u L=0.04u
M164 U289/net17 n289 U289/net39 VDD pmos W=0.195u L=0.04u
M165 U290/net8 n287 U290/net26 VSS nmos W=0.155u L=0.04u
M166 U290/net26 n299 VSS VSS nmos W=0.155u L=0.04u
M167 U290/net29 U290/net8 VSS VSS nmos W=0.155u L=0.04u
M168 U290/net29 n297 n295 VSS nmos W=0.155u L=0.04u
M169 U290/net29 n298 n295 VSS nmos W=0.155u L=0.04u
M170 U290/net8 n299 VDD VDD pmos W=0.205u L=0.04u
M171 U290/net8 n287 VDD VDD pmos W=0.205u L=0.04u
M172 n295 U290/net8 VDD VDD pmos W=0.205u L=0.04u
M173 n295 n297 U290/net20 VDD pmos W=0.205u L=0.04u
M174 U290/net20 n298 VDD VDD pmos W=0.205u L=0.04u
M175 U291/net29 n302 VSS VSS nmos W=0.155u L=0.04u
M176 n297 n288 U291/net29 VSS nmos W=0.155u L=0.04u
M177 n297 n300 U291/net23 VSS nmos W=0.155u L=0.04u
M178 U291/net23 n301 VSS VSS nmos W=0.155u L=0.04u
M179 U291/net20 n301 n297 VDD pmos W=0.205u L=0.04u
M180 U291/net20 n300 n297 VDD pmos W=0.205u L=0.04u
M181 VDD n288 U291/net20 VDD pmos W=0.205u L=0.04u
M182 VDD n302 U291/net20 VDD pmos W=0.205u L=0.04u
M183 n292 v10 U292/net19 VDD pmos W=0.205u L=0.04u
M184 n292 n304 U292/net19 VDD pmos W=0.205u L=0.04u
M185 n292 n303 U292/net19 VDD pmos W=0.205u L=0.04u
M186 U292/net19 n305 VDD VDD pmos W=0.205u L=0.04u
M187 n292 n305 VSS VSS nmos W=0.155u L=0.04u
M188 U292/XI20-net13 n304 VSS VSS nmos W=0.155u L=0.04u
M189 n292 v10 U292/XI20-net17 VSS nmos W=0.155u L=0.04u
M190 U292/XI20-net17 n303 U292/XI20-net13 VSS nmos W=0.155u L=0.04u
M191 U293/net36 n307 U293/net24 VSS nmos W=0.155u L=0.04u
M192 U293/net24 n308 VSS VSS nmos W=0.155u L=0.04u
M193 Av13_D_6B n287 U293/net36 VSS nmos W=0.155u L=0.04u
M194 Av13_D_6B n306 U293/net36 VSS nmos W=0.155u L=0.04u
M195 Av13_D_6B n306 U293/net35 VDD pmos W=0.205u L=0.04u
M196 U293/net35 n287 VDD VDD pmos W=0.205u L=0.04u
M197 Av13_D_6B n308 VDD VDD pmos W=0.205u L=0.04u
M198 Av13_D_6B n307 VDD VDD pmos W=0.205u L=0.04u
M199 U294/net17 v10 VSS VSS nmos W=0.155u L=0.04u
M200 U294/net17 n311 VSS VSS nmos W=0.155u L=0.04u
M201 U294/net63 n310 VSS VSS nmos W=0.155u L=0.04u
M202 n308 U294/net17 VSS VSS nmos W=0.155u L=0.04u
M203 n308 n309 U294/net63 VSS nmos W=0.155u L=0.04u
M204 n308 n310 U294/net31 VDD pmos W=0.205u L=0.04u
M205 U294/net39 v10 VDD VDD pmos W=0.195u L=0.04u
M206 U294/net31 U294/net17 VDD VDD pmos W=0.195u L=0.04u
M207 n308 n309 U294/net31 VDD pmos W=0.195u L=0.04u
M208 U294/net17 n311 U294/net39 VDD pmos W=0.195u L=0.04u
M209 U295/net36 n312 U295/net24 VSS nmos W=0.155u L=0.04u
M210 U295/net24 n313 VSS VSS nmos W=0.155u L=0.04u
M211 n309 v11 U295/net36 VSS nmos W=0.155u L=0.04u
M212 n309 n301 U295/net36 VSS nmos W=0.155u L=0.04u
M213 n309 n301 U295/net35 VDD pmos W=0.205u L=0.04u
M214 U295/net35 v11 VDD VDD pmos W=0.205u L=0.04u
M215 n309 n313 VDD VDD pmos W=0.205u L=0.04u
M216 n309 n312 VDD VDD pmos W=0.205u L=0.04u
M217 n313 n317 VSS VSS nmos W=0.155u L=0.04u
M218 n313 n315 U296/XI17-net17 VSS nmos W=0.155u L=0.04u
M219 U296/XI17-net17 n316 VSS VSS nmos W=0.155u L=0.04u
M220 n313 n314 U296/XI10-net17 VSS nmos W=0.155u L=0.04u
M221 U296/XI10-net17 n275 VSS VSS nmos W=0.155u L=0.04u
M222 U296/net30 n314 n313 VDD pmos W=0.205u L=0.04u
M223 U296/net30 n275 n313 VDD pmos W=0.205u L=0.04u
M224 VDD n317 U296/net36 VDD pmos W=0.205u L=0.04u
M225 U296/net36 n316 U296/net30 VDD pmos W=0.205u L=0.04u
M226 U296/net36 n315 U296/net30 VDD pmos W=0.205u L=0.04u
M227 n275 n290 VSS VSS nmos W=0.135u L=0.04u
M228 n275 n290 VDD VDD pmos W=0.205u L=0.04u
M229 n290 n318 VSS VSS nmos W=0.155u L=0.04u
M230 n290 v4 VSS VSS nmos W=0.155u L=0.04u
M231 U298/XI1-net8 v4 VDD VDD pmos W=0.205u L=0.04u
M232 n290 n318 U298/XI1-net8 VDD pmos W=0.205u L=0.04u
M233 U299/net29 n281 VSS VSS nmos W=0.155u L=0.04u
M234 n312 v9 U299/net29 VSS nmos W=0.155u L=0.04u
M235 n312 n282 U299/net23 VSS nmos W=0.155u L=0.04u
M236 U299/net23 n280 VSS VSS nmos W=0.155u L=0.04u
M237 U299/net20 n280 n312 VDD pmos W=0.205u L=0.04u
M238 U299/net20 n282 n312 VDD pmos W=0.205u L=0.04u
M239 VDD v9 U299/net20 VDD pmos W=0.205u L=0.04u
M240 VDD n281 U299/net20 VDD pmos W=0.205u L=0.04u
M241 U300/net19 n261 VSS VSS nmos W=0.155u L=0.04u
M242 n307 n261 U300/net40 VSS nmos W=0.155u L=0.04u
M243 n307 U300/net19 U300/net36 VSS nmos W=0.155u L=0.04u
M244 U300/net40 n320 VSS VSS nmos W=0.31u L=0.04u
M245 U300/net36 n319 VSS VSS nmos W=0.155u L=0.04u
M246 U300/net19 n261 VDD VDD pmos W=0.205u L=0.04u
M247 n307 U300/net19 U300/net26 VDD pmos W=0.325u L=0.04u
M248 U300/net26 n320 VDD VDD pmos W=0.41u L=0.04u
M249 n307 n261 U300/net30 VDD pmos W=0.325u L=0.04u
M250 U300/net30 n319 VDD VDD pmos W=0.205u L=0.04u
M251 n320 n321 VSS VSS nmos W=0.155u L=0.04u
M252 n320 n322 VSS VSS nmos W=0.155u L=0.04u
M253 U301/XI1-net8 n322 VDD VDD pmos W=0.205u L=0.04u
M254 n320 n321 U301/XI1-net8 VDD pmos W=0.205u L=0.04u
M255 Av13_D_5B n323 U302/XI0-net10 VSS nmos W=0.155u L=0.04u
M256 U302/XI0-net10 n324 U302/XI0-net13 VSS nmos W=0.155u L=0.04u
M257 U302/XI0-net13 n325 VSS VSS nmos W=0.155u L=0.04u
M258 Av13_D_5B n325 VDD VDD pmos W=0.205u L=0.04u
M259 Av13_D_5B n323 VDD VDD pmos W=0.205u L=0.04u
M260 Av13_D_5B n324 VDD VDD pmos W=0.205u L=0.04u
M261 n325 n306 U303/net19 VDD pmos W=0.205u L=0.04u
M262 n325 n326 U303/net19 VDD pmos W=0.205u L=0.04u
M263 n325 n302 U303/net19 VDD pmos W=0.205u L=0.04u
M264 U303/net19 n327 VDD VDD pmos W=0.205u L=0.04u
M265 n325 n327 VSS VSS nmos W=0.155u L=0.04u
M266 U303/XI20-net13 n326 VSS VSS nmos W=0.155u L=0.04u
M267 n325 n306 U303/XI20-net17 VSS nmos W=0.155u L=0.04u
M268 U303/XI20-net17 n302 U303/XI20-net13 VSS nmos W=0.155u L=0.04u
M269 U304/net15 n330 VSS VSS nmos W=0.155u L=0.04u
M270 U304/net15 n329 VSS VSS nmos W=0.155u L=0.04u
M271 n327 n258 U304/net15 VSS nmos W=0.155u L=0.04u
M272 n327 v2 U304/net15 VSS nmos W=0.155u L=0.04u
M273 U304/net15 n331 VSS VSS nmos W=0.155u L=0.04u
M274 n327 n328 U304/net15 VSS nmos W=0.155u L=0.04u
M275 n327 n331 U304/XI1-net11 VDD pmos W=0.205u L=0.04u
M276 U304/XI1-net11 n330 U304/XI1-net18 VDD pmos W=0.205u L=0.04u
M277 U304/XI1-net18 n329 VDD VDD pmos W=0.205u L=0.04u
M278 n327 n258 U304/XI7-net11 VDD pmos W=0.205u L=0.04u
M279 U304/XI7-net11 v2 U304/XI7-net18 VDD pmos W=0.205u L=0.04u
M280 U304/XI7-net18 n328 VDD VDD pmos W=0.205u L=0.04u
M281 U305/XU1-net6 n274 VSS VSS nmos W=0.155u L=0.04u
M282 n329 n314 U305/XU1-net6 VSS nmos W=0.155u L=0.04u
M283 n329 n274 VDD VDD pmos W=0.155u L=0.04u
M284 n329 n314 VDD VDD pmos W=0.155u L=0.04u
M285 U306/net29 n310 VSS VSS nmos W=0.155u L=0.04u
M286 n323 n333 U306/net29 VSS nmos W=0.155u L=0.04u
M287 n323 n332 U306/net23 VSS nmos W=0.155u L=0.04u
M288 U306/net23 v8 VSS VSS nmos W=0.155u L=0.04u
M289 U306/net20 v8 n323 VDD pmos W=0.205u L=0.04u
M290 U306/net20 n332 n323 VDD pmos W=0.205u L=0.04u
M291 VDD n333 U306/net20 VDD pmos W=0.205u L=0.04u
M292 VDD n310 U306/net20 VDD pmos W=0.205u L=0.04u
M293 U307/net36 n335 U307/net24 VSS nmos W=0.155u L=0.04u
M294 U307/net24 n336 VSS VSS nmos W=0.155u L=0.04u
M295 n333 n328 U307/net36 VSS nmos W=0.155u L=0.04u
M296 n333 n334 U307/net36 VSS nmos W=0.155u L=0.04u
M297 n333 n334 U307/net35 VDD pmos W=0.205u L=0.04u
M298 U307/net35 n328 VDD VDD pmos W=0.205u L=0.04u
M299 n333 n336 VDD VDD pmos W=0.205u L=0.04u
M300 n333 n335 VDD VDD pmos W=0.205u L=0.04u
M301 U308/net29 n338 VSS VSS nmos W=0.155u L=0.04u
M302 n336 n299 U308/net29 VSS nmos W=0.155u L=0.04u
M303 n336 n332 U308/net23 VSS nmos W=0.155u L=0.04u
M304 U308/net23 n337 VSS VSS nmos W=0.155u L=0.04u
M305 U308/net20 n337 n336 VDD pmos W=0.205u L=0.04u
M306 U308/net20 n332 n336 VDD pmos W=0.205u L=0.04u
M307 VDD n299 U308/net20 VDD pmos W=0.205u L=0.04u
M308 VDD n338 U308/net20 VDD pmos W=0.205u L=0.04u
M309 n337 v0 U309/net15 VSS nmos W=0.155u L=0.04u
M310 n337 n339 U309/net15 VSS nmos W=0.155u L=0.04u
M311 U309/net15 v11 VSS VSS nmos W=0.155u L=0.04u
M312 n337 v11 VDD VDD pmos W=0.205u L=0.04u
M313 n337 v0 U309/XI16-net11 VDD pmos W=0.205u L=0.04u
M314 U309/XI16-net11 n339 VDD VDD pmos W=0.205u L=0.04u
M315 U310/net19 n321 VSS VSS nmos W=0.155u L=0.04u
M316 n335 n321 U310/net40 VSS nmos W=0.155u L=0.04u
M317 n335 U310/net19 U310/net36 VSS nmos W=0.155u L=0.04u
M318 U310/net40 n341 VSS VSS nmos W=0.31u L=0.04u
M319 U310/net36 n340 VSS VSS nmos W=0.155u L=0.04u
M320 U310/net19 n321 VDD VDD pmos W=0.205u L=0.04u
M321 n335 U310/net19 U310/net26 VDD pmos W=0.325u L=0.04u
M322 U310/net26 n341 VDD VDD pmos W=0.41u L=0.04u
M323 n335 n321 U310/net30 VDD pmos W=0.325u L=0.04u
M324 U310/net30 n340 VDD VDD pmos W=0.205u L=0.04u
M325 n341 n322 VSS VSS nmos W=0.155u L=0.04u
M326 n341 n261 VSS VSS nmos W=0.155u L=0.04u
M327 n341 U311/net12 VSS VSS nmos W=0.155u L=0.04u
M328 U311/net12 n342 VSS VSS nmos W=0.155u L=0.04u
M329 U311/XU9-net9 U311/net12 VDD VDD pmos W=0.41u L=0.04u
M330 U311/XU9-net12 n261 U311/XU9-net9 VDD pmos W=0.41u L=0.04u
M331 n341 n322 U311/XU9-net12 VDD pmos W=0.41u L=0.04u
M332 U311/net12 n342 VDD VDD pmos W=0.31u L=0.04u
M333 U312/net36 n283 U312/net24 VSS nmos W=0.155u L=0.04u
M334 U312/net24 n344 VSS VSS nmos W=0.155u L=0.04u
M335 n340 n343 U312/net36 VSS nmos W=0.155u L=0.04u
M336 n340 n339 U312/net36 VSS nmos W=0.155u L=0.04u
M337 n340 n339 U312/net35 VDD pmos W=0.205u L=0.04u
M338 U312/net35 n343 VDD VDD pmos W=0.205u L=0.04u
M339 n340 n344 VDD VDD pmos W=0.205u L=0.04u
M340 n340 n283 VDD VDD pmos W=0.205u L=0.04u
M341 n344 n345 U313/net27 VSS nmos W=0.155u L=0.04u
M342 U313/net27 n346 VSS VSS nmos W=0.155u L=0.04u
M343 n344 n347 VSS VSS nmos W=0.155u L=0.04u
M344 n344 n346 U313/net13 VDD pmos W=0.205u L=0.04u
M345 U313/net13 n347 VDD VDD pmos W=0.205u L=0.04u
M346 n344 n345 U313/net13 VDD pmos W=0.205u L=0.04u
M347 U314/net19 n303 VSS VSS nmos W=0.155u L=0.04u
M348 n347 n303 U314/net40 VSS nmos W=0.155u L=0.04u
M349 n347 U314/net19 U314/net36 VSS nmos W=0.155u L=0.04u
M350 U314/net40 n349 VSS VSS nmos W=0.31u L=0.04u
M351 U314/net36 n348 VSS VSS nmos W=0.155u L=0.04u
M352 U314/net19 n303 VDD VDD pmos W=0.205u L=0.04u
M353 n347 U314/net19 U314/net26 VDD pmos W=0.325u L=0.04u
M354 U314/net26 n349 VDD VDD pmos W=0.41u L=0.04u
M355 n347 n303 U314/net30 VDD pmos W=0.325u L=0.04u
M356 U314/net30 n348 VDD VDD pmos W=0.205u L=0.04u
M357 U315/XU1-net6 n351 VSS VSS nmos W=0.155u L=0.04u
M358 n349 n350 U315/XU1-net6 VSS nmos W=0.155u L=0.04u
M359 n349 n351 VDD VDD pmos W=0.155u L=0.04u
M360 n349 n350 VDD VDD pmos W=0.155u L=0.04u
M361 U316/p2 n352 VSS VSS nmos W=0.155u L=0.04u
M362 U316/p0 v12 U316/p1 VSS nmos W=0.155u L=0.04u
M363 U316/p1 n263 U316/p2 VSS nmos W=0.155u L=0.04u
M364 n348 v3 U316/p0 VSS nmos W=0.155u L=0.04u
M365 n348 n263 VDD VDD pmos W=0.205u L=0.04u
M366 n348 v12 VDD VDD pmos W=0.205u L=0.04u
M367 n348 v3 VDD VDD pmos W=0.205u L=0.04u
M368 n348 n352 VDD VDD pmos W=0.205u L=0.04u
M369 U317/net36 n354 U317/net24 VSS nmos W=0.155u L=0.04u
M370 U317/net24 n355 VSS VSS nmos W=0.155u L=0.04u
M371 Av13_D_4B n298 U317/net36 VSS nmos W=0.155u L=0.04u
M372 Av13_D_4B n353 U317/net36 VSS nmos W=0.155u L=0.04u
M373 Av13_D_4B n353 U317/net35 VDD pmos W=0.205u L=0.04u
M374 U317/net35 n298 VDD VDD pmos W=0.205u L=0.04u
M375 Av13_D_4B n355 VDD VDD pmos W=0.205u L=0.04u
M376 Av13_D_4B n354 VDD VDD pmos W=0.205u L=0.04u
M377 U318/net11 n356 n355 VDD pmos W=0.205u L=0.04u
M378 U318/net11 n357 n355 VDD pmos W=0.205u L=0.04u
M379 U318/net11 n358 U318/XI16-net11 VDD pmos W=0.205u L=0.04u
M380 U318/XI16-net11 n359 VDD VDD pmos W=0.205u L=0.04u
M381 n355 n359 VSS VSS nmos W=0.155u L=0.04u
M382 n355 n358 VSS VSS nmos W=0.155u L=0.04u
M383 n355 n356 U318/XI12-net17 VSS nmos W=0.155u L=0.04u
M384 U318/XI12-net17 n357 VSS VSS nmos W=0.155u L=0.04u
M385 n359 n334 VSS VSS nmos W=0.155u L=0.04u
M386 n359 v10 VSS VSS nmos W=0.155u L=0.04u
M387 n359 n281 VSS VSS nmos W=0.155u L=0.04u
M388 U319/net25 n334 VDD VDD pmos W=0.41u L=0.04u
M389 U319/net28 v10 U319/net25 VDD pmos W=0.41u L=0.04u
M390 n359 n281 U319/net28 VDD pmos W=0.41u L=0.04u
M391 n357 U320/net27 VDD VDD pmos W=0.205u L=0.04u
M392 U320/net27 v2 U320/net23 VDD pmos W=0.205u L=0.04u
M393 U320/net27 n360 U320/net23 VDD pmos W=0.205u L=0.04u
M394 U320/net27 n284 U320/net23 VDD pmos W=0.205u L=0.04u
M395 U320/net23 n301 VDD VDD pmos W=0.205u L=0.04u
M396 U320/net23 n326 VDD VDD pmos W=0.205u L=0.04u
M397 n357 U320/net27 VSS VSS nmos W=0.155u L=0.04u
M398 U320/XI20-net13 n360 VSS VSS nmos W=0.155u L=0.04u
M399 U320/net27 v2 U320/XI20-net17 VSS nmos W=0.155u L=0.04u
M400 U320/XI20-net17 n284 U320/XI20-net13 VSS nmos W=0.155u L=0.04u
M401 U320/net27 n301 U320/XI17-net17 VSS nmos W=0.155u L=0.04u
M402 U320/XI17-net17 n326 VSS VSS nmos W=0.155u L=0.04u
M403 VSS n310 U321/net22 VSS nmos W=0.155u L=0.04u
M404 U321/net22 n363 n354 VSS nmos W=0.155u L=0.04u
M405 U321/net22 n362 n354 VSS nmos W=0.155u L=0.04u
M406 U321/net22 n361 n354 VSS nmos W=0.155u L=0.04u
M407 U321/net38 n361 VDD VDD pmos W=0.205u L=0.04u
M408 U321/net35 n362 U321/net38 VDD pmos W=0.205u L=0.04u
M409 n354 n363 U321/net35 VDD pmos W=0.205u L=0.04u
M410 n354 n310 VDD VDD pmos W=0.205u L=0.04u
M411 n363 n306 U322/net14 VSS nmos W=0.155u L=0.04u
M412 U322/net14 n287 VSS VSS nmos W=0.155u L=0.04u
M413 U322/net14 n364 VSS VSS nmos W=0.155u L=0.04u
M414 n363 n328 U322/net14 VSS nmos W=0.155u L=0.04u
M415 n363 v8 U322/net14 VSS nmos W=0.155u L=0.04u
M416 n363 n287 U322/XI16-net11 VDD pmos W=0.205u L=0.04u
M417 U322/XI16-net11 n364 VDD VDD pmos W=0.205u L=0.04u
M418 n363 n328 U322/XI15-net11 VDD pmos W=0.205u L=0.04u
M419 U322/XI15-net11 v8 U322/XI15-net18 VDD pmos W=0.205u L=0.04u
M420 U322/XI15-net18 n306 VDD VDD pmos W=0.205u L=0.04u
M421 n364 n365 U323/net27 VSS nmos W=0.155u L=0.04u
M422 U323/net27 n366 VSS VSS nmos W=0.155u L=0.04u
M423 n364 n281 VSS VSS nmos W=0.155u L=0.04u
M424 n364 n366 U323/net13 VDD pmos W=0.205u L=0.04u
M425 U323/net13 n281 VDD VDD pmos W=0.205u L=0.04u
M426 n364 n365 U323/net13 VDD pmos W=0.205u L=0.04u
M427 U324/net15 n368 VSS VSS nmos W=0.155u L=0.04u
M428 U324/net15 n365 VSS VSS nmos W=0.155u L=0.04u
M429 n362 v12 U324/net15 VSS nmos W=0.155u L=0.04u
M430 n362 v2 U324/net15 VSS nmos W=0.155u L=0.04u
M431 U324/net15 n369 VSS VSS nmos W=0.155u L=0.04u
M432 n362 n367 U324/net15 VSS nmos W=0.155u L=0.04u
M433 n362 n369 U324/XI1-net11 VDD pmos W=0.205u L=0.04u
M434 U324/XI1-net11 n368 U324/XI1-net18 VDD pmos W=0.205u L=0.04u
M435 U324/XI1-net18 n365 VDD VDD pmos W=0.205u L=0.04u
M436 n362 v12 U324/XI7-net11 VDD pmos W=0.205u L=0.04u
M437 U324/XI7-net11 v2 U324/XI7-net18 VDD pmos W=0.205u L=0.04u
M438 U324/XI7-net18 n367 VDD VDD pmos W=0.205u L=0.04u
M439 n369 n319 VSS VSS nmos W=0.135u L=0.04u
M440 n369 n319 VDD VDD pmos W=0.205u L=0.04u
M441 U326/net29 v8 VSS VSS nmos W=0.155u L=0.04u
M442 n367 n356 U326/net29 VSS nmos W=0.155u L=0.04u
M443 n367 n370 U326/net23 VSS nmos W=0.155u L=0.04u
M444 U326/net23 n371 VSS VSS nmos W=0.155u L=0.04u
M445 U326/net20 n371 n367 VDD pmos W=0.205u L=0.04u
M446 U326/net20 n370 n367 VDD pmos W=0.205u L=0.04u
M447 VDD n356 U326/net20 VDD pmos W=0.205u L=0.04u
M448 VDD v8 U326/net20 VDD pmos W=0.205u L=0.04u
M449 n361 n372 U327/net27 VSS nmos W=0.155u L=0.04u
M450 U327/net39 n375 VSS VSS nmos W=0.155u L=0.04u
M451 U327/net27 n373 U327/net39 VSS nmos W=0.155u L=0.04u
M452 U327/net27 n374 U327/net39 VSS nmos W=0.155u L=0.04u
M453 n361 v11 U327/net27 VSS nmos W=0.155u L=0.04u
M454 U327/net39 v10 VSS VSS nmos W=0.155u L=0.04u
M455 n361 n375 U327/net46 VDD pmos W=0.205u L=0.04u
M456 U327/net46 v10 VDD VDD pmos W=0.205u L=0.04u
M457 n361 v11 U327/net34 VDD pmos W=0.205u L=0.04u
M458 U327/net34 n372 VDD VDD pmos W=0.205u L=0.04u
M459 n361 n374 U327/net37 VDD pmos W=0.205u L=0.04u
M460 U327/net37 n373 VDD VDD pmos W=0.205u L=0.04u
M461 U328/net29 v9 VSS VSS nmos W=0.155u L=0.04u
M462 n373 v2 U328/net29 VSS nmos W=0.155u L=0.04u
M463 n373 n262 U328/net23 VSS nmos W=0.155u L=0.04u
M464 U328/net23 n331 VSS VSS nmos W=0.155u L=0.04u
M465 U328/net20 n331 n373 VDD pmos W=0.205u L=0.04u
M466 U328/net20 n262 n373 VDD pmos W=0.205u L=0.04u
M467 VDD v2 U328/net20 VDD pmos W=0.205u L=0.04u
M468 VDD v9 U328/net20 VDD pmos W=0.205u L=0.04u
M469 n372 n317 VSS VSS nmos W=0.155u L=0.04u
M470 n372 n288 U329/XI17-net17 VSS nmos W=0.155u L=0.04u
M471 U329/XI17-net17 n376 VSS VSS nmos W=0.155u L=0.04u
M472 n372 v9 U329/XI10-net17 VSS nmos W=0.155u L=0.04u
M473 U329/XI10-net17 v10 VSS VSS nmos W=0.155u L=0.04u
M474 U329/net30 v9 n372 VDD pmos W=0.205u L=0.04u
M475 U329/net30 v10 n372 VDD pmos W=0.205u L=0.04u
M476 VDD n317 U329/net36 VDD pmos W=0.205u L=0.04u
M477 U329/net36 n376 U329/net30 VDD pmos W=0.205u L=0.04u
M478 U329/net36 n288 U329/net30 VDD pmos W=0.205u L=0.04u
M479 U330/XU1-net6 n378 VSS VSS nmos W=0.155u L=0.04u
M480 Av13_D_3B n377 U330/XU1-net6 VSS nmos W=0.155u L=0.04u
M481 Av13_D_3B n378 VDD VDD pmos W=0.155u L=0.04u
M482 Av13_D_3B n377 VDD VDD pmos W=0.155u L=0.04u
M483 U331/net19 n310 VSS VSS nmos W=0.155u L=0.04u
M484 n378 n310 U331/net40 VSS nmos W=0.155u L=0.04u
M485 n378 U331/net19 U331/net36 VSS nmos W=0.155u L=0.04u
M486 U331/net40 n379 VSS VSS nmos W=0.31u L=0.04u
M487 U331/net36 n299 VSS VSS nmos W=0.155u L=0.04u
M488 U331/net19 n310 VDD VDD pmos W=0.205u L=0.04u
M489 n378 U331/net19 U331/net26 VDD pmos W=0.325u L=0.04u
M490 U331/net26 n379 VDD VDD pmos W=0.41u L=0.04u
M491 n378 n310 U331/net30 VDD pmos W=0.325u L=0.04u
M492 U331/net30 n299 VDD VDD pmos W=0.205u L=0.04u
M493 U332/net36 n381 U332/net24 VSS nmos W=0.155u L=0.04u
M494 U332/net24 n382 VSS VSS nmos W=0.155u L=0.04u
M495 n379 n380 U332/net36 VSS nmos W=0.155u L=0.04u
M496 n379 n321 U332/net36 VSS nmos W=0.155u L=0.04u
M497 n379 n321 U332/net35 VDD pmos W=0.205u L=0.04u
M498 U332/net35 n380 VDD VDD pmos W=0.205u L=0.04u
M499 n379 n382 VDD VDD pmos W=0.205u L=0.04u
M500 n379 n381 VDD VDD pmos W=0.205u L=0.04u
M501 n382 n385 VSS VSS nmos W=0.155u L=0.04u
M502 n382 n276 U333/XI17-net17 VSS nmos W=0.155u L=0.04u
M503 U333/XI17-net17 n262 VSS VSS nmos W=0.155u L=0.04u
M504 n382 n383 U333/XI10-net17 VSS nmos W=0.155u L=0.04u
M505 U333/XI10-net17 n384 VSS VSS nmos W=0.155u L=0.04u
M506 U333/net30 n383 n382 VDD pmos W=0.205u L=0.04u
M507 U333/net30 n384 n382 VDD pmos W=0.205u L=0.04u
M508 VDD n385 U333/net36 VDD pmos W=0.205u L=0.04u
M509 U333/net36 n262 U333/net30 VDD pmos W=0.205u L=0.04u
M510 U333/net36 n276 U333/net30 VDD pmos W=0.205u L=0.04u
M511 U334/net19 n301 VSS VSS nmos W=0.155u L=0.04u
M512 n385 n301 U334/net40 VSS nmos W=0.155u L=0.04u
M513 n385 U334/net19 U334/net36 VSS nmos W=0.155u L=0.04u
M514 U334/net40 n387 VSS VSS nmos W=0.31u L=0.04u
M515 U334/net36 n386 VSS VSS nmos W=0.155u L=0.04u
M516 U334/net19 n301 VDD VDD pmos W=0.205u L=0.04u
M517 n385 U334/net19 U334/net26 VDD pmos W=0.325u L=0.04u
M518 U334/net26 n387 VDD VDD pmos W=0.41u L=0.04u
M519 n385 n301 U334/net30 VDD pmos W=0.325u L=0.04u
M520 U334/net30 n386 VDD VDD pmos W=0.205u L=0.04u
M521 n387 v2 U335/net27 VSS nmos W=0.155u L=0.04u
M522 U335/net27 n338 VSS VSS nmos W=0.155u L=0.04u
M523 n387 n388 VSS VSS nmos W=0.155u L=0.04u
M524 n387 n338 U335/net13 VDD pmos W=0.205u L=0.04u
M525 U335/net13 n388 VDD VDD pmos W=0.205u L=0.04u
M526 n387 v2 U335/net13 VDD pmos W=0.205u L=0.04u
M527 n388 n298 U336/net14 VSS nmos W=0.155u L=0.04u
M528 U336/net14 n389 VSS VSS nmos W=0.155u L=0.04u
M529 U336/net14 v11 VSS VSS nmos W=0.155u L=0.04u
M530 n388 n366 U336/net14 VSS nmos W=0.155u L=0.04u
M531 n388 v6 U336/net14 VSS nmos W=0.155u L=0.04u
M532 n388 n389 U336/XI16-net11 VDD pmos W=0.205u L=0.04u
M533 U336/XI16-net11 v11 VDD VDD pmos W=0.205u L=0.04u
M534 n388 n366 U336/XI15-net11 VDD pmos W=0.205u L=0.04u
M535 U336/XI15-net11 v6 U336/XI15-net18 VDD pmos W=0.205u L=0.04u
M536 U336/XI15-net18 n298 VDD VDD pmos W=0.205u L=0.04u
M537 U337/net29 n365 VSS VSS nmos W=0.155u L=0.04u
M538 n389 n371 U337/net29 VSS nmos W=0.155u L=0.04u
M539 n389 n370 U337/net23 VSS nmos W=0.155u L=0.04u
M540 U337/net23 n277 VSS VSS nmos W=0.155u L=0.04u
M541 U337/net20 n277 n389 VDD pmos W=0.205u L=0.04u
M542 U337/net20 n370 n389 VDD pmos W=0.205u L=0.04u
M543 VDD n371 U337/net20 VDD pmos W=0.205u L=0.04u
M544 VDD n365 U337/net20 VDD pmos W=0.205u L=0.04u
M545 U338/XU1-net6 n390 VSS VSS nmos W=0.155u L=0.04u
M546 n386 n314 U338/XU1-net6 VSS nmos W=0.155u L=0.04u
M547 n386 n390 VDD VDD pmos W=0.155u L=0.04u
M548 n386 n314 VDD VDD pmos W=0.155u L=0.04u
M549 n381 n391 U339/net23 VDD pmos W=0.205u L=0.04u
M550 n381 n282 U339/net23 VDD pmos W=0.205u L=0.04u
M551 n381 n366 U339/net23 VDD pmos W=0.205u L=0.04u
M552 U339/net23 n338 VDD VDD pmos W=0.205u L=0.04u
M553 U339/net23 n392 VDD VDD pmos W=0.205u L=0.04u
M554 U339/XI20-net13 n282 VSS VSS nmos W=0.155u L=0.04u
M555 n381 n391 U339/XI20-net17 VSS nmos W=0.155u L=0.04u
M556 U339/XI20-net17 n366 U339/XI20-net13 VSS nmos W=0.155u L=0.04u
M557 n381 n338 U339/XI17-net17 VSS nmos W=0.155u L=0.04u
M558 U339/XI17-net17 n392 VSS VSS nmos W=0.155u L=0.04u
M559 U340/XU1-net6 n393 VSS VSS nmos W=0.155u L=0.04u
M560 n392 n370 U340/XU1-net6 VSS nmos W=0.155u L=0.04u
M561 n392 n393 VDD VDD pmos W=0.155u L=0.04u
M562 n392 n370 VDD VDD pmos W=0.155u L=0.04u
M563 VSS n300 U341/net22 VSS nmos W=0.155u L=0.04u
M564 U341/net22 n375 U341/net30 VSS nmos W=0.155u L=0.04u
M565 U341/net22 n368 U341/net30 VSS nmos W=0.155u L=0.04u
M566 U341/net22 n365 U341/net30 VSS nmos W=0.155u L=0.04u
M567 n380 U341/net30 VSS VSS nmos W=0.155u L=0.04u
M568 n380 U341/net30 VDD VDD pmos W=0.205u L=0.04u
M569 U341/net38 n365 VDD VDD pmos W=0.205u L=0.04u
M570 U341/net35 n368 U341/net38 VDD pmos W=0.205u L=0.04u
M571 U341/net30 n375 U341/net35 VDD pmos W=0.205u L=0.04u
M572 U341/net30 n300 VDD VDD pmos W=0.205u L=0.04u
M573 n375 n394 VSS VSS nmos W=0.135u L=0.04u
M574 n375 n394 VDD VDD pmos W=0.205u L=0.04u
M575 n368 n352 VSS VSS nmos W=0.155u L=0.04u
M576 n368 n303 VSS VSS nmos W=0.155u L=0.04u
M577 U343/XI1-net8 n303 VDD VDD pmos W=0.205u L=0.04u
M578 n368 n352 U343/XI1-net8 VDD pmos W=0.205u L=0.04u
M579 n299 n281 VSS VSS nmos W=0.155u L=0.04u
M580 n299 n366 VSS VSS nmos W=0.155u L=0.04u
M581 U344/XI1-net8 n366 VDD VDD pmos W=0.205u L=0.04u
M582 n299 n281 U344/XI1-net8 VDD pmos W=0.205u L=0.04u
M583 n377 n263 U345/net23 VDD pmos W=0.205u L=0.04u
M584 n377 n288 U345/net23 VDD pmos W=0.205u L=0.04u
M585 n377 n395 U345/net23 VDD pmos W=0.205u L=0.04u
M586 U345/net23 n282 VDD VDD pmos W=0.205u L=0.04u
M587 U345/net23 n396 VDD VDD pmos W=0.205u L=0.04u
M588 U345/XI20-net13 n288 VSS VSS nmos W=0.155u L=0.04u
M589 n377 n263 U345/XI20-net17 VSS nmos W=0.155u L=0.04u
M590 U345/XI20-net17 n395 U345/XI20-net13 VSS nmos W=0.155u L=0.04u
M591 n377 n282 U345/XI17-net17 VSS nmos W=0.155u L=0.04u
M592 U345/XI17-net17 n396 VSS VSS nmos W=0.155u L=0.04u
M593 n396 n301 U346/net10 VSS nmos W=0.155u L=0.04u
M594 U346/net10 n288 VSS VSS nmos W=0.155u L=0.04u
M595 n396 n283 U346/net10 VSS nmos W=0.155u L=0.04u
M596 U346/net10 v10 VSS VSS nmos W=0.155u L=0.04u
M597 U346/net30 n288 VDD VDD pmos W=0.205u L=0.04u
M598 n396 n301 U346/net24 VDD pmos W=0.205u L=0.04u
M599 U346/net24 n283 VDD VDD pmos W=0.205u L=0.04u
M600 n396 v10 U346/net30 VDD pmos W=0.205u L=0.04u
M601 U347/net36 n398 U347/net24 VSS nmos W=0.155u L=0.04u
M602 U347/net24 n399 VSS VSS nmos W=0.155u L=0.04u
M603 Av13_D_2B n397 U347/net36 VSS nmos W=0.155u L=0.04u
M604 Av13_D_2B n300 U347/net36 VSS nmos W=0.155u L=0.04u
M605 Av13_D_2B n300 U347/net35 VDD pmos W=0.205u L=0.04u
M606 U347/net35 n397 VDD VDD pmos W=0.205u L=0.04u
M607 Av13_D_2B n399 VDD VDD pmos W=0.205u L=0.04u
M608 Av13_D_2B n398 VDD VDD pmos W=0.205u L=0.04u
M609 n399 n401 U348/XI21-net17 VSS nmos W=0.155u L=0.04u
M610 U348/XI21-net17 n261 VSS VSS nmos W=0.155u L=0.04u
M611 n399 n400 U348/XI6-net17 VSS nmos W=0.155u L=0.04u
M612 U348/XI6-net17 n310 VSS VSS nmos W=0.155u L=0.04u
M613 n399 n326 U348/XI20-net17 VSS nmos W=0.155u L=0.04u
M614 U348/XI20-net17 n356 VSS VSS nmos W=0.155u L=0.04u
M615 VDD n401 U348/net22 VDD pmos W=0.205u L=0.04u
M616 VDD n261 U348/net22 VDD pmos W=0.205u L=0.04u
M617 U348/net16 n400 n399 VDD pmos W=0.205u L=0.04u
M618 U348/net16 n310 n399 VDD pmos W=0.205u L=0.04u
M619 U348/net22 n326 U348/net16 VDD pmos W=0.205u L=0.04u
M620 U348/net22 n356 U348/net16 VDD pmos W=0.205u L=0.04u
M621 U349/net36 n403 U349/net24 VSS nmos W=0.155u L=0.04u
M622 U349/net24 n404 VSS VSS nmos W=0.155u L=0.04u
M623 n400 n366 U349/net36 VSS nmos W=0.155u L=0.04u
M624 n400 n402 U349/net36 VSS nmos W=0.155u L=0.04u
M625 n400 n402 U349/net35 VDD pmos W=0.205u L=0.04u
M626 U349/net35 n366 VDD VDD pmos W=0.205u L=0.04u
M627 n400 n404 VDD VDD pmos W=0.205u L=0.04u
M628 n400 n403 VDD VDD pmos W=0.205u L=0.04u
M629 n404 n406 U350/XI21-net17 VSS nmos W=0.155u L=0.04u
M630 U350/XI21-net17 v2 VSS VSS nmos W=0.155u L=0.04u
M631 n404 n405 U350/XI6-net17 VSS nmos W=0.155u L=0.04u
M632 U350/XI6-net17 n321 VSS VSS nmos W=0.155u L=0.04u
M633 n404 n319 U350/XI20-net17 VSS nmos W=0.155u L=0.04u
M634 U350/XI20-net17 n328 VSS VSS nmos W=0.155u L=0.04u
M635 VDD n406 U350/net22 VDD pmos W=0.205u L=0.04u
M636 VDD v2 U350/net22 VDD pmos W=0.205u L=0.04u
M637 U350/net16 n405 n404 VDD pmos W=0.205u L=0.04u
M638 U350/net16 n321 n404 VDD pmos W=0.205u L=0.04u
M639 U350/net22 n319 U350/net16 VDD pmos W=0.205u L=0.04u
M640 U350/net22 n328 U350/net16 VDD pmos W=0.205u L=0.04u
M641 n319 n301 VSS VSS nmos W=0.155u L=0.04u
M642 n319 n407 VSS VSS nmos W=0.155u L=0.04u
M643 U351/XI1-net8 n407 VDD VDD pmos W=0.205u L=0.04u
M644 n319 n301 U351/XI1-net8 VDD pmos W=0.205u L=0.04u
M645 U352/XU1-net6 n296 VSS VSS nmos W=0.155u L=0.04u
M646 n405 n408 U352/XU1-net6 VSS nmos W=0.155u L=0.04u
M647 n405 n296 VDD VDD pmos W=0.155u L=0.04u
M648 n405 n408 VDD VDD pmos W=0.155u L=0.04u
M649 n296 n284 U353/net27 VSS nmos W=0.155u L=0.04u
M650 U353/net27 n277 VSS VSS nmos W=0.155u L=0.04u
M651 n296 n406 VSS VSS nmos W=0.155u L=0.04u
M652 n296 n277 U353/net13 VDD pmos W=0.205u L=0.04u
M653 U353/net13 n406 VDD VDD pmos W=0.205u L=0.04u
M654 n296 n284 U353/net13 VDD pmos W=0.205u L=0.04u
M655 n408 v0 U354/net23 VDD pmos W=0.205u L=0.04u
M656 n408 n384 U354/net23 VDD pmos W=0.205u L=0.04u
M657 n408 n366 U354/net23 VDD pmos W=0.205u L=0.04u
M658 U354/net23 n332 VDD VDD pmos W=0.205u L=0.04u
M659 U354/net23 n339 VDD VDD pmos W=0.205u L=0.04u
M660 U354/XI20-net13 n384 VSS VSS nmos W=0.155u L=0.04u
M661 n408 v0 U354/XI20-net17 VSS nmos W=0.155u L=0.04u
M662 U354/XI20-net17 n366 U354/XI20-net13 VSS nmos W=0.155u L=0.04u
M663 n408 n332 U354/XI17-net17 VSS nmos W=0.155u L=0.04u
M664 U354/XI17-net17 n339 VSS VSS nmos W=0.155u L=0.04u
M665 n332 n306 VSS VSS nmos W=0.155u L=0.04u
M666 n332 n302 VSS VSS nmos W=0.155u L=0.04u
M667 U355/XI1-net8 n302 VDD VDD pmos W=0.205u L=0.04u
M668 n332 n306 U355/XI1-net8 VDD pmos W=0.205u L=0.04u
M669 n403 n338 U356/net23 VDD pmos W=0.205u L=0.04u
M670 n403 n409 U356/net23 VDD pmos W=0.205u L=0.04u
M671 n403 n284 U356/net23 VDD pmos W=0.205u L=0.04u
M672 U356/net23 n314 VDD VDD pmos W=0.205u L=0.04u
M673 U356/net23 n410 VDD VDD pmos W=0.205u L=0.04u
M674 U356/XI20-net13 n409 VSS VSS nmos W=0.155u L=0.04u
M675 n403 n338 U356/XI20-net17 VSS nmos W=0.155u L=0.04u
M676 U356/XI20-net17 n284 U356/XI20-net13 VSS nmos W=0.155u L=0.04u
M677 n403 n314 U356/XI17-net17 VSS nmos W=0.155u L=0.04u
M678 U356/XI17-net17 n410 VSS VSS nmos W=0.155u L=0.04u
M679 n410 n306 U357/net10 VSS nmos W=0.155u L=0.04u
M680 U357/net10 n411 VSS VSS nmos W=0.155u L=0.04u
M681 n410 n339 U357/net10 VSS nmos W=0.155u L=0.04u
M682 U357/net10 v12 VSS VSS nmos W=0.155u L=0.04u
M683 U357/net30 n411 VDD VDD pmos W=0.205u L=0.04u
M684 n410 n306 U357/net24 VDD pmos W=0.205u L=0.04u
M685 U357/net24 n339 VDD VDD pmos W=0.205u L=0.04u
M686 n410 v12 U357/net30 VDD pmos W=0.205u L=0.04u
M687 n411 n383 VSS VSS nmos W=0.155u L=0.04u
M688 n411 n262 U358/XI17-net17 VSS nmos W=0.155u L=0.04u
M689 U358/XI17-net17 n331 VSS VSS nmos W=0.155u L=0.04u
M690 n411 v3 U358/XI10-net17 VSS nmos W=0.155u L=0.04u
M691 U358/XI10-net17 v8 VSS VSS nmos W=0.155u L=0.04u
M692 U358/net30 v3 n411 VDD pmos W=0.205u L=0.04u
M693 U358/net30 v8 n411 VDD pmos W=0.205u L=0.04u
M694 VDD n383 U358/net36 VDD pmos W=0.205u L=0.04u
M695 U358/net36 n331 U358/net30 VDD pmos W=0.205u L=0.04u
M696 U358/net36 n262 U358/net30 VDD pmos W=0.205u L=0.04u
M697 U359/net19 n279 VSS VSS nmos W=0.155u L=0.04u
M698 n402 n279 U359/net40 VSS nmos W=0.155u L=0.04u
M699 n402 U359/net19 U359/net36 VSS nmos W=0.155u L=0.04u
M700 U359/net40 n317 VSS VSS nmos W=0.31u L=0.04u
M701 U359/net36 n412 VSS VSS nmos W=0.155u L=0.04u
M702 U359/net19 n279 VDD VDD pmos W=0.205u L=0.04u
M703 n402 U359/net19 U359/net26 VDD pmos W=0.325u L=0.04u
M704 U359/net26 n317 VDD VDD pmos W=0.41u L=0.04u
M705 n402 n279 U359/net30 VDD pmos W=0.325u L=0.04u
M706 U359/net30 n412 VDD VDD pmos W=0.205u L=0.04u
M707 n412 n413 VSS VSS nmos W=0.155u L=0.04u
M708 n412 n287 VSS VSS nmos W=0.155u L=0.04u
M709 U360/XI1-net8 n287 VDD VDD pmos W=0.205u L=0.04u
M710 n412 n413 U360/XI1-net8 VDD pmos W=0.205u L=0.04u
M711 n287 n338 VSS VSS nmos W=0.135u L=0.04u
M712 n287 n338 VDD VDD pmos W=0.205u L=0.04u
M713 n398 v11 U362/net19 VDD pmos W=0.205u L=0.04u
M714 n398 n414 U362/net19 VDD pmos W=0.205u L=0.04u
M715 n398 n280 U362/net19 VDD pmos W=0.205u L=0.04u
M716 U362/net19 n415 VDD VDD pmos W=0.205u L=0.04u
M717 n398 n415 VSS VSS nmos W=0.155u L=0.04u
M718 U362/XI20-net13 n414 VSS VSS nmos W=0.155u L=0.04u
M719 n398 v11 U362/XI20-net17 VSS nmos W=0.155u L=0.04u
M720 U362/XI20-net17 n280 U362/XI20-net13 VSS nmos W=0.155u L=0.04u
M721 U363/net29 n301 VSS VSS nmos W=0.155u L=0.04u
M722 n397 n282 U363/net29 VSS nmos W=0.155u L=0.04u
M723 n397 n416 U363/net23 VSS nmos W=0.155u L=0.04u
M724 U363/net23 n365 VSS VSS nmos W=0.155u L=0.04u
M725 U363/net20 n365 n397 VDD pmos W=0.205u L=0.04u
M726 U363/net20 n416 n397 VDD pmos W=0.205u L=0.04u
M727 VDD n282 U363/net20 VDD pmos W=0.205u L=0.04u
M728 VDD n301 U363/net20 VDD pmos W=0.205u L=0.04u
M729 n416 U364/net26 VDD VDD pmos W=0.205u L=0.04u
M730 U364/net26 v12 U364/net19 VDD pmos W=0.205u L=0.04u
M731 U364/net26 n376 U364/net19 VDD pmos W=0.205u L=0.04u
M732 U364/net26 n395 U364/net19 VDD pmos W=0.205u L=0.04u
M733 U364/net19 n417 VDD VDD pmos W=0.205u L=0.04u
M734 U364/net26 n417 VSS VSS nmos W=0.155u L=0.04u
M735 n416 U364/net26 VSS VSS nmos W=0.155u L=0.04u
M736 U364/XI20-net13 n395 VSS VSS nmos W=0.155u L=0.04u
M737 U364/net26 v12 U364/XI20-net17 VSS nmos W=0.155u L=0.04u
M738 U364/XI20-net17 n376 U364/XI20-net13 VSS nmos W=0.155u L=0.04u
M739 U365/net36 n418 U365/net24 VSS nmos W=0.155u L=0.04u
M740 U365/net24 n419 VSS VSS nmos W=0.155u L=0.04u
M741 Av13_D_24B n300 U365/net36 VSS nmos W=0.155u L=0.04u
M742 Av13_D_24B n291 U365/net36 VSS nmos W=0.155u L=0.04u
M743 Av13_D_24B n291 U365/net35 VDD pmos W=0.205u L=0.04u
M744 U365/net35 n300 VDD VDD pmos W=0.205u L=0.04u
M745 Av13_D_24B n419 VDD VDD pmos W=0.205u L=0.04u
M746 Av13_D_24B n418 VDD VDD pmos W=0.205u L=0.04u
M747 U366/net11 n420 n419 VDD pmos W=0.205u L=0.04u
M748 U366/net11 n318 n419 VDD pmos W=0.205u L=0.04u
M749 U366/net11 n421 U366/XI16-net11 VDD pmos W=0.205u L=0.04u
M750 U366/XI16-net11 n422 VDD VDD pmos W=0.205u L=0.04u
M751 n419 n422 VSS VSS nmos W=0.155u L=0.04u
M752 n419 n421 VSS VSS nmos W=0.155u L=0.04u
M753 n419 n420 U366/XI12-net17 VSS nmos W=0.155u L=0.04u
M754 U366/XI12-net17 n318 VSS VSS nmos W=0.155u L=0.04u
M755 VSS n423 U367/net22 VSS nmos W=0.155u L=0.04u
M756 U367/net22 n300 n420 VSS nmos W=0.155u L=0.04u
M757 U367/net22 v11 n420 VSS nmos W=0.155u L=0.04u
M758 U367/net22 n330 n420 VSS nmos W=0.155u L=0.04u
M759 U367/net38 n330 VDD VDD pmos W=0.205u L=0.04u
M760 U367/net35 v11 U367/net38 VDD pmos W=0.205u L=0.04u
M761 n420 n300 U367/net35 VDD pmos W=0.205u L=0.04u
M762 n420 n423 VDD VDD pmos W=0.205u L=0.04u
M763 U368/net40 n391 n423 VDD pmos W=0.205u L=0.04u
M764 U368/net40 n346 n423 VDD pmos W=0.205u L=0.04u
M765 VDD n304 U368/net40 VDD pmos W=0.205u L=0.04u
M766 VDD n263 U368/net40 VDD pmos W=0.205u L=0.04u
M767 U368/net40 n424 n423 VDD pmos W=0.205u L=0.04u
M768 VDD n303 U368/net40 VDD pmos W=0.205u L=0.04u
M769 U368/XI13-net13 n424 VSS VSS nmos W=0.155u L=0.04u
M770 n423 n346 U368/XI13-net17 VSS nmos W=0.155u L=0.04u
M771 U368/XI13-net17 n391 U368/XI13-net13 VSS nmos W=0.155u L=0.04u
M772 U368/XI7-net13 n304 VSS VSS nmos W=0.155u L=0.04u
M773 n423 n263 U368/XI7-net17 VSS nmos W=0.155u L=0.04u
M774 U368/XI7-net17 n303 U368/XI7-net13 VSS nmos W=0.155u L=0.04u
M775 U369/net29 n263 VSS VSS nmos W=0.155u L=0.04u
M776 n418 n426 U369/net29 VSS nmos W=0.155u L=0.04u
M777 n418 v7 U369/net23 VSS nmos W=0.155u L=0.04u
M778 U369/net23 n425 VSS VSS nmos W=0.155u L=0.04u
M779 U369/net20 n425 n418 VDD pmos W=0.205u L=0.04u
M780 U369/net20 v7 n418 VDD pmos W=0.205u L=0.04u
M781 VDD n426 U369/net20 VDD pmos W=0.205u L=0.04u
M782 VDD n263 U369/net20 VDD pmos W=0.205u L=0.04u
M783 U370/XU1-net6 n428 VSS VSS nmos W=0.155u L=0.04u
M784 n425 n427 U370/XU1-net6 VSS nmos W=0.155u L=0.04u
M785 n425 n428 VDD VDD pmos W=0.155u L=0.04u
M786 n425 n427 VDD VDD pmos W=0.155u L=0.04u
M787 U371/p2 n391 VSS VSS nmos W=0.155u L=0.04u
M788 U371/p0 n338 U371/p1 VSS nmos W=0.155u L=0.04u
M789 U371/p1 n303 U371/p2 VSS nmos W=0.155u L=0.04u
M790 n428 n429 U371/p0 VSS nmos W=0.155u L=0.04u
M791 n428 n303 VDD VDD pmos W=0.205u L=0.04u
M792 n428 n338 VDD VDD pmos W=0.205u L=0.04u
M793 n428 n429 VDD VDD pmos W=0.205u L=0.04u
M794 n428 n391 VDD VDD pmos W=0.205u L=0.04u
M795 n338 n321 VSS VSS nmos W=0.155u L=0.04u
M796 n338 v10 VSS VSS nmos W=0.155u L=0.04u
M797 U372/XI1-net8 v10 VDD VDD pmos W=0.205u L=0.04u
M798 n338 n321 U372/XI1-net8 VDD pmos W=0.205u L=0.04u
M799 U373/net19 n407 VSS VSS nmos W=0.155u L=0.04u
M800 n427 n407 U373/net40 VSS nmos W=0.155u L=0.04u
M801 n427 U373/net19 U373/net36 VSS nmos W=0.155u L=0.04u
M802 U373/net40 n431 VSS VSS nmos W=0.31u L=0.04u
M803 U373/net36 n430 VSS VSS nmos W=0.155u L=0.04u
M804 U373/net19 n407 VDD VDD pmos W=0.205u L=0.04u
M805 n427 U373/net19 U373/net26 VDD pmos W=0.325u L=0.04u
M806 U373/net26 n431 VDD VDD pmos W=0.41u L=0.04u
M807 n427 n407 U373/net30 VDD pmos W=0.325u L=0.04u
M808 U373/net30 n430 VDD VDD pmos W=0.205u L=0.04u
M809 n431 v10 VSS VSS nmos W=0.155u L=0.04u
M810 n431 n281 VSS VSS nmos W=0.155u L=0.04u
M811 U374/XI1-net8 n281 VDD VDD pmos W=0.205u L=0.04u
M812 n431 v10 U374/XI1-net8 VDD pmos W=0.205u L=0.04u
M813 Av13_D_23B n432 U375/net27 VSS nmos W=0.155u L=0.04u
M814 U375/net27 n433 VSS VSS nmos W=0.155u L=0.04u
M815 Av13_D_23B n289 VSS VSS nmos W=0.155u L=0.04u
M816 Av13_D_23B n433 U375/net13 VDD pmos W=0.205u L=0.04u
M817 U375/net13 n289 VDD VDD pmos W=0.205u L=0.04u
M818 Av13_D_23B n432 U375/net13 VDD pmos W=0.205u L=0.04u
M819 U376/XU1-net6 v10 VSS VSS nmos W=0.155u L=0.04u
M820 n433 n394 U376/XU1-net6 VSS nmos W=0.155u L=0.04u
M821 n433 v10 VDD VDD pmos W=0.155u L=0.04u
M822 n433 n394 VDD VDD pmos W=0.155u L=0.04u
M823 U377/net40 n288 n432 VDD pmos W=0.205u L=0.04u
M824 U377/net40 n314 n432 VDD pmos W=0.205u L=0.04u
M825 VDD n356 U377/net40 VDD pmos W=0.205u L=0.04u
M826 VDD n346 U377/net40 VDD pmos W=0.205u L=0.04u
M827 U377/net40 v6 n432 VDD pmos W=0.205u L=0.04u
M828 VDD v0 U377/net40 VDD pmos W=0.205u L=0.04u
M829 U377/XI13-net13 v6 VSS VSS nmos W=0.155u L=0.04u
M830 n432 n314 U377/XI13-net17 VSS nmos W=0.155u L=0.04u
M831 U377/XI13-net17 n288 U377/XI13-net13 VSS nmos W=0.155u L=0.04u
M832 U377/XI7-net13 n356 VSS VSS nmos W=0.155u L=0.04u
M833 n432 n346 U377/XI7-net17 VSS nmos W=0.155u L=0.04u
M834 U377/XI7-net17 v0 U377/XI7-net13 VSS nmos W=0.155u L=0.04u
M835 U378/net36 n434 U378/net24 VSS nmos W=0.155u L=0.04u
M836 U378/net24 n435 VSS VSS nmos W=0.155u L=0.04u
M837 Av13_D_22B n311 U378/net36 VSS nmos W=0.155u L=0.04u
M838 Av13_D_22B n353 U378/net36 VSS nmos W=0.155u L=0.04u
M839 Av13_D_22B n353 U378/net35 VDD pmos W=0.205u L=0.04u
M840 U378/net35 n311 VDD VDD pmos W=0.205u L=0.04u
M841 Av13_D_22B n435 VDD VDD pmos W=0.205u L=0.04u
M842 Av13_D_22B n434 VDD VDD pmos W=0.205u L=0.04u
M843 U379/net14 n374 VSS VSS nmos W=0.155u L=0.04u
M844 U379/net14 n298 VSS VSS nmos W=0.155u L=0.04u
M845 U379/net14 v2 VSS VSS nmos W=0.155u L=0.04u
M846 U379/net14 v7 VSS VSS nmos W=0.155u L=0.04u
M847 n434 U379/net14 VSS VSS nmos W=0.155u L=0.04u
M848 U379/net14 v7 U379/XU8-net7 VDD pmos W=0.205u L=0.04u
M849 U379/XU8-net7 v2 U379/XU8-net10 VDD pmos W=0.205u L=0.04u
M850 U379/XU8-net10 n298 U379/XU8-net13 VDD pmos W=0.205u L=0.04u
M851 U379/XU8-net13 n374 VDD VDD pmos W=0.205u L=0.04u
M852 n434 U379/net14 VDD VDD pmos W=0.205u L=0.04u
M853 VSS n437 U380/net22 VSS nmos W=0.155u L=0.04u
M854 U380/net22 n374 Av13_D_21B VSS nmos W=0.155u L=0.04u
M855 U380/net22 n391 Av13_D_21B VSS nmos W=0.155u L=0.04u
M856 U380/net22 n436 Av13_D_21B VSS nmos W=0.155u L=0.04u
M857 U380/net38 n436 VDD VDD pmos W=0.205u L=0.04u
M858 U380/net35 n391 U380/net38 VDD pmos W=0.205u L=0.04u
M859 Av13_D_21B n374 U380/net35 VDD pmos W=0.205u L=0.04u
M860 Av13_D_21B n437 VDD VDD pmos W=0.205u L=0.04u
M861 n436 n424 VSS VSS nmos W=0.135u L=0.04u
M862 n436 n424 VDD VDD pmos W=0.205u L=0.04u
M863 U382/net7 n350 U382/X_u4-net10 VSS nmos W=0.155u L=0.04u
M864 U382/X_u4-net10 n424 U382/X_u4-net13 VSS nmos W=0.155u L=0.04u
M865 U382/X_u4-net13 n352 VSS VSS nmos W=0.155u L=0.04u
M866 Av13_D_20B U382/net7 VSS VSS nmos W=0.155u L=0.04u
M867 U382/net7 n352 VDD VDD pmos W=0.205u L=0.04u
M868 U382/net7 n350 VDD VDD pmos W=0.205u L=0.04u
M869 U382/net7 n424 VDD VDD pmos W=0.205u L=0.04u
M870 Av13_D_20B U382/net7 VDD VDD pmos W=0.205u L=0.04u
M871 n350 n365 VSS VSS nmos W=0.155u L=0.04u
M872 n350 n302 VSS VSS nmos W=0.155u L=0.04u
M873 n350 n393 VSS VSS nmos W=0.155u L=0.04u
M874 U383/net25 n365 VDD VDD pmos W=0.41u L=0.04u
M875 U383/net28 n302 U383/net25 VDD pmos W=0.41u L=0.04u
M876 n350 n393 U383/net28 VDD pmos W=0.41u L=0.04u
M877 U384/p2 n440 VSS VSS nmos W=0.155u L=0.04u
M878 U384/p0 n324 U384/p1 VSS nmos W=0.155u L=0.04u
M879 U384/p1 n439 U384/p2 VSS nmos W=0.155u L=0.04u
M880 Av13_D_1B n438 U384/p0 VSS nmos W=0.155u L=0.04u
M881 Av13_D_1B n439 VDD VDD pmos W=0.205u L=0.04u
M882 Av13_D_1B n324 VDD VDD pmos W=0.205u L=0.04u
M883 Av13_D_1B n438 VDD VDD pmos W=0.205u L=0.04u
M884 Av13_D_1B n440 VDD VDD pmos W=0.205u L=0.04u
M885 n440 v8 U385/net23 VDD pmos W=0.205u L=0.04u
M886 n440 n430 U385/net23 VDD pmos W=0.205u L=0.04u
M887 n440 n391 U385/net23 VDD pmos W=0.205u L=0.04u
M888 U385/net23 n282 VDD VDD pmos W=0.205u L=0.04u
M889 U385/net23 n441 VDD VDD pmos W=0.205u L=0.04u
M890 U385/XI20-net13 n430 VSS VSS nmos W=0.155u L=0.04u
M891 n440 v8 U385/XI20-net17 VSS nmos W=0.155u L=0.04u
M892 U385/XI20-net17 n391 U385/XI20-net13 VSS nmos W=0.155u L=0.04u
M893 n440 n282 U385/XI17-net17 VSS nmos W=0.155u L=0.04u
M894 U385/XI17-net17 n441 VSS VSS nmos W=0.155u L=0.04u
M895 n441 n365 U386/net15 VSS nmos W=0.155u L=0.04u
M896 n441 n374 U386/net15 VSS nmos W=0.155u L=0.04u
M897 U386/net15 n322 VSS VSS nmos W=0.155u L=0.04u
M898 n441 n322 VDD VDD pmos W=0.205u L=0.04u
M899 n441 n365 U386/XI16-net11 VDD pmos W=0.205u L=0.04u
M900 U386/XI16-net11 n374 VDD VDD pmos W=0.205u L=0.04u
M901 U387/net29 n444 VSS VSS nmos W=0.155u L=0.04u
M902 n439 n360 U387/net29 VSS nmos W=0.155u L=0.04u
M903 n439 n442 U387/net23 VSS nmos W=0.155u L=0.04u
M904 U387/net23 n443 VSS VSS nmos W=0.155u L=0.04u
M905 U387/net20 n443 n439 VDD pmos W=0.205u L=0.04u
M906 U387/net20 n442 n439 VDD pmos W=0.205u L=0.04u
M907 VDD n360 U387/net20 VDD pmos W=0.205u L=0.04u
M908 VDD n444 U387/net20 VDD pmos W=0.205u L=0.04u
M909 U388/net36 n343 U388/net24 VSS nmos W=0.155u L=0.04u
M910 U388/net24 n261 VSS VSS nmos W=0.155u L=0.04u
M911 n444 n345 U388/net36 VSS nmos W=0.155u L=0.04u
M912 n444 n322 U388/net36 VSS nmos W=0.155u L=0.04u
M913 n444 n322 U388/net35 VDD pmos W=0.205u L=0.04u
M914 U388/net35 n345 VDD VDD pmos W=0.205u L=0.04u
M915 n444 n261 VDD VDD pmos W=0.205u L=0.04u
M916 n444 n343 VDD VDD pmos W=0.205u L=0.04u
M917 n324 n430 U389/net19 VDD pmos W=0.205u L=0.04u
M918 n324 v7 U389/net19 VDD pmos W=0.205u L=0.04u
M919 n324 v9 U389/net19 VDD pmos W=0.205u L=0.04u
M920 U389/net19 n358 VDD VDD pmos W=0.205u L=0.04u
M921 n324 n358 VSS VSS nmos W=0.155u L=0.04u
M922 U389/XI20-net13 v7 VSS VSS nmos W=0.155u L=0.04u
M923 n324 n430 U389/XI20-net17 VSS nmos W=0.155u L=0.04u
M924 U389/XI20-net17 v9 U389/XI20-net13 VSS nmos W=0.155u L=0.04u
M925 n358 n264 VSS VSS nmos W=0.135u L=0.04u
M926 n358 n264 VDD VDD pmos W=0.205u L=0.04u
M927 U391/net29 n310 VSS VSS nmos W=0.155u L=0.04u
M928 n438 n446 U391/net29 VSS nmos W=0.155u L=0.04u
M929 n438 n395 U391/net23 VSS nmos W=0.155u L=0.04u
M930 U391/net23 n445 VSS VSS nmos W=0.155u L=0.04u
M931 U391/net20 n445 n438 VDD pmos W=0.205u L=0.04u
M932 U391/net20 n395 n438 VDD pmos W=0.205u L=0.04u
M933 VDD n446 U391/net20 VDD pmos W=0.205u L=0.04u
M934 VDD n310 U391/net20 VDD pmos W=0.205u L=0.04u
M935 U392/net36 n447 U392/net24 VSS nmos W=0.155u L=0.04u
M936 U392/net24 n448 VSS VSS nmos W=0.155u L=0.04u
M937 n446 n267 U392/net36 VSS nmos W=0.155u L=0.04u
M938 n446 n334 U392/net36 VSS nmos W=0.155u L=0.04u
M939 n446 n334 U392/net35 VDD pmos W=0.205u L=0.04u
M940 U392/net35 n267 VDD VDD pmos W=0.205u L=0.04u
M941 n446 n448 VDD VDD pmos W=0.205u L=0.04u
M942 n446 n447 VDD VDD pmos W=0.205u L=0.04u
M943 U393/net11 n449 n448 VDD pmos W=0.205u L=0.04u
M944 U393/net11 n284 n448 VDD pmos W=0.205u L=0.04u
M945 U393/net11 n394 U393/XI16-net11 VDD pmos W=0.205u L=0.04u
M946 U393/XI16-net11 n383 VDD VDD pmos W=0.205u L=0.04u
M947 n448 n383 VSS VSS nmos W=0.155u L=0.04u
M948 n448 n394 VSS VSS nmos W=0.155u L=0.04u
M949 n448 n449 U393/XI12-net17 VSS nmos W=0.155u L=0.04u
M950 U393/XI12-net17 n284 VSS VSS nmos W=0.155u L=0.04u
M951 n383 n391 VSS VSS nmos W=0.155u L=0.04u
M952 n383 n334 VSS VSS nmos W=0.155u L=0.04u
M953 U394/XI1-net8 n334 VDD VDD pmos W=0.205u L=0.04u
M954 n383 n391 U394/XI1-net8 VDD pmos W=0.205u L=0.04u
M955 n449 v10 VSS VSS nmos W=0.155u L=0.04u
M956 n449 n409 VSS VSS nmos W=0.155u L=0.04u
M957 U395/XI1-net8 n409 VDD VDD pmos W=0.205u L=0.04u
M958 n449 v10 U395/XI1-net8 VDD pmos W=0.205u L=0.04u
M959 U396/net4 v2 U396/net14 VSS nmos W=0.155u L=0.04u
M960 U396/net6 U396/net10 U396/net14 VSS nmos W=0.17u L=0.04u
M961 U396/net4 v1 VSS VSS nmos W=0.155u L=0.04u
M962 U396/net6 U396/net4 VSS VSS nmos W=0.17u L=0.04u
M963 n409 U396/net14 VSS VSS nmos W=0.155u L=0.04u
M964 U396/net10 v2 VSS VSS nmos W=0.155u L=0.04u
M965 U396/net4 U396/net10 U396/net14 VDD pmos W=0.255u L=0.04u
M966 U396/net6 v2 U396/net14 VDD pmos W=0.28u L=0.04u
M967 U396/net4 v1 VDD VDD pmos W=0.205u L=0.04u
M968 U396/net6 U396/net4 VDD VDD pmos W=0.24u L=0.04u
M969 n409 U396/net14 VDD VDD pmos W=0.205u L=0.04u
M970 U396/net10 v2 VDD VDD pmos W=0.205u L=0.04u
M971 n447 n346 U397/net23 VDD pmos W=0.205u L=0.04u
M972 n447 n413 U397/net23 VDD pmos W=0.205u L=0.04u
M973 n447 v8 U397/net23 VDD pmos W=0.205u L=0.04u
M974 U397/net23 n417 VDD VDD pmos W=0.205u L=0.04u
M975 U397/net23 n277 VDD VDD pmos W=0.205u L=0.04u
M976 U397/XI20-net13 n413 VSS VSS nmos W=0.155u L=0.04u
M977 n447 n346 U397/XI20-net17 VSS nmos W=0.155u L=0.04u
M978 U397/XI20-net17 v8 U397/XI20-net13 VSS nmos W=0.155u L=0.04u
M979 n447 n417 U397/XI17-net17 VSS nmos W=0.155u L=0.04u
M980 U397/XI17-net17 n277 VSS VSS nmos W=0.155u L=0.04u
M981 n413 n339 VSS VSS nmos W=0.155u L=0.04u
M982 n413 v2 VSS VSS nmos W=0.155u L=0.04u
M983 U398/XI1-net8 v2 VDD VDD pmos W=0.205u L=0.04u
M984 n413 n339 U398/XI1-net8 VDD pmos W=0.205u L=0.04u
M985 n334 n262 VSS VSS nmos W=0.135u L=0.04u
M986 n334 n262 VDD VDD pmos W=0.205u L=0.04u
M987 n445 n342 U400/net27 VSS nmos W=0.155u L=0.04u
M988 U400/net39 n393 VSS VSS nmos W=0.155u L=0.04u
M989 U400/net27 n450 U400/net39 VSS nmos W=0.155u L=0.04u
M990 U400/net27 n451 U400/net39 VSS nmos W=0.155u L=0.04u
M991 n445 n353 U400/net27 VSS nmos W=0.155u L=0.04u
M992 U400/net39 v10 VSS VSS nmos W=0.155u L=0.04u
M993 n445 n393 U400/net46 VDD pmos W=0.205u L=0.04u
M994 U400/net46 v10 VDD VDD pmos W=0.205u L=0.04u
M995 n445 n353 U400/net34 VDD pmos W=0.205u L=0.04u
M996 U400/net34 n342 VDD VDD pmos W=0.205u L=0.04u
M997 n445 n451 U400/net37 VDD pmos W=0.205u L=0.04u
M998 U400/net37 n450 VDD VDD pmos W=0.205u L=0.04u
M999 n450 v2 U401/net27 VSS nmos W=0.155u L=0.04u
M1000 U401/net27 n365 VSS VSS nmos W=0.155u L=0.04u
M1001 n450 n279 VSS VSS nmos W=0.155u L=0.04u
M1002 n450 n365 U401/net13 VDD pmos W=0.205u L=0.04u
M1003 U401/net13 n279 VDD VDD pmos W=0.205u L=0.04u
M1004 n450 v2 U401/net13 VDD pmos W=0.205u L=0.04u
M1005 U402/XU1-net6 n365 VSS VSS nmos W=0.155u L=0.04u
M1006 n342 n376 U402/XU1-net6 VSS nmos W=0.155u L=0.04u
M1007 n342 n365 VDD VDD pmos W=0.155u L=0.04u
M1008 n342 n376 VDD VDD pmos W=0.155u L=0.04u
M1009 n353 n276 VSS VSS nmos W=0.135u L=0.04u
M1010 n353 n276 VDD VDD pmos W=0.205u L=0.04u
M1011 VSS n454 U404/net22 VSS nmos W=0.155u L=0.04u
M1012 U404/net22 n390 Av13_D_19B VSS nmos W=0.155u L=0.04u
M1013 U404/net22 n453 Av13_D_19B VSS nmos W=0.155u L=0.04u
M1014 U404/net22 n452 Av13_D_19B VSS nmos W=0.155u L=0.04u
M1015 U404/net38 n452 VDD VDD pmos W=0.205u L=0.04u
M1016 U404/net35 n453 U404/net38 VDD pmos W=0.205u L=0.04u
M1017 Av13_D_19B n390 U404/net35 VDD pmos W=0.205u L=0.04u
M1018 Av13_D_19B n454 VDD VDD pmos W=0.205u L=0.04u
M1019 U405/XU1-net6 n376 VSS VSS nmos W=0.155u L=0.04u
M1020 n390 v3 U405/XU1-net6 VSS nmos W=0.155u L=0.04u
M1021 n390 n376 VDD VDD pmos W=0.155u L=0.04u
M1022 n390 v3 VDD VDD pmos W=0.155u L=0.04u
M1023 U406/XU1-net6 v12 VSS VSS nmos W=0.155u L=0.04u
M1024 n452 n277 U406/XU1-net6 VSS nmos W=0.155u L=0.04u
M1025 n452 v12 VDD VDD pmos W=0.155u L=0.04u
M1026 n452 n277 VDD VDD pmos W=0.155u L=0.04u
M1027 U407/XU1-net6 n455 VSS VSS nmos W=0.155u L=0.04u
M1028 Av13_D_18B n437 U407/XU1-net6 VSS nmos W=0.155u L=0.04u
M1029 Av13_D_18B n455 VDD VDD pmos W=0.155u L=0.04u
M1030 Av13_D_18B n437 VDD VDD pmos W=0.155u L=0.04u
M1031 n455 v4 U408/net10 VSS nmos W=0.155u L=0.04u
M1032 U408/net10 n305 VSS VSS nmos W=0.155u L=0.04u
M1033 n455 v5 U408/net10 VSS nmos W=0.155u L=0.04u
M1034 U408/net10 n456 VSS VSS nmos W=0.155u L=0.04u
M1035 U408/net30 n305 VDD VDD pmos W=0.205u L=0.04u
M1036 n455 v4 U408/net24 VDD pmos W=0.205u L=0.04u
M1037 U408/net24 v5 VDD VDD pmos W=0.205u L=0.04u
M1038 n455 n456 U408/net30 VDD pmos W=0.205u L=0.04u
M1039 n456 n283 VSS VSS nmos W=0.155u L=0.04u
M1040 n456 n281 VSS VSS nmos W=0.155u L=0.04u
M1041 n456 n289 VSS VSS nmos W=0.155u L=0.04u
M1042 n456 v0 VSS VSS nmos W=0.155u L=0.04u
M1043 U409/net49 n281 U409/net52 VDD pmos W=0.41u L=0.04u
M1044 U409/net52 n283 VDD VDD pmos W=0.41u L=0.04u
M1045 U409/net46 n289 U409/net49 VDD pmos W=0.41u L=0.04u
M1046 n456 v0 U409/net46 VDD pmos W=0.41u L=0.04u
M1047 U410/p2 n458 VSS VSS nmos W=0.155u L=0.04u
M1048 U410/p0 n293 U410/p1 VSS nmos W=0.155u L=0.04u
M1049 U410/p1 n457 U410/p2 VSS nmos W=0.155u L=0.04u
M1050 Av13_D_17B n437 U410/p0 VSS nmos W=0.155u L=0.04u
M1051 Av13_D_17B n457 VDD VDD pmos W=0.205u L=0.04u
M1052 Av13_D_17B n293 VDD VDD pmos W=0.205u L=0.04u
M1053 Av13_D_17B n437 VDD VDD pmos W=0.205u L=0.04u
M1054 Av13_D_17B n458 VDD VDD pmos W=0.205u L=0.04u
M1055 U411/net29 n460 VSS VSS nmos W=0.155u L=0.04u
M1056 n458 n346 U411/net29 VSS nmos W=0.155u L=0.04u
M1057 n458 v2 U411/net23 VSS nmos W=0.155u L=0.04u
M1058 U411/net23 n459 VSS VSS nmos W=0.155u L=0.04u
M1059 U411/net20 n459 n458 VDD pmos W=0.205u L=0.04u
M1060 U411/net20 v2 n458 VDD pmos W=0.205u L=0.04u
M1061 VDD n346 U411/net20 VDD pmos W=0.205u L=0.04u
M1062 VDD n460 U411/net20 VDD pmos W=0.205u L=0.04u
M1063 n460 n391 U412/net14 VSS nmos W=0.155u L=0.04u
M1064 U412/net14 n280 VSS VSS nmos W=0.155u L=0.04u
M1065 U412/net14 n461 VSS VSS nmos W=0.155u L=0.04u
M1066 n460 n310 U412/net14 VSS nmos W=0.155u L=0.04u
M1067 n460 v10 U412/net14 VSS nmos W=0.155u L=0.04u
M1068 n460 n280 U412/XI16-net11 VDD pmos W=0.205u L=0.04u
M1069 U412/XI16-net11 n461 VDD VDD pmos W=0.205u L=0.04u
M1070 n460 n310 U412/XI15-net11 VDD pmos W=0.205u L=0.04u
M1071 U412/XI15-net11 v10 U412/XI15-net18 VDD pmos W=0.205u L=0.04u
M1072 U412/XI15-net18 n391 VDD VDD pmos W=0.205u L=0.04u
M1073 n461 n303 U413/net27 VSS nmos W=0.155u L=0.04u
M1074 U413/net27 n310 VSS VSS nmos W=0.155u L=0.04u
M1075 n461 v9 VSS VSS nmos W=0.155u L=0.04u
M1076 n461 n310 U413/net13 VDD pmos W=0.205u L=0.04u
M1077 U413/net13 v9 VDD VDD pmos W=0.205u L=0.04u
M1078 n461 n303 U413/net13 VDD pmos W=0.205u L=0.04u
M1079 U414/net32 n414 VSS VSS nmos W=0.155u L=0.04u
M1080 U414/net59 n263 U414/net32 VSS nmos W=0.155u L=0.04u
M1081 U414/net59 n401 VSS VSS nmos W=0.155u L=0.04u
M1082 n459 U414/net59 VSS VSS nmos W=0.155u L=0.04u
M1083 n459 U414/net59 VDD VDD pmos W=0.2u L=0.04u
M1084 U414/net59 n263 U414/net22 VDD pmos W=0.205u L=0.04u
M1085 U414/net59 n414 U414/net22 VDD pmos W=0.205u L=0.04u
M1086 U414/net22 n401 VDD VDD pmos W=0.2u L=0.04u
M1087 n293 n462 VSS VSS nmos W=0.135u L=0.04u
M1088 n293 n462 VDD VDD pmos W=0.205u L=0.04u
M1089 n437 n314 U416/XI0-net10 VSS nmos W=0.155u L=0.04u
M1090 U416/XI0-net10 n304 U416/XI0-net13 VSS nmos W=0.155u L=0.04u
M1091 U416/XI0-net13 n370 VSS VSS nmos W=0.155u L=0.04u
M1092 n437 n370 VDD VDD pmos W=0.205u L=0.04u
M1093 n437 n314 VDD VDD pmos W=0.205u L=0.04u
M1094 n437 n304 VDD VDD pmos W=0.205u L=0.04u
M1095 Av13_D_16B n454 VSS VSS nmos W=0.135u L=0.04u
M1096 Av13_D_16B n454 VDD VDD pmos W=0.205u L=0.04u
M1097 n454 n414 U418/net19 VDD pmos W=0.205u L=0.04u
M1098 n454 n345 U418/net19 VDD pmos W=0.205u L=0.04u
M1099 n454 n284 U418/net19 VDD pmos W=0.205u L=0.04u
M1100 U418/net19 n422 VDD VDD pmos W=0.205u L=0.04u
M1101 n454 n422 VSS VSS nmos W=0.155u L=0.04u
M1102 U418/XI20-net13 n345 VSS VSS nmos W=0.155u L=0.04u
M1103 n454 n414 U418/XI20-net17 VSS nmos W=0.155u L=0.04u
M1104 U418/XI20-net17 n284 U418/XI20-net13 VSS nmos W=0.155u L=0.04u
M1105 n422 U419/net6 VSS VSS nmos W=0.155u L=0.04u
M1106 U419/net6 n424 U419/XU30-net23 VSS nmos W=0.155u L=0.04u
M1107 U419/XU30-net23 v3 U419/XU30-net26 VSS nmos W=0.155u L=0.04u
M1108 U419/XU30-net26 v6 U419/XU30-net29 VSS nmos W=0.155u L=0.04u
M1109 U419/XU30-net29 n267 VSS VSS nmos W=0.155u L=0.04u
M1110 n422 U419/net6 VDD VDD pmos W=0.205u L=0.04u
M1111 U419/net6 n267 VDD VDD pmos W=0.205u L=0.04u
M1112 U419/net6 v6 VDD VDD pmos W=0.205u L=0.04u
M1113 U419/net6 v3 VDD VDD pmos W=0.205u L=0.04u
M1114 U419/net6 n424 VDD VDD pmos W=0.205u L=0.04u
M1115 n424 n407 VSS VSS nmos W=0.155u L=0.04u
M1116 n424 v7 VSS VSS nmos W=0.155u L=0.04u
M1117 U420/XI1-net8 v7 VDD VDD pmos W=0.205u L=0.04u
M1118 n424 n407 U420/XI1-net8 VDD pmos W=0.205u L=0.04u
M1119 n414 n285 VSS VSS nmos W=0.155u L=0.04u
M1120 n414 v9 VSS VSS nmos W=0.155u L=0.04u
M1121 U421/XI1-net8 v9 VDD VDD pmos W=0.205u L=0.04u
M1122 n414 n285 U421/XI1-net8 VDD pmos W=0.205u L=0.04u
M1123 U422/net11 n463 Av13_D_15B VDD pmos W=0.205u L=0.04u
M1124 U422/net11 n464 Av13_D_15B VDD pmos W=0.205u L=0.04u
M1125 U422/net11 n465 U422/XI16-net11 VDD pmos W=0.205u L=0.04u
M1126 U422/XI16-net11 v5 VDD VDD pmos W=0.205u L=0.04u
M1127 Av13_D_15B v5 VSS VSS nmos W=0.155u L=0.04u
M1128 Av13_D_15B n465 VSS VSS nmos W=0.155u L=0.04u
M1129 Av13_D_15B n463 U422/XI12-net17 VSS nmos W=0.155u L=0.04u
M1130 U422/XI12-net17 n464 VSS VSS nmos W=0.155u L=0.04u
M1131 U423/XU1-net6 n443 VSS VSS nmos W=0.155u L=0.04u
M1132 n464 n304 U423/XU1-net6 VSS nmos W=0.155u L=0.04u
M1133 n464 n443 VDD VDD pmos W=0.155u L=0.04u
M1134 n464 n304 VDD VDD pmos W=0.155u L=0.04u
M1135 n443 v0 U424/net15 VSS nmos W=0.155u L=0.04u
M1136 n443 n328 U424/net15 VSS nmos W=0.155u L=0.04u
M1137 U424/net15 n261 VSS VSS nmos W=0.155u L=0.04u
M1138 n443 n261 VDD VDD pmos W=0.205u L=0.04u
M1139 n443 v0 U424/XI16-net11 VDD pmos W=0.205u L=0.04u
M1140 U424/XI16-net11 n328 VDD VDD pmos W=0.205u L=0.04u
M1141 Av13_D_14B n466 U425/XI0-net10 VSS nmos W=0.155u L=0.04u
M1142 U425/XI0-net10 n467 U425/XI0-net13 VSS nmos W=0.155u L=0.04u
M1143 U425/XI0-net13 n468 VSS VSS nmos W=0.155u L=0.04u
M1144 Av13_D_14B n468 VDD VDD pmos W=0.205u L=0.04u
M1145 Av13_D_14B n466 VDD VDD pmos W=0.205u L=0.04u
M1146 Av13_D_14B n467 VDD VDD pmos W=0.205u L=0.04u
M1147 U426/net11 n469 n468 VDD pmos W=0.205u L=0.04u
M1148 U426/net11 n310 n468 VDD pmos W=0.205u L=0.04u
M1149 U426/net11 n415 U426/XI16-net11 VDD pmos W=0.205u L=0.04u
M1150 U426/XI16-net11 n401 VDD VDD pmos W=0.205u L=0.04u
M1151 n468 n401 VSS VSS nmos W=0.155u L=0.04u
M1152 n468 n415 VSS VSS nmos W=0.155u L=0.04u
M1153 n468 n469 U426/XI12-net17 VSS nmos W=0.155u L=0.04u
M1154 U426/XI12-net17 n310 VSS VSS nmos W=0.155u L=0.04u
M1155 n415 n281 VSS VSS nmos W=0.155u L=0.04u
M1156 n415 n356 VSS VSS nmos W=0.155u L=0.04u
M1157 n415 n310 VSS VSS nmos W=0.155u L=0.04u
M1158 U427/net25 n281 VDD VDD pmos W=0.41u L=0.04u
M1159 U427/net28 n356 U427/net25 VDD pmos W=0.41u L=0.04u
M1160 n415 n310 U427/net28 VDD pmos W=0.41u L=0.04u
M1161 U428/net32 n465 VSS VSS nmos W=0.155u L=0.04u
M1162 U428/net59 n318 U428/net32 VSS nmos W=0.155u L=0.04u
M1163 U428/net59 n470 VSS VSS nmos W=0.155u L=0.04u
M1164 n469 U428/net59 VSS VSS nmos W=0.155u L=0.04u
M1165 n469 U428/net59 VDD VDD pmos W=0.2u L=0.04u
M1166 U428/net59 n318 U428/net22 VDD pmos W=0.205u L=0.04u
M1167 U428/net59 n465 U428/net22 VDD pmos W=0.205u L=0.04u
M1168 U428/net22 n470 VDD VDD pmos W=0.2u L=0.04u
M1169 U429/net29 n471 VSS VSS nmos W=0.155u L=0.04u
M1170 n466 n395 U429/net29 VSS nmos W=0.155u L=0.04u
M1171 n466 n417 U429/net23 VSS nmos W=0.155u L=0.04u
M1172 U429/net23 v2 VSS VSS nmos W=0.155u L=0.04u
M1173 U429/net20 v2 n466 VDD pmos W=0.205u L=0.04u
M1174 U429/net20 n417 n466 VDD pmos W=0.205u L=0.04u
M1175 VDD n395 U429/net20 VDD pmos W=0.205u L=0.04u
M1176 VDD n471 U429/net20 VDD pmos W=0.205u L=0.04u
M1177 n417 n321 VSS VSS nmos W=0.155u L=0.04u
M1178 n417 v12 VSS VSS nmos W=0.155u L=0.04u
M1179 U430/XI1-net8 v12 VDD VDD pmos W=0.205u L=0.04u
M1180 n417 n321 U430/XI1-net8 VDD pmos W=0.205u L=0.04u
M1181 U431/p2 n473 VSS VSS nmos W=0.155u L=0.04u
M1182 U431/p0 n264 U431/p1 VSS nmos W=0.155u L=0.04u
M1183 U431/p1 n472 U431/p2 VSS nmos W=0.155u L=0.04u
M1184 Av13_D_13B n435 U431/p0 VSS nmos W=0.155u L=0.04u
M1185 Av13_D_13B n472 VDD VDD pmos W=0.205u L=0.04u
M1186 Av13_D_13B n264 VDD VDD pmos W=0.205u L=0.04u
M1187 Av13_D_13B n435 VDD VDD pmos W=0.205u L=0.04u
M1188 Av13_D_13B n473 VDD VDD pmos W=0.205u L=0.04u
M1189 n473 n475 VSS VSS nmos W=0.155u L=0.04u
M1190 n473 n305 U432/XI17-net17 VSS nmos W=0.155u L=0.04u
M1191 U432/XI17-net17 n370 VSS VSS nmos W=0.155u L=0.04u
M1192 n473 n356 U432/XI10-net17 VSS nmos W=0.155u L=0.04u
M1193 U432/XI10-net17 n474 VSS VSS nmos W=0.155u L=0.04u
M1194 U432/net30 n356 n473 VDD pmos W=0.205u L=0.04u
M1195 U432/net30 n474 n473 VDD pmos W=0.205u L=0.04u
M1196 VDD n475 U432/net36 VDD pmos W=0.205u L=0.04u
M1197 U432/net36 n370 U432/net30 VDD pmos W=0.205u L=0.04u
M1198 U432/net36 n305 U432/net30 VDD pmos W=0.205u L=0.04u
M1199 n475 n476 U433/net10 VSS nmos W=0.155u L=0.04u
M1200 U433/net10 n477 VSS VSS nmos W=0.155u L=0.04u
M1201 n475 n471 U433/net10 VSS nmos W=0.155u L=0.04u
M1202 U433/net10 v7 VSS VSS nmos W=0.155u L=0.04u
M1203 U433/net30 n477 VDD VDD pmos W=0.205u L=0.04u
M1204 n475 n476 U433/net24 VDD pmos W=0.205u L=0.04u
M1205 U433/net24 n471 VDD VDD pmos W=0.205u L=0.04u
M1206 n475 v7 U433/net30 VDD pmos W=0.205u L=0.04u
M1207 n477 n406 VSS VSS nmos W=0.155u L=0.04u
M1208 n477 U434/net4 VSS VSS nmos W=0.155u L=0.04u
M1209 U434/net4 n457 VSS VSS nmos W=0.155u L=0.04u
M1210 U434/XU1-net8 U434/net4 VDD VDD pmos W=0.205u L=0.04u
M1211 n477 n406 U434/XU1-net8 VDD pmos W=0.205u L=0.04u
M1212 U434/net4 n457 VDD VDD pmos W=0.205u L=0.04u
M1213 n406 v9 VSS VSS nmos W=0.155u L=0.04u
M1214 n406 U435/net4 VSS VSS nmos W=0.155u L=0.04u
M1215 U435/net4 n267 VSS VSS nmos W=0.155u L=0.04u
M1216 U435/XU1-net8 U435/net4 VDD VDD pmos W=0.205u L=0.04u
M1217 n406 v9 U435/XU1-net8 VDD pmos W=0.205u L=0.04u
M1218 U435/net4 n267 VDD VDD pmos W=0.205u L=0.04u
M1219 n471 n478 U436/net15 VSS nmos W=0.155u L=0.04u
M1220 n471 n279 U436/net15 VSS nmos W=0.155u L=0.04u
M1221 U436/net15 n366 VSS VSS nmos W=0.155u L=0.04u
M1222 n471 n366 VDD VDD pmos W=0.205u L=0.04u
M1223 n471 n478 U436/XI16-net11 VDD pmos W=0.205u L=0.04u
M1224 U436/XI16-net11 n279 VDD VDD pmos W=0.205u L=0.04u
M1225 n478 v0 VSS VSS nmos W=0.155u L=0.04u
M1226 n478 n302 VSS VSS nmos W=0.155u L=0.04u
M1227 U437/XI1-net8 n302 VDD VDD pmos W=0.205u L=0.04u
M1228 n478 v0 U437/XI1-net8 VDD pmos W=0.205u L=0.04u
M1229 n476 n442 VSS VSS nmos W=0.135u L=0.04u
M1230 n476 n442 VDD VDD pmos W=0.205u L=0.04u
M1231 n474 n479 U439/net26 VSS nmos W=0.155u L=0.04u
M1232 n474 v1 U439/net26 VSS nmos W=0.155u L=0.04u
M1233 U439/net29 n453 VSS VSS nmos W=0.155u L=0.04u
M1234 U439/net26 n321 U439/net29 VSS nmos W=0.155u L=0.04u
M1235 U439/net26 n393 U439/net29 VSS nmos W=0.155u L=0.04u
M1236 n474 v1 U439/net43 VDD pmos W=0.205u L=0.04u
M1237 n474 n393 U439/net49 VDD pmos W=0.205u L=0.04u
M1238 U439/net49 n321 VDD VDD pmos W=0.205u L=0.04u
M1239 U439/net43 n479 VDD VDD pmos W=0.205u L=0.04u
M1240 n474 n453 VDD VDD pmos W=0.205u L=0.04u
M1241 n479 n301 U440/net27 VSS nmos W=0.155u L=0.04u
M1242 U440/net27 n310 VSS VSS nmos W=0.155u L=0.04u
M1243 n479 n315 VSS VSS nmos W=0.155u L=0.04u
M1244 n479 n310 U440/net13 VDD pmos W=0.205u L=0.04u
M1245 U440/net13 n315 VDD VDD pmos W=0.205u L=0.04u
M1246 n479 n301 U440/net13 VDD pmos W=0.205u L=0.04u
M1247 n472 n430 U441/net23 VDD pmos W=0.205u L=0.04u
M1248 n472 v1 U441/net23 VDD pmos W=0.205u L=0.04u
M1249 n472 v9 U441/net23 VDD pmos W=0.205u L=0.04u
M1250 U441/net23 n277 VDD VDD pmos W=0.205u L=0.04u
M1251 U441/net23 n480 VDD VDD pmos W=0.205u L=0.04u
M1252 U441/XI20-net13 v1 VSS VSS nmos W=0.155u L=0.04u
M1253 n472 n430 U441/XI20-net17 VSS nmos W=0.155u L=0.04u
M1254 U441/XI20-net17 v9 U441/XI20-net13 VSS nmos W=0.155u L=0.04u
M1255 n472 n277 U441/XI17-net17 VSS nmos W=0.155u L=0.04u
M1256 U441/XI17-net17 n480 VSS VSS nmos W=0.155u L=0.04u
M1257 n480 n284 U442/net15 VSS nmos W=0.155u L=0.04u
M1258 n480 n285 U442/net15 VSS nmos W=0.155u L=0.04u
M1259 U442/net15 n291 VSS VSS nmos W=0.155u L=0.04u
M1260 n480 n291 VDD VDD pmos W=0.205u L=0.04u
M1261 n480 n284 U442/XI16-net11 VDD pmos W=0.205u L=0.04u
M1262 U442/XI16-net11 n285 VDD VDD pmos W=0.205u L=0.04u
M1263 U443/XU1-net6 n395 VSS VSS nmos W=0.155u L=0.04u
M1264 n291 n284 U443/XU1-net6 VSS nmos W=0.155u L=0.04u
M1265 n291 n395 VDD VDD pmos W=0.155u L=0.04u
M1266 n291 n284 VDD VDD pmos W=0.155u L=0.04u
M1267 n264 v7 U444/XI0-net10 VSS nmos W=0.155u L=0.04u
M1268 U444/XI0-net10 n302 U444/XI0-net13 VSS nmos W=0.155u L=0.04u
M1269 U444/XI0-net13 n481 VSS VSS nmos W=0.155u L=0.04u
M1270 n264 n481 VDD VDD pmos W=0.205u L=0.04u
M1271 n264 v7 VDD VDD pmos W=0.205u L=0.04u
M1272 n264 n302 VDD VDD pmos W=0.205u L=0.04u
M1273 U445/XU1-net6 n260 VSS VSS nmos W=0.155u L=0.04u
M1274 n435 n267 U445/XU1-net6 VSS nmos W=0.155u L=0.04u
M1275 n435 n260 VDD VDD pmos W=0.155u L=0.04u
M1276 n435 n267 VDD VDD pmos W=0.155u L=0.04u
M1277 U446/net36 n482 U446/net24 VSS nmos W=0.155u L=0.04u
M1278 U446/net24 n483 VSS VSS nmos W=0.155u L=0.04u
M1279 Av13_D_12B n311 U446/net36 VSS nmos W=0.155u L=0.04u
M1280 Av13_D_12B n343 U446/net36 VSS nmos W=0.155u L=0.04u
M1281 Av13_D_12B n343 U446/net35 VDD pmos W=0.205u L=0.04u
M1282 U446/net35 n311 VDD VDD pmos W=0.205u L=0.04u
M1283 Av13_D_12B n483 VDD VDD pmos W=0.205u L=0.04u
M1284 Av13_D_12B n482 VDD VDD pmos W=0.205u L=0.04u
M1285 U447/net11 n442 n483 VDD pmos W=0.205u L=0.04u
M1286 U447/net11 n277 n483 VDD pmos W=0.205u L=0.04u
M1287 U447/net11 n421 U447/XI16-net11 VDD pmos W=0.205u L=0.04u
M1288 U447/XI16-net11 n401 VDD VDD pmos W=0.205u L=0.04u
M1289 n483 n401 VSS VSS nmos W=0.155u L=0.04u
M1290 n483 n421 VSS VSS nmos W=0.155u L=0.04u
M1291 n483 n442 U447/XI12-net17 VSS nmos W=0.155u L=0.04u
M1292 U447/XI12-net17 n277 VSS VSS nmos W=0.155u L=0.04u
M1293 n401 n285 VSS VSS nmos W=0.155u L=0.04u
M1294 n401 v12 VSS VSS nmos W=0.155u L=0.04u
M1295 U448/XI1-net8 v12 VDD VDD pmos W=0.205u L=0.04u
M1296 n401 n285 U448/XI1-net8 VDD pmos W=0.205u L=0.04u
M1297 n421 n451 VSS VSS nmos W=0.155u L=0.04u
M1298 n421 v9 VSS VSS nmos W=0.155u L=0.04u
M1299 n421 n453 VSS VSS nmos W=0.155u L=0.04u
M1300 U449/net25 n451 VDD VDD pmos W=0.41u L=0.04u
M1301 U449/net28 v9 U449/net25 VDD pmos W=0.41u L=0.04u
M1302 n421 n453 U449/net28 VDD pmos W=0.41u L=0.04u
M1303 n451 n317 VSS VSS nmos W=0.135u L=0.04u
M1304 n451 n317 VDD VDD pmos W=0.205u L=0.04u
M1305 n453 n484 VSS VSS nmos W=0.135u L=0.04u
M1306 n453 n484 VDD VDD pmos W=0.205u L=0.04u
M1307 n442 n339 VSS VSS nmos W=0.155u L=0.04u
M1308 n442 n330 VSS VSS nmos W=0.155u L=0.04u
M1309 U452/XI1-net8 n330 VDD VDD pmos W=0.205u L=0.04u
M1310 n442 n339 U452/XI1-net8 VDD pmos W=0.205u L=0.04u
M1311 n330 n485 VSS VSS nmos W=0.135u L=0.04u
M1312 n330 n485 VDD VDD pmos W=0.205u L=0.04u
M1313 n343 n430 VSS VSS nmos W=0.135u L=0.04u
M1314 n343 n430 VDD VDD pmos W=0.205u L=0.04u
M1315 U455/XU1-net6 n395 VSS VSS nmos W=0.155u L=0.04u
M1316 n311 v9 U455/XU1-net6 VSS nmos W=0.155u L=0.04u
M1317 n311 n395 VDD VDD pmos W=0.155u L=0.04u
M1318 n311 v9 VDD VDD pmos W=0.155u L=0.04u
M1319 U456/p2 n259 VSS VSS nmos W=0.155u L=0.04u
M1320 U456/p0 n467 U456/p1 VSS nmos W=0.155u L=0.04u
M1321 U456/p1 n487 U456/p2 VSS nmos W=0.155u L=0.04u
M1322 Av13_D_11B n486 U456/p0 VSS nmos W=0.155u L=0.04u
M1323 Av13_D_11B n487 VDD VDD pmos W=0.205u L=0.04u
M1324 Av13_D_11B n467 VDD VDD pmos W=0.205u L=0.04u
M1325 Av13_D_11B n486 VDD VDD pmos W=0.205u L=0.04u
M1326 Av13_D_11B n259 VDD VDD pmos W=0.205u L=0.04u
M1327 n259 v0 U457/XI0-net10 VSS nmos W=0.155u L=0.04u
M1328 U457/XI0-net10 n395 U457/XI0-net13 VSS nmos W=0.155u L=0.04u
M1329 U457/XI0-net13 v11 VSS VSS nmos W=0.155u L=0.04u
M1330 n259 v11 VDD VDD pmos W=0.205u L=0.04u
M1331 n259 v0 VDD VDD pmos W=0.205u L=0.04u
M1332 n259 n395 VDD VDD pmos W=0.205u L=0.04u
M1333 VSS n310 U458/net22 VSS nmos W=0.155u L=0.04u
M1334 U458/net22 n489 n487 VSS nmos W=0.155u L=0.04u
M1335 U458/net22 n262 n487 VSS nmos W=0.155u L=0.04u
M1336 U458/net22 n488 n487 VSS nmos W=0.155u L=0.04u
M1337 U458/net38 n488 VDD VDD pmos W=0.205u L=0.04u
M1338 U458/net35 n262 U458/net38 VDD pmos W=0.205u L=0.04u
M1339 n487 n489 U458/net35 VDD pmos W=0.205u L=0.04u
M1340 n487 n310 VDD VDD pmos W=0.205u L=0.04u
M1341 n489 U459/net6 VSS VSS nmos W=0.155u L=0.04u
M1342 U459/X_u2-net6 v2 VSS VSS nmos W=0.155u L=0.04u
M1343 U459/net6 n315 U459/X_u2-net6 VSS nmos W=0.155u L=0.04u
M1344 n489 U459/net6 VDD VDD pmos W=0.205u L=0.04u
M1345 U459/net6 v2 VDD VDD pmos W=0.205u L=0.04u
M1346 U459/net6 n315 VDD VDD pmos W=0.205u L=0.04u
M1347 n315 n279 VSS VSS nmos W=0.155u L=0.04u
M1348 n315 n321 VSS VSS nmos W=0.155u L=0.04u
M1349 U460/XI1-net8 n321 VDD VDD pmos W=0.205u L=0.04u
M1350 n315 n279 U460/XI1-net8 VDD pmos W=0.205u L=0.04u
M1351 U461/net19 n298 VSS VSS nmos W=0.155u L=0.04u
M1352 n488 n298 U461/net40 VSS nmos W=0.155u L=0.04u
M1353 n488 U461/net19 U461/net36 VSS nmos W=0.155u L=0.04u
M1354 U461/net40 n339 VSS VSS nmos W=0.31u L=0.04u
M1355 U461/net36 n490 VSS VSS nmos W=0.155u L=0.04u
M1356 U461/net19 n298 VDD VDD pmos W=0.205u L=0.04u
M1357 n488 U461/net19 U461/net26 VDD pmos W=0.325u L=0.04u
M1358 U461/net26 n339 VDD VDD pmos W=0.41u L=0.04u
M1359 n488 n298 U461/net30 VDD pmos W=0.325u L=0.04u
M1360 U461/net30 n490 VDD VDD pmos W=0.205u L=0.04u
M1361 n490 n376 VSS VSS nmos W=0.155u L=0.04u
M1362 n490 n365 VSS VSS nmos W=0.155u L=0.04u
M1363 U462/XI1-net8 n365 VDD VDD pmos W=0.205u L=0.04u
M1364 n490 n376 U462/XI1-net8 VDD pmos W=0.205u L=0.04u
M1365 U463/net32 n261 U463/net26 VSS nmos W=0.155u L=0.04u
M1366 U463/net32 n321 U463/net26 VSS nmos W=0.155u L=0.04u
M1367 U463/net29 n258 VSS VSS nmos W=0.155u L=0.04u
M1368 U463/net26 v7 U463/net29 VSS nmos W=0.155u L=0.04u
M1369 U463/net26 n301 U463/net29 VSS nmos W=0.155u L=0.04u
M1370 n467 U463/net32 VSS VSS nmos W=0.155u L=0.04u
M1371 n467 U463/net32 VDD VDD pmos W=0.205u L=0.04u
M1372 U463/net32 n321 U463/net43 VDD pmos W=0.205u L=0.04u
M1373 U463/net32 n301 U463/net49 VDD pmos W=0.205u L=0.04u
M1374 U463/net49 v7 VDD VDD pmos W=0.205u L=0.04u
M1375 U463/net43 n261 VDD VDD pmos W=0.205u L=0.04u
M1376 U463/net32 n258 VDD VDD pmos W=0.205u L=0.04u
M1377 U464/XU1-net6 n366 VSS VSS nmos W=0.155u L=0.04u
M1378 n258 v8 U464/XU1-net6 VSS nmos W=0.155u L=0.04u
M1379 n258 n366 VDD VDD pmos W=0.155u L=0.04u
M1380 n258 v8 VDD VDD pmos W=0.155u L=0.04u
M1381 n261 n314 VSS VSS nmos W=0.135u L=0.04u
M1382 n261 n314 VDD VDD pmos W=0.205u L=0.04u
M1383 U466/net19 n302 VSS VSS nmos W=0.155u L=0.04u
M1384 n486 n302 U466/net40 VSS nmos W=0.155u L=0.04u
M1385 n486 U466/net19 U466/net36 VSS nmos W=0.155u L=0.04u
M1386 U466/net40 n481 VSS VSS nmos W=0.31u L=0.04u
M1387 U466/net36 n484 VSS VSS nmos W=0.155u L=0.04u
M1388 U466/net19 n302 VDD VDD pmos W=0.205u L=0.04u
M1389 n486 U466/net19 U466/net26 VDD pmos W=0.325u L=0.04u
M1390 U466/net26 n481 VDD VDD pmos W=0.41u L=0.04u
M1391 n486 n302 U466/net30 VDD pmos W=0.325u L=0.04u
M1392 U466/net30 n484 VDD VDD pmos W=0.205u L=0.04u
M1393 n484 n289 VSS VSS nmos W=0.155u L=0.04u
M1394 n484 v11 VSS VSS nmos W=0.155u L=0.04u
M1395 U467/XI1-net8 v11 VDD VDD pmos W=0.205u L=0.04u
M1396 n484 n289 U467/XI1-net8 VDD pmos W=0.205u L=0.04u
M1397 Av13_D_10B n491 U468/XI0-net10 VSS nmos W=0.155u L=0.04u
M1398 U468/XI0-net10 n482 U468/XI0-net13 VSS nmos W=0.155u L=0.04u
M1399 U468/XI0-net13 n492 VSS VSS nmos W=0.155u L=0.04u
M1400 Av13_D_10B n492 VDD VDD pmos W=0.205u L=0.04u
M1401 Av13_D_10B n491 VDD VDD pmos W=0.205u L=0.04u
M1402 Av13_D_10B n482 VDD VDD pmos W=0.205u L=0.04u
M1403 n492 n462 VSS VSS nmos W=0.155u L=0.04u
M1404 n492 n326 U469/XI17-net17 VSS nmos W=0.155u L=0.04u
M1405 U469/XI17-net17 n494 VSS VSS nmos W=0.155u L=0.04u
M1406 n492 n346 U469/XI10-net17 VSS nmos W=0.155u L=0.04u
M1407 U469/XI10-net17 n493 VSS VSS nmos W=0.155u L=0.04u
M1408 U469/net30 n346 n492 VDD pmos W=0.205u L=0.04u
M1409 U469/net30 n493 n492 VDD pmos W=0.205u L=0.04u
M1410 VDD n462 U469/net36 VDD pmos W=0.205u L=0.04u
M1411 U469/net36 n494 U469/net30 VDD pmos W=0.205u L=0.04u
M1412 U469/net36 n326 U469/net30 VDD pmos W=0.205u L=0.04u
M1413 n462 v7 VSS VSS nmos W=0.155u L=0.04u
M1414 n462 v11 VSS VSS nmos W=0.155u L=0.04u
M1415 n462 n280 VSS VSS nmos W=0.155u L=0.04u
M1416 n462 n306 VSS VSS nmos W=0.155u L=0.04u
M1417 U470/net49 v11 U470/net52 VDD pmos W=0.41u L=0.04u
M1418 U470/net52 v7 VDD VDD pmos W=0.41u L=0.04u
M1419 U470/net46 n280 U470/net49 VDD pmos W=0.41u L=0.04u
M1420 n462 n306 U470/net46 VDD pmos W=0.41u L=0.04u
M1421 n280 n345 VSS VSS nmos W=0.135u L=0.04u
M1422 n280 n345 VDD VDD pmos W=0.205u L=0.04u
M1423 n345 n391 VSS VSS nmos W=0.155u L=0.04u
M1424 n345 n302 VSS VSS nmos W=0.155u L=0.04u
M1425 U472/XI1-net8 n302 VDD VDD pmos W=0.205u L=0.04u
M1426 n345 n391 U472/XI1-net8 VDD pmos W=0.205u L=0.04u
M1427 n391 v2 VSS VSS nmos W=0.135u L=0.04u
M1428 n391 v2 VDD VDD pmos W=0.205u L=0.04u
M1429 n494 v9 U474/net15 VSS nmos W=0.155u L=0.04u
M1430 n494 n317 U474/net15 VSS nmos W=0.155u L=0.04u
M1431 U474/net15 n374 VSS VSS nmos W=0.155u L=0.04u
M1432 n494 n374 VDD VDD pmos W=0.205u L=0.04u
M1433 n494 v9 U474/XI16-net11 VDD pmos W=0.205u L=0.04u
M1434 U474/XI16-net11 n317 VDD VDD pmos W=0.205u L=0.04u
M1435 U475/XU1-net6 n301 VSS VSS nmos W=0.155u L=0.04u
M1436 n374 n302 U475/XU1-net6 VSS nmos W=0.155u L=0.04u
M1437 n374 n301 VDD VDD pmos W=0.155u L=0.04u
M1438 n374 n302 VDD VDD pmos W=0.155u L=0.04u
M1439 n317 n301 VSS VSS nmos W=0.155u L=0.04u
M1440 n317 n302 VSS VSS nmos W=0.155u L=0.04u
M1441 U476/XI1-net8 n302 VDD VDD pmos W=0.205u L=0.04u
M1442 n317 n301 U476/XI1-net8 VDD pmos W=0.205u L=0.04u
M1443 n326 n298 VSS VSS nmos W=0.155u L=0.04u
M1444 n326 n310 VSS VSS nmos W=0.155u L=0.04u
M1445 U477/XI1-net8 n310 VDD VDD pmos W=0.205u L=0.04u
M1446 n326 n298 U477/XI1-net8 VDD pmos W=0.205u L=0.04u
M1447 n298 n282 VSS VSS nmos W=0.135u L=0.04u
M1448 n298 n282 VDD VDD pmos W=0.205u L=0.04u
M1449 n493 n407 U479/net10 VSS nmos W=0.155u L=0.04u
M1450 U479/net10 n285 VSS VSS nmos W=0.155u L=0.04u
M1451 n493 n339 U479/net10 VSS nmos W=0.155u L=0.04u
M1452 U479/net10 n277 VSS VSS nmos W=0.155u L=0.04u
M1453 U479/net30 n285 VDD VDD pmos W=0.205u L=0.04u
M1454 n493 n407 U479/net24 VDD pmos W=0.205u L=0.04u
M1455 U479/net24 n339 VDD VDD pmos W=0.205u L=0.04u
M1456 n493 n277 U479/net30 VDD pmos W=0.205u L=0.04u
M1457 U480/net7 n495 U480/X_u4-net10 VSS nmos W=0.155u L=0.04u
M1458 U480/X_u4-net10 n457 U480/X_u4-net13 VSS nmos W=0.155u L=0.04u
M1459 U480/X_u4-net13 n496 VSS VSS nmos W=0.155u L=0.04u
M1460 n482 U480/net7 VSS VSS nmos W=0.155u L=0.04u
M1461 U480/net7 n496 VDD VDD pmos W=0.205u L=0.04u
M1462 U480/net7 n495 VDD VDD pmos W=0.205u L=0.04u
M1463 U480/net7 n457 VDD VDD pmos W=0.205u L=0.04u
M1464 n482 U480/net7 VDD VDD pmos W=0.205u L=0.04u
M1465 n496 n263 U481/net23 VDD pmos W=0.205u L=0.04u
M1466 n496 n288 U481/net23 VDD pmos W=0.205u L=0.04u
M1467 n496 v8 U481/net23 VDD pmos W=0.205u L=0.04u
M1468 U481/net23 n277 VDD VDD pmos W=0.205u L=0.04u
M1469 U481/net23 n481 VDD VDD pmos W=0.205u L=0.04u
M1470 U481/XI20-net13 n288 VSS VSS nmos W=0.155u L=0.04u
M1471 n496 n263 U481/XI20-net17 VSS nmos W=0.155u L=0.04u
M1472 U481/XI20-net17 v8 U481/XI20-net13 VSS nmos W=0.155u L=0.04u
M1473 n496 n277 U481/XI17-net17 VSS nmos W=0.155u L=0.04u
M1474 U481/XI17-net17 n481 VSS VSS nmos W=0.155u L=0.04u
M1475 U482/p2 n300 VSS VSS nmos W=0.155u L=0.04u
M1476 U482/p0 n346 U482/p1 VSS nmos W=0.155u L=0.04u
M1477 U482/p1 v8 U482/p2 VSS nmos W=0.155u L=0.04u
M1478 n457 v2 U482/p0 VSS nmos W=0.155u L=0.04u
M1479 n457 v8 VDD VDD pmos W=0.205u L=0.04u
M1480 n457 n346 VDD VDD pmos W=0.205u L=0.04u
M1481 n457 v2 VDD VDD pmos W=0.205u L=0.04u
M1482 n457 n300 VDD VDD pmos W=0.205u L=0.04u
M1483 n300 n277 VSS VSS nmos W=0.135u L=0.04u
M1484 n300 n277 VDD VDD pmos W=0.205u L=0.04u
M1485 n277 v10 VSS VSS nmos W=0.155u L=0.04u
M1486 n277 v9 VSS VSS nmos W=0.155u L=0.04u
M1487 U484/XI1-net8 v9 VDD VDD pmos W=0.205u L=0.04u
M1488 n277 v10 U484/XI1-net8 VDD pmos W=0.205u L=0.04u
M1489 U485/p2 n366 VSS VSS nmos W=0.155u L=0.04u
M1490 U485/p0 v0 U485/p1 VSS nmos W=0.155u L=0.04u
M1491 U485/p1 n395 U485/p2 VSS nmos W=0.155u L=0.04u
M1492 n495 n346 U485/p0 VSS nmos W=0.155u L=0.04u
M1493 n495 n395 VDD VDD pmos W=0.205u L=0.04u
M1494 n495 v0 VDD VDD pmos W=0.205u L=0.04u
M1495 n495 n346 VDD VDD pmos W=0.205u L=0.04u
M1496 n495 n366 VDD VDD pmos W=0.205u L=0.04u
M1497 U486/net29 n262 VSS VSS nmos W=0.155u L=0.04u
M1498 n491 n430 U486/net29 VSS nmos W=0.155u L=0.04u
M1499 n491 n304 U486/net23 VSS nmos W=0.155u L=0.04u
M1500 U486/net23 n470 VSS VSS nmos W=0.155u L=0.04u
M1501 U486/net20 n470 n491 VDD pmos W=0.205u L=0.04u
M1502 U486/net20 n304 n491 VDD pmos W=0.205u L=0.04u
M1503 VDD n430 U486/net20 VDD pmos W=0.205u L=0.04u
M1504 VDD n262 U486/net20 VDD pmos W=0.205u L=0.04u
M1505 n430 n281 VSS VSS nmos W=0.155u L=0.04u
M1506 n430 n302 VSS VSS nmos W=0.155u L=0.04u
M1507 U487/XI1-net8 n302 VDD VDD pmos W=0.205u L=0.04u
M1508 n430 n281 U487/XI1-net8 VDD pmos W=0.205u L=0.04u
M1509 n470 v11 U488/net15 VSS nmos W=0.155u L=0.04u
M1510 n470 n302 U488/net15 VSS nmos W=0.155u L=0.04u
M1511 U488/net15 n339 VSS VSS nmos W=0.155u L=0.04u
M1512 n470 n339 VDD VDD pmos W=0.205u L=0.04u
M1513 n470 v11 U488/XI16-net11 VDD pmos W=0.205u L=0.04u
M1514 U488/XI16-net11 n302 VDD VDD pmos W=0.205u L=0.04u
M1515 n304 n306 VSS VSS nmos W=0.155u L=0.04u
M1516 n304 n289 VSS VSS nmos W=0.155u L=0.04u
M1517 U489/XI1-net8 n289 VDD VDD pmos W=0.205u L=0.04u
M1518 n304 n306 U489/XI1-net8 VDD pmos W=0.205u L=0.04u
M1519 n306 n429 VSS VSS nmos W=0.135u L=0.04u
M1520 n306 n429 VDD VDD pmos W=0.205u L=0.04u
M1521 n429 v12 VSS VSS nmos W=0.155u L=0.04u
M1522 n429 v9 VSS VSS nmos W=0.155u L=0.04u
M1523 U491/XI1-net8 v9 VDD VDD pmos W=0.205u L=0.04u
M1524 n429 v12 U491/XI1-net8 VDD pmos W=0.205u L=0.04u
M1525 U492/net36 n497 U492/net24 VSS nmos W=0.155u L=0.04u
M1526 U492/net24 n498 VSS VSS nmos W=0.155u L=0.04u
M1527 Av13_D_0B n339 U492/net36 VSS nmos W=0.155u L=0.04u
M1528 Av13_D_0B n463 U492/net36 VSS nmos W=0.155u L=0.04u
M1529 Av13_D_0B n463 U492/net35 VDD pmos W=0.205u L=0.04u
M1530 U492/net35 n339 VDD VDD pmos W=0.205u L=0.04u
M1531 Av13_D_0B n498 VDD VDD pmos W=0.205u L=0.04u
M1532 Av13_D_0B n497 VDD VDD pmos W=0.205u L=0.04u
M1533 n498 n360 U493/net19 VDD pmos W=0.205u L=0.04u
M1534 n498 n288 U493/net19 VDD pmos W=0.205u L=0.04u
M1535 n498 n328 U493/net19 VDD pmos W=0.205u L=0.04u
M1536 U493/net19 n499 VDD VDD pmos W=0.205u L=0.04u
M1537 n498 n499 VSS VSS nmos W=0.155u L=0.04u
M1538 U493/XI20-net13 n288 VSS VSS nmos W=0.155u L=0.04u
M1539 n498 n360 U493/XI20-net17 VSS nmos W=0.155u L=0.04u
M1540 U493/XI20-net17 n328 U493/XI20-net13 VSS nmos W=0.155u L=0.04u
M1541 n499 U494/net26 VDD VDD pmos W=0.205u L=0.04u
M1542 U494/net26 n485 U494/net19 VDD pmos W=0.205u L=0.04u
M1543 U494/net26 n279 U494/net19 VDD pmos W=0.205u L=0.04u
M1544 U494/net26 n274 U494/net19 VDD pmos W=0.205u L=0.04u
M1545 U494/net19 n426 VDD VDD pmos W=0.205u L=0.04u
M1546 U494/net26 n426 VSS VSS nmos W=0.155u L=0.04u
M1547 n499 U494/net26 VSS VSS nmos W=0.155u L=0.04u
M1548 U494/XI20-net13 n274 VSS VSS nmos W=0.155u L=0.04u
M1549 U494/net26 n485 U494/XI20-net17 VSS nmos W=0.155u L=0.04u
M1550 U494/XI20-net17 n279 U494/XI20-net13 VSS nmos W=0.155u L=0.04u
M1551 n426 n322 VSS VSS nmos W=0.155u L=0.04u
M1552 n426 v2 VSS VSS nmos W=0.155u L=0.04u
M1553 n426 n285 VSS VSS nmos W=0.155u L=0.04u
M1554 U495/net25 n322 VDD VDD pmos W=0.41u L=0.04u
M1555 U495/net28 v2 U495/net25 VDD pmos W=0.41u L=0.04u
M1556 n426 n285 U495/net28 VDD pmos W=0.41u L=0.04u
M1557 n322 n288 VSS VSS nmos W=0.135u L=0.04u
M1558 n322 n288 VDD VDD pmos W=0.205u L=0.04u
M1559 n285 n360 VSS VSS nmos W=0.135u L=0.04u
M1560 n285 n360 VDD VDD pmos W=0.205u L=0.04u
M1561 n485 n289 VSS VSS nmos W=0.155u L=0.04u
M1562 n485 v12 VSS VSS nmos W=0.155u L=0.04u
M1563 U498/XI1-net8 v12 VDD VDD pmos W=0.205u L=0.04u
M1564 n485 n289 U498/XI1-net8 VDD pmos W=0.205u L=0.04u
M1565 n289 n395 VSS VSS nmos W=0.135u L=0.04u
M1566 n289 n395 VDD VDD pmos W=0.205u L=0.04u
M1567 n395 v7 VSS VSS nmos W=0.155u L=0.04u
M1568 n395 v8 VSS VSS nmos W=0.155u L=0.04u
M1569 U500/XI1-net8 v8 VDD VDD pmos W=0.205u L=0.04u
M1570 n395 v7 U500/XI1-net8 VDD pmos W=0.205u L=0.04u
M1571 n288 n301 VSS VSS nmos W=0.155u L=0.04u
M1572 n288 v9 VSS VSS nmos W=0.155u L=0.04u
M1573 U501/XI1-net8 v9 VDD VDD pmos W=0.205u L=0.04u
M1574 n288 n301 U501/XI1-net8 VDD pmos W=0.205u L=0.04u
M1575 n328 n263 VSS VSS nmos W=0.135u L=0.04u
M1576 n328 n263 VDD VDD pmos W=0.205u L=0.04u
M1577 n263 n279 VSS VSS nmos W=0.155u L=0.04u
M1578 n263 n302 VSS VSS nmos W=0.155u L=0.04u
M1579 U503/XI1-net8 n302 VDD VDD pmos W=0.205u L=0.04u
M1580 n263 n279 U503/XI1-net8 VDD pmos W=0.205u L=0.04u
M1581 n360 n310 VSS VSS nmos W=0.155u L=0.04u
M1582 n360 n321 VSS VSS nmos W=0.155u L=0.04u
M1583 U504/XI1-net8 n321 VDD VDD pmos W=0.205u L=0.04u
M1584 n360 n310 U504/XI1-net8 VDD pmos W=0.205u L=0.04u
M1585 U505/net29 n310 VSS VSS nmos W=0.155u L=0.04u
M1586 n497 n500 U505/net29 VSS nmos W=0.155u L=0.04u
M1587 n497 n314 U505/net23 VSS nmos W=0.155u L=0.04u
M1588 U505/net23 n260 VSS VSS nmos W=0.155u L=0.04u
M1589 U505/net20 n260 n497 VDD pmos W=0.205u L=0.04u
M1590 U505/net20 n314 n497 VDD pmos W=0.205u L=0.04u
M1591 VDD n500 U505/net20 VDD pmos W=0.205u L=0.04u
M1592 VDD n310 U505/net20 VDD pmos W=0.205u L=0.04u
M1593 U506/net36 n502 U506/net24 VSS nmos W=0.155u L=0.04u
M1594 U506/net24 n503 VSS VSS nmos W=0.155u L=0.04u
M1595 n500 n501 U506/net36 VSS nmos W=0.155u L=0.04u
M1596 n500 n366 U506/net36 VSS nmos W=0.155u L=0.04u
M1597 n500 n366 U506/net35 VDD pmos W=0.205u L=0.04u
M1598 U506/net35 n501 VDD VDD pmos W=0.205u L=0.04u
M1599 n500 n503 VDD VDD pmos W=0.205u L=0.04u
M1600 n500 n502 VDD VDD pmos W=0.205u L=0.04u
M1601 n503 n481 U507/net23 VDD pmos W=0.205u L=0.04u
M1602 n503 n504 U507/net23 VDD pmos W=0.205u L=0.04u
M1603 n503 n303 U507/net23 VDD pmos W=0.205u L=0.04u
M1604 U507/net23 n394 VDD VDD pmos W=0.205u L=0.04u
M1605 U507/net23 n505 VDD VDD pmos W=0.205u L=0.04u
M1606 U507/XI20-net13 n504 VSS VSS nmos W=0.155u L=0.04u
M1607 n503 n481 U507/XI20-net17 VSS nmos W=0.155u L=0.04u
M1608 U507/XI20-net17 n303 U507/XI20-net13 VSS nmos W=0.155u L=0.04u
M1609 n503 n394 U507/XI17-net17 VSS nmos W=0.155u L=0.04u
M1610 U507/XI17-net17 n505 VSS VSS nmos W=0.155u L=0.04u
M1611 U508/XU1-net6 n352 VSS VSS nmos W=0.155u L=0.04u
M1612 n505 v3 U508/XU1-net6 VSS nmos W=0.155u L=0.04u
M1613 n505 n352 VDD VDD pmos W=0.155u L=0.04u
M1614 n505 v3 VDD VDD pmos W=0.155u L=0.04u
M1615 n352 n351 VSS VSS nmos W=0.135u L=0.04u
M1616 n352 n351 VDD VDD pmos W=0.205u L=0.04u
M1617 n351 n376 VSS VSS nmos W=0.155u L=0.04u
M1618 n351 v1 VSS VSS nmos W=0.155u L=0.04u
M1619 U510/XI1-net8 v1 VDD VDD pmos W=0.205u L=0.04u
M1620 n351 n376 U510/XI1-net8 VDD pmos W=0.205u L=0.04u
M1621 n376 v6 VSS VSS nmos W=0.135u L=0.04u
M1622 n376 v6 VDD VDD pmos W=0.205u L=0.04u
M1623 n394 n393 VSS VSS nmos W=0.155u L=0.04u
M1624 n394 n366 VSS VSS nmos W=0.155u L=0.04u
M1625 U512/XI1-net8 n366 VDD VDD pmos W=0.205u L=0.04u
M1626 n394 n393 U512/XI1-net8 VDD pmos W=0.205u L=0.04u
M1627 n393 n284 VSS VSS nmos W=0.135u L=0.04u
M1628 n393 n284 VDD VDD pmos W=0.205u L=0.04u
M1629 n284 n301 VSS VSS nmos W=0.155u L=0.04u
M1630 n284 n279 VSS VSS nmos W=0.155u L=0.04u
M1631 U514/XI1-net8 n279 VDD VDD pmos W=0.205u L=0.04u
M1632 n284 n301 U514/XI1-net8 VDD pmos W=0.205u L=0.04u
M1633 n504 n283 VSS VSS nmos W=0.155u L=0.04u
M1634 n504 n339 VSS VSS nmos W=0.155u L=0.04u
M1635 U515/XI1-net8 n339 VDD VDD pmos W=0.205u L=0.04u
M1636 n504 n283 U515/XI1-net8 VDD pmos W=0.205u L=0.04u
M1637 n283 n356 VSS VSS nmos W=0.135u L=0.04u
M1638 n283 n356 VDD VDD pmos W=0.205u L=0.04u
M1639 n356 n302 VSS VSS nmos W=0.155u L=0.04u
M1640 n356 v9 VSS VSS nmos W=0.155u L=0.04u
M1641 U517/XI1-net8 v9 VDD VDD pmos W=0.205u L=0.04u
M1642 n356 n302 U517/XI1-net8 VDD pmos W=0.205u L=0.04u
M1643 n303 v0 VSS VSS nmos W=0.135u L=0.04u
M1644 n303 v0 VDD VDD pmos W=0.205u L=0.04u
M1645 n481 n281 VSS VSS nmos W=0.155u L=0.04u
M1646 n481 v8 VSS VSS nmos W=0.155u L=0.04u
M1647 U519/XI1-net8 v8 VDD VDD pmos W=0.205u L=0.04u
M1648 n481 n281 U519/XI1-net8 VDD pmos W=0.205u L=0.04u
M1649 n502 n267 U520/net15 VSS nmos W=0.155u L=0.04u
M1650 n502 n506 U520/net15 VSS nmos W=0.155u L=0.04u
M1651 U520/net15 n262 VSS VSS nmos W=0.155u L=0.04u
M1652 n502 n262 VDD VDD pmos W=0.205u L=0.04u
M1653 n502 n267 U520/XI16-net11 VDD pmos W=0.205u L=0.04u
M1654 U520/XI16-net11 n506 VDD VDD pmos W=0.205u L=0.04u
M1655 n262 n366 VSS VSS nmos W=0.155u L=0.04u
M1656 n262 v8 VSS VSS nmos W=0.155u L=0.04u
M1657 U521/XI1-net8 v8 VDD VDD pmos W=0.205u L=0.04u
M1658 n262 n366 U521/XI1-net8 VDD pmos W=0.205u L=0.04u
M1659 U522/net19 n279 VSS VSS nmos W=0.155u L=0.04u
M1660 n506 n279 U522/net40 VSS nmos W=0.155u L=0.04u
M1661 n506 U522/net19 U522/net36 VSS nmos W=0.155u L=0.04u
M1662 U522/net40 n507 VSS VSS nmos W=0.31u L=0.04u
M1663 U522/net36 n384 VSS VSS nmos W=0.155u L=0.04u
M1664 U522/net19 n279 VDD VDD pmos W=0.205u L=0.04u
M1665 n506 U522/net19 U522/net26 VDD pmos W=0.325u L=0.04u
M1666 U522/net26 n507 VDD VDD pmos W=0.41u L=0.04u
M1667 n506 n279 U522/net30 VDD pmos W=0.325u L=0.04u
M1668 U522/net30 n384 VDD VDD pmos W=0.205u L=0.04u
M1669 n507 n331 U523/net15 VSS nmos W=0.155u L=0.04u
M1670 n507 n365 U523/net15 VSS nmos W=0.155u L=0.04u
M1671 U523/net15 n301 VSS VSS nmos W=0.155u L=0.04u
M1672 n507 n301 VDD VDD pmos W=0.205u L=0.04u
M1673 n507 n331 U523/XI16-net11 VDD pmos W=0.205u L=0.04u
M1674 U523/XI16-net11 n365 VDD VDD pmos W=0.205u L=0.04u
M1675 n365 v3 VSS VSS nmos W=0.135u L=0.04u
M1676 n365 v3 VDD VDD pmos W=0.205u L=0.04u
M1677 U525/XU1-net6 v1 VSS VSS nmos W=0.155u L=0.04u
M1678 n331 v6 U525/XU1-net6 VSS nmos W=0.155u L=0.04u
M1679 n331 v1 VDD VDD pmos W=0.155u L=0.04u
M1680 n331 v6 VDD VDD pmos W=0.155u L=0.04u
M1681 n267 n257 VSS VSS nmos W=0.155u L=0.04u
M1682 n267 v11 VSS VSS nmos W=0.155u L=0.04u
M1683 U526/XI1-net8 v11 VDD VDD pmos W=0.205u L=0.04u
M1684 n267 n257 U526/XI1-net8 VDD pmos W=0.205u L=0.04u
M1685 n257 n384 VSS VSS nmos W=0.135u L=0.04u
M1686 n257 n384 VDD VDD pmos W=0.205u L=0.04u
M1687 n384 n302 VSS VSS nmos W=0.155u L=0.04u
M1688 n384 v12 VSS VSS nmos W=0.155u L=0.04u
M1689 U528/XI1-net8 v12 VDD VDD pmos W=0.205u L=0.04u
M1690 n384 n302 U528/XI1-net8 VDD pmos W=0.205u L=0.04u
M1691 n302 v10 VSS VSS nmos W=0.135u L=0.04u
M1692 n302 v10 VDD VDD pmos W=0.205u L=0.04u
M1693 n501 n282 U530/net27 VSS nmos W=0.155u L=0.04u
M1694 U530/net27 v12 VSS VSS nmos W=0.155u L=0.04u
M1695 n501 n276 VSS VSS nmos W=0.155u L=0.04u
M1696 n501 v12 U530/net13 VDD pmos W=0.205u L=0.04u
M1697 U530/net13 n276 VDD VDD pmos W=0.205u L=0.04u
M1698 n501 n282 U530/net13 VDD pmos W=0.205u L=0.04u
M1699 n276 n301 VSS VSS nmos W=0.155u L=0.04u
M1700 n276 v10 VSS VSS nmos W=0.155u L=0.04u
M1701 U531/XI1-net8 v10 VDD VDD pmos W=0.205u L=0.04u
M1702 n276 n301 U531/XI1-net8 VDD pmos W=0.205u L=0.04u
M1703 n301 v12 VSS VSS nmos W=0.135u L=0.04u
M1704 n301 v12 VDD VDD pmos W=0.205u L=0.04u
M1705 n282 n321 VSS VSS nmos W=0.155u L=0.04u
M1706 n282 v11 VSS VSS nmos W=0.155u L=0.04u
M1707 U533/XI1-net8 v11 VDD VDD pmos W=0.205u L=0.04u
M1708 n282 n321 U533/XI1-net8 VDD pmos W=0.205u L=0.04u
M1709 n260 n310 VSS VSS nmos W=0.155u L=0.04u
M1710 n260 n407 VSS VSS nmos W=0.155u L=0.04u
M1711 U534/XI1-net8 n407 VDD VDD pmos W=0.205u L=0.04u
M1712 n260 n310 U534/XI1-net8 VDD pmos W=0.205u L=0.04u
M1713 n407 n371 VSS VSS nmos W=0.135u L=0.04u
M1714 n407 n371 VDD VDD pmos W=0.205u L=0.04u
M1715 n371 n366 VSS VSS nmos W=0.155u L=0.04u
M1716 n371 n321 VSS VSS nmos W=0.155u L=0.04u
M1717 U536/XI1-net8 n321 VDD VDD pmos W=0.205u L=0.04u
M1718 n371 n366 U536/XI1-net8 VDD pmos W=0.205u L=0.04u
M1719 n310 v7 VSS VSS nmos W=0.135u L=0.04u
M1720 n310 v7 VDD VDD pmos W=0.205u L=0.04u
M1721 n314 v10 VSS VSS nmos W=0.155u L=0.04u
M1722 n314 v11 VSS VSS nmos W=0.155u L=0.04u
M1723 U538/XI1-net8 v11 VDD VDD pmos W=0.205u L=0.04u
M1724 n314 v10 U538/XI1-net8 VDD pmos W=0.205u L=0.04u
M1725 n463 n305 VSS VSS nmos W=0.135u L=0.04u
M1726 n463 n305 VDD VDD pmos W=0.205u L=0.04u
M1727 n305 v7 VSS VSS nmos W=0.155u L=0.04u
M1728 n305 n321 VSS VSS nmos W=0.155u L=0.04u
M1729 n305 n281 VSS VSS nmos W=0.155u L=0.04u
M1730 n305 n316 VSS VSS nmos W=0.155u L=0.04u
M1731 U540/net49 n321 U540/net52 VDD pmos W=0.41u L=0.04u
M1732 U540/net52 v7 VDD VDD pmos W=0.41u L=0.04u
M1733 U540/net46 n281 U540/net49 VDD pmos W=0.41u L=0.04u
M1734 n305 n316 U540/net46 VDD pmos W=0.41u L=0.04u
M1735 n321 v8 VSS VSS nmos W=0.135u L=0.04u
M1736 n321 v8 VDD VDD pmos W=0.205u L=0.04u
M1737 n281 n346 VSS VSS nmos W=0.135u L=0.04u
M1738 n281 n346 VDD VDD pmos W=0.205u L=0.04u
M1739 n346 n279 VSS VSS nmos W=0.155u L=0.04u
M1740 n346 v12 VSS VSS nmos W=0.155u L=0.04u
M1741 U543/XI1-net8 v12 VDD VDD pmos W=0.205u L=0.04u
M1742 n346 n279 U543/XI1-net8 VDD pmos W=0.205u L=0.04u
M1743 n279 v11 VSS VSS nmos W=0.135u L=0.04u
M1744 n279 v11 VDD VDD pmos W=0.205u L=0.04u
M1745 n316 n274 VSS VSS nmos W=0.135u L=0.04u
M1746 n316 n274 VDD VDD pmos W=0.205u L=0.04u
M1747 n274 n366 VSS VSS nmos W=0.155u L=0.04u
M1748 n274 v2 VSS VSS nmos W=0.155u L=0.04u
M1749 U546/XI1-net8 v2 VDD VDD pmos W=0.205u L=0.04u
M1750 n274 n366 U546/XI1-net8 VDD pmos W=0.205u L=0.04u
M1751 n366 v9 VSS VSS nmos W=0.135u L=0.04u
M1752 n366 v9 VDD VDD pmos W=0.205u L=0.04u
M1753 n339 n370 VSS VSS nmos W=0.135u L=0.04u
M1754 n339 n370 VDD VDD pmos W=0.205u L=0.04u
M1755 n370 n465 VSS VSS nmos W=0.155u L=0.04u
M1756 n370 n318 VSS VSS nmos W=0.155u L=0.04u
M1757 U549/XI1-net8 n318 VDD VDD pmos W=0.205u L=0.04u
M1758 n370 n465 U549/XI1-net8 VDD pmos W=0.205u L=0.04u
M1759 n318 v5 VSS VSS nmos W=0.135u L=0.04u
M1760 n318 v5 VDD VDD pmos W=0.205u L=0.04u
M1761 n465 v4 VSS VSS nmos W=0.135u L=0.04u
M1762 n465 v4 VDD VDD pmos W=0.205u L=0.04u
.ENDS
