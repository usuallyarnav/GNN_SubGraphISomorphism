.SUBCKT s38417 CK g1249 g16297 g16355 g16399 g16437 g16496 g1943 g23919 g25420 g24909 g25442 g25489 g25490 g26135 g25566 g2637 g26974 g3212 g3213 g3214 g3215 g3216 g3217 g3218 g3219 g3220 g3221 g3222 g3223 g3224 g3225 g3226 g3227 g3228 g3229 g3230 g3231 g3232 g3233 g3234 g3993 g4088 g4090 g4200 g4321 g4323 g4450 g4590 g51 g5388 g5437 g5472 g5511 g5549 g5555 g5595 g5612 g5629 g563 g5637 g5648 g5657 g5686 g5695 g5738 g5747 g5796 g6225 g6231 g6313 g6368 g6442 g6447 g6485 g6518 g6573 g6642 g6677 g6712 g6750 g6782 g6837 g6895 g6911 g6944 g6979 g7014 g7052 g7084 g7161 g7194 g7229 g7264 g7302 g7334 g7357 g7390 g7425 g7487 g7519 g7909 g7956 g7961 g8007 g8012 g8021 g8023 g8030 g8082 g8087 g8096 g8106 g8167 g8175 g8249 g8251 g1 g2 g5 g8 g11 g14 g17 g20 g23 g26 g27 g30 g33 g36 g39 g42 g45 g48 VDD VSS
M1 g11509 g125 VSS VSS nmos W=0.31u L=0.04u
M2 g11509 g125 VDD VDD pmos W=0.41u L=0.04u
M3 g11510 g121 VSS VSS nmos W=0.31u L=0.04u
M4 g11510 g121 VDD VDD pmos W=0.41u L=0.04u
M5 g11511 g117 VSS VSS nmos W=0.31u L=0.04u
M6 g11511 g117 VDD VDD pmos W=0.41u L=0.04u
M7 g11491 g113 VSS VSS nmos W=0.31u L=0.04u
M8 g11491 g113 VDD VDD pmos W=0.41u L=0.04u
M9 g11492 g109 VSS VSS nmos W=0.31u L=0.04u
M10 g11492 g109 VDD VDD pmos W=0.41u L=0.04u
M11 g11493 g105 VSS VSS nmos W=0.31u L=0.04u
M12 g11493 g105 VDD VDD pmos W=0.41u L=0.04u
M13 g11494 g101 VSS VSS nmos W=0.31u L=0.04u
M14 g11494 g101 VDD VDD pmos W=0.41u L=0.04u
M15 g11495 g97 VSS VSS nmos W=0.31u L=0.04u
M16 g11495 g97 VDD VDD pmos W=0.41u L=0.04u
M17 g13410 g451 VSS VSS nmos W=0.31u L=0.04u
M18 g13410 g451 VDD VDD pmos W=0.41u L=0.04u
M19 g13411 g453 VSS VSS nmos W=0.31u L=0.04u
M20 g13411 g453 VDD VDD pmos W=0.41u L=0.04u
M21 g13412 g279 VSS VSS nmos W=0.31u L=0.04u
M22 g13412 g279 VDD VDD pmos W=0.41u L=0.04u
M23 g13413 g281 VSS VSS nmos W=0.31u L=0.04u
M24 g13413 g281 VDD VDD pmos W=0.41u L=0.04u
M25 g13414 g283 VSS VSS nmos W=0.31u L=0.04u
M26 g13414 g283 VDD VDD pmos W=0.41u L=0.04u
M27 g13415 g285 VSS VSS nmos W=0.31u L=0.04u
M28 g13415 g285 VDD VDD pmos W=0.41u L=0.04u
M29 g13416 g287 VSS VSS nmos W=0.31u L=0.04u
M30 g13416 g287 VDD VDD pmos W=0.41u L=0.04u
M31 g13417 g289 VSS VSS nmos W=0.31u L=0.04u
M32 g13417 g289 VDD VDD pmos W=0.41u L=0.04u
M33 g13418 g291 VSS VSS nmos W=0.31u L=0.04u
M34 g13418 g291 VDD VDD pmos W=0.41u L=0.04u
M35 g11536 g813 VSS VSS nmos W=0.31u L=0.04u
M36 g11536 g813 VDD VDD pmos W=0.41u L=0.04u
M37 g11537 g809 VSS VSS nmos W=0.31u L=0.04u
M38 g11537 g809 VDD VDD pmos W=0.41u L=0.04u
M39 g11538 g805 VSS VSS nmos W=0.31u L=0.04u
M40 g11538 g805 VDD VDD pmos W=0.41u L=0.04u
M41 g11518 g801 VSS VSS nmos W=0.31u L=0.04u
M42 g11518 g801 VDD VDD pmos W=0.41u L=0.04u
M43 g11519 g797 VSS VSS nmos W=0.31u L=0.04u
M44 g11519 g797 VDD VDD pmos W=0.41u L=0.04u
M45 g11520 g793 VSS VSS nmos W=0.31u L=0.04u
M46 g11520 g793 VDD VDD pmos W=0.41u L=0.04u
M47 g11521 g789 VSS VSS nmos W=0.31u L=0.04u
M48 g11521 g789 VDD VDD pmos W=0.41u L=0.04u
M49 g11522 g785 VSS VSS nmos W=0.31u L=0.04u
M50 g11522 g785 VDD VDD pmos W=0.41u L=0.04u
M51 g13426 g1138 VSS VSS nmos W=0.31u L=0.04u
M52 g13426 g1138 VDD VDD pmos W=0.41u L=0.04u
M53 g13427 g1140 VSS VSS nmos W=0.31u L=0.04u
M54 g13427 g1140 VDD VDD pmos W=0.41u L=0.04u
M55 g13428 g966 VSS VSS nmos W=0.31u L=0.04u
M56 g13428 g966 VDD VDD pmos W=0.41u L=0.04u
M57 g13429 g968 VSS VSS nmos W=0.31u L=0.04u
M58 g13429 g968 VDD VDD pmos W=0.41u L=0.04u
M59 g13430 g970 VSS VSS nmos W=0.31u L=0.04u
M60 g13430 g970 VDD VDD pmos W=0.41u L=0.04u
M61 g13431 g972 VSS VSS nmos W=0.31u L=0.04u
M62 g13431 g972 VDD VDD pmos W=0.41u L=0.04u
M63 g13432 g974 VSS VSS nmos W=0.31u L=0.04u
M64 g13432 g974 VDD VDD pmos W=0.41u L=0.04u
M65 g13433 g976 VSS VSS nmos W=0.31u L=0.04u
M66 g13433 g976 VDD VDD pmos W=0.41u L=0.04u
M67 g13434 g978 VSS VSS nmos W=0.31u L=0.04u
M68 g13434 g978 VDD VDD pmos W=0.41u L=0.04u
M69 g11563 g1506 VSS VSS nmos W=0.31u L=0.04u
M70 g11563 g1506 VDD VDD pmos W=0.41u L=0.04u
M71 g11564 g1501 VSS VSS nmos W=0.31u L=0.04u
M72 g11564 g1501 VDD VDD pmos W=0.41u L=0.04u
M73 g11565 g1496 VSS VSS nmos W=0.31u L=0.04u
M74 g11565 g1496 VDD VDD pmos W=0.41u L=0.04u
M75 g11545 g1491 VSS VSS nmos W=0.31u L=0.04u
M76 g11545 g1491 VDD VDD pmos W=0.41u L=0.04u
M77 g11546 g1486 VSS VSS nmos W=0.31u L=0.04u
M78 g11546 g1486 VDD VDD pmos W=0.41u L=0.04u
M79 g11547 g1481 VSS VSS nmos W=0.31u L=0.04u
M80 g11547 g1481 VDD VDD pmos W=0.41u L=0.04u
M81 g11548 g1476 VSS VSS nmos W=0.31u L=0.04u
M82 g11548 g1476 VDD VDD pmos W=0.41u L=0.04u
M83 g11549 g1471 VSS VSS nmos W=0.31u L=0.04u
M84 g11549 g1471 VDD VDD pmos W=0.41u L=0.04u
M85 g13442 g1832 VSS VSS nmos W=0.31u L=0.04u
M86 g13442 g1832 VDD VDD pmos W=0.41u L=0.04u
M87 g13443 g1834 VSS VSS nmos W=0.31u L=0.04u
M88 g13443 g1834 VDD VDD pmos W=0.41u L=0.04u
M89 g13444 g1660 VSS VSS nmos W=0.31u L=0.04u
M90 g13444 g1660 VDD VDD pmos W=0.41u L=0.04u
M91 g13445 g1662 VSS VSS nmos W=0.31u L=0.04u
M92 g13445 g1662 VDD VDD pmos W=0.41u L=0.04u
M93 g13446 g1664 VSS VSS nmos W=0.31u L=0.04u
M94 g13446 g1664 VDD VDD pmos W=0.41u L=0.04u
M95 g13447 g1666 VSS VSS nmos W=0.31u L=0.04u
M96 g13447 g1666 VDD VDD pmos W=0.41u L=0.04u
M97 g13448 g1668 VSS VSS nmos W=0.31u L=0.04u
M98 g13448 g1668 VDD VDD pmos W=0.41u L=0.04u
M99 g13449 g1670 VSS VSS nmos W=0.31u L=0.04u
M100 g13449 g1670 VDD VDD pmos W=0.41u L=0.04u
M101 g13450 g1672 VSS VSS nmos W=0.31u L=0.04u
M102 g13450 g1672 VDD VDD pmos W=0.41u L=0.04u
M103 g11590 g2200 VSS VSS nmos W=0.31u L=0.04u
M104 g11590 g2200 VDD VDD pmos W=0.41u L=0.04u
M105 g11591 g2195 VSS VSS nmos W=0.31u L=0.04u
M106 g11591 g2195 VDD VDD pmos W=0.41u L=0.04u
M107 g11592 g2190 VSS VSS nmos W=0.31u L=0.04u
M108 g11592 g2190 VDD VDD pmos W=0.41u L=0.04u
M109 g11572 g2185 VSS VSS nmos W=0.31u L=0.04u
M110 g11572 g2185 VDD VDD pmos W=0.41u L=0.04u
M111 g11573 g2180 VSS VSS nmos W=0.31u L=0.04u
M112 g11573 g2180 VDD VDD pmos W=0.41u L=0.04u
M113 g11574 g2175 VSS VSS nmos W=0.31u L=0.04u
M114 g11574 g2175 VDD VDD pmos W=0.41u L=0.04u
M115 g11575 g2170 VSS VSS nmos W=0.31u L=0.04u
M116 g11575 g2170 VDD VDD pmos W=0.41u L=0.04u
M117 g11576 g2165 VSS VSS nmos W=0.31u L=0.04u
M118 g11576 g2165 VDD VDD pmos W=0.41u L=0.04u
M119 g13458 g2526 VSS VSS nmos W=0.31u L=0.04u
M120 g13458 g2526 VDD VDD pmos W=0.41u L=0.04u
M121 g13459 g2528 VSS VSS nmos W=0.31u L=0.04u
M122 g13459 g2528 VDD VDD pmos W=0.41u L=0.04u
M123 g13460 g2354 VSS VSS nmos W=0.31u L=0.04u
M124 g13460 g2354 VDD VDD pmos W=0.41u L=0.04u
M125 g13461 g2356 VSS VSS nmos W=0.31u L=0.04u
M126 g13461 g2356 VDD VDD pmos W=0.41u L=0.04u
M127 g13462 g2358 VSS VSS nmos W=0.31u L=0.04u
M128 g13462 g2358 VDD VDD pmos W=0.41u L=0.04u
M129 g13463 g2360 VSS VSS nmos W=0.31u L=0.04u
M130 g13463 g2360 VDD VDD pmos W=0.41u L=0.04u
M131 g13464 g2362 VSS VSS nmos W=0.31u L=0.04u
M132 g13464 g2362 VDD VDD pmos W=0.41u L=0.04u
M133 g13465 g2364 VSS VSS nmos W=0.31u L=0.04u
M134 g13465 g2364 VDD VDD pmos W=0.41u L=0.04u
M135 g13466 g2366 VSS VSS nmos W=0.31u L=0.04u
M136 g13466 g2366 VDD VDD pmos W=0.41u L=0.04u
M137 g16476 n638 VSS VSS nmos W=0.31u L=0.04u
M138 g16476 n638 VDD VDD pmos W=0.41u L=0.04u
M139 g16477 n654 VSS VSS nmos W=0.31u L=0.04u
M140 g16477 n654 VDD VDD pmos W=0.41u L=0.04u
M141 g16478 n653 VSS VSS nmos W=0.31u L=0.04u
M142 g16478 n653 VDD VDD pmos W=0.41u L=0.04u
M143 g16479 n652 VSS VSS nmos W=0.31u L=0.04u
M144 g16479 n652 VDD VDD pmos W=0.41u L=0.04u
M145 g16480 n651 VSS VSS nmos W=0.31u L=0.04u
M146 g16480 n651 VDD VDD pmos W=0.41u L=0.04u
M147 g16481 n650 VSS VSS nmos W=0.31u L=0.04u
M148 g16481 n650 VDD VDD pmos W=0.41u L=0.04u
M149 g16482 n649 VSS VSS nmos W=0.31u L=0.04u
M150 g16482 n649 VDD VDD pmos W=0.41u L=0.04u
M151 g16483 n648 VSS VSS nmos W=0.31u L=0.04u
M152 g16483 n648 VDD VDD pmos W=0.41u L=0.04u
M153 g16484 n647 VSS VSS nmos W=0.31u L=0.04u
M154 g16484 n647 VDD VDD pmos W=0.41u L=0.04u
M155 g16485 n658 VSS VSS nmos W=0.31u L=0.04u
M156 g16485 n658 VDD VDD pmos W=0.41u L=0.04u
M157 g16486 n646 VSS VSS nmos W=0.31u L=0.04u
M158 g16486 n646 VDD VDD pmos W=0.41u L=0.04u
M159 g16487 n645 VSS VSS nmos W=0.31u L=0.04u
M160 g16487 n645 VDD VDD pmos W=0.41u L=0.04u
M161 g16488 n644 VSS VSS nmos W=0.31u L=0.04u
M162 g16488 n644 VDD VDD pmos W=0.41u L=0.04u
M163 g16489 n643 VSS VSS nmos W=0.31u L=0.04u
M164 g16489 n643 VDD VDD pmos W=0.41u L=0.04u
M165 g16490 n642 VSS VSS nmos W=0.31u L=0.04u
M166 g16490 n642 VDD VDD pmos W=0.41u L=0.04u
M167 g16491 n641 VSS VSS nmos W=0.31u L=0.04u
M168 g16491 n641 VDD VDD pmos W=0.41u L=0.04u
M169 g16492 n640 VSS VSS nmos W=0.31u L=0.04u
M170 g16492 n640 VDD VDD pmos W=0.41u L=0.04u
M171 g16493 n639 VSS VSS nmos W=0.31u L=0.04u
M172 g16493 n639 VDD VDD pmos W=0.41u L=0.04u
M173 g11496 II14030 VSS VSS nmos W=0.31u L=0.04u
M174 g11496 II14030 VDD VDD pmos W=0.41u L=0.04u
M175 g13407 II20520 VSS VSS nmos W=0.31u L=0.04u
M176 g13407 II20520 VDD VDD pmos W=0.41u L=0.04u
M177 g11512 II18512 VSS VSS nmos W=0.31u L=0.04u
M178 g11512 II18512 VDD VDD pmos W=0.41u L=0.04u
M179 g11515 II18521 VSS VSS nmos W=0.31u L=0.04u
M180 g11515 II18521 VDD VDD pmos W=0.41u L=0.04u
M181 g11516 II18524 VSS VSS nmos W=0.31u L=0.04u
M182 g11516 II18524 VDD VDD pmos W=0.41u L=0.04u
M183 g11517 II18527 VSS VSS nmos W=0.31u L=0.04u
M184 g11517 II18527 VDD VDD pmos W=0.41u L=0.04u
M185 g11513 II18515 VSS VSS nmos W=0.31u L=0.04u
M186 g11513 II18515 VDD VDD pmos W=0.41u L=0.04u
M187 g11514 II18518 VSS VSS nmos W=0.31u L=0.04u
M188 g11514 II18518 VDD VDD pmos W=0.41u L=0.04u
M189 g11523 II14052 VSS VSS nmos W=0.31u L=0.04u
M190 g11523 II14052 VDD VDD pmos W=0.41u L=0.04u
M191 g13423 II20568 VSS VSS nmos W=0.31u L=0.04u
M192 g13423 II20568 VDD VDD pmos W=0.41u L=0.04u
M193 g11539 II18593 VSS VSS nmos W=0.31u L=0.04u
M194 g11539 II18593 VDD VDD pmos W=0.41u L=0.04u
M195 g11542 II18602 VSS VSS nmos W=0.31u L=0.04u
M196 g11542 II18602 VDD VDD pmos W=0.41u L=0.04u
M197 g11543 II18605 VSS VSS nmos W=0.31u L=0.04u
M198 g11543 II18605 VDD VDD pmos W=0.41u L=0.04u
M199 g11544 II18608 VSS VSS nmos W=0.31u L=0.04u
M200 g11544 II18608 VDD VDD pmos W=0.41u L=0.04u
M201 g11540 II18596 VSS VSS nmos W=0.31u L=0.04u
M202 g11540 II18596 VDD VDD pmos W=0.41u L=0.04u
M203 g11541 II18599 VSS VSS nmos W=0.31u L=0.04u
M204 g11541 II18599 VDD VDD pmos W=0.41u L=0.04u
M205 g11550 II14069 VSS VSS nmos W=0.31u L=0.04u
M206 g11550 II14069 VDD VDD pmos W=0.41u L=0.04u
M207 g13439 II20616 VSS VSS nmos W=0.31u L=0.04u
M208 g13439 II20616 VDD VDD pmos W=0.41u L=0.04u
M209 g11566 II18674 VSS VSS nmos W=0.31u L=0.04u
M210 g11566 II18674 VDD VDD pmos W=0.41u L=0.04u
M211 g11569 II18683 VSS VSS nmos W=0.31u L=0.04u
M212 g11569 II18683 VDD VDD pmos W=0.41u L=0.04u
M213 g11570 II18686 VSS VSS nmos W=0.31u L=0.04u
M214 g11570 II18686 VDD VDD pmos W=0.41u L=0.04u
M215 g11571 II18689 VSS VSS nmos W=0.31u L=0.04u
M216 g11571 II18689 VDD VDD pmos W=0.41u L=0.04u
M217 g11567 II18677 VSS VSS nmos W=0.31u L=0.04u
M218 g11567 II18677 VDD VDD pmos W=0.41u L=0.04u
M219 g11568 II18680 VSS VSS nmos W=0.31u L=0.04u
M220 g11568 II18680 VDD VDD pmos W=0.41u L=0.04u
M221 g11577 II14094 VSS VSS nmos W=0.31u L=0.04u
M222 g11577 II14094 VDD VDD pmos W=0.41u L=0.04u
M223 g13455 II20664 VSS VSS nmos W=0.31u L=0.04u
M224 g13455 II20664 VDD VDD pmos W=0.41u L=0.04u
M225 g11593 II18755 VSS VSS nmos W=0.31u L=0.04u
M226 g11593 II18755 VDD VDD pmos W=0.41u L=0.04u
M227 g11596 II18764 VSS VSS nmos W=0.31u L=0.04u
M228 g11596 II18764 VDD VDD pmos W=0.41u L=0.04u
M229 g11597 II18767 VSS VSS nmos W=0.31u L=0.04u
M230 g11597 II18767 VDD VDD pmos W=0.41u L=0.04u
M231 g11598 II18770 VSS VSS nmos W=0.31u L=0.04u
M232 g11598 II18770 VDD VDD pmos W=0.41u L=0.04u
M233 g11594 II18758 VSS VSS nmos W=0.31u L=0.04u
M234 g11594 II18758 VDD VDD pmos W=0.41u L=0.04u
M235 g11595 II18761 VSS VSS nmos W=0.31u L=0.04u
M236 g11595 II18761 VDD VDD pmos W=0.41u L=0.04u
M237 g16494 N159 VSS VSS nmos W=0.31u L=0.04u
M238 g16494 N159 VDD VDD pmos W=0.41u L=0.04u
M239 g20556 n3448 VSS VSS nmos W=0.31u L=0.04u
M240 g20556 n3448 VDD VDD pmos W=0.41u L=0.04u
M241 g20560 n3548 VSS VSS nmos W=0.31u L=0.04u
M242 g20560 n3548 VDD VDD pmos W=0.41u L=0.04u
M243 g20564 n3648 VSS VSS nmos W=0.31u L=0.04u
M244 g20564 n3648 VDD VDD pmos W=0.41u L=0.04u
M245 g20568 n3748 VSS VSS nmos W=0.31u L=0.04u
M246 g20568 n3748 VDD VDD pmos W=0.41u L=0.04u
M247 g19061 N466 VSS VSS nmos W=0.31u L=0.04u
M248 g19061 N466 VDD VDD pmos W=0.41u L=0.04u
M249 g19060 N461 VSS VSS nmos W=0.31u L=0.04u
M250 g19060 N461 VDD VDD pmos W=0.41u L=0.04u
M251 g21966 n3828 VSS VSS nmos W=0.31u L=0.04u
M252 g21966 n3828 VDD VDD pmos W=0.41u L=0.04u
M253 g21964 n3829 VSS VSS nmos W=0.31u L=0.04u
M254 g21964 n3829 VDD VDD pmos W=0.41u L=0.04u
M255 g25993 n3519 VSS VSS nmos W=0.31u L=0.04u
M256 g25993 n3519 VDD VDD pmos W=0.41u L=0.04u
M257 g29453 g28488 VSS VSS nmos W=0.31u L=0.04u
M258 g29453 g28488 VDD VDD pmos W=0.41u L=0.04u
M259 g29456 g28489 VSS VSS nmos W=0.31u L=0.04u
M260 g29456 g28489 VDD VDD pmos W=0.41u L=0.04u
M261 g29454 g28525 VSS VSS nmos W=0.31u L=0.04u
M262 g29454 g28525 VDD VDD pmos W=0.41u L=0.04u
M263 g29455 g28470 VSS VSS nmos W=0.31u L=0.04u
M264 g29455 g28470 VDD VDD pmos W=0.41u L=0.04u
M265 g23317 n3809 VSS VSS nmos W=0.31u L=0.04u
M266 g23317 n3809 VDD VDD pmos W=0.41u L=0.04u
M267 g23318 n3798 VSS VSS nmos W=0.31u L=0.04u
M268 g23318 n3798 VDD VDD pmos W=0.41u L=0.04u
M269 g21951 N1004 VSS VSS nmos W=0.31u L=0.04u
M270 g21951 N1004 VDD VDD pmos W=0.41u L=0.04u
M271 g21965 N1181 VSS VSS nmos W=0.31u L=0.04u
M272 g21965 N1181 VDD VDD pmos W=0.41u L=0.04u
M273 g27239 n3804 VSS VSS nmos W=0.31u L=0.04u
M274 g27239 n3804 VDD VDD pmos W=0.41u L=0.04u
M275 g27716 n3805 VSS VSS nmos W=0.31u L=0.04u
M276 g27716 n3805 VDD VDD pmos W=0.41u L=0.04u
M277 g20571 n2743 VSS VSS nmos W=0.31u L=0.04u
M278 g20571 n2743 VDD VDD pmos W=0.41u L=0.04u
M279 g20588 n2742 VSS VSS nmos W=0.31u L=0.04u
M280 g20588 n2742 VDD VDD pmos W=0.41u L=0.04u
M281 g26746 n2733 VSS VSS nmos W=0.31u L=0.04u
M282 g26746 n2733 VDD VDD pmos W=0.41u L=0.04u
M283 g26749 n3808 VSS VSS nmos W=0.31u L=0.04u
M284 g26749 n3808 VDD VDD pmos W=0.41u L=0.04u
M285 g27237 n2737 VSS VSS nmos W=0.31u L=0.04u
M286 g27237 n2737 VDD VDD pmos W=0.41u L=0.04u
M287 g27715 n2736 VSS VSS nmos W=0.31u L=0.04u
M288 g27715 n2736 VDD VDD pmos W=0.41u L=0.04u
M289 g20572 n2920 VSS VSS nmos W=0.31u L=0.04u
M290 g20572 n2920 VDD VDD pmos W=0.41u L=0.04u
M291 g20573 n2919 VSS VSS nmos W=0.31u L=0.04u
M292 g20573 n2919 VDD VDD pmos W=0.41u L=0.04u
M293 g20574 n2918 VSS VSS nmos W=0.31u L=0.04u
M294 g20574 n2918 VDD VDD pmos W=0.41u L=0.04u
M295 g20575 n2917 VSS VSS nmos W=0.31u L=0.04u
M296 g20575 n2917 VDD VDD pmos W=0.41u L=0.04u
M297 g20576 n2916 VSS VSS nmos W=0.31u L=0.04u
M298 g20576 n2916 VDD VDD pmos W=0.41u L=0.04u
M299 g20577 n2914 VSS VSS nmos W=0.31u L=0.04u
M300 g20577 n2914 VDD VDD pmos W=0.41u L=0.04u
M301 g20578 n2913 VSS VSS nmos W=0.31u L=0.04u
M302 g20578 n2913 VDD VDD pmos W=0.41u L=0.04u
M303 g20579 n2911 VSS VSS nmos W=0.31u L=0.04u
M304 g20579 n2911 VDD VDD pmos W=0.41u L=0.04u
M305 g23313 n2909 VSS VSS nmos W=0.31u L=0.04u
M306 g23313 n2909 VDD VDD pmos W=0.41u L=0.04u
M307 g21960 n2893 VSS VSS nmos W=0.31u L=0.04u
M308 g21960 n2893 VDD VDD pmos W=0.41u L=0.04u
M309 g21961 n2890 VSS VSS nmos W=0.31u L=0.04u
M310 g21961 n2890 VDD VDD pmos W=0.41u L=0.04u
M311 g21962 n2887 VSS VSS nmos W=0.31u L=0.04u
M312 g21962 n2887 VDD VDD pmos W=0.41u L=0.04u
M313 g21963 n2885 VSS VSS nmos W=0.31u L=0.04u
M314 g21963 n2885 VDD VDD pmos W=0.41u L=0.04u
M315 g21947 n2902 VSS VSS nmos W=0.31u L=0.04u
M316 g21947 n2902 VDD VDD pmos W=0.41u L=0.04u
M317 g21948 n2901 VSS VSS nmos W=0.31u L=0.04u
M318 g21948 n2901 VDD VDD pmos W=0.41u L=0.04u
M319 g21949 n2900 VSS VSS nmos W=0.31u L=0.04u
M320 g21949 n2900 VDD VDD pmos W=0.41u L=0.04u
M321 g21950 n2899 VSS VSS nmos W=0.31u L=0.04u
M322 g21950 n2899 VDD VDD pmos W=0.41u L=0.04u
M323 g21952 n2894 VSS VSS nmos W=0.31u L=0.04u
M324 g21952 n2894 VDD VDD pmos W=0.41u L=0.04u
M325 g21953 n2891 VSS VSS nmos W=0.31u L=0.04u
M326 g21953 n2891 VDD VDD pmos W=0.41u L=0.04u
M327 g21954 n2888 VSS VSS nmos W=0.31u L=0.04u
M328 g21954 n2888 VDD VDD pmos W=0.41u L=0.04u
M329 g21955 n2897 VSS VSS nmos W=0.31u L=0.04u
M330 g21955 n2897 VDD VDD pmos W=0.41u L=0.04u
M331 g21956 n2895 VSS VSS nmos W=0.31u L=0.04u
M332 g21956 n2895 VDD VDD pmos W=0.41u L=0.04u
M333 g21957 n2892 VSS VSS nmos W=0.31u L=0.04u
M334 g21957 n2892 VDD VDD pmos W=0.41u L=0.04u
M335 g21958 n2889 VSS VSS nmos W=0.31u L=0.04u
M336 g21958 n2889 VDD VDD pmos W=0.41u L=0.04u
M337 g21959 n2886 VSS VSS nmos W=0.31u L=0.04u
M338 g21959 n2886 VDD VDD pmos W=0.41u L=0.04u
M339 g20587 n2910 VSS VSS nmos W=0.31u L=0.04u
M340 g20587 n2910 VDD VDD pmos W=0.41u L=0.04u
M341 g20585 n2903 VSS VSS nmos W=0.31u L=0.04u
M342 g20585 n2903 VDD VDD pmos W=0.41u L=0.04u
M343 g20586 n2904 VSS VSS nmos W=0.31u L=0.04u
M344 g20586 n2904 VDD VDD pmos W=0.41u L=0.04u
M345 g20584 n2906 VSS VSS nmos W=0.31u L=0.04u
M346 g20584 n2906 VDD VDD pmos W=0.41u L=0.04u
M347 g20583 n2908 VSS VSS nmos W=0.31u L=0.04u
M348 g20583 n2908 VDD VDD pmos W=0.41u L=0.04u
M349 g20582 n2912 VSS VSS nmos W=0.31u L=0.04u
M350 g20582 n2912 VDD VDD pmos W=0.41u L=0.04u
M351 g20581 n2915 VSS VSS nmos W=0.31u L=0.04u
M352 g20581 n2915 VDD VDD pmos W=0.41u L=0.04u
M353 g20580 n2905 VSS VSS nmos W=0.31u L=0.04u
M354 g20580 n2905 VDD VDD pmos W=0.41u L=0.04u
M355 g23314 n2907 VSS VSS nmos W=0.31u L=0.04u
M356 g23314 n2907 VDD VDD pmos W=0.41u L=0.04u
M357 g20630 n3269 VSS VSS nmos W=0.31u L=0.04u
M358 g20630 n3269 VDD VDD pmos W=0.41u L=0.04u
M359 g20631 n3281 VSS VSS nmos W=0.31u L=0.04u
M360 g20631 n3281 VDD VDD pmos W=0.41u L=0.04u
M361 g20632 n3304 VSS VSS nmos W=0.31u L=0.04u
M362 g20632 n3304 VDD VDD pmos W=0.41u L=0.04u
M363 g20609 n3280 VSS VSS nmos W=0.31u L=0.04u
M364 g20609 n3280 VDD VDD pmos W=0.41u L=0.04u
M365 g20610 n3292 VSS VSS nmos W=0.31u L=0.04u
M366 g20610 n3292 VDD VDD pmos W=0.41u L=0.04u
M367 g20611 n3303 VSS VSS nmos W=0.31u L=0.04u
M368 g20611 n3303 VDD VDD pmos W=0.41u L=0.04u
M369 g20612 n3279 VSS VSS nmos W=0.31u L=0.04u
M370 g20612 n3279 VDD VDD pmos W=0.41u L=0.04u
M371 g20613 n3291 VSS VSS nmos W=0.31u L=0.04u
M372 g20613 n3291 VDD VDD pmos W=0.41u L=0.04u
M373 g20614 n3302 VSS VSS nmos W=0.31u L=0.04u
M374 g20614 n3302 VDD VDD pmos W=0.41u L=0.04u
M375 g20615 n3278 VSS VSS nmos W=0.31u L=0.04u
M376 g20615 n3278 VDD VDD pmos W=0.41u L=0.04u
M377 g20616 n3290 VSS VSS nmos W=0.31u L=0.04u
M378 g20616 n3290 VDD VDD pmos W=0.41u L=0.04u
M379 g20617 n3301 VSS VSS nmos W=0.31u L=0.04u
M380 g20617 n3301 VDD VDD pmos W=0.41u L=0.04u
M381 g29163 n3275 VSS VSS nmos W=0.31u L=0.04u
M382 g29163 n3275 VDD VDD pmos W=0.41u L=0.04u
M383 g29164 n3287 VSS VSS nmos W=0.31u L=0.04u
M384 g29164 n3287 VDD VDD pmos W=0.41u L=0.04u
M385 g29165 n3298 VSS VSS nmos W=0.31u L=0.04u
M386 g29165 n3298 VDD VDD pmos W=0.41u L=0.04u
M387 g30120 n3273 VSS VSS nmos W=0.31u L=0.04u
M388 g30120 n3273 VDD VDD pmos W=0.41u L=0.04u
M389 g30121 n3285 VSS VSS nmos W=0.31u L=0.04u
M390 g30121 n3285 VDD VDD pmos W=0.41u L=0.04u
M391 g30122 n3296 VSS VSS nmos W=0.31u L=0.04u
M392 g30122 n3296 VDD VDD pmos W=0.41u L=0.04u
M393 g30941 n3271 VSS VSS nmos W=0.31u L=0.04u
M394 g30941 n3271 VDD VDD pmos W=0.41u L=0.04u
M395 g30942 n3283 VSS VSS nmos W=0.31u L=0.04u
M396 g30942 n3283 VDD VDD pmos W=0.41u L=0.04u
M397 g30943 n3294 VSS VSS nmos W=0.31u L=0.04u
M398 g30943 n3294 VDD VDD pmos W=0.41u L=0.04u
M399 g20618 n3276 VSS VSS nmos W=0.31u L=0.04u
M400 g20618 n3276 VDD VDD pmos W=0.41u L=0.04u
M401 g20619 n3288 VSS VSS nmos W=0.31u L=0.04u
M402 g20619 n3288 VDD VDD pmos W=0.41u L=0.04u
M403 g20620 n3299 VSS VSS nmos W=0.31u L=0.04u
M404 g20620 n3299 VDD VDD pmos W=0.41u L=0.04u
M405 g20621 n3274 VSS VSS nmos W=0.31u L=0.04u
M406 g20621 n3274 VDD VDD pmos W=0.41u L=0.04u
M407 g20622 n3286 VSS VSS nmos W=0.31u L=0.04u
M408 g20622 n3286 VDD VDD pmos W=0.41u L=0.04u
M409 g20623 n3297 VSS VSS nmos W=0.31u L=0.04u
M410 g20623 n3297 VDD VDD pmos W=0.41u L=0.04u
M411 g20624 n3272 VSS VSS nmos W=0.31u L=0.04u
M412 g20624 n3272 VDD VDD pmos W=0.41u L=0.04u
M413 g20625 n3284 VSS VSS nmos W=0.31u L=0.04u
M414 g20625 n3284 VDD VDD pmos W=0.41u L=0.04u
M415 g20626 n3295 VSS VSS nmos W=0.31u L=0.04u
M416 g20626 n3295 VDD VDD pmos W=0.41u L=0.04u
M417 g20627 n3270 VSS VSS nmos W=0.31u L=0.04u
M418 g20627 n3270 VDD VDD pmos W=0.41u L=0.04u
M419 g20628 n3282 VSS VSS nmos W=0.31u L=0.04u
M420 g20628 n3282 VDD VDD pmos W=0.41u L=0.04u
M421 g20629 n3293 VSS VSS nmos W=0.31u L=0.04u
M422 g20629 n3293 VDD VDD pmos W=0.41u L=0.04u
M423 g24292 n3364 VSS VSS nmos W=0.31u L=0.04u
M424 g24292 n3364 VDD VDD pmos W=0.41u L=0.04u
M425 g24293 n3363 VSS VSS nmos W=0.31u L=0.04u
M426 g24293 n3363 VDD VDD pmos W=0.41u L=0.04u
M427 g24294 n3362 VSS VSS nmos W=0.31u L=0.04u
M428 g24294 n3362 VDD VDD pmos W=0.41u L=0.04u
M429 g25139 n3372 VSS VSS nmos W=0.31u L=0.04u
M430 g25139 n3372 VDD VDD pmos W=0.41u L=0.04u
M431 g25131 n3371 VSS VSS nmos W=0.31u L=0.04u
M432 g25131 n3371 VDD VDD pmos W=0.41u L=0.04u
M433 g25132 n3373 VSS VSS nmos W=0.31u L=0.04u
M434 g25132 n3373 VDD VDD pmos W=0.41u L=0.04u
M435 g25984 n3395 VSS VSS nmos W=0.31u L=0.04u
M436 g25984 n3395 VDD VDD pmos W=0.41u L=0.04u
M437 g24333 n3506 VSS VSS nmos W=0.31u L=0.04u
M438 g24333 n3506 VDD VDD pmos W=0.41u L=0.04u
M439 g24334 n3505 VSS VSS nmos W=0.31u L=0.04u
M440 g24334 n3505 VDD VDD pmos W=0.41u L=0.04u
M441 g24335 n3504 VSS VSS nmos W=0.31u L=0.04u
M442 g24335 n3504 VDD VDD pmos W=0.41u L=0.04u
M443 g25150 n3514 VSS VSS nmos W=0.31u L=0.04u
M444 g25150 n3514 VDD VDD pmos W=0.41u L=0.04u
M445 g25142 n3513 VSS VSS nmos W=0.31u L=0.04u
M446 g25142 n3513 VDD VDD pmos W=0.41u L=0.04u
M447 g25143 n3515 VSS VSS nmos W=0.31u L=0.04u
M448 g25143 n3515 VDD VDD pmos W=0.41u L=0.04u
M449 g24374 n3606 VSS VSS nmos W=0.31u L=0.04u
M450 g24374 n3606 VDD VDD pmos W=0.41u L=0.04u
M451 g24375 n3605 VSS VSS nmos W=0.31u L=0.04u
M452 g24375 n3605 VDD VDD pmos W=0.41u L=0.04u
M453 g24376 n3604 VSS VSS nmos W=0.31u L=0.04u
M454 g24376 n3604 VDD VDD pmos W=0.41u L=0.04u
M455 g25161 n3614 VSS VSS nmos W=0.31u L=0.04u
M456 g25161 n3614 VDD VDD pmos W=0.41u L=0.04u
M457 g25153 n3613 VSS VSS nmos W=0.31u L=0.04u
M458 g25153 n3613 VDD VDD pmos W=0.41u L=0.04u
M459 g25154 n3615 VSS VSS nmos W=0.31u L=0.04u
M460 g25154 n3615 VDD VDD pmos W=0.41u L=0.04u
M461 g26002 n3619 VSS VSS nmos W=0.31u L=0.04u
M462 g26002 n3619 VDD VDD pmos W=0.41u L=0.04u
M463 g24415 n3706 VSS VSS nmos W=0.31u L=0.04u
M464 g24415 n3706 VDD VDD pmos W=0.41u L=0.04u
M465 g24416 n3705 VSS VSS nmos W=0.31u L=0.04u
M466 g24416 n3705 VDD VDD pmos W=0.41u L=0.04u
M467 g24417 n3704 VSS VSS nmos W=0.31u L=0.04u
M468 g24417 n3704 VDD VDD pmos W=0.41u L=0.04u
M469 g25172 n3714 VSS VSS nmos W=0.31u L=0.04u
M470 g25172 n3714 VDD VDD pmos W=0.41u L=0.04u
M471 g25164 n3713 VSS VSS nmos W=0.31u L=0.04u
M472 g25164 n3713 VDD VDD pmos W=0.41u L=0.04u
M473 g25165 n3715 VSS VSS nmos W=0.31u L=0.04u
M474 g25165 n3715 VDD VDD pmos W=0.41u L=0.04u
M475 g26011 n3719 VSS VSS nmos W=0.31u L=0.04u
M476 g26011 n3719 VDD VDD pmos W=0.41u L=0.04u
M477 g20595 n3810 VSS VSS nmos W=0.31u L=0.04u
M478 g20595 n3810 VDD VDD pmos W=0.41u L=0.04u
M479 g20596 n3811 VSS VSS nmos W=0.31u L=0.04u
M480 g20596 n3811 VDD VDD pmos W=0.41u L=0.04u
M481 g20597 n3812 VSS VSS nmos W=0.31u L=0.04u
M482 g20597 n3812 VDD VDD pmos W=0.41u L=0.04u
M483 g20598 n3813 VSS VSS nmos W=0.31u L=0.04u
M484 g20598 n3813 VDD VDD pmos W=0.41u L=0.04u
M485 g20599 n3814 VSS VSS nmos W=0.31u L=0.04u
M486 g20599 n3814 VDD VDD pmos W=0.41u L=0.04u
M487 g20600 n3815 VSS VSS nmos W=0.31u L=0.04u
M488 g20600 n3815 VDD VDD pmos W=0.41u L=0.04u
M489 g20601 n3816 VSS VSS nmos W=0.31u L=0.04u
M490 g20601 n3816 VDD VDD pmos W=0.41u L=0.04u
M491 g20602 n3817 VSS VSS nmos W=0.31u L=0.04u
M492 g20602 n3817 VDD VDD pmos W=0.41u L=0.04u
M493 g20603 n3818 VSS VSS nmos W=0.31u L=0.04u
M494 g20603 n3818 VDD VDD pmos W=0.41u L=0.04u
M495 g20605 n3819 VSS VSS nmos W=0.31u L=0.04u
M496 g20605 n3819 VDD VDD pmos W=0.41u L=0.04u
M497 g20606 n3820 VSS VSS nmos W=0.31u L=0.04u
M498 g20606 n3820 VDD VDD pmos W=0.41u L=0.04u
M499 g20607 n3821 VSS VSS nmos W=0.31u L=0.04u
M500 g20607 n3821 VDD VDD pmos W=0.41u L=0.04u
M501 g20608 n3822 VSS VSS nmos W=0.31u L=0.04u
M502 g20608 n3822 VDD VDD pmos W=0.41u L=0.04u
M503 g20589 n3823 VSS VSS nmos W=0.31u L=0.04u
M504 g20589 n3823 VDD VDD pmos W=0.41u L=0.04u
M505 g20590 n3824 VSS VSS nmos W=0.31u L=0.04u
M506 g20590 n3824 VDD VDD pmos W=0.41u L=0.04u
M507 g20591 n3825 VSS VSS nmos W=0.31u L=0.04u
M508 g20591 n3825 VDD VDD pmos W=0.41u L=0.04u
M509 g20592 n3826 VSS VSS nmos W=0.31u L=0.04u
M510 g20592 n3826 VDD VDD pmos W=0.41u L=0.04u
M511 g20593 n3827 VSS VSS nmos W=0.31u L=0.04u
M512 g20593 n3827 VDD VDD pmos W=0.41u L=0.04u
M513 g26751 n3277 VSS VSS nmos W=0.31u L=0.04u
M514 g26751 n3277 VDD VDD pmos W=0.41u L=0.04u
M515 g26752 n3289 VSS VSS nmos W=0.31u L=0.04u
M516 g26752 n3289 VDD VDD pmos W=0.41u L=0.04u
M517 g26753 n3300 VSS VSS nmos W=0.31u L=0.04u
M518 g26753 n3300 VDD VDD pmos W=0.41u L=0.04u
M519 g29655 g28954 VSS VSS nmos W=0.31u L=0.04u
M520 g29655 g28954 VDD VDD pmos W=0.41u L=0.04u
M521 g30119 g29761 VSS VSS nmos W=0.31u L=0.04u
M522 g30119 g29761 VDD VDD pmos W=0.41u L=0.04u
M523 g30940 g30685 VSS VSS nmos W=0.31u L=0.04u
M524 g30940 g30685 VDD VDD pmos W=0.41u L=0.04u
M525 g30989 g30970 VSS VSS nmos W=0.31u L=0.04u
M526 g30989 g30970 VDD VDD pmos W=0.41u L=0.04u
M527 g23312 n2898 VSS VSS nmos W=0.31u L=0.04u
M528 g23312 n2898 VDD VDD pmos W=0.41u L=0.04u
M529 g23316 n2896 VSS VSS nmos W=0.31u L=0.04u
M530 g23316 n2896 VDD VDD pmos W=0.41u L=0.04u
M531 g27238 n3800 VSS VSS nmos W=0.31u L=0.04u
M532 g27238 n3800 VDD VDD pmos W=0.41u L=0.04u
M533 g29457 g28499 VSS VSS nmos W=0.31u L=0.04u
M534 g29457 g28499 VDD VDD pmos W=0.41u L=0.04u
M535 g29458 g28528 VSS VSS nmos W=0.31u L=0.04u
M536 g29458 g28528 VDD VDD pmos W=0.41u L=0.04u
M537 g25144 n3518 VSS VSS nmos W=0.31u L=0.04u
M538 g25144 n3518 VDD VDD pmos W=0.41u L=0.04u
M539 g25145 n3517 VSS VSS nmos W=0.31u L=0.04u
M540 g25145 n3517 VDD VDD pmos W=0.41u L=0.04u
M541 g25146 n3516 VSS VSS nmos W=0.31u L=0.04u
M542 g25146 n3516 VDD VDD pmos W=0.41u L=0.04u
M543 g25133 n3376 VSS VSS nmos W=0.31u L=0.04u
M544 g25133 n3376 VDD VDD pmos W=0.41u L=0.04u
M545 g25134 n3375 VSS VSS nmos W=0.31u L=0.04u
M546 g25134 n3375 VDD VDD pmos W=0.41u L=0.04u
M547 g25135 n3374 VSS VSS nmos W=0.31u L=0.04u
M548 g25135 n3374 VDD VDD pmos W=0.41u L=0.04u
M549 g25155 n3618 VSS VSS nmos W=0.31u L=0.04u
M550 g25155 n3618 VDD VDD pmos W=0.41u L=0.04u
M551 g25156 n3617 VSS VSS nmos W=0.31u L=0.04u
M552 g25156 n3617 VDD VDD pmos W=0.41u L=0.04u
M553 g25157 n3616 VSS VSS nmos W=0.31u L=0.04u
M554 g25157 n3616 VDD VDD pmos W=0.41u L=0.04u
M555 g25166 n3718 VSS VSS nmos W=0.31u L=0.04u
M556 g25166 n3718 VDD VDD pmos W=0.41u L=0.04u
M557 g25167 n3717 VSS VSS nmos W=0.31u L=0.04u
M558 g25167 n3717 VDD VDD pmos W=0.41u L=0.04u
M559 g25168 n3716 VSS VSS nmos W=0.31u L=0.04u
M560 g25168 n3716 VDD VDD pmos W=0.41u L=0.04u
M561 g29972 g29569 VSS VSS nmos W=0.31u L=0.04u
M562 g29972 g29569 VDD VDD pmos W=0.41u L=0.04u
M563 g29973 g29577 VSS VSS nmos W=0.31u L=0.04u
M564 g29973 g29577 VDD VDD pmos W=0.41u L=0.04u
M565 g29974 g29552 VSS VSS nmos W=0.31u L=0.04u
M566 g29974 g29552 VDD VDD pmos W=0.41u L=0.04u
M567 g29975 g29570 VSS VSS nmos W=0.31u L=0.04u
M568 g29975 g29570 VDD VDD pmos W=0.41u L=0.04u
M569 g29976 g29576 VSS VSS nmos W=0.31u L=0.04u
M570 g29976 g29576 VDD VDD pmos W=0.41u L=0.04u
M571 g29977 g29578 VSS VSS nmos W=0.31u L=0.04u
M572 g29977 g29578 VDD VDD pmos W=0.41u L=0.04u
M573 g30908 g30400 VSS VSS nmos W=0.31u L=0.04u
M574 g30908 g30400 VDD VDD pmos W=0.41u L=0.04u
M575 g30909 g30405 VSS VSS nmos W=0.31u L=0.04u
M576 g30909 g30405 VDD VDD pmos W=0.41u L=0.04u
M577 g30910 g30399 VSS VSS nmos W=0.31u L=0.04u
M578 g30910 g30399 VDD VDD pmos W=0.41u L=0.04u
M579 g30911 g30401 VSS VSS nmos W=0.31u L=0.04u
M580 g30911 g30401 VDD VDD pmos W=0.41u L=0.04u
M581 g30912 g30404 VSS VSS nmos W=0.31u L=0.04u
M582 g30912 g30404 VDD VDD pmos W=0.41u L=0.04u
M583 g30913 g30406 VSS VSS nmos W=0.31u L=0.04u
M584 g30913 g30406 VDD VDD pmos W=0.41u L=0.04u
M585 g30980 g30955 VSS VSS nmos W=0.31u L=0.04u
M586 g30980 g30955 VDD VDD pmos W=0.41u L=0.04u
M587 g30981 g30960 VSS VSS nmos W=0.31u L=0.04u
M588 g30981 g30960 VDD VDD pmos W=0.41u L=0.04u
M589 g30982 g30954 VSS VSS nmos W=0.31u L=0.04u
M590 g30982 g30954 VDD VDD pmos W=0.41u L=0.04u
M591 g30983 g30956 VSS VSS nmos W=0.31u L=0.04u
M592 g30983 g30956 VDD VDD pmos W=0.41u L=0.04u
M593 g30984 g30959 VSS VSS nmos W=0.31u L=0.04u
M594 g30984 g30959 VDD VDD pmos W=0.41u L=0.04u
M595 g30985 g30961 VSS VSS nmos W=0.31u L=0.04u
M596 g30985 g30961 VDD VDD pmos W=0.41u L=0.04u
M597 g25136 n3370 VSS VSS nmos W=0.31u L=0.04u
M598 g25136 n3370 VDD VDD pmos W=0.41u L=0.04u
M599 g25137 n3369 VSS VSS nmos W=0.31u L=0.04u
M600 g25137 n3369 VDD VDD pmos W=0.41u L=0.04u
M601 g25138 n3368 VSS VSS nmos W=0.31u L=0.04u
M602 g25138 n3368 VDD VDD pmos W=0.41u L=0.04u
M603 g25147 n3512 VSS VSS nmos W=0.31u L=0.04u
M604 g25147 n3512 VDD VDD pmos W=0.41u L=0.04u
M605 g25148 n3511 VSS VSS nmos W=0.31u L=0.04u
M606 g25148 n3511 VDD VDD pmos W=0.41u L=0.04u
M607 g25149 n3510 VSS VSS nmos W=0.31u L=0.04u
M608 g25149 n3510 VDD VDD pmos W=0.41u L=0.04u
M609 g25158 n3612 VSS VSS nmos W=0.31u L=0.04u
M610 g25158 n3612 VDD VDD pmos W=0.41u L=0.04u
M611 g25159 n3611 VSS VSS nmos W=0.31u L=0.04u
M612 g25159 n3611 VDD VDD pmos W=0.41u L=0.04u
M613 g25160 n3610 VSS VSS nmos W=0.31u L=0.04u
M614 g25160 n3610 VDD VDD pmos W=0.41u L=0.04u
M615 g25169 n3712 VSS VSS nmos W=0.31u L=0.04u
M616 g25169 n3712 VDD VDD pmos W=0.41u L=0.04u
M617 g25170 n3711 VSS VSS nmos W=0.31u L=0.04u
M618 g25170 n3711 VDD VDD pmos W=0.41u L=0.04u
M619 g25171 n3710 VSS VSS nmos W=0.31u L=0.04u
M620 g25171 n3710 VDD VDD pmos W=0.41u L=0.04u
M621 g29627 n2831 VSS VSS nmos W=0.31u L=0.04u
M622 g29627 n2831 VDD VDD pmos W=0.41u L=0.04u
M623 g29794 n2832 VSS VSS nmos W=0.31u L=0.04u
M624 g29794 n2832 VDD VDD pmos W=0.41u L=0.04u
M625 g29634 n2821 VSS VSS nmos W=0.31u L=0.04u
M626 g29634 n2821 VDD VDD pmos W=0.41u L=0.04u
M627 g29798 n2822 VSS VSS nmos W=0.31u L=0.04u
M628 g29798 n2822 VDD VDD pmos W=0.41u L=0.04u
M629 g29641 n2811 VSS VSS nmos W=0.31u L=0.04u
M630 g29641 n2811 VDD VDD pmos W=0.41u L=0.04u
M631 g29802 n2812 VSS VSS nmos W=0.31u L=0.04u
M632 g29802 n2812 VDD VDD pmos W=0.41u L=0.04u
M633 g29648 n2801 VSS VSS nmos W=0.31u L=0.04u
M634 g29648 n2801 VDD VDD pmos W=0.41u L=0.04u
M635 g29806 n2802 VSS VSS nmos W=0.31u L=0.04u
M636 g29806 n2802 VDD VDD pmos W=0.41u L=0.04u
M637 g28677 n3488 VSS VSS nmos W=0.31u L=0.04u
M638 g28677 n3488 VDD VDD pmos W=0.41u L=0.04u
M639 g28682 n3588 VSS VSS nmos W=0.31u L=0.04u
M640 g28682 n3588 VDD VDD pmos W=0.41u L=0.04u
M641 g28687 n3688 VSS VSS nmos W=0.31u L=0.04u
M642 g28687 n3688 VDD VDD pmos W=0.41u L=0.04u
M643 g28692 n3788 VSS VSS nmos W=0.31u L=0.04u
M644 g28692 n3788 VDD VDD pmos W=0.41u L=0.04u
M645 g29978 g29571 VSS VSS nmos W=0.31u L=0.04u
M646 g29978 g29571 VDD VDD pmos W=0.41u L=0.04u
M647 g29979 g29574 VSS VSS nmos W=0.31u L=0.04u
M648 g29979 g29574 VDD VDD pmos W=0.41u L=0.04u
M649 g30914 g30402 VSS VSS nmos W=0.31u L=0.04u
M650 g30914 g30402 VDD VDD pmos W=0.41u L=0.04u
M651 g30915 g30403 VSS VSS nmos W=0.31u L=0.04u
M652 g30915 g30403 VDD VDD pmos W=0.41u L=0.04u
M653 g30986 g30957 VSS VSS nmos W=0.31u L=0.04u
M654 g30986 g30957 VDD VDD pmos W=0.41u L=0.04u
M655 g30987 g30958 VSS VSS nmos W=0.31u L=0.04u
M656 g30987 g30958 VDD VDD pmos W=0.41u L=0.04u
M657 g29459 g28490 VSS VSS nmos W=0.31u L=0.04u
M658 g29459 g28490 VDD VDD pmos W=0.41u L=0.04u
M659 g29460 g28495 VSS VSS nmos W=0.31u L=0.04u
M660 g29460 g28495 VDD VDD pmos W=0.41u L=0.04u
M661 g23195 n3421 VSS VSS nmos W=0.31u L=0.04u
M662 g23195 n3421 VDD VDD pmos W=0.41u L=0.04u
M663 g23197 n3419 VSS VSS nmos W=0.31u L=0.04u
M664 g23197 n3419 VDD VDD pmos W=0.41u L=0.04u
M665 g23233 n3541 VSS VSS nmos W=0.31u L=0.04u
M666 g23233 n3541 VDD VDD pmos W=0.41u L=0.04u
M667 g23235 n3539 VSS VSS nmos W=0.31u L=0.04u
M668 g23235 n3539 VDD VDD pmos W=0.41u L=0.04u
M669 g23271 n3641 VSS VSS nmos W=0.31u L=0.04u
M670 g23271 n3641 VDD VDD pmos W=0.41u L=0.04u
M671 g23273 n3639 VSS VSS nmos W=0.31u L=0.04u
M672 g23273 n3639 VDD VDD pmos W=0.41u L=0.04u
M673 g23309 n3741 VSS VSS nmos W=0.31u L=0.04u
M674 g23309 n3741 VDD VDD pmos W=0.41u L=0.04u
M675 g23311 n3739 VSS VSS nmos W=0.31u L=0.04u
M676 g23311 n3739 VDD VDD pmos W=0.41u L=0.04u
M677 g23192 n3407 VSS VSS nmos W=0.31u L=0.04u
M678 g23192 n3407 VDD VDD pmos W=0.41u L=0.04u
M679 g23194 n3405 VSS VSS nmos W=0.31u L=0.04u
M680 g23194 n3405 VDD VDD pmos W=0.41u L=0.04u
M681 g23230 n3527 VSS VSS nmos W=0.31u L=0.04u
M682 g23230 n3527 VDD VDD pmos W=0.41u L=0.04u
M683 g23232 n3525 VSS VSS nmos W=0.31u L=0.04u
M684 g23232 n3525 VDD VDD pmos W=0.41u L=0.04u
M685 g23268 n3627 VSS VSS nmos W=0.31u L=0.04u
M686 g23268 n3627 VDD VDD pmos W=0.41u L=0.04u
M687 g23270 n3625 VSS VSS nmos W=0.31u L=0.04u
M688 g23270 n3625 VDD VDD pmos W=0.41u L=0.04u
M689 g23306 n3727 VSS VSS nmos W=0.31u L=0.04u
M690 g23306 n3727 VDD VDD pmos W=0.41u L=0.04u
M691 g23308 n3725 VSS VSS nmos W=0.31u L=0.04u
M692 g23308 n3725 VDD VDD pmos W=0.41u L=0.04u
M693 g23193 n3406 VSS VSS nmos W=0.31u L=0.04u
M694 g23193 n3406 VDD VDD pmos W=0.41u L=0.04u
M695 g23196 n3420 VSS VSS nmos W=0.31u L=0.04u
M696 g23196 n3420 VDD VDD pmos W=0.41u L=0.04u
M697 g23231 n3526 VSS VSS nmos W=0.31u L=0.04u
M698 g23231 n3526 VDD VDD pmos W=0.41u L=0.04u
M699 g23234 n3540 VSS VSS nmos W=0.31u L=0.04u
M700 g23234 n3540 VDD VDD pmos W=0.41u L=0.04u
M701 g23269 n3626 VSS VSS nmos W=0.31u L=0.04u
M702 g23269 n3626 VDD VDD pmos W=0.41u L=0.04u
M703 g23272 n3640 VSS VSS nmos W=0.31u L=0.04u
M704 g23272 n3640 VDD VDD pmos W=0.41u L=0.04u
M705 g23307 n3726 VSS VSS nmos W=0.31u L=0.04u
M706 g23307 n3726 VDD VDD pmos W=0.41u L=0.04u
M707 g23310 n3740 VSS VSS nmos W=0.31u L=0.04u
M708 g23310 n3740 VDD VDD pmos W=0.41u L=0.04u
M709 g25175 n2740 VSS VSS nmos W=0.31u L=0.04u
M710 g25175 n2740 VDD VDD pmos W=0.41u L=0.04u
M711 g25177 n3801 VSS VSS nmos W=0.31u L=0.04u
M712 g25177 n3801 VDD VDD pmos W=0.41u L=0.04u
M713 g28220 n3414 VSS VSS nmos W=0.31u L=0.04u
M714 g28220 n3414 VDD VDD pmos W=0.41u L=0.04u
M715 g28223 n3413 VSS VSS nmos W=0.31u L=0.04u
M716 g28223 n3413 VDD VDD pmos W=0.41u L=0.04u
M717 g28226 n3412 VSS VSS nmos W=0.31u L=0.04u
M718 g28226 n3412 VDD VDD pmos W=0.41u L=0.04u
M719 g28229 n3411 VSS VSS nmos W=0.31u L=0.04u
M720 g28229 n3411 VDD VDD pmos W=0.41u L=0.04u
M721 g28245 n3524 VSS VSS nmos W=0.31u L=0.04u
M722 g28245 n3524 VDD VDD pmos W=0.41u L=0.04u
M723 g28246 n3534 VSS VSS nmos W=0.31u L=0.04u
M724 g28246 n3534 VDD VDD pmos W=0.41u L=0.04u
M725 g28248 n3523 VSS VSS nmos W=0.31u L=0.04u
M726 g28248 n3523 VDD VDD pmos W=0.41u L=0.04u
M727 g28249 n3533 VSS VSS nmos W=0.31u L=0.04u
M728 g28249 n3533 VDD VDD pmos W=0.41u L=0.04u
M729 g28251 n3522 VSS VSS nmos W=0.31u L=0.04u
M730 g28251 n3522 VDD VDD pmos W=0.41u L=0.04u
M731 g28252 n3532 VSS VSS nmos W=0.31u L=0.04u
M732 g28252 n3532 VDD VDD pmos W=0.41u L=0.04u
M733 g28254 n3521 VSS VSS nmos W=0.31u L=0.04u
M734 g28254 n3521 VDD VDD pmos W=0.41u L=0.04u
M735 g28255 n3531 VSS VSS nmos W=0.31u L=0.04u
M736 g28255 n3531 VDD VDD pmos W=0.41u L=0.04u
M737 g28271 n3624 VSS VSS nmos W=0.31u L=0.04u
M738 g28271 n3624 VDD VDD pmos W=0.41u L=0.04u
M739 g28274 n3623 VSS VSS nmos W=0.31u L=0.04u
M740 g28274 n3623 VDD VDD pmos W=0.41u L=0.04u
M741 g28277 n3622 VSS VSS nmos W=0.31u L=0.04u
M742 g28277 n3622 VDD VDD pmos W=0.41u L=0.04u
M743 g28280 n3621 VSS VSS nmos W=0.31u L=0.04u
M744 g28280 n3621 VDD VDD pmos W=0.41u L=0.04u
M745 g28297 n3724 VSS VSS nmos W=0.31u L=0.04u
M746 g28297 n3724 VDD VDD pmos W=0.41u L=0.04u
M747 g28300 n3723 VSS VSS nmos W=0.31u L=0.04u
M748 g28300 n3723 VDD VDD pmos W=0.41u L=0.04u
M749 g28303 n3722 VSS VSS nmos W=0.31u L=0.04u
M750 g28303 n3722 VDD VDD pmos W=0.41u L=0.04u
M751 g28306 n3721 VSS VSS nmos W=0.31u L=0.04u
M752 g28306 n3721 VDD VDD pmos W=0.41u L=0.04u
M753 g26748 n3799 VSS VSS nmos W=0.31u L=0.04u
M754 g26748 n3799 VDD VDD pmos W=0.41u L=0.04u
M755 g28272 n3634 VSS VSS nmos W=0.31u L=0.04u
M756 g28272 n3634 VDD VDD pmos W=0.41u L=0.04u
M757 g28275 n3633 VSS VSS nmos W=0.31u L=0.04u
M758 g28275 n3633 VDD VDD pmos W=0.41u L=0.04u
M759 g28278 n3632 VSS VSS nmos W=0.31u L=0.04u
M760 g28278 n3632 VDD VDD pmos W=0.41u L=0.04u
M761 g28281 n3631 VSS VSS nmos W=0.31u L=0.04u
M762 g28281 n3631 VDD VDD pmos W=0.41u L=0.04u
M763 g28298 n3734 VSS VSS nmos W=0.31u L=0.04u
M764 g28298 n3734 VDD VDD pmos W=0.41u L=0.04u
M765 g28301 n3733 VSS VSS nmos W=0.31u L=0.04u
M766 g28301 n3733 VDD VDD pmos W=0.41u L=0.04u
M767 g28304 n3732 VSS VSS nmos W=0.31u L=0.04u
M768 g28304 n3732 VDD VDD pmos W=0.41u L=0.04u
M769 g28307 n3731 VSS VSS nmos W=0.31u L=0.04u
M770 g28307 n3731 VDD VDD pmos W=0.41u L=0.04u
M771 g28219 n3404 VSS VSS nmos W=0.31u L=0.04u
M772 g28219 n3404 VDD VDD pmos W=0.41u L=0.04u
M773 g28222 n3403 VSS VSS nmos W=0.31u L=0.04u
M774 g28222 n3403 VDD VDD pmos W=0.41u L=0.04u
M775 g28225 n3402 VSS VSS nmos W=0.31u L=0.04u
M776 g28225 n3402 VDD VDD pmos W=0.41u L=0.04u
M777 g28228 n3401 VSS VSS nmos W=0.31u L=0.04u
M778 g28228 n3401 VDD VDD pmos W=0.41u L=0.04u
M779 g26750 n3803 VSS VSS nmos W=0.31u L=0.04u
M780 g26750 n3803 VDD VDD pmos W=0.41u L=0.04u
M781 g26747 n2738 VSS VSS nmos W=0.31u L=0.04u
M782 g26747 n2738 VDD VDD pmos W=0.41u L=0.04u
M783 g25174 n2735 VSS VSS nmos W=0.31u L=0.04u
M784 g25174 n2735 VDD VDD pmos W=0.41u L=0.04u
M785 g26020 n2734 VSS VSS nmos W=0.31u L=0.04u
M786 g26020 n2734 VDD VDD pmos W=0.41u L=0.04u
M787 g25176 n3806 VSS VSS nmos W=0.31u L=0.04u
M788 g25176 n3806 VDD VDD pmos W=0.41u L=0.04u
M789 g26022 n3807 VSS VSS nmos W=0.31u L=0.04u
M790 g26022 n3807 VDD VDD pmos W=0.41u L=0.04u
M791 g28221 n3418 VSS VSS nmos W=0.31u L=0.04u
M792 g28221 n3418 VDD VDD pmos W=0.41u L=0.04u
M793 g28224 n3417 VSS VSS nmos W=0.31u L=0.04u
M794 g28224 n3417 VDD VDD pmos W=0.41u L=0.04u
M795 g28227 n3416 VSS VSS nmos W=0.31u L=0.04u
M796 g28227 n3416 VDD VDD pmos W=0.41u L=0.04u
M797 g28230 n3415 VSS VSS nmos W=0.31u L=0.04u
M798 g28230 n3415 VDD VDD pmos W=0.41u L=0.04u
M799 g28247 n3538 VSS VSS nmos W=0.31u L=0.04u
M800 g28247 n3538 VDD VDD pmos W=0.41u L=0.04u
M801 g28250 n3537 VSS VSS nmos W=0.31u L=0.04u
M802 g28250 n3537 VDD VDD pmos W=0.41u L=0.04u
M803 g28253 n3536 VSS VSS nmos W=0.31u L=0.04u
M804 g28253 n3536 VDD VDD pmos W=0.41u L=0.04u
M805 g28256 n3535 VSS VSS nmos W=0.31u L=0.04u
M806 g28256 n3535 VDD VDD pmos W=0.41u L=0.04u
M807 g28273 n3638 VSS VSS nmos W=0.31u L=0.04u
M808 g28273 n3638 VDD VDD pmos W=0.41u L=0.04u
M809 g28276 n3637 VSS VSS nmos W=0.31u L=0.04u
M810 g28276 n3637 VDD VDD pmos W=0.41u L=0.04u
M811 g28279 n3636 VSS VSS nmos W=0.31u L=0.04u
M812 g28279 n3636 VDD VDD pmos W=0.41u L=0.04u
M813 g28282 n3635 VSS VSS nmos W=0.31u L=0.04u
M814 g28282 n3635 VDD VDD pmos W=0.41u L=0.04u
M815 g28299 n3738 VSS VSS nmos W=0.31u L=0.04u
M816 g28299 n3738 VDD VDD pmos W=0.41u L=0.04u
M817 g28302 n3737 VSS VSS nmos W=0.31u L=0.04u
M818 g28302 n3737 VDD VDD pmos W=0.41u L=0.04u
M819 g28305 n3736 VSS VSS nmos W=0.31u L=0.04u
M820 g28305 n3736 VDD VDD pmos W=0.41u L=0.04u
M821 g28308 n3735 VSS VSS nmos W=0.31u L=0.04u
M822 g28308 n3735 VDD VDD pmos W=0.41u L=0.04u
M823 g28207 n2879 VSS VSS nmos W=0.31u L=0.04u
M824 g28207 n2879 VDD VDD pmos W=0.41u L=0.04u
M825 g28208 n2880 VSS VSS nmos W=0.31u L=0.04u
M826 g28208 n2880 VDD VDD pmos W=0.41u L=0.04u
M827 g28209 n2884 VSS VSS nmos W=0.31u L=0.04u
M828 g28209 n2884 VDD VDD pmos W=0.41u L=0.04u
M829 g28210 n2877 VSS VSS nmos W=0.31u L=0.04u
M830 g28210 n2877 VDD VDD pmos W=0.41u L=0.04u
M831 g28211 n2878 VSS VSS nmos W=0.31u L=0.04u
M832 g28211 n2878 VDD VDD pmos W=0.41u L=0.04u
M833 g28212 n2883 VSS VSS nmos W=0.31u L=0.04u
M834 g28212 n2883 VDD VDD pmos W=0.41u L=0.04u
M835 g28213 n2875 VSS VSS nmos W=0.31u L=0.04u
M836 g28213 n2875 VDD VDD pmos W=0.41u L=0.04u
M837 g28214 n2876 VSS VSS nmos W=0.31u L=0.04u
M838 g28214 n2876 VDD VDD pmos W=0.41u L=0.04u
M839 g28215 n2882 VSS VSS nmos W=0.31u L=0.04u
M840 g28215 n2882 VDD VDD pmos W=0.41u L=0.04u
M841 g28216 n2873 VSS VSS nmos W=0.31u L=0.04u
M842 g28216 n2873 VDD VDD pmos W=0.41u L=0.04u
M843 g28217 n2874 VSS VSS nmos W=0.31u L=0.04u
M844 g28217 n2874 VDD VDD pmos W=0.41u L=0.04u
M845 g28218 n2881 VSS VSS nmos W=0.31u L=0.04u
M846 g28218 n2881 VDD VDD pmos W=0.41u L=0.04u
M847 g28233 n2866 VSS VSS nmos W=0.31u L=0.04u
M848 g28233 n2866 VDD VDD pmos W=0.41u L=0.04u
M849 g28235 n2871 VSS VSS nmos W=0.31u L=0.04u
M850 g28235 n2871 VDD VDD pmos W=0.41u L=0.04u
M851 g28236 n2864 VSS VSS nmos W=0.31u L=0.04u
M852 g28236 n2864 VDD VDD pmos W=0.41u L=0.04u
M853 g28238 n2870 VSS VSS nmos W=0.31u L=0.04u
M854 g28238 n2870 VDD VDD pmos W=0.41u L=0.04u
M855 g28239 n2862 VSS VSS nmos W=0.31u L=0.04u
M856 g28239 n2862 VDD VDD pmos W=0.41u L=0.04u
M857 g28241 n2869 VSS VSS nmos W=0.31u L=0.04u
M858 g28241 n2869 VDD VDD pmos W=0.41u L=0.04u
M859 g28242 n2860 VSS VSS nmos W=0.31u L=0.04u
M860 g28242 n2860 VDD VDD pmos W=0.41u L=0.04u
M861 g28244 n2868 VSS VSS nmos W=0.31u L=0.04u
M862 g28244 n2868 VDD VDD pmos W=0.41u L=0.04u
M863 g28259 n2853 VSS VSS nmos W=0.31u L=0.04u
M864 g28259 n2853 VDD VDD pmos W=0.41u L=0.04u
M865 g28261 n2858 VSS VSS nmos W=0.31u L=0.04u
M866 g28261 n2858 VDD VDD pmos W=0.41u L=0.04u
M867 g28262 n2851 VSS VSS nmos W=0.31u L=0.04u
M868 g28262 n2851 VDD VDD pmos W=0.41u L=0.04u
M869 g28264 n2857 VSS VSS nmos W=0.31u L=0.04u
M870 g28264 n2857 VDD VDD pmos W=0.41u L=0.04u
M871 g28265 n2849 VSS VSS nmos W=0.31u L=0.04u
M872 g28265 n2849 VDD VDD pmos W=0.41u L=0.04u
M873 g28267 n2856 VSS VSS nmos W=0.31u L=0.04u
M874 g28267 n2856 VDD VDD pmos W=0.41u L=0.04u
M875 g28268 n2847 VSS VSS nmos W=0.31u L=0.04u
M876 g28268 n2847 VDD VDD pmos W=0.41u L=0.04u
M877 g28270 n2855 VSS VSS nmos W=0.31u L=0.04u
M878 g28270 n2855 VDD VDD pmos W=0.41u L=0.04u
M879 g28285 n2840 VSS VSS nmos W=0.31u L=0.04u
M880 g28285 n2840 VDD VDD pmos W=0.41u L=0.04u
M881 g28287 n2845 VSS VSS nmos W=0.31u L=0.04u
M882 g28287 n2845 VDD VDD pmos W=0.41u L=0.04u
M883 g28288 n2838 VSS VSS nmos W=0.31u L=0.04u
M884 g28288 n2838 VDD VDD pmos W=0.41u L=0.04u
M885 g28290 n2844 VSS VSS nmos W=0.31u L=0.04u
M886 g28290 n2844 VDD VDD pmos W=0.41u L=0.04u
M887 g28291 n2836 VSS VSS nmos W=0.31u L=0.04u
M888 g28291 n2836 VDD VDD pmos W=0.41u L=0.04u
M889 g28293 n2843 VSS VSS nmos W=0.31u L=0.04u
M890 g28293 n2843 VDD VDD pmos W=0.41u L=0.04u
M891 g28294 n2834 VSS VSS nmos W=0.31u L=0.04u
M892 g28294 n2834 VDD VDD pmos W=0.41u L=0.04u
M893 g28296 n2842 VSS VSS nmos W=0.31u L=0.04u
M894 g28296 n2842 VDD VDD pmos W=0.41u L=0.04u
M895 g25986 n3345 VSS VSS nmos W=0.31u L=0.04u
M896 g25986 n3345 VDD VDD pmos W=0.41u L=0.04u
M897 g25989 n3354 VSS VSS nmos W=0.31u L=0.04u
M898 g25989 n3354 VDD VDD pmos W=0.41u L=0.04u
M899 g29136 n3339 VSS VSS nmos W=0.31u L=0.04u
M900 g29136 n3339 VDD VDD pmos W=0.41u L=0.04u
M901 g29133 n3342 VSS VSS nmos W=0.31u L=0.04u
M902 g29133 n3342 VDD VDD pmos W=0.41u L=0.04u
M903 g27195 n3409 VSS VSS nmos W=0.31u L=0.04u
M904 g27195 n3409 VDD VDD pmos W=0.41u L=0.04u
M905 g28234 n2867 VSS VSS nmos W=0.31u L=0.04u
M906 g28234 n2867 VDD VDD pmos W=0.41u L=0.04u
M907 g28237 n2865 VSS VSS nmos W=0.31u L=0.04u
M908 g28237 n2865 VDD VDD pmos W=0.41u L=0.04u
M909 g28240 n2863 VSS VSS nmos W=0.31u L=0.04u
M910 g28240 n2863 VDD VDD pmos W=0.41u L=0.04u
M911 g28243 n2861 VSS VSS nmos W=0.31u L=0.04u
M912 g28243 n2861 VDD VDD pmos W=0.41u L=0.04u
M913 g25995 n3333 VSS VSS nmos W=0.31u L=0.04u
M914 g25995 n3333 VDD VDD pmos W=0.41u L=0.04u
M915 g25998 n3351 VSS VSS nmos W=0.31u L=0.04u
M916 g25998 n3351 VDD VDD pmos W=0.41u L=0.04u
M917 g29144 n3327 VSS VSS nmos W=0.31u L=0.04u
M918 g29144 n3327 VDD VDD pmos W=0.41u L=0.04u
M919 g29141 n3330 VSS VSS nmos W=0.31u L=0.04u
M920 g29141 n3330 VDD VDD pmos W=0.41u L=0.04u
M921 g27210 n3529 VSS VSS nmos W=0.31u L=0.04u
M922 g27210 n3529 VDD VDD pmos W=0.41u L=0.04u
M923 g28260 n2854 VSS VSS nmos W=0.31u L=0.04u
M924 g28260 n2854 VDD VDD pmos W=0.41u L=0.04u
M925 g28263 n2852 VSS VSS nmos W=0.31u L=0.04u
M926 g28263 n2852 VDD VDD pmos W=0.41u L=0.04u
M927 g28266 n2850 VSS VSS nmos W=0.31u L=0.04u
M928 g28266 n2850 VDD VDD pmos W=0.41u L=0.04u
M929 g28269 n2848 VSS VSS nmos W=0.31u L=0.04u
M930 g28269 n2848 VDD VDD pmos W=0.41u L=0.04u
M931 g28286 n2841 VSS VSS nmos W=0.31u L=0.04u
M932 g28286 n2841 VDD VDD pmos W=0.41u L=0.04u
M933 g28289 n2839 VSS VSS nmos W=0.31u L=0.04u
M934 g28289 n2839 VDD VDD pmos W=0.41u L=0.04u
M935 g28292 n2837 VSS VSS nmos W=0.31u L=0.04u
M936 g28292 n2837 VDD VDD pmos W=0.41u L=0.04u
M937 g28295 n2835 VSS VSS nmos W=0.31u L=0.04u
M938 g28295 n2835 VDD VDD pmos W=0.41u L=0.04u
M939 g25994 n3334 VSS VSS nmos W=0.31u L=0.04u
M940 g25994 n3334 VDD VDD pmos W=0.41u L=0.04u
M941 g25997 n3352 VSS VSS nmos W=0.31u L=0.04u
M942 g25997 n3352 VDD VDD pmos W=0.41u L=0.04u
M943 g29143 n3328 VSS VSS nmos W=0.31u L=0.04u
M944 g29143 n3328 VDD VDD pmos W=0.41u L=0.04u
M945 g29140 n3331 VSS VSS nmos W=0.31u L=0.04u
M946 g29140 n3331 VDD VDD pmos W=0.41u L=0.04u
M947 g27209 n3520 VSS VSS nmos W=0.31u L=0.04u
M948 g27209 n3520 VDD VDD pmos W=0.41u L=0.04u
M949 g26003 n3325 VSS VSS nmos W=0.31u L=0.04u
M950 g26003 n3325 VDD VDD pmos W=0.41u L=0.04u
M951 g26006 n3349 VSS VSS nmos W=0.31u L=0.04u
M952 g26006 n3349 VDD VDD pmos W=0.41u L=0.04u
M953 g29151 n3319 VSS VSS nmos W=0.31u L=0.04u
M954 g29151 n3319 VDD VDD pmos W=0.41u L=0.04u
M955 g29148 n3322 VSS VSS nmos W=0.31u L=0.04u
M956 g29148 n3322 VDD VDD pmos W=0.41u L=0.04u
M957 g27224 n3620 VSS VSS nmos W=0.31u L=0.04u
M958 g27224 n3620 VDD VDD pmos W=0.41u L=0.04u
M959 g26012 n3316 VSS VSS nmos W=0.31u L=0.04u
M960 g26012 n3316 VDD VDD pmos W=0.41u L=0.04u
M961 g26015 n3337 VSS VSS nmos W=0.31u L=0.04u
M962 g26015 n3337 VDD VDD pmos W=0.41u L=0.04u
M963 g29159 n3310 VSS VSS nmos W=0.31u L=0.04u
M964 g29159 n3310 VDD VDD pmos W=0.41u L=0.04u
M965 g29156 n3313 VSS VSS nmos W=0.31u L=0.04u
M966 g29156 n3313 VDD VDD pmos W=0.41u L=0.04u
M967 g27233 n3720 VSS VSS nmos W=0.31u L=0.04u
M968 g27233 n3720 VDD VDD pmos W=0.41u L=0.04u
M969 g24423 n2741 VSS VSS nmos W=0.31u L=0.04u
M970 g24423 n2741 VDD VDD pmos W=0.41u L=0.04u
M971 g20558 n3450 VSS VSS nmos W=0.31u L=0.04u
M972 g20558 n3450 VDD VDD pmos W=0.41u L=0.04u
M973 g21943 n3497 VSS VSS nmos W=0.31u L=0.04u
M974 g21943 n3497 VDD VDD pmos W=0.41u L=0.04u
M975 g20562 n3550 VSS VSS nmos W=0.31u L=0.04u
M976 g20562 n3550 VDD VDD pmos W=0.41u L=0.04u
M977 g21944 n3597 VSS VSS nmos W=0.31u L=0.04u
M978 g21944 n3597 VDD VDD pmos W=0.41u L=0.04u
M979 g20566 n3650 VSS VSS nmos W=0.31u L=0.04u
M980 g20566 n3650 VDD VDD pmos W=0.41u L=0.04u
M981 g21945 n3697 VSS VSS nmos W=0.31u L=0.04u
M982 g21945 n3697 VDD VDD pmos W=0.41u L=0.04u
M983 g20570 n3750 VSS VSS nmos W=0.31u L=0.04u
M984 g20570 n3750 VDD VDD pmos W=0.41u L=0.04u
M985 g21946 n3797 VSS VSS nmos W=0.31u L=0.04u
M986 g21946 n3797 VDD VDD pmos W=0.41u L=0.04u
M987 g24259 n3181 VSS VSS nmos W=0.31u L=0.04u
M988 g24259 n3181 VDD VDD pmos W=0.41u L=0.04u
M989 g24260 n3180 VSS VSS nmos W=0.31u L=0.04u
M990 g24260 n3180 VDD VDD pmos W=0.41u L=0.04u
M991 g24262 n3178 VSS VSS nmos W=0.31u L=0.04u
M992 g24262 n3178 VDD VDD pmos W=0.41u L=0.04u
M993 g24263 n3177 VSS VSS nmos W=0.31u L=0.04u
M994 g24263 n3177 VDD VDD pmos W=0.41u L=0.04u
M995 g24265 n3175 VSS VSS nmos W=0.31u L=0.04u
M996 g24265 n3175 VDD VDD pmos W=0.41u L=0.04u
M997 g24266 n3174 VSS VSS nmos W=0.31u L=0.04u
M998 g24266 n3174 VDD VDD pmos W=0.41u L=0.04u
M999 g24268 n3172 VSS VSS nmos W=0.31u L=0.04u
M1000 g24268 n3172 VDD VDD pmos W=0.41u L=0.04u
M1001 g24269 n3171 VSS VSS nmos W=0.31u L=0.04u
M1002 g24269 n3171 VDD VDD pmos W=0.41u L=0.04u
M1003 g24271 n3169 VSS VSS nmos W=0.31u L=0.04u
M1004 g24271 n3169 VDD VDD pmos W=0.41u L=0.04u
M1005 g24272 n3168 VSS VSS nmos W=0.31u L=0.04u
M1006 g24272 n3168 VDD VDD pmos W=0.41u L=0.04u
M1007 g24274 n3166 VSS VSS nmos W=0.31u L=0.04u
M1008 g24274 n3166 VDD VDD pmos W=0.41u L=0.04u
M1009 g24275 n3165 VSS VSS nmos W=0.31u L=0.04u
M1010 g24275 n3165 VDD VDD pmos W=0.41u L=0.04u
M1011 g24277 n3163 VSS VSS nmos W=0.31u L=0.04u
M1012 g24277 n3163 VDD VDD pmos W=0.41u L=0.04u
M1013 g24278 n3162 VSS VSS nmos W=0.31u L=0.04u
M1014 g24278 n3162 VDD VDD pmos W=0.41u L=0.04u
M1015 g24280 n3142 VSS VSS nmos W=0.31u L=0.04u
M1016 g24280 n3142 VDD VDD pmos W=0.41u L=0.04u
M1017 g24281 n3141 VSS VSS nmos W=0.31u L=0.04u
M1018 g24281 n3141 VDD VDD pmos W=0.41u L=0.04u
M1019 g24283 n3357 VSS VSS nmos W=0.31u L=0.04u
M1020 g24283 n3357 VDD VDD pmos W=0.41u L=0.04u
M1021 g24284 n3359 VSS VSS nmos W=0.31u L=0.04u
M1022 g24284 n3359 VDD VDD pmos W=0.41u L=0.04u
M1023 g24286 n3356 VSS VSS nmos W=0.31u L=0.04u
M1024 g24286 n3356 VDD VDD pmos W=0.41u L=0.04u
M1025 g24287 n3361 VSS VSS nmos W=0.31u L=0.04u
M1026 g24287 n3361 VDD VDD pmos W=0.41u L=0.04u
M1027 g24300 n3094 VSS VSS nmos W=0.31u L=0.04u
M1028 g24300 n3094 VDD VDD pmos W=0.41u L=0.04u
M1029 g24301 n3093 VSS VSS nmos W=0.31u L=0.04u
M1030 g24301 n3093 VDD VDD pmos W=0.41u L=0.04u
M1031 g24303 n3091 VSS VSS nmos W=0.31u L=0.04u
M1032 g24303 n3091 VDD VDD pmos W=0.41u L=0.04u
M1033 g24304 n3090 VSS VSS nmos W=0.31u L=0.04u
M1034 g24304 n3090 VDD VDD pmos W=0.41u L=0.04u
M1035 g24306 n3088 VSS VSS nmos W=0.31u L=0.04u
M1036 g24306 n3088 VDD VDD pmos W=0.41u L=0.04u
M1037 g24307 n3087 VSS VSS nmos W=0.31u L=0.04u
M1038 g24307 n3087 VDD VDD pmos W=0.41u L=0.04u
M1039 g24309 n3085 VSS VSS nmos W=0.31u L=0.04u
M1040 g24309 n3085 VDD VDD pmos W=0.41u L=0.04u
M1041 g24310 n3084 VSS VSS nmos W=0.31u L=0.04u
M1042 g24310 n3084 VDD VDD pmos W=0.41u L=0.04u
M1043 g24312 n3082 VSS VSS nmos W=0.31u L=0.04u
M1044 g24312 n3082 VDD VDD pmos W=0.41u L=0.04u
M1045 g24313 n3081 VSS VSS nmos W=0.31u L=0.04u
M1046 g24313 n3081 VDD VDD pmos W=0.41u L=0.04u
M1047 g24315 n3079 VSS VSS nmos W=0.31u L=0.04u
M1048 g24315 n3079 VDD VDD pmos W=0.41u L=0.04u
M1049 g24316 n3078 VSS VSS nmos W=0.31u L=0.04u
M1050 g24316 n3078 VDD VDD pmos W=0.41u L=0.04u
M1051 g24318 n3076 VSS VSS nmos W=0.31u L=0.04u
M1052 g24318 n3076 VDD VDD pmos W=0.41u L=0.04u
M1053 g24319 n3075 VSS VSS nmos W=0.31u L=0.04u
M1054 g24319 n3075 VDD VDD pmos W=0.41u L=0.04u
M1055 g24321 n3055 VSS VSS nmos W=0.31u L=0.04u
M1056 g24321 n3055 VDD VDD pmos W=0.41u L=0.04u
M1057 g24322 n3054 VSS VSS nmos W=0.31u L=0.04u
M1058 g24322 n3054 VDD VDD pmos W=0.41u L=0.04u
M1059 g24324 n3499 VSS VSS nmos W=0.31u L=0.04u
M1060 g24324 n3499 VDD VDD pmos W=0.41u L=0.04u
M1061 g24325 n3501 VSS VSS nmos W=0.31u L=0.04u
M1062 g24325 n3501 VDD VDD pmos W=0.41u L=0.04u
M1063 g24327 n3498 VSS VSS nmos W=0.31u L=0.04u
M1064 g24327 n3498 VDD VDD pmos W=0.41u L=0.04u
M1065 g24328 n3503 VSS VSS nmos W=0.31u L=0.04u
M1066 g24328 n3503 VDD VDD pmos W=0.41u L=0.04u
M1067 g24341 n3007 VSS VSS nmos W=0.31u L=0.04u
M1068 g24341 n3007 VDD VDD pmos W=0.41u L=0.04u
M1069 g24342 n3006 VSS VSS nmos W=0.31u L=0.04u
M1070 g24342 n3006 VDD VDD pmos W=0.41u L=0.04u
M1071 g24344 n3004 VSS VSS nmos W=0.31u L=0.04u
M1072 g24344 n3004 VDD VDD pmos W=0.41u L=0.04u
M1073 g24345 n3003 VSS VSS nmos W=0.31u L=0.04u
M1074 g24345 n3003 VDD VDD pmos W=0.41u L=0.04u
M1075 g24347 n3001 VSS VSS nmos W=0.31u L=0.04u
M1076 g24347 n3001 VDD VDD pmos W=0.41u L=0.04u
M1077 g24348 n3000 VSS VSS nmos W=0.31u L=0.04u
M1078 g24348 n3000 VDD VDD pmos W=0.41u L=0.04u
M1079 g24350 n2998 VSS VSS nmos W=0.31u L=0.04u
M1080 g24350 n2998 VDD VDD pmos W=0.41u L=0.04u
M1081 g24351 n2997 VSS VSS nmos W=0.31u L=0.04u
M1082 g24351 n2997 VDD VDD pmos W=0.41u L=0.04u
M1083 g24353 n2995 VSS VSS nmos W=0.31u L=0.04u
M1084 g24353 n2995 VDD VDD pmos W=0.41u L=0.04u
M1085 g24354 n2994 VSS VSS nmos W=0.31u L=0.04u
M1086 g24354 n2994 VDD VDD pmos W=0.41u L=0.04u
M1087 g24356 n2992 VSS VSS nmos W=0.31u L=0.04u
M1088 g24356 n2992 VDD VDD pmos W=0.41u L=0.04u
M1089 g24357 n2991 VSS VSS nmos W=0.31u L=0.04u
M1090 g24357 n2991 VDD VDD pmos W=0.41u L=0.04u
M1091 g24359 n2989 VSS VSS nmos W=0.31u L=0.04u
M1092 g24359 n2989 VDD VDD pmos W=0.41u L=0.04u
M1093 g24360 n2988 VSS VSS nmos W=0.31u L=0.04u
M1094 g24360 n2988 VDD VDD pmos W=0.41u L=0.04u
M1095 g24362 n2968 VSS VSS nmos W=0.31u L=0.04u
M1096 g24362 n2968 VDD VDD pmos W=0.41u L=0.04u
M1097 g24363 n2967 VSS VSS nmos W=0.31u L=0.04u
M1098 g24363 n2967 VDD VDD pmos W=0.41u L=0.04u
M1099 g24365 n3599 VSS VSS nmos W=0.31u L=0.04u
M1100 g24365 n3599 VDD VDD pmos W=0.41u L=0.04u
M1101 g24366 n3601 VSS VSS nmos W=0.31u L=0.04u
M1102 g24366 n3601 VDD VDD pmos W=0.41u L=0.04u
M1103 g24368 n3598 VSS VSS nmos W=0.31u L=0.04u
M1104 g24368 n3598 VDD VDD pmos W=0.41u L=0.04u
M1105 g24369 n3603 VSS VSS nmos W=0.31u L=0.04u
M1106 g24369 n3603 VDD VDD pmos W=0.41u L=0.04u
M1107 g24382 n3268 VSS VSS nmos W=0.31u L=0.04u
M1108 g24382 n3268 VDD VDD pmos W=0.41u L=0.04u
M1109 g24383 n3267 VSS VSS nmos W=0.31u L=0.04u
M1110 g24383 n3267 VDD VDD pmos W=0.41u L=0.04u
M1111 g24385 n3265 VSS VSS nmos W=0.31u L=0.04u
M1112 g24385 n3265 VDD VDD pmos W=0.41u L=0.04u
M1113 g24386 n3264 VSS VSS nmos W=0.31u L=0.04u
M1114 g24386 n3264 VDD VDD pmos W=0.41u L=0.04u
M1115 g24388 n3262 VSS VSS nmos W=0.31u L=0.04u
M1116 g24388 n3262 VDD VDD pmos W=0.41u L=0.04u
M1117 g24389 n3261 VSS VSS nmos W=0.31u L=0.04u
M1118 g24389 n3261 VDD VDD pmos W=0.41u L=0.04u
M1119 g24391 n3259 VSS VSS nmos W=0.31u L=0.04u
M1120 g24391 n3259 VDD VDD pmos W=0.41u L=0.04u
M1121 g24392 n3258 VSS VSS nmos W=0.31u L=0.04u
M1122 g24392 n3258 VDD VDD pmos W=0.41u L=0.04u
M1123 g24394 n3256 VSS VSS nmos W=0.31u L=0.04u
M1124 g24394 n3256 VDD VDD pmos W=0.41u L=0.04u
M1125 g24395 n3255 VSS VSS nmos W=0.31u L=0.04u
M1126 g24395 n3255 VDD VDD pmos W=0.41u L=0.04u
M1127 g24397 n3253 VSS VSS nmos W=0.31u L=0.04u
M1128 g24397 n3253 VDD VDD pmos W=0.41u L=0.04u
M1129 g24398 n3252 VSS VSS nmos W=0.31u L=0.04u
M1130 g24398 n3252 VDD VDD pmos W=0.41u L=0.04u
M1131 g24400 n3250 VSS VSS nmos W=0.31u L=0.04u
M1132 g24400 n3250 VDD VDD pmos W=0.41u L=0.04u
M1133 g24401 n3249 VSS VSS nmos W=0.31u L=0.04u
M1134 g24401 n3249 VDD VDD pmos W=0.41u L=0.04u
M1135 g24403 n3229 VSS VSS nmos W=0.31u L=0.04u
M1136 g24403 n3229 VDD VDD pmos W=0.41u L=0.04u
M1137 g24404 n3228 VSS VSS nmos W=0.31u L=0.04u
M1138 g24404 n3228 VDD VDD pmos W=0.41u L=0.04u
M1139 g24406 n3699 VSS VSS nmos W=0.31u L=0.04u
M1140 g24406 n3699 VDD VDD pmos W=0.41u L=0.04u
M1141 g24407 n3701 VSS VSS nmos W=0.31u L=0.04u
M1142 g24407 n3701 VDD VDD pmos W=0.41u L=0.04u
M1143 g24409 n3698 VSS VSS nmos W=0.31u L=0.04u
M1144 g24409 n3698 VDD VDD pmos W=0.41u L=0.04u
M1145 g24410 n3703 VSS VSS nmos W=0.31u L=0.04u
M1146 g24410 n3703 VDD VDD pmos W=0.41u L=0.04u
M1147 g26004 n3324 VSS VSS nmos W=0.31u L=0.04u
M1148 g26004 n3324 VDD VDD pmos W=0.41u L=0.04u
M1149 g26007 n3348 VSS VSS nmos W=0.31u L=0.04u
M1150 g26007 n3348 VDD VDD pmos W=0.41u L=0.04u
M1151 g29152 n3318 VSS VSS nmos W=0.31u L=0.04u
M1152 g29152 n3318 VDD VDD pmos W=0.41u L=0.04u
M1153 g29149 n3321 VSS VSS nmos W=0.31u L=0.04u
M1154 g29149 n3321 VDD VDD pmos W=0.41u L=0.04u
M1155 g27225 n3629 VSS VSS nmos W=0.31u L=0.04u
M1156 g27225 n3629 VDD VDD pmos W=0.41u L=0.04u
M1157 g26013 n3315 VSS VSS nmos W=0.31u L=0.04u
M1158 g26013 n3315 VDD VDD pmos W=0.41u L=0.04u
M1159 g26016 n3336 VSS VSS nmos W=0.31u L=0.04u
M1160 g26016 n3336 VDD VDD pmos W=0.41u L=0.04u
M1161 g29160 n3309 VSS VSS nmos W=0.31u L=0.04u
M1162 g29160 n3309 VDD VDD pmos W=0.41u L=0.04u
M1163 g29157 n3312 VSS VSS nmos W=0.31u L=0.04u
M1164 g29157 n3312 VDD VDD pmos W=0.41u L=0.04u
M1165 g27234 n3729 VSS VSS nmos W=0.31u L=0.04u
M1166 g27234 n3729 VDD VDD pmos W=0.41u L=0.04u
M1167 g24261 n3179 VSS VSS nmos W=0.31u L=0.04u
M1168 g24261 n3179 VDD VDD pmos W=0.41u L=0.04u
M1169 g24264 n3176 VSS VSS nmos W=0.31u L=0.04u
M1170 g24264 n3176 VDD VDD pmos W=0.41u L=0.04u
M1171 g24267 n3173 VSS VSS nmos W=0.31u L=0.04u
M1172 g24267 n3173 VDD VDD pmos W=0.41u L=0.04u
M1173 g24270 n3170 VSS VSS nmos W=0.31u L=0.04u
M1174 g24270 n3170 VDD VDD pmos W=0.41u L=0.04u
M1175 g24273 n3167 VSS VSS nmos W=0.31u L=0.04u
M1176 g24273 n3167 VDD VDD pmos W=0.41u L=0.04u
M1177 g24276 n3164 VSS VSS nmos W=0.31u L=0.04u
M1178 g24276 n3164 VDD VDD pmos W=0.41u L=0.04u
M1179 g24279 n3161 VSS VSS nmos W=0.31u L=0.04u
M1180 g24279 n3161 VDD VDD pmos W=0.41u L=0.04u
M1181 g24282 n3140 VSS VSS nmos W=0.31u L=0.04u
M1182 g24282 n3140 VDD VDD pmos W=0.41u L=0.04u
M1183 g24285 n3358 VSS VSS nmos W=0.31u L=0.04u
M1184 g24285 n3358 VDD VDD pmos W=0.41u L=0.04u
M1185 g24288 n3360 VSS VSS nmos W=0.31u L=0.04u
M1186 g24288 n3360 VDD VDD pmos W=0.41u L=0.04u
M1187 g24302 n3092 VSS VSS nmos W=0.31u L=0.04u
M1188 g24302 n3092 VDD VDD pmos W=0.41u L=0.04u
M1189 g24305 n3089 VSS VSS nmos W=0.31u L=0.04u
M1190 g24305 n3089 VDD VDD pmos W=0.41u L=0.04u
M1191 g24308 n3086 VSS VSS nmos W=0.31u L=0.04u
M1192 g24308 n3086 VDD VDD pmos W=0.41u L=0.04u
M1193 g24311 n3083 VSS VSS nmos W=0.31u L=0.04u
M1194 g24311 n3083 VDD VDD pmos W=0.41u L=0.04u
M1195 g24314 n3080 VSS VSS nmos W=0.31u L=0.04u
M1196 g24314 n3080 VDD VDD pmos W=0.41u L=0.04u
M1197 g24317 n3077 VSS VSS nmos W=0.31u L=0.04u
M1198 g24317 n3077 VDD VDD pmos W=0.41u L=0.04u
M1199 g24320 n3074 VSS VSS nmos W=0.31u L=0.04u
M1200 g24320 n3074 VDD VDD pmos W=0.41u L=0.04u
M1201 g24323 n3053 VSS VSS nmos W=0.31u L=0.04u
M1202 g24323 n3053 VDD VDD pmos W=0.41u L=0.04u
M1203 g24326 n3500 VSS VSS nmos W=0.31u L=0.04u
M1204 g24326 n3500 VDD VDD pmos W=0.41u L=0.04u
M1205 g24329 n3502 VSS VSS nmos W=0.31u L=0.04u
M1206 g24329 n3502 VDD VDD pmos W=0.41u L=0.04u
M1207 g24343 n3005 VSS VSS nmos W=0.31u L=0.04u
M1208 g24343 n3005 VDD VDD pmos W=0.41u L=0.04u
M1209 g24346 n3002 VSS VSS nmos W=0.31u L=0.04u
M1210 g24346 n3002 VDD VDD pmos W=0.41u L=0.04u
M1211 g24349 n2999 VSS VSS nmos W=0.31u L=0.04u
M1212 g24349 n2999 VDD VDD pmos W=0.41u L=0.04u
M1213 g24352 n2996 VSS VSS nmos W=0.31u L=0.04u
M1214 g24352 n2996 VDD VDD pmos W=0.41u L=0.04u
M1215 g24355 n2993 VSS VSS nmos W=0.31u L=0.04u
M1216 g24355 n2993 VDD VDD pmos W=0.41u L=0.04u
M1217 g24358 n2990 VSS VSS nmos W=0.31u L=0.04u
M1218 g24358 n2990 VDD VDD pmos W=0.41u L=0.04u
M1219 g24361 n2987 VSS VSS nmos W=0.31u L=0.04u
M1220 g24361 n2987 VDD VDD pmos W=0.41u L=0.04u
M1221 g24364 n2966 VSS VSS nmos W=0.31u L=0.04u
M1222 g24364 n2966 VDD VDD pmos W=0.41u L=0.04u
M1223 g24367 n3600 VSS VSS nmos W=0.31u L=0.04u
M1224 g24367 n3600 VDD VDD pmos W=0.41u L=0.04u
M1225 g24370 n3602 VSS VSS nmos W=0.31u L=0.04u
M1226 g24370 n3602 VDD VDD pmos W=0.41u L=0.04u
M1227 g24384 n3266 VSS VSS nmos W=0.31u L=0.04u
M1228 g24384 n3266 VDD VDD pmos W=0.41u L=0.04u
M1229 g24387 n3263 VSS VSS nmos W=0.31u L=0.04u
M1230 g24387 n3263 VDD VDD pmos W=0.41u L=0.04u
M1231 g24390 n3260 VSS VSS nmos W=0.31u L=0.04u
M1232 g24390 n3260 VDD VDD pmos W=0.41u L=0.04u
M1233 g24393 n3257 VSS VSS nmos W=0.31u L=0.04u
M1234 g24393 n3257 VDD VDD pmos W=0.41u L=0.04u
M1235 g24396 n3254 VSS VSS nmos W=0.31u L=0.04u
M1236 g24396 n3254 VDD VDD pmos W=0.41u L=0.04u
M1237 g24399 n3251 VSS VSS nmos W=0.31u L=0.04u
M1238 g24399 n3251 VDD VDD pmos W=0.41u L=0.04u
M1239 g24402 n3248 VSS VSS nmos W=0.31u L=0.04u
M1240 g24402 n3248 VDD VDD pmos W=0.41u L=0.04u
M1241 g24405 n3227 VSS VSS nmos W=0.31u L=0.04u
M1242 g24405 n3227 VDD VDD pmos W=0.41u L=0.04u
M1243 g24408 n3700 VSS VSS nmos W=0.31u L=0.04u
M1244 g24408 n3700 VDD VDD pmos W=0.41u L=0.04u
M1245 g24411 n3702 VSS VSS nmos W=0.31u L=0.04u
M1246 g24411 n3702 VDD VDD pmos W=0.41u L=0.04u
M1247 g25985 n3346 VSS VSS nmos W=0.31u L=0.04u
M1248 g25985 n3346 VDD VDD pmos W=0.41u L=0.04u
M1249 g25988 n3355 VSS VSS nmos W=0.31u L=0.04u
M1250 g25988 n3355 VDD VDD pmos W=0.41u L=0.04u
M1251 g29135 n3340 VSS VSS nmos W=0.31u L=0.04u
M1252 g29135 n3340 VDD VDD pmos W=0.41u L=0.04u
M1253 g29132 n3343 VSS VSS nmos W=0.31u L=0.04u
M1254 g29132 n3343 VDD VDD pmos W=0.41u L=0.04u
M1255 g27194 n3400 VSS VSS nmos W=0.31u L=0.04u
M1256 g27194 n3400 VDD VDD pmos W=0.41u L=0.04u
M1257 g25983 n2823 VSS VSS nmos W=0.31u L=0.04u
M1258 g25983 n2823 VDD VDD pmos W=0.41u L=0.04u
M1259 g27189 n2825 VSS VSS nmos W=0.31u L=0.04u
M1260 g27189 n2825 VDD VDD pmos W=0.41u L=0.04u
M1261 g27683 n2826 VSS VSS nmos W=0.31u L=0.04u
M1262 g27683 n2826 VDD VDD pmos W=0.41u L=0.04u
M1263 g28206 n2827 VSS VSS nmos W=0.31u L=0.04u
M1264 g28206 n2827 VDD VDD pmos W=0.41u L=0.04u
M1265 g28673 n2828 VSS VSS nmos W=0.31u L=0.04u
M1266 g28673 n2828 VDD VDD pmos W=0.41u L=0.04u
M1267 g29131 n2829 VSS VSS nmos W=0.31u L=0.04u
M1268 g29131 n2829 VDD VDD pmos W=0.41u L=0.04u
M1269 g29413 n2830 VSS VSS nmos W=0.31u L=0.04u
M1270 g29413 n2830 VDD VDD pmos W=0.41u L=0.04u
M1271 g25992 n2813 VSS VSS nmos W=0.31u L=0.04u
M1272 g25992 n2813 VDD VDD pmos W=0.41u L=0.04u
M1273 g26695 n2814 VSS VSS nmos W=0.31u L=0.04u
M1274 g26695 n2814 VDD VDD pmos W=0.41u L=0.04u
M1275 g27198 n2815 VSS VSS nmos W=0.31u L=0.04u
M1276 g27198 n2815 VDD VDD pmos W=0.41u L=0.04u
M1277 g27691 n2816 VSS VSS nmos W=0.31u L=0.04u
M1278 g27691 n2816 VDD VDD pmos W=0.41u L=0.04u
M1279 g28232 n2817 VSS VSS nmos W=0.31u L=0.04u
M1280 g28232 n2817 VDD VDD pmos W=0.41u L=0.04u
M1281 g29139 n2819 VSS VSS nmos W=0.31u L=0.04u
M1282 g29139 n2819 VDD VDD pmos W=0.41u L=0.04u
M1283 g29420 n2820 VSS VSS nmos W=0.31u L=0.04u
M1284 g29420 n2820 VDD VDD pmos W=0.41u L=0.04u
M1285 g26001 n2803 VSS VSS nmos W=0.31u L=0.04u
M1286 g26001 n2803 VDD VDD pmos W=0.41u L=0.04u
M1287 g27219 n2805 VSS VSS nmos W=0.31u L=0.04u
M1288 g27219 n2805 VDD VDD pmos W=0.41u L=0.04u
M1289 g27699 n2806 VSS VSS nmos W=0.31u L=0.04u
M1290 g27699 n2806 VDD VDD pmos W=0.41u L=0.04u
M1291 g28258 n2807 VSS VSS nmos W=0.31u L=0.04u
M1292 g28258 n2807 VDD VDD pmos W=0.41u L=0.04u
M1293 g28683 n2808 VSS VSS nmos W=0.31u L=0.04u
M1294 g28683 n2808 VDD VDD pmos W=0.41u L=0.04u
M1295 g29147 n2809 VSS VSS nmos W=0.31u L=0.04u
M1296 g29147 n2809 VDD VDD pmos W=0.41u L=0.04u
M1297 g29427 n2810 VSS VSS nmos W=0.31u L=0.04u
M1298 g29427 n2810 VDD VDD pmos W=0.41u L=0.04u
M1299 g26010 n2793 VSS VSS nmos W=0.31u L=0.04u
M1300 g26010 n2793 VDD VDD pmos W=0.41u L=0.04u
M1301 g27228 n2795 VSS VSS nmos W=0.31u L=0.04u
M1302 g27228 n2795 VDD VDD pmos W=0.41u L=0.04u
M1303 g27707 n2796 VSS VSS nmos W=0.31u L=0.04u
M1304 g27707 n2796 VDD VDD pmos W=0.41u L=0.04u
M1305 g28284 n2797 VSS VSS nmos W=0.31u L=0.04u
M1306 g28284 n2797 VDD VDD pmos W=0.41u L=0.04u
M1307 g28688 n2798 VSS VSS nmos W=0.31u L=0.04u
M1308 g28688 n2798 VDD VDD pmos W=0.41u L=0.04u
M1309 g29155 n2799 VSS VSS nmos W=0.31u L=0.04u
M1310 g29155 n2799 VDD VDD pmos W=0.41u L=0.04u
M1311 g29446 n2800 VSS VSS nmos W=0.31u L=0.04u
M1312 g29446 n2800 VDD VDD pmos W=0.41u L=0.04u
M1313 g24289 n3365 VSS VSS nmos W=0.31u L=0.04u
M1314 g24289 n3365 VDD VDD pmos W=0.41u L=0.04u
M1315 g24290 n3367 VSS VSS nmos W=0.31u L=0.04u
M1316 g24290 n3367 VDD VDD pmos W=0.41u L=0.04u
M1317 g24291 n3366 VSS VSS nmos W=0.31u L=0.04u
M1318 g24291 n3366 VDD VDD pmos W=0.41u L=0.04u
M1319 g24330 n3507 VSS VSS nmos W=0.31u L=0.04u
M1320 g24330 n3507 VDD VDD pmos W=0.41u L=0.04u
M1321 g24331 n3509 VSS VSS nmos W=0.31u L=0.04u
M1322 g24331 n3509 VDD VDD pmos W=0.41u L=0.04u
M1323 g24332 n3508 VSS VSS nmos W=0.31u L=0.04u
M1324 g24332 n3508 VDD VDD pmos W=0.41u L=0.04u
M1325 g24371 n3607 VSS VSS nmos W=0.31u L=0.04u
M1326 g24371 n3607 VDD VDD pmos W=0.41u L=0.04u
M1327 g24372 n3609 VSS VSS nmos W=0.31u L=0.04u
M1328 g24372 n3609 VDD VDD pmos W=0.41u L=0.04u
M1329 g24373 n3608 VSS VSS nmos W=0.31u L=0.04u
M1330 g24373 n3608 VDD VDD pmos W=0.41u L=0.04u
M1331 g24412 n3707 VSS VSS nmos W=0.31u L=0.04u
M1332 g24412 n3707 VDD VDD pmos W=0.41u L=0.04u
M1333 g24413 n3709 VSS VSS nmos W=0.31u L=0.04u
M1334 g24413 n3709 VDD VDD pmos W=0.41u L=0.04u
M1335 g24414 n3708 VSS VSS nmos W=0.31u L=0.04u
M1336 g24414 n3708 VDD VDD pmos W=0.41u L=0.04u
M1337 g26679 n2786 VSS VSS nmos W=0.31u L=0.04u
M1338 g26679 n2786 VDD VDD pmos W=0.41u L=0.04u
M1339 g26680 n2787 VSS VSS nmos W=0.31u L=0.04u
M1340 g26680 n2787 VDD VDD pmos W=0.41u L=0.04u
M1341 g26681 n2791 VSS VSS nmos W=0.31u L=0.04u
M1342 g26681 n2791 VDD VDD pmos W=0.41u L=0.04u
M1343 g26682 n2784 VSS VSS nmos W=0.31u L=0.04u
M1344 g26682 n2784 VDD VDD pmos W=0.41u L=0.04u
M1345 g26683 n2785 VSS VSS nmos W=0.31u L=0.04u
M1346 g26683 n2785 VDD VDD pmos W=0.41u L=0.04u
M1347 g26684 n2790 VSS VSS nmos W=0.31u L=0.04u
M1348 g26684 n2790 VDD VDD pmos W=0.41u L=0.04u
M1349 g26685 n2782 VSS VSS nmos W=0.31u L=0.04u
M1350 g26685 n2782 VDD VDD pmos W=0.41u L=0.04u
M1351 g26686 n2783 VSS VSS nmos W=0.31u L=0.04u
M1352 g26686 n2783 VDD VDD pmos W=0.41u L=0.04u
M1353 g26687 n2789 VSS VSS nmos W=0.31u L=0.04u
M1354 g26687 n2789 VDD VDD pmos W=0.41u L=0.04u
M1355 g26688 n2780 VSS VSS nmos W=0.31u L=0.04u
M1356 g26688 n2780 VDD VDD pmos W=0.41u L=0.04u
M1357 g26689 n2781 VSS VSS nmos W=0.31u L=0.04u
M1358 g26689 n2781 VDD VDD pmos W=0.41u L=0.04u
M1359 g26690 n2788 VSS VSS nmos W=0.31u L=0.04u
M1360 g26690 n2788 VDD VDD pmos W=0.41u L=0.04u
M1361 g26696 n2774 VSS VSS nmos W=0.31u L=0.04u
M1362 g26696 n2774 VDD VDD pmos W=0.41u L=0.04u
M1363 g26697 n2775 VSS VSS nmos W=0.31u L=0.04u
M1364 g26697 n2775 VDD VDD pmos W=0.41u L=0.04u
M1365 g26698 n2779 VSS VSS nmos W=0.31u L=0.04u
M1366 g26698 n2779 VDD VDD pmos W=0.41u L=0.04u
M1367 g26699 n2772 VSS VSS nmos W=0.31u L=0.04u
M1368 g26699 n2772 VDD VDD pmos W=0.41u L=0.04u
M1369 g26700 n2773 VSS VSS nmos W=0.31u L=0.04u
M1370 g26700 n2773 VDD VDD pmos W=0.41u L=0.04u
M1371 g26701 n2778 VSS VSS nmos W=0.31u L=0.04u
M1372 g26701 n2778 VDD VDD pmos W=0.41u L=0.04u
M1373 g26702 n2770 VSS VSS nmos W=0.31u L=0.04u
M1374 g26702 n2770 VDD VDD pmos W=0.41u L=0.04u
M1375 g26703 n2771 VSS VSS nmos W=0.31u L=0.04u
M1376 g26703 n2771 VDD VDD pmos W=0.41u L=0.04u
M1377 g26704 n2777 VSS VSS nmos W=0.31u L=0.04u
M1378 g26704 n2777 VDD VDD pmos W=0.41u L=0.04u
M1379 g26705 n2768 VSS VSS nmos W=0.31u L=0.04u
M1380 g26705 n2768 VDD VDD pmos W=0.41u L=0.04u
M1381 g26706 n2769 VSS VSS nmos W=0.31u L=0.04u
M1382 g26706 n2769 VDD VDD pmos W=0.41u L=0.04u
M1383 g26707 n2776 VSS VSS nmos W=0.31u L=0.04u
M1384 g26707 n2776 VDD VDD pmos W=0.41u L=0.04u
M1385 g26713 n2762 VSS VSS nmos W=0.31u L=0.04u
M1386 g26713 n2762 VDD VDD pmos W=0.41u L=0.04u
M1387 g26714 n2763 VSS VSS nmos W=0.31u L=0.04u
M1388 g26714 n2763 VDD VDD pmos W=0.41u L=0.04u
M1389 g26715 n2767 VSS VSS nmos W=0.31u L=0.04u
M1390 g26715 n2767 VDD VDD pmos W=0.41u L=0.04u
M1391 g26716 n2760 VSS VSS nmos W=0.31u L=0.04u
M1392 g26716 n2760 VDD VDD pmos W=0.41u L=0.04u
M1393 g26717 n2761 VSS VSS nmos W=0.31u L=0.04u
M1394 g26717 n2761 VDD VDD pmos W=0.41u L=0.04u
M1395 g26718 n2766 VSS VSS nmos W=0.31u L=0.04u
M1396 g26718 n2766 VDD VDD pmos W=0.41u L=0.04u
M1397 g26719 n2758 VSS VSS nmos W=0.31u L=0.04u
M1398 g26719 n2758 VDD VDD pmos W=0.41u L=0.04u
M1399 g26720 n2759 VSS VSS nmos W=0.31u L=0.04u
M1400 g26720 n2759 VDD VDD pmos W=0.41u L=0.04u
M1401 g26721 n2765 VSS VSS nmos W=0.31u L=0.04u
M1402 g26721 n2765 VDD VDD pmos W=0.41u L=0.04u
M1403 g26722 n2756 VSS VSS nmos W=0.31u L=0.04u
M1404 g26722 n2756 VDD VDD pmos W=0.41u L=0.04u
M1405 g26723 n2757 VSS VSS nmos W=0.31u L=0.04u
M1406 g26723 n2757 VDD VDD pmos W=0.41u L=0.04u
M1407 g26724 n2764 VSS VSS nmos W=0.31u L=0.04u
M1408 g26724 n2764 VDD VDD pmos W=0.41u L=0.04u
M1409 g26730 n2750 VSS VSS nmos W=0.31u L=0.04u
M1410 g26730 n2750 VDD VDD pmos W=0.41u L=0.04u
M1411 g26731 n2751 VSS VSS nmos W=0.31u L=0.04u
M1412 g26731 n2751 VDD VDD pmos W=0.41u L=0.04u
M1413 g26732 n2755 VSS VSS nmos W=0.31u L=0.04u
M1414 g26732 n2755 VDD VDD pmos W=0.41u L=0.04u
M1415 g26733 n2748 VSS VSS nmos W=0.31u L=0.04u
M1416 g26733 n2748 VDD VDD pmos W=0.41u L=0.04u
M1417 g26734 n2749 VSS VSS nmos W=0.31u L=0.04u
M1418 g26734 n2749 VDD VDD pmos W=0.41u L=0.04u
M1419 g26735 n2754 VSS VSS nmos W=0.31u L=0.04u
M1420 g26735 n2754 VDD VDD pmos W=0.41u L=0.04u
M1421 g26736 n2746 VSS VSS nmos W=0.31u L=0.04u
M1422 g26736 n2746 VDD VDD pmos W=0.41u L=0.04u
M1423 g26737 n2747 VSS VSS nmos W=0.31u L=0.04u
M1424 g26737 n2747 VDD VDD pmos W=0.41u L=0.04u
M1425 g26738 n2753 VSS VSS nmos W=0.31u L=0.04u
M1426 g26738 n2753 VDD VDD pmos W=0.41u L=0.04u
M1427 g26739 n2744 VSS VSS nmos W=0.31u L=0.04u
M1428 g26739 n2744 VDD VDD pmos W=0.41u L=0.04u
M1429 g26740 n2745 VSS VSS nmos W=0.31u L=0.04u
M1430 g26740 n2745 VDD VDD pmos W=0.41u L=0.04u
M1431 g26741 n2752 VSS VSS nmos W=0.31u L=0.04u
M1432 g26741 n2752 VDD VDD pmos W=0.41u L=0.04u
M1433 g23161 n3496 VSS VSS nmos W=0.31u L=0.04u
M1434 g23161 n3496 VDD VDD pmos W=0.41u L=0.04u
M1435 g25140 n3494 VSS VSS nmos W=0.31u L=0.04u
M1436 g25140 n3494 VDD VDD pmos W=0.41u L=0.04u
M1437 g26691 n3492 VSS VSS nmos W=0.31u L=0.04u
M1438 g26691 n3492 VDD VDD pmos W=0.41u L=0.04u
M1439 g27690 n3490 VSS VSS nmos W=0.31u L=0.04u
M1440 g27690 n3490 VDD VDD pmos W=0.41u L=0.04u
M1441 g28231 n3489 VSS VSS nmos W=0.31u L=0.04u
M1442 g28231 n3489 VDD VDD pmos W=0.41u L=0.04u
M1443 g23199 n3596 VSS VSS nmos W=0.31u L=0.04u
M1444 g23199 n3596 VDD VDD pmos W=0.41u L=0.04u
M1445 g25151 n3594 VSS VSS nmos W=0.31u L=0.04u
M1446 g25151 n3594 VDD VDD pmos W=0.41u L=0.04u
M1447 g26708 n3592 VSS VSS nmos W=0.31u L=0.04u
M1448 g26708 n3592 VDD VDD pmos W=0.41u L=0.04u
M1449 g27698 n3590 VSS VSS nmos W=0.31u L=0.04u
M1450 g27698 n3590 VDD VDD pmos W=0.41u L=0.04u
M1451 g28257 n3589 VSS VSS nmos W=0.31u L=0.04u
M1452 g28257 n3589 VDD VDD pmos W=0.41u L=0.04u
M1453 g23237 n3696 VSS VSS nmos W=0.31u L=0.04u
M1454 g23237 n3696 VDD VDD pmos W=0.41u L=0.04u
M1455 g25162 n3694 VSS VSS nmos W=0.31u L=0.04u
M1456 g25162 n3694 VDD VDD pmos W=0.41u L=0.04u
M1457 g26725 n3692 VSS VSS nmos W=0.31u L=0.04u
M1458 g26725 n3692 VDD VDD pmos W=0.41u L=0.04u
M1459 g27706 n3690 VSS VSS nmos W=0.31u L=0.04u
M1460 g27706 n3690 VDD VDD pmos W=0.41u L=0.04u
M1461 g28283 n3689 VSS VSS nmos W=0.31u L=0.04u
M1462 g28283 n3689 VDD VDD pmos W=0.41u L=0.04u
M1463 g23275 n3796 VSS VSS nmos W=0.31u L=0.04u
M1464 g23275 n3796 VDD VDD pmos W=0.41u L=0.04u
M1465 g25173 n3794 VSS VSS nmos W=0.31u L=0.04u
M1466 g25173 n3794 VDD VDD pmos W=0.41u L=0.04u
M1467 g26742 n3792 VSS VSS nmos W=0.31u L=0.04u
M1468 g26742 n3792 VDD VDD pmos W=0.41u L=0.04u
M1469 g27714 n3790 VSS VSS nmos W=0.31u L=0.04u
M1470 g27714 n3790 VDD VDD pmos W=0.41u L=0.04u
M1471 g28309 n3789 VSS VSS nmos W=0.31u L=0.04u
M1472 g28309 n3789 VDD VDD pmos W=0.41u L=0.04u
M1473 g23160 n3449 VSS VSS nmos W=0.31u L=0.04u
M1474 g23160 n3449 VDD VDD pmos W=0.41u L=0.04u
M1475 g20557 n3447 VSS VSS nmos W=0.31u L=0.04u
M1476 g20557 n3447 VDD VDD pmos W=0.41u L=0.04u
M1477 g25987 n3344 VSS VSS nmos W=0.31u L=0.04u
M1478 g25987 n3344 VDD VDD pmos W=0.41u L=0.04u
M1479 g25990 n3353 VSS VSS nmos W=0.31u L=0.04u
M1480 g25990 n3353 VDD VDD pmos W=0.41u L=0.04u
M1481 g29137 n3338 VSS VSS nmos W=0.31u L=0.04u
M1482 g29137 n3338 VDD VDD pmos W=0.41u L=0.04u
M1483 g29134 n3341 VSS VSS nmos W=0.31u L=0.04u
M1484 g29134 n3341 VDD VDD pmos W=0.41u L=0.04u
M1485 g27196 n3408 VSS VSS nmos W=0.31u L=0.04u
M1486 g27196 n3408 VDD VDD pmos W=0.41u L=0.04u
M1487 g23198 n3549 VSS VSS nmos W=0.31u L=0.04u
M1488 g23198 n3549 VDD VDD pmos W=0.41u L=0.04u
M1489 g20561 n3547 VSS VSS nmos W=0.31u L=0.04u
M1490 g20561 n3547 VDD VDD pmos W=0.41u L=0.04u
M1491 g25996 n3332 VSS VSS nmos W=0.31u L=0.04u
M1492 g25996 n3332 VDD VDD pmos W=0.41u L=0.04u
M1493 g25999 n3350 VSS VSS nmos W=0.31u L=0.04u
M1494 g25999 n3350 VDD VDD pmos W=0.41u L=0.04u
M1495 g29145 n3326 VSS VSS nmos W=0.31u L=0.04u
M1496 g29145 n3326 VDD VDD pmos W=0.41u L=0.04u
M1497 g29142 n3329 VSS VSS nmos W=0.31u L=0.04u
M1498 g29142 n3329 VDD VDD pmos W=0.41u L=0.04u
M1499 g27211 n3528 VSS VSS nmos W=0.31u L=0.04u
M1500 g27211 n3528 VDD VDD pmos W=0.41u L=0.04u
M1501 g23236 n3649 VSS VSS nmos W=0.31u L=0.04u
M1502 g23236 n3649 VDD VDD pmos W=0.41u L=0.04u
M1503 g20565 n3647 VSS VSS nmos W=0.31u L=0.04u
M1504 g20565 n3647 VDD VDD pmos W=0.41u L=0.04u
M1505 g26005 n3323 VSS VSS nmos W=0.31u L=0.04u
M1506 g26005 n3323 VDD VDD pmos W=0.41u L=0.04u
M1507 g26008 n3347 VSS VSS nmos W=0.31u L=0.04u
M1508 g26008 n3347 VDD VDD pmos W=0.41u L=0.04u
M1509 g29153 n3317 VSS VSS nmos W=0.31u L=0.04u
M1510 g29153 n3317 VDD VDD pmos W=0.41u L=0.04u
M1511 g29150 n3320 VSS VSS nmos W=0.31u L=0.04u
M1512 g29150 n3320 VDD VDD pmos W=0.41u L=0.04u
M1513 g27226 n3628 VSS VSS nmos W=0.31u L=0.04u
M1514 g27226 n3628 VDD VDD pmos W=0.41u L=0.04u
M1515 g23274 n3749 VSS VSS nmos W=0.31u L=0.04u
M1516 g23274 n3749 VDD VDD pmos W=0.41u L=0.04u
M1517 g20569 n3747 VSS VSS nmos W=0.31u L=0.04u
M1518 g20569 n3747 VDD VDD pmos W=0.41u L=0.04u
M1519 g26014 n3314 VSS VSS nmos W=0.31u L=0.04u
M1520 g26014 n3314 VDD VDD pmos W=0.41u L=0.04u
M1521 g26017 n3335 VSS VSS nmos W=0.31u L=0.04u
M1522 g26017 n3335 VDD VDD pmos W=0.41u L=0.04u
M1523 g29161 n3308 VSS VSS nmos W=0.31u L=0.04u
M1524 g29161 n3308 VDD VDD pmos W=0.41u L=0.04u
M1525 g29158 n3311 VSS VSS nmos W=0.31u L=0.04u
M1526 g29158 n3311 VDD VDD pmos W=0.41u L=0.04u
M1527 g27235 n3728 VSS VSS nmos W=0.31u L=0.04u
M1528 g27235 n3728 VDD VDD pmos W=0.41u L=0.04u
M1529 g30317 n3377 VSS VSS nmos W=0.31u L=0.04u
M1530 g30317 n3377 VDD VDD pmos W=0.41u L=0.04u
M1531 g30314 n3388 VSS VSS nmos W=0.31u L=0.04u
M1532 g30314 n3388 VDD VDD pmos W=0.41u L=0.04u
M1533 g29416 n3143 VSS VSS nmos W=0.31u L=0.04u
M1534 g29416 n3143 VDD VDD pmos W=0.41u L=0.04u
M1535 g29633 n3149 VSS VSS nmos W=0.31u L=0.04u
M1536 g29633 n3149 VDD VDD pmos W=0.41u L=0.04u
M1537 g27686 n3158 VSS VSS nmos W=0.31u L=0.04u
M1538 g27686 n3158 VDD VDD pmos W=0.41u L=0.04u
M1539 g27689 n3155 VSS VSS nmos W=0.31u L=0.04u
M1540 g27689 n3155 VDD VDD pmos W=0.41u L=0.04u
M1541 g29797 n3134 VSS VSS nmos W=0.31u L=0.04u
M1542 g29797 n3134 VDD VDD pmos W=0.41u L=0.04u
M1543 g30853 n3098 VSS VSS nmos W=0.31u L=0.04u
M1544 g30853 n3098 VDD VDD pmos W=0.41u L=0.04u
M1545 g30712 n3101 VSS VSS nmos W=0.31u L=0.04u
M1546 g30712 n3101 VDD VDD pmos W=0.41u L=0.04u
M1547 g29436 n2969 VSS VSS nmos W=0.31u L=0.04u
M1548 g29436 n2969 VDD VDD pmos W=0.41u L=0.04u
M1549 g29647 n2975 VSS VSS nmos W=0.31u L=0.04u
M1550 g29647 n2975 VDD VDD pmos W=0.41u L=0.04u
M1551 g27702 n2984 VSS VSS nmos W=0.31u L=0.04u
M1552 g27702 n2984 VDD VDD pmos W=0.41u L=0.04u
M1553 g27705 n2981 VSS VSS nmos W=0.31u L=0.04u
M1554 g27705 n2981 VDD VDD pmos W=0.41u L=0.04u
M1555 g29805 n2960 VSS VSS nmos W=0.31u L=0.04u
M1556 g29805 n2960 VDD VDD pmos W=0.41u L=0.04u
M1557 g30889 n2924 VSS VSS nmos W=0.31u L=0.04u
M1558 g30889 n2924 VDD VDD pmos W=0.41u L=0.04u
M1559 g30718 n2927 VSS VSS nmos W=0.31u L=0.04u
M1560 g30718 n2927 VDD VDD pmos W=0.41u L=0.04u
M1561 g29449 n3230 VSS VSS nmos W=0.31u L=0.04u
M1562 g29449 n3230 VDD VDD pmos W=0.41u L=0.04u
M1563 g29654 n3236 VSS VSS nmos W=0.31u L=0.04u
M1564 g29654 n3236 VDD VDD pmos W=0.41u L=0.04u
M1565 g27710 n3245 VSS VSS nmos W=0.31u L=0.04u
M1566 g27710 n3245 VDD VDD pmos W=0.41u L=0.04u
M1567 g27713 n3242 VSS VSS nmos W=0.31u L=0.04u
M1568 g27713 n3242 VDD VDD pmos W=0.41u L=0.04u
M1569 g29809 n3221 VSS VSS nmos W=0.31u L=0.04u
M1570 g29809 n3221 VDD VDD pmos W=0.41u L=0.04u
M1571 g30907 n3185 VSS VSS nmos W=0.31u L=0.04u
M1572 g30907 n3185 VDD VDD pmos W=0.41u L=0.04u
M1573 g30721 n3188 VSS VSS nmos W=0.31u L=0.04u
M1574 g30721 n3188 VDD VDD pmos W=0.41u L=0.04u
M1575 g29423 n3056 VSS VSS nmos W=0.31u L=0.04u
M1576 g29423 n3056 VDD VDD pmos W=0.41u L=0.04u
M1577 g29640 n3062 VSS VSS nmos W=0.31u L=0.04u
M1578 g29640 n3062 VDD VDD pmos W=0.41u L=0.04u
M1579 g27694 n3071 VSS VSS nmos W=0.31u L=0.04u
M1580 g27694 n3071 VDD VDD pmos W=0.41u L=0.04u
M1581 g27697 n3068 VSS VSS nmos W=0.31u L=0.04u
M1582 g27697 n3068 VDD VDD pmos W=0.41u L=0.04u
M1583 g29801 n3047 VSS VSS nmos W=0.31u L=0.04u
M1584 g29801 n3047 VDD VDD pmos W=0.41u L=0.04u
M1585 g30871 n3011 VSS VSS nmos W=0.31u L=0.04u
M1586 g30871 n3011 VDD VDD pmos W=0.41u L=0.04u
M1587 g30715 n3014 VSS VSS nmos W=0.31u L=0.04u
M1588 g30715 n3014 VDD VDD pmos W=0.41u L=0.04u
M1589 g29414 n3145 VSS VSS nmos W=0.31u L=0.04u
M1590 g29414 n3145 VDD VDD pmos W=0.41u L=0.04u
M1591 g29415 n3144 VSS VSS nmos W=0.31u L=0.04u
M1592 g29415 n3144 VDD VDD pmos W=0.41u L=0.04u
M1593 g29631 n3151 VSS VSS nmos W=0.31u L=0.04u
M1594 g29631 n3151 VDD VDD pmos W=0.41u L=0.04u
M1595 g29632 n3150 VSS VSS nmos W=0.31u L=0.04u
M1596 g29632 n3150 VDD VDD pmos W=0.41u L=0.04u
M1597 g27684 n3160 VSS VSS nmos W=0.31u L=0.04u
M1598 g27684 n3160 VDD VDD pmos W=0.41u L=0.04u
M1599 g27685 n3159 VSS VSS nmos W=0.31u L=0.04u
M1600 g27685 n3159 VDD VDD pmos W=0.41u L=0.04u
M1601 g27687 n3157 VSS VSS nmos W=0.31u L=0.04u
M1602 g27687 n3157 VDD VDD pmos W=0.41u L=0.04u
M1603 g27688 n3156 VSS VSS nmos W=0.31u L=0.04u
M1604 g27688 n3156 VDD VDD pmos W=0.41u L=0.04u
M1605 g29795 n3136 VSS VSS nmos W=0.31u L=0.04u
M1606 g29795 n3136 VDD VDD pmos W=0.41u L=0.04u
M1607 g29796 n3135 VSS VSS nmos W=0.31u L=0.04u
M1608 g29796 n3135 VDD VDD pmos W=0.41u L=0.04u
M1609 g30851 n3100 VSS VSS nmos W=0.31u L=0.04u
M1610 g30851 n3100 VDD VDD pmos W=0.41u L=0.04u
M1611 g30852 n3099 VSS VSS nmos W=0.31u L=0.04u
M1612 g30852 n3099 VDD VDD pmos W=0.41u L=0.04u
M1613 g30710 n3103 VSS VSS nmos W=0.31u L=0.04u
M1614 g30710 n3103 VDD VDD pmos W=0.41u L=0.04u
M1615 g30711 n3102 VSS VSS nmos W=0.31u L=0.04u
M1616 g30711 n3102 VDD VDD pmos W=0.41u L=0.04u
M1617 g29421 n3058 VSS VSS nmos W=0.31u L=0.04u
M1618 g29421 n3058 VDD VDD pmos W=0.41u L=0.04u
M1619 g29638 n3064 VSS VSS nmos W=0.31u L=0.04u
M1620 g29638 n3064 VDD VDD pmos W=0.41u L=0.04u
M1621 g27692 n3073 VSS VSS nmos W=0.31u L=0.04u
M1622 g27692 n3073 VDD VDD pmos W=0.41u L=0.04u
M1623 g27695 n3070 VSS VSS nmos W=0.31u L=0.04u
M1624 g27695 n3070 VDD VDD pmos W=0.41u L=0.04u
M1625 g29799 n3049 VSS VSS nmos W=0.31u L=0.04u
M1626 g29799 n3049 VDD VDD pmos W=0.41u L=0.04u
M1627 g30869 n3013 VSS VSS nmos W=0.31u L=0.04u
M1628 g30869 n3013 VDD VDD pmos W=0.41u L=0.04u
M1629 g30713 n3016 VSS VSS nmos W=0.31u L=0.04u
M1630 g30713 n3016 VDD VDD pmos W=0.41u L=0.04u
M1631 g29434 n2971 VSS VSS nmos W=0.31u L=0.04u
M1632 g29434 n2971 VDD VDD pmos W=0.41u L=0.04u
M1633 g29645 n2977 VSS VSS nmos W=0.31u L=0.04u
M1634 g29645 n2977 VDD VDD pmos W=0.41u L=0.04u
M1635 g27700 n2986 VSS VSS nmos W=0.31u L=0.04u
M1636 g27700 n2986 VDD VDD pmos W=0.41u L=0.04u
M1637 g27703 n2983 VSS VSS nmos W=0.31u L=0.04u
M1638 g27703 n2983 VDD VDD pmos W=0.41u L=0.04u
M1639 g29803 n2962 VSS VSS nmos W=0.31u L=0.04u
M1640 g29803 n2962 VDD VDD pmos W=0.41u L=0.04u
M1641 g30887 n2926 VSS VSS nmos W=0.31u L=0.04u
M1642 g30887 n2926 VDD VDD pmos W=0.41u L=0.04u
M1643 g30716 n2929 VSS VSS nmos W=0.31u L=0.04u
M1644 g30716 n2929 VDD VDD pmos W=0.41u L=0.04u
M1645 g29447 n3232 VSS VSS nmos W=0.31u L=0.04u
M1646 g29447 n3232 VDD VDD pmos W=0.41u L=0.04u
M1647 g29652 n3238 VSS VSS nmos W=0.31u L=0.04u
M1648 g29652 n3238 VDD VDD pmos W=0.41u L=0.04u
M1649 g27708 n3247 VSS VSS nmos W=0.31u L=0.04u
M1650 g27708 n3247 VDD VDD pmos W=0.41u L=0.04u
M1651 g27711 n3244 VSS VSS nmos W=0.31u L=0.04u
M1652 g27711 n3244 VDD VDD pmos W=0.41u L=0.04u
M1653 g29807 n3223 VSS VSS nmos W=0.31u L=0.04u
M1654 g29807 n3223 VDD VDD pmos W=0.41u L=0.04u
M1655 g30905 n3187 VSS VSS nmos W=0.31u L=0.04u
M1656 g30905 n3187 VDD VDD pmos W=0.41u L=0.04u
M1657 g30719 n3190 VSS VSS nmos W=0.31u L=0.04u
M1658 g30719 n3190 VDD VDD pmos W=0.41u L=0.04u
M1659 g30315 n3391 VSS VSS nmos W=0.31u L=0.04u
M1660 g30315 n3391 VDD VDD pmos W=0.41u L=0.04u
M1661 g30316 n3393 VSS VSS nmos W=0.31u L=0.04u
M1662 g30316 n3393 VDD VDD pmos W=0.41u L=0.04u
M1663 g30318 n3382 VSS VSS nmos W=0.31u L=0.04u
M1664 g30318 n3382 VDD VDD pmos W=0.41u L=0.04u
M1665 g30319 n3385 VSS VSS nmos W=0.31u L=0.04u
M1666 g30319 n3385 VDD VDD pmos W=0.41u L=0.04u
M1667 g30324 n3446 VSS VSS nmos W=0.31u L=0.04u
M1668 g30324 n3446 VDD VDD pmos W=0.41u L=0.04u
M1669 g30323 n3442 VSS VSS nmos W=0.31u L=0.04u
M1670 g30323 n3442 VDD VDD pmos W=0.41u L=0.04u
M1671 g30322 n3438 VSS VSS nmos W=0.31u L=0.04u
M1672 g30322 n3438 VDD VDD pmos W=0.41u L=0.04u
M1673 g30321 n3434 VSS VSS nmos W=0.31u L=0.04u
M1674 g30321 n3434 VDD VDD pmos W=0.41u L=0.04u
M1675 g30320 n3430 VSS VSS nmos W=0.31u L=0.04u
M1676 g30320 n3430 VDD VDD pmos W=0.41u L=0.04u
M1677 g29422 n3057 VSS VSS nmos W=0.31u L=0.04u
M1678 g29422 n3057 VDD VDD pmos W=0.41u L=0.04u
M1679 g29639 n3063 VSS VSS nmos W=0.31u L=0.04u
M1680 g29639 n3063 VDD VDD pmos W=0.41u L=0.04u
M1681 g27693 n3072 VSS VSS nmos W=0.31u L=0.04u
M1682 g27693 n3072 VDD VDD pmos W=0.41u L=0.04u
M1683 g27696 n3069 VSS VSS nmos W=0.31u L=0.04u
M1684 g27696 n3069 VDD VDD pmos W=0.41u L=0.04u
M1685 g29800 n3048 VSS VSS nmos W=0.31u L=0.04u
M1686 g29800 n3048 VDD VDD pmos W=0.41u L=0.04u
M1687 g30870 n3012 VSS VSS nmos W=0.31u L=0.04u
M1688 g30870 n3012 VDD VDD pmos W=0.41u L=0.04u
M1689 g30714 n3015 VSS VSS nmos W=0.31u L=0.04u
M1690 g30714 n3015 VDD VDD pmos W=0.41u L=0.04u
M1691 g29435 n2970 VSS VSS nmos W=0.31u L=0.04u
M1692 g29435 n2970 VDD VDD pmos W=0.41u L=0.04u
M1693 g29646 n2976 VSS VSS nmos W=0.31u L=0.04u
M1694 g29646 n2976 VDD VDD pmos W=0.41u L=0.04u
M1695 g27701 n2985 VSS VSS nmos W=0.31u L=0.04u
M1696 g27701 n2985 VDD VDD pmos W=0.41u L=0.04u
M1697 g27704 n2982 VSS VSS nmos W=0.31u L=0.04u
M1698 g27704 n2982 VDD VDD pmos W=0.41u L=0.04u
M1699 g29804 n2961 VSS VSS nmos W=0.31u L=0.04u
M1700 g29804 n2961 VDD VDD pmos W=0.41u L=0.04u
M1701 g30888 n2925 VSS VSS nmos W=0.31u L=0.04u
M1702 g30888 n2925 VDD VDD pmos W=0.41u L=0.04u
M1703 g30717 n2928 VSS VSS nmos W=0.31u L=0.04u
M1704 g30717 n2928 VDD VDD pmos W=0.41u L=0.04u
M1705 g29448 n3231 VSS VSS nmos W=0.31u L=0.04u
M1706 g29448 n3231 VDD VDD pmos W=0.41u L=0.04u
M1707 g29653 n3237 VSS VSS nmos W=0.31u L=0.04u
M1708 g29653 n3237 VDD VDD pmos W=0.41u L=0.04u
M1709 g27709 n3246 VSS VSS nmos W=0.31u L=0.04u
M1710 g27709 n3246 VDD VDD pmos W=0.41u L=0.04u
M1711 g27712 n3243 VSS VSS nmos W=0.31u L=0.04u
M1712 g27712 n3243 VDD VDD pmos W=0.41u L=0.04u
M1713 g29808 n3222 VSS VSS nmos W=0.31u L=0.04u
M1714 g29808 n3222 VDD VDD pmos W=0.41u L=0.04u
M1715 g30906 n3186 VSS VSS nmos W=0.31u L=0.04u
M1716 g30906 n3186 VDD VDD pmos W=0.41u L=0.04u
M1717 g30720 n3189 VSS VSS nmos W=0.31u L=0.04u
M1718 g30720 n3189 VDD VDD pmos W=0.41u L=0.04u
M1719 g29419 n3146 VSS VSS nmos W=0.31u L=0.04u
M1720 g29419 n3146 VDD VDD pmos W=0.41u L=0.04u
M1721 g28676 n3154 VSS VSS nmos W=0.31u L=0.04u
M1722 g28676 n3154 VDD VDD pmos W=0.41u L=0.04u
M1723 g29630 n3104 VSS VSS nmos W=0.31u L=0.04u
M1724 g29630 n3104 VDD VDD pmos W=0.41u L=0.04u
M1725 g27193 n3137 VSS VSS nmos W=0.31u L=0.04u
M1726 g27193 n3137 VDD VDD pmos W=0.41u L=0.04u
M1727 g29426 n3059 VSS VSS nmos W=0.31u L=0.04u
M1728 g29426 n3059 VDD VDD pmos W=0.41u L=0.04u
M1729 g28681 n3067 VSS VSS nmos W=0.31u L=0.04u
M1730 g28681 n3067 VDD VDD pmos W=0.41u L=0.04u
M1731 g29637 n3017 VSS VSS nmos W=0.31u L=0.04u
M1732 g29637 n3017 VDD VDD pmos W=0.41u L=0.04u
M1733 g27208 n3050 VSS VSS nmos W=0.31u L=0.04u
M1734 g27208 n3050 VDD VDD pmos W=0.41u L=0.04u
M1735 g29439 n2972 VSS VSS nmos W=0.31u L=0.04u
M1736 g29439 n2972 VDD VDD pmos W=0.41u L=0.04u
M1737 g28686 n2980 VSS VSS nmos W=0.31u L=0.04u
M1738 g28686 n2980 VDD VDD pmos W=0.41u L=0.04u
M1739 g29644 n2930 VSS VSS nmos W=0.31u L=0.04u
M1740 g29644 n2930 VDD VDD pmos W=0.41u L=0.04u
M1741 g27223 n2963 VSS VSS nmos W=0.31u L=0.04u
M1742 g27223 n2963 VDD VDD pmos W=0.41u L=0.04u
M1743 g29452 n3233 VSS VSS nmos W=0.31u L=0.04u
M1744 g29452 n3233 VDD VDD pmos W=0.41u L=0.04u
M1745 g28691 n3241 VSS VSS nmos W=0.31u L=0.04u
M1746 g28691 n3241 VDD VDD pmos W=0.41u L=0.04u
M1747 g29651 n3191 VSS VSS nmos W=0.31u L=0.04u
M1748 g29651 n3191 VDD VDD pmos W=0.41u L=0.04u
M1749 g27232 n3224 VSS VSS nmos W=0.31u L=0.04u
M1750 g27232 n3224 VDD VDD pmos W=0.41u L=0.04u
M1751 g29417 n3148 VSS VSS nmos W=0.31u L=0.04u
M1752 g29417 n3148 VDD VDD pmos W=0.41u L=0.04u
M1753 g29418 n3147 VSS VSS nmos W=0.31u L=0.04u
M1754 g29418 n3147 VDD VDD pmos W=0.41u L=0.04u
M1755 g28674 n3152 VSS VSS nmos W=0.31u L=0.04u
M1756 g28674 n3152 VDD VDD pmos W=0.41u L=0.04u
M1757 g28675 n3153 VSS VSS nmos W=0.31u L=0.04u
M1758 g28675 n3153 VDD VDD pmos W=0.41u L=0.04u
M1759 g29628 n3105 VSS VSS nmos W=0.31u L=0.04u
M1760 g29628 n3105 VDD VDD pmos W=0.41u L=0.04u
M1761 g29629 n3106 VSS VSS nmos W=0.31u L=0.04u
M1762 g29629 n3106 VDD VDD pmos W=0.41u L=0.04u
M1763 g27191 n3139 VSS VSS nmos W=0.31u L=0.04u
M1764 g27191 n3139 VDD VDD pmos W=0.41u L=0.04u
M1765 g27192 n3138 VSS VSS nmos W=0.31u L=0.04u
M1766 g27192 n3138 VDD VDD pmos W=0.41u L=0.04u
M1767 g29424 n3061 VSS VSS nmos W=0.31u L=0.04u
M1768 g29424 n3061 VDD VDD pmos W=0.41u L=0.04u
M1769 g28679 n3065 VSS VSS nmos W=0.31u L=0.04u
M1770 g28679 n3065 VDD VDD pmos W=0.41u L=0.04u
M1771 g29635 n3018 VSS VSS nmos W=0.31u L=0.04u
M1772 g29635 n3018 VDD VDD pmos W=0.41u L=0.04u
M1773 g27206 n3052 VSS VSS nmos W=0.31u L=0.04u
M1774 g27206 n3052 VDD VDD pmos W=0.41u L=0.04u
M1775 g29437 n2974 VSS VSS nmos W=0.31u L=0.04u
M1776 g29437 n2974 VDD VDD pmos W=0.41u L=0.04u
M1777 g28684 n2978 VSS VSS nmos W=0.31u L=0.04u
M1778 g28684 n2978 VDD VDD pmos W=0.41u L=0.04u
M1779 g29642 n2931 VSS VSS nmos W=0.31u L=0.04u
M1780 g29642 n2931 VDD VDD pmos W=0.41u L=0.04u
M1781 g27221 n2965 VSS VSS nmos W=0.31u L=0.04u
M1782 g27221 n2965 VDD VDD pmos W=0.41u L=0.04u
M1783 g29450 n3235 VSS VSS nmos W=0.31u L=0.04u
M1784 g29450 n3235 VDD VDD pmos W=0.41u L=0.04u
M1785 g28689 n3239 VSS VSS nmos W=0.31u L=0.04u
M1786 g28689 n3239 VDD VDD pmos W=0.41u L=0.04u
M1787 g29649 n3192 VSS VSS nmos W=0.31u L=0.04u
M1788 g29649 n3192 VDD VDD pmos W=0.41u L=0.04u
M1789 g27230 n3226 VSS VSS nmos W=0.31u L=0.04u
M1790 g27230 n3226 VDD VDD pmos W=0.41u L=0.04u
M1791 g29425 n3060 VSS VSS nmos W=0.31u L=0.04u
M1792 g29425 n3060 VDD VDD pmos W=0.41u L=0.04u
M1793 g28680 n3066 VSS VSS nmos W=0.31u L=0.04u
M1794 g28680 n3066 VDD VDD pmos W=0.41u L=0.04u
M1795 g29636 n3019 VSS VSS nmos W=0.31u L=0.04u
M1796 g29636 n3019 VDD VDD pmos W=0.41u L=0.04u
M1797 g27207 n3051 VSS VSS nmos W=0.31u L=0.04u
M1798 g27207 n3051 VDD VDD pmos W=0.41u L=0.04u
M1799 g29438 n2973 VSS VSS nmos W=0.31u L=0.04u
M1800 g29438 n2973 VDD VDD pmos W=0.41u L=0.04u
M1801 g28685 n2979 VSS VSS nmos W=0.31u L=0.04u
M1802 g28685 n2979 VDD VDD pmos W=0.41u L=0.04u
M1803 g29643 n2932 VSS VSS nmos W=0.31u L=0.04u
M1804 g29643 n2932 VDD VDD pmos W=0.41u L=0.04u
M1805 g27222 n2964 VSS VSS nmos W=0.31u L=0.04u
M1806 g27222 n2964 VDD VDD pmos W=0.41u L=0.04u
M1807 g29451 n3234 VSS VSS nmos W=0.31u L=0.04u
M1808 g29451 n3234 VDD VDD pmos W=0.41u L=0.04u
M1809 g28690 n3240 VSS VSS nmos W=0.31u L=0.04u
M1810 g28690 n3240 VDD VDD pmos W=0.41u L=0.04u
M1811 g29650 n3193 VSS VSS nmos W=0.31u L=0.04u
M1812 g29650 n3193 VDD VDD pmos W=0.41u L=0.04u
M1813 g27231 n3225 VSS VSS nmos W=0.31u L=0.04u
M1814 g27231 n3225 VDD VDD pmos W=0.41u L=0.04u
M1815 g30521 n3036 VSS VSS nmos W=0.31u L=0.04u
M1816 g30521 n3036 VDD VDD pmos W=0.41u L=0.04u
M1817 g30860 n3022 VSS VSS nmos W=0.31u L=0.04u
M1818 g30860 n3022 VDD VDD pmos W=0.41u L=0.04u
M1819 g30854 n3023 VSS VSS nmos W=0.31u L=0.04u
M1820 g30854 n3023 VDD VDD pmos W=0.41u L=0.04u
M1821 g30863 n3028 VSS VSS nmos W=0.31u L=0.04u
M1822 g30863 n3028 VDD VDD pmos W=0.41u L=0.04u
M1823 g30524 n3040 VSS VSS nmos W=0.31u L=0.04u
M1824 g30524 n3040 VDD VDD pmos W=0.41u L=0.04u
M1825 g30530 n3043 VSS VSS nmos W=0.31u L=0.04u
M1826 g30530 n3043 VDD VDD pmos W=0.41u L=0.04u
M1827 g30527 n3046 VSS VSS nmos W=0.31u L=0.04u
M1828 g30527 n3046 VDD VDD pmos W=0.41u L=0.04u
M1829 g30533 n3010 VSS VSS nmos W=0.31u L=0.04u
M1830 g30533 n3010 VDD VDD pmos W=0.41u L=0.04u
M1831 g30857 n3031 VSS VSS nmos W=0.31u L=0.04u
M1832 g30857 n3031 VDD VDD pmos W=0.41u L=0.04u
M1833 g30866 n3033 VSS VSS nmos W=0.31u L=0.04u
M1834 g30866 n3033 VDD VDD pmos W=0.41u L=0.04u
M1835 g30507 n3123 VSS VSS nmos W=0.31u L=0.04u
M1836 g30507 n3123 VDD VDD pmos W=0.41u L=0.04u
M1837 g30843 n3108 VSS VSS nmos W=0.31u L=0.04u
M1838 g30843 n3108 VDD VDD pmos W=0.41u L=0.04u
M1839 g30837 n3110 VSS VSS nmos W=0.31u L=0.04u
M1840 g30837 n3110 VDD VDD pmos W=0.41u L=0.04u
M1841 g30846 n3114 VSS VSS nmos W=0.31u L=0.04u
M1842 g30846 n3114 VDD VDD pmos W=0.41u L=0.04u
M1843 g30510 n3127 VSS VSS nmos W=0.31u L=0.04u
M1844 g30510 n3127 VDD VDD pmos W=0.41u L=0.04u
M1845 g30516 n3129 VSS VSS nmos W=0.31u L=0.04u
M1846 g30516 n3129 VDD VDD pmos W=0.41u L=0.04u
M1847 g30513 n3132 VSS VSS nmos W=0.31u L=0.04u
M1848 g30513 n3132 VDD VDD pmos W=0.41u L=0.04u
M1849 g30519 n3096 VSS VSS nmos W=0.31u L=0.04u
M1850 g30519 n3096 VDD VDD pmos W=0.41u L=0.04u
M1851 g30840 n3117 VSS VSS nmos W=0.31u L=0.04u
M1852 g30840 n3117 VDD VDD pmos W=0.41u L=0.04u
M1853 g30849 n3120 VSS VSS nmos W=0.31u L=0.04u
M1854 g30849 n3120 VDD VDD pmos W=0.41u L=0.04u
M1855 g30537 n2950 VSS VSS nmos W=0.31u L=0.04u
M1856 g30537 n2950 VDD VDD pmos W=0.41u L=0.04u
M1857 g30879 n2934 VSS VSS nmos W=0.31u L=0.04u
M1858 g30879 n2934 VDD VDD pmos W=0.41u L=0.04u
M1859 g30873 n2937 VSS VSS nmos W=0.31u L=0.04u
M1860 g30873 n2937 VDD VDD pmos W=0.41u L=0.04u
M1861 g30882 n2940 VSS VSS nmos W=0.31u L=0.04u
M1862 g30882 n2940 VDD VDD pmos W=0.41u L=0.04u
M1863 g30540 n2952 VSS VSS nmos W=0.31u L=0.04u
M1864 g30540 n2952 VDD VDD pmos W=0.41u L=0.04u
M1865 g30546 n2955 VSS VSS nmos W=0.31u L=0.04u
M1866 g30546 n2955 VDD VDD pmos W=0.41u L=0.04u
M1867 g30543 n2958 VSS VSS nmos W=0.31u L=0.04u
M1868 g30543 n2958 VDD VDD pmos W=0.41u L=0.04u
M1869 g30549 n2921 VSS VSS nmos W=0.31u L=0.04u
M1870 g30549 n2921 VDD VDD pmos W=0.41u L=0.04u
M1871 g30876 n2943 VSS VSS nmos W=0.31u L=0.04u
M1872 g30876 n2943 VDD VDD pmos W=0.41u L=0.04u
M1873 g30885 n2947 VSS VSS nmos W=0.31u L=0.04u
M1874 g30885 n2947 VDD VDD pmos W=0.41u L=0.04u
M1875 g30552 n3210 VSS VSS nmos W=0.31u L=0.04u
M1876 g30552 n3210 VDD VDD pmos W=0.41u L=0.04u
M1877 g30897 n3195 VSS VSS nmos W=0.31u L=0.04u
M1878 g30897 n3195 VDD VDD pmos W=0.41u L=0.04u
M1879 g30891 n3198 VSS VSS nmos W=0.31u L=0.04u
M1880 g30891 n3198 VDD VDD pmos W=0.41u L=0.04u
M1881 g30900 n3201 VSS VSS nmos W=0.31u L=0.04u
M1882 g30900 n3201 VDD VDD pmos W=0.41u L=0.04u
M1883 g30555 n3213 VSS VSS nmos W=0.31u L=0.04u
M1884 g30555 n3213 VDD VDD pmos W=0.41u L=0.04u
M1885 g30561 n3215 VSS VSS nmos W=0.31u L=0.04u
M1886 g30561 n3215 VDD VDD pmos W=0.41u L=0.04u
M1887 g30558 n3219 VSS VSS nmos W=0.31u L=0.04u
M1888 g30558 n3219 VDD VDD pmos W=0.41u L=0.04u
M1889 g30564 n3184 VSS VSS nmos W=0.31u L=0.04u
M1890 g30564 n3184 VDD VDD pmos W=0.41u L=0.04u
M1891 g30894 n3204 VSS VSS nmos W=0.31u L=0.04u
M1892 g30894 n3204 VDD VDD pmos W=0.41u L=0.04u
M1893 g30903 n3207 VSS VSS nmos W=0.31u L=0.04u
M1894 g30903 n3207 VDD VDD pmos W=0.41u L=0.04u
M1895 g30508 n3122 VSS VSS nmos W=0.31u L=0.04u
M1896 g30508 n3122 VDD VDD pmos W=0.41u L=0.04u
M1897 g30844 n3107 VSS VSS nmos W=0.31u L=0.04u
M1898 g30844 n3107 VDD VDD pmos W=0.41u L=0.04u
M1899 g30838 n3112 VSS VSS nmos W=0.31u L=0.04u
M1900 g30838 n3112 VDD VDD pmos W=0.41u L=0.04u
M1901 g30847 n3113 VSS VSS nmos W=0.31u L=0.04u
M1902 g30847 n3113 VDD VDD pmos W=0.41u L=0.04u
M1903 g30511 n3126 VSS VSS nmos W=0.31u L=0.04u
M1904 g30511 n3126 VDD VDD pmos W=0.41u L=0.04u
M1905 g30517 n3128 VSS VSS nmos W=0.31u L=0.04u
M1906 g30517 n3128 VDD VDD pmos W=0.41u L=0.04u
M1907 g30514 n3131 VSS VSS nmos W=0.31u L=0.04u
M1908 g30514 n3131 VDD VDD pmos W=0.41u L=0.04u
M1909 g30520 n3095 VSS VSS nmos W=0.31u L=0.04u
M1910 g30520 n3095 VDD VDD pmos W=0.41u L=0.04u
M1911 g30841 n3116 VSS VSS nmos W=0.31u L=0.04u
M1912 g30841 n3116 VDD VDD pmos W=0.41u L=0.04u
M1913 g30850 n3119 VSS VSS nmos W=0.31u L=0.04u
M1914 g30850 n3119 VDD VDD pmos W=0.41u L=0.04u
M1915 g30538 n2949 VSS VSS nmos W=0.31u L=0.04u
M1916 g30538 n2949 VDD VDD pmos W=0.41u L=0.04u
M1917 g30880 n2933 VSS VSS nmos W=0.31u L=0.04u
M1918 g30880 n2933 VDD VDD pmos W=0.41u L=0.04u
M1919 g30874 n2936 VSS VSS nmos W=0.31u L=0.04u
M1920 g30874 n2936 VDD VDD pmos W=0.41u L=0.04u
M1921 g30883 n2939 VSS VSS nmos W=0.31u L=0.04u
M1922 g30883 n2939 VDD VDD pmos W=0.41u L=0.04u
M1923 g30541 n2951 VSS VSS nmos W=0.31u L=0.04u
M1924 g30541 n2951 VDD VDD pmos W=0.41u L=0.04u
M1925 g30547 n2954 VSS VSS nmos W=0.31u L=0.04u
M1926 g30547 n2954 VDD VDD pmos W=0.41u L=0.04u
M1927 g30544 n2957 VSS VSS nmos W=0.31u L=0.04u
M1928 g30544 n2957 VDD VDD pmos W=0.41u L=0.04u
M1929 g30550 n2923 VSS VSS nmos W=0.31u L=0.04u
M1930 g30550 n2923 VDD VDD pmos W=0.41u L=0.04u
M1931 g30877 n2942 VSS VSS nmos W=0.31u L=0.04u
M1932 g30877 n2942 VDD VDD pmos W=0.41u L=0.04u
M1933 g30886 n2946 VSS VSS nmos W=0.31u L=0.04u
M1934 g30886 n2946 VDD VDD pmos W=0.41u L=0.04u
M1935 g30553 n3209 VSS VSS nmos W=0.31u L=0.04u
M1936 g30553 n3209 VDD VDD pmos W=0.41u L=0.04u
M1937 g30898 n3194 VSS VSS nmos W=0.31u L=0.04u
M1938 g30898 n3194 VDD VDD pmos W=0.41u L=0.04u
M1939 g30892 n3197 VSS VSS nmos W=0.31u L=0.04u
M1940 g30892 n3197 VDD VDD pmos W=0.41u L=0.04u
M1941 g30901 n3200 VSS VSS nmos W=0.31u L=0.04u
M1942 g30901 n3200 VDD VDD pmos W=0.41u L=0.04u
M1943 g30556 n3212 VSS VSS nmos W=0.31u L=0.04u
M1944 g30556 n3212 VDD VDD pmos W=0.41u L=0.04u
M1945 g30562 n3217 VSS VSS nmos W=0.31u L=0.04u
M1946 g30562 n3217 VDD VDD pmos W=0.41u L=0.04u
M1947 g30559 n3218 VSS VSS nmos W=0.31u L=0.04u
M1948 g30559 n3218 VDD VDD pmos W=0.41u L=0.04u
M1949 g30565 n3183 VSS VSS nmos W=0.31u L=0.04u
M1950 g30565 n3183 VDD VDD pmos W=0.41u L=0.04u
M1951 g30895 n3203 VSS VSS nmos W=0.31u L=0.04u
M1952 g30895 n3203 VDD VDD pmos W=0.41u L=0.04u
M1953 g30904 n3206 VSS VSS nmos W=0.31u L=0.04u
M1954 g30904 n3206 VDD VDD pmos W=0.41u L=0.04u
M1955 g30506 n3124 VSS VSS nmos W=0.31u L=0.04u
M1956 g30506 n3124 VDD VDD pmos W=0.41u L=0.04u
M1957 g30842 n3109 VSS VSS nmos W=0.31u L=0.04u
M1958 g30842 n3109 VDD VDD pmos W=0.41u L=0.04u
M1959 g30836 n3111 VSS VSS nmos W=0.31u L=0.04u
M1960 g30836 n3111 VDD VDD pmos W=0.41u L=0.04u
M1961 g30845 n3115 VSS VSS nmos W=0.31u L=0.04u
M1962 g30845 n3115 VDD VDD pmos W=0.41u L=0.04u
M1963 g30509 n3125 VSS VSS nmos W=0.31u L=0.04u
M1964 g30509 n3125 VDD VDD pmos W=0.41u L=0.04u
M1965 g30515 n3130 VSS VSS nmos W=0.31u L=0.04u
M1966 g30515 n3130 VDD VDD pmos W=0.41u L=0.04u
M1967 g30512 n3133 VSS VSS nmos W=0.31u L=0.04u
M1968 g30512 n3133 VDD VDD pmos W=0.41u L=0.04u
M1969 g30518 n3097 VSS VSS nmos W=0.31u L=0.04u
M1970 g30518 n3097 VDD VDD pmos W=0.41u L=0.04u
M1971 g30839 n3118 VSS VSS nmos W=0.31u L=0.04u
M1972 g30839 n3118 VDD VDD pmos W=0.41u L=0.04u
M1973 g30848 n3121 VSS VSS nmos W=0.31u L=0.04u
M1974 g30848 n3121 VDD VDD pmos W=0.41u L=0.04u
M1975 g30522 n3035 VSS VSS nmos W=0.31u L=0.04u
M1976 g30522 n3035 VDD VDD pmos W=0.41u L=0.04u
M1977 g30861 n3021 VSS VSS nmos W=0.31u L=0.04u
M1978 g30861 n3021 VDD VDD pmos W=0.41u L=0.04u
M1979 g30855 n3025 VSS VSS nmos W=0.31u L=0.04u
M1980 g30855 n3025 VDD VDD pmos W=0.41u L=0.04u
M1981 g30864 n3027 VSS VSS nmos W=0.31u L=0.04u
M1982 g30864 n3027 VDD VDD pmos W=0.41u L=0.04u
M1983 g30525 n3039 VSS VSS nmos W=0.31u L=0.04u
M1984 g30525 n3039 VDD VDD pmos W=0.41u L=0.04u
M1985 g30531 n3042 VSS VSS nmos W=0.31u L=0.04u
M1986 g30531 n3042 VDD VDD pmos W=0.41u L=0.04u
M1987 g30528 n3045 VSS VSS nmos W=0.31u L=0.04u
M1988 g30528 n3045 VDD VDD pmos W=0.41u L=0.04u
M1989 g30534 n3009 VSS VSS nmos W=0.31u L=0.04u
M1990 g30534 n3009 VDD VDD pmos W=0.41u L=0.04u
M1991 g30858 n3030 VSS VSS nmos W=0.31u L=0.04u
M1992 g30858 n3030 VDD VDD pmos W=0.41u L=0.04u
M1993 g30867 n3032 VSS VSS nmos W=0.31u L=0.04u
M1994 g30867 n3032 VDD VDD pmos W=0.41u L=0.04u
M1995 g30536 n2948 VSS VSS nmos W=0.31u L=0.04u
M1996 g30536 n2948 VDD VDD pmos W=0.41u L=0.04u
M1997 g30878 n2935 VSS VSS nmos W=0.31u L=0.04u
M1998 g30878 n2935 VDD VDD pmos W=0.41u L=0.04u
M1999 g30872 n2938 VSS VSS nmos W=0.31u L=0.04u
M2000 g30872 n2938 VDD VDD pmos W=0.41u L=0.04u
M2001 g30881 n2941 VSS VSS nmos W=0.31u L=0.04u
M2002 g30881 n2941 VDD VDD pmos W=0.41u L=0.04u
M2003 g30539 n2953 VSS VSS nmos W=0.31u L=0.04u
M2004 g30539 n2953 VDD VDD pmos W=0.41u L=0.04u
M2005 g30545 n2956 VSS VSS nmos W=0.31u L=0.04u
M2006 g30545 n2956 VDD VDD pmos W=0.41u L=0.04u
M2007 g30542 n2959 VSS VSS nmos W=0.31u L=0.04u
M2008 g30542 n2959 VDD VDD pmos W=0.41u L=0.04u
M2009 g30548 n2922 VSS VSS nmos W=0.31u L=0.04u
M2010 g30548 n2922 VDD VDD pmos W=0.41u L=0.04u
M2011 g30875 n2944 VSS VSS nmos W=0.31u L=0.04u
M2012 g30875 n2944 VDD VDD pmos W=0.41u L=0.04u
M2013 g30884 n2945 VSS VSS nmos W=0.31u L=0.04u
M2014 g30884 n2945 VDD VDD pmos W=0.41u L=0.04u
M2015 g30551 n3211 VSS VSS nmos W=0.31u L=0.04u
M2016 g30551 n3211 VDD VDD pmos W=0.41u L=0.04u
M2017 g30896 n3196 VSS VSS nmos W=0.31u L=0.04u
M2018 g30896 n3196 VDD VDD pmos W=0.41u L=0.04u
M2019 g30890 n3199 VSS VSS nmos W=0.31u L=0.04u
M2020 g30890 n3199 VDD VDD pmos W=0.41u L=0.04u
M2021 g30899 n3202 VSS VSS nmos W=0.31u L=0.04u
M2022 g30899 n3202 VDD VDD pmos W=0.41u L=0.04u
M2023 g30554 n3214 VSS VSS nmos W=0.31u L=0.04u
M2024 g30554 n3214 VDD VDD pmos W=0.41u L=0.04u
M2025 g30560 n3216 VSS VSS nmos W=0.31u L=0.04u
M2026 g30560 n3216 VDD VDD pmos W=0.41u L=0.04u
M2027 g30557 n3220 VSS VSS nmos W=0.31u L=0.04u
M2028 g30557 n3220 VDD VDD pmos W=0.41u L=0.04u
M2029 g30563 n3182 VSS VSS nmos W=0.31u L=0.04u
M2030 g30563 n3182 VDD VDD pmos W=0.41u L=0.04u
M2031 g30893 n3205 VSS VSS nmos W=0.31u L=0.04u
M2032 g30893 n3205 VDD VDD pmos W=0.41u L=0.04u
M2033 g30902 n3208 VSS VSS nmos W=0.31u L=0.04u
M2034 g30902 n3208 VDD VDD pmos W=0.41u L=0.04u
M2035 g30523 n3037 VSS VSS nmos W=0.31u L=0.04u
M2036 g30523 n3037 VDD VDD pmos W=0.41u L=0.04u
M2037 g30862 n3020 VSS VSS nmos W=0.31u L=0.04u
M2038 g30862 n3020 VDD VDD pmos W=0.41u L=0.04u
M2039 g30856 n3024 VSS VSS nmos W=0.31u L=0.04u
M2040 g30856 n3024 VDD VDD pmos W=0.41u L=0.04u
M2041 g30865 n3026 VSS VSS nmos W=0.31u L=0.04u
M2042 g30865 n3026 VDD VDD pmos W=0.41u L=0.04u
M2043 g30526 n3038 VSS VSS nmos W=0.31u L=0.04u
M2044 g30526 n3038 VDD VDD pmos W=0.41u L=0.04u
M2045 g30532 n3041 VSS VSS nmos W=0.31u L=0.04u
M2046 g30532 n3041 VDD VDD pmos W=0.41u L=0.04u
M2047 g30529 n3044 VSS VSS nmos W=0.31u L=0.04u
M2048 g30529 n3044 VDD VDD pmos W=0.41u L=0.04u
M2049 g30535 n3008 VSS VSS nmos W=0.31u L=0.04u
M2050 g30535 n3008 VDD VDD pmos W=0.41u L=0.04u
M2051 g30859 n3029 VSS VSS nmos W=0.31u L=0.04u
M2052 g30859 n3029 VDD VDD pmos W=0.41u L=0.04u
M2053 g30868 n3034 VSS VSS nmos W=0.31u L=0.04u
M2054 g30868 n3034 VDD VDD pmos W=0.41u L=0.04u
M2055 g19022 n3426 VSS VSS nmos W=0.31u L=0.04u
M2056 g19022 n3426 VDD VDD pmos W=0.41u L=0.04u
M2057 g19034 n3546 VSS VSS nmos W=0.31u L=0.04u
M2058 g19034 n3546 VDD VDD pmos W=0.41u L=0.04u
M2059 g19046 n3646 VSS VSS nmos W=0.31u L=0.04u
M2060 g19046 n3646 VDD VDD pmos W=0.41u L=0.04u
M2061 g19058 n3746 VSS VSS nmos W=0.31u L=0.04u
M2062 g19058 n3746 VDD VDD pmos W=0.41u L=0.04u
M2063 g24298 n3485 VSS VSS nmos W=0.31u L=0.04u
M2064 g24298 n3485 VDD VDD pmos W=0.41u L=0.04u
M2065 g24339 n3585 VSS VSS nmos W=0.31u L=0.04u
M2066 g24339 n3585 VDD VDD pmos W=0.41u L=0.04u
M2067 g24380 n3685 VSS VSS nmos W=0.31u L=0.04u
M2068 g24380 n3685 VDD VDD pmos W=0.41u L=0.04u
M2069 g24421 n3785 VSS VSS nmos W=0.31u L=0.04u
M2070 g24421 n3785 VDD VDD pmos W=0.41u L=0.04u
M2071 g24297 n3484 VSS VSS nmos W=0.31u L=0.04u
M2072 g24297 n3484 VDD VDD pmos W=0.41u L=0.04u
M2073 g24299 n3486 VSS VSS nmos W=0.31u L=0.04u
M2074 g24299 n3486 VDD VDD pmos W=0.41u L=0.04u
M2075 g24338 n3584 VSS VSS nmos W=0.31u L=0.04u
M2076 g24338 n3584 VDD VDD pmos W=0.41u L=0.04u
M2077 g24340 n3586 VSS VSS nmos W=0.31u L=0.04u
M2078 g24340 n3586 VDD VDD pmos W=0.41u L=0.04u
M2079 g24379 n3684 VSS VSS nmos W=0.31u L=0.04u
M2080 g24379 n3684 VDD VDD pmos W=0.41u L=0.04u
M2081 g24381 n3686 VSS VSS nmos W=0.31u L=0.04u
M2082 g24381 n3686 VDD VDD pmos W=0.41u L=0.04u
M2083 g24420 n3784 VSS VSS nmos W=0.31u L=0.04u
M2084 g24420 n3784 VDD VDD pmos W=0.41u L=0.04u
M2085 g24422 n3786 VSS VSS nmos W=0.31u L=0.04u
M2086 g24422 n3786 VDD VDD pmos W=0.41u L=0.04u
M2087 g19021 n3425 VSS VSS nmos W=0.31u L=0.04u
M2088 g19021 n3425 VDD VDD pmos W=0.41u L=0.04u
M2089 g19023 n3424 VSS VSS nmos W=0.31u L=0.04u
M2090 g19023 n3424 VDD VDD pmos W=0.41u L=0.04u
M2091 g19033 n3545 VSS VSS nmos W=0.31u L=0.04u
M2092 g19033 n3545 VDD VDD pmos W=0.41u L=0.04u
M2093 g19035 n3544 VSS VSS nmos W=0.31u L=0.04u
M2094 g19035 n3544 VDD VDD pmos W=0.41u L=0.04u
M2095 g19045 n3645 VSS VSS nmos W=0.31u L=0.04u
M2096 g19045 n3645 VDD VDD pmos W=0.41u L=0.04u
M2097 g19047 n3644 VSS VSS nmos W=0.31u L=0.04u
M2098 g19047 n3644 VDD VDD pmos W=0.41u L=0.04u
M2099 g19057 n3745 VSS VSS nmos W=0.31u L=0.04u
M2100 g19057 n3745 VDD VDD pmos W=0.41u L=0.04u
M2101 g19059 n3744 VSS VSS nmos W=0.31u L=0.04u
M2102 g19059 n3744 VDD VDD pmos W=0.41u L=0.04u
M2103 g23163 n3472 VSS VSS nmos W=0.31u L=0.04u
M2104 g23163 n3472 VDD VDD pmos W=0.41u L=0.04u
M2105 g23166 n3469 VSS VSS nmos W=0.31u L=0.04u
M2106 g23166 n3469 VDD VDD pmos W=0.41u L=0.04u
M2107 g23169 n3466 VSS VSS nmos W=0.31u L=0.04u
M2108 g23169 n3466 VDD VDD pmos W=0.41u L=0.04u
M2109 g23172 n3464 VSS VSS nmos W=0.31u L=0.04u
M2110 g23172 n3464 VDD VDD pmos W=0.41u L=0.04u
M2111 g23175 n3462 VSS VSS nmos W=0.31u L=0.04u
M2112 g23175 n3462 VDD VDD pmos W=0.41u L=0.04u
M2113 g23178 n3460 VSS VSS nmos W=0.31u L=0.04u
M2114 g23178 n3460 VDD VDD pmos W=0.41u L=0.04u
M2115 g23181 n3458 VSS VSS nmos W=0.31u L=0.04u
M2116 g23181 n3458 VDD VDD pmos W=0.41u L=0.04u
M2117 g23184 n3455 VSS VSS nmos W=0.31u L=0.04u
M2118 g23184 n3455 VDD VDD pmos W=0.41u L=0.04u
M2119 g23187 n3452 VSS VSS nmos W=0.31u L=0.04u
M2120 g23187 n3452 VDD VDD pmos W=0.41u L=0.04u
M2121 g23190 n3471 VSS VSS nmos W=0.31u L=0.04u
M2122 g23190 n3471 VDD VDD pmos W=0.41u L=0.04u
M2123 g26693 n3457 VSS VSS nmos W=0.31u L=0.04u
M2124 g26693 n3457 VDD VDD pmos W=0.41u L=0.04u
M2125 g23201 n3572 VSS VSS nmos W=0.31u L=0.04u
M2126 g23201 n3572 VDD VDD pmos W=0.41u L=0.04u
M2127 g23204 n3569 VSS VSS nmos W=0.31u L=0.04u
M2128 g23204 n3569 VDD VDD pmos W=0.41u L=0.04u
M2129 g23207 n3566 VSS VSS nmos W=0.31u L=0.04u
M2130 g23207 n3566 VDD VDD pmos W=0.41u L=0.04u
M2131 g23210 n3564 VSS VSS nmos W=0.31u L=0.04u
M2132 g23210 n3564 VDD VDD pmos W=0.41u L=0.04u
M2133 g23213 n3562 VSS VSS nmos W=0.31u L=0.04u
M2134 g23213 n3562 VDD VDD pmos W=0.41u L=0.04u
M2135 g23216 n3560 VSS VSS nmos W=0.31u L=0.04u
M2136 g23216 n3560 VDD VDD pmos W=0.41u L=0.04u
M2137 g23219 n3558 VSS VSS nmos W=0.31u L=0.04u
M2138 g23219 n3558 VDD VDD pmos W=0.41u L=0.04u
M2139 g23222 n3555 VSS VSS nmos W=0.31u L=0.04u
M2140 g23222 n3555 VDD VDD pmos W=0.41u L=0.04u
M2141 g23225 n3552 VSS VSS nmos W=0.31u L=0.04u
M2142 g23225 n3552 VDD VDD pmos W=0.41u L=0.04u
M2143 g23228 n3571 VSS VSS nmos W=0.31u L=0.04u
M2144 g23228 n3571 VDD VDD pmos W=0.41u L=0.04u
M2145 g26710 n3557 VSS VSS nmos W=0.31u L=0.04u
M2146 g26710 n3557 VDD VDD pmos W=0.41u L=0.04u
M2147 g23239 n3672 VSS VSS nmos W=0.31u L=0.04u
M2148 g23239 n3672 VDD VDD pmos W=0.41u L=0.04u
M2149 g23242 n3669 VSS VSS nmos W=0.31u L=0.04u
M2150 g23242 n3669 VDD VDD pmos W=0.41u L=0.04u
M2151 g23245 n3666 VSS VSS nmos W=0.31u L=0.04u
M2152 g23245 n3666 VDD VDD pmos W=0.41u L=0.04u
M2153 g23248 n3664 VSS VSS nmos W=0.31u L=0.04u
M2154 g23248 n3664 VDD VDD pmos W=0.41u L=0.04u
M2155 g23251 n3662 VSS VSS nmos W=0.31u L=0.04u
M2156 g23251 n3662 VDD VDD pmos W=0.41u L=0.04u
M2157 g23254 n3660 VSS VSS nmos W=0.31u L=0.04u
M2158 g23254 n3660 VDD VDD pmos W=0.41u L=0.04u
M2159 g23257 n3658 VSS VSS nmos W=0.31u L=0.04u
M2160 g23257 n3658 VDD VDD pmos W=0.41u L=0.04u
M2161 g23260 n3655 VSS VSS nmos W=0.31u L=0.04u
M2162 g23260 n3655 VDD VDD pmos W=0.41u L=0.04u
M2163 g23263 n3652 VSS VSS nmos W=0.31u L=0.04u
M2164 g23263 n3652 VDD VDD pmos W=0.41u L=0.04u
M2165 g23266 n3671 VSS VSS nmos W=0.31u L=0.04u
M2166 g23266 n3671 VDD VDD pmos W=0.41u L=0.04u
M2167 g26727 n3657 VSS VSS nmos W=0.31u L=0.04u
M2168 g26727 n3657 VDD VDD pmos W=0.41u L=0.04u
M2169 g23277 n3772 VSS VSS nmos W=0.31u L=0.04u
M2170 g23277 n3772 VDD VDD pmos W=0.41u L=0.04u
M2171 g23280 n3769 VSS VSS nmos W=0.31u L=0.04u
M2172 g23280 n3769 VDD VDD pmos W=0.41u L=0.04u
M2173 g23283 n3766 VSS VSS nmos W=0.31u L=0.04u
M2174 g23283 n3766 VDD VDD pmos W=0.41u L=0.04u
M2175 g23286 n3764 VSS VSS nmos W=0.31u L=0.04u
M2176 g23286 n3764 VDD VDD pmos W=0.41u L=0.04u
M2177 g23289 n3762 VSS VSS nmos W=0.31u L=0.04u
M2178 g23289 n3762 VDD VDD pmos W=0.41u L=0.04u
M2179 g23292 n3760 VSS VSS nmos W=0.31u L=0.04u
M2180 g23292 n3760 VDD VDD pmos W=0.41u L=0.04u
M2181 g23295 n3758 VSS VSS nmos W=0.31u L=0.04u
M2182 g23295 n3758 VDD VDD pmos W=0.41u L=0.04u
M2183 g23298 n3755 VSS VSS nmos W=0.31u L=0.04u
M2184 g23298 n3755 VDD VDD pmos W=0.41u L=0.04u
M2185 g23301 n3752 VSS VSS nmos W=0.31u L=0.04u
M2186 g23301 n3752 VDD VDD pmos W=0.41u L=0.04u
M2187 g23304 n3771 VSS VSS nmos W=0.31u L=0.04u
M2188 g23304 n3771 VDD VDD pmos W=0.41u L=0.04u
M2189 g26744 n3757 VSS VSS nmos W=0.31u L=0.04u
M2190 g26744 n3757 VDD VDD pmos W=0.41u L=0.04u
M2191 g23162 n3470 VSS VSS nmos W=0.31u L=0.04u
M2192 g23162 n3470 VDD VDD pmos W=0.41u L=0.04u
M2193 g23165 n3467 VSS VSS nmos W=0.31u L=0.04u
M2194 g23165 n3467 VDD VDD pmos W=0.41u L=0.04u
M2195 g23168 n3465 VSS VSS nmos W=0.31u L=0.04u
M2196 g23168 n3465 VDD VDD pmos W=0.41u L=0.04u
M2197 g23171 n3463 VSS VSS nmos W=0.31u L=0.04u
M2198 g23171 n3463 VDD VDD pmos W=0.41u L=0.04u
M2199 g23174 n3461 VSS VSS nmos W=0.31u L=0.04u
M2200 g23174 n3461 VDD VDD pmos W=0.41u L=0.04u
M2201 g23177 n3459 VSS VSS nmos W=0.31u L=0.04u
M2202 g23177 n3459 VDD VDD pmos W=0.41u L=0.04u
M2203 g23180 n3456 VSS VSS nmos W=0.31u L=0.04u
M2204 g23180 n3456 VDD VDD pmos W=0.41u L=0.04u
M2205 g23183 n3453 VSS VSS nmos W=0.31u L=0.04u
M2206 g23183 n3453 VDD VDD pmos W=0.41u L=0.04u
M2207 g23186 n3451 VSS VSS nmos W=0.31u L=0.04u
M2208 g23186 n3451 VDD VDD pmos W=0.41u L=0.04u
M2209 g23189 n3468 VSS VSS nmos W=0.31u L=0.04u
M2210 g23189 n3468 VDD VDD pmos W=0.41u L=0.04u
M2211 g26692 n3454 VSS VSS nmos W=0.31u L=0.04u
M2212 g26692 n3454 VDD VDD pmos W=0.41u L=0.04u
M2213 g23200 n3570 VSS VSS nmos W=0.31u L=0.04u
M2214 g23200 n3570 VDD VDD pmos W=0.41u L=0.04u
M2215 g23203 n3567 VSS VSS nmos W=0.31u L=0.04u
M2216 g23203 n3567 VDD VDD pmos W=0.41u L=0.04u
M2217 g23206 n3565 VSS VSS nmos W=0.31u L=0.04u
M2218 g23206 n3565 VDD VDD pmos W=0.41u L=0.04u
M2219 g23209 n3563 VSS VSS nmos W=0.31u L=0.04u
M2220 g23209 n3563 VDD VDD pmos W=0.41u L=0.04u
M2221 g23212 n3561 VSS VSS nmos W=0.31u L=0.04u
M2222 g23212 n3561 VDD VDD pmos W=0.41u L=0.04u
M2223 g23215 n3559 VSS VSS nmos W=0.31u L=0.04u
M2224 g23215 n3559 VDD VDD pmos W=0.41u L=0.04u
M2225 g23218 n3556 VSS VSS nmos W=0.31u L=0.04u
M2226 g23218 n3556 VDD VDD pmos W=0.41u L=0.04u
M2227 g23221 n3553 VSS VSS nmos W=0.31u L=0.04u
M2228 g23221 n3553 VDD VDD pmos W=0.41u L=0.04u
M2229 g23224 n3551 VSS VSS nmos W=0.31u L=0.04u
M2230 g23224 n3551 VDD VDD pmos W=0.41u L=0.04u
M2231 g23227 n3568 VSS VSS nmos W=0.31u L=0.04u
M2232 g23227 n3568 VDD VDD pmos W=0.41u L=0.04u
M2233 g26709 n3554 VSS VSS nmos W=0.31u L=0.04u
M2234 g26709 n3554 VDD VDD pmos W=0.41u L=0.04u
M2235 g23238 n3670 VSS VSS nmos W=0.31u L=0.04u
M2236 g23238 n3670 VDD VDD pmos W=0.41u L=0.04u
M2237 g23241 n3667 VSS VSS nmos W=0.31u L=0.04u
M2238 g23241 n3667 VDD VDD pmos W=0.41u L=0.04u
M2239 g23244 n3665 VSS VSS nmos W=0.31u L=0.04u
M2240 g23244 n3665 VDD VDD pmos W=0.41u L=0.04u
M2241 g23247 n3663 VSS VSS nmos W=0.31u L=0.04u
M2242 g23247 n3663 VDD VDD pmos W=0.41u L=0.04u
M2243 g23250 n3661 VSS VSS nmos W=0.31u L=0.04u
M2244 g23250 n3661 VDD VDD pmos W=0.41u L=0.04u
M2245 g23253 n3659 VSS VSS nmos W=0.31u L=0.04u
M2246 g23253 n3659 VDD VDD pmos W=0.41u L=0.04u
M2247 g23256 n3656 VSS VSS nmos W=0.31u L=0.04u
M2248 g23256 n3656 VDD VDD pmos W=0.41u L=0.04u
M2249 g23259 n3653 VSS VSS nmos W=0.31u L=0.04u
M2250 g23259 n3653 VDD VDD pmos W=0.41u L=0.04u
M2251 g23262 n3651 VSS VSS nmos W=0.31u L=0.04u
M2252 g23262 n3651 VDD VDD pmos W=0.41u L=0.04u
M2253 g23265 n3668 VSS VSS nmos W=0.31u L=0.04u
M2254 g23265 n3668 VDD VDD pmos W=0.41u L=0.04u
M2255 g26726 n3654 VSS VSS nmos W=0.31u L=0.04u
M2256 g26726 n3654 VDD VDD pmos W=0.41u L=0.04u
M2257 g23276 n3770 VSS VSS nmos W=0.31u L=0.04u
M2258 g23276 n3770 VDD VDD pmos W=0.41u L=0.04u
M2259 g23279 n3767 VSS VSS nmos W=0.31u L=0.04u
M2260 g23279 n3767 VDD VDD pmos W=0.41u L=0.04u
M2261 g23282 n3765 VSS VSS nmos W=0.31u L=0.04u
M2262 g23282 n3765 VDD VDD pmos W=0.41u L=0.04u
M2263 g23285 n3763 VSS VSS nmos W=0.31u L=0.04u
M2264 g23285 n3763 VDD VDD pmos W=0.41u L=0.04u
M2265 g23288 n3761 VSS VSS nmos W=0.31u L=0.04u
M2266 g23288 n3761 VDD VDD pmos W=0.41u L=0.04u
M2267 g23291 n3759 VSS VSS nmos W=0.31u L=0.04u
M2268 g23291 n3759 VDD VDD pmos W=0.41u L=0.04u
M2269 g23294 n3756 VSS VSS nmos W=0.31u L=0.04u
M2270 g23294 n3756 VDD VDD pmos W=0.41u L=0.04u
M2271 g23297 n3753 VSS VSS nmos W=0.31u L=0.04u
M2272 g23297 n3753 VDD VDD pmos W=0.41u L=0.04u
M2273 g23300 n3751 VSS VSS nmos W=0.31u L=0.04u
M2274 g23300 n3751 VDD VDD pmos W=0.41u L=0.04u
M2275 g23303 n3768 VSS VSS nmos W=0.31u L=0.04u
M2276 g23303 n3768 VDD VDD pmos W=0.41u L=0.04u
M2277 g26743 n3754 VSS VSS nmos W=0.31u L=0.04u
M2278 g26743 n3754 VDD VDD pmos W=0.41u L=0.04u
M2279 g23164 n3483 VSS VSS nmos W=0.31u L=0.04u
M2280 g23164 n3483 VDD VDD pmos W=0.41u L=0.04u
M2281 g23167 n3481 VSS VSS nmos W=0.31u L=0.04u
M2282 g23167 n3481 VDD VDD pmos W=0.41u L=0.04u
M2283 g23170 n3480 VSS VSS nmos W=0.31u L=0.04u
M2284 g23170 n3480 VDD VDD pmos W=0.41u L=0.04u
M2285 g23173 n3479 VSS VSS nmos W=0.31u L=0.04u
M2286 g23173 n3479 VDD VDD pmos W=0.41u L=0.04u
M2287 g23176 n3478 VSS VSS nmos W=0.31u L=0.04u
M2288 g23176 n3478 VDD VDD pmos W=0.41u L=0.04u
M2289 g23179 n3477 VSS VSS nmos W=0.31u L=0.04u
M2290 g23179 n3477 VDD VDD pmos W=0.41u L=0.04u
M2291 g23182 n3476 VSS VSS nmos W=0.31u L=0.04u
M2292 g23182 n3476 VDD VDD pmos W=0.41u L=0.04u
M2293 g23185 n3474 VSS VSS nmos W=0.31u L=0.04u
M2294 g23185 n3474 VDD VDD pmos W=0.41u L=0.04u
M2295 g23188 n3473 VSS VSS nmos W=0.31u L=0.04u
M2296 g23188 n3473 VDD VDD pmos W=0.41u L=0.04u
M2297 g23191 n3482 VSS VSS nmos W=0.31u L=0.04u
M2298 g23191 n3482 VDD VDD pmos W=0.41u L=0.04u
M2299 g26694 n3475 VSS VSS nmos W=0.31u L=0.04u
M2300 g26694 n3475 VDD VDD pmos W=0.41u L=0.04u
M2301 g23202 n3583 VSS VSS nmos W=0.31u L=0.04u
M2302 g23202 n3583 VDD VDD pmos W=0.41u L=0.04u
M2303 g23205 n3581 VSS VSS nmos W=0.31u L=0.04u
M2304 g23205 n3581 VDD VDD pmos W=0.41u L=0.04u
M2305 g23208 n3580 VSS VSS nmos W=0.31u L=0.04u
M2306 g23208 n3580 VDD VDD pmos W=0.41u L=0.04u
M2307 g23211 n3579 VSS VSS nmos W=0.31u L=0.04u
M2308 g23211 n3579 VDD VDD pmos W=0.41u L=0.04u
M2309 g23214 n3578 VSS VSS nmos W=0.31u L=0.04u
M2310 g23214 n3578 VDD VDD pmos W=0.41u L=0.04u
M2311 g23217 n3577 VSS VSS nmos W=0.31u L=0.04u
M2312 g23217 n3577 VDD VDD pmos W=0.41u L=0.04u
M2313 g23220 n3576 VSS VSS nmos W=0.31u L=0.04u
M2314 g23220 n3576 VDD VDD pmos W=0.41u L=0.04u
M2315 g23223 n3574 VSS VSS nmos W=0.31u L=0.04u
M2316 g23223 n3574 VDD VDD pmos W=0.41u L=0.04u
M2317 g23226 n3573 VSS VSS nmos W=0.31u L=0.04u
M2318 g23226 n3573 VDD VDD pmos W=0.41u L=0.04u
M2319 g23229 n3582 VSS VSS nmos W=0.31u L=0.04u
M2320 g23229 n3582 VDD VDD pmos W=0.41u L=0.04u
M2321 g26711 n3575 VSS VSS nmos W=0.31u L=0.04u
M2322 g26711 n3575 VDD VDD pmos W=0.41u L=0.04u
M2323 g23240 n3683 VSS VSS nmos W=0.31u L=0.04u
M2324 g23240 n3683 VDD VDD pmos W=0.41u L=0.04u
M2325 g23243 n3681 VSS VSS nmos W=0.31u L=0.04u
M2326 g23243 n3681 VDD VDD pmos W=0.41u L=0.04u
M2327 g23246 n3680 VSS VSS nmos W=0.31u L=0.04u
M2328 g23246 n3680 VDD VDD pmos W=0.41u L=0.04u
M2329 g23249 n3679 VSS VSS nmos W=0.31u L=0.04u
M2330 g23249 n3679 VDD VDD pmos W=0.41u L=0.04u
M2331 g23252 n3678 VSS VSS nmos W=0.31u L=0.04u
M2332 g23252 n3678 VDD VDD pmos W=0.41u L=0.04u
M2333 g23255 n3677 VSS VSS nmos W=0.31u L=0.04u
M2334 g23255 n3677 VDD VDD pmos W=0.41u L=0.04u
M2335 g23258 n3676 VSS VSS nmos W=0.31u L=0.04u
M2336 g23258 n3676 VDD VDD pmos W=0.41u L=0.04u
M2337 g23261 n3674 VSS VSS nmos W=0.31u L=0.04u
M2338 g23261 n3674 VDD VDD pmos W=0.41u L=0.04u
M2339 g23264 n3673 VSS VSS nmos W=0.31u L=0.04u
M2340 g23264 n3673 VDD VDD pmos W=0.41u L=0.04u
M2341 g23267 n3682 VSS VSS nmos W=0.31u L=0.04u
M2342 g23267 n3682 VDD VDD pmos W=0.41u L=0.04u
M2343 g26728 n3675 VSS VSS nmos W=0.31u L=0.04u
M2344 g26728 n3675 VDD VDD pmos W=0.41u L=0.04u
M2345 g23278 n3783 VSS VSS nmos W=0.31u L=0.04u
M2346 g23278 n3783 VDD VDD pmos W=0.41u L=0.04u
M2347 g23281 n3781 VSS VSS nmos W=0.31u L=0.04u
M2348 g23281 n3781 VDD VDD pmos W=0.41u L=0.04u
M2349 g23284 n3780 VSS VSS nmos W=0.31u L=0.04u
M2350 g23284 n3780 VDD VDD pmos W=0.41u L=0.04u
M2351 g23287 n3779 VSS VSS nmos W=0.31u L=0.04u
M2352 g23287 n3779 VDD VDD pmos W=0.41u L=0.04u
M2353 g23290 n3778 VSS VSS nmos W=0.31u L=0.04u
M2354 g23290 n3778 VDD VDD pmos W=0.41u L=0.04u
M2355 g23293 n3777 VSS VSS nmos W=0.31u L=0.04u
M2356 g23293 n3777 VDD VDD pmos W=0.41u L=0.04u
M2357 g23296 n3776 VSS VSS nmos W=0.31u L=0.04u
M2358 g23296 n3776 VDD VDD pmos W=0.41u L=0.04u
M2359 g23299 n3774 VSS VSS nmos W=0.31u L=0.04u
M2360 g23299 n3774 VDD VDD pmos W=0.41u L=0.04u
M2361 g23302 n3773 VSS VSS nmos W=0.31u L=0.04u
M2362 g23302 n3773 VDD VDD pmos W=0.41u L=0.04u
M2363 g23305 n3782 VSS VSS nmos W=0.31u L=0.04u
M2364 g23305 n3782 VDD VDD pmos W=0.41u L=0.04u
M2365 g26745 n3775 VSS VSS nmos W=0.31u L=0.04u
M2366 g26745 n3775 VDD VDD pmos W=0.41u L=0.04u
M2367 g16495 N141 VSS VSS nmos W=0.31u L=0.04u
M2368 g16495 N141 VDD VDD pmos W=0.41u L=0.04u
M2369 g27200 n3387 VSS VSS nmos W=0.31u L=0.04u
M2370 g27200 n3387 VDD VDD pmos W=0.41u L=0.04u
M2371 g8293 II15505 VSS VSS nmos W=0.31u L=0.04u
M2372 g8293 II15505 VDD VDD pmos W=0.41u L=0.04u
M2373 g8302 II15511 VSS VSS nmos W=0.31u L=0.04u
M2374 g8302 II15511 VDD VDD pmos W=0.41u L=0.04u
M2375 g8311 II15517 VSS VSS nmos W=0.31u L=0.04u
M2376 g8311 II15517 VDD VDD pmos W=0.41u L=0.04u
M2377 g11497 II18467 VSS VSS nmos W=0.31u L=0.04u
M2378 g11497 II18467 VDD VDD pmos W=0.41u L=0.04u
M2379 g11500 II18476 VSS VSS nmos W=0.31u L=0.04u
M2380 g11500 II18476 VDD VDD pmos W=0.41u L=0.04u
M2381 g11503 II18485 VSS VSS nmos W=0.31u L=0.04u
M2382 g11503 II18485 VDD VDD pmos W=0.41u L=0.04u
M2383 g11506 II18494 VSS VSS nmos W=0.31u L=0.04u
M2384 g11506 II18494 VDD VDD pmos W=0.41u L=0.04u
M2385 g11524 II18548 VSS VSS nmos W=0.31u L=0.04u
M2386 g11524 II18548 VDD VDD pmos W=0.41u L=0.04u
M2387 g11527 II18557 VSS VSS nmos W=0.31u L=0.04u
M2388 g11527 II18557 VDD VDD pmos W=0.41u L=0.04u
M2389 g11530 II18566 VSS VSS nmos W=0.31u L=0.04u
M2390 g11530 II18566 VDD VDD pmos W=0.41u L=0.04u
M2391 g11533 II18575 VSS VSS nmos W=0.31u L=0.04u
M2392 g11533 II18575 VDD VDD pmos W=0.41u L=0.04u
M2393 g11551 II18629 VSS VSS nmos W=0.31u L=0.04u
M2394 g11551 II18629 VDD VDD pmos W=0.41u L=0.04u
M2395 g11554 II18638 VSS VSS nmos W=0.31u L=0.04u
M2396 g11554 II18638 VDD VDD pmos W=0.41u L=0.04u
M2397 g11557 II18647 VSS VSS nmos W=0.31u L=0.04u
M2398 g11557 II18647 VDD VDD pmos W=0.41u L=0.04u
M2399 g11560 II18656 VSS VSS nmos W=0.31u L=0.04u
M2400 g11560 II18656 VDD VDD pmos W=0.41u L=0.04u
M2401 g11578 II18710 VSS VSS nmos W=0.31u L=0.04u
M2402 g11578 II18710 VDD VDD pmos W=0.41u L=0.04u
M2403 g11581 II18719 VSS VSS nmos W=0.31u L=0.04u
M2404 g11581 II18719 VDD VDD pmos W=0.41u L=0.04u
M2405 g11584 II18728 VSS VSS nmos W=0.31u L=0.04u
M2406 g11584 II18728 VDD VDD pmos W=0.41u L=0.04u
M2407 g11587 II18737 VSS VSS nmos W=0.31u L=0.04u
M2408 g11587 II18737 VDD VDD pmos W=0.41u L=0.04u
M2409 g11498 II18470 VSS VSS nmos W=0.31u L=0.04u
M2410 g11498 II18470 VDD VDD pmos W=0.41u L=0.04u
M2411 g11501 II18479 VSS VSS nmos W=0.31u L=0.04u
M2412 g11501 II18479 VDD VDD pmos W=0.41u L=0.04u
M2413 g11504 II18488 VSS VSS nmos W=0.31u L=0.04u
M2414 g11504 II18488 VDD VDD pmos W=0.41u L=0.04u
M2415 g11507 II18497 VSS VSS nmos W=0.31u L=0.04u
M2416 g11507 II18497 VDD VDD pmos W=0.41u L=0.04u
M2417 g11525 II18551 VSS VSS nmos W=0.31u L=0.04u
M2418 g11525 II18551 VDD VDD pmos W=0.41u L=0.04u
M2419 g11528 II18560 VSS VSS nmos W=0.31u L=0.04u
M2420 g11528 II18560 VDD VDD pmos W=0.41u L=0.04u
M2421 g11531 II18569 VSS VSS nmos W=0.31u L=0.04u
M2422 g11531 II18569 VDD VDD pmos W=0.41u L=0.04u
M2423 g11534 II18578 VSS VSS nmos W=0.31u L=0.04u
M2424 g11534 II18578 VDD VDD pmos W=0.41u L=0.04u
M2425 g11552 II18632 VSS VSS nmos W=0.31u L=0.04u
M2426 g11552 II18632 VDD VDD pmos W=0.41u L=0.04u
M2427 g11555 II18641 VSS VSS nmos W=0.31u L=0.04u
M2428 g11555 II18641 VDD VDD pmos W=0.41u L=0.04u
M2429 g11558 II18650 VSS VSS nmos W=0.31u L=0.04u
M2430 g11558 II18650 VDD VDD pmos W=0.41u L=0.04u
M2431 g11561 II18659 VSS VSS nmos W=0.31u L=0.04u
M2432 g11561 II18659 VDD VDD pmos W=0.41u L=0.04u
M2433 g11579 II18713 VSS VSS nmos W=0.31u L=0.04u
M2434 g11579 II18713 VDD VDD pmos W=0.41u L=0.04u
M2435 g11582 II18722 VSS VSS nmos W=0.31u L=0.04u
M2436 g11582 II18722 VDD VDD pmos W=0.41u L=0.04u
M2437 g11585 II18731 VSS VSS nmos W=0.31u L=0.04u
M2438 g11585 II18731 VDD VDD pmos W=0.41u L=0.04u
M2439 g11588 II18740 VSS VSS nmos W=0.31u L=0.04u
M2440 g11588 II18740 VDD VDD pmos W=0.41u L=0.04u
M2441 g11499 II18473 VSS VSS nmos W=0.31u L=0.04u
M2442 g11499 II18473 VDD VDD pmos W=0.41u L=0.04u
M2443 g11502 II18482 VSS VSS nmos W=0.31u L=0.04u
M2444 g11502 II18482 VDD VDD pmos W=0.41u L=0.04u
M2445 g11505 II18491 VSS VSS nmos W=0.31u L=0.04u
M2446 g11505 II18491 VDD VDD pmos W=0.41u L=0.04u
M2447 g11508 II18500 VSS VSS nmos W=0.31u L=0.04u
M2448 g11508 II18500 VDD VDD pmos W=0.41u L=0.04u
M2449 g11526 II18554 VSS VSS nmos W=0.31u L=0.04u
M2450 g11526 II18554 VDD VDD pmos W=0.41u L=0.04u
M2451 g11529 II18563 VSS VSS nmos W=0.31u L=0.04u
M2452 g11529 II18563 VDD VDD pmos W=0.41u L=0.04u
M2453 g11532 II18572 VSS VSS nmos W=0.31u L=0.04u
M2454 g11532 II18572 VDD VDD pmos W=0.41u L=0.04u
M2455 g11535 II18581 VSS VSS nmos W=0.31u L=0.04u
M2456 g11535 II18581 VDD VDD pmos W=0.41u L=0.04u
M2457 g11553 II18635 VSS VSS nmos W=0.31u L=0.04u
M2458 g11553 II18635 VDD VDD pmos W=0.41u L=0.04u
M2459 g11556 II18644 VSS VSS nmos W=0.31u L=0.04u
M2460 g11556 II18644 VDD VDD pmos W=0.41u L=0.04u
M2461 g11559 II18653 VSS VSS nmos W=0.31u L=0.04u
M2462 g11559 II18653 VDD VDD pmos W=0.41u L=0.04u
M2463 g11562 II18662 VSS VSS nmos W=0.31u L=0.04u
M2464 g11562 II18662 VDD VDD pmos W=0.41u L=0.04u
M2465 g11580 II18716 VSS VSS nmos W=0.31u L=0.04u
M2466 g11580 II18716 VDD VDD pmos W=0.41u L=0.04u
M2467 g11583 II18725 VSS VSS nmos W=0.31u L=0.04u
M2468 g11583 II18725 VDD VDD pmos W=0.41u L=0.04u
M2469 g11586 II18734 VSS VSS nmos W=0.31u L=0.04u
M2470 g11586 II18734 VDD VDD pmos W=0.41u L=0.04u
M2471 g11589 II18743 VSS VSS nmos W=0.31u L=0.04u
M2472 g11589 II18743 VDD VDD pmos W=0.41u L=0.04u
M2473 g20604 N478 VSS VSS nmos W=0.31u L=0.04u
M2474 g20604 N478 VDD VDD pmos W=0.41u L=0.04u
M2475 g20594 N930 VSS VSS nmos W=0.31u L=0.04u
M2476 g20594 N930 VDD VDD pmos W=0.41u L=0.04u
M2477 g23154 n3427 VSS VSS nmos W=0.31u L=0.04u
M2478 g23154 n3427 VDD VDD pmos W=0.41u L=0.04u
M2479 g26019 n2739 VSS VSS nmos W=0.31u L=0.04u
M2480 g26019 n2739 VDD VDD pmos W=0.41u L=0.04u
M2481 g28678 n2818 VSS VSS nmos W=0.31u L=0.04u
M2482 g28678 n2818 VDD VDD pmos W=0.41u L=0.04u
M2483 g27717 n366 VSS VSS nmos W=0.31u L=0.04u
M2484 g27717 n366 VDD VDD pmos W=0.41u L=0.04u
M2485 g24296 n3495 VSS VSS nmos W=0.31u L=0.04u
M2486 g24296 n3495 VDD VDD pmos W=0.41u L=0.04u
M2487 g25991 n3493 VSS VSS nmos W=0.31u L=0.04u
M2488 g25991 n3493 VDD VDD pmos W=0.41u L=0.04u
M2489 g27197 n3491 VSS VSS nmos W=0.31u L=0.04u
M2490 g27197 n3491 VDD VDD pmos W=0.41u L=0.04u
M2491 g24337 n3595 VSS VSS nmos W=0.31u L=0.04u
M2492 g24337 n3595 VDD VDD pmos W=0.41u L=0.04u
M2493 g26000 n3593 VSS VSS nmos W=0.31u L=0.04u
M2494 g26000 n3593 VDD VDD pmos W=0.41u L=0.04u
M2495 g27218 n3591 VSS VSS nmos W=0.31u L=0.04u
M2496 g27218 n3591 VDD VDD pmos W=0.41u L=0.04u
M2497 g24378 n3695 VSS VSS nmos W=0.31u L=0.04u
M2498 g24378 n3695 VDD VDD pmos W=0.41u L=0.04u
M2499 g26009 n3693 VSS VSS nmos W=0.31u L=0.04u
M2500 g26009 n3693 VDD VDD pmos W=0.41u L=0.04u
M2501 g27227 n3691 VSS VSS nmos W=0.31u L=0.04u
M2502 g27227 n3691 VDD VDD pmos W=0.41u L=0.04u
M2503 g24419 n3795 VSS VSS nmos W=0.31u L=0.04u
M2504 g24419 n3795 VDD VDD pmos W=0.41u L=0.04u
M2505 g26018 n3793 VSS VSS nmos W=0.31u L=0.04u
M2506 g26018 n3793 VDD VDD pmos W=0.41u L=0.04u
M2507 g27236 n3791 VSS VSS nmos W=0.31u L=0.04u
M2508 g27236 n3791 VDD VDD pmos W=0.41u L=0.04u
M2509 g26678 n2824 VSS VSS nmos W=0.31u L=0.04u
M2510 g26678 n2824 VDD VDD pmos W=0.41u L=0.04u
M2511 g26712 n2804 VSS VSS nmos W=0.31u L=0.04u
M2512 g26712 n2804 VDD VDD pmos W=0.41u L=0.04u
M2513 g26729 n2794 VSS VSS nmos W=0.31u L=0.04u
M2514 g26729 n2794 VDD VDD pmos W=0.41u L=0.04u
M2515 g26021 n3802 VSS VSS nmos W=0.31u L=0.04u
M2516 g26021 n3802 VDD VDD pmos W=0.41u L=0.04u
M2517 g24424 N1282 VSS VSS nmos W=0.31u L=0.04u
M2518 g24424 N1282 VDD VDD pmos W=0.41u L=0.04u
M2519 g24425 N1285 VSS VSS nmos W=0.31u L=0.04u
M2520 g24425 N1285 VDD VDD pmos W=0.41u L=0.04u
M2521 g8284 II15499 VSS VSS nmos W=0.31u L=0.04u
M2522 g8284 II15499 VDD VDD pmos W=0.41u L=0.04u
M2523 g16467 n3422 VSS VSS nmos W=0.31u L=0.04u
M2524 g16467 n3422 VDD VDD pmos W=0.41u L=0.04u
M2525 g16468 n3423 VSS VSS nmos W=0.31u L=0.04u
M2526 g16468 n3423 VDD VDD pmos W=0.41u L=0.04u
M2527 g16469 n3542 VSS VSS nmos W=0.31u L=0.04u
M2528 g16469 n3542 VDD VDD pmos W=0.41u L=0.04u
M2529 g16470 n3543 VSS VSS nmos W=0.31u L=0.04u
M2530 g16470 n3543 VDD VDD pmos W=0.41u L=0.04u
M2531 g16471 n3642 VSS VSS nmos W=0.31u L=0.04u
M2532 g16471 n3642 VDD VDD pmos W=0.41u L=0.04u
M2533 g16472 n3643 VSS VSS nmos W=0.31u L=0.04u
M2534 g16472 n3643 VDD VDD pmos W=0.41u L=0.04u
M2535 g16473 n3742 VSS VSS nmos W=0.31u L=0.04u
M2536 g16473 n3742 VDD VDD pmos W=0.41u L=0.04u
M2537 g16474 n3743 VSS VSS nmos W=0.31u L=0.04u
M2538 g16474 n3743 VDD VDD pmos W=0.41u L=0.04u
M2539 g27190 N1762 VSS VSS nmos W=0.31u L=0.04u
M2540 g27190 N1762 VDD VDD pmos W=0.41u L=0.04u
M2541 g27220 N1766 VSS VSS nmos W=0.31u L=0.04u
M2542 g27220 N1766 VDD VDD pmos W=0.41u L=0.04u
M2543 g27229 N1768 VSS VSS nmos W=0.31u L=0.04u
M2544 g27229 N1768 VDD VDD pmos W=0.41u L=0.04u
M2545 g16497 n659 VSS VSS nmos W=0.31u L=0.04u
M2546 g16497 n659 VDD VDD pmos W=0.41u L=0.04u
M2547 g23315 N1202 VSS VSS nmos W=0.31u L=0.04u
M2548 g23315 N1202 VDD VDD pmos W=0.41u L=0.04u
M2549 g16475 n660 VSS VSS nmos W=0.31u L=0.04u
M2550 g16475 n660 VDD VDD pmos W=0.41u L=0.04u
M2551 g19062 n660 VSS VSS nmos W=0.31u L=0.04u
M2552 g19062 n660 VDD VDD pmos W=0.41u L=0.04u
M2553 g28313 g23919 VSS VSS nmos W=0.31u L=0.04u
M2554 g28313 g23919 VDD VDD pmos W=0.41u L=0.04u
M2555 g29138 n3487 VSS VSS nmos W=0.31u L=0.04u
M2556 g29138 n3487 VDD VDD pmos W=0.41u L=0.04u
M2557 g29146 n3587 VSS VSS nmos W=0.31u L=0.04u
M2558 g29146 n3587 VDD VDD pmos W=0.41u L=0.04u
M2559 g29154 n3687 VSS VSS nmos W=0.31u L=0.04u
M2560 g29154 n3687 VDD VDD pmos W=0.41u L=0.04u
M2561 g29162 n3787 VSS VSS nmos W=0.31u L=0.04u
M2562 g29162 n3787 VDD VDD pmos W=0.41u L=0.04u
M2563 g23158 n3443 VSS VSS nmos W=0.31u L=0.04u
M2564 g23158 n3443 VDD VDD pmos W=0.41u L=0.04u
M2565 g23157 n3439 VSS VSS nmos W=0.31u L=0.04u
M2566 g23157 n3439 VDD VDD pmos W=0.41u L=0.04u
M2567 g23156 n3435 VSS VSS nmos W=0.31u L=0.04u
M2568 g23156 n3435 VDD VDD pmos W=0.41u L=0.04u
M2569 g23155 n3431 VSS VSS nmos W=0.31u L=0.04u
M2570 g23155 n3431 VDD VDD pmos W=0.41u L=0.04u
M2571 g23149 n3389 VSS VSS nmos W=0.31u L=0.04u
M2572 g23149 n3389 VDD VDD pmos W=0.41u L=0.04u
M2573 g23148 n3386 VSS VSS nmos W=0.31u L=0.04u
M2574 g23148 n3386 VDD VDD pmos W=0.41u L=0.04u
M2575 g23150 n3392 VSS VSS nmos W=0.31u L=0.04u
M2576 g23150 n3392 VDD VDD pmos W=0.41u L=0.04u
M2577 g23151 n3379 VSS VSS nmos W=0.31u L=0.04u
M2578 g23151 n3379 VDD VDD pmos W=0.41u L=0.04u
M2579 g23152 n3380 VSS VSS nmos W=0.31u L=0.04u
M2580 g23152 n3380 VDD VDD pmos W=0.41u L=0.04u
M2581 g23153 n3383 VSS VSS nmos W=0.31u L=0.04u
M2582 g23153 n3383 VDD VDD pmos W=0.41u L=0.04u
M2583 g28696 g24909 VSS VSS nmos W=0.31u L=0.04u
M2584 g28696 g24909 VDD VDD pmos W=0.41u L=0.04u
M2585 g27199 N1764 VSS VSS nmos W=0.31u L=0.04u
M2586 g27199 N1764 VDD VDD pmos W=0.41u L=0.04u
M2587 g27217 n3398 VSS VSS nmos W=0.31u L=0.04u
M2588 g27217 n3398 VDD VDD pmos W=0.41u L=0.04u
M2589 g27216 n3444 VSS VSS nmos W=0.31u L=0.04u
M2590 g27216 n3444 VDD VDD pmos W=0.41u L=0.04u
M2591 g27215 n3440 VSS VSS nmos W=0.31u L=0.04u
M2592 g27215 n3440 VDD VDD pmos W=0.41u L=0.04u
M2593 g27214 n3436 VSS VSS nmos W=0.31u L=0.04u
M2594 g27214 n3436 VDD VDD pmos W=0.41u L=0.04u
M2595 g27213 n3432 VSS VSS nmos W=0.31u L=0.04u
M2596 g27213 n3432 VDD VDD pmos W=0.41u L=0.04u
M2597 g27212 n3428 VSS VSS nmos W=0.31u L=0.04u
M2598 g27212 n3428 VDD VDD pmos W=0.41u L=0.04u
M2599 g29445 n3397 VSS VSS nmos W=0.31u L=0.04u
M2600 g29445 n3397 VDD VDD pmos W=0.41u L=0.04u
M2601 g30325 n3396 VSS VSS nmos W=0.31u L=0.04u
M2602 g30325 n3396 VDD VDD pmos W=0.41u L=0.04u
M2603 g29463 n329 VSS VSS nmos W=0.31u L=0.04u
M2604 g29463 n329 VDD VDD pmos W=0.41u L=0.04u
M2605 g29461 n329 VSS VSS nmos W=0.31u L=0.04u
M2606 g29461 n329 VDD VDD pmos W=0.41u L=0.04u
M2607 g29462 n329 VSS VSS nmos W=0.31u L=0.04u
M2608 g29462 n329 VDD VDD pmos W=0.41u L=0.04u
M2609 g29166 g26135 VSS VSS nmos W=0.31u L=0.04u
M2610 g29166 g26135 VDD VDD pmos W=0.41u L=0.04u
M2611 g27201 n3390 VSS VSS nmos W=0.31u L=0.04u
M2612 g27201 n3390 VDD VDD pmos W=0.41u L=0.04u
M2613 g27202 n3394 VSS VSS nmos W=0.31u L=0.04u
M2614 g27202 n3394 VDD VDD pmos W=0.41u L=0.04u
M2615 g27203 n3378 VSS VSS nmos W=0.31u L=0.04u
M2616 g27203 n3378 VDD VDD pmos W=0.41u L=0.04u
M2617 g27204 n3381 VSS VSS nmos W=0.31u L=0.04u
M2618 g27204 n3381 VDD VDD pmos W=0.41u L=0.04u
M2619 g27205 n3384 VSS VSS nmos W=0.31u L=0.04u
M2620 g27205 n3384 VDD VDD pmos W=0.41u L=0.04u
M2621 g24295 n3410 VSS VSS nmos W=0.31u L=0.04u
M2622 g24295 n3410 VDD VDD pmos W=0.41u L=0.04u
M2623 g24336 n3530 VSS VSS nmos W=0.31u L=0.04u
M2624 g24336 n3530 VDD VDD pmos W=0.41u L=0.04u
M2625 g24377 n3630 VSS VSS nmos W=0.31u L=0.04u
M2626 g24377 n3630 VDD VDD pmos W=0.41u L=0.04u
M2627 g29444 n3445 VSS VSS nmos W=0.31u L=0.04u
M2628 g29444 n3445 VDD VDD pmos W=0.41u L=0.04u
M2629 g29443 n3441 VSS VSS nmos W=0.31u L=0.04u
M2630 g29443 n3441 VDD VDD pmos W=0.41u L=0.04u
M2631 g29442 n3437 VSS VSS nmos W=0.31u L=0.04u
M2632 g29442 n3437 VDD VDD pmos W=0.41u L=0.04u
M2633 g29441 n3433 VSS VSS nmos W=0.31u L=0.04u
M2634 g29441 n3433 VDD VDD pmos W=0.41u L=0.04u
M2635 g29440 n3429 VSS VSS nmos W=0.31u L=0.04u
M2636 g29440 n3429 VDD VDD pmos W=0.41u L=0.04u
M2637 g24418 n3730 VSS VSS nmos W=0.31u L=0.04u
M2638 g24418 n3730 VDD VDD pmos W=0.41u L=0.04u
M2639 g29429 n408 VSS VSS nmos W=0.31u L=0.04u
M2640 g29429 n408 VDD VDD pmos W=0.41u L=0.04u
M2641 g29430 n407 VSS VSS nmos W=0.31u L=0.04u
M2642 g29430 n407 VDD VDD pmos W=0.41u L=0.04u
M2643 g29431 n412 VSS VSS nmos W=0.31u L=0.04u
M2644 g29431 n412 VDD VDD pmos W=0.41u L=0.04u
M2645 g29432 n411 VSS VSS nmos W=0.31u L=0.04u
M2646 g29432 n411 VDD VDD pmos W=0.41u L=0.04u
M2647 g29433 n410 VSS VSS nmos W=0.31u L=0.04u
M2648 g29433 n410 VDD VDD pmos W=0.41u L=0.04u
M2649 g29428 n409 VSS VSS nmos W=0.31u L=0.04u
M2650 g29428 n409 VDD VDD pmos W=0.41u L=0.04u
M2651 g19013 g12079 VSS VSS nmos W=0.31u L=0.04u
M2652 g19013 g12079 VDD VDD pmos W=0.41u L=0.04u
M2653 g19025 g12151 VSS VSS nmos W=0.31u L=0.04u
M2654 g19025 g12151 VDD VDD pmos W=0.41u L=0.04u
M2655 g19037 g12213 VSS VSS nmos W=0.31u L=0.04u
M2656 g19037 g12213 VDD VDD pmos W=0.41u L=0.04u
M2657 g19049 g12268 VSS VSS nmos W=0.31u L=0.04u
M2658 g19049 g12268 VDD VDD pmos W=0.41u L=0.04u
M2659 g19016 g11934 VSS VSS nmos W=0.31u L=0.04u
M2660 g19016 g11934 VDD VDD pmos W=0.41u L=0.04u
M2661 g19014 g12026 VSS VSS nmos W=0.31u L=0.04u
M2662 g19014 g12026 VDD VDD pmos W=0.41u L=0.04u
M2663 g19028 g11987 VSS VSS nmos W=0.31u L=0.04u
M2664 g19028 g11987 VDD VDD pmos W=0.41u L=0.04u
M2665 g19026 g12090 VSS VSS nmos W=0.31u L=0.04u
M2666 g19026 g12090 VDD VDD pmos W=0.41u L=0.04u
M2667 g19040 g12056 VSS VSS nmos W=0.31u L=0.04u
M2668 g19040 g12056 VDD VDD pmos W=0.41u L=0.04u
M2669 g19038 g12162 VSS VSS nmos W=0.31u L=0.04u
M2670 g19038 g12162 VDD VDD pmos W=0.41u L=0.04u
M2671 g19052 g12120 VSS VSS nmos W=0.31u L=0.04u
M2672 g19052 g12120 VDD VDD pmos W=0.41u L=0.04u
M2673 g19050 g12224 VSS VSS nmos W=0.31u L=0.04u
M2674 g19050 g12224 VDD VDD pmos W=0.41u L=0.04u
M2675 g28316 n3307 VSS VSS nmos W=0.31u L=0.04u
M2676 g28316 n3307 VDD VDD pmos W=0.41u L=0.04u
M2677 g28318 n3306 VSS VSS nmos W=0.31u L=0.04u
M2678 g28318 n3306 VDD VDD pmos W=0.41u L=0.04u
M2679 g28315 n3306 VSS VSS nmos W=0.31u L=0.04u
M2680 g28315 n3306 VDD VDD pmos W=0.41u L=0.04u
M2681 g28314 n3307 VSS VSS nmos W=0.31u L=0.04u
M2682 g28314 n3307 VDD VDD pmos W=0.41u L=0.04u
M2683 g28312 n3306 VSS VSS nmos W=0.31u L=0.04u
M2684 g28312 n3306 VDD VDD pmos W=0.41u L=0.04u
M2685 g28310 n3307 VSS VSS nmos W=0.31u L=0.04u
M2686 g28310 n3307 VDD VDD pmos W=0.41u L=0.04u
M2687 g19015 g11974 VSS VSS nmos W=0.31u L=0.04u
M2688 g19015 g11974 VDD VDD pmos W=0.41u L=0.04u
M2689 g19027 g12043 VSS VSS nmos W=0.31u L=0.04u
M2690 g19027 g12043 VDD VDD pmos W=0.41u L=0.04u
M2691 g19039 g12107 VSS VSS nmos W=0.31u L=0.04u
M2692 g19039 g12107 VDD VDD pmos W=0.41u L=0.04u
M2693 g19051 g12179 VSS VSS nmos W=0.31u L=0.04u
M2694 g19051 g12179 VDD VDD pmos W=0.41u L=0.04u
M2695 g13475 II20523 VSS VSS nmos W=0.31u L=0.04u
M2696 g13475 II20523 VDD VDD pmos W=0.41u L=0.04u
M2697 g13408 II20523 VSS VSS nmos W=0.31u L=0.04u
M2698 g13408 II20523 VDD VDD pmos W=0.41u L=0.04u
M2699 g13419 II20523 VSS VSS nmos W=0.31u L=0.04u
M2700 g13419 II20523 VDD VDD pmos W=0.41u L=0.04u
M2701 g13420 II20523 VSS VSS nmos W=0.31u L=0.04u
M2702 g13420 II20523 VDD VDD pmos W=0.41u L=0.04u
M2703 g13424 II20523 VSS VSS nmos W=0.31u L=0.04u
M2704 g13424 II20523 VDD VDD pmos W=0.41u L=0.04u
M2705 g13435 II20523 VSS VSS nmos W=0.31u L=0.04u
M2706 g13435 II20523 VDD VDD pmos W=0.41u L=0.04u
M2707 g13436 II20523 VSS VSS nmos W=0.31u L=0.04u
M2708 g13436 II20523 VDD VDD pmos W=0.41u L=0.04u
M2709 g13440 II20523 VSS VSS nmos W=0.31u L=0.04u
M2710 g13440 II20523 VDD VDD pmos W=0.41u L=0.04u
M2711 g13451 II20523 VSS VSS nmos W=0.31u L=0.04u
M2712 g13451 II20523 VDD VDD pmos W=0.41u L=0.04u
M2713 g13452 II20523 VSS VSS nmos W=0.31u L=0.04u
M2714 g13452 II20523 VDD VDD pmos W=0.41u L=0.04u
M2715 g13456 II20523 VSS VSS nmos W=0.31u L=0.04u
M2716 g13456 II20523 VDD VDD pmos W=0.41u L=0.04u
M2717 g13467 II20523 VSS VSS nmos W=0.31u L=0.04u
M2718 g13467 II20523 VDD VDD pmos W=0.41u L=0.04u
M2719 g13468 II20523 VSS VSS nmos W=0.31u L=0.04u
M2720 g13468 II20523 VDD VDD pmos W=0.41u L=0.04u
M2721 g13405 II20514 VSS VSS nmos W=0.31u L=0.04u
M2722 g13405 II20514 VDD VDD pmos W=0.41u L=0.04u
M2723 g13406 II20514 VSS VSS nmos W=0.31u L=0.04u
M2724 g13406 II20514 VDD VDD pmos W=0.41u L=0.04u
M2725 g13409 II20514 VSS VSS nmos W=0.31u L=0.04u
M2726 g13409 II20514 VDD VDD pmos W=0.41u L=0.04u
M2727 g13421 II20514 VSS VSS nmos W=0.31u L=0.04u
M2728 g13421 II20514 VDD VDD pmos W=0.41u L=0.04u
M2729 g13422 II20514 VSS VSS nmos W=0.31u L=0.04u
M2730 g13422 II20514 VDD VDD pmos W=0.41u L=0.04u
M2731 g13425 II20514 VSS VSS nmos W=0.31u L=0.04u
M2732 g13425 II20514 VDD VDD pmos W=0.41u L=0.04u
M2733 g13437 II20514 VSS VSS nmos W=0.31u L=0.04u
M2734 g13437 II20514 VDD VDD pmos W=0.41u L=0.04u
M2735 g13438 II20514 VSS VSS nmos W=0.31u L=0.04u
M2736 g13438 II20514 VDD VDD pmos W=0.41u L=0.04u
M2737 g13441 II20514 VSS VSS nmos W=0.31u L=0.04u
M2738 g13441 II20514 VDD VDD pmos W=0.41u L=0.04u
M2739 g13453 II20514 VSS VSS nmos W=0.31u L=0.04u
M2740 g13453 II20514 VDD VDD pmos W=0.41u L=0.04u
M2741 g13454 II20514 VSS VSS nmos W=0.31u L=0.04u
M2742 g13454 II20514 VDD VDD pmos W=0.41u L=0.04u
M2743 g13457 II20514 VSS VSS nmos W=0.31u L=0.04u
M2744 g13457 II20514 VDD VDD pmos W=0.41u L=0.04u
M2745 g19012 g11860 VSS VSS nmos W=0.31u L=0.04u
M2746 g19012 g11860 VDD VDD pmos W=0.41u L=0.04u
M2747 g19024 g11902 VSS VSS nmos W=0.31u L=0.04u
M2748 g19024 g11902 VDD VDD pmos W=0.41u L=0.04u
M2749 g19036 g11952 VSS VSS nmos W=0.31u L=0.04u
M2750 g19036 g11952 VDD VDD pmos W=0.41u L=0.04u
M2751 g19048 g12005 VSS VSS nmos W=0.31u L=0.04u
M2752 g19048 g12005 VDD VDD pmos W=0.41u L=0.04u
M2753 g20555 n2792 VSS VSS nmos W=0.155u L=0.04u
M2754 g20555 n2792 VDD VDD pmos W=0.205u L=0.04u
M2755 g20559 n2792 VSS VSS nmos W=0.31u L=0.04u
M2756 g20559 n2792 VDD VDD pmos W=0.41u L=0.04u
M2757 g20563 n2792 VSS VSS nmos W=0.31u L=0.04u
M2758 g20563 n2792 VDD VDD pmos W=0.41u L=0.04u
M2759 g20567 n2792 VSS VSS nmos W=0.31u L=0.04u
M2760 g20567 n2792 VDD VDD pmos W=0.41u L=0.04u
M2761 g23159 n3399 VSS VSS nmos W=0.31u L=0.04u
M2762 g23159 n3399 VDD VDD pmos W=0.41u L=0.04u
M2763 g28317 n370 VSS VSS nmos W=0.31u L=0.04u
M2764 g28317 n370 VDD VDD pmos W=0.41u L=0.04u
M2765 g28311 n370 VSS VSS nmos W=0.31u L=0.04u
M2766 g28311 n370 VDD VDD pmos W=0.41u L=0.04u
M2767 g29656 g26974 VSS VSS nmos W=0.31u L=0.04u
M2768 g29656 g26974 VDD VDD pmos W=0.41u L=0.04u
M2769 g29657 g26974 VSS VSS nmos W=0.31u L=0.04u
M2770 g29657 g26974 VDD VDD pmos W=0.41u L=0.04u
M2771 g19017 n421 VSS VSS nmos W=0.31u L=0.04u
M2772 g19017 n421 VDD VDD pmos W=0.41u L=0.04u
M2773 g19029 n496 VSS VSS nmos W=0.31u L=0.04u
M2774 g19029 n496 VDD VDD pmos W=0.41u L=0.04u
M2775 g19041 n555 VSS VSS nmos W=0.31u L=0.04u
M2776 g19041 n555 VDD VDD pmos W=0.41u L=0.04u
M2777 g19054 n613 VSS VSS nmos W=0.31u L=0.04u
M2778 g19054 n613 VDD VDD pmos W=0.41u L=0.04u
M2779 g19053 n614 VSS VSS nmos W=0.31u L=0.04u
M2780 g19053 n614 VDD VDD pmos W=0.41u L=0.04u
M2781 g19018 n420 VSS VSS nmos W=0.31u L=0.04u
M2782 g19018 n420 VDD VDD pmos W=0.41u L=0.04u
M2783 g19030 n495 VSS VSS nmos W=0.31u L=0.04u
M2784 g19030 n495 VDD VDD pmos W=0.41u L=0.04u
M2785 g19042 n554 VSS VSS nmos W=0.31u L=0.04u
M2786 g19042 n554 VDD VDD pmos W=0.41u L=0.04u
M2787 g19055 n612 VSS VSS nmos W=0.31u L=0.04u
M2788 g19055 n612 VDD VDD pmos W=0.41u L=0.04u
M2789 g19019 n419 VSS VSS nmos W=0.31u L=0.04u
M2790 g19019 n419 VDD VDD pmos W=0.41u L=0.04u
M2791 g19031 n494 VSS VSS nmos W=0.31u L=0.04u
M2792 g19031 n494 VDD VDD pmos W=0.41u L=0.04u
M2793 g19043 n553 VSS VSS nmos W=0.31u L=0.04u
M2794 g19043 n553 VDD VDD pmos W=0.41u L=0.04u
M2795 g28704 n365 VSS VSS nmos W=0.31u L=0.04u
M2796 g28704 n365 VDD VDD pmos W=0.41u L=0.04u
M2797 g28697 n365 VSS VSS nmos W=0.31u L=0.04u
M2798 g28697 n365 VDD VDD pmos W=0.41u L=0.04u
M2799 g28693 n365 VSS VSS nmos W=0.31u L=0.04u
M2800 g28693 n365 VDD VDD pmos W=0.41u L=0.04u
M2801 g28699 n365 VSS VSS nmos W=0.31u L=0.04u
M2802 g28699 n365 VDD VDD pmos W=0.41u L=0.04u
M2803 g28705 n3305 VSS VSS nmos W=0.31u L=0.04u
M2804 g28705 n3305 VDD VDD pmos W=0.41u L=0.04u
M2805 g28694 n3305 VSS VSS nmos W=0.31u L=0.04u
M2806 g28694 n3305 VDD VDD pmos W=0.41u L=0.04u
M2807 g28700 n3305 VSS VSS nmos W=0.31u L=0.04u
M2808 g28700 n3305 VDD VDD pmos W=0.41u L=0.04u
M2809 g28702 n3305 VSS VSS nmos W=0.31u L=0.04u
M2810 g28702 n3305 VDD VDD pmos W=0.41u L=0.04u
M2811 g25130 n2872 VSS VSS nmos W=0.31u L=0.04u
M2812 g25130 n2872 VDD VDD pmos W=0.41u L=0.04u
M2813 g25141 n2859 VSS VSS nmos W=0.31u L=0.04u
M2814 g25141 n2859 VDD VDD pmos W=0.41u L=0.04u
M2815 g25152 n2846 VSS VSS nmos W=0.31u L=0.04u
M2816 g25152 n2846 VDD VDD pmos W=0.41u L=0.04u
M2817 g25163 n2833 VSS VSS nmos W=0.31u L=0.04u
M2818 g25163 n2833 VDD VDD pmos W=0.41u L=0.04u
M2819 g19056 n611 VSS VSS nmos W=0.31u L=0.04u
M2820 g19056 n611 VDD VDD pmos W=0.41u L=0.04u
M2821 g19020 n418 VSS VSS nmos W=0.31u L=0.04u
M2822 g19020 n418 VDD VDD pmos W=0.41u L=0.04u
M2823 g19032 n493 VSS VSS nmos W=0.31u L=0.04u
M2824 g19032 n493 VDD VDD pmos W=0.41u L=0.04u
M2825 g19044 n552 VSS VSS nmos W=0.31u L=0.04u
M2826 g19044 n552 VDD VDD pmos W=0.41u L=0.04u
M2827 g28706 n328 VSS VSS nmos W=0.31u L=0.04u
M2828 g28706 n328 VDD VDD pmos W=0.41u L=0.04u
M2829 g28698 n328 VSS VSS nmos W=0.31u L=0.04u
M2830 g28698 n328 VDD VDD pmos W=0.41u L=0.04u
M2831 g28695 n328 VSS VSS nmos W=0.31u L=0.04u
M2832 g28695 n328 VDD VDD pmos W=0.41u L=0.04u
M2833 g28701 n328 VSS VSS nmos W=0.31u L=0.04u
M2834 g28701 n328 VDD VDD pmos W=0.41u L=0.04u
M2835 g28703 n328 VSS VSS nmos W=0.31u L=0.04u
M2836 g28703 n328 VDD VDD pmos W=0.41u L=0.04u
M2837 n3937 g3229 VSS VSS nmos W=0.27u L=0.04u
M2838 n3937 g3229 VDD VDD pmos W=0.41u L=0.04u
M2839 n658 g3232 VSS VSS nmos W=0.135u L=0.04u
M2840 n658 g3232 VDD VDD pmos W=0.205u L=0.04u
M2841 n654 g3228 VSS VSS nmos W=0.135u L=0.04u
M2842 n654 g3228 VDD VDD pmos W=0.205u L=0.04u
M2843 n653 g3227 VSS VSS nmos W=0.135u L=0.04u
M2844 n653 g3227 VDD VDD pmos W=0.205u L=0.04u
M2845 n652 g3226 VSS VSS nmos W=0.135u L=0.04u
M2846 n652 g3226 VDD VDD pmos W=0.205u L=0.04u
M2847 n651 g3225 VSS VSS nmos W=0.135u L=0.04u
M2848 n651 g3225 VDD VDD pmos W=0.205u L=0.04u
M2849 n650 g3224 VSS VSS nmos W=0.135u L=0.04u
M2850 n650 g3224 VDD VDD pmos W=0.205u L=0.04u
M2851 n649 g3223 VSS VSS nmos W=0.135u L=0.04u
M2852 n649 g3223 VDD VDD pmos W=0.205u L=0.04u
M2853 n648 g3222 VSS VSS nmos W=0.135u L=0.04u
M2854 n648 g3222 VDD VDD pmos W=0.205u L=0.04u
M2855 n647 g3221 VSS VSS nmos W=0.135u L=0.04u
M2856 n647 g3221 VDD VDD pmos W=0.205u L=0.04u
M2857 n646 g3220 VSS VSS nmos W=0.135u L=0.04u
M2858 n646 g3220 VDD VDD pmos W=0.205u L=0.04u
M2859 n645 g3219 VSS VSS nmos W=0.135u L=0.04u
M2860 n645 g3219 VDD VDD pmos W=0.205u L=0.04u
M2861 n644 g3218 VSS VSS nmos W=0.135u L=0.04u
M2862 n644 g3218 VDD VDD pmos W=0.205u L=0.04u
M2863 n643 g3217 VSS VSS nmos W=0.135u L=0.04u
M2864 n643 g3217 VDD VDD pmos W=0.205u L=0.04u
M2865 n642 g3216 VSS VSS nmos W=0.135u L=0.04u
M2866 n642 g3216 VDD VDD pmos W=0.205u L=0.04u
M2867 n641 g3215 VSS VSS nmos W=0.135u L=0.04u
M2868 n641 g3215 VDD VDD pmos W=0.205u L=0.04u
M2869 n640 g3214 VSS VSS nmos W=0.135u L=0.04u
M2870 n640 g3214 VDD VDD pmos W=0.205u L=0.04u
M2871 n639 g3213 VSS VSS nmos W=0.135u L=0.04u
M2872 n639 g3213 VDD VDD pmos W=0.205u L=0.04u
M2873 n638 g3212 VSS VSS nmos W=0.135u L=0.04u
M2874 n638 g3212 VDD VDD pmos W=0.205u L=0.04u
M2875 U3710/net4 g2990 U3710/net14 VSS nmos W=0.155u L=0.04u
M2876 U3710/net6 U3710/net10 U3710/net14 VSS nmos W=0.17u L=0.04u
M2877 U3710/net4 n3830 VSS VSS nmos W=0.155u L=0.04u
M2878 U3710/net6 U3710/net4 VSS VSS nmos W=0.17u L=0.04u
M2879 n3829 U3710/net14 VSS VSS nmos W=0.155u L=0.04u
M2880 U3710/net10 g2990 VSS VSS nmos W=0.155u L=0.04u
M2881 U3710/net4 U3710/net10 U3710/net14 VDD pmos W=0.255u L=0.04u
M2882 U3710/net6 g2990 U3710/net14 VDD pmos W=0.28u L=0.04u
M2883 U3710/net4 n3830 VDD VDD pmos W=0.205u L=0.04u
M2884 U3710/net6 U3710/net4 VDD VDD pmos W=0.24u L=0.04u
M2885 n3829 U3710/net14 VDD VDD pmos W=0.205u L=0.04u
M2886 U3710/net10 g2990 VDD VDD pmos W=0.205u L=0.04u
M2887 U3711/net4 g3083 U3711/net14 VSS nmos W=0.155u L=0.04u
M2888 U3711/net6 U3711/net10 U3711/net14 VSS nmos W=0.17u L=0.04u
M2889 U3711/net4 n3831 VSS VSS nmos W=0.155u L=0.04u
M2890 U3711/net6 U3711/net4 VSS VSS nmos W=0.17u L=0.04u
M2891 n3828 U3711/net14 VSS VSS nmos W=0.155u L=0.04u
M2892 U3711/net10 g3083 VSS VSS nmos W=0.155u L=0.04u
M2893 U3711/net4 U3711/net10 U3711/net14 VDD pmos W=0.255u L=0.04u
M2894 U3711/net6 g3083 U3711/net14 VDD pmos W=0.28u L=0.04u
M2895 U3711/net4 n3831 VDD VDD pmos W=0.205u L=0.04u
M2896 U3711/net6 U3711/net4 VDD VDD pmos W=0.24u L=0.04u
M2897 n3828 U3711/net14 VDD VDD pmos W=0.205u L=0.04u
M2898 U3711/net10 g3083 VDD VDD pmos W=0.205u L=0.04u
M2899 U3712/net19 g2987 VSS VSS nmos W=0.155u L=0.04u
M2900 n3827 g2987 U3712/net40 VSS nmos W=0.155u L=0.04u
M2901 n3827 U3712/net19 U3712/net36 VSS nmos W=0.155u L=0.04u
M2902 U3712/net40 g2997 VSS VSS nmos W=0.31u L=0.04u
M2903 U3712/net36 g3061 VSS VSS nmos W=0.155u L=0.04u
M2904 U3712/net19 g2987 VDD VDD pmos W=0.205u L=0.04u
M2905 n3827 U3712/net19 U3712/net26 VDD pmos W=0.325u L=0.04u
M2906 U3712/net26 g2997 VDD VDD pmos W=0.41u L=0.04u
M2907 n3827 g2987 U3712/net30 VDD pmos W=0.325u L=0.04u
M2908 U3712/net30 g3061 VDD VDD pmos W=0.205u L=0.04u
M2909 U3713/net19 g2987 VSS VSS nmos W=0.155u L=0.04u
M2910 n3826 g2987 U3713/net40 VSS nmos W=0.155u L=0.04u
M2911 n3826 U3713/net19 U3713/net36 VSS nmos W=0.155u L=0.04u
M2912 U3713/net40 g3078 VSS VSS nmos W=0.31u L=0.04u
M2913 U3713/net36 g3060 VSS VSS nmos W=0.155u L=0.04u
M2914 U3713/net19 g2987 VDD VDD pmos W=0.205u L=0.04u
M2915 n3826 U3713/net19 U3713/net26 VDD pmos W=0.325u L=0.04u
M2916 U3713/net26 g3078 VDD VDD pmos W=0.41u L=0.04u
M2917 n3826 g2987 U3713/net30 VDD pmos W=0.325u L=0.04u
M2918 U3713/net30 g3060 VDD VDD pmos W=0.205u L=0.04u
M2919 U3714/net19 g2987 VSS VSS nmos W=0.155u L=0.04u
M2920 n3825 g2987 U3714/net40 VSS nmos W=0.155u L=0.04u
M2921 n3825 U3714/net19 U3714/net36 VSS nmos W=0.155u L=0.04u
M2922 U3714/net40 g3077 VSS VSS nmos W=0.31u L=0.04u
M2923 U3714/net36 g3059 VSS VSS nmos W=0.155u L=0.04u
M2924 U3714/net19 g2987 VDD VDD pmos W=0.205u L=0.04u
M2925 n3825 U3714/net19 U3714/net26 VDD pmos W=0.325u L=0.04u
M2926 U3714/net26 g3077 VDD VDD pmos W=0.41u L=0.04u
M2927 n3825 g2987 U3714/net30 VDD pmos W=0.325u L=0.04u
M2928 U3714/net30 g3059 VDD VDD pmos W=0.205u L=0.04u
M2929 U3715/net19 g2987 VSS VSS nmos W=0.155u L=0.04u
M2930 n3824 g2987 U3715/net40 VSS nmos W=0.155u L=0.04u
M2931 n3824 U3715/net19 U3715/net36 VSS nmos W=0.155u L=0.04u
M2932 U3715/net40 g3076 VSS VSS nmos W=0.31u L=0.04u
M2933 U3715/net36 g3058 VSS VSS nmos W=0.155u L=0.04u
M2934 U3715/net19 g2987 VDD VDD pmos W=0.205u L=0.04u
M2935 n3824 U3715/net19 U3715/net26 VDD pmos W=0.325u L=0.04u
M2936 U3715/net26 g3076 VDD VDD pmos W=0.41u L=0.04u
M2937 n3824 g2987 U3715/net30 VDD pmos W=0.325u L=0.04u
M2938 U3715/net30 g3058 VDD VDD pmos W=0.205u L=0.04u
M2939 U3716/net19 g2987 VSS VSS nmos W=0.155u L=0.04u
M2940 n3823 g2987 U3716/net40 VSS nmos W=0.155u L=0.04u
M2941 n3823 U3716/net19 U3716/net36 VSS nmos W=0.155u L=0.04u
M2942 U3716/net40 g3075 VSS VSS nmos W=0.31u L=0.04u
M2943 U3716/net36 g3057 VSS VSS nmos W=0.155u L=0.04u
M2944 U3716/net19 g2987 VDD VDD pmos W=0.205u L=0.04u
M2945 n3823 U3716/net19 U3716/net26 VDD pmos W=0.325u L=0.04u
M2946 U3716/net26 g3075 VDD VDD pmos W=0.41u L=0.04u
M2947 n3823 g2987 U3716/net30 VDD pmos W=0.325u L=0.04u
M2948 U3716/net30 g3057 VDD VDD pmos W=0.205u L=0.04u
M2949 U3717/net19 g2987 VSS VSS nmos W=0.155u L=0.04u
M2950 n3822 g2987 U3717/net40 VSS nmos W=0.155u L=0.04u
M2951 n3822 U3717/net19 U3717/net36 VSS nmos W=0.155u L=0.04u
M2952 U3717/net40 g3074 VSS VSS nmos W=0.31u L=0.04u
M2953 U3717/net36 g3056 VSS VSS nmos W=0.155u L=0.04u
M2954 U3717/net19 g2987 VDD VDD pmos W=0.205u L=0.04u
M2955 n3822 U3717/net19 U3717/net26 VDD pmos W=0.325u L=0.04u
M2956 U3717/net26 g3074 VDD VDD pmos W=0.41u L=0.04u
M2957 n3822 g2987 U3717/net30 VDD pmos W=0.325u L=0.04u
M2958 U3717/net30 g3056 VDD VDD pmos W=0.205u L=0.04u
M2959 U3718/net19 g2987 VSS VSS nmos W=0.155u L=0.04u
M2960 n3821 g2987 U3718/net40 VSS nmos W=0.155u L=0.04u
M2961 n3821 U3718/net19 U3718/net36 VSS nmos W=0.155u L=0.04u
M2962 U3718/net40 g3073 VSS VSS nmos W=0.31u L=0.04u
M2963 U3718/net36 g3055 VSS VSS nmos W=0.155u L=0.04u
M2964 U3718/net19 g2987 VDD VDD pmos W=0.205u L=0.04u
M2965 n3821 U3718/net19 U3718/net26 VDD pmos W=0.325u L=0.04u
M2966 U3718/net26 g3073 VDD VDD pmos W=0.41u L=0.04u
M2967 n3821 g2987 U3718/net30 VDD pmos W=0.325u L=0.04u
M2968 U3718/net30 g3055 VDD VDD pmos W=0.205u L=0.04u
M2969 U3719/net19 g2987 VSS VSS nmos W=0.155u L=0.04u
M2970 n3820 g2987 U3719/net40 VSS nmos W=0.155u L=0.04u
M2971 n3820 U3719/net19 U3719/net36 VSS nmos W=0.155u L=0.04u
M2972 U3719/net40 g3072 VSS VSS nmos W=0.31u L=0.04u
M2973 U3719/net36 g3053 VSS VSS nmos W=0.155u L=0.04u
M2974 U3719/net19 g2987 VDD VDD pmos W=0.205u L=0.04u
M2975 n3820 U3719/net19 U3719/net26 VDD pmos W=0.325u L=0.04u
M2976 U3719/net26 g3072 VDD VDD pmos W=0.41u L=0.04u
M2977 n3820 g2987 U3719/net30 VDD pmos W=0.325u L=0.04u
M2978 U3719/net30 g3053 VDD VDD pmos W=0.205u L=0.04u
M2979 U3720/net19 g2987 VSS VSS nmos W=0.155u L=0.04u
M2980 n3819 g2987 U3720/net40 VSS nmos W=0.155u L=0.04u
M2981 n3819 U3720/net19 U3720/net36 VSS nmos W=0.155u L=0.04u
M2982 U3720/net40 g3071 VSS VSS nmos W=0.31u L=0.04u
M2983 U3720/net36 g3052 VSS VSS nmos W=0.155u L=0.04u
M2984 U3720/net19 g2987 VDD VDD pmos W=0.205u L=0.04u
M2985 n3819 U3720/net19 U3720/net26 VDD pmos W=0.325u L=0.04u
M2986 U3720/net26 g3071 VDD VDD pmos W=0.41u L=0.04u
M2987 n3819 g2987 U3720/net30 VDD pmos W=0.325u L=0.04u
M2988 U3720/net30 g3052 VDD VDD pmos W=0.205u L=0.04u
M2989 U3721/net19 g2987 VSS VSS nmos W=0.155u L=0.04u
M2990 n3818 g2987 U3721/net40 VSS nmos W=0.155u L=0.04u
M2991 n3818 U3721/net19 U3721/net36 VSS nmos W=0.155u L=0.04u
M2992 U3721/net40 g3070 VSS VSS nmos W=0.31u L=0.04u
M2993 U3721/net36 g3051 VSS VSS nmos W=0.155u L=0.04u
M2994 U3721/net19 g2987 VDD VDD pmos W=0.205u L=0.04u
M2995 n3818 U3721/net19 U3721/net26 VDD pmos W=0.325u L=0.04u
M2996 U3721/net26 g3070 VDD VDD pmos W=0.41u L=0.04u
M2997 n3818 g2987 U3721/net30 VDD pmos W=0.325u L=0.04u
M2998 U3721/net30 g3051 VDD VDD pmos W=0.205u L=0.04u
M2999 U3722/net19 g2987 VSS VSS nmos W=0.155u L=0.04u
M3000 n3817 g2987 U3722/net40 VSS nmos W=0.155u L=0.04u
M3001 n3817 U3722/net19 U3722/net36 VSS nmos W=0.155u L=0.04u
M3002 U3722/net40 g3069 VSS VSS nmos W=0.31u L=0.04u
M3003 U3722/net36 g3050 VSS VSS nmos W=0.155u L=0.04u
M3004 U3722/net19 g2987 VDD VDD pmos W=0.205u L=0.04u
M3005 n3817 U3722/net19 U3722/net26 VDD pmos W=0.325u L=0.04u
M3006 U3722/net26 g3069 VDD VDD pmos W=0.41u L=0.04u
M3007 n3817 g2987 U3722/net30 VDD pmos W=0.325u L=0.04u
M3008 U3722/net30 g3050 VDD VDD pmos W=0.205u L=0.04u
M3009 U3723/net19 g2987 VSS VSS nmos W=0.155u L=0.04u
M3010 n3816 g2987 U3723/net40 VSS nmos W=0.155u L=0.04u
M3011 n3816 U3723/net19 U3723/net36 VSS nmos W=0.155u L=0.04u
M3012 U3723/net40 g3068 VSS VSS nmos W=0.31u L=0.04u
M3013 U3723/net36 g3049 VSS VSS nmos W=0.155u L=0.04u
M3014 U3723/net19 g2987 VDD VDD pmos W=0.205u L=0.04u
M3015 n3816 U3723/net19 U3723/net26 VDD pmos W=0.325u L=0.04u
M3016 U3723/net26 g3068 VDD VDD pmos W=0.41u L=0.04u
M3017 n3816 g2987 U3723/net30 VDD pmos W=0.325u L=0.04u
M3018 U3723/net30 g3049 VDD VDD pmos W=0.205u L=0.04u
M3019 U3724/net19 g2987 VSS VSS nmos W=0.155u L=0.04u
M3020 n3815 g2987 U3724/net40 VSS nmos W=0.155u L=0.04u
M3021 n3815 U3724/net19 U3724/net36 VSS nmos W=0.155u L=0.04u
M3022 U3724/net40 g3067 VSS VSS nmos W=0.31u L=0.04u
M3023 U3724/net36 g3048 VSS VSS nmos W=0.155u L=0.04u
M3024 U3724/net19 g2987 VDD VDD pmos W=0.205u L=0.04u
M3025 n3815 U3724/net19 U3724/net26 VDD pmos W=0.325u L=0.04u
M3026 U3724/net26 g3067 VDD VDD pmos W=0.41u L=0.04u
M3027 n3815 g2987 U3724/net30 VDD pmos W=0.325u L=0.04u
M3028 U3724/net30 g3048 VDD VDD pmos W=0.205u L=0.04u
M3029 U3725/net19 g2987 VSS VSS nmos W=0.155u L=0.04u
M3030 n3814 g2987 U3725/net40 VSS nmos W=0.155u L=0.04u
M3031 n3814 U3725/net19 U3725/net36 VSS nmos W=0.155u L=0.04u
M3032 U3725/net40 g3066 VSS VSS nmos W=0.31u L=0.04u
M3033 U3725/net36 g3047 VSS VSS nmos W=0.155u L=0.04u
M3034 U3725/net19 g2987 VDD VDD pmos W=0.205u L=0.04u
M3035 n3814 U3725/net19 U3725/net26 VDD pmos W=0.325u L=0.04u
M3036 U3725/net26 g3066 VDD VDD pmos W=0.41u L=0.04u
M3037 n3814 g2987 U3725/net30 VDD pmos W=0.325u L=0.04u
M3038 U3725/net30 g3047 VDD VDD pmos W=0.205u L=0.04u
M3039 U3726/net19 g2987 VSS VSS nmos W=0.155u L=0.04u
M3040 n3813 g2987 U3726/net40 VSS nmos W=0.155u L=0.04u
M3041 n3813 U3726/net19 U3726/net36 VSS nmos W=0.155u L=0.04u
M3042 U3726/net40 g3065 VSS VSS nmos W=0.31u L=0.04u
M3043 U3726/net36 g3046 VSS VSS nmos W=0.155u L=0.04u
M3044 U3726/net19 g2987 VDD VDD pmos W=0.205u L=0.04u
M3045 n3813 U3726/net19 U3726/net26 VDD pmos W=0.325u L=0.04u
M3046 U3726/net26 g3065 VDD VDD pmos W=0.41u L=0.04u
M3047 n3813 g2987 U3726/net30 VDD pmos W=0.325u L=0.04u
M3048 U3726/net30 g3046 VDD VDD pmos W=0.205u L=0.04u
M3049 U3727/net19 g2987 VSS VSS nmos W=0.155u L=0.04u
M3050 n3812 g2987 U3727/net40 VSS nmos W=0.155u L=0.04u
M3051 n3812 U3727/net19 U3727/net36 VSS nmos W=0.155u L=0.04u
M3052 U3727/net40 g3064 VSS VSS nmos W=0.31u L=0.04u
M3053 U3727/net36 g3045 VSS VSS nmos W=0.155u L=0.04u
M3054 U3727/net19 g2987 VDD VDD pmos W=0.205u L=0.04u
M3055 n3812 U3727/net19 U3727/net26 VDD pmos W=0.325u L=0.04u
M3056 U3727/net26 g3064 VDD VDD pmos W=0.41u L=0.04u
M3057 n3812 g2987 U3727/net30 VDD pmos W=0.325u L=0.04u
M3058 U3727/net30 g3045 VDD VDD pmos W=0.205u L=0.04u
M3059 U3728/net19 g2987 VSS VSS nmos W=0.155u L=0.04u
M3060 n3811 g2987 U3728/net40 VSS nmos W=0.155u L=0.04u
M3061 n3811 U3728/net19 U3728/net36 VSS nmos W=0.155u L=0.04u
M3062 U3728/net40 g3063 VSS VSS nmos W=0.31u L=0.04u
M3063 U3728/net36 g3044 VSS VSS nmos W=0.155u L=0.04u
M3064 U3728/net19 g2987 VDD VDD pmos W=0.205u L=0.04u
M3065 n3811 U3728/net19 U3728/net26 VDD pmos W=0.325u L=0.04u
M3066 U3728/net26 g3063 VDD VDD pmos W=0.41u L=0.04u
M3067 n3811 g2987 U3728/net30 VDD pmos W=0.325u L=0.04u
M3068 U3728/net30 g3044 VDD VDD pmos W=0.205u L=0.04u
M3069 U3729/net19 g2987 VSS VSS nmos W=0.155u L=0.04u
M3070 n3810 g2987 U3729/net40 VSS nmos W=0.155u L=0.04u
M3071 n3810 U3729/net19 U3729/net36 VSS nmos W=0.155u L=0.04u
M3072 U3729/net40 g3062 VSS VSS nmos W=0.31u L=0.04u
M3073 U3729/net36 g3043 VSS VSS nmos W=0.155u L=0.04u
M3074 U3729/net19 g2987 VDD VDD pmos W=0.205u L=0.04u
M3075 n3810 U3729/net19 U3729/net26 VDD pmos W=0.325u L=0.04u
M3076 U3729/net26 g3062 VDD VDD pmos W=0.41u L=0.04u
M3077 n3810 g2987 U3729/net30 VDD pmos W=0.325u L=0.04u
M3078 U3729/net30 g3043 VDD VDD pmos W=0.205u L=0.04u
M3079 U3730/XU1-net6 n659 VSS VSS nmos W=0.155u L=0.04u
M3080 n3809 g3080 U3730/XU1-net6 VSS nmos W=0.155u L=0.04u
M3081 n3809 n659 VDD VDD pmos W=0.155u L=0.04u
M3082 n3809 g3080 VDD VDD pmos W=0.155u L=0.04u
M3083 U3731/XU1-net6 n3833 VSS VSS nmos W=0.155u L=0.04u
M3084 n3808 n3832 U3731/XU1-net6 VSS nmos W=0.155u L=0.04u
M3085 n3808 n3833 VDD VDD pmos W=0.155u L=0.04u
M3086 n3808 n3832 VDD VDD pmos W=0.155u L=0.04u
M3087 U3732/net4 n3834 U3732/net14 VSS nmos W=0.155u L=0.04u
M3088 U3732/net6 U3732/net10 U3732/net14 VSS nmos W=0.17u L=0.04u
M3089 U3732/net4 g3032 VSS VSS nmos W=0.155u L=0.04u
M3090 U3732/net6 U3732/net4 VSS VSS nmos W=0.17u L=0.04u
M3091 n3832 U3732/net14 VSS VSS nmos W=0.155u L=0.04u
M3092 U3732/net10 n3834 VSS VSS nmos W=0.155u L=0.04u
M3093 U3732/net4 U3732/net10 U3732/net14 VDD pmos W=0.255u L=0.04u
M3094 U3732/net6 n3834 U3732/net14 VDD pmos W=0.28u L=0.04u
M3095 U3732/net4 g3032 VDD VDD pmos W=0.205u L=0.04u
M3096 U3732/net6 U3732/net4 VDD VDD pmos W=0.24u L=0.04u
M3097 n3832 U3732/net14 VDD VDD pmos W=0.205u L=0.04u
M3098 U3732/net10 n3834 VDD VDD pmos W=0.205u L=0.04u
M3099 U3733/net36 n3834 U3733/net24 VSS nmos W=0.155u L=0.04u
M3100 U3733/net24 n3833 VSS VSS nmos W=0.155u L=0.04u
M3101 n3807 g3036 U3733/net36 VSS nmos W=0.155u L=0.04u
M3102 n3807 n3835 U3733/net36 VSS nmos W=0.155u L=0.04u
M3103 n3807 n3835 U3733/net35 VDD pmos W=0.205u L=0.04u
M3104 U3733/net35 g3036 VDD VDD pmos W=0.205u L=0.04u
M3105 n3807 n3833 VDD VDD pmos W=0.205u L=0.04u
M3106 n3807 n3834 VDD VDD pmos W=0.205u L=0.04u
M3107 U3734/XU1-net6 n3835 VSS VSS nmos W=0.155u L=0.04u
M3108 n3834 g3036 U3734/XU1-net6 VSS nmos W=0.155u L=0.04u
M3109 n3834 n3835 VDD VDD pmos W=0.155u L=0.04u
M3110 n3834 g3036 VDD VDD pmos W=0.155u L=0.04u
M3111 n3835 n3836 VSS VSS nmos W=0.135u L=0.04u
M3112 n3835 n3836 VDD VDD pmos W=0.205u L=0.04u
M3113 U3736/net36 n3836 U3736/net24 VSS nmos W=0.155u L=0.04u
M3114 U3736/net24 n3833 VSS VSS nmos W=0.155u L=0.04u
M3115 n3806 g3028 U3736/net36 VSS nmos W=0.155u L=0.04u
M3116 n3806 n3837 U3736/net36 VSS nmos W=0.155u L=0.04u
M3117 n3806 n3837 U3736/net35 VDD pmos W=0.205u L=0.04u
M3118 U3736/net35 g3028 VDD VDD pmos W=0.205u L=0.04u
M3119 n3806 n3833 VDD VDD pmos W=0.205u L=0.04u
M3120 n3806 n3836 VDD VDD pmos W=0.205u L=0.04u
M3121 U3737/XU1-net6 n3837 VSS VSS nmos W=0.155u L=0.04u
M3122 n3836 g3028 U3737/XU1-net6 VSS nmos W=0.155u L=0.04u
M3123 n3836 n3837 VDD VDD pmos W=0.155u L=0.04u
M3124 n3836 g3028 VDD VDD pmos W=0.155u L=0.04u
M3125 U3738/XU1-net6 n3839 VSS VSS nmos W=0.155u L=0.04u
M3126 n3805 n3838 U3738/XU1-net6 VSS nmos W=0.155u L=0.04u
M3127 n3805 n3839 VDD VDD pmos W=0.155u L=0.04u
M3128 n3805 n3838 VDD VDD pmos W=0.155u L=0.04u
M3129 U3739/net4 U3739/net10 U3739/net14 VSS nmos W=0.155u L=0.04u
M3130 U3739/net6 g3024 U3739/net14 VSS nmos W=0.155u L=0.04u
M3131 U3739/net4 n3840 VSS VSS nmos W=0.155u L=0.04u
M3132 U3739/net6 U3739/net4 VSS VSS nmos W=0.155u L=0.04u
M3133 n3839 U3739/net14 VSS VSS nmos W=0.155u L=0.04u
M3134 U3739/net10 g3024 VSS VSS nmos W=0.155u L=0.04u
M3135 U3739/net4 g3024 U3739/net14 VDD pmos W=0.205u L=0.04u
M3136 U3739/net6 U3739/net10 U3739/net14 VDD pmos W=0.205u L=0.04u
M3137 U3739/net4 n3840 VDD VDD pmos W=0.205u L=0.04u
M3138 U3739/net6 U3739/net4 VDD VDD pmos W=0.205u L=0.04u
M3139 n3839 U3739/net14 VDD VDD pmos W=0.205u L=0.04u
M3140 U3739/net10 g3024 VDD VDD pmos W=0.205u L=0.04u
M3141 n3840 n3841 VSS VSS nmos W=0.155u L=0.04u
M3142 n3840 n3842 VSS VSS nmos W=0.155u L=0.04u
M3143 U3740/XI1-net8 n3842 VDD VDD pmos W=0.205u L=0.04u
M3144 n3840 n3841 U3740/XI1-net8 VDD pmos W=0.205u L=0.04u
M3145 U3741/XU1-net6 n3843 VSS VSS nmos W=0.155u L=0.04u
M3146 n3804 n3838 U3741/XU1-net6 VSS nmos W=0.155u L=0.04u
M3147 n3804 n3843 VDD VDD pmos W=0.155u L=0.04u
M3148 n3804 n3838 VDD VDD pmos W=0.155u L=0.04u
M3149 U3742/net4 n3841 U3742/net14 VSS nmos W=0.155u L=0.04u
M3150 U3742/net6 U3742/net10 U3742/net14 VSS nmos W=0.17u L=0.04u
M3151 U3742/net4 g3010 VSS VSS nmos W=0.155u L=0.04u
M3152 U3742/net6 U3742/net4 VSS VSS nmos W=0.17u L=0.04u
M3153 n3843 U3742/net14 VSS VSS nmos W=0.155u L=0.04u
M3154 U3742/net10 n3841 VSS VSS nmos W=0.155u L=0.04u
M3155 U3742/net4 U3742/net10 U3742/net14 VDD pmos W=0.255u L=0.04u
M3156 U3742/net6 n3841 U3742/net14 VDD pmos W=0.28u L=0.04u
M3157 U3742/net4 g3010 VDD VDD pmos W=0.205u L=0.04u
M3158 U3742/net6 U3742/net4 VDD VDD pmos W=0.24u L=0.04u
M3159 n3843 U3742/net14 VDD VDD pmos W=0.205u L=0.04u
M3160 U3742/net10 n3841 VDD VDD pmos W=0.205u L=0.04u
M3161 U3743/net36 n3841 U3743/net24 VSS nmos W=0.155u L=0.04u
M3162 U3743/net24 n3838 VSS VSS nmos W=0.155u L=0.04u
M3163 n3803 g3013 U3743/net36 VSS nmos W=0.155u L=0.04u
M3164 n3803 n3844 U3743/net36 VSS nmos W=0.155u L=0.04u
M3165 n3803 n3844 U3743/net35 VDD pmos W=0.205u L=0.04u
M3166 U3743/net35 g3013 VDD VDD pmos W=0.205u L=0.04u
M3167 n3803 n3838 VDD VDD pmos W=0.205u L=0.04u
M3168 n3803 n3841 VDD VDD pmos W=0.205u L=0.04u
M3169 U3744/XU1-net6 g3013 VSS VSS nmos W=0.155u L=0.04u
M3170 n3841 n3844 U3744/XU1-net6 VSS nmos W=0.155u L=0.04u
M3171 n3841 g3013 VDD VDD pmos W=0.155u L=0.04u
M3172 n3841 n3844 VDD VDD pmos W=0.155u L=0.04u
M3173 n3802 U3745/net27 VDD VDD pmos W=0.205u L=0.04u
M3174 U3745/net11 n3845 U3745/net27 VDD pmos W=0.205u L=0.04u
M3175 U3745/net11 n3846 U3745/net27 VDD pmos W=0.205u L=0.04u
M3176 U3745/net11 n3844 U3745/XI16-net11 VDD pmos W=0.205u L=0.04u
M3177 U3745/XI16-net11 n3847 VDD VDD pmos W=0.205u L=0.04u
M3178 U3745/net27 n3847 VSS VSS nmos W=0.155u L=0.04u
M3179 U3745/net27 n3844 VSS VSS nmos W=0.155u L=0.04u
M3180 n3802 U3745/net27 VSS VSS nmos W=0.155u L=0.04u
M3181 U3745/net27 n3845 U3745/XI12-net17 VSS nmos W=0.155u L=0.04u
M3182 U3745/XI12-net17 n3846 VSS VSS nmos W=0.155u L=0.04u
M3183 n3844 n3846 VSS VSS nmos W=0.155u L=0.04u
M3184 n3844 n3845 VSS VSS nmos W=0.155u L=0.04u
M3185 U3746/XI1-net8 n3845 VDD VDD pmos W=0.205u L=0.04u
M3186 n3844 n3846 U3746/XI1-net8 VDD pmos W=0.205u L=0.04u
M3187 U3747/net36 n3846 U3747/net24 VSS nmos W=0.155u L=0.04u
M3188 U3747/net24 n3838 VSS VSS nmos W=0.155u L=0.04u
M3189 n3801 g3006 U3747/net36 VSS nmos W=0.155u L=0.04u
M3190 n3801 n3848 U3747/net36 VSS nmos W=0.155u L=0.04u
M3191 n3801 n3848 U3747/net35 VDD pmos W=0.205u L=0.04u
M3192 U3747/net35 g3006 VDD VDD pmos W=0.205u L=0.04u
M3193 n3801 n3838 VDD VDD pmos W=0.205u L=0.04u
M3194 n3801 n3846 VDD VDD pmos W=0.205u L=0.04u
M3195 n3838 n3847 VSS VSS nmos W=0.135u L=0.04u
M3196 n3838 n3847 VDD VDD pmos W=0.205u L=0.04u
M3197 U3749/XU1-net6 n3848 VSS VSS nmos W=0.155u L=0.04u
M3198 n3846 g3006 U3749/XU1-net6 VSS nmos W=0.155u L=0.04u
M3199 n3846 n3848 VDD VDD pmos W=0.155u L=0.04u
M3200 n3846 g3006 VDD VDD pmos W=0.155u L=0.04u
M3201 U3750/net19 n3847 VSS VSS nmos W=0.155u L=0.04u
M3202 n3800 n3847 U3750/net40 VSS nmos W=0.155u L=0.04u
M3203 n3800 U3750/net19 U3750/net36 VSS nmos W=0.155u L=0.04u
M3204 U3750/net40 g3234 VSS VSS nmos W=0.31u L=0.04u
M3205 U3750/net36 n3849 VSS VSS nmos W=0.155u L=0.04u
M3206 U3750/net19 n3847 VDD VDD pmos W=0.205u L=0.04u
M3207 n3800 U3750/net19 U3750/net26 VDD pmos W=0.325u L=0.04u
M3208 U3750/net26 g3234 VDD VDD pmos W=0.41u L=0.04u
M3209 n3800 n3847 U3750/net30 VDD pmos W=0.325u L=0.04u
M3210 U3750/net30 n3849 VDD VDD pmos W=0.205u L=0.04u
M3211 n3849 n3850 U3751/net27 VSS nmos W=0.155u L=0.04u
M3212 U3751/net27 n3851 VSS VSS nmos W=0.155u L=0.04u
M3213 n3849 n3848 VSS VSS nmos W=0.155u L=0.04u
M3214 n3849 n3851 U3751/net13 VDD pmos W=0.205u L=0.04u
M3215 U3751/net13 n3848 VDD VDD pmos W=0.205u L=0.04u
M3216 n3849 n3850 U3751/net13 VDD pmos W=0.205u L=0.04u
M3217 n3848 n3850 VSS VSS nmos W=0.155u L=0.04u
M3218 n3848 n3851 VSS VSS nmos W=0.155u L=0.04u
M3219 U3752/XI1-net8 n3851 VDD VDD pmos W=0.205u L=0.04u
M3220 n3848 n3850 U3752/XI1-net8 VDD pmos W=0.205u L=0.04u
M3221 U3753/net36 n3850 U3753/net24 VSS nmos W=0.155u L=0.04u
M3222 U3753/net24 n659 VSS VSS nmos W=0.155u L=0.04u
M3223 n3799 g3080 U3753/net36 VSS nmos W=0.155u L=0.04u
M3224 n3799 g2993 U3753/net36 VSS nmos W=0.155u L=0.04u
M3225 n3799 g2993 U3753/net35 VDD pmos W=0.205u L=0.04u
M3226 U3753/net35 g3080 VDD VDD pmos W=0.205u L=0.04u
M3227 n3799 n659 VDD VDD pmos W=0.205u L=0.04u
M3228 n3799 n3850 VDD VDD pmos W=0.205u L=0.04u
M3229 U3754/XU1-net6 g3080 VSS VSS nmos W=0.155u L=0.04u
M3230 n3850 g2993 U3754/XU1-net6 VSS nmos W=0.155u L=0.04u
M3231 n3850 g3080 VDD VDD pmos W=0.155u L=0.04u
M3232 n3850 g2993 VDD VDD pmos W=0.155u L=0.04u
M3233 U3755/XU1-net6 n659 VSS VSS nmos W=0.155u L=0.04u
M3234 n3798 g3054 U3755/XU1-net6 VSS nmos W=0.155u L=0.04u
M3235 n3798 n659 VDD VDD pmos W=0.155u L=0.04u
M3236 n3798 g3054 VDD VDD pmos W=0.155u L=0.04u
M3237 U3756/net19 n3853 VSS VSS nmos W=0.155u L=0.04u
M3238 n3797 n3853 U3756/net40 VSS nmos W=0.155u L=0.04u
M3239 n3797 U3756/net19 U3756/net36 VSS nmos W=0.155u L=0.04u
M3240 U3756/net40 g2733 VSS VSS nmos W=0.31u L=0.04u
M3241 U3756/net36 n3852 VSS VSS nmos W=0.155u L=0.04u
M3242 U3756/net19 n3853 VDD VDD pmos W=0.205u L=0.04u
M3243 n3797 U3756/net19 U3756/net26 VDD pmos W=0.325u L=0.04u
M3244 U3756/net26 g2733 VDD VDD pmos W=0.41u L=0.04u
M3245 n3797 n3853 U3756/net30 VDD pmos W=0.325u L=0.04u
M3246 U3756/net30 n3852 VDD VDD pmos W=0.205u L=0.04u
M3247 U3757/net36 n3855 U3757/net24 VSS nmos W=0.155u L=0.04u
M3248 U3757/net24 n3856 VSS VSS nmos W=0.155u L=0.04u
M3249 n3796 g2714 U3757/net36 VSS nmos W=0.155u L=0.04u
M3250 n3796 n3854 U3757/net36 VSS nmos W=0.155u L=0.04u
M3251 n3796 n3854 U3757/net35 VDD pmos W=0.205u L=0.04u
M3252 U3757/net35 g2714 VDD VDD pmos W=0.205u L=0.04u
M3253 n3796 n3856 VDD VDD pmos W=0.205u L=0.04u
M3254 n3796 n3855 VDD VDD pmos W=0.205u L=0.04u
M3255 n3795 U3758/net27 VDD VDD pmos W=0.205u L=0.04u
M3256 U3758/net11 n3857 U3758/net27 VDD pmos W=0.205u L=0.04u
M3257 U3758/net11 n3855 U3758/net27 VDD pmos W=0.205u L=0.04u
M3258 U3758/net11 n3858 U3758/XI16-net11 VDD pmos W=0.205u L=0.04u
M3259 U3758/XI16-net11 n3859 VDD VDD pmos W=0.205u L=0.04u
M3260 U3758/net27 n3859 VSS VSS nmos W=0.155u L=0.04u
M3261 U3758/net27 n3858 VSS VSS nmos W=0.155u L=0.04u
M3262 n3795 U3758/net27 VSS VSS nmos W=0.155u L=0.04u
M3263 U3758/net27 n3857 U3758/XI12-net17 VSS nmos W=0.155u L=0.04u
M3264 U3758/XI12-net17 n3855 VSS VSS nmos W=0.155u L=0.04u
M3265 U3759/net36 n3860 U3759/net24 VSS nmos W=0.155u L=0.04u
M3266 U3759/net24 n3856 VSS VSS nmos W=0.155u L=0.04u
M3267 n3794 g2727 U3759/net36 VSS nmos W=0.155u L=0.04u
M3268 n3794 n3858 U3759/net36 VSS nmos W=0.155u L=0.04u
M3269 n3794 n3858 U3759/net35 VDD pmos W=0.205u L=0.04u
M3270 U3759/net35 g2727 VDD VDD pmos W=0.205u L=0.04u
M3271 n3794 n3856 VDD VDD pmos W=0.205u L=0.04u
M3272 n3794 n3860 VDD VDD pmos W=0.205u L=0.04u
M3273 n3793 U3760/net27 VDD VDD pmos W=0.205u L=0.04u
M3274 U3760/net11 n3861 U3760/net27 VDD pmos W=0.205u L=0.04u
M3275 U3760/net11 n3860 U3760/net27 VDD pmos W=0.205u L=0.04u
M3276 U3760/net11 n3862 U3760/XI16-net11 VDD pmos W=0.205u L=0.04u
M3277 U3760/XI16-net11 n3859 VDD VDD pmos W=0.205u L=0.04u
M3278 U3760/net27 n3859 VSS VSS nmos W=0.155u L=0.04u
M3279 U3760/net27 n3862 VSS VSS nmos W=0.155u L=0.04u
M3280 n3793 U3760/net27 VSS VSS nmos W=0.155u L=0.04u
M3281 U3760/net27 n3861 U3760/XI12-net17 VSS nmos W=0.155u L=0.04u
M3282 U3760/XI12-net17 n3860 VSS VSS nmos W=0.155u L=0.04u
M3283 U3761/net36 n3863 U3761/net24 VSS nmos W=0.155u L=0.04u
M3284 U3761/net24 n3856 VSS VSS nmos W=0.155u L=0.04u
M3285 n3792 g2734 U3761/net36 VSS nmos W=0.155u L=0.04u
M3286 n3792 n3862 U3761/net36 VSS nmos W=0.155u L=0.04u
M3287 n3792 n3862 U3761/net35 VDD pmos W=0.205u L=0.04u
M3288 U3761/net35 g2734 VDD VDD pmos W=0.205u L=0.04u
M3289 n3792 n3856 VDD VDD pmos W=0.205u L=0.04u
M3290 n3792 n3863 VDD VDD pmos W=0.205u L=0.04u
M3291 n3791 U3762/net27 VDD VDD pmos W=0.205u L=0.04u
M3292 U3762/net11 n3864 U3762/net27 VDD pmos W=0.205u L=0.04u
M3293 U3762/net11 n3863 U3762/net27 VDD pmos W=0.205u L=0.04u
M3294 U3762/net11 n3865 U3762/XI16-net11 VDD pmos W=0.205u L=0.04u
M3295 U3762/XI16-net11 n3859 VDD VDD pmos W=0.205u L=0.04u
M3296 U3762/net27 n3859 VSS VSS nmos W=0.155u L=0.04u
M3297 U3762/net27 n3865 VSS VSS nmos W=0.155u L=0.04u
M3298 n3791 U3762/net27 VSS VSS nmos W=0.155u L=0.04u
M3299 U3762/net27 n3864 U3762/XI12-net17 VSS nmos W=0.155u L=0.04u
M3300 U3762/XI12-net17 n3863 VSS VSS nmos W=0.155u L=0.04u
M3301 n3859 n3856 VSS VSS nmos W=0.135u L=0.04u
M3302 n3859 n3856 VDD VDD pmos W=0.205u L=0.04u
M3303 U3764/net36 n3866 U3764/net24 VSS nmos W=0.155u L=0.04u
M3304 U3764/net24 n3856 VSS VSS nmos W=0.155u L=0.04u
M3305 n3790 g2740 U3764/net36 VSS nmos W=0.155u L=0.04u
M3306 n3790 n3865 U3764/net36 VSS nmos W=0.155u L=0.04u
M3307 n3790 n3865 U3764/net35 VDD pmos W=0.205u L=0.04u
M3308 U3764/net35 g2740 VDD VDD pmos W=0.205u L=0.04u
M3309 n3790 n3856 VDD VDD pmos W=0.205u L=0.04u
M3310 n3790 n3866 VDD VDD pmos W=0.205u L=0.04u
M3311 U3765/net36 n3868 U3765/net24 VSS nmos W=0.155u L=0.04u
M3312 U3765/net24 n3856 VSS VSS nmos W=0.155u L=0.04u
M3313 n3789 g2753 U3765/net36 VSS nmos W=0.155u L=0.04u
M3314 n3789 n3867 U3765/net36 VSS nmos W=0.155u L=0.04u
M3315 n3789 n3867 U3765/net35 VDD pmos W=0.205u L=0.04u
M3316 U3765/net35 g2753 VDD VDD pmos W=0.205u L=0.04u
M3317 n3789 n3856 VDD VDD pmos W=0.205u L=0.04u
M3318 n3789 n3868 VDD VDD pmos W=0.205u L=0.04u
M3319 U3766/XU1-net6 n3856 VSS VSS nmos W=0.155u L=0.04u
M3320 n3788 n3869 U3766/XU1-net6 VSS nmos W=0.155u L=0.04u
M3321 n3788 n3856 VDD VDD pmos W=0.155u L=0.04u
M3322 n3788 n3869 VDD VDD pmos W=0.155u L=0.04u
M3323 U3767/net4 n3868 U3767/net14 VSS nmos W=0.155u L=0.04u
M3324 U3767/net6 U3767/net10 U3767/net14 VSS nmos W=0.17u L=0.04u
M3325 U3767/net4 g2760 VSS VSS nmos W=0.155u L=0.04u
M3326 U3767/net6 U3767/net4 VSS VSS nmos W=0.17u L=0.04u
M3327 n3869 U3767/net14 VSS VSS nmos W=0.155u L=0.04u
M3328 U3767/net10 n3868 VSS VSS nmos W=0.155u L=0.04u
M3329 U3767/net4 U3767/net10 U3767/net14 VDD pmos W=0.255u L=0.04u
M3330 U3767/net6 n3868 U3767/net14 VDD pmos W=0.28u L=0.04u
M3331 U3767/net4 g2760 VDD VDD pmos W=0.205u L=0.04u
M3332 U3767/net6 U3767/net4 VDD VDD pmos W=0.24u L=0.04u
M3333 n3869 U3767/net14 VDD VDD pmos W=0.205u L=0.04u
M3334 U3767/net10 n3868 VDD VDD pmos W=0.205u L=0.04u
M3335 U3768/XU1-net6 n3856 VSS VSS nmos W=0.155u L=0.04u
M3336 n3787 n3870 U3768/XU1-net6 VSS nmos W=0.155u L=0.04u
M3337 n3787 n3856 VDD VDD pmos W=0.155u L=0.04u
M3338 n3787 n3870 VDD VDD pmos W=0.155u L=0.04u
M3339 U3769/net4 n3871 U3769/net14 VSS nmos W=0.155u L=0.04u
M3340 U3769/net6 U3769/net10 U3769/net14 VSS nmos W=0.17u L=0.04u
M3341 U3769/net4 n3872 VSS VSS nmos W=0.155u L=0.04u
M3342 U3769/net6 U3769/net4 VSS VSS nmos W=0.17u L=0.04u
M3343 n3870 U3769/net14 VSS VSS nmos W=0.155u L=0.04u
M3344 U3769/net10 n3871 VSS VSS nmos W=0.155u L=0.04u
M3345 U3769/net4 U3769/net10 U3769/net14 VDD pmos W=0.255u L=0.04u
M3346 U3769/net6 n3871 U3769/net14 VDD pmos W=0.28u L=0.04u
M3347 U3769/net4 n3872 VDD VDD pmos W=0.205u L=0.04u
M3348 U3769/net6 U3769/net4 VDD VDD pmos W=0.24u L=0.04u
M3349 n3870 U3769/net14 VDD VDD pmos W=0.205u L=0.04u
M3350 U3769/net10 n3871 VDD VDD pmos W=0.205u L=0.04u
M3351 n3872 n3873 VSS VSS nmos W=0.155u L=0.04u
M3352 n3872 n3868 VSS VSS nmos W=0.155u L=0.04u
M3353 U3770/XI1-net8 n3868 VDD VDD pmos W=0.205u L=0.04u
M3354 n3872 n3873 U3770/XI1-net8 VDD pmos W=0.205u L=0.04u
M3355 U3771/XU1-net6 n3867 VSS VSS nmos W=0.155u L=0.04u
M3356 n3868 g2753 U3771/XU1-net6 VSS nmos W=0.155u L=0.04u
M3357 n3868 n3867 VDD VDD pmos W=0.155u L=0.04u
M3358 n3868 g2753 VDD VDD pmos W=0.155u L=0.04u
M3359 n3867 n3866 VSS VSS nmos W=0.135u L=0.04u
M3360 n3867 n3866 VDD VDD pmos W=0.205u L=0.04u
M3361 U3773/XU1-net6 n3865 VSS VSS nmos W=0.155u L=0.04u
M3362 n3866 g2740 U3773/XU1-net6 VSS nmos W=0.155u L=0.04u
M3363 n3866 n3865 VDD VDD pmos W=0.155u L=0.04u
M3364 n3866 g2740 VDD VDD pmos W=0.155u L=0.04u
M3365 n3865 n3864 VSS VSS nmos W=0.155u L=0.04u
M3366 n3865 n3863 VSS VSS nmos W=0.155u L=0.04u
M3367 U3774/XI1-net8 n3863 VDD VDD pmos W=0.205u L=0.04u
M3368 n3865 n3864 U3774/XI1-net8 VDD pmos W=0.205u L=0.04u
M3369 U3775/XU1-net6 n3862 VSS VSS nmos W=0.155u L=0.04u
M3370 n3863 g2734 U3775/XU1-net6 VSS nmos W=0.155u L=0.04u
M3371 n3863 n3862 VDD VDD pmos W=0.155u L=0.04u
M3372 n3863 g2734 VDD VDD pmos W=0.155u L=0.04u
M3373 n3862 n3861 VSS VSS nmos W=0.155u L=0.04u
M3374 n3862 n3860 VSS VSS nmos W=0.155u L=0.04u
M3375 U3776/XI1-net8 n3860 VDD VDD pmos W=0.205u L=0.04u
M3376 n3862 n3861 U3776/XI1-net8 VDD pmos W=0.205u L=0.04u
M3377 U3777/XU1-net6 n3858 VSS VSS nmos W=0.155u L=0.04u
M3378 n3860 g2727 U3777/XU1-net6 VSS nmos W=0.155u L=0.04u
M3379 n3860 n3858 VDD VDD pmos W=0.155u L=0.04u
M3380 n3860 g2727 VDD VDD pmos W=0.155u L=0.04u
M3381 n3858 n3857 VSS VSS nmos W=0.155u L=0.04u
M3382 n3858 n3855 VSS VSS nmos W=0.155u L=0.04u
M3383 U3778/XI1-net8 n3855 VDD VDD pmos W=0.205u L=0.04u
M3384 n3858 n3857 U3778/XI1-net8 VDD pmos W=0.205u L=0.04u
M3385 U3779/XU1-net6 n3854 VSS VSS nmos W=0.155u L=0.04u
M3386 n3855 g2714 U3779/XU1-net6 VSS nmos W=0.155u L=0.04u
M3387 n3855 n3854 VDD VDD pmos W=0.155u L=0.04u
M3388 n3855 g2714 VDD VDD pmos W=0.155u L=0.04u
M3389 n3854 n3853 VSS VSS nmos W=0.155u L=0.04u
M3390 n3854 g2733 VSS VSS nmos W=0.155u L=0.04u
M3391 U3780/XI1-net8 g2733 VDD VDD pmos W=0.205u L=0.04u
M3392 n3854 n3853 U3780/XI1-net8 VDD pmos W=0.205u L=0.04u
M3393 n3786 g2811 U3781/net15 VSS nmos W=0.155u L=0.04u
M3394 n3786 n3874 U3781/net15 VSS nmos W=0.155u L=0.04u
M3395 U3781/net15 n3875 VSS VSS nmos W=0.155u L=0.04u
M3396 n3786 n3875 VDD VDD pmos W=0.205u L=0.04u
M3397 n3786 g2811 U3781/XI16-net11 VDD pmos W=0.205u L=0.04u
M3398 U3781/XI16-net11 n3874 VDD VDD pmos W=0.205u L=0.04u
M3399 n3785 g2813 U3782/net15 VSS nmos W=0.155u L=0.04u
M3400 n3785 n3876 U3782/net15 VSS nmos W=0.155u L=0.04u
M3401 U3782/net15 n3856 VSS VSS nmos W=0.155u L=0.04u
M3402 n3785 n3856 VDD VDD pmos W=0.205u L=0.04u
M3403 n3785 g2813 U3782/XI16-net11 VDD pmos W=0.205u L=0.04u
M3404 U3782/XI16-net11 n3876 VDD VDD pmos W=0.205u L=0.04u
M3405 n3784 g2812 U3783/net15 VSS nmos W=0.155u L=0.04u
M3406 n3784 n3877 U3783/net15 VSS nmos W=0.155u L=0.04u
M3407 U3783/net15 n3878 VSS VSS nmos W=0.155u L=0.04u
M3408 n3784 n3878 VDD VDD pmos W=0.205u L=0.04u
M3409 n3784 g2812 U3783/XI16-net11 VDD pmos W=0.205u L=0.04u
M3410 U3783/XI16-net11 n3877 VDD VDD pmos W=0.205u L=0.04u
M3411 U3784/net19 n3874 VSS VSS nmos W=0.155u L=0.04u
M3412 n3783 n3874 U3784/net40 VSS nmos W=0.155u L=0.04u
M3413 n3783 U3784/net19 U3784/net36 VSS nmos W=0.155u L=0.04u
M3414 U3784/net40 n3879 VSS VSS nmos W=0.31u L=0.04u
M3415 U3784/net36 g2772 VSS VSS nmos W=0.155u L=0.04u
M3416 U3784/net19 n3874 VDD VDD pmos W=0.205u L=0.04u
M3417 n3783 U3784/net19 U3784/net26 VDD pmos W=0.325u L=0.04u
M3418 U3784/net26 n3879 VDD VDD pmos W=0.41u L=0.04u
M3419 n3783 n3874 U3784/net30 VDD pmos W=0.325u L=0.04u
M3420 U3784/net30 g2772 VDD VDD pmos W=0.205u L=0.04u
M3421 U3785/net19 n3874 VSS VSS nmos W=0.155u L=0.04u
M3422 n3782 n3874 U3785/net40 VSS nmos W=0.155u L=0.04u
M3423 n3782 U3785/net19 U3785/net36 VSS nmos W=0.155u L=0.04u
M3424 U3785/net40 n3871 VSS VSS nmos W=0.31u L=0.04u
M3425 U3785/net36 g2799 VSS VSS nmos W=0.155u L=0.04u
M3426 U3785/net19 n3874 VDD VDD pmos W=0.205u L=0.04u
M3427 n3782 U3785/net19 U3785/net26 VDD pmos W=0.325u L=0.04u
M3428 U3785/net26 n3871 VDD VDD pmos W=0.41u L=0.04u
M3429 n3782 n3874 U3785/net30 VDD pmos W=0.325u L=0.04u
M3430 U3785/net30 g2799 VDD VDD pmos W=0.205u L=0.04u
M3431 U3786/net19 n3874 VSS VSS nmos W=0.155u L=0.04u
M3432 n3781 n3874 U3786/net40 VSS nmos W=0.155u L=0.04u
M3433 n3781 U3786/net19 U3786/net36 VSS nmos W=0.155u L=0.04u
M3434 U3786/net40 n3857 VSS VSS nmos W=0.31u L=0.04u
M3435 U3786/net36 g2775 VSS VSS nmos W=0.155u L=0.04u
M3436 U3786/net19 n3874 VDD VDD pmos W=0.205u L=0.04u
M3437 n3781 U3786/net19 U3786/net26 VDD pmos W=0.325u L=0.04u
M3438 U3786/net26 n3857 VDD VDD pmos W=0.41u L=0.04u
M3439 n3781 n3874 U3786/net30 VDD pmos W=0.325u L=0.04u
M3440 U3786/net30 g2775 VDD VDD pmos W=0.205u L=0.04u
M3441 U3787/net19 n3874 VSS VSS nmos W=0.155u L=0.04u
M3442 n3780 n3874 U3787/net40 VSS nmos W=0.155u L=0.04u
M3443 n3780 U3787/net19 U3787/net36 VSS nmos W=0.155u L=0.04u
M3444 U3787/net40 n3880 VSS VSS nmos W=0.31u L=0.04u
M3445 U3787/net36 g2778 VSS VSS nmos W=0.155u L=0.04u
M3446 U3787/net19 n3874 VDD VDD pmos W=0.205u L=0.04u
M3447 n3780 U3787/net19 U3787/net26 VDD pmos W=0.325u L=0.04u
M3448 U3787/net26 n3880 VDD VDD pmos W=0.41u L=0.04u
M3449 n3780 n3874 U3787/net30 VDD pmos W=0.325u L=0.04u
M3450 U3787/net30 g2778 VDD VDD pmos W=0.205u L=0.04u
M3451 U3788/net19 n3874 VSS VSS nmos W=0.155u L=0.04u
M3452 n3779 n3874 U3788/net40 VSS nmos W=0.155u L=0.04u
M3453 n3779 U3788/net19 U3788/net36 VSS nmos W=0.155u L=0.04u
M3454 U3788/net40 n3861 VSS VSS nmos W=0.31u L=0.04u
M3455 U3788/net36 g2781 VSS VSS nmos W=0.155u L=0.04u
M3456 U3788/net19 n3874 VDD VDD pmos W=0.205u L=0.04u
M3457 n3779 U3788/net19 U3788/net26 VDD pmos W=0.325u L=0.04u
M3458 U3788/net26 n3861 VDD VDD pmos W=0.41u L=0.04u
M3459 n3779 n3874 U3788/net30 VDD pmos W=0.325u L=0.04u
M3460 U3788/net30 g2781 VDD VDD pmos W=0.205u L=0.04u
M3461 U3789/net19 n3874 VSS VSS nmos W=0.155u L=0.04u
M3462 n3778 n3874 U3789/net40 VSS nmos W=0.155u L=0.04u
M3463 n3778 U3789/net19 U3789/net36 VSS nmos W=0.155u L=0.04u
M3464 U3789/net40 n3881 VSS VSS nmos W=0.31u L=0.04u
M3465 U3789/net36 g2784 VSS VSS nmos W=0.155u L=0.04u
M3466 U3789/net19 n3874 VDD VDD pmos W=0.205u L=0.04u
M3467 n3778 U3789/net19 U3789/net26 VDD pmos W=0.325u L=0.04u
M3468 U3789/net26 n3881 VDD VDD pmos W=0.41u L=0.04u
M3469 n3778 n3874 U3789/net30 VDD pmos W=0.325u L=0.04u
M3470 U3789/net30 g2784 VDD VDD pmos W=0.205u L=0.04u
M3471 U3790/net19 n3874 VSS VSS nmos W=0.155u L=0.04u
M3472 n3777 n3874 U3790/net40 VSS nmos W=0.155u L=0.04u
M3473 n3777 U3790/net19 U3790/net36 VSS nmos W=0.155u L=0.04u
M3474 U3790/net40 n3864 VSS VSS nmos W=0.31u L=0.04u
M3475 U3790/net36 g2787 VSS VSS nmos W=0.155u L=0.04u
M3476 U3790/net19 n3874 VDD VDD pmos W=0.205u L=0.04u
M3477 n3777 U3790/net19 U3790/net26 VDD pmos W=0.325u L=0.04u
M3478 U3790/net26 n3864 VDD VDD pmos W=0.41u L=0.04u
M3479 n3777 n3874 U3790/net30 VDD pmos W=0.325u L=0.04u
M3480 U3790/net30 g2787 VDD VDD pmos W=0.205u L=0.04u
M3481 U3791/net19 n3874 VSS VSS nmos W=0.155u L=0.04u
M3482 n3776 n3874 U3791/net40 VSS nmos W=0.155u L=0.04u
M3483 n3776 U3791/net19 U3791/net36 VSS nmos W=0.155u L=0.04u
M3484 U3791/net40 n3882 VSS VSS nmos W=0.31u L=0.04u
M3485 U3791/net36 g2790 VSS VSS nmos W=0.155u L=0.04u
M3486 U3791/net19 n3874 VDD VDD pmos W=0.205u L=0.04u
M3487 n3776 U3791/net19 U3791/net26 VDD pmos W=0.325u L=0.04u
M3488 U3791/net26 n3882 VDD VDD pmos W=0.41u L=0.04u
M3489 n3776 n3874 U3791/net30 VDD pmos W=0.325u L=0.04u
M3490 U3791/net30 g2790 VDD VDD pmos W=0.205u L=0.04u
M3491 U3792/net19 n3874 VSS VSS nmos W=0.155u L=0.04u
M3492 n3775 n3874 U3792/net40 VSS nmos W=0.155u L=0.04u
M3493 n3775 U3792/net19 U3792/net36 VSS nmos W=0.155u L=0.04u
M3494 U3792/net40 n3883 VSS VSS nmos W=0.31u L=0.04u
M3495 U3792/net36 g2808 VSS VSS nmos W=0.155u L=0.04u
M3496 U3792/net19 n3874 VDD VDD pmos W=0.205u L=0.04u
M3497 n3775 U3792/net19 U3792/net26 VDD pmos W=0.325u L=0.04u
M3498 U3792/net26 n3883 VDD VDD pmos W=0.41u L=0.04u
M3499 n3775 n3874 U3792/net30 VDD pmos W=0.325u L=0.04u
M3500 U3792/net30 g2808 VDD VDD pmos W=0.205u L=0.04u
M3501 U3793/net19 n3874 VSS VSS nmos W=0.155u L=0.04u
M3502 n3774 n3874 U3793/net40 VSS nmos W=0.155u L=0.04u
M3503 n3774 U3793/net19 U3793/net36 VSS nmos W=0.155u L=0.04u
M3504 U3793/net40 n3884 VSS VSS nmos W=0.31u L=0.04u
M3505 U3793/net36 g2793 VSS VSS nmos W=0.155u L=0.04u
M3506 U3793/net19 n3874 VDD VDD pmos W=0.205u L=0.04u
M3507 n3774 U3793/net19 U3793/net26 VDD pmos W=0.325u L=0.04u
M3508 U3793/net26 n3884 VDD VDD pmos W=0.41u L=0.04u
M3509 n3774 n3874 U3793/net30 VDD pmos W=0.325u L=0.04u
M3510 U3793/net30 g2793 VDD VDD pmos W=0.205u L=0.04u
M3511 U3794/net19 n3874 VSS VSS nmos W=0.155u L=0.04u
M3512 n3773 n3874 U3794/net40 VSS nmos W=0.155u L=0.04u
M3513 n3773 U3794/net19 U3794/net36 VSS nmos W=0.155u L=0.04u
M3514 U3794/net40 n3873 VSS VSS nmos W=0.31u L=0.04u
M3515 U3794/net36 g2796 VSS VSS nmos W=0.155u L=0.04u
M3516 U3794/net19 n3874 VDD VDD pmos W=0.205u L=0.04u
M3517 n3773 U3794/net19 U3794/net26 VDD pmos W=0.325u L=0.04u
M3518 U3794/net26 n3873 VDD VDD pmos W=0.41u L=0.04u
M3519 n3773 n3874 U3794/net30 VDD pmos W=0.325u L=0.04u
M3520 U3794/net30 g2796 VDD VDD pmos W=0.205u L=0.04u
M3521 n3874 n3885 VSS VSS nmos W=0.155u L=0.04u
M3522 n3874 n3853 VSS VSS nmos W=0.155u L=0.04u
M3523 U3795/XI1-net8 n3853 VDD VDD pmos W=0.205u L=0.04u
M3524 n3874 n3885 U3795/XI1-net8 VDD pmos W=0.205u L=0.04u
M3525 U3796/net19 n3876 VSS VSS nmos W=0.155u L=0.04u
M3526 n3772 n3876 U3796/net40 VSS nmos W=0.155u L=0.04u
M3527 n3772 U3796/net19 U3796/net36 VSS nmos W=0.155u L=0.04u
M3528 U3796/net40 n3879 VSS VSS nmos W=0.31u L=0.04u
M3529 U3796/net36 g2774 VSS VSS nmos W=0.155u L=0.04u
M3530 U3796/net19 n3876 VDD VDD pmos W=0.205u L=0.04u
M3531 n3772 U3796/net19 U3796/net26 VDD pmos W=0.325u L=0.04u
M3532 U3796/net26 n3879 VDD VDD pmos W=0.41u L=0.04u
M3533 n3772 n3876 U3796/net30 VDD pmos W=0.325u L=0.04u
M3534 U3796/net30 g2774 VDD VDD pmos W=0.205u L=0.04u
M3535 U3797/net19 n3876 VSS VSS nmos W=0.155u L=0.04u
M3536 n3771 n3876 U3797/net40 VSS nmos W=0.155u L=0.04u
M3537 n3771 U3797/net19 U3797/net36 VSS nmos W=0.155u L=0.04u
M3538 U3797/net40 n3871 VSS VSS nmos W=0.31u L=0.04u
M3539 U3797/net36 g2801 VSS VSS nmos W=0.155u L=0.04u
M3540 U3797/net19 n3876 VDD VDD pmos W=0.205u L=0.04u
M3541 n3771 U3797/net19 U3797/net26 VDD pmos W=0.325u L=0.04u
M3542 U3797/net26 n3871 VDD VDD pmos W=0.41u L=0.04u
M3543 n3771 n3876 U3797/net30 VDD pmos W=0.325u L=0.04u
M3544 U3797/net30 g2801 VDD VDD pmos W=0.205u L=0.04u
M3545 U3798/net19 n3877 VSS VSS nmos W=0.155u L=0.04u
M3546 n3770 n3877 U3798/net40 VSS nmos W=0.155u L=0.04u
M3547 n3770 U3798/net19 U3798/net36 VSS nmos W=0.155u L=0.04u
M3548 U3798/net40 n3879 VSS VSS nmos W=0.31u L=0.04u
M3549 U3798/net36 g2773 VSS VSS nmos W=0.155u L=0.04u
M3550 U3798/net19 n3877 VDD VDD pmos W=0.205u L=0.04u
M3551 n3770 U3798/net19 U3798/net26 VDD pmos W=0.325u L=0.04u
M3552 U3798/net26 n3879 VDD VDD pmos W=0.41u L=0.04u
M3553 n3770 n3877 U3798/net30 VDD pmos W=0.325u L=0.04u
M3554 U3798/net30 g2773 VDD VDD pmos W=0.205u L=0.04u
M3555 U3799/net19 n3876 VSS VSS nmos W=0.155u L=0.04u
M3556 n3769 n3876 U3799/net40 VSS nmos W=0.155u L=0.04u
M3557 n3769 U3799/net19 U3799/net36 VSS nmos W=0.155u L=0.04u
M3558 U3799/net40 n3857 VSS VSS nmos W=0.31u L=0.04u
M3559 U3799/net36 g2777 VSS VSS nmos W=0.155u L=0.04u
M3560 U3799/net19 n3876 VDD VDD pmos W=0.205u L=0.04u
M3561 n3769 U3799/net19 U3799/net26 VDD pmos W=0.325u L=0.04u
M3562 U3799/net26 n3857 VDD VDD pmos W=0.41u L=0.04u
M3563 n3769 n3876 U3799/net30 VDD pmos W=0.325u L=0.04u
M3564 U3799/net30 g2777 VDD VDD pmos W=0.205u L=0.04u
M3565 U3800/net19 n3877 VSS VSS nmos W=0.155u L=0.04u
M3566 n3768 n3877 U3800/net40 VSS nmos W=0.155u L=0.04u
M3567 n3768 U3800/net19 U3800/net36 VSS nmos W=0.155u L=0.04u
M3568 U3800/net40 n3871 VSS VSS nmos W=0.31u L=0.04u
M3569 U3800/net36 g2800 VSS VSS nmos W=0.155u L=0.04u
M3570 U3800/net19 n3877 VDD VDD pmos W=0.205u L=0.04u
M3571 n3768 U3800/net19 U3800/net26 VDD pmos W=0.325u L=0.04u
M3572 U3800/net26 n3871 VDD VDD pmos W=0.41u L=0.04u
M3573 n3768 n3877 U3800/net30 VDD pmos W=0.325u L=0.04u
M3574 U3800/net30 g2800 VDD VDD pmos W=0.205u L=0.04u
M3575 n3871 g2766 VSS VSS nmos W=0.135u L=0.04u
M3576 n3871 g2766 VDD VDD pmos W=0.205u L=0.04u
M3577 U3802/net19 n3877 VSS VSS nmos W=0.155u L=0.04u
M3578 n3767 n3877 U3802/net40 VSS nmos W=0.155u L=0.04u
M3579 n3767 U3802/net19 U3802/net36 VSS nmos W=0.155u L=0.04u
M3580 U3802/net40 n3857 VSS VSS nmos W=0.31u L=0.04u
M3581 U3802/net36 g2776 VSS VSS nmos W=0.155u L=0.04u
M3582 U3802/net19 n3877 VDD VDD pmos W=0.205u L=0.04u
M3583 n3767 U3802/net19 U3802/net26 VDD pmos W=0.325u L=0.04u
M3584 U3802/net26 n3857 VDD VDD pmos W=0.41u L=0.04u
M3585 n3767 n3877 U3802/net30 VDD pmos W=0.325u L=0.04u
M3586 U3802/net30 g2776 VDD VDD pmos W=0.205u L=0.04u
M3587 n3857 g2707 VSS VSS nmos W=0.135u L=0.04u
M3588 n3857 g2707 VDD VDD pmos W=0.205u L=0.04u
M3589 U3804/net19 n3876 VSS VSS nmos W=0.155u L=0.04u
M3590 n3766 n3876 U3804/net40 VSS nmos W=0.155u L=0.04u
M3591 n3766 U3804/net19 U3804/net36 VSS nmos W=0.155u L=0.04u
M3592 U3804/net40 n3880 VSS VSS nmos W=0.31u L=0.04u
M3593 U3804/net36 g2780 VSS VSS nmos W=0.155u L=0.04u
M3594 U3804/net19 n3876 VDD VDD pmos W=0.205u L=0.04u
M3595 n3766 U3804/net19 U3804/net26 VDD pmos W=0.325u L=0.04u
M3596 U3804/net26 n3880 VDD VDD pmos W=0.41u L=0.04u
M3597 n3766 n3876 U3804/net30 VDD pmos W=0.325u L=0.04u
M3598 U3804/net30 g2780 VDD VDD pmos W=0.205u L=0.04u
M3599 U3805/net19 n3877 VSS VSS nmos W=0.155u L=0.04u
M3600 n3765 n3877 U3805/net40 VSS nmos W=0.155u L=0.04u
M3601 n3765 U3805/net19 U3805/net36 VSS nmos W=0.155u L=0.04u
M3602 U3805/net40 n3880 VSS VSS nmos W=0.31u L=0.04u
M3603 U3805/net36 g2779 VSS VSS nmos W=0.155u L=0.04u
M3604 U3805/net19 n3877 VDD VDD pmos W=0.205u L=0.04u
M3605 n3765 U3805/net19 U3805/net26 VDD pmos W=0.325u L=0.04u
M3606 U3805/net26 n3880 VDD VDD pmos W=0.41u L=0.04u
M3607 n3765 n3877 U3805/net30 VDD pmos W=0.325u L=0.04u
M3608 U3805/net30 g2779 VDD VDD pmos W=0.205u L=0.04u
M3609 n3880 g2727 VSS VSS nmos W=0.135u L=0.04u
M3610 n3880 g2727 VDD VDD pmos W=0.205u L=0.04u
M3611 U3807/net19 n3876 VSS VSS nmos W=0.155u L=0.04u
M3612 n3764 n3876 U3807/net40 VSS nmos W=0.155u L=0.04u
M3613 n3764 U3807/net19 U3807/net36 VSS nmos W=0.155u L=0.04u
M3614 U3807/net40 n3861 VSS VSS nmos W=0.31u L=0.04u
M3615 U3807/net36 g2783 VSS VSS nmos W=0.155u L=0.04u
M3616 U3807/net19 n3876 VDD VDD pmos W=0.205u L=0.04u
M3617 n3764 U3807/net19 U3807/net26 VDD pmos W=0.325u L=0.04u
M3618 U3807/net26 n3861 VDD VDD pmos W=0.41u L=0.04u
M3619 n3764 n3876 U3807/net30 VDD pmos W=0.325u L=0.04u
M3620 U3807/net30 g2783 VDD VDD pmos W=0.205u L=0.04u
M3621 U3808/net19 n3877 VSS VSS nmos W=0.155u L=0.04u
M3622 n3763 n3877 U3808/net40 VSS nmos W=0.155u L=0.04u
M3623 n3763 U3808/net19 U3808/net36 VSS nmos W=0.155u L=0.04u
M3624 U3808/net40 n3861 VSS VSS nmos W=0.31u L=0.04u
M3625 U3808/net36 g2782 VSS VSS nmos W=0.155u L=0.04u
M3626 U3808/net19 n3877 VDD VDD pmos W=0.205u L=0.04u
M3627 n3763 U3808/net19 U3808/net26 VDD pmos W=0.325u L=0.04u
M3628 U3808/net26 n3861 VDD VDD pmos W=0.41u L=0.04u
M3629 n3763 n3877 U3808/net30 VDD pmos W=0.325u L=0.04u
M3630 U3808/net30 g2782 VDD VDD pmos W=0.205u L=0.04u
M3631 n3861 g2720 VSS VSS nmos W=0.135u L=0.04u
M3632 n3861 g2720 VDD VDD pmos W=0.205u L=0.04u
M3633 U3810/net19 n3876 VSS VSS nmos W=0.155u L=0.04u
M3634 n3762 n3876 U3810/net40 VSS nmos W=0.155u L=0.04u
M3635 n3762 U3810/net19 U3810/net36 VSS nmos W=0.155u L=0.04u
M3636 U3810/net40 n3881 VSS VSS nmos W=0.31u L=0.04u
M3637 U3810/net36 g2786 VSS VSS nmos W=0.155u L=0.04u
M3638 U3810/net19 n3876 VDD VDD pmos W=0.205u L=0.04u
M3639 n3762 U3810/net19 U3810/net26 VDD pmos W=0.325u L=0.04u
M3640 U3810/net26 n3881 VDD VDD pmos W=0.41u L=0.04u
M3641 n3762 n3876 U3810/net30 VDD pmos W=0.325u L=0.04u
M3642 U3810/net30 g2786 VDD VDD pmos W=0.205u L=0.04u
M3643 U3811/net19 n3877 VSS VSS nmos W=0.155u L=0.04u
M3644 n3761 n3877 U3811/net40 VSS nmos W=0.155u L=0.04u
M3645 n3761 U3811/net19 U3811/net36 VSS nmos W=0.155u L=0.04u
M3646 U3811/net40 n3881 VSS VSS nmos W=0.31u L=0.04u
M3647 U3811/net36 g2785 VSS VSS nmos W=0.155u L=0.04u
M3648 U3811/net19 n3877 VDD VDD pmos W=0.205u L=0.04u
M3649 n3761 U3811/net19 U3811/net26 VDD pmos W=0.325u L=0.04u
M3650 U3811/net26 n3881 VDD VDD pmos W=0.41u L=0.04u
M3651 n3761 n3877 U3811/net30 VDD pmos W=0.325u L=0.04u
M3652 U3811/net30 g2785 VDD VDD pmos W=0.205u L=0.04u
M3653 n3881 g2734 VSS VSS nmos W=0.135u L=0.04u
M3654 n3881 g2734 VDD VDD pmos W=0.205u L=0.04u
M3655 U3813/net19 n3876 VSS VSS nmos W=0.155u L=0.04u
M3656 n3760 n3876 U3813/net40 VSS nmos W=0.155u L=0.04u
M3657 n3760 U3813/net19 U3813/net36 VSS nmos W=0.155u L=0.04u
M3658 U3813/net40 n3864 VSS VSS nmos W=0.31u L=0.04u
M3659 U3813/net36 g2789 VSS VSS nmos W=0.155u L=0.04u
M3660 U3813/net19 n3876 VDD VDD pmos W=0.205u L=0.04u
M3661 n3760 U3813/net19 U3813/net26 VDD pmos W=0.325u L=0.04u
M3662 U3813/net26 n3864 VDD VDD pmos W=0.41u L=0.04u
M3663 n3760 n3876 U3813/net30 VDD pmos W=0.325u L=0.04u
M3664 U3813/net30 g2789 VDD VDD pmos W=0.205u L=0.04u
M3665 U3814/net19 n3877 VSS VSS nmos W=0.155u L=0.04u
M3666 n3759 n3877 U3814/net40 VSS nmos W=0.155u L=0.04u
M3667 n3759 U3814/net19 U3814/net36 VSS nmos W=0.155u L=0.04u
M3668 U3814/net40 n3864 VSS VSS nmos W=0.31u L=0.04u
M3669 U3814/net36 g2788 VSS VSS nmos W=0.155u L=0.04u
M3670 U3814/net19 n3877 VDD VDD pmos W=0.205u L=0.04u
M3671 n3759 U3814/net19 U3814/net26 VDD pmos W=0.325u L=0.04u
M3672 U3814/net26 n3864 VDD VDD pmos W=0.41u L=0.04u
M3673 n3759 n3877 U3814/net30 VDD pmos W=0.325u L=0.04u
M3674 U3814/net30 g2788 VDD VDD pmos W=0.205u L=0.04u
M3675 U3815/net19 n3876 VSS VSS nmos W=0.155u L=0.04u
M3676 n3758 n3876 U3815/net40 VSS nmos W=0.155u L=0.04u
M3677 n3758 U3815/net19 U3815/net36 VSS nmos W=0.155u L=0.04u
M3678 U3815/net40 n3882 VSS VSS nmos W=0.31u L=0.04u
M3679 U3815/net36 g2792 VSS VSS nmos W=0.155u L=0.04u
M3680 U3815/net19 n3876 VDD VDD pmos W=0.205u L=0.04u
M3681 n3758 U3815/net19 U3815/net26 VDD pmos W=0.325u L=0.04u
M3682 U3815/net26 n3882 VDD VDD pmos W=0.41u L=0.04u
M3683 n3758 n3876 U3815/net30 VDD pmos W=0.325u L=0.04u
M3684 U3815/net30 g2792 VDD VDD pmos W=0.205u L=0.04u
M3685 U3816/net19 n3876 VSS VSS nmos W=0.155u L=0.04u
M3686 n3757 n3876 U3816/net40 VSS nmos W=0.155u L=0.04u
M3687 n3757 U3816/net19 U3816/net36 VSS nmos W=0.155u L=0.04u
M3688 U3816/net40 n3883 VSS VSS nmos W=0.31u L=0.04u
M3689 U3816/net36 g2810 VSS VSS nmos W=0.155u L=0.04u
M3690 U3816/net19 n3876 VDD VDD pmos W=0.205u L=0.04u
M3691 n3757 U3816/net19 U3816/net26 VDD pmos W=0.325u L=0.04u
M3692 U3816/net26 n3883 VDD VDD pmos W=0.41u L=0.04u
M3693 n3757 n3876 U3816/net30 VDD pmos W=0.325u L=0.04u
M3694 U3816/net30 g2810 VDD VDD pmos W=0.205u L=0.04u
M3695 U3817/net19 n3877 VSS VSS nmos W=0.155u L=0.04u
M3696 n3756 n3877 U3817/net40 VSS nmos W=0.155u L=0.04u
M3697 n3756 U3817/net19 U3817/net36 VSS nmos W=0.155u L=0.04u
M3698 U3817/net40 n3882 VSS VSS nmos W=0.31u L=0.04u
M3699 U3817/net36 g2791 VSS VSS nmos W=0.155u L=0.04u
M3700 U3817/net19 n3877 VDD VDD pmos W=0.205u L=0.04u
M3701 n3756 U3817/net19 U3817/net26 VDD pmos W=0.325u L=0.04u
M3702 U3817/net26 n3882 VDD VDD pmos W=0.41u L=0.04u
M3703 n3756 n3877 U3817/net30 VDD pmos W=0.325u L=0.04u
M3704 U3817/net30 g2791 VDD VDD pmos W=0.205u L=0.04u
M3705 U3818/net19 n3876 VSS VSS nmos W=0.155u L=0.04u
M3706 n3755 n3876 U3818/net40 VSS nmos W=0.155u L=0.04u
M3707 n3755 U3818/net19 U3818/net36 VSS nmos W=0.155u L=0.04u
M3708 U3818/net40 n3884 VSS VSS nmos W=0.31u L=0.04u
M3709 U3818/net36 g2795 VSS VSS nmos W=0.155u L=0.04u
M3710 U3818/net19 n3876 VDD VDD pmos W=0.205u L=0.04u
M3711 n3755 U3818/net19 U3818/net26 VDD pmos W=0.325u L=0.04u
M3712 U3818/net26 n3884 VDD VDD pmos W=0.41u L=0.04u
M3713 n3755 n3876 U3818/net30 VDD pmos W=0.325u L=0.04u
M3714 U3818/net30 g2795 VDD VDD pmos W=0.205u L=0.04u
M3715 U3819/net19 n3877 VSS VSS nmos W=0.155u L=0.04u
M3716 n3754 n3877 U3819/net40 VSS nmos W=0.155u L=0.04u
M3717 n3754 U3819/net19 U3819/net36 VSS nmos W=0.155u L=0.04u
M3718 U3819/net40 n3883 VSS VSS nmos W=0.31u L=0.04u
M3719 U3819/net36 g2809 VSS VSS nmos W=0.155u L=0.04u
M3720 U3819/net19 n3877 VDD VDD pmos W=0.205u L=0.04u
M3721 n3754 U3819/net19 U3819/net26 VDD pmos W=0.325u L=0.04u
M3722 U3819/net26 n3883 VDD VDD pmos W=0.41u L=0.04u
M3723 n3754 n3877 U3819/net30 VDD pmos W=0.325u L=0.04u
M3724 U3819/net30 g2809 VDD VDD pmos W=0.205u L=0.04u
M3725 U3820/net36 n3887 U3820/net24 VSS nmos W=0.155u L=0.04u
M3726 U3820/net24 n3888 VSS VSS nmos W=0.155u L=0.04u
M3727 U3820/net33 g2803 U3820/net36 VSS nmos W=0.155u L=0.04u
M3728 U3820/net33 n3886 U3820/net36 VSS nmos W=0.155u L=0.04u
M3729 n3883 U3820/net33 VSS VSS nmos W=0.155u L=0.04u
M3730 n3883 U3820/net33 VDD VDD pmos W=0.205u L=0.04u
M3731 U3820/net33 n3886 U3820/net35 VDD pmos W=0.205u L=0.04u
M3732 U3820/net35 g2803 VDD VDD pmos W=0.205u L=0.04u
M3733 U3820/net33 n3888 VDD VDD pmos W=0.205u L=0.04u
M3734 U3820/net33 n3887 VDD VDD pmos W=0.205u L=0.04u
M3735 n3888 g2703 U3821/XI21-net17 VSS nmos W=0.155u L=0.04u
M3736 U3821/XI21-net17 n3892 VSS VSS nmos W=0.155u L=0.04u
M3737 n3888 n3889 U3821/XI6-net17 VSS nmos W=0.155u L=0.04u
M3738 U3821/XI6-net17 n3890 VSS VSS nmos W=0.155u L=0.04u
M3739 n3888 g7487 U3821/XI20-net17 VSS nmos W=0.155u L=0.04u
M3740 U3821/XI20-net17 n3891 VSS VSS nmos W=0.155u L=0.04u
M3741 VDD g2703 U3821/net22 VDD pmos W=0.205u L=0.04u
M3742 VDD n3892 U3821/net22 VDD pmos W=0.205u L=0.04u
M3743 U3821/net16 n3889 n3888 VDD pmos W=0.205u L=0.04u
M3744 U3821/net16 n3890 n3888 VDD pmos W=0.205u L=0.04u
M3745 U3821/net22 g7487 U3821/net16 VDD pmos W=0.205u L=0.04u
M3746 U3821/net22 n3891 U3821/net16 VDD pmos W=0.205u L=0.04u
M3747 n3892 g2802 VSS VSS nmos W=0.135u L=0.04u
M3748 n3892 g2802 VDD VDD pmos W=0.205u L=0.04u
M3749 n3891 g2804 VSS VSS nmos W=0.135u L=0.04u
M3750 n3891 g2804 VDD VDD pmos W=0.205u L=0.04u
M3751 n3890 n3896 VSS VSS nmos W=0.155u L=0.04u
M3752 n3890 n3895 VSS VSS nmos W=0.155u L=0.04u
M3753 n3890 n3894 VSS VSS nmos W=0.155u L=0.04u
M3754 n3890 n3893 VSS VSS nmos W=0.155u L=0.04u
M3755 U3824/net49 n3895 U3824/net52 VDD pmos W=0.41u L=0.04u
M3756 U3824/net52 n3896 VDD VDD pmos W=0.41u L=0.04u
M3757 U3824/net46 n3894 U3824/net49 VDD pmos W=0.41u L=0.04u
M3758 n3890 n3893 U3824/net46 VDD pmos W=0.41u L=0.04u
M3759 U3825/net4 n3897 U3825/net14 VSS nmos W=0.155u L=0.04u
M3760 U3825/net6 U3825/net10 U3825/net14 VSS nmos W=0.17u L=0.04u
M3761 U3825/net4 g2760 VSS VSS nmos W=0.155u L=0.04u
M3762 U3825/net6 U3825/net4 VSS VSS nmos W=0.17u L=0.04u
M3763 n3896 U3825/net14 VSS VSS nmos W=0.155u L=0.04u
M3764 U3825/net10 n3897 VSS VSS nmos W=0.155u L=0.04u
M3765 U3825/net4 U3825/net10 U3825/net14 VDD pmos W=0.255u L=0.04u
M3766 U3825/net6 n3897 U3825/net14 VDD pmos W=0.28u L=0.04u
M3767 U3825/net4 g2760 VDD VDD pmos W=0.205u L=0.04u
M3768 U3825/net6 U3825/net4 VDD VDD pmos W=0.24u L=0.04u
M3769 n3896 U3825/net14 VDD VDD pmos W=0.205u L=0.04u
M3770 U3825/net10 n3897 VDD VDD pmos W=0.205u L=0.04u
M3771 U3826/net4 n3898 U3826/net14 VSS nmos W=0.155u L=0.04u
M3772 U3826/net6 U3826/net10 U3826/net14 VSS nmos W=0.17u L=0.04u
M3773 U3826/net4 g2766 VSS VSS nmos W=0.155u L=0.04u
M3774 U3826/net6 U3826/net4 VSS VSS nmos W=0.17u L=0.04u
M3775 n3895 U3826/net14 VSS VSS nmos W=0.155u L=0.04u
M3776 U3826/net10 n3898 VSS VSS nmos W=0.155u L=0.04u
M3777 U3826/net4 U3826/net10 U3826/net14 VDD pmos W=0.255u L=0.04u
M3778 U3826/net6 n3898 U3826/net14 VDD pmos W=0.28u L=0.04u
M3779 U3826/net4 g2766 VDD VDD pmos W=0.205u L=0.04u
M3780 U3826/net6 U3826/net4 VDD VDD pmos W=0.24u L=0.04u
M3781 n3895 U3826/net14 VDD VDD pmos W=0.205u L=0.04u
M3782 U3826/net10 n3898 VDD VDD pmos W=0.205u L=0.04u
M3783 U3827/net4 n3899 U3827/net14 VSS nmos W=0.155u L=0.04u
M3784 U3827/net6 U3827/net10 U3827/net14 VSS nmos W=0.17u L=0.04u
M3785 U3827/net4 g2727 VSS VSS nmos W=0.155u L=0.04u
M3786 U3827/net6 U3827/net4 VSS VSS nmos W=0.17u L=0.04u
M3787 n3894 U3827/net14 VSS VSS nmos W=0.155u L=0.04u
M3788 U3827/net10 n3899 VSS VSS nmos W=0.155u L=0.04u
M3789 U3827/net4 U3827/net10 U3827/net14 VDD pmos W=0.255u L=0.04u
M3790 U3827/net6 n3899 U3827/net14 VDD pmos W=0.28u L=0.04u
M3791 U3827/net4 g2727 VDD VDD pmos W=0.205u L=0.04u
M3792 U3827/net6 U3827/net4 VDD VDD pmos W=0.24u L=0.04u
M3793 n3894 U3827/net14 VDD VDD pmos W=0.205u L=0.04u
M3794 U3827/net10 n3899 VDD VDD pmos W=0.205u L=0.04u
M3795 U3828/XU1-net6 n3901 VSS VSS nmos W=0.155u L=0.04u
M3796 n3893 n3900 U3828/XU1-net6 VSS nmos W=0.155u L=0.04u
M3797 n3893 n3901 VDD VDD pmos W=0.155u L=0.04u
M3798 n3893 n3900 VDD VDD pmos W=0.155u L=0.04u
M3799 U3829/net4 g2707 U3829/net14 VSS nmos W=0.155u L=0.04u
M3800 U3829/net6 U3829/net10 U3829/net14 VSS nmos W=0.17u L=0.04u
M3801 U3829/net4 n3902 VSS VSS nmos W=0.155u L=0.04u
M3802 U3829/net6 U3829/net4 VSS VSS nmos W=0.17u L=0.04u
M3803 n3901 U3829/net14 VSS VSS nmos W=0.155u L=0.04u
M3804 U3829/net10 g2707 VSS VSS nmos W=0.155u L=0.04u
M3805 U3829/net4 U3829/net10 U3829/net14 VDD pmos W=0.255u L=0.04u
M3806 U3829/net6 g2707 U3829/net14 VDD pmos W=0.28u L=0.04u
M3807 U3829/net4 n3902 VDD VDD pmos W=0.205u L=0.04u
M3808 U3829/net6 U3829/net4 VDD VDD pmos W=0.24u L=0.04u
M3809 n3901 U3829/net14 VDD VDD pmos W=0.205u L=0.04u
M3810 U3829/net10 g2707 VDD VDD pmos W=0.205u L=0.04u
M3811 U3830/net4 g2720 U3830/net14 VSS nmos W=0.155u L=0.04u
M3812 U3830/net6 U3830/net10 U3830/net14 VSS nmos W=0.17u L=0.04u
M3813 U3830/net4 n3903 VSS VSS nmos W=0.155u L=0.04u
M3814 U3830/net6 U3830/net4 VSS VSS nmos W=0.17u L=0.04u
M3815 n3900 U3830/net14 VSS VSS nmos W=0.155u L=0.04u
M3816 U3830/net10 g2720 VSS VSS nmos W=0.155u L=0.04u
M3817 U3830/net4 U3830/net10 U3830/net14 VDD pmos W=0.255u L=0.04u
M3818 U3830/net6 g2720 U3830/net14 VDD pmos W=0.28u L=0.04u
M3819 U3830/net4 n3903 VDD VDD pmos W=0.205u L=0.04u
M3820 U3830/net6 U3830/net4 VDD VDD pmos W=0.24u L=0.04u
M3821 n3900 U3830/net14 VDD VDD pmos W=0.205u L=0.04u
M3822 U3830/net10 g2720 VDD VDD pmos W=0.205u L=0.04u
M3823 n3889 n3907 VSS VSS nmos W=0.155u L=0.04u
M3824 n3889 n3906 VSS VSS nmos W=0.155u L=0.04u
M3825 n3889 n3905 VSS VSS nmos W=0.155u L=0.04u
M3826 n3889 n3904 VSS VSS nmos W=0.155u L=0.04u
M3827 U3831/net49 n3906 U3831/net52 VDD pmos W=0.41u L=0.04u
M3828 U3831/net52 n3907 VDD VDD pmos W=0.41u L=0.04u
M3829 U3831/net46 n3905 U3831/net49 VDD pmos W=0.41u L=0.04u
M3830 n3889 n3904 U3831/net46 VDD pmos W=0.41u L=0.04u
M3831 U3832/net4 n3908 U3832/net14 VSS nmos W=0.155u L=0.04u
M3832 U3832/net6 U3832/net10 U3832/net14 VSS nmos W=0.17u L=0.04u
M3833 U3832/net4 n3882 VSS VSS nmos W=0.155u L=0.04u
M3834 U3832/net6 U3832/net4 VSS VSS nmos W=0.17u L=0.04u
M3835 n3907 U3832/net14 VSS VSS nmos W=0.155u L=0.04u
M3836 U3832/net10 n3908 VSS VSS nmos W=0.155u L=0.04u
M3837 U3832/net4 U3832/net10 U3832/net14 VDD pmos W=0.255u L=0.04u
M3838 U3832/net6 n3908 U3832/net14 VDD pmos W=0.28u L=0.04u
M3839 U3832/net4 n3882 VDD VDD pmos W=0.205u L=0.04u
M3840 U3832/net6 U3832/net4 VDD VDD pmos W=0.24u L=0.04u
M3841 n3907 U3832/net14 VDD VDD pmos W=0.205u L=0.04u
M3842 U3832/net10 n3908 VDD VDD pmos W=0.205u L=0.04u
M3843 n3882 g2740 VSS VSS nmos W=0.135u L=0.04u
M3844 n3882 g2740 VDD VDD pmos W=0.205u L=0.04u
M3845 U3834/net4 n3909 U3834/net14 VSS nmos W=0.155u L=0.04u
M3846 U3834/net6 U3834/net10 U3834/net14 VSS nmos W=0.17u L=0.04u
M3847 U3834/net4 n3884 VSS VSS nmos W=0.155u L=0.04u
M3848 U3834/net6 U3834/net4 VSS VSS nmos W=0.17u L=0.04u
M3849 n3906 U3834/net14 VSS VSS nmos W=0.155u L=0.04u
M3850 U3834/net10 n3909 VSS VSS nmos W=0.155u L=0.04u
M3851 U3834/net4 U3834/net10 U3834/net14 VDD pmos W=0.255u L=0.04u
M3852 U3834/net6 n3909 U3834/net14 VDD pmos W=0.28u L=0.04u
M3853 U3834/net4 n3884 VDD VDD pmos W=0.205u L=0.04u
M3854 U3834/net6 U3834/net4 VDD VDD pmos W=0.24u L=0.04u
M3855 n3906 U3834/net14 VDD VDD pmos W=0.205u L=0.04u
M3856 U3834/net10 n3909 VDD VDD pmos W=0.205u L=0.04u
M3857 U3835/net4 n3910 U3835/net14 VSS nmos W=0.155u L=0.04u
M3858 U3835/net6 U3835/net10 U3835/net14 VSS nmos W=0.17u L=0.04u
M3859 U3835/net4 g2734 VSS VSS nmos W=0.155u L=0.04u
M3860 U3835/net6 U3835/net4 VSS VSS nmos W=0.17u L=0.04u
M3861 n3905 U3835/net14 VSS VSS nmos W=0.155u L=0.04u
M3862 U3835/net10 n3910 VSS VSS nmos W=0.155u L=0.04u
M3863 U3835/net4 U3835/net10 U3835/net14 VDD pmos W=0.255u L=0.04u
M3864 U3835/net6 n3910 U3835/net14 VDD pmos W=0.28u L=0.04u
M3865 U3835/net4 g2734 VDD VDD pmos W=0.205u L=0.04u
M3866 U3835/net6 U3835/net4 VDD VDD pmos W=0.24u L=0.04u
M3867 n3905 U3835/net14 VDD VDD pmos W=0.205u L=0.04u
M3868 U3835/net10 n3910 VDD VDD pmos W=0.205u L=0.04u
M3869 U3836/XU1-net6 n3912 VSS VSS nmos W=0.155u L=0.04u
M3870 n3904 n3911 U3836/XU1-net6 VSS nmos W=0.155u L=0.04u
M3871 n3904 n3912 VDD VDD pmos W=0.155u L=0.04u
M3872 n3904 n3911 VDD VDD pmos W=0.155u L=0.04u
M3873 U3837/net4 n3879 U3837/net14 VSS nmos W=0.155u L=0.04u
M3874 U3837/net6 U3837/net10 U3837/net14 VSS nmos W=0.17u L=0.04u
M3875 U3837/net4 n3913 VSS VSS nmos W=0.155u L=0.04u
M3876 U3837/net6 U3837/net4 VSS VSS nmos W=0.17u L=0.04u
M3877 n3912 U3837/net14 VSS VSS nmos W=0.155u L=0.04u
M3878 U3837/net10 n3879 VSS VSS nmos W=0.155u L=0.04u
M3879 U3837/net4 U3837/net10 U3837/net14 VDD pmos W=0.255u L=0.04u
M3880 U3837/net6 n3879 U3837/net14 VDD pmos W=0.28u L=0.04u
M3881 U3837/net4 n3913 VDD VDD pmos W=0.205u L=0.04u
M3882 U3837/net6 U3837/net4 VDD VDD pmos W=0.24u L=0.04u
M3883 n3912 U3837/net14 VDD VDD pmos W=0.205u L=0.04u
M3884 U3837/net10 n3879 VDD VDD pmos W=0.205u L=0.04u
M3885 n3879 g2714 VSS VSS nmos W=0.135u L=0.04u
M3886 n3879 g2714 VDD VDD pmos W=0.205u L=0.04u
M3887 U3839/net4 n3864 U3839/net14 VSS nmos W=0.155u L=0.04u
M3888 U3839/net6 U3839/net10 U3839/net14 VSS nmos W=0.17u L=0.04u
M3889 U3839/net4 n3914 VSS VSS nmos W=0.155u L=0.04u
M3890 U3839/net6 U3839/net4 VSS VSS nmos W=0.17u L=0.04u
M3891 n3911 U3839/net14 VSS VSS nmos W=0.155u L=0.04u
M3892 U3839/net10 n3864 VSS VSS nmos W=0.155u L=0.04u
M3893 U3839/net4 U3839/net10 U3839/net14 VDD pmos W=0.255u L=0.04u
M3894 U3839/net6 n3864 U3839/net14 VDD pmos W=0.28u L=0.04u
M3895 U3839/net4 n3914 VDD VDD pmos W=0.205u L=0.04u
M3896 U3839/net6 U3839/net4 VDD VDD pmos W=0.24u L=0.04u
M3897 n3911 U3839/net14 VDD VDD pmos W=0.205u L=0.04u
M3898 U3839/net10 n3864 VDD VDD pmos W=0.205u L=0.04u
M3899 n3864 g2746 VSS VSS nmos W=0.135u L=0.04u
M3900 n3864 g2746 VDD VDD pmos W=0.205u L=0.04u
M3901 n3887 n3915 VSS VSS nmos W=0.135u L=0.04u
M3902 n3887 n3915 VDD VDD pmos W=0.205u L=0.04u
M3903 U3842/net19 n3877 VSS VSS nmos W=0.155u L=0.04u
M3904 n3753 n3877 U3842/net40 VSS nmos W=0.155u L=0.04u
M3905 n3753 U3842/net19 U3842/net36 VSS nmos W=0.155u L=0.04u
M3906 U3842/net40 n3884 VSS VSS nmos W=0.31u L=0.04u
M3907 U3842/net36 g2794 VSS VSS nmos W=0.155u L=0.04u
M3908 U3842/net19 n3877 VDD VDD pmos W=0.205u L=0.04u
M3909 n3753 U3842/net19 U3842/net26 VDD pmos W=0.325u L=0.04u
M3910 U3842/net26 n3884 VDD VDD pmos W=0.41u L=0.04u
M3911 n3753 n3877 U3842/net30 VDD pmos W=0.325u L=0.04u
M3912 U3842/net30 g2794 VDD VDD pmos W=0.205u L=0.04u
M3913 n3884 g2753 VSS VSS nmos W=0.135u L=0.04u
M3914 n3884 g2753 VDD VDD pmos W=0.205u L=0.04u
M3915 U3844/net19 n3876 VSS VSS nmos W=0.155u L=0.04u
M3916 n3752 n3876 U3844/net40 VSS nmos W=0.155u L=0.04u
M3917 n3752 U3844/net19 U3844/net36 VSS nmos W=0.155u L=0.04u
M3918 U3844/net40 n3873 VSS VSS nmos W=0.31u L=0.04u
M3919 U3844/net36 g2798 VSS VSS nmos W=0.155u L=0.04u
M3920 U3844/net19 n3876 VDD VDD pmos W=0.205u L=0.04u
M3921 n3752 U3844/net19 U3844/net26 VDD pmos W=0.325u L=0.04u
M3922 U3844/net26 n3873 VDD VDD pmos W=0.41u L=0.04u
M3923 n3752 n3876 U3844/net30 VDD pmos W=0.325u L=0.04u
M3924 U3844/net30 g2798 VDD VDD pmos W=0.205u L=0.04u
M3925 n3876 n3885 VSS VSS nmos W=0.155u L=0.04u
M3926 n3876 n3916 VSS VSS nmos W=0.155u L=0.04u
M3927 U3845/XI1-net8 n3916 VDD VDD pmos W=0.205u L=0.04u
M3928 n3876 n3885 U3845/XI1-net8 VDD pmos W=0.205u L=0.04u
M3929 U3846/net19 n3877 VSS VSS nmos W=0.155u L=0.04u
M3930 n3751 n3877 U3846/net40 VSS nmos W=0.155u L=0.04u
M3931 n3751 U3846/net19 U3846/net36 VSS nmos W=0.155u L=0.04u
M3932 U3846/net40 n3873 VSS VSS nmos W=0.31u L=0.04u
M3933 U3846/net36 g2797 VSS VSS nmos W=0.155u L=0.04u
M3934 U3846/net19 n3877 VDD VDD pmos W=0.205u L=0.04u
M3935 n3751 U3846/net19 U3846/net26 VDD pmos W=0.325u L=0.04u
M3936 U3846/net26 n3873 VDD VDD pmos W=0.41u L=0.04u
M3937 n3751 n3877 U3846/net30 VDD pmos W=0.325u L=0.04u
M3938 U3846/net30 g2797 VDD VDD pmos W=0.205u L=0.04u
M3939 n3877 n3886 VSS VSS nmos W=0.155u L=0.04u
M3940 n3877 n3885 VSS VSS nmos W=0.155u L=0.04u
M3941 U3847/XI1-net8 n3885 VDD VDD pmos W=0.205u L=0.04u
M3942 n3877 n3886 U3847/XI1-net8 VDD pmos W=0.205u L=0.04u
M3943 U3848/net30 g2733 VSS VSS nmos W=0.155u L=0.04u
M3944 n3885 g2612 U3848/net23 VSS nmos W=0.155u L=0.04u
M3945 U3848/net20 U3848/net30 VSS VSS nmos W=0.155u L=0.04u
M3946 U3848/net23 g2599 U3848/net20 VSS nmos W=0.155u L=0.04u
M3947 U3848/net30 g2733 VDD VDD pmos W=0.205u L=0.04u
M3948 VDD g2612 n3885 VDD pmos W=0.205u L=0.04u
M3949 VDD g2599 n3885 VDD pmos W=0.205u L=0.04u
M3950 VDD U3848/net30 n3885 VDD pmos W=0.205u L=0.04u
M3951 n3873 g2760 VSS VSS nmos W=0.135u L=0.04u
M3952 n3873 g2760 VDD VDD pmos W=0.205u L=0.04u
M3953 U3850/net19 n3853 VSS VSS nmos W=0.155u L=0.04u
M3954 n3750 n3853 U3850/net40 VSS nmos W=0.155u L=0.04u
M3955 n3750 U3850/net19 U3850/net36 VSS nmos W=0.155u L=0.04u
M3956 U3850/net40 g2704 VSS VSS nmos W=0.31u L=0.04u
M3957 U3850/net36 g2584 VSS VSS nmos W=0.155u L=0.04u
M3958 U3850/net19 n3853 VDD VDD pmos W=0.205u L=0.04u
M3959 n3750 U3850/net19 U3850/net26 VDD pmos W=0.325u L=0.04u
M3960 U3850/net26 g2704 VDD VDD pmos W=0.41u L=0.04u
M3961 n3750 n3853 U3850/net30 VDD pmos W=0.325u L=0.04u
M3962 U3850/net30 g2584 VDD VDD pmos W=0.205u L=0.04u
M3963 U3851/net19 n3918 VSS VSS nmos W=0.155u L=0.04u
M3964 n3749 n3918 U3851/net40 VSS nmos W=0.155u L=0.04u
M3965 n3749 U3851/net19 U3851/net36 VSS nmos W=0.155u L=0.04u
M3966 U3851/net40 g2628 VSS VSS nmos W=0.31u L=0.04u
M3967 U3851/net36 n3917 VSS VSS nmos W=0.155u L=0.04u
M3968 U3851/net19 n3918 VDD VDD pmos W=0.205u L=0.04u
M3969 n3749 U3851/net19 U3851/net26 VDD pmos W=0.325u L=0.04u
M3970 U3851/net26 g2628 VDD VDD pmos W=0.41u L=0.04u
M3971 n3749 n3918 U3851/net30 VDD pmos W=0.325u L=0.04u
M3972 U3851/net30 n3917 VDD VDD pmos W=0.205u L=0.04u
M3973 n3748 U3852/net28 VSS VSS nmos W=0.155u L=0.04u
M3974 U3852/net47 n3919 VSS VSS nmos W=0.155u L=0.04u
M3975 U3852/net28 U3852/net6 U3852/net47 VSS nmos W=0.155u L=0.04u
M3976 U3852/net44 g2628 VSS VSS nmos W=0.155u L=0.04u
M3977 U3852/net28 g2624 U3852/net44 VSS nmos W=0.155u L=0.04u
M3978 U3852/net6 g2624 VSS VSS nmos W=0.155u L=0.04u
M3979 n3748 U3852/net28 VDD VDD pmos W=0.205u L=0.04u
M3980 VDD n3919 U3852/net47 VDD pmos W=0.205u L=0.04u
M3981 U3852/net47 g2624 U3852/net28 VDD pmos W=0.205u L=0.04u
M3982 U3852/net44 U3852/net6 U3852/net28 VDD pmos W=0.205u L=0.04u
M3983 VDD g2628 U3852/net44 VDD pmos W=0.205u L=0.04u
M3984 VDD g2624 U3852/net6 VDD pmos W=0.205u L=0.04u
M3985 U3853/net19 n3918 VSS VSS nmos W=0.155u L=0.04u
M3986 n3747 n3918 U3853/net40 VSS nmos W=0.155u L=0.04u
M3987 n3747 U3853/net19 U3853/net36 VSS nmos W=0.155u L=0.04u
M3988 U3853/net40 g2584 VSS VSS nmos W=0.31u L=0.04u
M3989 U3853/net36 g2631 VSS VSS nmos W=0.155u L=0.04u
M3990 U3853/net19 n3918 VDD VDD pmos W=0.205u L=0.04u
M3991 n3747 U3853/net19 U3853/net26 VDD pmos W=0.325u L=0.04u
M3992 U3853/net26 g2584 VDD VDD pmos W=0.41u L=0.04u
M3993 n3747 n3918 U3853/net30 VDD pmos W=0.325u L=0.04u
M3994 U3853/net30 g2631 VDD VDD pmos W=0.205u L=0.04u
M3995 n3746 n3920 U3854/net27 VSS nmos W=0.155u L=0.04u
M3996 U3854/net39 n3918 VSS VSS nmos W=0.155u L=0.04u
M3997 U3854/net27 g2539 U3854/net39 VSS nmos W=0.155u L=0.04u
M3998 U3854/net27 n3921 U3854/net39 VSS nmos W=0.155u L=0.04u
M3999 n3746 g2555 U3854/net27 VSS nmos W=0.155u L=0.04u
M4000 U3854/net39 g2559 VSS VSS nmos W=0.155u L=0.04u
M4001 n3746 n3918 U3854/net46 VDD pmos W=0.205u L=0.04u
M4002 U3854/net46 g2559 VDD VDD pmos W=0.205u L=0.04u
M4003 n3746 g2555 U3854/net34 VDD pmos W=0.205u L=0.04u
M4004 U3854/net34 n3920 VDD VDD pmos W=0.205u L=0.04u
M4005 n3746 n3921 U3854/net37 VDD pmos W=0.205u L=0.04u
M4006 U3854/net37 g2539 VDD VDD pmos W=0.205u L=0.04u
M4007 n3745 n3918 U3855/net27 VSS nmos W=0.155u L=0.04u
M4008 U3855/net39 n3921 VSS VSS nmos W=0.155u L=0.04u
M4009 U3855/net27 g2552 U3855/net39 VSS nmos W=0.155u L=0.04u
M4010 U3855/net27 n3920 U3855/net39 VSS nmos W=0.155u L=0.04u
M4011 n3745 g2553 U3855/net27 VSS nmos W=0.155u L=0.04u
M4012 U3855/net39 g2554 VSS VSS nmos W=0.155u L=0.04u
M4013 n3745 n3921 U3855/net46 VDD pmos W=0.205u L=0.04u
M4014 U3855/net46 g2554 VDD VDD pmos W=0.205u L=0.04u
M4015 n3745 g2553 U3855/net34 VDD pmos W=0.205u L=0.04u
M4016 U3855/net34 n3918 VDD VDD pmos W=0.205u L=0.04u
M4017 n3745 n3920 U3855/net37 VDD pmos W=0.205u L=0.04u
M4018 U3855/net37 g2552 VDD VDD pmos W=0.205u L=0.04u
M4019 n3744 n3918 U3856/net27 VSS nmos W=0.155u L=0.04u
M4020 U3856/net39 n3921 VSS VSS nmos W=0.155u L=0.04u
M4021 U3856/net27 g2561 U3856/net39 VSS nmos W=0.155u L=0.04u
M4022 U3856/net27 n3920 U3856/net39 VSS nmos W=0.155u L=0.04u
M4023 n3744 g2562 U3856/net27 VSS nmos W=0.155u L=0.04u
M4024 U3856/net39 g2563 VSS VSS nmos W=0.155u L=0.04u
M4025 n3744 n3921 U3856/net46 VDD pmos W=0.205u L=0.04u
M4026 U3856/net46 g2563 VDD VDD pmos W=0.205u L=0.04u
M4027 n3744 g2562 U3856/net34 VDD pmos W=0.205u L=0.04u
M4028 U3856/net34 n3918 VDD VDD pmos W=0.205u L=0.04u
M4029 n3744 n3920 U3856/net37 VDD pmos W=0.205u L=0.04u
M4030 U3856/net37 g2561 VDD VDD pmos W=0.205u L=0.04u
M4031 U3857/net19 n3878 VSS VSS nmos W=0.155u L=0.04u
M4032 n3741 n3878 U3857/net40 VSS nmos W=0.155u L=0.04u
M4033 n3741 U3857/net19 U3857/net36 VSS nmos W=0.155u L=0.04u
M4034 U3857/net40 g2806 VSS VSS nmos W=0.31u L=0.04u
M4035 U3857/net36 n3922 VSS VSS nmos W=0.155u L=0.04u
M4036 U3857/net19 n3878 VDD VDD pmos W=0.205u L=0.04u
M4037 n3741 U3857/net19 U3857/net26 VDD pmos W=0.325u L=0.04u
M4038 U3857/net26 g2806 VDD VDD pmos W=0.41u L=0.04u
M4039 n3741 n3878 U3857/net30 VDD pmos W=0.325u L=0.04u
M4040 U3857/net30 n3922 VDD VDD pmos W=0.205u L=0.04u
M4041 U3858/net19 n3856 VSS VSS nmos W=0.155u L=0.04u
M4042 n3740 n3856 U3858/net40 VSS nmos W=0.155u L=0.04u
M4043 n3740 U3858/net19 U3858/net36 VSS nmos W=0.155u L=0.04u
M4044 U3858/net40 g2807 VSS VSS nmos W=0.31u L=0.04u
M4045 U3858/net36 n3922 VSS VSS nmos W=0.155u L=0.04u
M4046 U3858/net19 n3856 VDD VDD pmos W=0.205u L=0.04u
M4047 n3740 U3858/net19 U3858/net26 VDD pmos W=0.325u L=0.04u
M4048 U3858/net26 g2807 VDD VDD pmos W=0.41u L=0.04u
M4049 n3740 n3856 U3858/net30 VDD pmos W=0.325u L=0.04u
M4050 U3858/net30 n3922 VDD VDD pmos W=0.205u L=0.04u
M4051 U3859/net19 n3875 VSS VSS nmos W=0.155u L=0.04u
M4052 n3739 n3875 U3859/net40 VSS nmos W=0.155u L=0.04u
M4053 n3739 U3859/net19 U3859/net36 VSS nmos W=0.155u L=0.04u
M4054 U3859/net40 g2805 VSS VSS nmos W=0.31u L=0.04u
M4055 U3859/net36 n3922 VSS VSS nmos W=0.155u L=0.04u
M4056 U3859/net19 n3875 VDD VDD pmos W=0.205u L=0.04u
M4057 n3739 U3859/net19 U3859/net26 VDD pmos W=0.325u L=0.04u
M4058 U3859/net26 g2805 VDD VDD pmos W=0.41u L=0.04u
M4059 n3739 n3875 U3859/net30 VDD pmos W=0.325u L=0.04u
M4060 U3859/net30 n3922 VDD VDD pmos W=0.205u L=0.04u
M4061 U3860/net19 n3924 VSS VSS nmos W=0.155u L=0.04u
M4062 n3738 n3924 U3860/net40 VSS nmos W=0.155u L=0.04u
M4063 n3738 U3860/net19 U3860/net36 VSS nmos W=0.155u L=0.04u
M4064 U3860/net40 n3923 VSS VSS nmos W=0.31u L=0.04u
M4065 U3860/net36 g2649 VSS VSS nmos W=0.155u L=0.04u
M4066 U3860/net19 n3924 VDD VDD pmos W=0.205u L=0.04u
M4067 n3738 U3860/net19 U3860/net26 VDD pmos W=0.325u L=0.04u
M4068 U3860/net26 n3923 VDD VDD pmos W=0.41u L=0.04u
M4069 n3738 n3924 U3860/net30 VDD pmos W=0.325u L=0.04u
M4070 U3860/net30 g2649 VDD VDD pmos W=0.205u L=0.04u
M4071 U3861/net19 n3924 VSS VSS nmos W=0.155u L=0.04u
M4072 n3737 n3924 U3861/net40 VSS nmos W=0.155u L=0.04u
M4073 n3737 U3861/net19 U3861/net36 VSS nmos W=0.155u L=0.04u
M4074 U3861/net40 n3925 VSS VSS nmos W=0.31u L=0.04u
M4075 U3861/net36 g2652 VSS VSS nmos W=0.155u L=0.04u
M4076 U3861/net19 n3924 VDD VDD pmos W=0.205u L=0.04u
M4077 n3737 U3861/net19 U3861/net26 VDD pmos W=0.325u L=0.04u
M4078 U3861/net26 n3925 VDD VDD pmos W=0.41u L=0.04u
M4079 n3737 n3924 U3861/net30 VDD pmos W=0.325u L=0.04u
M4080 U3861/net30 g2652 VDD VDD pmos W=0.205u L=0.04u
M4081 U3862/net19 n3924 VSS VSS nmos W=0.155u L=0.04u
M4082 n3736 n3924 U3862/net40 VSS nmos W=0.155u L=0.04u
M4083 n3736 U3862/net19 U3862/net36 VSS nmos W=0.155u L=0.04u
M4084 U3862/net40 n3926 VSS VSS nmos W=0.31u L=0.04u
M4085 U3862/net36 g2655 VSS VSS nmos W=0.155u L=0.04u
M4086 U3862/net19 n3924 VDD VDD pmos W=0.205u L=0.04u
M4087 n3736 U3862/net19 U3862/net26 VDD pmos W=0.325u L=0.04u
M4088 U3862/net26 n3926 VDD VDD pmos W=0.41u L=0.04u
M4089 n3736 n3924 U3862/net30 VDD pmos W=0.325u L=0.04u
M4090 U3862/net30 g2655 VDD VDD pmos W=0.205u L=0.04u
M4091 U3863/net19 n3924 VSS VSS nmos W=0.155u L=0.04u
M4092 n3735 n3924 U3863/net40 VSS nmos W=0.155u L=0.04u
M4093 n3735 U3863/net19 U3863/net36 VSS nmos W=0.155u L=0.04u
M4094 U3863/net40 n3927 VSS VSS nmos W=0.31u L=0.04u
M4095 U3863/net36 g2658 VSS VSS nmos W=0.155u L=0.04u
M4096 U3863/net19 n3924 VDD VDD pmos W=0.205u L=0.04u
M4097 n3735 U3863/net19 U3863/net26 VDD pmos W=0.325u L=0.04u
M4098 U3863/net26 n3927 VDD VDD pmos W=0.41u L=0.04u
M4099 n3735 n3924 U3863/net30 VDD pmos W=0.325u L=0.04u
M4100 U3863/net30 g2658 VDD VDD pmos W=0.205u L=0.04u
M4101 n3924 n3918 VSS VSS nmos W=0.155u L=0.04u
M4102 n3924 n3730 VSS VSS nmos W=0.155u L=0.04u
M4103 U3864/XI1-net8 n3730 VDD VDD pmos W=0.205u L=0.04u
M4104 n3924 n3918 U3864/XI1-net8 VDD pmos W=0.205u L=0.04u
M4105 U3865/net19 n3928 VSS VSS nmos W=0.155u L=0.04u
M4106 n3734 n3928 U3865/net40 VSS nmos W=0.155u L=0.04u
M4107 n3734 U3865/net19 U3865/net36 VSS nmos W=0.155u L=0.04u
M4108 U3865/net40 n3923 VSS VSS nmos W=0.31u L=0.04u
M4109 U3865/net36 g2651 VSS VSS nmos W=0.155u L=0.04u
M4110 U3865/net19 n3928 VDD VDD pmos W=0.205u L=0.04u
M4111 n3734 U3865/net19 U3865/net26 VDD pmos W=0.325u L=0.04u
M4112 U3865/net26 n3923 VDD VDD pmos W=0.41u L=0.04u
M4113 n3734 n3928 U3865/net30 VDD pmos W=0.325u L=0.04u
M4114 U3865/net30 g2651 VDD VDD pmos W=0.205u L=0.04u
M4115 U3866/net19 n3928 VSS VSS nmos W=0.155u L=0.04u
M4116 n3733 n3928 U3866/net40 VSS nmos W=0.155u L=0.04u
M4117 n3733 U3866/net19 U3866/net36 VSS nmos W=0.155u L=0.04u
M4118 U3866/net40 n3925 VSS VSS nmos W=0.31u L=0.04u
M4119 U3866/net36 g2654 VSS VSS nmos W=0.155u L=0.04u
M4120 U3866/net19 n3928 VDD VDD pmos W=0.205u L=0.04u
M4121 n3733 U3866/net19 U3866/net26 VDD pmos W=0.325u L=0.04u
M4122 U3866/net26 n3925 VDD VDD pmos W=0.41u L=0.04u
M4123 n3733 n3928 U3866/net30 VDD pmos W=0.325u L=0.04u
M4124 U3866/net30 g2654 VDD VDD pmos W=0.205u L=0.04u
M4125 U3867/net19 n3928 VSS VSS nmos W=0.155u L=0.04u
M4126 n3732 n3928 U3867/net40 VSS nmos W=0.155u L=0.04u
M4127 n3732 U3867/net19 U3867/net36 VSS nmos W=0.155u L=0.04u
M4128 U3867/net40 n3926 VSS VSS nmos W=0.31u L=0.04u
M4129 U3867/net36 g2657 VSS VSS nmos W=0.155u L=0.04u
M4130 U3867/net19 n3928 VDD VDD pmos W=0.205u L=0.04u
M4131 n3732 U3867/net19 U3867/net26 VDD pmos W=0.325u L=0.04u
M4132 U3867/net26 n3926 VDD VDD pmos W=0.41u L=0.04u
M4133 n3732 n3928 U3867/net30 VDD pmos W=0.325u L=0.04u
M4134 U3867/net30 g2657 VDD VDD pmos W=0.205u L=0.04u
M4135 U3868/net19 n3928 VSS VSS nmos W=0.155u L=0.04u
M4136 n3731 n3928 U3868/net40 VSS nmos W=0.155u L=0.04u
M4137 n3731 U3868/net19 U3868/net36 VSS nmos W=0.155u L=0.04u
M4138 U3868/net40 n3927 VSS VSS nmos W=0.31u L=0.04u
M4139 U3868/net36 g2660 VSS VSS nmos W=0.155u L=0.04u
M4140 U3868/net19 n3928 VDD VDD pmos W=0.205u L=0.04u
M4141 n3731 U3868/net19 U3868/net26 VDD pmos W=0.325u L=0.04u
M4142 U3868/net26 n3927 VDD VDD pmos W=0.41u L=0.04u
M4143 n3731 n3928 U3868/net30 VDD pmos W=0.325u L=0.04u
M4144 U3868/net30 g2660 VDD VDD pmos W=0.205u L=0.04u
M4145 n3928 n3920 VSS VSS nmos W=0.155u L=0.04u
M4146 n3928 n3730 VSS VSS nmos W=0.155u L=0.04u
M4147 U3869/XI1-net8 n3730 VDD VDD pmos W=0.205u L=0.04u
M4148 n3928 n3920 U3869/XI1-net8 VDD pmos W=0.205u L=0.04u
M4149 U3870/net19 n3920 VSS VSS nmos W=0.155u L=0.04u
M4150 n3729 n3920 U3870/net40 VSS nmos W=0.155u L=0.04u
M4151 n3729 U3870/net19 U3870/net36 VSS nmos W=0.155u L=0.04u
M4152 U3870/net40 g2568 VSS VSS nmos W=0.31u L=0.04u
M4153 U3870/net36 n3929 VSS VSS nmos W=0.155u L=0.04u
M4154 U3870/net19 n3920 VDD VDD pmos W=0.205u L=0.04u
M4155 n3729 U3870/net19 U3870/net26 VDD pmos W=0.325u L=0.04u
M4156 U3870/net26 g2568 VDD VDD pmos W=0.41u L=0.04u
M4157 n3729 n3920 U3870/net30 VDD pmos W=0.325u L=0.04u
M4158 U3870/net30 n3929 VDD VDD pmos W=0.205u L=0.04u
M4159 U3871/net19 n3918 VSS VSS nmos W=0.155u L=0.04u
M4160 n3728 n3918 U3871/net40 VSS nmos W=0.155u L=0.04u
M4161 n3728 U3871/net19 U3871/net36 VSS nmos W=0.155u L=0.04u
M4162 U3871/net40 g2571 VSS VSS nmos W=0.31u L=0.04u
M4163 U3871/net36 n3929 VSS VSS nmos W=0.155u L=0.04u
M4164 U3871/net19 n3918 VDD VDD pmos W=0.205u L=0.04u
M4165 n3728 U3871/net19 U3871/net26 VDD pmos W=0.325u L=0.04u
M4166 U3871/net26 g2571 VDD VDD pmos W=0.41u L=0.04u
M4167 n3728 n3918 U3871/net30 VDD pmos W=0.325u L=0.04u
M4168 U3871/net30 n3929 VDD VDD pmos W=0.205u L=0.04u
M4169 U3872/net19 n3878 VSS VSS nmos W=0.155u L=0.04u
M4170 n3727 n3878 U3872/net40 VSS nmos W=0.155u L=0.04u
M4171 n3727 U3872/net19 U3872/net36 VSS nmos W=0.155u L=0.04u
M4172 U3872/net40 g2803 VSS VSS nmos W=0.31u L=0.04u
M4173 U3872/net36 n3930 VSS VSS nmos W=0.155u L=0.04u
M4174 U3872/net19 n3878 VDD VDD pmos W=0.205u L=0.04u
M4175 n3727 U3872/net19 U3872/net26 VDD pmos W=0.325u L=0.04u
M4176 U3872/net26 g2803 VDD VDD pmos W=0.41u L=0.04u
M4177 n3727 n3878 U3872/net30 VDD pmos W=0.325u L=0.04u
M4178 U3872/net30 n3930 VDD VDD pmos W=0.205u L=0.04u
M4179 U3873/XU1-net6 g2704 VSS VSS nmos W=0.155u L=0.04u
M4180 n3878 g7425 U3873/XU1-net6 VSS nmos W=0.155u L=0.04u
M4181 n3878 g2704 VDD VDD pmos W=0.155u L=0.04u
M4182 n3878 g7425 VDD VDD pmos W=0.155u L=0.04u
M4183 U3874/net19 n3856 VSS VSS nmos W=0.155u L=0.04u
M4184 n3726 n3856 U3874/net40 VSS nmos W=0.155u L=0.04u
M4185 n3726 U3874/net19 U3874/net36 VSS nmos W=0.155u L=0.04u
M4186 U3874/net40 g2804 VSS VSS nmos W=0.31u L=0.04u
M4187 U3874/net36 n3930 VSS VSS nmos W=0.155u L=0.04u
M4188 U3874/net19 n3856 VDD VDD pmos W=0.205u L=0.04u
M4189 n3726 U3874/net19 U3874/net26 VDD pmos W=0.325u L=0.04u
M4190 U3874/net26 g2804 VDD VDD pmos W=0.41u L=0.04u
M4191 n3726 n3856 U3874/net30 VDD pmos W=0.325u L=0.04u
M4192 U3874/net30 n3930 VDD VDD pmos W=0.205u L=0.04u
M4193 U3875/XU1-net6 g2704 VSS VSS nmos W=0.155u L=0.04u
M4194 n3856 g7487 U3875/XU1-net6 VSS nmos W=0.155u L=0.04u
M4195 n3856 g2704 VDD VDD pmos W=0.155u L=0.04u
M4196 n3856 g7487 VDD VDD pmos W=0.155u L=0.04u
M4197 U3876/net19 n3875 VSS VSS nmos W=0.155u L=0.04u
M4198 n3725 n3875 U3876/net40 VSS nmos W=0.155u L=0.04u
M4199 n3725 U3876/net19 U3876/net36 VSS nmos W=0.155u L=0.04u
M4200 U3876/net40 g2802 VSS VSS nmos W=0.31u L=0.04u
M4201 U3876/net36 n3930 VSS VSS nmos W=0.155u L=0.04u
M4202 U3876/net19 n3875 VDD VDD pmos W=0.205u L=0.04u
M4203 n3725 U3876/net19 U3876/net26 VDD pmos W=0.325u L=0.04u
M4204 U3876/net26 g2802 VDD VDD pmos W=0.41u L=0.04u
M4205 n3725 n3875 U3876/net30 VDD pmos W=0.325u L=0.04u
M4206 U3876/net30 n3930 VDD VDD pmos W=0.205u L=0.04u
M4207 U3877/XU1-net6 g2703 VSS VSS nmos W=0.155u L=0.04u
M4208 n3875 g2704 U3877/XU1-net6 VSS nmos W=0.155u L=0.04u
M4209 n3875 g2703 VDD VDD pmos W=0.155u L=0.04u
M4210 n3875 g2704 VDD VDD pmos W=0.155u L=0.04u
M4211 U3878/net19 n3931 VSS VSS nmos W=0.155u L=0.04u
M4212 n3724 n3931 U3878/net40 VSS nmos W=0.155u L=0.04u
M4213 n3724 U3878/net19 U3878/net36 VSS nmos W=0.155u L=0.04u
M4214 U3878/net40 n3923 VSS VSS nmos W=0.31u L=0.04u
M4215 U3878/net36 g2650 VSS VSS nmos W=0.155u L=0.04u
M4216 U3878/net19 n3931 VDD VDD pmos W=0.205u L=0.04u
M4217 n3724 U3878/net19 U3878/net26 VDD pmos W=0.325u L=0.04u
M4218 U3878/net26 n3923 VDD VDD pmos W=0.41u L=0.04u
M4219 n3724 n3931 U3878/net30 VDD pmos W=0.325u L=0.04u
M4220 U3878/net30 g2650 VDD VDD pmos W=0.205u L=0.04u
M4221 U3879/net7 n3932 U3879/X_u4-net10 VSS nmos W=0.155u L=0.04u
M4222 U3879/X_u4-net10 n3933 U3879/X_u4-net13 VSS nmos W=0.155u L=0.04u
M4223 U3879/X_u4-net13 n3934 VSS VSS nmos W=0.155u L=0.04u
M4224 n3923 U3879/net7 VSS VSS nmos W=0.155u L=0.04u
M4225 U3879/net7 n3934 VDD VDD pmos W=0.205u L=0.04u
M4226 U3879/net7 n3932 VDD VDD pmos W=0.205u L=0.04u
M4227 U3879/net7 n3933 VDD VDD pmos W=0.205u L=0.04u
M4228 n3923 U3879/net7 VDD VDD pmos W=0.205u L=0.04u
M4229 U3880/net19 n3937 VSS VSS nmos W=0.155u L=0.04u
M4230 n3934 n3937 U3880/net40 VSS nmos W=0.155u L=0.04u
M4231 n3934 U3880/net19 U3880/net36 VSS nmos W=0.155u L=0.04u
M4232 U3880/net40 n3936 VSS VSS nmos W=0.31u L=0.04u
M4233 U3880/net36 n3935 VSS VSS nmos W=0.155u L=0.04u
M4234 U3880/net19 n3937 VDD VDD pmos W=0.205u L=0.04u
M4235 n3934 U3880/net19 U3880/net26 VDD pmos W=0.325u L=0.04u
M4236 U3880/net26 n3936 VDD VDD pmos W=0.41u L=0.04u
M4237 n3934 n3937 U3880/net30 VDD pmos W=0.325u L=0.04u
M4238 U3880/net30 n3935 VDD VDD pmos W=0.205u L=0.04u
M4239 n3936 n611 U3881/net15 VSS nmos W=0.155u L=0.04u
M4240 n3936 n3935 U3881/net15 VSS nmos W=0.155u L=0.04u
M4241 U3881/net15 n3938 VSS VSS nmos W=0.155u L=0.04u
M4242 n3936 n3938 VDD VDD pmos W=0.205u L=0.04u
M4243 n3936 n611 U3881/XI16-net11 VDD pmos W=0.205u L=0.04u
M4244 U3881/XI16-net11 n3935 VDD VDD pmos W=0.205u L=0.04u
M4245 U3882/net19 n3931 VSS VSS nmos W=0.155u L=0.04u
M4246 n3723 n3931 U3882/net40 VSS nmos W=0.155u L=0.04u
M4247 n3723 U3882/net19 U3882/net36 VSS nmos W=0.155u L=0.04u
M4248 U3882/net40 n3925 VSS VSS nmos W=0.31u L=0.04u
M4249 U3882/net36 g2653 VSS VSS nmos W=0.155u L=0.04u
M4250 U3882/net19 n3931 VDD VDD pmos W=0.205u L=0.04u
M4251 n3723 U3882/net19 U3882/net26 VDD pmos W=0.325u L=0.04u
M4252 U3882/net26 n3925 VDD VDD pmos W=0.41u L=0.04u
M4253 n3723 n3931 U3882/net30 VDD pmos W=0.325u L=0.04u
M4254 U3882/net30 g2653 VDD VDD pmos W=0.205u L=0.04u
M4255 U3883/net36 n3938 U3883/net24 VSS nmos W=0.155u L=0.04u
M4256 U3883/net24 n3932 VSS VSS nmos W=0.155u L=0.04u
M4257 U3883/net33 n3939 U3883/net36 VSS nmos W=0.155u L=0.04u
M4258 U3883/net33 n3940 U3883/net36 VSS nmos W=0.155u L=0.04u
M4259 n3925 U3883/net33 VSS VSS nmos W=0.155u L=0.04u
M4260 n3925 U3883/net33 VDD VDD pmos W=0.205u L=0.04u
M4261 U3883/net33 n3940 U3883/net35 VDD pmos W=0.205u L=0.04u
M4262 U3883/net35 n3939 VDD VDD pmos W=0.205u L=0.04u
M4263 U3883/net33 n3932 VDD VDD pmos W=0.205u L=0.04u
M4264 U3883/net33 n3938 VDD VDD pmos W=0.205u L=0.04u
M4265 n3932 n3939 U3884/XI0-net10 VSS nmos W=0.155u L=0.04u
M4266 U3884/XI0-net10 n3941 U3884/XI0-net13 VSS nmos W=0.155u L=0.04u
M4267 U3884/XI0-net13 g3229 VSS VSS nmos W=0.155u L=0.04u
M4268 n3932 g3229 VDD VDD pmos W=0.205u L=0.04u
M4269 n3932 n3939 VDD VDD pmos W=0.205u L=0.04u
M4270 n3932 n3941 VDD VDD pmos W=0.205u L=0.04u
M4271 U3885/XU1-net6 n3937 VSS VSS nmos W=0.155u L=0.04u
M4272 n3940 n3941 U3885/XU1-net6 VSS nmos W=0.155u L=0.04u
M4273 n3940 n3937 VDD VDD pmos W=0.155u L=0.04u
M4274 n3940 n3941 VDD VDD pmos W=0.155u L=0.04u
M4275 U3886/net19 n3931 VSS VSS nmos W=0.155u L=0.04u
M4276 n3722 n3931 U3886/net40 VSS nmos W=0.155u L=0.04u
M4277 n3722 U3886/net19 U3886/net36 VSS nmos W=0.155u L=0.04u
M4278 U3886/net40 n3926 VSS VSS nmos W=0.31u L=0.04u
M4279 U3886/net36 g2656 VSS VSS nmos W=0.155u L=0.04u
M4280 U3886/net19 n3931 VDD VDD pmos W=0.205u L=0.04u
M4281 n3722 U3886/net19 U3886/net26 VDD pmos W=0.325u L=0.04u
M4282 U3886/net26 n3926 VDD VDD pmos W=0.41u L=0.04u
M4283 n3722 n3931 U3886/net30 VDD pmos W=0.325u L=0.04u
M4284 U3886/net30 g2656 VDD VDD pmos W=0.205u L=0.04u
M4285 n3926 n3945 VSS VSS nmos W=0.155u L=0.04u
M4286 n3926 n3942 U3887/XI17-net17 VSS nmos W=0.155u L=0.04u
M4287 U3887/XI17-net17 n3944 VSS VSS nmos W=0.155u L=0.04u
M4288 n3926 n3942 U3887/XI10-net17 VSS nmos W=0.155u L=0.04u
M4289 U3887/XI10-net17 n3943 VSS VSS nmos W=0.155u L=0.04u
M4290 U3887/net30 n3942 n3926 VDD pmos W=0.205u L=0.04u
M4291 U3887/net30 n3943 n3926 VDD pmos W=0.205u L=0.04u
M4292 VDD n3945 U3887/net36 VDD pmos W=0.205u L=0.04u
M4293 U3887/net36 n3944 U3887/net30 VDD pmos W=0.205u L=0.04u
M4294 U3887/net36 n3942 U3887/net30 VDD pmos W=0.205u L=0.04u
M4295 VSS n3933 U3888/net22 VSS nmos W=0.155u L=0.04u
M4296 U3888/net22 n3939 n3945 VSS nmos W=0.155u L=0.04u
M4297 U3888/net22 g3229 n3945 VSS nmos W=0.155u L=0.04u
M4298 U3888/net22 n3946 n3945 VSS nmos W=0.155u L=0.04u
M4299 U3888/net38 n3946 VDD VDD pmos W=0.205u L=0.04u
M4300 U3888/net35 g3229 U3888/net38 VDD pmos W=0.205u L=0.04u
M4301 n3945 n3939 U3888/net35 VDD pmos W=0.205u L=0.04u
M4302 n3945 n3933 VDD VDD pmos W=0.205u L=0.04u
M4303 n3933 n3947 U3889/XI0-net10 VSS nmos W=0.155u L=0.04u
M4304 U3889/XI0-net10 n3939 U3889/XI0-net13 VSS nmos W=0.155u L=0.04u
M4305 U3889/XI0-net13 g3229 VSS VSS nmos W=0.155u L=0.04u
M4306 n3933 g3229 VDD VDD pmos W=0.205u L=0.04u
M4307 n3933 n3947 VDD VDD pmos W=0.205u L=0.04u
M4308 n3933 n3939 VDD VDD pmos W=0.205u L=0.04u
M4309 U3890/net19 n3931 VSS VSS nmos W=0.155u L=0.04u
M4310 n3721 n3931 U3890/net40 VSS nmos W=0.155u L=0.04u
M4311 n3721 U3890/net19 U3890/net36 VSS nmos W=0.155u L=0.04u
M4312 U3890/net40 n3927 VSS VSS nmos W=0.31u L=0.04u
M4313 U3890/net36 g2659 VSS VSS nmos W=0.155u L=0.04u
M4314 U3890/net19 n3931 VDD VDD pmos W=0.205u L=0.04u
M4315 n3721 U3890/net19 U3890/net26 VDD pmos W=0.325u L=0.04u
M4316 U3890/net26 n3927 VDD VDD pmos W=0.41u L=0.04u
M4317 n3721 n3931 U3890/net30 VDD pmos W=0.325u L=0.04u
M4318 U3890/net30 g2659 VDD VDD pmos W=0.205u L=0.04u
M4319 n3931 n3921 VSS VSS nmos W=0.155u L=0.04u
M4320 n3931 n3730 VSS VSS nmos W=0.155u L=0.04u
M4321 U3891/XI1-net8 n3730 VDD VDD pmos W=0.205u L=0.04u
M4322 n3931 n3921 U3891/XI1-net8 VDD pmos W=0.205u L=0.04u
M4323 n3730 n3922 U3892/net10 VSS nmos W=0.155u L=0.04u
M4324 U3892/net10 n3950 VSS VSS nmos W=0.155u L=0.04u
M4325 n3730 n3948 U3892/net10 VSS nmos W=0.155u L=0.04u
M4326 U3892/net10 n3949 VSS VSS nmos W=0.155u L=0.04u
M4327 U3892/net30 n3950 VDD VDD pmos W=0.205u L=0.04u
M4328 n3730 n3922 U3892/net24 VDD pmos W=0.205u L=0.04u
M4329 U3892/net24 n3948 VDD VDD pmos W=0.205u L=0.04u
M4330 n3730 n3949 U3892/net30 VDD pmos W=0.205u L=0.04u
M4331 U3893/net7 g2584 U3893/X_u4-net10 VSS nmos W=0.155u L=0.04u
M4332 U3893/X_u4-net10 n3951 U3893/X_u4-net13 VSS nmos W=0.155u L=0.04u
M4333 U3893/X_u4-net13 n3948 VSS VSS nmos W=0.155u L=0.04u
M4334 n3949 U3893/net7 VSS VSS nmos W=0.155u L=0.04u
M4335 U3893/net7 n3948 VDD VDD pmos W=0.205u L=0.04u
M4336 U3893/net7 g2584 VDD VDD pmos W=0.205u L=0.04u
M4337 U3893/net7 n3951 VDD VDD pmos W=0.205u L=0.04u
M4338 n3949 U3893/net7 VDD VDD pmos W=0.205u L=0.04u
M4339 n3927 n3944 U3894/net15 VSS nmos W=0.155u L=0.04u
M4340 n3927 n3943 U3894/net15 VSS nmos W=0.155u L=0.04u
M4341 U3894/net15 n3952 VSS VSS nmos W=0.155u L=0.04u
M4342 n3927 n3952 VDD VDD pmos W=0.205u L=0.04u
M4343 n3927 n3944 U3894/XI16-net11 VDD pmos W=0.205u L=0.04u
M4344 U3894/XI16-net11 n3943 VDD VDD pmos W=0.205u L=0.04u
M4345 n3943 g3229 VSS VSS nmos W=0.155u L=0.04u
M4346 n3943 n611 VSS VSS nmos W=0.155u L=0.04u
M4347 U3895/XI1-net8 n611 VDD VDD pmos W=0.205u L=0.04u
M4348 n3943 g3229 U3895/XI1-net8 VDD pmos W=0.205u L=0.04u
M4349 n3944 n3939 VSS VSS nmos W=0.155u L=0.04u
M4350 n3944 n3937 VSS VSS nmos W=0.155u L=0.04u
M4351 U3896/XI1-net8 n3937 VDD VDD pmos W=0.205u L=0.04u
M4352 n3944 n3939 U3896/XI1-net8 VDD pmos W=0.205u L=0.04u
M4353 U3897/net19 n3921 VSS VSS nmos W=0.155u L=0.04u
M4354 n3720 n3921 U3897/net40 VSS nmos W=0.155u L=0.04u
M4355 n3720 U3897/net19 U3897/net36 VSS nmos W=0.155u L=0.04u
M4356 U3897/net40 g2565 VSS VSS nmos W=0.31u L=0.04u
M4357 U3897/net36 n3929 VSS VSS nmos W=0.155u L=0.04u
M4358 U3897/net19 n3921 VDD VDD pmos W=0.205u L=0.04u
M4359 n3720 U3897/net19 U3897/net26 VDD pmos W=0.325u L=0.04u
M4360 U3897/net26 g2565 VDD VDD pmos W=0.41u L=0.04u
M4361 n3720 n3921 U3897/net30 VDD pmos W=0.325u L=0.04u
M4362 U3897/net30 n3929 VDD VDD pmos W=0.205u L=0.04u
M4363 U3898/net7 g2584 U3898/X_u4-net10 VSS nmos W=0.155u L=0.04u
M4364 U3898/X_u4-net10 n3948 U3898/X_u4-net13 VSS nmos W=0.155u L=0.04u
M4365 U3898/X_u4-net13 n3930 VSS VSS nmos W=0.155u L=0.04u
M4366 n3929 U3898/net7 VSS VSS nmos W=0.155u L=0.04u
M4367 U3898/net7 n3930 VDD VDD pmos W=0.205u L=0.04u
M4368 U3898/net7 g2584 VDD VDD pmos W=0.205u L=0.04u
M4369 U3898/net7 n3948 VDD VDD pmos W=0.205u L=0.04u
M4370 n3929 U3898/net7 VDD VDD pmos W=0.205u L=0.04u
M4371 n3948 g2624 U3899/XI21-net17 VSS nmos W=0.155u L=0.04u
M4372 U3899/XI21-net17 g2571 VSS VSS nmos W=0.155u L=0.04u
M4373 n3948 g7302 U3899/XI6-net17 VSS nmos W=0.155u L=0.04u
M4374 U3899/XI6-net17 g2565 VSS VSS nmos W=0.155u L=0.04u
M4375 n3948 g7390 U3899/XI20-net17 VSS nmos W=0.155u L=0.04u
M4376 U3899/XI20-net17 g2568 VSS VSS nmos W=0.155u L=0.04u
M4377 VDD g2624 U3899/net22 VDD pmos W=0.205u L=0.04u
M4378 VDD g2571 U3899/net22 VDD pmos W=0.205u L=0.04u
M4379 U3899/net16 g7302 n3948 VDD pmos W=0.205u L=0.04u
M4380 U3899/net16 g2565 n3948 VDD pmos W=0.205u L=0.04u
M4381 U3899/net22 g7390 U3899/net16 VDD pmos W=0.205u L=0.04u
M4382 U3899/net22 g2568 U3899/net16 VDD pmos W=0.205u L=0.04u
M4383 U3900/net19 g3229 VSS VSS nmos W=0.155u L=0.04u
M4384 n3719 g3229 U3900/net40 VSS nmos W=0.155u L=0.04u
M4385 n3719 U3900/net19 U3900/net36 VSS nmos W=0.155u L=0.04u
M4386 U3900/net40 n3953 VSS VSS nmos W=0.31u L=0.04u
M4387 U3900/net36 g2380 VSS VSS nmos W=0.155u L=0.04u
M4388 U3900/net19 g3229 VDD VDD pmos W=0.205u L=0.04u
M4389 n3719 U3900/net19 U3900/net26 VDD pmos W=0.325u L=0.04u
M4390 U3900/net26 n3953 VDD VDD pmos W=0.41u L=0.04u
M4391 n3719 g3229 U3900/net30 VDD pmos W=0.325u L=0.04u
M4392 U3900/net30 g2380 VDD VDD pmos W=0.205u L=0.04u
M4393 n3953 g2366 VSS VSS nmos W=0.135u L=0.04u
M4394 n3953 g2366 VDD VDD pmos W=0.205u L=0.04u
M4395 U3902/net19 g8087 VSS VSS nmos W=0.155u L=0.04u
M4396 n3718 g8087 U3902/net40 VSS nmos W=0.155u L=0.04u
M4397 n3718 U3902/net19 U3902/net36 VSS nmos W=0.155u L=0.04u
M4398 U3902/net40 n3954 VSS VSS nmos W=0.31u L=0.04u
M4399 U3902/net36 g2540 VSS VSS nmos W=0.155u L=0.04u
M4400 U3902/net19 g8087 VDD VDD pmos W=0.205u L=0.04u
M4401 n3718 U3902/net19 U3902/net26 VDD pmos W=0.325u L=0.04u
M4402 U3902/net26 n3954 VDD VDD pmos W=0.41u L=0.04u
M4403 n3718 g8087 U3902/net30 VDD pmos W=0.325u L=0.04u
M4404 U3902/net30 g2540 VDD VDD pmos W=0.205u L=0.04u
M4405 U3903/net19 g8167 VSS VSS nmos W=0.155u L=0.04u
M4406 n3717 g8167 U3903/net40 VSS nmos W=0.155u L=0.04u
M4407 n3717 U3903/net19 U3903/net36 VSS nmos W=0.155u L=0.04u
M4408 U3903/net40 n3954 VSS VSS nmos W=0.31u L=0.04u
M4409 U3903/net36 g2543 VSS VSS nmos W=0.155u L=0.04u
M4410 U3903/net19 g8167 VDD VDD pmos W=0.205u L=0.04u
M4411 n3717 U3903/net19 U3903/net26 VDD pmos W=0.325u L=0.04u
M4412 U3903/net26 n3954 VDD VDD pmos W=0.41u L=0.04u
M4413 n3717 g8167 U3903/net30 VDD pmos W=0.325u L=0.04u
M4414 U3903/net30 g2543 VDD VDD pmos W=0.205u L=0.04u
M4415 U3904/net19 g2560 VSS VSS nmos W=0.155u L=0.04u
M4416 n3716 g2560 U3904/net40 VSS nmos W=0.155u L=0.04u
M4417 n3716 U3904/net19 U3904/net36 VSS nmos W=0.155u L=0.04u
M4418 U3904/net40 n3954 VSS VSS nmos W=0.31u L=0.04u
M4419 U3904/net36 g2546 VSS VSS nmos W=0.155u L=0.04u
M4420 U3904/net19 g2560 VDD VDD pmos W=0.205u L=0.04u
M4421 n3716 U3904/net19 U3904/net26 VDD pmos W=0.325u L=0.04u
M4422 U3904/net26 n3954 VDD VDD pmos W=0.41u L=0.04u
M4423 n3716 g2560 U3904/net30 VDD pmos W=0.325u L=0.04u
M4424 U3904/net30 g2546 VDD VDD pmos W=0.205u L=0.04u
M4425 U3905/net19 g2560 VSS VSS nmos W=0.155u L=0.04u
M4426 n3715 g2560 U3905/net40 VSS nmos W=0.155u L=0.04u
M4427 n3715 U3905/net19 U3905/net36 VSS nmos W=0.155u L=0.04u
M4428 U3905/net40 n3955 VSS VSS nmos W=0.31u L=0.04u
M4429 U3905/net36 g2536 VSS VSS nmos W=0.155u L=0.04u
M4430 U3905/net19 g2560 VDD VDD pmos W=0.205u L=0.04u
M4431 n3715 U3905/net19 U3905/net26 VDD pmos W=0.325u L=0.04u
M4432 U3905/net26 n3955 VDD VDD pmos W=0.41u L=0.04u
M4433 n3715 g2560 U3905/net30 VDD pmos W=0.325u L=0.04u
M4434 U3905/net30 g2536 VDD VDD pmos W=0.205u L=0.04u
M4435 U3906/net19 g8087 VSS VSS nmos W=0.155u L=0.04u
M4436 n3714 g8087 U3906/net40 VSS nmos W=0.155u L=0.04u
M4437 n3714 U3906/net19 U3906/net36 VSS nmos W=0.155u L=0.04u
M4438 U3906/net40 n3955 VSS VSS nmos W=0.31u L=0.04u
M4439 U3906/net36 g2530 VSS VSS nmos W=0.155u L=0.04u
M4440 U3906/net19 g8087 VDD VDD pmos W=0.205u L=0.04u
M4441 n3714 U3906/net19 U3906/net26 VDD pmos W=0.325u L=0.04u
M4442 U3906/net26 n3955 VDD VDD pmos W=0.41u L=0.04u
M4443 n3714 g8087 U3906/net30 VDD pmos W=0.325u L=0.04u
M4444 U3906/net30 g2530 VDD VDD pmos W=0.205u L=0.04u
M4445 U3907/net19 g8167 VSS VSS nmos W=0.155u L=0.04u
M4446 n3713 g8167 U3907/net40 VSS nmos W=0.155u L=0.04u
M4447 n3713 U3907/net19 U3907/net36 VSS nmos W=0.155u L=0.04u
M4448 U3907/net40 n3955 VSS VSS nmos W=0.31u L=0.04u
M4449 U3907/net36 g2533 VSS VSS nmos W=0.155u L=0.04u
M4450 U3907/net19 g8167 VDD VDD pmos W=0.205u L=0.04u
M4451 n3713 U3907/net19 U3907/net26 VDD pmos W=0.325u L=0.04u
M4452 U3907/net26 n3955 VDD VDD pmos W=0.41u L=0.04u
M4453 n3713 g8167 U3907/net30 VDD pmos W=0.325u L=0.04u
M4454 U3907/net30 g2533 VDD VDD pmos W=0.205u L=0.04u
M4455 n3955 n3956 VSS VSS nmos W=0.135u L=0.04u
M4456 n3955 n3956 VDD VDD pmos W=0.205u L=0.04u
M4457 U3909/net19 g8087 VSS VSS nmos W=0.155u L=0.04u
M4458 n3712 g8087 U3909/net40 VSS nmos W=0.155u L=0.04u
M4459 n3712 U3909/net19 U3909/net36 VSS nmos W=0.155u L=0.04u
M4460 U3909/net40 n3957 VSS VSS nmos W=0.31u L=0.04u
M4461 U3909/net36 g2552 VSS VSS nmos W=0.155u L=0.04u
M4462 U3909/net19 g8087 VDD VDD pmos W=0.205u L=0.04u
M4463 n3712 U3909/net19 U3909/net26 VDD pmos W=0.325u L=0.04u
M4464 U3909/net26 n3957 VDD VDD pmos W=0.41u L=0.04u
M4465 n3712 g8087 U3909/net30 VDD pmos W=0.325u L=0.04u
M4466 U3909/net30 g2552 VDD VDD pmos W=0.205u L=0.04u
M4467 U3910/net19 g8167 VSS VSS nmos W=0.155u L=0.04u
M4468 n3711 g8167 U3910/net40 VSS nmos W=0.155u L=0.04u
M4469 n3711 U3910/net19 U3910/net36 VSS nmos W=0.155u L=0.04u
M4470 U3910/net40 n3957 VSS VSS nmos W=0.31u L=0.04u
M4471 U3910/net36 g2553 VSS VSS nmos W=0.155u L=0.04u
M4472 U3910/net19 g8167 VDD VDD pmos W=0.205u L=0.04u
M4473 n3711 U3910/net19 U3910/net26 VDD pmos W=0.325u L=0.04u
M4474 U3910/net26 n3957 VDD VDD pmos W=0.41u L=0.04u
M4475 n3711 g8167 U3910/net30 VDD pmos W=0.325u L=0.04u
M4476 U3910/net30 g2553 VDD VDD pmos W=0.205u L=0.04u
M4477 U3911/net19 g2560 VSS VSS nmos W=0.155u L=0.04u
M4478 n3710 g2560 U3911/net40 VSS nmos W=0.155u L=0.04u
M4479 n3710 U3911/net19 U3911/net36 VSS nmos W=0.155u L=0.04u
M4480 U3911/net40 n3957 VSS VSS nmos W=0.31u L=0.04u
M4481 U3911/net36 g2554 VSS VSS nmos W=0.155u L=0.04u
M4482 U3911/net19 g2560 VDD VDD pmos W=0.205u L=0.04u
M4483 n3710 U3911/net19 U3911/net26 VDD pmos W=0.325u L=0.04u
M4484 U3911/net26 n3957 VDD VDD pmos W=0.41u L=0.04u
M4485 n3710 g2560 U3911/net30 VDD pmos W=0.325u L=0.04u
M4486 U3911/net30 g2554 VDD VDD pmos W=0.205u L=0.04u
M4487 U3912/net19 g8167 VSS VSS nmos W=0.155u L=0.04u
M4488 n3709 g8167 U3912/net40 VSS nmos W=0.155u L=0.04u
M4489 n3709 U3912/net19 U3912/net36 VSS nmos W=0.155u L=0.04u
M4490 U3912/net40 g12005 VSS VSS nmos W=0.31u L=0.04u
M4491 U3912/net36 g2559 VSS VSS nmos W=0.155u L=0.04u
M4492 U3912/net19 g8167 VDD VDD pmos W=0.205u L=0.04u
M4493 n3709 U3912/net19 U3912/net26 VDD pmos W=0.325u L=0.04u
M4494 U3912/net26 g12005 VDD VDD pmos W=0.41u L=0.04u
M4495 n3709 g8167 U3912/net30 VDD pmos W=0.325u L=0.04u
M4496 U3912/net30 g2559 VDD VDD pmos W=0.205u L=0.04u
M4497 U3913/net19 g2560 VSS VSS nmos W=0.155u L=0.04u
M4498 n3708 g2560 U3913/net40 VSS nmos W=0.155u L=0.04u
M4499 n3708 U3913/net19 U3913/net36 VSS nmos W=0.155u L=0.04u
M4500 U3913/net40 g12005 VSS VSS nmos W=0.31u L=0.04u
M4501 U3913/net36 g2539 VSS VSS nmos W=0.155u L=0.04u
M4502 U3913/net19 g2560 VDD VDD pmos W=0.205u L=0.04u
M4503 n3708 U3913/net19 U3913/net26 VDD pmos W=0.325u L=0.04u
M4504 U3913/net26 g12005 VDD VDD pmos W=0.41u L=0.04u
M4505 n3708 g2560 U3913/net30 VDD pmos W=0.325u L=0.04u
M4506 U3913/net30 g2539 VDD VDD pmos W=0.205u L=0.04u
M4507 U3914/net19 g8087 VSS VSS nmos W=0.155u L=0.04u
M4508 n3707 g8087 U3914/net40 VSS nmos W=0.155u L=0.04u
M4509 n3707 U3914/net19 U3914/net36 VSS nmos W=0.155u L=0.04u
M4510 U3914/net40 g12005 VSS VSS nmos W=0.31u L=0.04u
M4511 U3914/net36 g2555 VSS VSS nmos W=0.155u L=0.04u
M4512 U3914/net19 g8087 VDD VDD pmos W=0.205u L=0.04u
M4513 n3707 U3914/net19 U3914/net26 VDD pmos W=0.325u L=0.04u
M4514 U3914/net26 g12005 VDD VDD pmos W=0.41u L=0.04u
M4515 n3707 g8087 U3914/net30 VDD pmos W=0.325u L=0.04u
M4516 U3914/net30 g2555 VDD VDD pmos W=0.205u L=0.04u
M4517 U3915/net19 g8087 VSS VSS nmos W=0.155u L=0.04u
M4518 n3706 g8087 U3915/net40 VSS nmos W=0.155u L=0.04u
M4519 n3706 U3915/net19 U3915/net36 VSS nmos W=0.155u L=0.04u
M4520 U3915/net40 n3958 VSS VSS nmos W=0.31u L=0.04u
M4521 U3915/net36 g2561 VSS VSS nmos W=0.155u L=0.04u
M4522 U3915/net19 g8087 VDD VDD pmos W=0.205u L=0.04u
M4523 n3706 U3915/net19 U3915/net26 VDD pmos W=0.325u L=0.04u
M4524 U3915/net26 n3958 VDD VDD pmos W=0.41u L=0.04u
M4525 n3706 g8087 U3915/net30 VDD pmos W=0.325u L=0.04u
M4526 U3915/net30 g2561 VDD VDD pmos W=0.205u L=0.04u
M4527 U3916/net19 g8167 VSS VSS nmos W=0.155u L=0.04u
M4528 n3705 g8167 U3916/net40 VSS nmos W=0.155u L=0.04u
M4529 n3705 U3916/net19 U3916/net36 VSS nmos W=0.155u L=0.04u
M4530 U3916/net40 n3958 VSS VSS nmos W=0.31u L=0.04u
M4531 U3916/net36 g2562 VSS VSS nmos W=0.155u L=0.04u
M4532 U3916/net19 g8167 VDD VDD pmos W=0.205u L=0.04u
M4533 n3705 U3916/net19 U3916/net26 VDD pmos W=0.325u L=0.04u
M4534 U3916/net26 n3958 VDD VDD pmos W=0.41u L=0.04u
M4535 n3705 g8167 U3916/net30 VDD pmos W=0.325u L=0.04u
M4536 U3916/net30 g2562 VDD VDD pmos W=0.205u L=0.04u
M4537 U3917/net19 g2560 VSS VSS nmos W=0.155u L=0.04u
M4538 n3704 g2560 U3917/net40 VSS nmos W=0.155u L=0.04u
M4539 n3704 U3917/net19 U3917/net36 VSS nmos W=0.155u L=0.04u
M4540 U3917/net40 n3958 VSS VSS nmos W=0.31u L=0.04u
M4541 U3917/net36 g2563 VSS VSS nmos W=0.155u L=0.04u
M4542 U3917/net19 g2560 VDD VDD pmos W=0.205u L=0.04u
M4543 n3704 U3917/net19 U3917/net26 VDD pmos W=0.325u L=0.04u
M4544 U3917/net26 n3958 VDD VDD pmos W=0.41u L=0.04u
M4545 n3704 g2560 U3917/net30 VDD pmos W=0.325u L=0.04u
M4546 U3917/net30 g2563 VDD VDD pmos W=0.205u L=0.04u
M4547 U3918/net19 n3960 VSS VSS nmos W=0.155u L=0.04u
M4548 n3703 n3960 U3918/net40 VSS nmos W=0.155u L=0.04u
M4549 n3703 U3918/net19 U3918/net36 VSS nmos W=0.155u L=0.04u
M4550 U3918/net40 n3959 VSS VSS nmos W=0.31u L=0.04u
M4551 U3918/net36 g2240 VSS VSS nmos W=0.155u L=0.04u
M4552 U3918/net19 n3960 VDD VDD pmos W=0.205u L=0.04u
M4553 n3703 U3918/net19 U3918/net26 VDD pmos W=0.325u L=0.04u
M4554 U3918/net26 n3959 VDD VDD pmos W=0.41u L=0.04u
M4555 n3703 n3960 U3918/net30 VDD pmos W=0.325u L=0.04u
M4556 U3918/net30 g2240 VDD VDD pmos W=0.205u L=0.04u
M4557 U3919/net19 n3961 VSS VSS nmos W=0.155u L=0.04u
M4558 n3702 n3961 U3919/net40 VSS nmos W=0.155u L=0.04u
M4559 n3702 U3919/net19 U3919/net36 VSS nmos W=0.155u L=0.04u
M4560 U3919/net40 n3959 VSS VSS nmos W=0.31u L=0.04u
M4561 U3919/net36 g2238 VSS VSS nmos W=0.155u L=0.04u
M4562 U3919/net19 n3961 VDD VDD pmos W=0.205u L=0.04u
M4563 n3702 U3919/net19 U3919/net26 VDD pmos W=0.325u L=0.04u
M4564 U3919/net26 n3959 VDD VDD pmos W=0.41u L=0.04u
M4565 n3702 n3961 U3919/net30 VDD pmos W=0.325u L=0.04u
M4566 U3919/net30 g2238 VDD VDD pmos W=0.205u L=0.04u
M4567 U3920/net19 n3960 VSS VSS nmos W=0.155u L=0.04u
M4568 n3701 n3960 U3920/net40 VSS nmos W=0.155u L=0.04u
M4569 n3701 U3920/net19 U3920/net36 VSS nmos W=0.155u L=0.04u
M4570 U3920/net40 n3962 VSS VSS nmos W=0.31u L=0.04u
M4571 U3920/net36 g2237 VSS VSS nmos W=0.155u L=0.04u
M4572 U3920/net19 n3960 VDD VDD pmos W=0.205u L=0.04u
M4573 n3701 U3920/net19 U3920/net26 VDD pmos W=0.325u L=0.04u
M4574 U3920/net26 n3962 VDD VDD pmos W=0.41u L=0.04u
M4575 n3701 n3960 U3920/net30 VDD pmos W=0.325u L=0.04u
M4576 U3920/net30 g2237 VDD VDD pmos W=0.205u L=0.04u
M4577 U3921/net19 n3961 VSS VSS nmos W=0.155u L=0.04u
M4578 n3700 n3961 U3921/net40 VSS nmos W=0.155u L=0.04u
M4579 n3700 U3921/net19 U3921/net36 VSS nmos W=0.155u L=0.04u
M4580 U3921/net40 n3962 VSS VSS nmos W=0.31u L=0.04u
M4581 U3921/net36 g2235 VSS VSS nmos W=0.155u L=0.04u
M4582 U3921/net19 n3961 VDD VDD pmos W=0.205u L=0.04u
M4583 n3700 U3921/net19 U3921/net26 VDD pmos W=0.325u L=0.04u
M4584 U3921/net26 n3962 VDD VDD pmos W=0.41u L=0.04u
M4585 n3700 n3961 U3921/net30 VDD pmos W=0.325u L=0.04u
M4586 U3921/net30 g2235 VDD VDD pmos W=0.205u L=0.04u
M4587 n370 g24909 VSS VSS nmos W=0.135u L=0.04u
M4588 n370 g24909 VDD VDD pmos W=0.205u L=0.04u
M4589 U3923/net19 n3963 VSS VSS nmos W=0.155u L=0.04u
M4590 n3699 n3963 U3923/net40 VSS nmos W=0.155u L=0.04u
M4591 n3699 U3923/net19 U3923/net36 VSS nmos W=0.155u L=0.04u
M4592 U3923/net40 n3962 VSS VSS nmos W=0.31u L=0.04u
M4593 U3923/net36 g2236 VSS VSS nmos W=0.155u L=0.04u
M4594 U3923/net19 n3963 VDD VDD pmos W=0.205u L=0.04u
M4595 n3699 U3923/net19 U3923/net26 VDD pmos W=0.325u L=0.04u
M4596 U3923/net26 n3962 VDD VDD pmos W=0.41u L=0.04u
M4597 n3699 n3963 U3923/net30 VDD pmos W=0.325u L=0.04u
M4598 U3923/net30 g2236 VDD VDD pmos W=0.205u L=0.04u
M4599 U3924/net19 n3963 VSS VSS nmos W=0.155u L=0.04u
M4600 n3698 n3963 U3924/net40 VSS nmos W=0.155u L=0.04u
M4601 n3698 U3924/net19 U3924/net36 VSS nmos W=0.155u L=0.04u
M4602 U3924/net40 n3959 VSS VSS nmos W=0.31u L=0.04u
M4603 U3924/net36 g2239 VSS VSS nmos W=0.155u L=0.04u
M4604 U3924/net19 n3963 VDD VDD pmos W=0.205u L=0.04u
M4605 n3698 U3924/net19 U3924/net26 VDD pmos W=0.325u L=0.04u
M4606 U3924/net26 n3959 VDD VDD pmos W=0.41u L=0.04u
M4607 n3698 n3963 U3924/net30 VDD pmos W=0.325u L=0.04u
M4608 U3924/net30 g2239 VDD VDD pmos W=0.205u L=0.04u
M4609 U3925/net19 n3964 VSS VSS nmos W=0.155u L=0.04u
M4610 n3697 n3964 U3925/net40 VSS nmos W=0.155u L=0.04u
M4611 n3697 U3925/net19 U3925/net36 VSS nmos W=0.155u L=0.04u
M4612 U3925/net40 g2039 VSS VSS nmos W=0.31u L=0.04u
M4613 U3925/net36 n3852 VSS VSS nmos W=0.155u L=0.04u
M4614 U3925/net19 n3964 VDD VDD pmos W=0.205u L=0.04u
M4615 n3697 U3925/net19 U3925/net26 VDD pmos W=0.325u L=0.04u
M4616 U3925/net26 g2039 VDD VDD pmos W=0.41u L=0.04u
M4617 n3697 n3964 U3925/net30 VDD pmos W=0.325u L=0.04u
M4618 U3925/net30 n3852 VDD VDD pmos W=0.205u L=0.04u
M4619 U3926/net36 n3966 U3926/net24 VSS nmos W=0.155u L=0.04u
M4620 U3926/net24 n3967 VSS VSS nmos W=0.155u L=0.04u
M4621 n3696 g2020 U3926/net36 VSS nmos W=0.155u L=0.04u
M4622 n3696 n3965 U3926/net36 VSS nmos W=0.155u L=0.04u
M4623 n3696 n3965 U3926/net35 VDD pmos W=0.205u L=0.04u
M4624 U3926/net35 g2020 VDD VDD pmos W=0.205u L=0.04u
M4625 n3696 n3967 VDD VDD pmos W=0.205u L=0.04u
M4626 n3696 n3966 VDD VDD pmos W=0.205u L=0.04u
M4627 n3695 U3927/net27 VDD VDD pmos W=0.205u L=0.04u
M4628 U3927/net11 n3968 U3927/net27 VDD pmos W=0.205u L=0.04u
M4629 U3927/net11 n3966 U3927/net27 VDD pmos W=0.205u L=0.04u
M4630 U3927/net11 n3969 U3927/XI16-net11 VDD pmos W=0.205u L=0.04u
M4631 U3927/XI16-net11 n3970 VDD VDD pmos W=0.205u L=0.04u
M4632 U3927/net27 n3970 VSS VSS nmos W=0.155u L=0.04u
M4633 U3927/net27 n3969 VSS VSS nmos W=0.155u L=0.04u
M4634 n3695 U3927/net27 VSS VSS nmos W=0.155u L=0.04u
M4635 U3927/net27 n3968 U3927/XI12-net17 VSS nmos W=0.155u L=0.04u
M4636 U3927/XI12-net17 n3966 VSS VSS nmos W=0.155u L=0.04u
M4637 U3928/net36 n3971 U3928/net24 VSS nmos W=0.155u L=0.04u
M4638 U3928/net24 n3967 VSS VSS nmos W=0.155u L=0.04u
M4639 n3694 g2033 U3928/net36 VSS nmos W=0.155u L=0.04u
M4640 n3694 n3969 U3928/net36 VSS nmos W=0.155u L=0.04u
M4641 n3694 n3969 U3928/net35 VDD pmos W=0.205u L=0.04u
M4642 U3928/net35 g2033 VDD VDD pmos W=0.205u L=0.04u
M4643 n3694 n3967 VDD VDD pmos W=0.205u L=0.04u
M4644 n3694 n3971 VDD VDD pmos W=0.205u L=0.04u
M4645 n3693 U3929/net27 VDD VDD pmos W=0.205u L=0.04u
M4646 U3929/net11 n3972 U3929/net27 VDD pmos W=0.205u L=0.04u
M4647 U3929/net11 n3971 U3929/net27 VDD pmos W=0.205u L=0.04u
M4648 U3929/net11 n3973 U3929/XI16-net11 VDD pmos W=0.205u L=0.04u
M4649 U3929/XI16-net11 n3970 VDD VDD pmos W=0.205u L=0.04u
M4650 U3929/net27 n3970 VSS VSS nmos W=0.155u L=0.04u
M4651 U3929/net27 n3973 VSS VSS nmos W=0.155u L=0.04u
M4652 n3693 U3929/net27 VSS VSS nmos W=0.155u L=0.04u
M4653 U3929/net27 n3972 U3929/XI12-net17 VSS nmos W=0.155u L=0.04u
M4654 U3929/XI12-net17 n3971 VSS VSS nmos W=0.155u L=0.04u
M4655 U3930/net36 n3974 U3930/net24 VSS nmos W=0.155u L=0.04u
M4656 U3930/net24 n3967 VSS VSS nmos W=0.155u L=0.04u
M4657 n3692 g2040 U3930/net36 VSS nmos W=0.155u L=0.04u
M4658 n3692 n3973 U3930/net36 VSS nmos W=0.155u L=0.04u
M4659 n3692 n3973 U3930/net35 VDD pmos W=0.205u L=0.04u
M4660 U3930/net35 g2040 VDD VDD pmos W=0.205u L=0.04u
M4661 n3692 n3967 VDD VDD pmos W=0.205u L=0.04u
M4662 n3692 n3974 VDD VDD pmos W=0.205u L=0.04u
M4663 n3691 U3931/net27 VDD VDD pmos W=0.205u L=0.04u
M4664 U3931/net11 n3975 U3931/net27 VDD pmos W=0.205u L=0.04u
M4665 U3931/net11 n3974 U3931/net27 VDD pmos W=0.205u L=0.04u
M4666 U3931/net11 n3976 U3931/XI16-net11 VDD pmos W=0.205u L=0.04u
M4667 U3931/XI16-net11 n3970 VDD VDD pmos W=0.205u L=0.04u
M4668 U3931/net27 n3970 VSS VSS nmos W=0.155u L=0.04u
M4669 U3931/net27 n3976 VSS VSS nmos W=0.155u L=0.04u
M4670 n3691 U3931/net27 VSS VSS nmos W=0.155u L=0.04u
M4671 U3931/net27 n3975 U3931/XI12-net17 VSS nmos W=0.155u L=0.04u
M4672 U3931/XI12-net17 n3974 VSS VSS nmos W=0.155u L=0.04u
M4673 n3970 n3967 VSS VSS nmos W=0.135u L=0.04u
M4674 n3970 n3967 VDD VDD pmos W=0.205u L=0.04u
M4675 U3933/net36 n3977 U3933/net24 VSS nmos W=0.155u L=0.04u
M4676 U3933/net24 n3967 VSS VSS nmos W=0.155u L=0.04u
M4677 n3690 g2046 U3933/net36 VSS nmos W=0.155u L=0.04u
M4678 n3690 n3976 U3933/net36 VSS nmos W=0.155u L=0.04u
M4679 n3690 n3976 U3933/net35 VDD pmos W=0.205u L=0.04u
M4680 U3933/net35 g2046 VDD VDD pmos W=0.205u L=0.04u
M4681 n3690 n3967 VDD VDD pmos W=0.205u L=0.04u
M4682 n3690 n3977 VDD VDD pmos W=0.205u L=0.04u
M4683 U3934/net36 n3979 U3934/net24 VSS nmos W=0.155u L=0.04u
M4684 U3934/net24 n3967 VSS VSS nmos W=0.155u L=0.04u
M4685 n3689 g2059 U3934/net36 VSS nmos W=0.155u L=0.04u
M4686 n3689 n3978 U3934/net36 VSS nmos W=0.155u L=0.04u
M4687 n3689 n3978 U3934/net35 VDD pmos W=0.205u L=0.04u
M4688 U3934/net35 g2059 VDD VDD pmos W=0.205u L=0.04u
M4689 n3689 n3967 VDD VDD pmos W=0.205u L=0.04u
M4690 n3689 n3979 VDD VDD pmos W=0.205u L=0.04u
M4691 U3935/XU1-net6 n3967 VSS VSS nmos W=0.155u L=0.04u
M4692 n3688 n3980 U3935/XU1-net6 VSS nmos W=0.155u L=0.04u
M4693 n3688 n3967 VDD VDD pmos W=0.155u L=0.04u
M4694 n3688 n3980 VDD VDD pmos W=0.155u L=0.04u
M4695 U3936/net4 n3979 U3936/net14 VSS nmos W=0.155u L=0.04u
M4696 U3936/net6 U3936/net10 U3936/net14 VSS nmos W=0.17u L=0.04u
M4697 U3936/net4 g2066 VSS VSS nmos W=0.155u L=0.04u
M4698 U3936/net6 U3936/net4 VSS VSS nmos W=0.17u L=0.04u
M4699 n3980 U3936/net14 VSS VSS nmos W=0.155u L=0.04u
M4700 U3936/net10 n3979 VSS VSS nmos W=0.155u L=0.04u
M4701 U3936/net4 U3936/net10 U3936/net14 VDD pmos W=0.255u L=0.04u
M4702 U3936/net6 n3979 U3936/net14 VDD pmos W=0.28u L=0.04u
M4703 U3936/net4 g2066 VDD VDD pmos W=0.205u L=0.04u
M4704 U3936/net6 U3936/net4 VDD VDD pmos W=0.24u L=0.04u
M4705 n3980 U3936/net14 VDD VDD pmos W=0.205u L=0.04u
M4706 U3936/net10 n3979 VDD VDD pmos W=0.205u L=0.04u
M4707 U3937/XU1-net6 n3967 VSS VSS nmos W=0.155u L=0.04u
M4708 n3687 n3981 U3937/XU1-net6 VSS nmos W=0.155u L=0.04u
M4709 n3687 n3967 VDD VDD pmos W=0.155u L=0.04u
M4710 n3687 n3981 VDD VDD pmos W=0.155u L=0.04u
M4711 U3938/net4 n3982 U3938/net14 VSS nmos W=0.155u L=0.04u
M4712 U3938/net6 U3938/net10 U3938/net14 VSS nmos W=0.17u L=0.04u
M4713 U3938/net4 n3983 VSS VSS nmos W=0.155u L=0.04u
M4714 U3938/net6 U3938/net4 VSS VSS nmos W=0.17u L=0.04u
M4715 n3981 U3938/net14 VSS VSS nmos W=0.155u L=0.04u
M4716 U3938/net10 n3982 VSS VSS nmos W=0.155u L=0.04u
M4717 U3938/net4 U3938/net10 U3938/net14 VDD pmos W=0.255u L=0.04u
M4718 U3938/net6 n3982 U3938/net14 VDD pmos W=0.28u L=0.04u
M4719 U3938/net4 n3983 VDD VDD pmos W=0.205u L=0.04u
M4720 U3938/net6 U3938/net4 VDD VDD pmos W=0.24u L=0.04u
M4721 n3981 U3938/net14 VDD VDD pmos W=0.205u L=0.04u
M4722 U3938/net10 n3982 VDD VDD pmos W=0.205u L=0.04u
M4723 n3983 n3984 VSS VSS nmos W=0.155u L=0.04u
M4724 n3983 n3979 VSS VSS nmos W=0.155u L=0.04u
M4725 U3939/XI1-net8 n3979 VDD VDD pmos W=0.205u L=0.04u
M4726 n3983 n3984 U3939/XI1-net8 VDD pmos W=0.205u L=0.04u
M4727 U3940/XU1-net6 n3978 VSS VSS nmos W=0.155u L=0.04u
M4728 n3979 g2059 U3940/XU1-net6 VSS nmos W=0.155u L=0.04u
M4729 n3979 n3978 VDD VDD pmos W=0.155u L=0.04u
M4730 n3979 g2059 VDD VDD pmos W=0.155u L=0.04u
M4731 n3978 n3977 VSS VSS nmos W=0.135u L=0.04u
M4732 n3978 n3977 VDD VDD pmos W=0.205u L=0.04u
M4733 U3942/XU1-net6 n3976 VSS VSS nmos W=0.155u L=0.04u
M4734 n3977 g2046 U3942/XU1-net6 VSS nmos W=0.155u L=0.04u
M4735 n3977 n3976 VDD VDD pmos W=0.155u L=0.04u
M4736 n3977 g2046 VDD VDD pmos W=0.155u L=0.04u
M4737 n3976 n3975 VSS VSS nmos W=0.155u L=0.04u
M4738 n3976 n3974 VSS VSS nmos W=0.155u L=0.04u
M4739 U3943/XI1-net8 n3974 VDD VDD pmos W=0.205u L=0.04u
M4740 n3976 n3975 U3943/XI1-net8 VDD pmos W=0.205u L=0.04u
M4741 U3944/XU1-net6 n3973 VSS VSS nmos W=0.155u L=0.04u
M4742 n3974 g2040 U3944/XU1-net6 VSS nmos W=0.155u L=0.04u
M4743 n3974 n3973 VDD VDD pmos W=0.155u L=0.04u
M4744 n3974 g2040 VDD VDD pmos W=0.155u L=0.04u
M4745 n3973 n3972 VSS VSS nmos W=0.155u L=0.04u
M4746 n3973 n3971 VSS VSS nmos W=0.155u L=0.04u
M4747 U3945/XI1-net8 n3971 VDD VDD pmos W=0.205u L=0.04u
M4748 n3973 n3972 U3945/XI1-net8 VDD pmos W=0.205u L=0.04u
M4749 U3946/XU1-net6 n3969 VSS VSS nmos W=0.155u L=0.04u
M4750 n3971 g2033 U3946/XU1-net6 VSS nmos W=0.155u L=0.04u
M4751 n3971 n3969 VDD VDD pmos W=0.155u L=0.04u
M4752 n3971 g2033 VDD VDD pmos W=0.155u L=0.04u
M4753 n3969 n3968 VSS VSS nmos W=0.155u L=0.04u
M4754 n3969 n3966 VSS VSS nmos W=0.155u L=0.04u
M4755 U3947/XI1-net8 n3966 VDD VDD pmos W=0.205u L=0.04u
M4756 n3969 n3968 U3947/XI1-net8 VDD pmos W=0.205u L=0.04u
M4757 U3948/XU1-net6 n3965 VSS VSS nmos W=0.155u L=0.04u
M4758 n3966 g2020 U3948/XU1-net6 VSS nmos W=0.155u L=0.04u
M4759 n3966 n3965 VDD VDD pmos W=0.155u L=0.04u
M4760 n3966 g2020 VDD VDD pmos W=0.155u L=0.04u
M4761 n3965 n3964 VSS VSS nmos W=0.155u L=0.04u
M4762 n3965 g2039 VSS VSS nmos W=0.155u L=0.04u
M4763 U3949/XI1-net8 g2039 VDD VDD pmos W=0.205u L=0.04u
M4764 n3965 n3964 U3949/XI1-net8 VDD pmos W=0.205u L=0.04u
M4765 n3686 g2117 U3950/net15 VSS nmos W=0.155u L=0.04u
M4766 n3686 n3985 U3950/net15 VSS nmos W=0.155u L=0.04u
M4767 U3950/net15 n3986 VSS VSS nmos W=0.155u L=0.04u
M4768 n3686 n3986 VDD VDD pmos W=0.205u L=0.04u
M4769 n3686 g2117 U3950/XI16-net11 VDD pmos W=0.205u L=0.04u
M4770 U3950/XI16-net11 n3985 VDD VDD pmos W=0.205u L=0.04u
M4771 n3685 g2119 U3951/net15 VSS nmos W=0.155u L=0.04u
M4772 n3685 n3987 U3951/net15 VSS nmos W=0.155u L=0.04u
M4773 U3951/net15 n3967 VSS VSS nmos W=0.155u L=0.04u
M4774 n3685 n3967 VDD VDD pmos W=0.205u L=0.04u
M4775 n3685 g2119 U3951/XI16-net11 VDD pmos W=0.205u L=0.04u
M4776 U3951/XI16-net11 n3987 VDD VDD pmos W=0.205u L=0.04u
M4777 n3684 g2118 U3952/net15 VSS nmos W=0.155u L=0.04u
M4778 n3684 n3988 U3952/net15 VSS nmos W=0.155u L=0.04u
M4779 U3952/net15 n3989 VSS VSS nmos W=0.155u L=0.04u
M4780 n3684 n3989 VDD VDD pmos W=0.205u L=0.04u
M4781 n3684 g2118 U3952/XI16-net11 VDD pmos W=0.205u L=0.04u
M4782 U3952/XI16-net11 n3988 VDD VDD pmos W=0.205u L=0.04u
M4783 U3953/net19 n3985 VSS VSS nmos W=0.155u L=0.04u
M4784 n3683 n3985 U3953/net40 VSS nmos W=0.155u L=0.04u
M4785 n3683 U3953/net19 U3953/net36 VSS nmos W=0.155u L=0.04u
M4786 U3953/net40 n3990 VSS VSS nmos W=0.31u L=0.04u
M4787 U3953/net36 g2078 VSS VSS nmos W=0.155u L=0.04u
M4788 U3953/net19 n3985 VDD VDD pmos W=0.205u L=0.04u
M4789 n3683 U3953/net19 U3953/net26 VDD pmos W=0.325u L=0.04u
M4790 U3953/net26 n3990 VDD VDD pmos W=0.41u L=0.04u
M4791 n3683 n3985 U3953/net30 VDD pmos W=0.325u L=0.04u
M4792 U3953/net30 g2078 VDD VDD pmos W=0.205u L=0.04u
M4793 U3954/net19 n3985 VSS VSS nmos W=0.155u L=0.04u
M4794 n3682 n3985 U3954/net40 VSS nmos W=0.155u L=0.04u
M4795 n3682 U3954/net19 U3954/net36 VSS nmos W=0.155u L=0.04u
M4796 U3954/net40 n3982 VSS VSS nmos W=0.31u L=0.04u
M4797 U3954/net36 g2105 VSS VSS nmos W=0.155u L=0.04u
M4798 U3954/net19 n3985 VDD VDD pmos W=0.205u L=0.04u
M4799 n3682 U3954/net19 U3954/net26 VDD pmos W=0.325u L=0.04u
M4800 U3954/net26 n3982 VDD VDD pmos W=0.41u L=0.04u
M4801 n3682 n3985 U3954/net30 VDD pmos W=0.325u L=0.04u
M4802 U3954/net30 g2105 VDD VDD pmos W=0.205u L=0.04u
M4803 U3955/net19 n3985 VSS VSS nmos W=0.155u L=0.04u
M4804 n3681 n3985 U3955/net40 VSS nmos W=0.155u L=0.04u
M4805 n3681 U3955/net19 U3955/net36 VSS nmos W=0.155u L=0.04u
M4806 U3955/net40 n3968 VSS VSS nmos W=0.31u L=0.04u
M4807 U3955/net36 g2081 VSS VSS nmos W=0.155u L=0.04u
M4808 U3955/net19 n3985 VDD VDD pmos W=0.205u L=0.04u
M4809 n3681 U3955/net19 U3955/net26 VDD pmos W=0.325u L=0.04u
M4810 U3955/net26 n3968 VDD VDD pmos W=0.41u L=0.04u
M4811 n3681 n3985 U3955/net30 VDD pmos W=0.325u L=0.04u
M4812 U3955/net30 g2081 VDD VDD pmos W=0.205u L=0.04u
M4813 U3956/net19 n3985 VSS VSS nmos W=0.155u L=0.04u
M4814 n3680 n3985 U3956/net40 VSS nmos W=0.155u L=0.04u
M4815 n3680 U3956/net19 U3956/net36 VSS nmos W=0.155u L=0.04u
M4816 U3956/net40 n3991 VSS VSS nmos W=0.31u L=0.04u
M4817 U3956/net36 g2084 VSS VSS nmos W=0.155u L=0.04u
M4818 U3956/net19 n3985 VDD VDD pmos W=0.205u L=0.04u
M4819 n3680 U3956/net19 U3956/net26 VDD pmos W=0.325u L=0.04u
M4820 U3956/net26 n3991 VDD VDD pmos W=0.41u L=0.04u
M4821 n3680 n3985 U3956/net30 VDD pmos W=0.325u L=0.04u
M4822 U3956/net30 g2084 VDD VDD pmos W=0.205u L=0.04u
M4823 U3957/net19 n3985 VSS VSS nmos W=0.155u L=0.04u
M4824 n3679 n3985 U3957/net40 VSS nmos W=0.155u L=0.04u
M4825 n3679 U3957/net19 U3957/net36 VSS nmos W=0.155u L=0.04u
M4826 U3957/net40 n3972 VSS VSS nmos W=0.31u L=0.04u
M4827 U3957/net36 g2087 VSS VSS nmos W=0.155u L=0.04u
M4828 U3957/net19 n3985 VDD VDD pmos W=0.205u L=0.04u
M4829 n3679 U3957/net19 U3957/net26 VDD pmos W=0.325u L=0.04u
M4830 U3957/net26 n3972 VDD VDD pmos W=0.41u L=0.04u
M4831 n3679 n3985 U3957/net30 VDD pmos W=0.325u L=0.04u
M4832 U3957/net30 g2087 VDD VDD pmos W=0.205u L=0.04u
M4833 U3958/net19 n3985 VSS VSS nmos W=0.155u L=0.04u
M4834 n3678 n3985 U3958/net40 VSS nmos W=0.155u L=0.04u
M4835 n3678 U3958/net19 U3958/net36 VSS nmos W=0.155u L=0.04u
M4836 U3958/net40 n3992 VSS VSS nmos W=0.31u L=0.04u
M4837 U3958/net36 g2090 VSS VSS nmos W=0.155u L=0.04u
M4838 U3958/net19 n3985 VDD VDD pmos W=0.205u L=0.04u
M4839 n3678 U3958/net19 U3958/net26 VDD pmos W=0.325u L=0.04u
M4840 U3958/net26 n3992 VDD VDD pmos W=0.41u L=0.04u
M4841 n3678 n3985 U3958/net30 VDD pmos W=0.325u L=0.04u
M4842 U3958/net30 g2090 VDD VDD pmos W=0.205u L=0.04u
M4843 U3959/net19 n3985 VSS VSS nmos W=0.155u L=0.04u
M4844 n3677 n3985 U3959/net40 VSS nmos W=0.155u L=0.04u
M4845 n3677 U3959/net19 U3959/net36 VSS nmos W=0.155u L=0.04u
M4846 U3959/net40 n3975 VSS VSS nmos W=0.31u L=0.04u
M4847 U3959/net36 g2093 VSS VSS nmos W=0.155u L=0.04u
M4848 U3959/net19 n3985 VDD VDD pmos W=0.205u L=0.04u
M4849 n3677 U3959/net19 U3959/net26 VDD pmos W=0.325u L=0.04u
M4850 U3959/net26 n3975 VDD VDD pmos W=0.41u L=0.04u
M4851 n3677 n3985 U3959/net30 VDD pmos W=0.325u L=0.04u
M4852 U3959/net30 g2093 VDD VDD pmos W=0.205u L=0.04u
M4853 U3960/net19 n3985 VSS VSS nmos W=0.155u L=0.04u
M4854 n3676 n3985 U3960/net40 VSS nmos W=0.155u L=0.04u
M4855 n3676 U3960/net19 U3960/net36 VSS nmos W=0.155u L=0.04u
M4856 U3960/net40 n3993 VSS VSS nmos W=0.31u L=0.04u
M4857 U3960/net36 g2096 VSS VSS nmos W=0.155u L=0.04u
M4858 U3960/net19 n3985 VDD VDD pmos W=0.205u L=0.04u
M4859 n3676 U3960/net19 U3960/net26 VDD pmos W=0.325u L=0.04u
M4860 U3960/net26 n3993 VDD VDD pmos W=0.41u L=0.04u
M4861 n3676 n3985 U3960/net30 VDD pmos W=0.325u L=0.04u
M4862 U3960/net30 g2096 VDD VDD pmos W=0.205u L=0.04u
M4863 U3961/net19 n3985 VSS VSS nmos W=0.155u L=0.04u
M4864 n3675 n3985 U3961/net40 VSS nmos W=0.155u L=0.04u
M4865 n3675 U3961/net19 U3961/net36 VSS nmos W=0.155u L=0.04u
M4866 U3961/net40 n3994 VSS VSS nmos W=0.31u L=0.04u
M4867 U3961/net36 g2114 VSS VSS nmos W=0.155u L=0.04u
M4868 U3961/net19 n3985 VDD VDD pmos W=0.205u L=0.04u
M4869 n3675 U3961/net19 U3961/net26 VDD pmos W=0.325u L=0.04u
M4870 U3961/net26 n3994 VDD VDD pmos W=0.41u L=0.04u
M4871 n3675 n3985 U3961/net30 VDD pmos W=0.325u L=0.04u
M4872 U3961/net30 g2114 VDD VDD pmos W=0.205u L=0.04u
M4873 U3962/net19 n3985 VSS VSS nmos W=0.155u L=0.04u
M4874 n3674 n3985 U3962/net40 VSS nmos W=0.155u L=0.04u
M4875 n3674 U3962/net19 U3962/net36 VSS nmos W=0.155u L=0.04u
M4876 U3962/net40 n3995 VSS VSS nmos W=0.31u L=0.04u
M4877 U3962/net36 g2099 VSS VSS nmos W=0.155u L=0.04u
M4878 U3962/net19 n3985 VDD VDD pmos W=0.205u L=0.04u
M4879 n3674 U3962/net19 U3962/net26 VDD pmos W=0.325u L=0.04u
M4880 U3962/net26 n3995 VDD VDD pmos W=0.41u L=0.04u
M4881 n3674 n3985 U3962/net30 VDD pmos W=0.325u L=0.04u
M4882 U3962/net30 g2099 VDD VDD pmos W=0.205u L=0.04u
M4883 U3963/net19 n3985 VSS VSS nmos W=0.155u L=0.04u
M4884 n3673 n3985 U3963/net40 VSS nmos W=0.155u L=0.04u
M4885 n3673 U3963/net19 U3963/net36 VSS nmos W=0.155u L=0.04u
M4886 U3963/net40 n3984 VSS VSS nmos W=0.31u L=0.04u
M4887 U3963/net36 g2102 VSS VSS nmos W=0.155u L=0.04u
M4888 U3963/net19 n3985 VDD VDD pmos W=0.205u L=0.04u
M4889 n3673 U3963/net19 U3963/net26 VDD pmos W=0.325u L=0.04u
M4890 U3963/net26 n3984 VDD VDD pmos W=0.41u L=0.04u
M4891 n3673 n3985 U3963/net30 VDD pmos W=0.325u L=0.04u
M4892 U3963/net30 g2102 VDD VDD pmos W=0.205u L=0.04u
M4893 n3985 n3996 VSS VSS nmos W=0.155u L=0.04u
M4894 n3985 n3964 VSS VSS nmos W=0.155u L=0.04u
M4895 U3964/XI1-net8 n3964 VDD VDD pmos W=0.205u L=0.04u
M4896 n3985 n3996 U3964/XI1-net8 VDD pmos W=0.205u L=0.04u
M4897 U3965/net19 n3987 VSS VSS nmos W=0.155u L=0.04u
M4898 n3672 n3987 U3965/net40 VSS nmos W=0.155u L=0.04u
M4899 n3672 U3965/net19 U3965/net36 VSS nmos W=0.155u L=0.04u
M4900 U3965/net40 n3990 VSS VSS nmos W=0.31u L=0.04u
M4901 U3965/net36 g2080 VSS VSS nmos W=0.155u L=0.04u
M4902 U3965/net19 n3987 VDD VDD pmos W=0.205u L=0.04u
M4903 n3672 U3965/net19 U3965/net26 VDD pmos W=0.325u L=0.04u
M4904 U3965/net26 n3990 VDD VDD pmos W=0.41u L=0.04u
M4905 n3672 n3987 U3965/net30 VDD pmos W=0.325u L=0.04u
M4906 U3965/net30 g2080 VDD VDD pmos W=0.205u L=0.04u
M4907 U3966/net19 n3987 VSS VSS nmos W=0.155u L=0.04u
M4908 n3671 n3987 U3966/net40 VSS nmos W=0.155u L=0.04u
M4909 n3671 U3966/net19 U3966/net36 VSS nmos W=0.155u L=0.04u
M4910 U3966/net40 n3982 VSS VSS nmos W=0.31u L=0.04u
M4911 U3966/net36 g2107 VSS VSS nmos W=0.155u L=0.04u
M4912 U3966/net19 n3987 VDD VDD pmos W=0.205u L=0.04u
M4913 n3671 U3966/net19 U3966/net26 VDD pmos W=0.325u L=0.04u
M4914 U3966/net26 n3982 VDD VDD pmos W=0.41u L=0.04u
M4915 n3671 n3987 U3966/net30 VDD pmos W=0.325u L=0.04u
M4916 U3966/net30 g2107 VDD VDD pmos W=0.205u L=0.04u
M4917 U3967/net19 n3988 VSS VSS nmos W=0.155u L=0.04u
M4918 n3670 n3988 U3967/net40 VSS nmos W=0.155u L=0.04u
M4919 n3670 U3967/net19 U3967/net36 VSS nmos W=0.155u L=0.04u
M4920 U3967/net40 n3990 VSS VSS nmos W=0.31u L=0.04u
M4921 U3967/net36 g2079 VSS VSS nmos W=0.155u L=0.04u
M4922 U3967/net19 n3988 VDD VDD pmos W=0.205u L=0.04u
M4923 n3670 U3967/net19 U3967/net26 VDD pmos W=0.325u L=0.04u
M4924 U3967/net26 n3990 VDD VDD pmos W=0.41u L=0.04u
M4925 n3670 n3988 U3967/net30 VDD pmos W=0.325u L=0.04u
M4926 U3967/net30 g2079 VDD VDD pmos W=0.205u L=0.04u
M4927 U3968/net19 n3987 VSS VSS nmos W=0.155u L=0.04u
M4928 n3669 n3987 U3968/net40 VSS nmos W=0.155u L=0.04u
M4929 n3669 U3968/net19 U3968/net36 VSS nmos W=0.155u L=0.04u
M4930 U3968/net40 n3968 VSS VSS nmos W=0.31u L=0.04u
M4931 U3968/net36 g2083 VSS VSS nmos W=0.155u L=0.04u
M4932 U3968/net19 n3987 VDD VDD pmos W=0.205u L=0.04u
M4933 n3669 U3968/net19 U3968/net26 VDD pmos W=0.325u L=0.04u
M4934 U3968/net26 n3968 VDD VDD pmos W=0.41u L=0.04u
M4935 n3669 n3987 U3968/net30 VDD pmos W=0.325u L=0.04u
M4936 U3968/net30 g2083 VDD VDD pmos W=0.205u L=0.04u
M4937 U3969/net19 n3988 VSS VSS nmos W=0.155u L=0.04u
M4938 n3668 n3988 U3969/net40 VSS nmos W=0.155u L=0.04u
M4939 n3668 U3969/net19 U3969/net36 VSS nmos W=0.155u L=0.04u
M4940 U3969/net40 n3982 VSS VSS nmos W=0.31u L=0.04u
M4941 U3969/net36 g2106 VSS VSS nmos W=0.155u L=0.04u
M4942 U3969/net19 n3988 VDD VDD pmos W=0.205u L=0.04u
M4943 n3668 U3969/net19 U3969/net26 VDD pmos W=0.325u L=0.04u
M4944 U3969/net26 n3982 VDD VDD pmos W=0.41u L=0.04u
M4945 n3668 n3988 U3969/net30 VDD pmos W=0.325u L=0.04u
M4946 U3969/net30 g2106 VDD VDD pmos W=0.205u L=0.04u
M4947 n3982 g2072 VSS VSS nmos W=0.135u L=0.04u
M4948 n3982 g2072 VDD VDD pmos W=0.205u L=0.04u
M4949 U3971/net19 n3988 VSS VSS nmos W=0.155u L=0.04u
M4950 n3667 n3988 U3971/net40 VSS nmos W=0.155u L=0.04u
M4951 n3667 U3971/net19 U3971/net36 VSS nmos W=0.155u L=0.04u
M4952 U3971/net40 n3968 VSS VSS nmos W=0.31u L=0.04u
M4953 U3971/net36 g2082 VSS VSS nmos W=0.155u L=0.04u
M4954 U3971/net19 n3988 VDD VDD pmos W=0.205u L=0.04u
M4955 n3667 U3971/net19 U3971/net26 VDD pmos W=0.325u L=0.04u
M4956 U3971/net26 n3968 VDD VDD pmos W=0.41u L=0.04u
M4957 n3667 n3988 U3971/net30 VDD pmos W=0.325u L=0.04u
M4958 U3971/net30 g2082 VDD VDD pmos W=0.205u L=0.04u
M4959 n3968 g2013 VSS VSS nmos W=0.135u L=0.04u
M4960 n3968 g2013 VDD VDD pmos W=0.205u L=0.04u
M4961 U3973/net19 n3987 VSS VSS nmos W=0.155u L=0.04u
M4962 n3666 n3987 U3973/net40 VSS nmos W=0.155u L=0.04u
M4963 n3666 U3973/net19 U3973/net36 VSS nmos W=0.155u L=0.04u
M4964 U3973/net40 n3991 VSS VSS nmos W=0.31u L=0.04u
M4965 U3973/net36 g2086 VSS VSS nmos W=0.155u L=0.04u
M4966 U3973/net19 n3987 VDD VDD pmos W=0.205u L=0.04u
M4967 n3666 U3973/net19 U3973/net26 VDD pmos W=0.325u L=0.04u
M4968 U3973/net26 n3991 VDD VDD pmos W=0.41u L=0.04u
M4969 n3666 n3987 U3973/net30 VDD pmos W=0.325u L=0.04u
M4970 U3973/net30 g2086 VDD VDD pmos W=0.205u L=0.04u
M4971 U3974/net19 n3988 VSS VSS nmos W=0.155u L=0.04u
M4972 n3665 n3988 U3974/net40 VSS nmos W=0.155u L=0.04u
M4973 n3665 U3974/net19 U3974/net36 VSS nmos W=0.155u L=0.04u
M4974 U3974/net40 n3991 VSS VSS nmos W=0.31u L=0.04u
M4975 U3974/net36 g2085 VSS VSS nmos W=0.155u L=0.04u
M4976 U3974/net19 n3988 VDD VDD pmos W=0.205u L=0.04u
M4977 n3665 U3974/net19 U3974/net26 VDD pmos W=0.325u L=0.04u
M4978 U3974/net26 n3991 VDD VDD pmos W=0.41u L=0.04u
M4979 n3665 n3988 U3974/net30 VDD pmos W=0.325u L=0.04u
M4980 U3974/net30 g2085 VDD VDD pmos W=0.205u L=0.04u
M4981 n3991 g2033 VSS VSS nmos W=0.135u L=0.04u
M4982 n3991 g2033 VDD VDD pmos W=0.205u L=0.04u
M4983 U3976/net19 n3987 VSS VSS nmos W=0.155u L=0.04u
M4984 n3664 n3987 U3976/net40 VSS nmos W=0.155u L=0.04u
M4985 n3664 U3976/net19 U3976/net36 VSS nmos W=0.155u L=0.04u
M4986 U3976/net40 n3972 VSS VSS nmos W=0.31u L=0.04u
M4987 U3976/net36 g2089 VSS VSS nmos W=0.155u L=0.04u
M4988 U3976/net19 n3987 VDD VDD pmos W=0.205u L=0.04u
M4989 n3664 U3976/net19 U3976/net26 VDD pmos W=0.325u L=0.04u
M4990 U3976/net26 n3972 VDD VDD pmos W=0.41u L=0.04u
M4991 n3664 n3987 U3976/net30 VDD pmos W=0.325u L=0.04u
M4992 U3976/net30 g2089 VDD VDD pmos W=0.205u L=0.04u
M4993 U3977/net19 n3988 VSS VSS nmos W=0.155u L=0.04u
M4994 n3663 n3988 U3977/net40 VSS nmos W=0.155u L=0.04u
M4995 n3663 U3977/net19 U3977/net36 VSS nmos W=0.155u L=0.04u
M4996 U3977/net40 n3972 VSS VSS nmos W=0.31u L=0.04u
M4997 U3977/net36 g2088 VSS VSS nmos W=0.155u L=0.04u
M4998 U3977/net19 n3988 VDD VDD pmos W=0.205u L=0.04u
M4999 n3663 U3977/net19 U3977/net26 VDD pmos W=0.325u L=0.04u
M5000 U3977/net26 n3972 VDD VDD pmos W=0.41u L=0.04u
M5001 n3663 n3988 U3977/net30 VDD pmos W=0.325u L=0.04u
M5002 U3977/net30 g2088 VDD VDD pmos W=0.205u L=0.04u
M5003 n3972 g2026 VSS VSS nmos W=0.135u L=0.04u
M5004 n3972 g2026 VDD VDD pmos W=0.205u L=0.04u
M5005 U3979/net19 n3987 VSS VSS nmos W=0.155u L=0.04u
M5006 n3662 n3987 U3979/net40 VSS nmos W=0.155u L=0.04u
M5007 n3662 U3979/net19 U3979/net36 VSS nmos W=0.155u L=0.04u
M5008 U3979/net40 n3992 VSS VSS nmos W=0.31u L=0.04u
M5009 U3979/net36 g2092 VSS VSS nmos W=0.155u L=0.04u
M5010 U3979/net19 n3987 VDD VDD pmos W=0.205u L=0.04u
M5011 n3662 U3979/net19 U3979/net26 VDD pmos W=0.325u L=0.04u
M5012 U3979/net26 n3992 VDD VDD pmos W=0.41u L=0.04u
M5013 n3662 n3987 U3979/net30 VDD pmos W=0.325u L=0.04u
M5014 U3979/net30 g2092 VDD VDD pmos W=0.205u L=0.04u
M5015 U3980/net19 n3988 VSS VSS nmos W=0.155u L=0.04u
M5016 n3661 n3988 U3980/net40 VSS nmos W=0.155u L=0.04u
M5017 n3661 U3980/net19 U3980/net36 VSS nmos W=0.155u L=0.04u
M5018 U3980/net40 n3992 VSS VSS nmos W=0.31u L=0.04u
M5019 U3980/net36 g2091 VSS VSS nmos W=0.155u L=0.04u
M5020 U3980/net19 n3988 VDD VDD pmos W=0.205u L=0.04u
M5021 n3661 U3980/net19 U3980/net26 VDD pmos W=0.325u L=0.04u
M5022 U3980/net26 n3992 VDD VDD pmos W=0.41u L=0.04u
M5023 n3661 n3988 U3980/net30 VDD pmos W=0.325u L=0.04u
M5024 U3980/net30 g2091 VDD VDD pmos W=0.205u L=0.04u
M5025 n3992 g2040 VSS VSS nmos W=0.135u L=0.04u
M5026 n3992 g2040 VDD VDD pmos W=0.205u L=0.04u
M5027 U3982/net19 n3987 VSS VSS nmos W=0.155u L=0.04u
M5028 n3660 n3987 U3982/net40 VSS nmos W=0.155u L=0.04u
M5029 n3660 U3982/net19 U3982/net36 VSS nmos W=0.155u L=0.04u
M5030 U3982/net40 n3975 VSS VSS nmos W=0.31u L=0.04u
M5031 U3982/net36 g2095 VSS VSS nmos W=0.155u L=0.04u
M5032 U3982/net19 n3987 VDD VDD pmos W=0.205u L=0.04u
M5033 n3660 U3982/net19 U3982/net26 VDD pmos W=0.325u L=0.04u
M5034 U3982/net26 n3975 VDD VDD pmos W=0.41u L=0.04u
M5035 n3660 n3987 U3982/net30 VDD pmos W=0.325u L=0.04u
M5036 U3982/net30 g2095 VDD VDD pmos W=0.205u L=0.04u
M5037 n366 g23919 VSS VSS nmos W=0.135u L=0.04u
M5038 n366 g23919 VDD VDD pmos W=0.205u L=0.04u
M5039 U3984/net19 n3988 VSS VSS nmos W=0.155u L=0.04u
M5040 n3659 n3988 U3984/net40 VSS nmos W=0.155u L=0.04u
M5041 n3659 U3984/net19 U3984/net36 VSS nmos W=0.155u L=0.04u
M5042 U3984/net40 n3975 VSS VSS nmos W=0.31u L=0.04u
M5043 U3984/net36 g2094 VSS VSS nmos W=0.155u L=0.04u
M5044 U3984/net19 n3988 VDD VDD pmos W=0.205u L=0.04u
M5045 n3659 U3984/net19 U3984/net26 VDD pmos W=0.325u L=0.04u
M5046 U3984/net26 n3975 VDD VDD pmos W=0.41u L=0.04u
M5047 n3659 n3988 U3984/net30 VDD pmos W=0.325u L=0.04u
M5048 U3984/net30 g2094 VDD VDD pmos W=0.205u L=0.04u
M5049 U3985/net19 n3987 VSS VSS nmos W=0.155u L=0.04u
M5050 n3658 n3987 U3985/net40 VSS nmos W=0.155u L=0.04u
M5051 n3658 U3985/net19 U3985/net36 VSS nmos W=0.155u L=0.04u
M5052 U3985/net40 n3993 VSS VSS nmos W=0.31u L=0.04u
M5053 U3985/net36 g2098 VSS VSS nmos W=0.155u L=0.04u
M5054 U3985/net19 n3987 VDD VDD pmos W=0.205u L=0.04u
M5055 n3658 U3985/net19 U3985/net26 VDD pmos W=0.325u L=0.04u
M5056 U3985/net26 n3993 VDD VDD pmos W=0.41u L=0.04u
M5057 n3658 n3987 U3985/net30 VDD pmos W=0.325u L=0.04u
M5058 U3985/net30 g2098 VDD VDD pmos W=0.205u L=0.04u
M5059 U3986/net19 n3987 VSS VSS nmos W=0.155u L=0.04u
M5060 n3657 n3987 U3986/net40 VSS nmos W=0.155u L=0.04u
M5061 n3657 U3986/net19 U3986/net36 VSS nmos W=0.155u L=0.04u
M5062 U3986/net40 n3994 VSS VSS nmos W=0.31u L=0.04u
M5063 U3986/net36 g2116 VSS VSS nmos W=0.155u L=0.04u
M5064 U3986/net19 n3987 VDD VDD pmos W=0.205u L=0.04u
M5065 n3657 U3986/net19 U3986/net26 VDD pmos W=0.325u L=0.04u
M5066 U3986/net26 n3994 VDD VDD pmos W=0.41u L=0.04u
M5067 n3657 n3987 U3986/net30 VDD pmos W=0.325u L=0.04u
M5068 U3986/net30 g2116 VDD VDD pmos W=0.205u L=0.04u
M5069 U3987/net19 n3988 VSS VSS nmos W=0.155u L=0.04u
M5070 n3656 n3988 U3987/net40 VSS nmos W=0.155u L=0.04u
M5071 n3656 U3987/net19 U3987/net36 VSS nmos W=0.155u L=0.04u
M5072 U3987/net40 n3993 VSS VSS nmos W=0.31u L=0.04u
M5073 U3987/net36 g2097 VSS VSS nmos W=0.155u L=0.04u
M5074 U3987/net19 n3988 VDD VDD pmos W=0.205u L=0.04u
M5075 n3656 U3987/net19 U3987/net26 VDD pmos W=0.325u L=0.04u
M5076 U3987/net26 n3993 VDD VDD pmos W=0.41u L=0.04u
M5077 n3656 n3988 U3987/net30 VDD pmos W=0.325u L=0.04u
M5078 U3987/net30 g2097 VDD VDD pmos W=0.205u L=0.04u
M5079 U3988/net19 n3987 VSS VSS nmos W=0.155u L=0.04u
M5080 n3655 n3987 U3988/net40 VSS nmos W=0.155u L=0.04u
M5081 n3655 U3988/net19 U3988/net36 VSS nmos W=0.155u L=0.04u
M5082 U3988/net40 n3995 VSS VSS nmos W=0.31u L=0.04u
M5083 U3988/net36 g2101 VSS VSS nmos W=0.155u L=0.04u
M5084 U3988/net19 n3987 VDD VDD pmos W=0.205u L=0.04u
M5085 n3655 U3988/net19 U3988/net26 VDD pmos W=0.325u L=0.04u
M5086 U3988/net26 n3995 VDD VDD pmos W=0.41u L=0.04u
M5087 n3655 n3987 U3988/net30 VDD pmos W=0.325u L=0.04u
M5088 U3988/net30 g2101 VDD VDD pmos W=0.205u L=0.04u
M5089 U3989/net19 n3988 VSS VSS nmos W=0.155u L=0.04u
M5090 n3654 n3988 U3989/net40 VSS nmos W=0.155u L=0.04u
M5091 n3654 U3989/net19 U3989/net36 VSS nmos W=0.155u L=0.04u
M5092 U3989/net40 n3994 VSS VSS nmos W=0.31u L=0.04u
M5093 U3989/net36 g2115 VSS VSS nmos W=0.155u L=0.04u
M5094 U3989/net19 n3988 VDD VDD pmos W=0.205u L=0.04u
M5095 n3654 U3989/net19 U3989/net26 VDD pmos W=0.325u L=0.04u
M5096 U3989/net26 n3994 VDD VDD pmos W=0.41u L=0.04u
M5097 n3654 n3988 U3989/net30 VDD pmos W=0.325u L=0.04u
M5098 U3989/net30 g2115 VDD VDD pmos W=0.205u L=0.04u
M5099 U3990/net36 n3998 U3990/net24 VSS nmos W=0.155u L=0.04u
M5100 U3990/net24 n3999 VSS VSS nmos W=0.155u L=0.04u
M5101 U3990/net33 g2109 U3990/net36 VSS nmos W=0.155u L=0.04u
M5102 U3990/net33 n3997 U3990/net36 VSS nmos W=0.155u L=0.04u
M5103 n3994 U3990/net33 VSS VSS nmos W=0.155u L=0.04u
M5104 n3994 U3990/net33 VDD VDD pmos W=0.205u L=0.04u
M5105 U3990/net33 n3997 U3990/net35 VDD pmos W=0.205u L=0.04u
M5106 U3990/net35 g2109 VDD VDD pmos W=0.205u L=0.04u
M5107 U3990/net33 n3999 VDD VDD pmos W=0.205u L=0.04u
M5108 U3990/net33 n3998 VDD VDD pmos W=0.205u L=0.04u
M5109 n3999 g2009 U3991/XI21-net17 VSS nmos W=0.155u L=0.04u
M5110 U3991/XI21-net17 n4003 VSS VSS nmos W=0.155u L=0.04u
M5111 n3999 n4000 U3991/XI6-net17 VSS nmos W=0.155u L=0.04u
M5112 U3991/XI6-net17 n4001 VSS VSS nmos W=0.155u L=0.04u
M5113 n3999 g7357 U3991/XI20-net17 VSS nmos W=0.155u L=0.04u
M5114 U3991/XI20-net17 n4002 VSS VSS nmos W=0.155u L=0.04u
M5115 VDD g2009 U3991/net22 VDD pmos W=0.205u L=0.04u
M5116 VDD n4003 U3991/net22 VDD pmos W=0.205u L=0.04u
M5117 U3991/net16 n4000 n3999 VDD pmos W=0.205u L=0.04u
M5118 U3991/net16 n4001 n3999 VDD pmos W=0.205u L=0.04u
M5119 U3991/net22 g7357 U3991/net16 VDD pmos W=0.205u L=0.04u
M5120 U3991/net22 n4002 U3991/net16 VDD pmos W=0.205u L=0.04u
M5121 n4003 g2108 VSS VSS nmos W=0.135u L=0.04u
M5122 n4003 g2108 VDD VDD pmos W=0.205u L=0.04u
M5123 n4002 g2110 VSS VSS nmos W=0.135u L=0.04u
M5124 n4002 g2110 VDD VDD pmos W=0.205u L=0.04u
M5125 n4001 n4007 VSS VSS nmos W=0.155u L=0.04u
M5126 n4001 n4006 VSS VSS nmos W=0.155u L=0.04u
M5127 n4001 n4005 VSS VSS nmos W=0.155u L=0.04u
M5128 n4001 n4004 VSS VSS nmos W=0.155u L=0.04u
M5129 U3994/net49 n4006 U3994/net52 VDD pmos W=0.41u L=0.04u
M5130 U3994/net52 n4007 VDD VDD pmos W=0.41u L=0.04u
M5131 U3994/net46 n4005 U3994/net49 VDD pmos W=0.41u L=0.04u
M5132 n4001 n4004 U3994/net46 VDD pmos W=0.41u L=0.04u
M5133 U3995/net4 n4008 U3995/net14 VSS nmos W=0.155u L=0.04u
M5134 U3995/net6 U3995/net10 U3995/net14 VSS nmos W=0.17u L=0.04u
M5135 U3995/net4 g2066 VSS VSS nmos W=0.155u L=0.04u
M5136 U3995/net6 U3995/net4 VSS VSS nmos W=0.17u L=0.04u
M5137 n4007 U3995/net14 VSS VSS nmos W=0.155u L=0.04u
M5138 U3995/net10 n4008 VSS VSS nmos W=0.155u L=0.04u
M5139 U3995/net4 U3995/net10 U3995/net14 VDD pmos W=0.255u L=0.04u
M5140 U3995/net6 n4008 U3995/net14 VDD pmos W=0.28u L=0.04u
M5141 U3995/net4 g2066 VDD VDD pmos W=0.205u L=0.04u
M5142 U3995/net6 U3995/net4 VDD VDD pmos W=0.24u L=0.04u
M5143 n4007 U3995/net14 VDD VDD pmos W=0.205u L=0.04u
M5144 U3995/net10 n4008 VDD VDD pmos W=0.205u L=0.04u
M5145 U3996/net4 n4009 U3996/net14 VSS nmos W=0.155u L=0.04u
M5146 U3996/net6 U3996/net10 U3996/net14 VSS nmos W=0.17u L=0.04u
M5147 U3996/net4 g2072 VSS VSS nmos W=0.155u L=0.04u
M5148 U3996/net6 U3996/net4 VSS VSS nmos W=0.17u L=0.04u
M5149 n4006 U3996/net14 VSS VSS nmos W=0.155u L=0.04u
M5150 U3996/net10 n4009 VSS VSS nmos W=0.155u L=0.04u
M5151 U3996/net4 U3996/net10 U3996/net14 VDD pmos W=0.255u L=0.04u
M5152 U3996/net6 n4009 U3996/net14 VDD pmos W=0.28u L=0.04u
M5153 U3996/net4 g2072 VDD VDD pmos W=0.205u L=0.04u
M5154 U3996/net6 U3996/net4 VDD VDD pmos W=0.24u L=0.04u
M5155 n4006 U3996/net14 VDD VDD pmos W=0.205u L=0.04u
M5156 U3996/net10 n4009 VDD VDD pmos W=0.205u L=0.04u
M5157 U3997/net4 n4010 U3997/net14 VSS nmos W=0.155u L=0.04u
M5158 U3997/net6 U3997/net10 U3997/net14 VSS nmos W=0.17u L=0.04u
M5159 U3997/net4 g2033 VSS VSS nmos W=0.155u L=0.04u
M5160 U3997/net6 U3997/net4 VSS VSS nmos W=0.17u L=0.04u
M5161 n4005 U3997/net14 VSS VSS nmos W=0.155u L=0.04u
M5162 U3997/net10 n4010 VSS VSS nmos W=0.155u L=0.04u
M5163 U3997/net4 U3997/net10 U3997/net14 VDD pmos W=0.255u L=0.04u
M5164 U3997/net6 n4010 U3997/net14 VDD pmos W=0.28u L=0.04u
M5165 U3997/net4 g2033 VDD VDD pmos W=0.205u L=0.04u
M5166 U3997/net6 U3997/net4 VDD VDD pmos W=0.24u L=0.04u
M5167 n4005 U3997/net14 VDD VDD pmos W=0.205u L=0.04u
M5168 U3997/net10 n4010 VDD VDD pmos W=0.205u L=0.04u
M5169 U3998/XU1-net6 n4012 VSS VSS nmos W=0.155u L=0.04u
M5170 n4004 n4011 U3998/XU1-net6 VSS nmos W=0.155u L=0.04u
M5171 n4004 n4012 VDD VDD pmos W=0.155u L=0.04u
M5172 n4004 n4011 VDD VDD pmos W=0.155u L=0.04u
M5173 U3999/net4 g2013 U3999/net14 VSS nmos W=0.155u L=0.04u
M5174 U3999/net6 U3999/net10 U3999/net14 VSS nmos W=0.17u L=0.04u
M5175 U3999/net4 n4013 VSS VSS nmos W=0.155u L=0.04u
M5176 U3999/net6 U3999/net4 VSS VSS nmos W=0.17u L=0.04u
M5177 n4012 U3999/net14 VSS VSS nmos W=0.155u L=0.04u
M5178 U3999/net10 g2013 VSS VSS nmos W=0.155u L=0.04u
M5179 U3999/net4 U3999/net10 U3999/net14 VDD pmos W=0.255u L=0.04u
M5180 U3999/net6 g2013 U3999/net14 VDD pmos W=0.28u L=0.04u
M5181 U3999/net4 n4013 VDD VDD pmos W=0.205u L=0.04u
M5182 U3999/net6 U3999/net4 VDD VDD pmos W=0.24u L=0.04u
M5183 n4012 U3999/net14 VDD VDD pmos W=0.205u L=0.04u
M5184 U3999/net10 g2013 VDD VDD pmos W=0.205u L=0.04u
M5185 U4000/net4 g2026 U4000/net14 VSS nmos W=0.155u L=0.04u
M5186 U4000/net6 U4000/net10 U4000/net14 VSS nmos W=0.17u L=0.04u
M5187 U4000/net4 n4014 VSS VSS nmos W=0.155u L=0.04u
M5188 U4000/net6 U4000/net4 VSS VSS nmos W=0.17u L=0.04u
M5189 n4011 U4000/net14 VSS VSS nmos W=0.155u L=0.04u
M5190 U4000/net10 g2026 VSS VSS nmos W=0.155u L=0.04u
M5191 U4000/net4 U4000/net10 U4000/net14 VDD pmos W=0.255u L=0.04u
M5192 U4000/net6 g2026 U4000/net14 VDD pmos W=0.28u L=0.04u
M5193 U4000/net4 n4014 VDD VDD pmos W=0.205u L=0.04u
M5194 U4000/net6 U4000/net4 VDD VDD pmos W=0.24u L=0.04u
M5195 n4011 U4000/net14 VDD VDD pmos W=0.205u L=0.04u
M5196 U4000/net10 g2026 VDD VDD pmos W=0.205u L=0.04u
M5197 n4000 n4018 VSS VSS nmos W=0.155u L=0.04u
M5198 n4000 n4017 VSS VSS nmos W=0.155u L=0.04u
M5199 n4000 n4016 VSS VSS nmos W=0.155u L=0.04u
M5200 n4000 n4015 VSS VSS nmos W=0.155u L=0.04u
M5201 U4001/net49 n4017 U4001/net52 VDD pmos W=0.41u L=0.04u
M5202 U4001/net52 n4018 VDD VDD pmos W=0.41u L=0.04u
M5203 U4001/net46 n4016 U4001/net49 VDD pmos W=0.41u L=0.04u
M5204 n4000 n4015 U4001/net46 VDD pmos W=0.41u L=0.04u
M5205 U4002/net4 n4019 U4002/net14 VSS nmos W=0.155u L=0.04u
M5206 U4002/net6 U4002/net10 U4002/net14 VSS nmos W=0.17u L=0.04u
M5207 U4002/net4 n3993 VSS VSS nmos W=0.155u L=0.04u
M5208 U4002/net6 U4002/net4 VSS VSS nmos W=0.17u L=0.04u
M5209 n4018 U4002/net14 VSS VSS nmos W=0.155u L=0.04u
M5210 U4002/net10 n4019 VSS VSS nmos W=0.155u L=0.04u
M5211 U4002/net4 U4002/net10 U4002/net14 VDD pmos W=0.255u L=0.04u
M5212 U4002/net6 n4019 U4002/net14 VDD pmos W=0.28u L=0.04u
M5213 U4002/net4 n3993 VDD VDD pmos W=0.205u L=0.04u
M5214 U4002/net6 U4002/net4 VDD VDD pmos W=0.24u L=0.04u
M5215 n4018 U4002/net14 VDD VDD pmos W=0.205u L=0.04u
M5216 U4002/net10 n4019 VDD VDD pmos W=0.205u L=0.04u
M5217 n3993 g2046 VSS VSS nmos W=0.135u L=0.04u
M5218 n3993 g2046 VDD VDD pmos W=0.205u L=0.04u
M5219 U4004/net4 n4020 U4004/net14 VSS nmos W=0.155u L=0.04u
M5220 U4004/net6 U4004/net10 U4004/net14 VSS nmos W=0.17u L=0.04u
M5221 U4004/net4 n3995 VSS VSS nmos W=0.155u L=0.04u
M5222 U4004/net6 U4004/net4 VSS VSS nmos W=0.17u L=0.04u
M5223 n4017 U4004/net14 VSS VSS nmos W=0.155u L=0.04u
M5224 U4004/net10 n4020 VSS VSS nmos W=0.155u L=0.04u
M5225 U4004/net4 U4004/net10 U4004/net14 VDD pmos W=0.255u L=0.04u
M5226 U4004/net6 n4020 U4004/net14 VDD pmos W=0.28u L=0.04u
M5227 U4004/net4 n3995 VDD VDD pmos W=0.205u L=0.04u
M5228 U4004/net6 U4004/net4 VDD VDD pmos W=0.24u L=0.04u
M5229 n4017 U4004/net14 VDD VDD pmos W=0.205u L=0.04u
M5230 U4004/net10 n4020 VDD VDD pmos W=0.205u L=0.04u
M5231 U4005/net4 n4021 U4005/net14 VSS nmos W=0.155u L=0.04u
M5232 U4005/net6 U4005/net10 U4005/net14 VSS nmos W=0.17u L=0.04u
M5233 U4005/net4 g2040 VSS VSS nmos W=0.155u L=0.04u
M5234 U4005/net6 U4005/net4 VSS VSS nmos W=0.17u L=0.04u
M5235 n4016 U4005/net14 VSS VSS nmos W=0.155u L=0.04u
M5236 U4005/net10 n4021 VSS VSS nmos W=0.155u L=0.04u
M5237 U4005/net4 U4005/net10 U4005/net14 VDD pmos W=0.255u L=0.04u
M5238 U4005/net6 n4021 U4005/net14 VDD pmos W=0.28u L=0.04u
M5239 U4005/net4 g2040 VDD VDD pmos W=0.205u L=0.04u
M5240 U4005/net6 U4005/net4 VDD VDD pmos W=0.24u L=0.04u
M5241 n4016 U4005/net14 VDD VDD pmos W=0.205u L=0.04u
M5242 U4005/net10 n4021 VDD VDD pmos W=0.205u L=0.04u
M5243 U4006/XU1-net6 n4023 VSS VSS nmos W=0.155u L=0.04u
M5244 n4015 n4022 U4006/XU1-net6 VSS nmos W=0.155u L=0.04u
M5245 n4015 n4023 VDD VDD pmos W=0.155u L=0.04u
M5246 n4015 n4022 VDD VDD pmos W=0.155u L=0.04u
M5247 U4007/net4 n3990 U4007/net14 VSS nmos W=0.155u L=0.04u
M5248 U4007/net6 U4007/net10 U4007/net14 VSS nmos W=0.17u L=0.04u
M5249 U4007/net4 n4024 VSS VSS nmos W=0.155u L=0.04u
M5250 U4007/net6 U4007/net4 VSS VSS nmos W=0.17u L=0.04u
M5251 n4023 U4007/net14 VSS VSS nmos W=0.155u L=0.04u
M5252 U4007/net10 n3990 VSS VSS nmos W=0.155u L=0.04u
M5253 U4007/net4 U4007/net10 U4007/net14 VDD pmos W=0.255u L=0.04u
M5254 U4007/net6 n3990 U4007/net14 VDD pmos W=0.28u L=0.04u
M5255 U4007/net4 n4024 VDD VDD pmos W=0.205u L=0.04u
M5256 U4007/net6 U4007/net4 VDD VDD pmos W=0.24u L=0.04u
M5257 n4023 U4007/net14 VDD VDD pmos W=0.205u L=0.04u
M5258 U4007/net10 n3990 VDD VDD pmos W=0.205u L=0.04u
M5259 n3990 g2020 VSS VSS nmos W=0.135u L=0.04u
M5260 n3990 g2020 VDD VDD pmos W=0.205u L=0.04u
M5261 U4009/net4 n3975 U4009/net14 VSS nmos W=0.155u L=0.04u
M5262 U4009/net6 U4009/net10 U4009/net14 VSS nmos W=0.17u L=0.04u
M5263 U4009/net4 n4025 VSS VSS nmos W=0.155u L=0.04u
M5264 U4009/net6 U4009/net4 VSS VSS nmos W=0.17u L=0.04u
M5265 n4022 U4009/net14 VSS VSS nmos W=0.155u L=0.04u
M5266 U4009/net10 n3975 VSS VSS nmos W=0.155u L=0.04u
M5267 U4009/net4 U4009/net10 U4009/net14 VDD pmos W=0.255u L=0.04u
M5268 U4009/net6 n3975 U4009/net14 VDD pmos W=0.28u L=0.04u
M5269 U4009/net4 n4025 VDD VDD pmos W=0.205u L=0.04u
M5270 U4009/net6 U4009/net4 VDD VDD pmos W=0.24u L=0.04u
M5271 n4022 U4009/net14 VDD VDD pmos W=0.205u L=0.04u
M5272 U4009/net10 n3975 VDD VDD pmos W=0.205u L=0.04u
M5273 n3975 g2052 VSS VSS nmos W=0.135u L=0.04u
M5274 n3975 g2052 VDD VDD pmos W=0.205u L=0.04u
M5275 n3998 n4026 VSS VSS nmos W=0.135u L=0.04u
M5276 n3998 n4026 VDD VDD pmos W=0.205u L=0.04u
M5277 U4012/net19 n3988 VSS VSS nmos W=0.155u L=0.04u
M5278 n3653 n3988 U4012/net40 VSS nmos W=0.155u L=0.04u
M5279 n3653 U4012/net19 U4012/net36 VSS nmos W=0.155u L=0.04u
M5280 U4012/net40 n3995 VSS VSS nmos W=0.31u L=0.04u
M5281 U4012/net36 g2100 VSS VSS nmos W=0.155u L=0.04u
M5282 U4012/net19 n3988 VDD VDD pmos W=0.205u L=0.04u
M5283 n3653 U4012/net19 U4012/net26 VDD pmos W=0.325u L=0.04u
M5284 U4012/net26 n3995 VDD VDD pmos W=0.41u L=0.04u
M5285 n3653 n3988 U4012/net30 VDD pmos W=0.325u L=0.04u
M5286 U4012/net30 g2100 VDD VDD pmos W=0.205u L=0.04u
M5287 n3995 g2059 VSS VSS nmos W=0.135u L=0.04u
M5288 n3995 g2059 VDD VDD pmos W=0.205u L=0.04u
M5289 U4014/net19 n3987 VSS VSS nmos W=0.155u L=0.04u
M5290 n3652 n3987 U4014/net40 VSS nmos W=0.155u L=0.04u
M5291 n3652 U4014/net19 U4014/net36 VSS nmos W=0.155u L=0.04u
M5292 U4014/net40 n3984 VSS VSS nmos W=0.31u L=0.04u
M5293 U4014/net36 g2104 VSS VSS nmos W=0.155u L=0.04u
M5294 U4014/net19 n3987 VDD VDD pmos W=0.205u L=0.04u
M5295 n3652 U4014/net19 U4014/net26 VDD pmos W=0.325u L=0.04u
M5296 U4014/net26 n3984 VDD VDD pmos W=0.41u L=0.04u
M5297 n3652 n3987 U4014/net30 VDD pmos W=0.325u L=0.04u
M5298 U4014/net30 g2104 VDD VDD pmos W=0.205u L=0.04u
M5299 n3987 n3996 VSS VSS nmos W=0.155u L=0.04u
M5300 n3987 n4027 VSS VSS nmos W=0.155u L=0.04u
M5301 U4015/XI1-net8 n4027 VDD VDD pmos W=0.205u L=0.04u
M5302 n3987 n3996 U4015/XI1-net8 VDD pmos W=0.205u L=0.04u
M5303 U4016/net19 n3988 VSS VSS nmos W=0.155u L=0.04u
M5304 n3651 n3988 U4016/net40 VSS nmos W=0.155u L=0.04u
M5305 n3651 U4016/net19 U4016/net36 VSS nmos W=0.155u L=0.04u
M5306 U4016/net40 n3984 VSS VSS nmos W=0.31u L=0.04u
M5307 U4016/net36 g2103 VSS VSS nmos W=0.155u L=0.04u
M5308 U4016/net19 n3988 VDD VDD pmos W=0.205u L=0.04u
M5309 n3651 U4016/net19 U4016/net26 VDD pmos W=0.325u L=0.04u
M5310 U4016/net26 n3984 VDD VDD pmos W=0.41u L=0.04u
M5311 n3651 n3988 U4016/net30 VDD pmos W=0.325u L=0.04u
M5312 U4016/net30 g2103 VDD VDD pmos W=0.205u L=0.04u
M5313 n3988 n3997 VSS VSS nmos W=0.155u L=0.04u
M5314 n3988 n3996 VSS VSS nmos W=0.155u L=0.04u
M5315 U4017/XI1-net8 n3996 VDD VDD pmos W=0.205u L=0.04u
M5316 n3988 n3997 U4017/XI1-net8 VDD pmos W=0.205u L=0.04u
M5317 U4018/net30 g2039 VSS VSS nmos W=0.155u L=0.04u
M5318 n3996 g1918 U4018/net23 VSS nmos W=0.155u L=0.04u
M5319 U4018/net20 U4018/net30 VSS VSS nmos W=0.155u L=0.04u
M5320 U4018/net23 g1905 U4018/net20 VSS nmos W=0.155u L=0.04u
M5321 U4018/net30 g2039 VDD VDD pmos W=0.205u L=0.04u
M5322 VDD g1918 n3996 VDD pmos W=0.205u L=0.04u
M5323 VDD g1905 n3996 VDD pmos W=0.205u L=0.04u
M5324 VDD U4018/net30 n3996 VDD pmos W=0.205u L=0.04u
M5325 n3984 g2066 VSS VSS nmos W=0.135u L=0.04u
M5326 n3984 g2066 VDD VDD pmos W=0.205u L=0.04u
M5327 U4020/net19 n3964 VSS VSS nmos W=0.155u L=0.04u
M5328 n3650 n3964 U4020/net40 VSS nmos W=0.155u L=0.04u
M5329 n3650 U4020/net19 U4020/net36 VSS nmos W=0.155u L=0.04u
M5330 U4020/net40 g2010 VSS VSS nmos W=0.31u L=0.04u
M5331 U4020/net36 g1890 VSS VSS nmos W=0.155u L=0.04u
M5332 U4020/net19 n3964 VDD VDD pmos W=0.205u L=0.04u
M5333 n3650 U4020/net19 U4020/net26 VDD pmos W=0.325u L=0.04u
M5334 U4020/net26 g2010 VDD VDD pmos W=0.41u L=0.04u
M5335 n3650 n3964 U4020/net30 VDD pmos W=0.325u L=0.04u
M5336 U4020/net30 g1890 VDD VDD pmos W=0.205u L=0.04u
M5337 n365 g25566 VSS VSS nmos W=0.135u L=0.04u
M5338 n365 g25566 VDD VDD pmos W=0.205u L=0.04u
M5339 U4022/net19 n4028 VSS VSS nmos W=0.155u L=0.04u
M5340 n3649 n4028 U4022/net40 VSS nmos W=0.155u L=0.04u
M5341 n3649 U4022/net19 U4022/net36 VSS nmos W=0.155u L=0.04u
M5342 U4022/net40 g1934 VSS VSS nmos W=0.31u L=0.04u
M5343 U4022/net36 n3917 VSS VSS nmos W=0.155u L=0.04u
M5344 U4022/net19 n4028 VDD VDD pmos W=0.205u L=0.04u
M5345 n3649 U4022/net19 U4022/net26 VDD pmos W=0.325u L=0.04u
M5346 U4022/net26 g1934 VDD VDD pmos W=0.41u L=0.04u
M5347 n3649 n4028 U4022/net30 VDD pmos W=0.325u L=0.04u
M5348 U4022/net30 n3917 VDD VDD pmos W=0.205u L=0.04u
M5349 n3648 U4023/net28 VSS VSS nmos W=0.155u L=0.04u
M5350 U4023/net47 n4029 VSS VSS nmos W=0.155u L=0.04u
M5351 U4023/net28 U4023/net6 U4023/net47 VSS nmos W=0.155u L=0.04u
M5352 U4023/net44 g1934 VSS VSS nmos W=0.155u L=0.04u
M5353 U4023/net28 g1930 U4023/net44 VSS nmos W=0.155u L=0.04u
M5354 U4023/net6 g1930 VSS VSS nmos W=0.155u L=0.04u
M5355 n3648 U4023/net28 VDD VDD pmos W=0.205u L=0.04u
M5356 VDD n4029 U4023/net47 VDD pmos W=0.205u L=0.04u
M5357 U4023/net47 g1930 U4023/net28 VDD pmos W=0.205u L=0.04u
M5358 U4023/net44 U4023/net6 U4023/net28 VDD pmos W=0.205u L=0.04u
M5359 VDD g1934 U4023/net44 VDD pmos W=0.205u L=0.04u
M5360 VDD g1930 U4023/net6 VDD pmos W=0.205u L=0.04u
M5361 U4024/net19 n4028 VSS VSS nmos W=0.155u L=0.04u
M5362 n3647 n4028 U4024/net40 VSS nmos W=0.155u L=0.04u
M5363 n3647 U4024/net19 U4024/net36 VSS nmos W=0.155u L=0.04u
M5364 U4024/net40 g1890 VSS VSS nmos W=0.31u L=0.04u
M5365 U4024/net36 g1937 VSS VSS nmos W=0.155u L=0.04u
M5366 U4024/net19 n4028 VDD VDD pmos W=0.205u L=0.04u
M5367 n3647 U4024/net19 U4024/net26 VDD pmos W=0.325u L=0.04u
M5368 U4024/net26 g1890 VDD VDD pmos W=0.41u L=0.04u
M5369 n3647 n4028 U4024/net30 VDD pmos W=0.325u L=0.04u
M5370 U4024/net30 g1937 VDD VDD pmos W=0.205u L=0.04u
M5371 n3646 n4030 U4025/net27 VSS nmos W=0.155u L=0.04u
M5372 U4025/net39 n4028 VSS VSS nmos W=0.155u L=0.04u
M5373 U4025/net27 g1845 U4025/net39 VSS nmos W=0.155u L=0.04u
M5374 U4025/net27 n4031 U4025/net39 VSS nmos W=0.155u L=0.04u
M5375 n3646 g1861 U4025/net27 VSS nmos W=0.155u L=0.04u
M5376 U4025/net39 g1865 VSS VSS nmos W=0.155u L=0.04u
M5377 n3646 n4028 U4025/net46 VDD pmos W=0.205u L=0.04u
M5378 U4025/net46 g1865 VDD VDD pmos W=0.205u L=0.04u
M5379 n3646 g1861 U4025/net34 VDD pmos W=0.205u L=0.04u
M5380 U4025/net34 n4030 VDD VDD pmos W=0.205u L=0.04u
M5381 n3646 n4031 U4025/net37 VDD pmos W=0.205u L=0.04u
M5382 U4025/net37 g1845 VDD VDD pmos W=0.205u L=0.04u
M5383 n3645 n4028 U4026/net27 VSS nmos W=0.155u L=0.04u
M5384 U4026/net39 n4031 VSS VSS nmos W=0.155u L=0.04u
M5385 U4026/net27 g1858 U4026/net39 VSS nmos W=0.155u L=0.04u
M5386 U4026/net27 n4030 U4026/net39 VSS nmos W=0.155u L=0.04u
M5387 n3645 g1859 U4026/net27 VSS nmos W=0.155u L=0.04u
M5388 U4026/net39 g1860 VSS VSS nmos W=0.155u L=0.04u
M5389 n3645 n4031 U4026/net46 VDD pmos W=0.205u L=0.04u
M5390 U4026/net46 g1860 VDD VDD pmos W=0.205u L=0.04u
M5391 n3645 g1859 U4026/net34 VDD pmos W=0.205u L=0.04u
M5392 U4026/net34 n4028 VDD VDD pmos W=0.205u L=0.04u
M5393 n3645 n4030 U4026/net37 VDD pmos W=0.205u L=0.04u
M5394 U4026/net37 g1858 VDD VDD pmos W=0.205u L=0.04u
M5395 n3644 n4028 U4027/net27 VSS nmos W=0.155u L=0.04u
M5396 U4027/net39 n4031 VSS VSS nmos W=0.155u L=0.04u
M5397 U4027/net27 g1867 U4027/net39 VSS nmos W=0.155u L=0.04u
M5398 U4027/net27 n4030 U4027/net39 VSS nmos W=0.155u L=0.04u
M5399 n3644 g1868 U4027/net27 VSS nmos W=0.155u L=0.04u
M5400 U4027/net39 g1869 VSS VSS nmos W=0.155u L=0.04u
M5401 n3644 n4031 U4027/net46 VDD pmos W=0.205u L=0.04u
M5402 U4027/net46 g1869 VDD VDD pmos W=0.205u L=0.04u
M5403 n3644 g1868 U4027/net34 VDD pmos W=0.205u L=0.04u
M5404 U4027/net34 n4028 VDD VDD pmos W=0.205u L=0.04u
M5405 n3644 n4030 U4027/net37 VDD pmos W=0.205u L=0.04u
M5406 U4027/net37 g1867 VDD VDD pmos W=0.205u L=0.04u
M5407 U4028/net19 n3989 VSS VSS nmos W=0.155u L=0.04u
M5408 n3641 n3989 U4028/net40 VSS nmos W=0.155u L=0.04u
M5409 n3641 U4028/net19 U4028/net36 VSS nmos W=0.155u L=0.04u
M5410 U4028/net40 g2112 VSS VSS nmos W=0.31u L=0.04u
M5411 U4028/net36 n4032 VSS VSS nmos W=0.155u L=0.04u
M5412 U4028/net19 n3989 VDD VDD pmos W=0.205u L=0.04u
M5413 n3641 U4028/net19 U4028/net26 VDD pmos W=0.325u L=0.04u
M5414 U4028/net26 g2112 VDD VDD pmos W=0.41u L=0.04u
M5415 n3641 n3989 U4028/net30 VDD pmos W=0.325u L=0.04u
M5416 U4028/net30 n4032 VDD VDD pmos W=0.205u L=0.04u
M5417 U4029/net19 n3967 VSS VSS nmos W=0.155u L=0.04u
M5418 n3640 n3967 U4029/net40 VSS nmos W=0.155u L=0.04u
M5419 n3640 U4029/net19 U4029/net36 VSS nmos W=0.155u L=0.04u
M5420 U4029/net40 g2113 VSS VSS nmos W=0.31u L=0.04u
M5421 U4029/net36 n4032 VSS VSS nmos W=0.155u L=0.04u
M5422 U4029/net19 n3967 VDD VDD pmos W=0.205u L=0.04u
M5423 n3640 U4029/net19 U4029/net26 VDD pmos W=0.325u L=0.04u
M5424 U4029/net26 g2113 VDD VDD pmos W=0.41u L=0.04u
M5425 n3640 n3967 U4029/net30 VDD pmos W=0.325u L=0.04u
M5426 U4029/net30 n4032 VDD VDD pmos W=0.205u L=0.04u
M5427 U4030/net19 n3986 VSS VSS nmos W=0.155u L=0.04u
M5428 n3639 n3986 U4030/net40 VSS nmos W=0.155u L=0.04u
M5429 n3639 U4030/net19 U4030/net36 VSS nmos W=0.155u L=0.04u
M5430 U4030/net40 g2111 VSS VSS nmos W=0.31u L=0.04u
M5431 U4030/net36 n4032 VSS VSS nmos W=0.155u L=0.04u
M5432 U4030/net19 n3986 VDD VDD pmos W=0.205u L=0.04u
M5433 n3639 U4030/net19 U4030/net26 VDD pmos W=0.325u L=0.04u
M5434 U4030/net26 g2111 VDD VDD pmos W=0.41u L=0.04u
M5435 n3639 n3986 U4030/net30 VDD pmos W=0.325u L=0.04u
M5436 U4030/net30 n4032 VDD VDD pmos W=0.205u L=0.04u
M5437 U4031/net19 n4034 VSS VSS nmos W=0.155u L=0.04u
M5438 n3638 n4034 U4031/net40 VSS nmos W=0.155u L=0.04u
M5439 n3638 U4031/net19 U4031/net36 VSS nmos W=0.155u L=0.04u
M5440 U4031/net40 n4033 VSS VSS nmos W=0.31u L=0.04u
M5441 U4031/net36 g1955 VSS VSS nmos W=0.155u L=0.04u
M5442 U4031/net19 n4034 VDD VDD pmos W=0.205u L=0.04u
M5443 n3638 U4031/net19 U4031/net26 VDD pmos W=0.325u L=0.04u
M5444 U4031/net26 n4033 VDD VDD pmos W=0.41u L=0.04u
M5445 n3638 n4034 U4031/net30 VDD pmos W=0.325u L=0.04u
M5446 U4031/net30 g1955 VDD VDD pmos W=0.205u L=0.04u
M5447 U4032/net19 n4034 VSS VSS nmos W=0.155u L=0.04u
M5448 n3637 n4034 U4032/net40 VSS nmos W=0.155u L=0.04u
M5449 n3637 U4032/net19 U4032/net36 VSS nmos W=0.155u L=0.04u
M5450 U4032/net40 n4035 VSS VSS nmos W=0.31u L=0.04u
M5451 U4032/net36 g1958 VSS VSS nmos W=0.155u L=0.04u
M5452 U4032/net19 n4034 VDD VDD pmos W=0.205u L=0.04u
M5453 n3637 U4032/net19 U4032/net26 VDD pmos W=0.325u L=0.04u
M5454 U4032/net26 n4035 VDD VDD pmos W=0.41u L=0.04u
M5455 n3637 n4034 U4032/net30 VDD pmos W=0.325u L=0.04u
M5456 U4032/net30 g1958 VDD VDD pmos W=0.205u L=0.04u
M5457 U4033/net19 n4034 VSS VSS nmos W=0.155u L=0.04u
M5458 n3636 n4034 U4033/net40 VSS nmos W=0.155u L=0.04u
M5459 n3636 U4033/net19 U4033/net36 VSS nmos W=0.155u L=0.04u
M5460 U4033/net40 n4036 VSS VSS nmos W=0.31u L=0.04u
M5461 U4033/net36 g1961 VSS VSS nmos W=0.155u L=0.04u
M5462 U4033/net19 n4034 VDD VDD pmos W=0.205u L=0.04u
M5463 n3636 U4033/net19 U4033/net26 VDD pmos W=0.325u L=0.04u
M5464 U4033/net26 n4036 VDD VDD pmos W=0.41u L=0.04u
M5465 n3636 n4034 U4033/net30 VDD pmos W=0.325u L=0.04u
M5466 U4033/net30 g1961 VDD VDD pmos W=0.205u L=0.04u
M5467 U4034/net19 n4034 VSS VSS nmos W=0.155u L=0.04u
M5468 n3635 n4034 U4034/net40 VSS nmos W=0.155u L=0.04u
M5469 n3635 U4034/net19 U4034/net36 VSS nmos W=0.155u L=0.04u
M5470 U4034/net40 n4037 VSS VSS nmos W=0.31u L=0.04u
M5471 U4034/net36 g1964 VSS VSS nmos W=0.155u L=0.04u
M5472 U4034/net19 n4034 VDD VDD pmos W=0.205u L=0.04u
M5473 n3635 U4034/net19 U4034/net26 VDD pmos W=0.325u L=0.04u
M5474 U4034/net26 n4037 VDD VDD pmos W=0.41u L=0.04u
M5475 n3635 n4034 U4034/net30 VDD pmos W=0.325u L=0.04u
M5476 U4034/net30 g1964 VDD VDD pmos W=0.205u L=0.04u
M5477 n4034 n4028 VSS VSS nmos W=0.155u L=0.04u
M5478 n4034 n3630 VSS VSS nmos W=0.155u L=0.04u
M5479 U4035/XI1-net8 n3630 VDD VDD pmos W=0.205u L=0.04u
M5480 n4034 n4028 U4035/XI1-net8 VDD pmos W=0.205u L=0.04u
M5481 U4036/net19 n4038 VSS VSS nmos W=0.155u L=0.04u
M5482 n3634 n4038 U4036/net40 VSS nmos W=0.155u L=0.04u
M5483 n3634 U4036/net19 U4036/net36 VSS nmos W=0.155u L=0.04u
M5484 U4036/net40 n4033 VSS VSS nmos W=0.31u L=0.04u
M5485 U4036/net36 g1957 VSS VSS nmos W=0.155u L=0.04u
M5486 U4036/net19 n4038 VDD VDD pmos W=0.205u L=0.04u
M5487 n3634 U4036/net19 U4036/net26 VDD pmos W=0.325u L=0.04u
M5488 U4036/net26 n4033 VDD VDD pmos W=0.41u L=0.04u
M5489 n3634 n4038 U4036/net30 VDD pmos W=0.325u L=0.04u
M5490 U4036/net30 g1957 VDD VDD pmos W=0.205u L=0.04u
M5491 U4037/net19 n4038 VSS VSS nmos W=0.155u L=0.04u
M5492 n3633 n4038 U4037/net40 VSS nmos W=0.155u L=0.04u
M5493 n3633 U4037/net19 U4037/net36 VSS nmos W=0.155u L=0.04u
M5494 U4037/net40 n4035 VSS VSS nmos W=0.31u L=0.04u
M5495 U4037/net36 g1960 VSS VSS nmos W=0.155u L=0.04u
M5496 U4037/net19 n4038 VDD VDD pmos W=0.205u L=0.04u
M5497 n3633 U4037/net19 U4037/net26 VDD pmos W=0.325u L=0.04u
M5498 U4037/net26 n4035 VDD VDD pmos W=0.41u L=0.04u
M5499 n3633 n4038 U4037/net30 VDD pmos W=0.325u L=0.04u
M5500 U4037/net30 g1960 VDD VDD pmos W=0.205u L=0.04u
M5501 U4038/net19 n4038 VSS VSS nmos W=0.155u L=0.04u
M5502 n3632 n4038 U4038/net40 VSS nmos W=0.155u L=0.04u
M5503 n3632 U4038/net19 U4038/net36 VSS nmos W=0.155u L=0.04u
M5504 U4038/net40 n4036 VSS VSS nmos W=0.31u L=0.04u
M5505 U4038/net36 g1963 VSS VSS nmos W=0.155u L=0.04u
M5506 U4038/net19 n4038 VDD VDD pmos W=0.205u L=0.04u
M5507 n3632 U4038/net19 U4038/net26 VDD pmos W=0.325u L=0.04u
M5508 U4038/net26 n4036 VDD VDD pmos W=0.41u L=0.04u
M5509 n3632 n4038 U4038/net30 VDD pmos W=0.325u L=0.04u
M5510 U4038/net30 g1963 VDD VDD pmos W=0.205u L=0.04u
M5511 U4039/net19 n4038 VSS VSS nmos W=0.155u L=0.04u
M5512 n3631 n4038 U4039/net40 VSS nmos W=0.155u L=0.04u
M5513 n3631 U4039/net19 U4039/net36 VSS nmos W=0.155u L=0.04u
M5514 U4039/net40 n4037 VSS VSS nmos W=0.31u L=0.04u
M5515 U4039/net36 g1966 VSS VSS nmos W=0.155u L=0.04u
M5516 U4039/net19 n4038 VDD VDD pmos W=0.205u L=0.04u
M5517 n3631 U4039/net19 U4039/net26 VDD pmos W=0.325u L=0.04u
M5518 U4039/net26 n4037 VDD VDD pmos W=0.41u L=0.04u
M5519 n3631 n4038 U4039/net30 VDD pmos W=0.325u L=0.04u
M5520 U4039/net30 g1966 VDD VDD pmos W=0.205u L=0.04u
M5521 n4038 n4030 VSS VSS nmos W=0.155u L=0.04u
M5522 n4038 n3630 VSS VSS nmos W=0.155u L=0.04u
M5523 U4040/XI1-net8 n3630 VDD VDD pmos W=0.205u L=0.04u
M5524 n4038 n4030 U4040/XI1-net8 VDD pmos W=0.205u L=0.04u
M5525 U4041/net19 n4030 VSS VSS nmos W=0.155u L=0.04u
M5526 n3629 n4030 U4041/net40 VSS nmos W=0.155u L=0.04u
M5527 n3629 U4041/net19 U4041/net36 VSS nmos W=0.155u L=0.04u
M5528 U4041/net40 g1874 VSS VSS nmos W=0.31u L=0.04u
M5529 U4041/net36 n4039 VSS VSS nmos W=0.155u L=0.04u
M5530 U4041/net19 n4030 VDD VDD pmos W=0.205u L=0.04u
M5531 n3629 U4041/net19 U4041/net26 VDD pmos W=0.325u L=0.04u
M5532 U4041/net26 g1874 VDD VDD pmos W=0.41u L=0.04u
M5533 n3629 n4030 U4041/net30 VDD pmos W=0.325u L=0.04u
M5534 U4041/net30 n4039 VDD VDD pmos W=0.205u L=0.04u
M5535 U4042/net19 n4028 VSS VSS nmos W=0.155u L=0.04u
M5536 n3628 n4028 U4042/net40 VSS nmos W=0.155u L=0.04u
M5537 n3628 U4042/net19 U4042/net36 VSS nmos W=0.155u L=0.04u
M5538 U4042/net40 g1877 VSS VSS nmos W=0.31u L=0.04u
M5539 U4042/net36 n4039 VSS VSS nmos W=0.155u L=0.04u
M5540 U4042/net19 n4028 VDD VDD pmos W=0.205u L=0.04u
M5541 n3628 U4042/net19 U4042/net26 VDD pmos W=0.325u L=0.04u
M5542 U4042/net26 g1877 VDD VDD pmos W=0.41u L=0.04u
M5543 n3628 n4028 U4042/net30 VDD pmos W=0.325u L=0.04u
M5544 U4042/net30 n4039 VDD VDD pmos W=0.205u L=0.04u
M5545 U4043/net19 n3989 VSS VSS nmos W=0.155u L=0.04u
M5546 n3627 n3989 U4043/net40 VSS nmos W=0.155u L=0.04u
M5547 n3627 U4043/net19 U4043/net36 VSS nmos W=0.155u L=0.04u
M5548 U4043/net40 g2109 VSS VSS nmos W=0.31u L=0.04u
M5549 U4043/net36 n4040 VSS VSS nmos W=0.155u L=0.04u
M5550 U4043/net19 n3989 VDD VDD pmos W=0.205u L=0.04u
M5551 n3627 U4043/net19 U4043/net26 VDD pmos W=0.325u L=0.04u
M5552 U4043/net26 g2109 VDD VDD pmos W=0.41u L=0.04u
M5553 n3627 n3989 U4043/net30 VDD pmos W=0.325u L=0.04u
M5554 U4043/net30 n4040 VDD VDD pmos W=0.205u L=0.04u
M5555 U4044/XU1-net6 g2010 VSS VSS nmos W=0.155u L=0.04u
M5556 n3989 g7229 U4044/XU1-net6 VSS nmos W=0.155u L=0.04u
M5557 n3989 g2010 VDD VDD pmos W=0.155u L=0.04u
M5558 n3989 g7229 VDD VDD pmos W=0.155u L=0.04u
M5559 U4045/net19 n3967 VSS VSS nmos W=0.155u L=0.04u
M5560 n3626 n3967 U4045/net40 VSS nmos W=0.155u L=0.04u
M5561 n3626 U4045/net19 U4045/net36 VSS nmos W=0.155u L=0.04u
M5562 U4045/net40 g2110 VSS VSS nmos W=0.31u L=0.04u
M5563 U4045/net36 n4040 VSS VSS nmos W=0.155u L=0.04u
M5564 U4045/net19 n3967 VDD VDD pmos W=0.205u L=0.04u
M5565 n3626 U4045/net19 U4045/net26 VDD pmos W=0.325u L=0.04u
M5566 U4045/net26 g2110 VDD VDD pmos W=0.41u L=0.04u
M5567 n3626 n3967 U4045/net30 VDD pmos W=0.325u L=0.04u
M5568 U4045/net30 n4040 VDD VDD pmos W=0.205u L=0.04u
M5569 U4046/XU1-net6 g2010 VSS VSS nmos W=0.155u L=0.04u
M5570 n3967 g7357 U4046/XU1-net6 VSS nmos W=0.155u L=0.04u
M5571 n3967 g2010 VDD VDD pmos W=0.155u L=0.04u
M5572 n3967 g7357 VDD VDD pmos W=0.155u L=0.04u
M5573 U4047/net19 n3986 VSS VSS nmos W=0.155u L=0.04u
M5574 n3625 n3986 U4047/net40 VSS nmos W=0.155u L=0.04u
M5575 n3625 U4047/net19 U4047/net36 VSS nmos W=0.155u L=0.04u
M5576 U4047/net40 g2108 VSS VSS nmos W=0.31u L=0.04u
M5577 U4047/net36 n4040 VSS VSS nmos W=0.155u L=0.04u
M5578 U4047/net19 n3986 VDD VDD pmos W=0.205u L=0.04u
M5579 n3625 U4047/net19 U4047/net26 VDD pmos W=0.325u L=0.04u
M5580 U4047/net26 g2108 VDD VDD pmos W=0.41u L=0.04u
M5581 n3625 n3986 U4047/net30 VDD pmos W=0.325u L=0.04u
M5582 U4047/net30 n4040 VDD VDD pmos W=0.205u L=0.04u
M5583 U4048/XU1-net6 g2009 VSS VSS nmos W=0.155u L=0.04u
M5584 n3986 g2010 U4048/XU1-net6 VSS nmos W=0.155u L=0.04u
M5585 n3986 g2009 VDD VDD pmos W=0.155u L=0.04u
M5586 n3986 g2010 VDD VDD pmos W=0.155u L=0.04u
M5587 U4049/net19 n4041 VSS VSS nmos W=0.155u L=0.04u
M5588 n3624 n4041 U4049/net40 VSS nmos W=0.155u L=0.04u
M5589 n3624 U4049/net19 U4049/net36 VSS nmos W=0.155u L=0.04u
M5590 U4049/net40 n4033 VSS VSS nmos W=0.31u L=0.04u
M5591 U4049/net36 g1956 VSS VSS nmos W=0.155u L=0.04u
M5592 U4049/net19 n4041 VDD VDD pmos W=0.205u L=0.04u
M5593 n3624 U4049/net19 U4049/net26 VDD pmos W=0.325u L=0.04u
M5594 U4049/net26 n4033 VDD VDD pmos W=0.41u L=0.04u
M5595 n3624 n4041 U4049/net30 VDD pmos W=0.325u L=0.04u
M5596 U4049/net30 g1956 VDD VDD pmos W=0.205u L=0.04u
M5597 U4050/net7 n4042 U4050/X_u4-net10 VSS nmos W=0.155u L=0.04u
M5598 U4050/X_u4-net10 n4043 U4050/X_u4-net13 VSS nmos W=0.155u L=0.04u
M5599 U4050/X_u4-net13 n4044 VSS VSS nmos W=0.155u L=0.04u
M5600 n4033 U4050/net7 VSS VSS nmos W=0.155u L=0.04u
M5601 U4050/net7 n4044 VDD VDD pmos W=0.205u L=0.04u
M5602 U4050/net7 n4042 VDD VDD pmos W=0.205u L=0.04u
M5603 U4050/net7 n4043 VDD VDD pmos W=0.205u L=0.04u
M5604 n4033 U4050/net7 VDD VDD pmos W=0.205u L=0.04u
M5605 U4051/net19 n3937 VSS VSS nmos W=0.155u L=0.04u
M5606 n4044 n3937 U4051/net40 VSS nmos W=0.155u L=0.04u
M5607 n4044 U4051/net19 U4051/net36 VSS nmos W=0.155u L=0.04u
M5608 U4051/net40 n4046 VSS VSS nmos W=0.31u L=0.04u
M5609 U4051/net36 n4045 VSS VSS nmos W=0.155u L=0.04u
M5610 U4051/net19 n3937 VDD VDD pmos W=0.205u L=0.04u
M5611 n4044 U4051/net19 U4051/net26 VDD pmos W=0.325u L=0.04u
M5612 U4051/net26 n4046 VDD VDD pmos W=0.41u L=0.04u
M5613 n4044 n3937 U4051/net30 VDD pmos W=0.325u L=0.04u
M5614 U4051/net30 n4045 VDD VDD pmos W=0.205u L=0.04u
M5615 n4046 n552 U4052/net15 VSS nmos W=0.155u L=0.04u
M5616 n4046 n4045 U4052/net15 VSS nmos W=0.155u L=0.04u
M5617 U4052/net15 n4047 VSS VSS nmos W=0.155u L=0.04u
M5618 n4046 n4047 VDD VDD pmos W=0.205u L=0.04u
M5619 n4046 n552 U4052/XI16-net11 VDD pmos W=0.205u L=0.04u
M5620 U4052/XI16-net11 n4045 VDD VDD pmos W=0.205u L=0.04u
M5621 U4053/net19 n4041 VSS VSS nmos W=0.155u L=0.04u
M5622 n3623 n4041 U4053/net40 VSS nmos W=0.155u L=0.04u
M5623 n3623 U4053/net19 U4053/net36 VSS nmos W=0.155u L=0.04u
M5624 U4053/net40 n4035 VSS VSS nmos W=0.31u L=0.04u
M5625 U4053/net36 g1959 VSS VSS nmos W=0.155u L=0.04u
M5626 U4053/net19 n4041 VDD VDD pmos W=0.205u L=0.04u
M5627 n3623 U4053/net19 U4053/net26 VDD pmos W=0.325u L=0.04u
M5628 U4053/net26 n4035 VDD VDD pmos W=0.41u L=0.04u
M5629 n3623 n4041 U4053/net30 VDD pmos W=0.325u L=0.04u
M5630 U4053/net30 g1959 VDD VDD pmos W=0.205u L=0.04u
M5631 U4054/net36 n4047 U4054/net24 VSS nmos W=0.155u L=0.04u
M5632 U4054/net24 n4042 VSS VSS nmos W=0.155u L=0.04u
M5633 U4054/net33 n4048 U4054/net36 VSS nmos W=0.155u L=0.04u
M5634 U4054/net33 n4049 U4054/net36 VSS nmos W=0.155u L=0.04u
M5635 n4035 U4054/net33 VSS VSS nmos W=0.155u L=0.04u
M5636 n4035 U4054/net33 VDD VDD pmos W=0.205u L=0.04u
M5637 U4054/net33 n4049 U4054/net35 VDD pmos W=0.205u L=0.04u
M5638 U4054/net35 n4048 VDD VDD pmos W=0.205u L=0.04u
M5639 U4054/net33 n4042 VDD VDD pmos W=0.205u L=0.04u
M5640 U4054/net33 n4047 VDD VDD pmos W=0.205u L=0.04u
M5641 n4042 n4048 U4055/XI0-net10 VSS nmos W=0.155u L=0.04u
M5642 U4055/XI0-net10 n4050 U4055/XI0-net13 VSS nmos W=0.155u L=0.04u
M5643 U4055/XI0-net13 g3229 VSS VSS nmos W=0.155u L=0.04u
M5644 n4042 g3229 VDD VDD pmos W=0.205u L=0.04u
M5645 n4042 n4048 VDD VDD pmos W=0.205u L=0.04u
M5646 n4042 n4050 VDD VDD pmos W=0.205u L=0.04u
M5647 U4056/XU1-net6 n3937 VSS VSS nmos W=0.155u L=0.04u
M5648 n4049 n4050 U4056/XU1-net6 VSS nmos W=0.155u L=0.04u
M5649 n4049 n3937 VDD VDD pmos W=0.155u L=0.04u
M5650 n4049 n4050 VDD VDD pmos W=0.155u L=0.04u
M5651 U4057/net19 n4041 VSS VSS nmos W=0.155u L=0.04u
M5652 n3622 n4041 U4057/net40 VSS nmos W=0.155u L=0.04u
M5653 n3622 U4057/net19 U4057/net36 VSS nmos W=0.155u L=0.04u
M5654 U4057/net40 n4036 VSS VSS nmos W=0.31u L=0.04u
M5655 U4057/net36 g1962 VSS VSS nmos W=0.155u L=0.04u
M5656 U4057/net19 n4041 VDD VDD pmos W=0.205u L=0.04u
M5657 n3622 U4057/net19 U4057/net26 VDD pmos W=0.325u L=0.04u
M5658 U4057/net26 n4036 VDD VDD pmos W=0.41u L=0.04u
M5659 n3622 n4041 U4057/net30 VDD pmos W=0.325u L=0.04u
M5660 U4057/net30 g1962 VDD VDD pmos W=0.205u L=0.04u
M5661 n4036 n4054 VSS VSS nmos W=0.155u L=0.04u
M5662 n4036 n4051 U4058/XI17-net17 VSS nmos W=0.155u L=0.04u
M5663 U4058/XI17-net17 n4053 VSS VSS nmos W=0.155u L=0.04u
M5664 n4036 n4051 U4058/XI10-net17 VSS nmos W=0.155u L=0.04u
M5665 U4058/XI10-net17 n4052 VSS VSS nmos W=0.155u L=0.04u
M5666 U4058/net30 n4051 n4036 VDD pmos W=0.205u L=0.04u
M5667 U4058/net30 n4052 n4036 VDD pmos W=0.205u L=0.04u
M5668 VDD n4054 U4058/net36 VDD pmos W=0.205u L=0.04u
M5669 U4058/net36 n4053 U4058/net30 VDD pmos W=0.205u L=0.04u
M5670 U4058/net36 n4051 U4058/net30 VDD pmos W=0.205u L=0.04u
M5671 VSS n4043 U4059/net22 VSS nmos W=0.155u L=0.04u
M5672 U4059/net22 n4048 n4054 VSS nmos W=0.155u L=0.04u
M5673 U4059/net22 g3229 n4054 VSS nmos W=0.155u L=0.04u
M5674 U4059/net22 n4055 n4054 VSS nmos W=0.155u L=0.04u
M5675 U4059/net38 n4055 VDD VDD pmos W=0.205u L=0.04u
M5676 U4059/net35 g3229 U4059/net38 VDD pmos W=0.205u L=0.04u
M5677 n4054 n4048 U4059/net35 VDD pmos W=0.205u L=0.04u
M5678 n4054 n4043 VDD VDD pmos W=0.205u L=0.04u
M5679 n4043 g3229 U4060/XI0-net10 VSS nmos W=0.155u L=0.04u
M5680 U4060/XI0-net10 n4048 U4060/XI0-net13 VSS nmos W=0.155u L=0.04u
M5681 U4060/XI0-net13 n4056 VSS VSS nmos W=0.155u L=0.04u
M5682 n4043 n4056 VDD VDD pmos W=0.205u L=0.04u
M5683 n4043 g3229 VDD VDD pmos W=0.205u L=0.04u
M5684 n4043 n4048 VDD VDD pmos W=0.205u L=0.04u
M5685 U4061/net19 n4041 VSS VSS nmos W=0.155u L=0.04u
M5686 n3621 n4041 U4061/net40 VSS nmos W=0.155u L=0.04u
M5687 n3621 U4061/net19 U4061/net36 VSS nmos W=0.155u L=0.04u
M5688 U4061/net40 n4037 VSS VSS nmos W=0.31u L=0.04u
M5689 U4061/net36 g1965 VSS VSS nmos W=0.155u L=0.04u
M5690 U4061/net19 n4041 VDD VDD pmos W=0.205u L=0.04u
M5691 n3621 U4061/net19 U4061/net26 VDD pmos W=0.325u L=0.04u
M5692 U4061/net26 n4037 VDD VDD pmos W=0.41u L=0.04u
M5693 n3621 n4041 U4061/net30 VDD pmos W=0.325u L=0.04u
M5694 U4061/net30 g1965 VDD VDD pmos W=0.205u L=0.04u
M5695 n4041 n4031 VSS VSS nmos W=0.155u L=0.04u
M5696 n4041 n3630 VSS VSS nmos W=0.155u L=0.04u
M5697 U4062/XI1-net8 n3630 VDD VDD pmos W=0.205u L=0.04u
M5698 n4041 n4031 U4062/XI1-net8 VDD pmos W=0.205u L=0.04u
M5699 n3630 n4032 U4063/net10 VSS nmos W=0.155u L=0.04u
M5700 U4063/net10 n3950 VSS VSS nmos W=0.155u L=0.04u
M5701 n3630 n4057 U4063/net10 VSS nmos W=0.155u L=0.04u
M5702 U4063/net10 n4058 VSS VSS nmos W=0.155u L=0.04u
M5703 U4063/net30 n3950 VDD VDD pmos W=0.205u L=0.04u
M5704 n3630 n4032 U4063/net24 VDD pmos W=0.205u L=0.04u
M5705 U4063/net24 n4057 VDD VDD pmos W=0.205u L=0.04u
M5706 n3630 n4058 U4063/net30 VDD pmos W=0.205u L=0.04u
M5707 U4064/net7 g1890 U4064/X_u4-net10 VSS nmos W=0.155u L=0.04u
M5708 U4064/X_u4-net10 n4059 U4064/X_u4-net13 VSS nmos W=0.155u L=0.04u
M5709 U4064/X_u4-net13 n4057 VSS VSS nmos W=0.155u L=0.04u
M5710 n4058 U4064/net7 VSS VSS nmos W=0.155u L=0.04u
M5711 U4064/net7 n4057 VDD VDD pmos W=0.205u L=0.04u
M5712 U4064/net7 g1890 VDD VDD pmos W=0.205u L=0.04u
M5713 U4064/net7 n4059 VDD VDD pmos W=0.205u L=0.04u
M5714 n4058 U4064/net7 VDD VDD pmos W=0.205u L=0.04u
M5715 n4037 n4053 U4065/net15 VSS nmos W=0.155u L=0.04u
M5716 n4037 n4052 U4065/net15 VSS nmos W=0.155u L=0.04u
M5717 U4065/net15 n4060 VSS VSS nmos W=0.155u L=0.04u
M5718 n4037 n4060 VDD VDD pmos W=0.205u L=0.04u
M5719 n4037 n4053 U4065/XI16-net11 VDD pmos W=0.205u L=0.04u
M5720 U4065/XI16-net11 n4052 VDD VDD pmos W=0.205u L=0.04u
M5721 n4052 g3229 VSS VSS nmos W=0.155u L=0.04u
M5722 n4052 n552 VSS VSS nmos W=0.155u L=0.04u
M5723 U4066/XI1-net8 n552 VDD VDD pmos W=0.205u L=0.04u
M5724 n4052 g3229 U4066/XI1-net8 VDD pmos W=0.205u L=0.04u
M5725 n4053 n4048 VSS VSS nmos W=0.155u L=0.04u
M5726 n4053 n3937 VSS VSS nmos W=0.155u L=0.04u
M5727 U4067/XI1-net8 n3937 VDD VDD pmos W=0.205u L=0.04u
M5728 n4053 n4048 U4067/XI1-net8 VDD pmos W=0.205u L=0.04u
M5729 U4068/net19 n4031 VSS VSS nmos W=0.155u L=0.04u
M5730 n3620 n4031 U4068/net40 VSS nmos W=0.155u L=0.04u
M5731 n3620 U4068/net19 U4068/net36 VSS nmos W=0.155u L=0.04u
M5732 U4068/net40 g1871 VSS VSS nmos W=0.31u L=0.04u
M5733 U4068/net36 n4039 VSS VSS nmos W=0.155u L=0.04u
M5734 U4068/net19 n4031 VDD VDD pmos W=0.205u L=0.04u
M5735 n3620 U4068/net19 U4068/net26 VDD pmos W=0.325u L=0.04u
M5736 U4068/net26 g1871 VDD VDD pmos W=0.41u L=0.04u
M5737 n3620 n4031 U4068/net30 VDD pmos W=0.325u L=0.04u
M5738 U4068/net30 n4039 VDD VDD pmos W=0.205u L=0.04u
M5739 U4069/net7 g1890 U4069/X_u4-net10 VSS nmos W=0.155u L=0.04u
M5740 U4069/X_u4-net10 n4057 U4069/X_u4-net13 VSS nmos W=0.155u L=0.04u
M5741 U4069/X_u4-net13 n4040 VSS VSS nmos W=0.155u L=0.04u
M5742 n4039 U4069/net7 VSS VSS nmos W=0.155u L=0.04u
M5743 U4069/net7 n4040 VDD VDD pmos W=0.205u L=0.04u
M5744 U4069/net7 g1890 VDD VDD pmos W=0.205u L=0.04u
M5745 U4069/net7 n4057 VDD VDD pmos W=0.205u L=0.04u
M5746 n4039 U4069/net7 VDD VDD pmos W=0.205u L=0.04u
M5747 n4057 g1930 U4070/XI21-net17 VSS nmos W=0.155u L=0.04u
M5748 U4070/XI21-net17 g1877 VSS VSS nmos W=0.155u L=0.04u
M5749 n4057 g7052 U4070/XI6-net17 VSS nmos W=0.155u L=0.04u
M5750 U4070/XI6-net17 g1871 VSS VSS nmos W=0.155u L=0.04u
M5751 n4057 g7194 U4070/XI20-net17 VSS nmos W=0.155u L=0.04u
M5752 U4070/XI20-net17 g1874 VSS VSS nmos W=0.155u L=0.04u
M5753 VDD g1930 U4070/net22 VDD pmos W=0.205u L=0.04u
M5754 VDD g1877 U4070/net22 VDD pmos W=0.205u L=0.04u
M5755 U4070/net16 g7052 n4057 VDD pmos W=0.205u L=0.04u
M5756 U4070/net16 g1871 n4057 VDD pmos W=0.205u L=0.04u
M5757 U4070/net22 g7194 U4070/net16 VDD pmos W=0.205u L=0.04u
M5758 U4070/net22 g1874 U4070/net16 VDD pmos W=0.205u L=0.04u
M5759 U4071/net19 g3229 VSS VSS nmos W=0.155u L=0.04u
M5760 n3619 g3229 U4071/net40 VSS nmos W=0.155u L=0.04u
M5761 n3619 U4071/net19 U4071/net36 VSS nmos W=0.155u L=0.04u
M5762 U4071/net40 n4061 VSS VSS nmos W=0.31u L=0.04u
M5763 U4071/net36 g1686 VSS VSS nmos W=0.155u L=0.04u
M5764 U4071/net19 g3229 VDD VDD pmos W=0.205u L=0.04u
M5765 n3619 U4071/net19 U4071/net26 VDD pmos W=0.325u L=0.04u
M5766 U4071/net26 n4061 VDD VDD pmos W=0.41u L=0.04u
M5767 n3619 g3229 U4071/net30 VDD pmos W=0.325u L=0.04u
M5768 U4071/net30 g1686 VDD VDD pmos W=0.205u L=0.04u
M5769 n4061 g1672 VSS VSS nmos W=0.135u L=0.04u
M5770 n4061 g1672 VDD VDD pmos W=0.205u L=0.04u
M5771 U4073/net19 g8012 VSS VSS nmos W=0.155u L=0.04u
M5772 n3618 g8012 U4073/net40 VSS nmos W=0.155u L=0.04u
M5773 n3618 U4073/net19 U4073/net36 VSS nmos W=0.155u L=0.04u
M5774 U4073/net40 n4062 VSS VSS nmos W=0.31u L=0.04u
M5775 U4073/net36 g1846 VSS VSS nmos W=0.155u L=0.04u
M5776 U4073/net19 g8012 VDD VDD pmos W=0.205u L=0.04u
M5777 n3618 U4073/net19 U4073/net26 VDD pmos W=0.325u L=0.04u
M5778 U4073/net26 n4062 VDD VDD pmos W=0.41u L=0.04u
M5779 n3618 g8012 U4073/net30 VDD pmos W=0.325u L=0.04u
M5780 U4073/net30 g1846 VDD VDD pmos W=0.205u L=0.04u
M5781 U4074/net19 g8082 VSS VSS nmos W=0.155u L=0.04u
M5782 n3617 g8082 U4074/net40 VSS nmos W=0.155u L=0.04u
M5783 n3617 U4074/net19 U4074/net36 VSS nmos W=0.155u L=0.04u
M5784 U4074/net40 n4062 VSS VSS nmos W=0.31u L=0.04u
M5785 U4074/net36 g1849 VSS VSS nmos W=0.155u L=0.04u
M5786 U4074/net19 g8082 VDD VDD pmos W=0.205u L=0.04u
M5787 n3617 U4074/net19 U4074/net26 VDD pmos W=0.325u L=0.04u
M5788 U4074/net26 n4062 VDD VDD pmos W=0.41u L=0.04u
M5789 n3617 g8082 U4074/net30 VDD pmos W=0.325u L=0.04u
M5790 U4074/net30 g1849 VDD VDD pmos W=0.205u L=0.04u
M5791 U4075/net19 g1866 VSS VSS nmos W=0.155u L=0.04u
M5792 n3616 g1866 U4075/net40 VSS nmos W=0.155u L=0.04u
M5793 n3616 U4075/net19 U4075/net36 VSS nmos W=0.155u L=0.04u
M5794 U4075/net40 n4062 VSS VSS nmos W=0.31u L=0.04u
M5795 U4075/net36 g1852 VSS VSS nmos W=0.155u L=0.04u
M5796 U4075/net19 g1866 VDD VDD pmos W=0.205u L=0.04u
M5797 n3616 U4075/net19 U4075/net26 VDD pmos W=0.325u L=0.04u
M5798 U4075/net26 n4062 VDD VDD pmos W=0.41u L=0.04u
M5799 n3616 g1866 U4075/net30 VDD pmos W=0.325u L=0.04u
M5800 U4075/net30 g1852 VDD VDD pmos W=0.205u L=0.04u
M5801 U4076/net19 g1866 VSS VSS nmos W=0.155u L=0.04u
M5802 n3615 g1866 U4076/net40 VSS nmos W=0.155u L=0.04u
M5803 n3615 U4076/net19 U4076/net36 VSS nmos W=0.155u L=0.04u
M5804 U4076/net40 n4063 VSS VSS nmos W=0.31u L=0.04u
M5805 U4076/net36 g1842 VSS VSS nmos W=0.155u L=0.04u
M5806 U4076/net19 g1866 VDD VDD pmos W=0.205u L=0.04u
M5807 n3615 U4076/net19 U4076/net26 VDD pmos W=0.325u L=0.04u
M5808 U4076/net26 n4063 VDD VDD pmos W=0.41u L=0.04u
M5809 n3615 g1866 U4076/net30 VDD pmos W=0.325u L=0.04u
M5810 U4076/net30 g1842 VDD VDD pmos W=0.205u L=0.04u
M5811 U4077/net19 g8012 VSS VSS nmos W=0.155u L=0.04u
M5812 n3614 g8012 U4077/net40 VSS nmos W=0.155u L=0.04u
M5813 n3614 U4077/net19 U4077/net36 VSS nmos W=0.155u L=0.04u
M5814 U4077/net40 n4063 VSS VSS nmos W=0.31u L=0.04u
M5815 U4077/net36 g1836 VSS VSS nmos W=0.155u L=0.04u
M5816 U4077/net19 g8012 VDD VDD pmos W=0.205u L=0.04u
M5817 n3614 U4077/net19 U4077/net26 VDD pmos W=0.325u L=0.04u
M5818 U4077/net26 n4063 VDD VDD pmos W=0.41u L=0.04u
M5819 n3614 g8012 U4077/net30 VDD pmos W=0.325u L=0.04u
M5820 U4077/net30 g1836 VDD VDD pmos W=0.205u L=0.04u
M5821 U4078/net19 g8082 VSS VSS nmos W=0.155u L=0.04u
M5822 n3613 g8082 U4078/net40 VSS nmos W=0.155u L=0.04u
M5823 n3613 U4078/net19 U4078/net36 VSS nmos W=0.155u L=0.04u
M5824 U4078/net40 n4063 VSS VSS nmos W=0.31u L=0.04u
M5825 U4078/net36 g1839 VSS VSS nmos W=0.155u L=0.04u
M5826 U4078/net19 g8082 VDD VDD pmos W=0.205u L=0.04u
M5827 n3613 U4078/net19 U4078/net26 VDD pmos W=0.325u L=0.04u
M5828 U4078/net26 n4063 VDD VDD pmos W=0.41u L=0.04u
M5829 n3613 g8082 U4078/net30 VDD pmos W=0.325u L=0.04u
M5830 U4078/net30 g1839 VDD VDD pmos W=0.205u L=0.04u
M5831 n4063 n4064 VSS VSS nmos W=0.135u L=0.04u
M5832 n4063 n4064 VDD VDD pmos W=0.205u L=0.04u
M5833 U4080/net19 g8012 VSS VSS nmos W=0.155u L=0.04u
M5834 n3612 g8012 U4080/net40 VSS nmos W=0.155u L=0.04u
M5835 n3612 U4080/net19 U4080/net36 VSS nmos W=0.155u L=0.04u
M5836 U4080/net40 n4065 VSS VSS nmos W=0.31u L=0.04u
M5837 U4080/net36 g1858 VSS VSS nmos W=0.155u L=0.04u
M5838 U4080/net19 g8012 VDD VDD pmos W=0.205u L=0.04u
M5839 n3612 U4080/net19 U4080/net26 VDD pmos W=0.325u L=0.04u
M5840 U4080/net26 n4065 VDD VDD pmos W=0.41u L=0.04u
M5841 n3612 g8012 U4080/net30 VDD pmos W=0.325u L=0.04u
M5842 U4080/net30 g1858 VDD VDD pmos W=0.205u L=0.04u
M5843 U4081/net19 g8082 VSS VSS nmos W=0.155u L=0.04u
M5844 n3611 g8082 U4081/net40 VSS nmos W=0.155u L=0.04u
M5845 n3611 U4081/net19 U4081/net36 VSS nmos W=0.155u L=0.04u
M5846 U4081/net40 n4065 VSS VSS nmos W=0.31u L=0.04u
M5847 U4081/net36 g1859 VSS VSS nmos W=0.155u L=0.04u
M5848 U4081/net19 g8082 VDD VDD pmos W=0.205u L=0.04u
M5849 n3611 U4081/net19 U4081/net26 VDD pmos W=0.325u L=0.04u
M5850 U4081/net26 n4065 VDD VDD pmos W=0.41u L=0.04u
M5851 n3611 g8082 U4081/net30 VDD pmos W=0.325u L=0.04u
M5852 U4081/net30 g1859 VDD VDD pmos W=0.205u L=0.04u
M5853 U4082/net19 g1866 VSS VSS nmos W=0.155u L=0.04u
M5854 n3610 g1866 U4082/net40 VSS nmos W=0.155u L=0.04u
M5855 n3610 U4082/net19 U4082/net36 VSS nmos W=0.155u L=0.04u
M5856 U4082/net40 n4065 VSS VSS nmos W=0.31u L=0.04u
M5857 U4082/net36 g1860 VSS VSS nmos W=0.155u L=0.04u
M5858 U4082/net19 g1866 VDD VDD pmos W=0.205u L=0.04u
M5859 n3610 U4082/net19 U4082/net26 VDD pmos W=0.325u L=0.04u
M5860 U4082/net26 n4065 VDD VDD pmos W=0.41u L=0.04u
M5861 n3610 g1866 U4082/net30 VDD pmos W=0.325u L=0.04u
M5862 U4082/net30 g1860 VDD VDD pmos W=0.205u L=0.04u
M5863 U4083/net19 g8082 VSS VSS nmos W=0.155u L=0.04u
M5864 n3609 g8082 U4083/net40 VSS nmos W=0.155u L=0.04u
M5865 n3609 U4083/net19 U4083/net36 VSS nmos W=0.155u L=0.04u
M5866 U4083/net40 g11952 VSS VSS nmos W=0.31u L=0.04u
M5867 U4083/net36 g1865 VSS VSS nmos W=0.155u L=0.04u
M5868 U4083/net19 g8082 VDD VDD pmos W=0.205u L=0.04u
M5869 n3609 U4083/net19 U4083/net26 VDD pmos W=0.325u L=0.04u
M5870 U4083/net26 g11952 VDD VDD pmos W=0.41u L=0.04u
M5871 n3609 g8082 U4083/net30 VDD pmos W=0.325u L=0.04u
M5872 U4083/net30 g1865 VDD VDD pmos W=0.205u L=0.04u
M5873 U4084/net19 g1866 VSS VSS nmos W=0.155u L=0.04u
M5874 n3608 g1866 U4084/net40 VSS nmos W=0.155u L=0.04u
M5875 n3608 U4084/net19 U4084/net36 VSS nmos W=0.155u L=0.04u
M5876 U4084/net40 g11952 VSS VSS nmos W=0.31u L=0.04u
M5877 U4084/net36 g1845 VSS VSS nmos W=0.155u L=0.04u
M5878 U4084/net19 g1866 VDD VDD pmos W=0.205u L=0.04u
M5879 n3608 U4084/net19 U4084/net26 VDD pmos W=0.325u L=0.04u
M5880 U4084/net26 g11952 VDD VDD pmos W=0.41u L=0.04u
M5881 n3608 g1866 U4084/net30 VDD pmos W=0.325u L=0.04u
M5882 U4084/net30 g1845 VDD VDD pmos W=0.205u L=0.04u
M5883 U4085/net19 g8012 VSS VSS nmos W=0.155u L=0.04u
M5884 n3607 g8012 U4085/net40 VSS nmos W=0.155u L=0.04u
M5885 n3607 U4085/net19 U4085/net36 VSS nmos W=0.155u L=0.04u
M5886 U4085/net40 g11952 VSS VSS nmos W=0.31u L=0.04u
M5887 U4085/net36 g1861 VSS VSS nmos W=0.155u L=0.04u
M5888 U4085/net19 g8012 VDD VDD pmos W=0.205u L=0.04u
M5889 n3607 U4085/net19 U4085/net26 VDD pmos W=0.325u L=0.04u
M5890 U4085/net26 g11952 VDD VDD pmos W=0.41u L=0.04u
M5891 n3607 g8012 U4085/net30 VDD pmos W=0.325u L=0.04u
M5892 U4085/net30 g1861 VDD VDD pmos W=0.205u L=0.04u
M5893 U4086/net19 g8012 VSS VSS nmos W=0.155u L=0.04u
M5894 n3606 g8012 U4086/net40 VSS nmos W=0.155u L=0.04u
M5895 n3606 U4086/net19 U4086/net36 VSS nmos W=0.155u L=0.04u
M5896 U4086/net40 n4066 VSS VSS nmos W=0.31u L=0.04u
M5897 U4086/net36 g1867 VSS VSS nmos W=0.155u L=0.04u
M5898 U4086/net19 g8012 VDD VDD pmos W=0.205u L=0.04u
M5899 n3606 U4086/net19 U4086/net26 VDD pmos W=0.325u L=0.04u
M5900 U4086/net26 n4066 VDD VDD pmos W=0.41u L=0.04u
M5901 n3606 g8012 U4086/net30 VDD pmos W=0.325u L=0.04u
M5902 U4086/net30 g1867 VDD VDD pmos W=0.205u L=0.04u
M5903 U4087/net19 g8082 VSS VSS nmos W=0.155u L=0.04u
M5904 n3605 g8082 U4087/net40 VSS nmos W=0.155u L=0.04u
M5905 n3605 U4087/net19 U4087/net36 VSS nmos W=0.155u L=0.04u
M5906 U4087/net40 n4066 VSS VSS nmos W=0.31u L=0.04u
M5907 U4087/net36 g1868 VSS VSS nmos W=0.155u L=0.04u
M5908 U4087/net19 g8082 VDD VDD pmos W=0.205u L=0.04u
M5909 n3605 U4087/net19 U4087/net26 VDD pmos W=0.325u L=0.04u
M5910 U4087/net26 n4066 VDD VDD pmos W=0.41u L=0.04u
M5911 n3605 g8082 U4087/net30 VDD pmos W=0.325u L=0.04u
M5912 U4087/net30 g1868 VDD VDD pmos W=0.205u L=0.04u
M5913 U4088/net19 g1866 VSS VSS nmos W=0.155u L=0.04u
M5914 n3604 g1866 U4088/net40 VSS nmos W=0.155u L=0.04u
M5915 n3604 U4088/net19 U4088/net36 VSS nmos W=0.155u L=0.04u
M5916 U4088/net40 n4066 VSS VSS nmos W=0.31u L=0.04u
M5917 U4088/net36 g1869 VSS VSS nmos W=0.155u L=0.04u
M5918 U4088/net19 g1866 VDD VDD pmos W=0.205u L=0.04u
M5919 n3604 U4088/net19 U4088/net26 VDD pmos W=0.325u L=0.04u
M5920 U4088/net26 n4066 VDD VDD pmos W=0.41u L=0.04u
M5921 n3604 g1866 U4088/net30 VDD pmos W=0.325u L=0.04u
M5922 U4088/net30 g1869 VDD VDD pmos W=0.205u L=0.04u
M5923 U4089/net19 n4068 VSS VSS nmos W=0.155u L=0.04u
M5924 n3603 n4068 U4089/net40 VSS nmos W=0.155u L=0.04u
M5925 n3603 U4089/net19 U4089/net36 VSS nmos W=0.155u L=0.04u
M5926 U4089/net40 n4067 VSS VSS nmos W=0.31u L=0.04u
M5927 U4089/net36 g1546 VSS VSS nmos W=0.155u L=0.04u
M5928 U4089/net19 n4068 VDD VDD pmos W=0.205u L=0.04u
M5929 n3603 U4089/net19 U4089/net26 VDD pmos W=0.325u L=0.04u
M5930 U4089/net26 n4067 VDD VDD pmos W=0.41u L=0.04u
M5931 n3603 n4068 U4089/net30 VDD pmos W=0.325u L=0.04u
M5932 U4089/net30 g1546 VDD VDD pmos W=0.205u L=0.04u
M5933 U4090/net19 n4069 VSS VSS nmos W=0.155u L=0.04u
M5934 n3602 n4069 U4090/net40 VSS nmos W=0.155u L=0.04u
M5935 n3602 U4090/net19 U4090/net36 VSS nmos W=0.155u L=0.04u
M5936 U4090/net40 n4067 VSS VSS nmos W=0.31u L=0.04u
M5937 U4090/net36 g1544 VSS VSS nmos W=0.155u L=0.04u
M5938 U4090/net19 n4069 VDD VDD pmos W=0.205u L=0.04u
M5939 n3602 U4090/net19 U4090/net26 VDD pmos W=0.325u L=0.04u
M5940 U4090/net26 n4067 VDD VDD pmos W=0.41u L=0.04u
M5941 n3602 n4069 U4090/net30 VDD pmos W=0.325u L=0.04u
M5942 U4090/net30 g1544 VDD VDD pmos W=0.205u L=0.04u
M5943 U4091/net19 n4068 VSS VSS nmos W=0.155u L=0.04u
M5944 n3601 n4068 U4091/net40 VSS nmos W=0.155u L=0.04u
M5945 n3601 U4091/net19 U4091/net36 VSS nmos W=0.155u L=0.04u
M5946 U4091/net40 n4070 VSS VSS nmos W=0.31u L=0.04u
M5947 U4091/net36 g1543 VSS VSS nmos W=0.155u L=0.04u
M5948 U4091/net19 n4068 VDD VDD pmos W=0.205u L=0.04u
M5949 n3601 U4091/net19 U4091/net26 VDD pmos W=0.325u L=0.04u
M5950 U4091/net26 n4070 VDD VDD pmos W=0.41u L=0.04u
M5951 n3601 n4068 U4091/net30 VDD pmos W=0.325u L=0.04u
M5952 U4091/net30 g1543 VDD VDD pmos W=0.205u L=0.04u
M5953 U4092/net19 n4069 VSS VSS nmos W=0.155u L=0.04u
M5954 n3600 n4069 U4092/net40 VSS nmos W=0.155u L=0.04u
M5955 n3600 U4092/net19 U4092/net36 VSS nmos W=0.155u L=0.04u
M5956 U4092/net40 n4070 VSS VSS nmos W=0.31u L=0.04u
M5957 U4092/net36 g1541 VSS VSS nmos W=0.155u L=0.04u
M5958 U4092/net19 n4069 VDD VDD pmos W=0.205u L=0.04u
M5959 n3600 U4092/net19 U4092/net26 VDD pmos W=0.325u L=0.04u
M5960 U4092/net26 n4070 VDD VDD pmos W=0.41u L=0.04u
M5961 n3600 n4069 U4092/net30 VDD pmos W=0.325u L=0.04u
M5962 U4092/net30 g1541 VDD VDD pmos W=0.205u L=0.04u
M5963 U4093/net19 n4071 VSS VSS nmos W=0.155u L=0.04u
M5964 n3599 n4071 U4093/net40 VSS nmos W=0.155u L=0.04u
M5965 n3599 U4093/net19 U4093/net36 VSS nmos W=0.155u L=0.04u
M5966 U4093/net40 n4070 VSS VSS nmos W=0.31u L=0.04u
M5967 U4093/net36 g1542 VSS VSS nmos W=0.155u L=0.04u
M5968 U4093/net19 n4071 VDD VDD pmos W=0.205u L=0.04u
M5969 n3599 U4093/net19 U4093/net26 VDD pmos W=0.325u L=0.04u
M5970 U4093/net26 n4070 VDD VDD pmos W=0.41u L=0.04u
M5971 n3599 n4071 U4093/net30 VDD pmos W=0.325u L=0.04u
M5972 U4093/net30 g1542 VDD VDD pmos W=0.205u L=0.04u
M5973 U4094/net19 n4071 VSS VSS nmos W=0.155u L=0.04u
M5974 n3598 n4071 U4094/net40 VSS nmos W=0.155u L=0.04u
M5975 n3598 U4094/net19 U4094/net36 VSS nmos W=0.155u L=0.04u
M5976 U4094/net40 n4067 VSS VSS nmos W=0.31u L=0.04u
M5977 U4094/net36 g1545 VSS VSS nmos W=0.155u L=0.04u
M5978 U4094/net19 n4071 VDD VDD pmos W=0.205u L=0.04u
M5979 n3598 U4094/net19 U4094/net26 VDD pmos W=0.325u L=0.04u
M5980 U4094/net26 n4067 VDD VDD pmos W=0.41u L=0.04u
M5981 n3598 n4071 U4094/net30 VDD pmos W=0.325u L=0.04u
M5982 U4094/net30 g1545 VDD VDD pmos W=0.205u L=0.04u
M5983 U4095/net19 n4072 VSS VSS nmos W=0.155u L=0.04u
M5984 n3597 n4072 U4095/net40 VSS nmos W=0.155u L=0.04u
M5985 n3597 U4095/net19 U4095/net36 VSS nmos W=0.155u L=0.04u
M5986 U4095/net40 g1345 VSS VSS nmos W=0.31u L=0.04u
M5987 U4095/net36 n3852 VSS VSS nmos W=0.155u L=0.04u
M5988 U4095/net19 n4072 VDD VDD pmos W=0.205u L=0.04u
M5989 n3597 U4095/net19 U4095/net26 VDD pmos W=0.325u L=0.04u
M5990 U4095/net26 g1345 VDD VDD pmos W=0.41u L=0.04u
M5991 n3597 n4072 U4095/net30 VDD pmos W=0.325u L=0.04u
M5992 U4095/net30 n3852 VDD VDD pmos W=0.205u L=0.04u
M5993 U4096/net36 n4074 U4096/net24 VSS nmos W=0.155u L=0.04u
M5994 U4096/net24 n4075 VSS VSS nmos W=0.155u L=0.04u
M5995 n3596 g1326 U4096/net36 VSS nmos W=0.155u L=0.04u
M5996 n3596 n4073 U4096/net36 VSS nmos W=0.155u L=0.04u
M5997 n3596 n4073 U4096/net35 VDD pmos W=0.205u L=0.04u
M5998 U4096/net35 g1326 VDD VDD pmos W=0.205u L=0.04u
M5999 n3596 n4075 VDD VDD pmos W=0.205u L=0.04u
M6000 n3596 n4074 VDD VDD pmos W=0.205u L=0.04u
M6001 n3595 U4097/net27 VDD VDD pmos W=0.205u L=0.04u
M6002 U4097/net11 n4076 U4097/net27 VDD pmos W=0.205u L=0.04u
M6003 U4097/net11 n4074 U4097/net27 VDD pmos W=0.205u L=0.04u
M6004 U4097/net11 n4077 U4097/XI16-net11 VDD pmos W=0.205u L=0.04u
M6005 U4097/XI16-net11 n4078 VDD VDD pmos W=0.205u L=0.04u
M6006 U4097/net27 n4078 VSS VSS nmos W=0.155u L=0.04u
M6007 U4097/net27 n4077 VSS VSS nmos W=0.155u L=0.04u
M6008 n3595 U4097/net27 VSS VSS nmos W=0.155u L=0.04u
M6009 U4097/net27 n4076 U4097/XI12-net17 VSS nmos W=0.155u L=0.04u
M6010 U4097/XI12-net17 n4074 VSS VSS nmos W=0.155u L=0.04u
M6011 U4098/net36 n4079 U4098/net24 VSS nmos W=0.155u L=0.04u
M6012 U4098/net24 n4075 VSS VSS nmos W=0.155u L=0.04u
M6013 n3594 g1339 U4098/net36 VSS nmos W=0.155u L=0.04u
M6014 n3594 n4077 U4098/net36 VSS nmos W=0.155u L=0.04u
M6015 n3594 n4077 U4098/net35 VDD pmos W=0.205u L=0.04u
M6016 U4098/net35 g1339 VDD VDD pmos W=0.205u L=0.04u
M6017 n3594 n4075 VDD VDD pmos W=0.205u L=0.04u
M6018 n3594 n4079 VDD VDD pmos W=0.205u L=0.04u
M6019 n3593 U4099/net27 VDD VDD pmos W=0.205u L=0.04u
M6020 U4099/net11 n4080 U4099/net27 VDD pmos W=0.205u L=0.04u
M6021 U4099/net11 n4079 U4099/net27 VDD pmos W=0.205u L=0.04u
M6022 U4099/net11 n4081 U4099/XI16-net11 VDD pmos W=0.205u L=0.04u
M6023 U4099/XI16-net11 n4078 VDD VDD pmos W=0.205u L=0.04u
M6024 U4099/net27 n4078 VSS VSS nmos W=0.155u L=0.04u
M6025 U4099/net27 n4081 VSS VSS nmos W=0.155u L=0.04u
M6026 n3593 U4099/net27 VSS VSS nmos W=0.155u L=0.04u
M6027 U4099/net27 n4080 U4099/XI12-net17 VSS nmos W=0.155u L=0.04u
M6028 U4099/XI12-net17 n4079 VSS VSS nmos W=0.155u L=0.04u
M6029 U4100/net36 n4082 U4100/net24 VSS nmos W=0.155u L=0.04u
M6030 U4100/net24 n4075 VSS VSS nmos W=0.155u L=0.04u
M6031 n3592 g1346 U4100/net36 VSS nmos W=0.155u L=0.04u
M6032 n3592 n4081 U4100/net36 VSS nmos W=0.155u L=0.04u
M6033 n3592 n4081 U4100/net35 VDD pmos W=0.205u L=0.04u
M6034 U4100/net35 g1346 VDD VDD pmos W=0.205u L=0.04u
M6035 n3592 n4075 VDD VDD pmos W=0.205u L=0.04u
M6036 n3592 n4082 VDD VDD pmos W=0.205u L=0.04u
M6037 n3591 U4101/net27 VDD VDD pmos W=0.205u L=0.04u
M6038 U4101/net11 n4083 U4101/net27 VDD pmos W=0.205u L=0.04u
M6039 U4101/net11 n4082 U4101/net27 VDD pmos W=0.205u L=0.04u
M6040 U4101/net11 n4084 U4101/XI16-net11 VDD pmos W=0.205u L=0.04u
M6041 U4101/XI16-net11 n4078 VDD VDD pmos W=0.205u L=0.04u
M6042 U4101/net27 n4078 VSS VSS nmos W=0.155u L=0.04u
M6043 U4101/net27 n4084 VSS VSS nmos W=0.155u L=0.04u
M6044 n3591 U4101/net27 VSS VSS nmos W=0.155u L=0.04u
M6045 U4101/net27 n4083 U4101/XI12-net17 VSS nmos W=0.155u L=0.04u
M6046 U4101/XI12-net17 n4082 VSS VSS nmos W=0.155u L=0.04u
M6047 n4078 n4075 VSS VSS nmos W=0.135u L=0.04u
M6048 n4078 n4075 VDD VDD pmos W=0.205u L=0.04u
M6049 U4103/net36 n4085 U4103/net24 VSS nmos W=0.155u L=0.04u
M6050 U4103/net24 n4075 VSS VSS nmos W=0.155u L=0.04u
M6051 n3590 g1352 U4103/net36 VSS nmos W=0.155u L=0.04u
M6052 n3590 n4084 U4103/net36 VSS nmos W=0.155u L=0.04u
M6053 n3590 n4084 U4103/net35 VDD pmos W=0.205u L=0.04u
M6054 U4103/net35 g1352 VDD VDD pmos W=0.205u L=0.04u
M6055 n3590 n4075 VDD VDD pmos W=0.205u L=0.04u
M6056 n3590 n4085 VDD VDD pmos W=0.205u L=0.04u
M6057 U4104/net36 n4087 U4104/net24 VSS nmos W=0.155u L=0.04u
M6058 U4104/net24 n4075 VSS VSS nmos W=0.155u L=0.04u
M6059 n3589 g1365 U4104/net36 VSS nmos W=0.155u L=0.04u
M6060 n3589 n4086 U4104/net36 VSS nmos W=0.155u L=0.04u
M6061 n3589 n4086 U4104/net35 VDD pmos W=0.205u L=0.04u
M6062 U4104/net35 g1365 VDD VDD pmos W=0.205u L=0.04u
M6063 n3589 n4075 VDD VDD pmos W=0.205u L=0.04u
M6064 n3589 n4087 VDD VDD pmos W=0.205u L=0.04u
M6065 U4105/XU1-net6 n4075 VSS VSS nmos W=0.155u L=0.04u
M6066 n3588 n4088 U4105/XU1-net6 VSS nmos W=0.155u L=0.04u
M6067 n3588 n4075 VDD VDD pmos W=0.155u L=0.04u
M6068 n3588 n4088 VDD VDD pmos W=0.155u L=0.04u
M6069 U4106/net4 n4087 U4106/net14 VSS nmos W=0.155u L=0.04u
M6070 U4106/net6 U4106/net10 U4106/net14 VSS nmos W=0.17u L=0.04u
M6071 U4106/net4 g1372 VSS VSS nmos W=0.155u L=0.04u
M6072 U4106/net6 U4106/net4 VSS VSS nmos W=0.17u L=0.04u
M6073 n4088 U4106/net14 VSS VSS nmos W=0.155u L=0.04u
M6074 U4106/net10 n4087 VSS VSS nmos W=0.155u L=0.04u
M6075 U4106/net4 U4106/net10 U4106/net14 VDD pmos W=0.255u L=0.04u
M6076 U4106/net6 n4087 U4106/net14 VDD pmos W=0.28u L=0.04u
M6077 U4106/net4 g1372 VDD VDD pmos W=0.205u L=0.04u
M6078 U4106/net6 U4106/net4 VDD VDD pmos W=0.24u L=0.04u
M6079 n4088 U4106/net14 VDD VDD pmos W=0.205u L=0.04u
M6080 U4106/net10 n4087 VDD VDD pmos W=0.205u L=0.04u
M6081 U4107/XU1-net6 n4075 VSS VSS nmos W=0.155u L=0.04u
M6082 n3587 n4089 U4107/XU1-net6 VSS nmos W=0.155u L=0.04u
M6083 n3587 n4075 VDD VDD pmos W=0.155u L=0.04u
M6084 n3587 n4089 VDD VDD pmos W=0.155u L=0.04u
M6085 U4108/net4 n4090 U4108/net14 VSS nmos W=0.155u L=0.04u
M6086 U4108/net6 U4108/net10 U4108/net14 VSS nmos W=0.17u L=0.04u
M6087 U4108/net4 n4091 VSS VSS nmos W=0.155u L=0.04u
M6088 U4108/net6 U4108/net4 VSS VSS nmos W=0.17u L=0.04u
M6089 n4089 U4108/net14 VSS VSS nmos W=0.155u L=0.04u
M6090 U4108/net10 n4090 VSS VSS nmos W=0.155u L=0.04u
M6091 U4108/net4 U4108/net10 U4108/net14 VDD pmos W=0.255u L=0.04u
M6092 U4108/net6 n4090 U4108/net14 VDD pmos W=0.28u L=0.04u
M6093 U4108/net4 n4091 VDD VDD pmos W=0.205u L=0.04u
M6094 U4108/net6 U4108/net4 VDD VDD pmos W=0.24u L=0.04u
M6095 n4089 U4108/net14 VDD VDD pmos W=0.205u L=0.04u
M6096 U4108/net10 n4090 VDD VDD pmos W=0.205u L=0.04u
M6097 n4091 n4092 VSS VSS nmos W=0.155u L=0.04u
M6098 n4091 n4087 VSS VSS nmos W=0.155u L=0.04u
M6099 U4109/XI1-net8 n4087 VDD VDD pmos W=0.205u L=0.04u
M6100 n4091 n4092 U4109/XI1-net8 VDD pmos W=0.205u L=0.04u
M6101 U4110/XU1-net6 n4086 VSS VSS nmos W=0.155u L=0.04u
M6102 n4087 g1365 U4110/XU1-net6 VSS nmos W=0.155u L=0.04u
M6103 n4087 n4086 VDD VDD pmos W=0.155u L=0.04u
M6104 n4087 g1365 VDD VDD pmos W=0.155u L=0.04u
M6105 n4086 n4085 VSS VSS nmos W=0.135u L=0.04u
M6106 n4086 n4085 VDD VDD pmos W=0.205u L=0.04u
M6107 U4112/XU1-net6 n4084 VSS VSS nmos W=0.155u L=0.04u
M6108 n4085 g1352 U4112/XU1-net6 VSS nmos W=0.155u L=0.04u
M6109 n4085 n4084 VDD VDD pmos W=0.155u L=0.04u
M6110 n4085 g1352 VDD VDD pmos W=0.155u L=0.04u
M6111 n4084 n4083 VSS VSS nmos W=0.155u L=0.04u
M6112 n4084 n4082 VSS VSS nmos W=0.155u L=0.04u
M6113 U4113/XI1-net8 n4082 VDD VDD pmos W=0.205u L=0.04u
M6114 n4084 n4083 U4113/XI1-net8 VDD pmos W=0.205u L=0.04u
M6115 U4114/XU1-net6 n4081 VSS VSS nmos W=0.155u L=0.04u
M6116 n4082 g1346 U4114/XU1-net6 VSS nmos W=0.155u L=0.04u
M6117 n4082 n4081 VDD VDD pmos W=0.155u L=0.04u
M6118 n4082 g1346 VDD VDD pmos W=0.155u L=0.04u
M6119 n4081 n4080 VSS VSS nmos W=0.155u L=0.04u
M6120 n4081 n4079 VSS VSS nmos W=0.155u L=0.04u
M6121 U4115/XI1-net8 n4079 VDD VDD pmos W=0.205u L=0.04u
M6122 n4081 n4080 U4115/XI1-net8 VDD pmos W=0.205u L=0.04u
M6123 U4116/XU1-net6 n4077 VSS VSS nmos W=0.155u L=0.04u
M6124 n4079 g1339 U4116/XU1-net6 VSS nmos W=0.155u L=0.04u
M6125 n4079 n4077 VDD VDD pmos W=0.155u L=0.04u
M6126 n4079 g1339 VDD VDD pmos W=0.155u L=0.04u
M6127 n4077 n4076 VSS VSS nmos W=0.155u L=0.04u
M6128 n4077 n4074 VSS VSS nmos W=0.155u L=0.04u
M6129 U4117/XI1-net8 n4074 VDD VDD pmos W=0.205u L=0.04u
M6130 n4077 n4076 U4117/XI1-net8 VDD pmos W=0.205u L=0.04u
M6131 U4118/XU1-net6 n4073 VSS VSS nmos W=0.155u L=0.04u
M6132 n4074 g1326 U4118/XU1-net6 VSS nmos W=0.155u L=0.04u
M6133 n4074 n4073 VDD VDD pmos W=0.155u L=0.04u
M6134 n4074 g1326 VDD VDD pmos W=0.155u L=0.04u
M6135 n4073 n4072 VSS VSS nmos W=0.155u L=0.04u
M6136 n4073 g1345 VSS VSS nmos W=0.155u L=0.04u
M6137 U4119/XI1-net8 g1345 VDD VDD pmos W=0.205u L=0.04u
M6138 n4073 n4072 U4119/XI1-net8 VDD pmos W=0.205u L=0.04u
M6139 n3586 g1423 U4120/net15 VSS nmos W=0.155u L=0.04u
M6140 n3586 n4093 U4120/net15 VSS nmos W=0.155u L=0.04u
M6141 U4120/net15 n4094 VSS VSS nmos W=0.155u L=0.04u
M6142 n3586 n4094 VDD VDD pmos W=0.205u L=0.04u
M6143 n3586 g1423 U4120/XI16-net11 VDD pmos W=0.205u L=0.04u
M6144 U4120/XI16-net11 n4093 VDD VDD pmos W=0.205u L=0.04u
M6145 n3585 g1425 U4121/net15 VSS nmos W=0.155u L=0.04u
M6146 n3585 n4095 U4121/net15 VSS nmos W=0.155u L=0.04u
M6147 U4121/net15 n4075 VSS VSS nmos W=0.155u L=0.04u
M6148 n3585 n4075 VDD VDD pmos W=0.205u L=0.04u
M6149 n3585 g1425 U4121/XI16-net11 VDD pmos W=0.205u L=0.04u
M6150 U4121/XI16-net11 n4095 VDD VDD pmos W=0.205u L=0.04u
M6151 n3584 g1424 U4122/net15 VSS nmos W=0.155u L=0.04u
M6152 n3584 n4096 U4122/net15 VSS nmos W=0.155u L=0.04u
M6153 U4122/net15 n4097 VSS VSS nmos W=0.155u L=0.04u
M6154 n3584 n4097 VDD VDD pmos W=0.205u L=0.04u
M6155 n3584 g1424 U4122/XI16-net11 VDD pmos W=0.205u L=0.04u
M6156 U4122/XI16-net11 n4096 VDD VDD pmos W=0.205u L=0.04u
M6157 U4123/net19 n4093 VSS VSS nmos W=0.155u L=0.04u
M6158 n3583 n4093 U4123/net40 VSS nmos W=0.155u L=0.04u
M6159 n3583 U4123/net19 U4123/net36 VSS nmos W=0.155u L=0.04u
M6160 U4123/net40 n4098 VSS VSS nmos W=0.31u L=0.04u
M6161 U4123/net36 g1384 VSS VSS nmos W=0.155u L=0.04u
M6162 U4123/net19 n4093 VDD VDD pmos W=0.205u L=0.04u
M6163 n3583 U4123/net19 U4123/net26 VDD pmos W=0.325u L=0.04u
M6164 U4123/net26 n4098 VDD VDD pmos W=0.41u L=0.04u
M6165 n3583 n4093 U4123/net30 VDD pmos W=0.325u L=0.04u
M6166 U4123/net30 g1384 VDD VDD pmos W=0.205u L=0.04u
M6167 U4124/net19 n4093 VSS VSS nmos W=0.155u L=0.04u
M6168 n3582 n4093 U4124/net40 VSS nmos W=0.155u L=0.04u
M6169 n3582 U4124/net19 U4124/net36 VSS nmos W=0.155u L=0.04u
M6170 U4124/net40 n4090 VSS VSS nmos W=0.31u L=0.04u
M6171 U4124/net36 g1411 VSS VSS nmos W=0.155u L=0.04u
M6172 U4124/net19 n4093 VDD VDD pmos W=0.205u L=0.04u
M6173 n3582 U4124/net19 U4124/net26 VDD pmos W=0.325u L=0.04u
M6174 U4124/net26 n4090 VDD VDD pmos W=0.41u L=0.04u
M6175 n3582 n4093 U4124/net30 VDD pmos W=0.325u L=0.04u
M6176 U4124/net30 g1411 VDD VDD pmos W=0.205u L=0.04u
M6177 U4125/net19 n4093 VSS VSS nmos W=0.155u L=0.04u
M6178 n3581 n4093 U4125/net40 VSS nmos W=0.155u L=0.04u
M6179 n3581 U4125/net19 U4125/net36 VSS nmos W=0.155u L=0.04u
M6180 U4125/net40 n4076 VSS VSS nmos W=0.31u L=0.04u
M6181 U4125/net36 g1387 VSS VSS nmos W=0.155u L=0.04u
M6182 U4125/net19 n4093 VDD VDD pmos W=0.205u L=0.04u
M6183 n3581 U4125/net19 U4125/net26 VDD pmos W=0.325u L=0.04u
M6184 U4125/net26 n4076 VDD VDD pmos W=0.41u L=0.04u
M6185 n3581 n4093 U4125/net30 VDD pmos W=0.325u L=0.04u
M6186 U4125/net30 g1387 VDD VDD pmos W=0.205u L=0.04u
M6187 U4126/net19 n4093 VSS VSS nmos W=0.155u L=0.04u
M6188 n3580 n4093 U4126/net40 VSS nmos W=0.155u L=0.04u
M6189 n3580 U4126/net19 U4126/net36 VSS nmos W=0.155u L=0.04u
M6190 U4126/net40 n4099 VSS VSS nmos W=0.31u L=0.04u
M6191 U4126/net36 g1390 VSS VSS nmos W=0.155u L=0.04u
M6192 U4126/net19 n4093 VDD VDD pmos W=0.205u L=0.04u
M6193 n3580 U4126/net19 U4126/net26 VDD pmos W=0.325u L=0.04u
M6194 U4126/net26 n4099 VDD VDD pmos W=0.41u L=0.04u
M6195 n3580 n4093 U4126/net30 VDD pmos W=0.325u L=0.04u
M6196 U4126/net30 g1390 VDD VDD pmos W=0.205u L=0.04u
M6197 U4127/net19 n4093 VSS VSS nmos W=0.155u L=0.04u
M6198 n3579 n4093 U4127/net40 VSS nmos W=0.155u L=0.04u
M6199 n3579 U4127/net19 U4127/net36 VSS nmos W=0.155u L=0.04u
M6200 U4127/net40 n4080 VSS VSS nmos W=0.31u L=0.04u
M6201 U4127/net36 g1393 VSS VSS nmos W=0.155u L=0.04u
M6202 U4127/net19 n4093 VDD VDD pmos W=0.205u L=0.04u
M6203 n3579 U4127/net19 U4127/net26 VDD pmos W=0.325u L=0.04u
M6204 U4127/net26 n4080 VDD VDD pmos W=0.41u L=0.04u
M6205 n3579 n4093 U4127/net30 VDD pmos W=0.325u L=0.04u
M6206 U4127/net30 g1393 VDD VDD pmos W=0.205u L=0.04u
M6207 U4128/net19 n4093 VSS VSS nmos W=0.155u L=0.04u
M6208 n3578 n4093 U4128/net40 VSS nmos W=0.155u L=0.04u
M6209 n3578 U4128/net19 U4128/net36 VSS nmos W=0.155u L=0.04u
M6210 U4128/net40 n4100 VSS VSS nmos W=0.31u L=0.04u
M6211 U4128/net36 g1396 VSS VSS nmos W=0.155u L=0.04u
M6212 U4128/net19 n4093 VDD VDD pmos W=0.205u L=0.04u
M6213 n3578 U4128/net19 U4128/net26 VDD pmos W=0.325u L=0.04u
M6214 U4128/net26 n4100 VDD VDD pmos W=0.41u L=0.04u
M6215 n3578 n4093 U4128/net30 VDD pmos W=0.325u L=0.04u
M6216 U4128/net30 g1396 VDD VDD pmos W=0.205u L=0.04u
M6217 U4129/net19 n4093 VSS VSS nmos W=0.155u L=0.04u
M6218 n3577 n4093 U4129/net40 VSS nmos W=0.155u L=0.04u
M6219 n3577 U4129/net19 U4129/net36 VSS nmos W=0.155u L=0.04u
M6220 U4129/net40 n4083 VSS VSS nmos W=0.31u L=0.04u
M6221 U4129/net36 g1399 VSS VSS nmos W=0.155u L=0.04u
M6222 U4129/net19 n4093 VDD VDD pmos W=0.205u L=0.04u
M6223 n3577 U4129/net19 U4129/net26 VDD pmos W=0.325u L=0.04u
M6224 U4129/net26 n4083 VDD VDD pmos W=0.41u L=0.04u
M6225 n3577 n4093 U4129/net30 VDD pmos W=0.325u L=0.04u
M6226 U4129/net30 g1399 VDD VDD pmos W=0.205u L=0.04u
M6227 U4130/net19 n4093 VSS VSS nmos W=0.155u L=0.04u
M6228 n3576 n4093 U4130/net40 VSS nmos W=0.155u L=0.04u
M6229 n3576 U4130/net19 U4130/net36 VSS nmos W=0.155u L=0.04u
M6230 U4130/net40 n4101 VSS VSS nmos W=0.31u L=0.04u
M6231 U4130/net36 g1402 VSS VSS nmos W=0.155u L=0.04u
M6232 U4130/net19 n4093 VDD VDD pmos W=0.205u L=0.04u
M6233 n3576 U4130/net19 U4130/net26 VDD pmos W=0.325u L=0.04u
M6234 U4130/net26 n4101 VDD VDD pmos W=0.41u L=0.04u
M6235 n3576 n4093 U4130/net30 VDD pmos W=0.325u L=0.04u
M6236 U4130/net30 g1402 VDD VDD pmos W=0.205u L=0.04u
M6237 U4131/net19 n4093 VSS VSS nmos W=0.155u L=0.04u
M6238 n3575 n4093 U4131/net40 VSS nmos W=0.155u L=0.04u
M6239 n3575 U4131/net19 U4131/net36 VSS nmos W=0.155u L=0.04u
M6240 U4131/net40 n4102 VSS VSS nmos W=0.31u L=0.04u
M6241 U4131/net36 g1420 VSS VSS nmos W=0.155u L=0.04u
M6242 U4131/net19 n4093 VDD VDD pmos W=0.205u L=0.04u
M6243 n3575 U4131/net19 U4131/net26 VDD pmos W=0.325u L=0.04u
M6244 U4131/net26 n4102 VDD VDD pmos W=0.41u L=0.04u
M6245 n3575 n4093 U4131/net30 VDD pmos W=0.325u L=0.04u
M6246 U4131/net30 g1420 VDD VDD pmos W=0.205u L=0.04u
M6247 U4132/net19 n4093 VSS VSS nmos W=0.155u L=0.04u
M6248 n3574 n4093 U4132/net40 VSS nmos W=0.155u L=0.04u
M6249 n3574 U4132/net19 U4132/net36 VSS nmos W=0.155u L=0.04u
M6250 U4132/net40 n4103 VSS VSS nmos W=0.31u L=0.04u
M6251 U4132/net36 g1405 VSS VSS nmos W=0.155u L=0.04u
M6252 U4132/net19 n4093 VDD VDD pmos W=0.205u L=0.04u
M6253 n3574 U4132/net19 U4132/net26 VDD pmos W=0.325u L=0.04u
M6254 U4132/net26 n4103 VDD VDD pmos W=0.41u L=0.04u
M6255 n3574 n4093 U4132/net30 VDD pmos W=0.325u L=0.04u
M6256 U4132/net30 g1405 VDD VDD pmos W=0.205u L=0.04u
M6257 U4133/net19 n4093 VSS VSS nmos W=0.155u L=0.04u
M6258 n3573 n4093 U4133/net40 VSS nmos W=0.155u L=0.04u
M6259 n3573 U4133/net19 U4133/net36 VSS nmos W=0.155u L=0.04u
M6260 U4133/net40 n4092 VSS VSS nmos W=0.31u L=0.04u
M6261 U4133/net36 g1408 VSS VSS nmos W=0.155u L=0.04u
M6262 U4133/net19 n4093 VDD VDD pmos W=0.205u L=0.04u
M6263 n3573 U4133/net19 U4133/net26 VDD pmos W=0.325u L=0.04u
M6264 U4133/net26 n4092 VDD VDD pmos W=0.41u L=0.04u
M6265 n3573 n4093 U4133/net30 VDD pmos W=0.325u L=0.04u
M6266 U4133/net30 g1408 VDD VDD pmos W=0.205u L=0.04u
M6267 n4093 n4104 VSS VSS nmos W=0.155u L=0.04u
M6268 n4093 n4072 VSS VSS nmos W=0.155u L=0.04u
M6269 U4134/XI1-net8 n4072 VDD VDD pmos W=0.205u L=0.04u
M6270 n4093 n4104 U4134/XI1-net8 VDD pmos W=0.205u L=0.04u
M6271 U4135/net19 n4095 VSS VSS nmos W=0.155u L=0.04u
M6272 n3572 n4095 U4135/net40 VSS nmos W=0.155u L=0.04u
M6273 n3572 U4135/net19 U4135/net36 VSS nmos W=0.155u L=0.04u
M6274 U4135/net40 n4098 VSS VSS nmos W=0.31u L=0.04u
M6275 U4135/net36 g1386 VSS VSS nmos W=0.155u L=0.04u
M6276 U4135/net19 n4095 VDD VDD pmos W=0.205u L=0.04u
M6277 n3572 U4135/net19 U4135/net26 VDD pmos W=0.325u L=0.04u
M6278 U4135/net26 n4098 VDD VDD pmos W=0.41u L=0.04u
M6279 n3572 n4095 U4135/net30 VDD pmos W=0.325u L=0.04u
M6280 U4135/net30 g1386 VDD VDD pmos W=0.205u L=0.04u
M6281 U4136/net19 n4095 VSS VSS nmos W=0.155u L=0.04u
M6282 n3571 n4095 U4136/net40 VSS nmos W=0.155u L=0.04u
M6283 n3571 U4136/net19 U4136/net36 VSS nmos W=0.155u L=0.04u
M6284 U4136/net40 n4090 VSS VSS nmos W=0.31u L=0.04u
M6285 U4136/net36 g1413 VSS VSS nmos W=0.155u L=0.04u
M6286 U4136/net19 n4095 VDD VDD pmos W=0.205u L=0.04u
M6287 n3571 U4136/net19 U4136/net26 VDD pmos W=0.325u L=0.04u
M6288 U4136/net26 n4090 VDD VDD pmos W=0.41u L=0.04u
M6289 n3571 n4095 U4136/net30 VDD pmos W=0.325u L=0.04u
M6290 U4136/net30 g1413 VDD VDD pmos W=0.205u L=0.04u
M6291 U4137/net19 n4096 VSS VSS nmos W=0.155u L=0.04u
M6292 n3570 n4096 U4137/net40 VSS nmos W=0.155u L=0.04u
M6293 n3570 U4137/net19 U4137/net36 VSS nmos W=0.155u L=0.04u
M6294 U4137/net40 n4098 VSS VSS nmos W=0.31u L=0.04u
M6295 U4137/net36 g1385 VSS VSS nmos W=0.155u L=0.04u
M6296 U4137/net19 n4096 VDD VDD pmos W=0.205u L=0.04u
M6297 n3570 U4137/net19 U4137/net26 VDD pmos W=0.325u L=0.04u
M6298 U4137/net26 n4098 VDD VDD pmos W=0.41u L=0.04u
M6299 n3570 n4096 U4137/net30 VDD pmos W=0.325u L=0.04u
M6300 U4137/net30 g1385 VDD VDD pmos W=0.205u L=0.04u
M6301 U4138/net19 n4095 VSS VSS nmos W=0.155u L=0.04u
M6302 n3569 n4095 U4138/net40 VSS nmos W=0.155u L=0.04u
M6303 n3569 U4138/net19 U4138/net36 VSS nmos W=0.155u L=0.04u
M6304 U4138/net40 n4076 VSS VSS nmos W=0.31u L=0.04u
M6305 U4138/net36 g1389 VSS VSS nmos W=0.155u L=0.04u
M6306 U4138/net19 n4095 VDD VDD pmos W=0.205u L=0.04u
M6307 n3569 U4138/net19 U4138/net26 VDD pmos W=0.325u L=0.04u
M6308 U4138/net26 n4076 VDD VDD pmos W=0.41u L=0.04u
M6309 n3569 n4095 U4138/net30 VDD pmos W=0.325u L=0.04u
M6310 U4138/net30 g1389 VDD VDD pmos W=0.205u L=0.04u
M6311 U4139/net19 n4096 VSS VSS nmos W=0.155u L=0.04u
M6312 n3568 n4096 U4139/net40 VSS nmos W=0.155u L=0.04u
M6313 n3568 U4139/net19 U4139/net36 VSS nmos W=0.155u L=0.04u
M6314 U4139/net40 n4090 VSS VSS nmos W=0.31u L=0.04u
M6315 U4139/net36 g1412 VSS VSS nmos W=0.155u L=0.04u
M6316 U4139/net19 n4096 VDD VDD pmos W=0.205u L=0.04u
M6317 n3568 U4139/net19 U4139/net26 VDD pmos W=0.325u L=0.04u
M6318 U4139/net26 n4090 VDD VDD pmos W=0.41u L=0.04u
M6319 n3568 n4096 U4139/net30 VDD pmos W=0.325u L=0.04u
M6320 U4139/net30 g1412 VDD VDD pmos W=0.205u L=0.04u
M6321 n4090 g1378 VSS VSS nmos W=0.135u L=0.04u
M6322 n4090 g1378 VDD VDD pmos W=0.205u L=0.04u
M6323 U4141/net19 n4096 VSS VSS nmos W=0.155u L=0.04u
M6324 n3567 n4096 U4141/net40 VSS nmos W=0.155u L=0.04u
M6325 n3567 U4141/net19 U4141/net36 VSS nmos W=0.155u L=0.04u
M6326 U4141/net40 n4076 VSS VSS nmos W=0.31u L=0.04u
M6327 U4141/net36 g1388 VSS VSS nmos W=0.155u L=0.04u
M6328 U4141/net19 n4096 VDD VDD pmos W=0.205u L=0.04u
M6329 n3567 U4141/net19 U4141/net26 VDD pmos W=0.325u L=0.04u
M6330 U4141/net26 n4076 VDD VDD pmos W=0.41u L=0.04u
M6331 n3567 n4096 U4141/net30 VDD pmos W=0.325u L=0.04u
M6332 U4141/net30 g1388 VDD VDD pmos W=0.205u L=0.04u
M6333 n4076 g1319 VSS VSS nmos W=0.135u L=0.04u
M6334 n4076 g1319 VDD VDD pmos W=0.205u L=0.04u
M6335 U4143/net19 n4095 VSS VSS nmos W=0.155u L=0.04u
M6336 n3566 n4095 U4143/net40 VSS nmos W=0.155u L=0.04u
M6337 n3566 U4143/net19 U4143/net36 VSS nmos W=0.155u L=0.04u
M6338 U4143/net40 n4099 VSS VSS nmos W=0.31u L=0.04u
M6339 U4143/net36 g1392 VSS VSS nmos W=0.155u L=0.04u
M6340 U4143/net19 n4095 VDD VDD pmos W=0.205u L=0.04u
M6341 n3566 U4143/net19 U4143/net26 VDD pmos W=0.325u L=0.04u
M6342 U4143/net26 n4099 VDD VDD pmos W=0.41u L=0.04u
M6343 n3566 n4095 U4143/net30 VDD pmos W=0.325u L=0.04u
M6344 U4143/net30 g1392 VDD VDD pmos W=0.205u L=0.04u
M6345 U4144/net19 n4096 VSS VSS nmos W=0.155u L=0.04u
M6346 n3565 n4096 U4144/net40 VSS nmos W=0.155u L=0.04u
M6347 n3565 U4144/net19 U4144/net36 VSS nmos W=0.155u L=0.04u
M6348 U4144/net40 n4099 VSS VSS nmos W=0.31u L=0.04u
M6349 U4144/net36 g1391 VSS VSS nmos W=0.155u L=0.04u
M6350 U4144/net19 n4096 VDD VDD pmos W=0.205u L=0.04u
M6351 n3565 U4144/net19 U4144/net26 VDD pmos W=0.325u L=0.04u
M6352 U4144/net26 n4099 VDD VDD pmos W=0.41u L=0.04u
M6353 n3565 n4096 U4144/net30 VDD pmos W=0.325u L=0.04u
M6354 U4144/net30 g1391 VDD VDD pmos W=0.205u L=0.04u
M6355 n4099 g1339 VSS VSS nmos W=0.135u L=0.04u
M6356 n4099 g1339 VDD VDD pmos W=0.205u L=0.04u
M6357 U4146/net19 n4095 VSS VSS nmos W=0.155u L=0.04u
M6358 n3564 n4095 U4146/net40 VSS nmos W=0.155u L=0.04u
M6359 n3564 U4146/net19 U4146/net36 VSS nmos W=0.155u L=0.04u
M6360 U4146/net40 n4080 VSS VSS nmos W=0.31u L=0.04u
M6361 U4146/net36 g1395 VSS VSS nmos W=0.155u L=0.04u
M6362 U4146/net19 n4095 VDD VDD pmos W=0.205u L=0.04u
M6363 n3564 U4146/net19 U4146/net26 VDD pmos W=0.325u L=0.04u
M6364 U4146/net26 n4080 VDD VDD pmos W=0.41u L=0.04u
M6365 n3564 n4095 U4146/net30 VDD pmos W=0.325u L=0.04u
M6366 U4146/net30 g1395 VDD VDD pmos W=0.205u L=0.04u
M6367 U4147/net19 n4096 VSS VSS nmos W=0.155u L=0.04u
M6368 n3563 n4096 U4147/net40 VSS nmos W=0.155u L=0.04u
M6369 n3563 U4147/net19 U4147/net36 VSS nmos W=0.155u L=0.04u
M6370 U4147/net40 n4080 VSS VSS nmos W=0.31u L=0.04u
M6371 U4147/net36 g1394 VSS VSS nmos W=0.155u L=0.04u
M6372 U4147/net19 n4096 VDD VDD pmos W=0.205u L=0.04u
M6373 n3563 U4147/net19 U4147/net26 VDD pmos W=0.325u L=0.04u
M6374 U4147/net26 n4080 VDD VDD pmos W=0.41u L=0.04u
M6375 n3563 n4096 U4147/net30 VDD pmos W=0.325u L=0.04u
M6376 U4147/net30 g1394 VDD VDD pmos W=0.205u L=0.04u
M6377 n4080 g1332 VSS VSS nmos W=0.135u L=0.04u
M6378 n4080 g1332 VDD VDD pmos W=0.205u L=0.04u
M6379 U4149/net19 n4095 VSS VSS nmos W=0.155u L=0.04u
M6380 n3562 n4095 U4149/net40 VSS nmos W=0.155u L=0.04u
M6381 n3562 U4149/net19 U4149/net36 VSS nmos W=0.155u L=0.04u
M6382 U4149/net40 n4100 VSS VSS nmos W=0.31u L=0.04u
M6383 U4149/net36 g1398 VSS VSS nmos W=0.155u L=0.04u
M6384 U4149/net19 n4095 VDD VDD pmos W=0.205u L=0.04u
M6385 n3562 U4149/net19 U4149/net26 VDD pmos W=0.325u L=0.04u
M6386 U4149/net26 n4100 VDD VDD pmos W=0.41u L=0.04u
M6387 n3562 n4095 U4149/net30 VDD pmos W=0.325u L=0.04u
M6388 U4149/net30 g1398 VDD VDD pmos W=0.205u L=0.04u
M6389 U4150/net19 n4096 VSS VSS nmos W=0.155u L=0.04u
M6390 n3561 n4096 U4150/net40 VSS nmos W=0.155u L=0.04u
M6391 n3561 U4150/net19 U4150/net36 VSS nmos W=0.155u L=0.04u
M6392 U4150/net40 n4100 VSS VSS nmos W=0.31u L=0.04u
M6393 U4150/net36 g1397 VSS VSS nmos W=0.155u L=0.04u
M6394 U4150/net19 n4096 VDD VDD pmos W=0.205u L=0.04u
M6395 n3561 U4150/net19 U4150/net26 VDD pmos W=0.325u L=0.04u
M6396 U4150/net26 n4100 VDD VDD pmos W=0.41u L=0.04u
M6397 n3561 n4096 U4150/net30 VDD pmos W=0.325u L=0.04u
M6398 U4150/net30 g1397 VDD VDD pmos W=0.205u L=0.04u
M6399 n4100 g1346 VSS VSS nmos W=0.135u L=0.04u
M6400 n4100 g1346 VDD VDD pmos W=0.205u L=0.04u
M6401 U4152/net19 n4095 VSS VSS nmos W=0.155u L=0.04u
M6402 n3560 n4095 U4152/net40 VSS nmos W=0.155u L=0.04u
M6403 n3560 U4152/net19 U4152/net36 VSS nmos W=0.155u L=0.04u
M6404 U4152/net40 n4083 VSS VSS nmos W=0.31u L=0.04u
M6405 U4152/net36 g1401 VSS VSS nmos W=0.155u L=0.04u
M6406 U4152/net19 n4095 VDD VDD pmos W=0.205u L=0.04u
M6407 n3560 U4152/net19 U4152/net26 VDD pmos W=0.325u L=0.04u
M6408 U4152/net26 n4083 VDD VDD pmos W=0.41u L=0.04u
M6409 n3560 n4095 U4152/net30 VDD pmos W=0.325u L=0.04u
M6410 U4152/net30 g1401 VDD VDD pmos W=0.205u L=0.04u
M6411 U4153/net19 n4096 VSS VSS nmos W=0.155u L=0.04u
M6412 n3559 n4096 U4153/net40 VSS nmos W=0.155u L=0.04u
M6413 n3559 U4153/net19 U4153/net36 VSS nmos W=0.155u L=0.04u
M6414 U4153/net40 n4083 VSS VSS nmos W=0.31u L=0.04u
M6415 U4153/net36 g1400 VSS VSS nmos W=0.155u L=0.04u
M6416 U4153/net19 n4096 VDD VDD pmos W=0.205u L=0.04u
M6417 n3559 U4153/net19 U4153/net26 VDD pmos W=0.325u L=0.04u
M6418 U4153/net26 n4083 VDD VDD pmos W=0.41u L=0.04u
M6419 n3559 n4096 U4153/net30 VDD pmos W=0.325u L=0.04u
M6420 U4153/net30 g1400 VDD VDD pmos W=0.205u L=0.04u
M6421 U4154/net19 n4095 VSS VSS nmos W=0.155u L=0.04u
M6422 n3558 n4095 U4154/net40 VSS nmos W=0.155u L=0.04u
M6423 n3558 U4154/net19 U4154/net36 VSS nmos W=0.155u L=0.04u
M6424 U4154/net40 n4101 VSS VSS nmos W=0.31u L=0.04u
M6425 U4154/net36 g1404 VSS VSS nmos W=0.155u L=0.04u
M6426 U4154/net19 n4095 VDD VDD pmos W=0.205u L=0.04u
M6427 n3558 U4154/net19 U4154/net26 VDD pmos W=0.325u L=0.04u
M6428 U4154/net26 n4101 VDD VDD pmos W=0.41u L=0.04u
M6429 n3558 n4095 U4154/net30 VDD pmos W=0.325u L=0.04u
M6430 U4154/net30 g1404 VDD VDD pmos W=0.205u L=0.04u
M6431 U4155/net19 n4095 VSS VSS nmos W=0.155u L=0.04u
M6432 n3557 n4095 U4155/net40 VSS nmos W=0.155u L=0.04u
M6433 n3557 U4155/net19 U4155/net36 VSS nmos W=0.155u L=0.04u
M6434 U4155/net40 n4102 VSS VSS nmos W=0.31u L=0.04u
M6435 U4155/net36 g1422 VSS VSS nmos W=0.155u L=0.04u
M6436 U4155/net19 n4095 VDD VDD pmos W=0.205u L=0.04u
M6437 n3557 U4155/net19 U4155/net26 VDD pmos W=0.325u L=0.04u
M6438 U4155/net26 n4102 VDD VDD pmos W=0.41u L=0.04u
M6439 n3557 n4095 U4155/net30 VDD pmos W=0.325u L=0.04u
M6440 U4155/net30 g1422 VDD VDD pmos W=0.205u L=0.04u
M6441 U4156/net19 n4096 VSS VSS nmos W=0.155u L=0.04u
M6442 n3556 n4096 U4156/net40 VSS nmos W=0.155u L=0.04u
M6443 n3556 U4156/net19 U4156/net36 VSS nmos W=0.155u L=0.04u
M6444 U4156/net40 n4101 VSS VSS nmos W=0.31u L=0.04u
M6445 U4156/net36 g1403 VSS VSS nmos W=0.155u L=0.04u
M6446 U4156/net19 n4096 VDD VDD pmos W=0.205u L=0.04u
M6447 n3556 U4156/net19 U4156/net26 VDD pmos W=0.325u L=0.04u
M6448 U4156/net26 n4101 VDD VDD pmos W=0.41u L=0.04u
M6449 n3556 n4096 U4156/net30 VDD pmos W=0.325u L=0.04u
M6450 U4156/net30 g1403 VDD VDD pmos W=0.205u L=0.04u
M6451 U4157/net19 n4095 VSS VSS nmos W=0.155u L=0.04u
M6452 n3555 n4095 U4157/net40 VSS nmos W=0.155u L=0.04u
M6453 n3555 U4157/net19 U4157/net36 VSS nmos W=0.155u L=0.04u
M6454 U4157/net40 n4103 VSS VSS nmos W=0.31u L=0.04u
M6455 U4157/net36 g1407 VSS VSS nmos W=0.155u L=0.04u
M6456 U4157/net19 n4095 VDD VDD pmos W=0.205u L=0.04u
M6457 n3555 U4157/net19 U4157/net26 VDD pmos W=0.325u L=0.04u
M6458 U4157/net26 n4103 VDD VDD pmos W=0.41u L=0.04u
M6459 n3555 n4095 U4157/net30 VDD pmos W=0.325u L=0.04u
M6460 U4157/net30 g1407 VDD VDD pmos W=0.205u L=0.04u
M6461 U4158/net19 n4096 VSS VSS nmos W=0.155u L=0.04u
M6462 n3554 n4096 U4158/net40 VSS nmos W=0.155u L=0.04u
M6463 n3554 U4158/net19 U4158/net36 VSS nmos W=0.155u L=0.04u
M6464 U4158/net40 n4102 VSS VSS nmos W=0.31u L=0.04u
M6465 U4158/net36 g1421 VSS VSS nmos W=0.155u L=0.04u
M6466 U4158/net19 n4096 VDD VDD pmos W=0.205u L=0.04u
M6467 n3554 U4158/net19 U4158/net26 VDD pmos W=0.325u L=0.04u
M6468 U4158/net26 n4102 VDD VDD pmos W=0.41u L=0.04u
M6469 n3554 n4096 U4158/net30 VDD pmos W=0.325u L=0.04u
M6470 U4158/net30 g1421 VDD VDD pmos W=0.205u L=0.04u
M6471 U4159/net36 n4106 U4159/net24 VSS nmos W=0.155u L=0.04u
M6472 U4159/net24 n4107 VSS VSS nmos W=0.155u L=0.04u
M6473 U4159/net33 g1415 U4159/net36 VSS nmos W=0.155u L=0.04u
M6474 U4159/net33 n4105 U4159/net36 VSS nmos W=0.155u L=0.04u
M6475 n4102 U4159/net33 VSS VSS nmos W=0.155u L=0.04u
M6476 n4102 U4159/net33 VDD VDD pmos W=0.205u L=0.04u
M6477 U4159/net33 n4105 U4159/net35 VDD pmos W=0.205u L=0.04u
M6478 U4159/net35 g1415 VDD VDD pmos W=0.205u L=0.04u
M6479 U4159/net33 n4107 VDD VDD pmos W=0.205u L=0.04u
M6480 U4159/net33 n4106 VDD VDD pmos W=0.205u L=0.04u
M6481 n4107 g1315 U4160/XI21-net17 VSS nmos W=0.155u L=0.04u
M6482 U4160/XI21-net17 n4111 VSS VSS nmos W=0.155u L=0.04u
M6483 n4107 n4108 U4160/XI6-net17 VSS nmos W=0.155u L=0.04u
M6484 U4160/XI6-net17 n4109 VSS VSS nmos W=0.155u L=0.04u
M6485 n4107 g7161 U4160/XI20-net17 VSS nmos W=0.155u L=0.04u
M6486 U4160/XI20-net17 n4110 VSS VSS nmos W=0.155u L=0.04u
M6487 VDD g1315 U4160/net22 VDD pmos W=0.205u L=0.04u
M6488 VDD n4111 U4160/net22 VDD pmos W=0.205u L=0.04u
M6489 U4160/net16 n4108 n4107 VDD pmos W=0.205u L=0.04u
M6490 U4160/net16 n4109 n4107 VDD pmos W=0.205u L=0.04u
M6491 U4160/net22 g7161 U4160/net16 VDD pmos W=0.205u L=0.04u
M6492 U4160/net22 n4110 U4160/net16 VDD pmos W=0.205u L=0.04u
M6493 n4111 g1414 VSS VSS nmos W=0.135u L=0.04u
M6494 n4111 g1414 VDD VDD pmos W=0.205u L=0.04u
M6495 n4110 g1416 VSS VSS nmos W=0.135u L=0.04u
M6496 n4110 g1416 VDD VDD pmos W=0.205u L=0.04u
M6497 n4109 n4115 VSS VSS nmos W=0.155u L=0.04u
M6498 n4109 n4114 VSS VSS nmos W=0.155u L=0.04u
M6499 n4109 n4113 VSS VSS nmos W=0.155u L=0.04u
M6500 n4109 n4112 VSS VSS nmos W=0.155u L=0.04u
M6501 U4163/net49 n4114 U4163/net52 VDD pmos W=0.41u L=0.04u
M6502 U4163/net52 n4115 VDD VDD pmos W=0.41u L=0.04u
M6503 U4163/net46 n4113 U4163/net49 VDD pmos W=0.41u L=0.04u
M6504 n4109 n4112 U4163/net46 VDD pmos W=0.41u L=0.04u
M6505 U4164/net4 n4116 U4164/net14 VSS nmos W=0.155u L=0.04u
M6506 U4164/net6 U4164/net10 U4164/net14 VSS nmos W=0.17u L=0.04u
M6507 U4164/net4 g1372 VSS VSS nmos W=0.155u L=0.04u
M6508 U4164/net6 U4164/net4 VSS VSS nmos W=0.17u L=0.04u
M6509 n4115 U4164/net14 VSS VSS nmos W=0.155u L=0.04u
M6510 U4164/net10 n4116 VSS VSS nmos W=0.155u L=0.04u
M6511 U4164/net4 U4164/net10 U4164/net14 VDD pmos W=0.255u L=0.04u
M6512 U4164/net6 n4116 U4164/net14 VDD pmos W=0.28u L=0.04u
M6513 U4164/net4 g1372 VDD VDD pmos W=0.205u L=0.04u
M6514 U4164/net6 U4164/net4 VDD VDD pmos W=0.24u L=0.04u
M6515 n4115 U4164/net14 VDD VDD pmos W=0.205u L=0.04u
M6516 U4164/net10 n4116 VDD VDD pmos W=0.205u L=0.04u
M6517 U4165/net4 n4117 U4165/net14 VSS nmos W=0.155u L=0.04u
M6518 U4165/net6 U4165/net10 U4165/net14 VSS nmos W=0.17u L=0.04u
M6519 U4165/net4 g1378 VSS VSS nmos W=0.155u L=0.04u
M6520 U4165/net6 U4165/net4 VSS VSS nmos W=0.17u L=0.04u
M6521 n4114 U4165/net14 VSS VSS nmos W=0.155u L=0.04u
M6522 U4165/net10 n4117 VSS VSS nmos W=0.155u L=0.04u
M6523 U4165/net4 U4165/net10 U4165/net14 VDD pmos W=0.255u L=0.04u
M6524 U4165/net6 n4117 U4165/net14 VDD pmos W=0.28u L=0.04u
M6525 U4165/net4 g1378 VDD VDD pmos W=0.205u L=0.04u
M6526 U4165/net6 U4165/net4 VDD VDD pmos W=0.24u L=0.04u
M6527 n4114 U4165/net14 VDD VDD pmos W=0.205u L=0.04u
M6528 U4165/net10 n4117 VDD VDD pmos W=0.205u L=0.04u
M6529 U4166/net4 n4118 U4166/net14 VSS nmos W=0.155u L=0.04u
M6530 U4166/net6 U4166/net10 U4166/net14 VSS nmos W=0.17u L=0.04u
M6531 U4166/net4 g1339 VSS VSS nmos W=0.155u L=0.04u
M6532 U4166/net6 U4166/net4 VSS VSS nmos W=0.17u L=0.04u
M6533 n4113 U4166/net14 VSS VSS nmos W=0.155u L=0.04u
M6534 U4166/net10 n4118 VSS VSS nmos W=0.155u L=0.04u
M6535 U4166/net4 U4166/net10 U4166/net14 VDD pmos W=0.255u L=0.04u
M6536 U4166/net6 n4118 U4166/net14 VDD pmos W=0.28u L=0.04u
M6537 U4166/net4 g1339 VDD VDD pmos W=0.205u L=0.04u
M6538 U4166/net6 U4166/net4 VDD VDD pmos W=0.24u L=0.04u
M6539 n4113 U4166/net14 VDD VDD pmos W=0.205u L=0.04u
M6540 U4166/net10 n4118 VDD VDD pmos W=0.205u L=0.04u
M6541 U4167/XU1-net6 n4120 VSS VSS nmos W=0.155u L=0.04u
M6542 n4112 n4119 U4167/XU1-net6 VSS nmos W=0.155u L=0.04u
M6543 n4112 n4120 VDD VDD pmos W=0.155u L=0.04u
M6544 n4112 n4119 VDD VDD pmos W=0.155u L=0.04u
M6545 U4168/net4 g1319 U4168/net14 VSS nmos W=0.155u L=0.04u
M6546 U4168/net6 U4168/net10 U4168/net14 VSS nmos W=0.17u L=0.04u
M6547 U4168/net4 n4121 VSS VSS nmos W=0.155u L=0.04u
M6548 U4168/net6 U4168/net4 VSS VSS nmos W=0.17u L=0.04u
M6549 n4120 U4168/net14 VSS VSS nmos W=0.155u L=0.04u
M6550 U4168/net10 g1319 VSS VSS nmos W=0.155u L=0.04u
M6551 U4168/net4 U4168/net10 U4168/net14 VDD pmos W=0.255u L=0.04u
M6552 U4168/net6 g1319 U4168/net14 VDD pmos W=0.28u L=0.04u
M6553 U4168/net4 n4121 VDD VDD pmos W=0.205u L=0.04u
M6554 U4168/net6 U4168/net4 VDD VDD pmos W=0.24u L=0.04u
M6555 n4120 U4168/net14 VDD VDD pmos W=0.205u L=0.04u
M6556 U4168/net10 g1319 VDD VDD pmos W=0.205u L=0.04u
M6557 U4169/net4 g1332 U4169/net14 VSS nmos W=0.155u L=0.04u
M6558 U4169/net6 U4169/net10 U4169/net14 VSS nmos W=0.17u L=0.04u
M6559 U4169/net4 n4122 VSS VSS nmos W=0.155u L=0.04u
M6560 U4169/net6 U4169/net4 VSS VSS nmos W=0.17u L=0.04u
M6561 n4119 U4169/net14 VSS VSS nmos W=0.155u L=0.04u
M6562 U4169/net10 g1332 VSS VSS nmos W=0.155u L=0.04u
M6563 U4169/net4 U4169/net10 U4169/net14 VDD pmos W=0.255u L=0.04u
M6564 U4169/net6 g1332 U4169/net14 VDD pmos W=0.28u L=0.04u
M6565 U4169/net4 n4122 VDD VDD pmos W=0.205u L=0.04u
M6566 U4169/net6 U4169/net4 VDD VDD pmos W=0.24u L=0.04u
M6567 n4119 U4169/net14 VDD VDD pmos W=0.205u L=0.04u
M6568 U4169/net10 g1332 VDD VDD pmos W=0.205u L=0.04u
M6569 n4108 n4126 VSS VSS nmos W=0.155u L=0.04u
M6570 n4108 n4125 VSS VSS nmos W=0.155u L=0.04u
M6571 n4108 n4124 VSS VSS nmos W=0.155u L=0.04u
M6572 n4108 n4123 VSS VSS nmos W=0.155u L=0.04u
M6573 U4170/net49 n4125 U4170/net52 VDD pmos W=0.41u L=0.04u
M6574 U4170/net52 n4126 VDD VDD pmos W=0.41u L=0.04u
M6575 U4170/net46 n4124 U4170/net49 VDD pmos W=0.41u L=0.04u
M6576 n4108 n4123 U4170/net46 VDD pmos W=0.41u L=0.04u
M6577 U4171/net4 n4127 U4171/net14 VSS nmos W=0.155u L=0.04u
M6578 U4171/net6 U4171/net10 U4171/net14 VSS nmos W=0.17u L=0.04u
M6579 U4171/net4 n4101 VSS VSS nmos W=0.155u L=0.04u
M6580 U4171/net6 U4171/net4 VSS VSS nmos W=0.17u L=0.04u
M6581 n4126 U4171/net14 VSS VSS nmos W=0.155u L=0.04u
M6582 U4171/net10 n4127 VSS VSS nmos W=0.155u L=0.04u
M6583 U4171/net4 U4171/net10 U4171/net14 VDD pmos W=0.255u L=0.04u
M6584 U4171/net6 n4127 U4171/net14 VDD pmos W=0.28u L=0.04u
M6585 U4171/net4 n4101 VDD VDD pmos W=0.205u L=0.04u
M6586 U4171/net6 U4171/net4 VDD VDD pmos W=0.24u L=0.04u
M6587 n4126 U4171/net14 VDD VDD pmos W=0.205u L=0.04u
M6588 U4171/net10 n4127 VDD VDD pmos W=0.205u L=0.04u
M6589 n4101 g1352 VSS VSS nmos W=0.135u L=0.04u
M6590 n4101 g1352 VDD VDD pmos W=0.205u L=0.04u
M6591 U4173/net4 n4128 U4173/net14 VSS nmos W=0.155u L=0.04u
M6592 U4173/net6 U4173/net10 U4173/net14 VSS nmos W=0.17u L=0.04u
M6593 U4173/net4 n4103 VSS VSS nmos W=0.155u L=0.04u
M6594 U4173/net6 U4173/net4 VSS VSS nmos W=0.17u L=0.04u
M6595 n4125 U4173/net14 VSS VSS nmos W=0.155u L=0.04u
M6596 U4173/net10 n4128 VSS VSS nmos W=0.155u L=0.04u
M6597 U4173/net4 U4173/net10 U4173/net14 VDD pmos W=0.255u L=0.04u
M6598 U4173/net6 n4128 U4173/net14 VDD pmos W=0.28u L=0.04u
M6599 U4173/net4 n4103 VDD VDD pmos W=0.205u L=0.04u
M6600 U4173/net6 U4173/net4 VDD VDD pmos W=0.24u L=0.04u
M6601 n4125 U4173/net14 VDD VDD pmos W=0.205u L=0.04u
M6602 U4173/net10 n4128 VDD VDD pmos W=0.205u L=0.04u
M6603 U4174/net4 n4129 U4174/net14 VSS nmos W=0.155u L=0.04u
M6604 U4174/net6 U4174/net10 U4174/net14 VSS nmos W=0.17u L=0.04u
M6605 U4174/net4 g1346 VSS VSS nmos W=0.155u L=0.04u
M6606 U4174/net6 U4174/net4 VSS VSS nmos W=0.17u L=0.04u
M6607 n4124 U4174/net14 VSS VSS nmos W=0.155u L=0.04u
M6608 U4174/net10 n4129 VSS VSS nmos W=0.155u L=0.04u
M6609 U4174/net4 U4174/net10 U4174/net14 VDD pmos W=0.255u L=0.04u
M6610 U4174/net6 n4129 U4174/net14 VDD pmos W=0.28u L=0.04u
M6611 U4174/net4 g1346 VDD VDD pmos W=0.205u L=0.04u
M6612 U4174/net6 U4174/net4 VDD VDD pmos W=0.24u L=0.04u
M6613 n4124 U4174/net14 VDD VDD pmos W=0.205u L=0.04u
M6614 U4174/net10 n4129 VDD VDD pmos W=0.205u L=0.04u
M6615 U4175/XU1-net6 n4131 VSS VSS nmos W=0.155u L=0.04u
M6616 n4123 n4130 U4175/XU1-net6 VSS nmos W=0.155u L=0.04u
M6617 n4123 n4131 VDD VDD pmos W=0.155u L=0.04u
M6618 n4123 n4130 VDD VDD pmos W=0.155u L=0.04u
M6619 U4176/net4 n4098 U4176/net14 VSS nmos W=0.155u L=0.04u
M6620 U4176/net6 U4176/net10 U4176/net14 VSS nmos W=0.17u L=0.04u
M6621 U4176/net4 n4132 VSS VSS nmos W=0.155u L=0.04u
M6622 U4176/net6 U4176/net4 VSS VSS nmos W=0.17u L=0.04u
M6623 n4131 U4176/net14 VSS VSS nmos W=0.155u L=0.04u
M6624 U4176/net10 n4098 VSS VSS nmos W=0.155u L=0.04u
M6625 U4176/net4 U4176/net10 U4176/net14 VDD pmos W=0.255u L=0.04u
M6626 U4176/net6 n4098 U4176/net14 VDD pmos W=0.28u L=0.04u
M6627 U4176/net4 n4132 VDD VDD pmos W=0.205u L=0.04u
M6628 U4176/net6 U4176/net4 VDD VDD pmos W=0.24u L=0.04u
M6629 n4131 U4176/net14 VDD VDD pmos W=0.205u L=0.04u
M6630 U4176/net10 n4098 VDD VDD pmos W=0.205u L=0.04u
M6631 n4098 g1326 VSS VSS nmos W=0.135u L=0.04u
M6632 n4098 g1326 VDD VDD pmos W=0.205u L=0.04u
M6633 U4178/net4 n4083 U4178/net14 VSS nmos W=0.155u L=0.04u
M6634 U4178/net6 U4178/net10 U4178/net14 VSS nmos W=0.17u L=0.04u
M6635 U4178/net4 n4133 VSS VSS nmos W=0.155u L=0.04u
M6636 U4178/net6 U4178/net4 VSS VSS nmos W=0.17u L=0.04u
M6637 n4130 U4178/net14 VSS VSS nmos W=0.155u L=0.04u
M6638 U4178/net10 n4083 VSS VSS nmos W=0.155u L=0.04u
M6639 U4178/net4 U4178/net10 U4178/net14 VDD pmos W=0.255u L=0.04u
M6640 U4178/net6 n4083 U4178/net14 VDD pmos W=0.28u L=0.04u
M6641 U4178/net4 n4133 VDD VDD pmos W=0.205u L=0.04u
M6642 U4178/net6 U4178/net4 VDD VDD pmos W=0.24u L=0.04u
M6643 n4130 U4178/net14 VDD VDD pmos W=0.205u L=0.04u
M6644 U4178/net10 n4083 VDD VDD pmos W=0.205u L=0.04u
M6645 n4083 g1358 VSS VSS nmos W=0.135u L=0.04u
M6646 n4083 g1358 VDD VDD pmos W=0.205u L=0.04u
M6647 n4106 n4134 VSS VSS nmos W=0.135u L=0.04u
M6648 n4106 n4134 VDD VDD pmos W=0.205u L=0.04u
M6649 U4181/net19 n4096 VSS VSS nmos W=0.155u L=0.04u
M6650 n3553 n4096 U4181/net40 VSS nmos W=0.155u L=0.04u
M6651 n3553 U4181/net19 U4181/net36 VSS nmos W=0.155u L=0.04u
M6652 U4181/net40 n4103 VSS VSS nmos W=0.31u L=0.04u
M6653 U4181/net36 g1406 VSS VSS nmos W=0.155u L=0.04u
M6654 U4181/net19 n4096 VDD VDD pmos W=0.205u L=0.04u
M6655 n3553 U4181/net19 U4181/net26 VDD pmos W=0.325u L=0.04u
M6656 U4181/net26 n4103 VDD VDD pmos W=0.41u L=0.04u
M6657 n3553 n4096 U4181/net30 VDD pmos W=0.325u L=0.04u
M6658 U4181/net30 g1406 VDD VDD pmos W=0.205u L=0.04u
M6659 n4103 g1365 VSS VSS nmos W=0.135u L=0.04u
M6660 n4103 g1365 VDD VDD pmos W=0.205u L=0.04u
M6661 U4183/net19 n4095 VSS VSS nmos W=0.155u L=0.04u
M6662 n3552 n4095 U4183/net40 VSS nmos W=0.155u L=0.04u
M6663 n3552 U4183/net19 U4183/net36 VSS nmos W=0.155u L=0.04u
M6664 U4183/net40 n4092 VSS VSS nmos W=0.31u L=0.04u
M6665 U4183/net36 g1410 VSS VSS nmos W=0.155u L=0.04u
M6666 U4183/net19 n4095 VDD VDD pmos W=0.205u L=0.04u
M6667 n3552 U4183/net19 U4183/net26 VDD pmos W=0.325u L=0.04u
M6668 U4183/net26 n4092 VDD VDD pmos W=0.41u L=0.04u
M6669 n3552 n4095 U4183/net30 VDD pmos W=0.325u L=0.04u
M6670 U4183/net30 g1410 VDD VDD pmos W=0.205u L=0.04u
M6671 n4095 n4104 VSS VSS nmos W=0.155u L=0.04u
M6672 n4095 n4135 VSS VSS nmos W=0.155u L=0.04u
M6673 U4184/XI1-net8 n4135 VDD VDD pmos W=0.205u L=0.04u
M6674 n4095 n4104 U4184/XI1-net8 VDD pmos W=0.205u L=0.04u
M6675 U4185/net19 n4096 VSS VSS nmos W=0.155u L=0.04u
M6676 n3551 n4096 U4185/net40 VSS nmos W=0.155u L=0.04u
M6677 n3551 U4185/net19 U4185/net36 VSS nmos W=0.155u L=0.04u
M6678 U4185/net40 n4092 VSS VSS nmos W=0.31u L=0.04u
M6679 U4185/net36 g1409 VSS VSS nmos W=0.155u L=0.04u
M6680 U4185/net19 n4096 VDD VDD pmos W=0.205u L=0.04u
M6681 n3551 U4185/net19 U4185/net26 VDD pmos W=0.325u L=0.04u
M6682 U4185/net26 n4092 VDD VDD pmos W=0.41u L=0.04u
M6683 n3551 n4096 U4185/net30 VDD pmos W=0.325u L=0.04u
M6684 U4185/net30 g1409 VDD VDD pmos W=0.205u L=0.04u
M6685 n4096 n4105 VSS VSS nmos W=0.155u L=0.04u
M6686 n4096 n4104 VSS VSS nmos W=0.155u L=0.04u
M6687 U4186/XI1-net8 n4104 VDD VDD pmos W=0.205u L=0.04u
M6688 n4096 n4105 U4186/XI1-net8 VDD pmos W=0.205u L=0.04u
M6689 U4187/net30 g1345 VSS VSS nmos W=0.155u L=0.04u
M6690 n4104 g1224 U4187/net23 VSS nmos W=0.155u L=0.04u
M6691 U4187/net20 U4187/net30 VSS VSS nmos W=0.155u L=0.04u
M6692 U4187/net23 g1211 U4187/net20 VSS nmos W=0.155u L=0.04u
M6693 U4187/net30 g1345 VDD VDD pmos W=0.205u L=0.04u
M6694 VDD g1224 n4104 VDD pmos W=0.205u L=0.04u
M6695 VDD g1211 n4104 VDD pmos W=0.205u L=0.04u
M6696 VDD U4187/net30 n4104 VDD pmos W=0.205u L=0.04u
M6697 n4092 g1372 VSS VSS nmos W=0.135u L=0.04u
M6698 n4092 g1372 VDD VDD pmos W=0.205u L=0.04u
M6699 U4189/net19 n4072 VSS VSS nmos W=0.155u L=0.04u
M6700 n3550 n4072 U4189/net40 VSS nmos W=0.155u L=0.04u
M6701 n3550 U4189/net19 U4189/net36 VSS nmos W=0.155u L=0.04u
M6702 U4189/net40 g1316 VSS VSS nmos W=0.31u L=0.04u
M6703 U4189/net36 g1196 VSS VSS nmos W=0.155u L=0.04u
M6704 U4189/net19 n4072 VDD VDD pmos W=0.205u L=0.04u
M6705 n3550 U4189/net19 U4189/net26 VDD pmos W=0.325u L=0.04u
M6706 U4189/net26 g1316 VDD VDD pmos W=0.41u L=0.04u
M6707 n3550 n4072 U4189/net30 VDD pmos W=0.325u L=0.04u
M6708 U4189/net30 g1196 VDD VDD pmos W=0.205u L=0.04u
M6709 U4190/net19 n4136 VSS VSS nmos W=0.155u L=0.04u
M6710 n3549 n4136 U4190/net40 VSS nmos W=0.155u L=0.04u
M6711 n3549 U4190/net19 U4190/net36 VSS nmos W=0.155u L=0.04u
M6712 U4190/net40 g1240 VSS VSS nmos W=0.31u L=0.04u
M6713 U4190/net36 n3917 VSS VSS nmos W=0.155u L=0.04u
M6714 U4190/net19 n4136 VDD VDD pmos W=0.205u L=0.04u
M6715 n3549 U4190/net19 U4190/net26 VDD pmos W=0.325u L=0.04u
M6716 U4190/net26 g1240 VDD VDD pmos W=0.41u L=0.04u
M6717 n3549 n4136 U4190/net30 VDD pmos W=0.325u L=0.04u
M6718 U4190/net30 n3917 VDD VDD pmos W=0.205u L=0.04u
M6719 n3548 U4191/net28 VSS VSS nmos W=0.155u L=0.04u
M6720 U4191/net47 n4137 VSS VSS nmos W=0.155u L=0.04u
M6721 U4191/net28 U4191/net6 U4191/net47 VSS nmos W=0.155u L=0.04u
M6722 U4191/net44 g1240 VSS VSS nmos W=0.155u L=0.04u
M6723 U4191/net28 g1236 U4191/net44 VSS nmos W=0.155u L=0.04u
M6724 U4191/net6 g1236 VSS VSS nmos W=0.155u L=0.04u
M6725 n3548 U4191/net28 VDD VDD pmos W=0.205u L=0.04u
M6726 VDD n4137 U4191/net47 VDD pmos W=0.205u L=0.04u
M6727 U4191/net47 g1236 U4191/net28 VDD pmos W=0.205u L=0.04u
M6728 U4191/net44 U4191/net6 U4191/net28 VDD pmos W=0.205u L=0.04u
M6729 VDD g1240 U4191/net44 VDD pmos W=0.205u L=0.04u
M6730 VDD g1236 U4191/net6 VDD pmos W=0.205u L=0.04u
M6731 U4192/net19 n4136 VSS VSS nmos W=0.155u L=0.04u
M6732 n3547 n4136 U4192/net40 VSS nmos W=0.155u L=0.04u
M6733 n3547 U4192/net19 U4192/net36 VSS nmos W=0.155u L=0.04u
M6734 U4192/net40 g1196 VSS VSS nmos W=0.31u L=0.04u
M6735 U4192/net36 g1243 VSS VSS nmos W=0.155u L=0.04u
M6736 U4192/net19 n4136 VDD VDD pmos W=0.205u L=0.04u
M6737 n3547 U4192/net19 U4192/net26 VDD pmos W=0.325u L=0.04u
M6738 U4192/net26 g1196 VDD VDD pmos W=0.41u L=0.04u
M6739 n3547 n4136 U4192/net30 VDD pmos W=0.325u L=0.04u
M6740 U4192/net30 g1243 VDD VDD pmos W=0.205u L=0.04u
M6741 n3546 n4138 U4193/net27 VSS nmos W=0.155u L=0.04u
M6742 U4193/net39 n4136 VSS VSS nmos W=0.155u L=0.04u
M6743 U4193/net27 g1151 U4193/net39 VSS nmos W=0.155u L=0.04u
M6744 U4193/net27 n4139 U4193/net39 VSS nmos W=0.155u L=0.04u
M6745 n3546 g1167 U4193/net27 VSS nmos W=0.155u L=0.04u
M6746 U4193/net39 g1171 VSS VSS nmos W=0.155u L=0.04u
M6747 n3546 n4136 U4193/net46 VDD pmos W=0.205u L=0.04u
M6748 U4193/net46 g1171 VDD VDD pmos W=0.205u L=0.04u
M6749 n3546 g1167 U4193/net34 VDD pmos W=0.205u L=0.04u
M6750 U4193/net34 n4138 VDD VDD pmos W=0.205u L=0.04u
M6751 n3546 n4139 U4193/net37 VDD pmos W=0.205u L=0.04u
M6752 U4193/net37 g1151 VDD VDD pmos W=0.205u L=0.04u
M6753 n3545 n4136 U4194/net27 VSS nmos W=0.155u L=0.04u
M6754 U4194/net39 n4139 VSS VSS nmos W=0.155u L=0.04u
M6755 U4194/net27 g1164 U4194/net39 VSS nmos W=0.155u L=0.04u
M6756 U4194/net27 n4138 U4194/net39 VSS nmos W=0.155u L=0.04u
M6757 n3545 g1165 U4194/net27 VSS nmos W=0.155u L=0.04u
M6758 U4194/net39 g1166 VSS VSS nmos W=0.155u L=0.04u
M6759 n3545 n4139 U4194/net46 VDD pmos W=0.205u L=0.04u
M6760 U4194/net46 g1166 VDD VDD pmos W=0.205u L=0.04u
M6761 n3545 g1165 U4194/net34 VDD pmos W=0.205u L=0.04u
M6762 U4194/net34 n4136 VDD VDD pmos W=0.205u L=0.04u
M6763 n3545 n4138 U4194/net37 VDD pmos W=0.205u L=0.04u
M6764 U4194/net37 g1164 VDD VDD pmos W=0.205u L=0.04u
M6765 n3544 n4136 U4195/net27 VSS nmos W=0.155u L=0.04u
M6766 U4195/net39 n4139 VSS VSS nmos W=0.155u L=0.04u
M6767 U4195/net27 g1173 U4195/net39 VSS nmos W=0.155u L=0.04u
M6768 U4195/net27 n4138 U4195/net39 VSS nmos W=0.155u L=0.04u
M6769 n3544 g1174 U4195/net27 VSS nmos W=0.155u L=0.04u
M6770 U4195/net39 g1175 VSS VSS nmos W=0.155u L=0.04u
M6771 n3544 n4139 U4195/net46 VDD pmos W=0.205u L=0.04u
M6772 U4195/net46 g1175 VDD VDD pmos W=0.205u L=0.04u
M6773 n3544 g1174 U4195/net34 VDD pmos W=0.205u L=0.04u
M6774 U4195/net34 n4136 VDD VDD pmos W=0.205u L=0.04u
M6775 n3544 n4138 U4195/net37 VDD pmos W=0.205u L=0.04u
M6776 U4195/net37 g1173 VDD VDD pmos W=0.205u L=0.04u
M6777 U4196/net19 n4097 VSS VSS nmos W=0.155u L=0.04u
M6778 n3541 n4097 U4196/net40 VSS nmos W=0.155u L=0.04u
M6779 n3541 U4196/net19 U4196/net36 VSS nmos W=0.155u L=0.04u
M6780 U4196/net40 g1418 VSS VSS nmos W=0.31u L=0.04u
M6781 U4196/net36 n4140 VSS VSS nmos W=0.155u L=0.04u
M6782 U4196/net19 n4097 VDD VDD pmos W=0.205u L=0.04u
M6783 n3541 U4196/net19 U4196/net26 VDD pmos W=0.325u L=0.04u
M6784 U4196/net26 g1418 VDD VDD pmos W=0.41u L=0.04u
M6785 n3541 n4097 U4196/net30 VDD pmos W=0.325u L=0.04u
M6786 U4196/net30 n4140 VDD VDD pmos W=0.205u L=0.04u
M6787 U4197/net19 n4075 VSS VSS nmos W=0.155u L=0.04u
M6788 n3540 n4075 U4197/net40 VSS nmos W=0.155u L=0.04u
M6789 n3540 U4197/net19 U4197/net36 VSS nmos W=0.155u L=0.04u
M6790 U4197/net40 g1419 VSS VSS nmos W=0.31u L=0.04u
M6791 U4197/net36 n4140 VSS VSS nmos W=0.155u L=0.04u
M6792 U4197/net19 n4075 VDD VDD pmos W=0.205u L=0.04u
M6793 n3540 U4197/net19 U4197/net26 VDD pmos W=0.325u L=0.04u
M6794 U4197/net26 g1419 VDD VDD pmos W=0.41u L=0.04u
M6795 n3540 n4075 U4197/net30 VDD pmos W=0.325u L=0.04u
M6796 U4197/net30 n4140 VDD VDD pmos W=0.205u L=0.04u
M6797 U4198/net19 n4094 VSS VSS nmos W=0.155u L=0.04u
M6798 n3539 n4094 U4198/net40 VSS nmos W=0.155u L=0.04u
M6799 n3539 U4198/net19 U4198/net36 VSS nmos W=0.155u L=0.04u
M6800 U4198/net40 g1417 VSS VSS nmos W=0.31u L=0.04u
M6801 U4198/net36 n4140 VSS VSS nmos W=0.155u L=0.04u
M6802 U4198/net19 n4094 VDD VDD pmos W=0.205u L=0.04u
M6803 n3539 U4198/net19 U4198/net26 VDD pmos W=0.325u L=0.04u
M6804 U4198/net26 g1417 VDD VDD pmos W=0.41u L=0.04u
M6805 n3539 n4094 U4198/net30 VDD pmos W=0.325u L=0.04u
M6806 U4198/net30 n4140 VDD VDD pmos W=0.205u L=0.04u
M6807 U4199/net19 n4142 VSS VSS nmos W=0.155u L=0.04u
M6808 n3538 n4142 U4199/net40 VSS nmos W=0.155u L=0.04u
M6809 n3538 U4199/net19 U4199/net36 VSS nmos W=0.155u L=0.04u
M6810 U4199/net40 n4141 VSS VSS nmos W=0.31u L=0.04u
M6811 U4199/net36 g1261 VSS VSS nmos W=0.155u L=0.04u
M6812 U4199/net19 n4142 VDD VDD pmos W=0.205u L=0.04u
M6813 n3538 U4199/net19 U4199/net26 VDD pmos W=0.325u L=0.04u
M6814 U4199/net26 n4141 VDD VDD pmos W=0.41u L=0.04u
M6815 n3538 n4142 U4199/net30 VDD pmos W=0.325u L=0.04u
M6816 U4199/net30 g1261 VDD VDD pmos W=0.205u L=0.04u
M6817 U4200/net19 n4142 VSS VSS nmos W=0.155u L=0.04u
M6818 n3537 n4142 U4200/net40 VSS nmos W=0.155u L=0.04u
M6819 n3537 U4200/net19 U4200/net36 VSS nmos W=0.155u L=0.04u
M6820 U4200/net40 n4143 VSS VSS nmos W=0.31u L=0.04u
M6821 U4200/net36 g1264 VSS VSS nmos W=0.155u L=0.04u
M6822 U4200/net19 n4142 VDD VDD pmos W=0.205u L=0.04u
M6823 n3537 U4200/net19 U4200/net26 VDD pmos W=0.325u L=0.04u
M6824 U4200/net26 n4143 VDD VDD pmos W=0.41u L=0.04u
M6825 n3537 n4142 U4200/net30 VDD pmos W=0.325u L=0.04u
M6826 U4200/net30 g1264 VDD VDD pmos W=0.205u L=0.04u
M6827 U4201/net19 n4142 VSS VSS nmos W=0.155u L=0.04u
M6828 n3536 n4142 U4201/net40 VSS nmos W=0.155u L=0.04u
M6829 n3536 U4201/net19 U4201/net36 VSS nmos W=0.155u L=0.04u
M6830 U4201/net40 n4144 VSS VSS nmos W=0.31u L=0.04u
M6831 U4201/net36 g1267 VSS VSS nmos W=0.155u L=0.04u
M6832 U4201/net19 n4142 VDD VDD pmos W=0.205u L=0.04u
M6833 n3536 U4201/net19 U4201/net26 VDD pmos W=0.325u L=0.04u
M6834 U4201/net26 n4144 VDD VDD pmos W=0.41u L=0.04u
M6835 n3536 n4142 U4201/net30 VDD pmos W=0.325u L=0.04u
M6836 U4201/net30 g1267 VDD VDD pmos W=0.205u L=0.04u
M6837 U4202/net19 n4142 VSS VSS nmos W=0.155u L=0.04u
M6838 n3535 n4142 U4202/net40 VSS nmos W=0.155u L=0.04u
M6839 n3535 U4202/net19 U4202/net36 VSS nmos W=0.155u L=0.04u
M6840 U4202/net40 n4145 VSS VSS nmos W=0.31u L=0.04u
M6841 U4202/net36 g1270 VSS VSS nmos W=0.155u L=0.04u
M6842 U4202/net19 n4142 VDD VDD pmos W=0.205u L=0.04u
M6843 n3535 U4202/net19 U4202/net26 VDD pmos W=0.325u L=0.04u
M6844 U4202/net26 n4145 VDD VDD pmos W=0.41u L=0.04u
M6845 n3535 n4142 U4202/net30 VDD pmos W=0.325u L=0.04u
M6846 U4202/net30 g1270 VDD VDD pmos W=0.205u L=0.04u
M6847 n4142 n4136 VSS VSS nmos W=0.155u L=0.04u
M6848 n4142 n3530 VSS VSS nmos W=0.155u L=0.04u
M6849 U4203/XI1-net8 n3530 VDD VDD pmos W=0.205u L=0.04u
M6850 n4142 n4136 U4203/XI1-net8 VDD pmos W=0.205u L=0.04u
M6851 U4204/net19 n4146 VSS VSS nmos W=0.155u L=0.04u
M6852 n3534 n4146 U4204/net40 VSS nmos W=0.155u L=0.04u
M6853 n3534 U4204/net19 U4204/net36 VSS nmos W=0.155u L=0.04u
M6854 U4204/net40 n4141 VSS VSS nmos W=0.31u L=0.04u
M6855 U4204/net36 g1263 VSS VSS nmos W=0.155u L=0.04u
M6856 U4204/net19 n4146 VDD VDD pmos W=0.205u L=0.04u
M6857 n3534 U4204/net19 U4204/net26 VDD pmos W=0.325u L=0.04u
M6858 U4204/net26 n4141 VDD VDD pmos W=0.41u L=0.04u
M6859 n3534 n4146 U4204/net30 VDD pmos W=0.325u L=0.04u
M6860 U4204/net30 g1263 VDD VDD pmos W=0.205u L=0.04u
M6861 U4205/net19 n4146 VSS VSS nmos W=0.155u L=0.04u
M6862 n3533 n4146 U4205/net40 VSS nmos W=0.155u L=0.04u
M6863 n3533 U4205/net19 U4205/net36 VSS nmos W=0.155u L=0.04u
M6864 U4205/net40 n4143 VSS VSS nmos W=0.31u L=0.04u
M6865 U4205/net36 g1266 VSS VSS nmos W=0.155u L=0.04u
M6866 U4205/net19 n4146 VDD VDD pmos W=0.205u L=0.04u
M6867 n3533 U4205/net19 U4205/net26 VDD pmos W=0.325u L=0.04u
M6868 U4205/net26 n4143 VDD VDD pmos W=0.41u L=0.04u
M6869 n3533 n4146 U4205/net30 VDD pmos W=0.325u L=0.04u
M6870 U4205/net30 g1266 VDD VDD pmos W=0.205u L=0.04u
M6871 U4206/net19 n4146 VSS VSS nmos W=0.155u L=0.04u
M6872 n3532 n4146 U4206/net40 VSS nmos W=0.155u L=0.04u
M6873 n3532 U4206/net19 U4206/net36 VSS nmos W=0.155u L=0.04u
M6874 U4206/net40 n4144 VSS VSS nmos W=0.31u L=0.04u
M6875 U4206/net36 g1269 VSS VSS nmos W=0.155u L=0.04u
M6876 U4206/net19 n4146 VDD VDD pmos W=0.205u L=0.04u
M6877 n3532 U4206/net19 U4206/net26 VDD pmos W=0.325u L=0.04u
M6878 U4206/net26 n4144 VDD VDD pmos W=0.41u L=0.04u
M6879 n3532 n4146 U4206/net30 VDD pmos W=0.325u L=0.04u
M6880 U4206/net30 g1269 VDD VDD pmos W=0.205u L=0.04u
M6881 U4207/net19 n4146 VSS VSS nmos W=0.155u L=0.04u
M6882 n3531 n4146 U4207/net40 VSS nmos W=0.155u L=0.04u
M6883 n3531 U4207/net19 U4207/net36 VSS nmos W=0.155u L=0.04u
M6884 U4207/net40 n4145 VSS VSS nmos W=0.31u L=0.04u
M6885 U4207/net36 g1272 VSS VSS nmos W=0.155u L=0.04u
M6886 U4207/net19 n4146 VDD VDD pmos W=0.205u L=0.04u
M6887 n3531 U4207/net19 U4207/net26 VDD pmos W=0.325u L=0.04u
M6888 U4207/net26 n4145 VDD VDD pmos W=0.41u L=0.04u
M6889 n3531 n4146 U4207/net30 VDD pmos W=0.325u L=0.04u
M6890 U4207/net30 g1272 VDD VDD pmos W=0.205u L=0.04u
M6891 n4146 n4138 VSS VSS nmos W=0.155u L=0.04u
M6892 n4146 n3530 VSS VSS nmos W=0.155u L=0.04u
M6893 U4208/XI1-net8 n3530 VDD VDD pmos W=0.205u L=0.04u
M6894 n4146 n4138 U4208/XI1-net8 VDD pmos W=0.205u L=0.04u
M6895 U4209/net19 n4138 VSS VSS nmos W=0.155u L=0.04u
M6896 n3529 n4138 U4209/net40 VSS nmos W=0.155u L=0.04u
M6897 n3529 U4209/net19 U4209/net36 VSS nmos W=0.155u L=0.04u
M6898 U4209/net40 g1180 VSS VSS nmos W=0.31u L=0.04u
M6899 U4209/net36 n4147 VSS VSS nmos W=0.155u L=0.04u
M6900 U4209/net19 n4138 VDD VDD pmos W=0.205u L=0.04u
M6901 n3529 U4209/net19 U4209/net26 VDD pmos W=0.325u L=0.04u
M6902 U4209/net26 g1180 VDD VDD pmos W=0.41u L=0.04u
M6903 n3529 n4138 U4209/net30 VDD pmos W=0.325u L=0.04u
M6904 U4209/net30 n4147 VDD VDD pmos W=0.205u L=0.04u
M6905 U4210/net19 n4136 VSS VSS nmos W=0.155u L=0.04u
M6906 n3528 n4136 U4210/net40 VSS nmos W=0.155u L=0.04u
M6907 n3528 U4210/net19 U4210/net36 VSS nmos W=0.155u L=0.04u
M6908 U4210/net40 g1183 VSS VSS nmos W=0.31u L=0.04u
M6909 U4210/net36 n4147 VSS VSS nmos W=0.155u L=0.04u
M6910 U4210/net19 n4136 VDD VDD pmos W=0.205u L=0.04u
M6911 n3528 U4210/net19 U4210/net26 VDD pmos W=0.325u L=0.04u
M6912 U4210/net26 g1183 VDD VDD pmos W=0.41u L=0.04u
M6913 n3528 n4136 U4210/net30 VDD pmos W=0.325u L=0.04u
M6914 U4210/net30 n4147 VDD VDD pmos W=0.205u L=0.04u
M6915 U4211/net19 n4097 VSS VSS nmos W=0.155u L=0.04u
M6916 n3527 n4097 U4211/net40 VSS nmos W=0.155u L=0.04u
M6917 n3527 U4211/net19 U4211/net36 VSS nmos W=0.155u L=0.04u
M6918 U4211/net40 g1415 VSS VSS nmos W=0.31u L=0.04u
M6919 U4211/net36 n4148 VSS VSS nmos W=0.155u L=0.04u
M6920 U4211/net19 n4097 VDD VDD pmos W=0.205u L=0.04u
M6921 n3527 U4211/net19 U4211/net26 VDD pmos W=0.325u L=0.04u
M6922 U4211/net26 g1415 VDD VDD pmos W=0.41u L=0.04u
M6923 n3527 n4097 U4211/net30 VDD pmos W=0.325u L=0.04u
M6924 U4211/net30 n4148 VDD VDD pmos W=0.205u L=0.04u
M6925 U4212/XU1-net6 g1316 VSS VSS nmos W=0.155u L=0.04u
M6926 n4097 g6979 U4212/XU1-net6 VSS nmos W=0.155u L=0.04u
M6927 n4097 g1316 VDD VDD pmos W=0.155u L=0.04u
M6928 n4097 g6979 VDD VDD pmos W=0.155u L=0.04u
M6929 U4213/net19 n4075 VSS VSS nmos W=0.155u L=0.04u
M6930 n3526 n4075 U4213/net40 VSS nmos W=0.155u L=0.04u
M6931 n3526 U4213/net19 U4213/net36 VSS nmos W=0.155u L=0.04u
M6932 U4213/net40 g1416 VSS VSS nmos W=0.31u L=0.04u
M6933 U4213/net36 n4148 VSS VSS nmos W=0.155u L=0.04u
M6934 U4213/net19 n4075 VDD VDD pmos W=0.205u L=0.04u
M6935 n3526 U4213/net19 U4213/net26 VDD pmos W=0.325u L=0.04u
M6936 U4213/net26 g1416 VDD VDD pmos W=0.41u L=0.04u
M6937 n3526 n4075 U4213/net30 VDD pmos W=0.325u L=0.04u
M6938 U4213/net30 n4148 VDD VDD pmos W=0.205u L=0.04u
M6939 U4214/XU1-net6 g1316 VSS VSS nmos W=0.155u L=0.04u
M6940 n4075 g7161 U4214/XU1-net6 VSS nmos W=0.155u L=0.04u
M6941 n4075 g1316 VDD VDD pmos W=0.155u L=0.04u
M6942 n4075 g7161 VDD VDD pmos W=0.155u L=0.04u
M6943 U4215/net19 n4094 VSS VSS nmos W=0.155u L=0.04u
M6944 n3525 n4094 U4215/net40 VSS nmos W=0.155u L=0.04u
M6945 n3525 U4215/net19 U4215/net36 VSS nmos W=0.155u L=0.04u
M6946 U4215/net40 g1414 VSS VSS nmos W=0.31u L=0.04u
M6947 U4215/net36 n4148 VSS VSS nmos W=0.155u L=0.04u
M6948 U4215/net19 n4094 VDD VDD pmos W=0.205u L=0.04u
M6949 n3525 U4215/net19 U4215/net26 VDD pmos W=0.325u L=0.04u
M6950 U4215/net26 g1414 VDD VDD pmos W=0.41u L=0.04u
M6951 n3525 n4094 U4215/net30 VDD pmos W=0.325u L=0.04u
M6952 U4215/net30 n4148 VDD VDD pmos W=0.205u L=0.04u
M6953 U4216/XU1-net6 g1315 VSS VSS nmos W=0.155u L=0.04u
M6954 n4094 g1316 U4216/XU1-net6 VSS nmos W=0.155u L=0.04u
M6955 n4094 g1315 VDD VDD pmos W=0.155u L=0.04u
M6956 n4094 g1316 VDD VDD pmos W=0.155u L=0.04u
M6957 U4217/net19 n4149 VSS VSS nmos W=0.155u L=0.04u
M6958 n3524 n4149 U4217/net40 VSS nmos W=0.155u L=0.04u
M6959 n3524 U4217/net19 U4217/net36 VSS nmos W=0.155u L=0.04u
M6960 U4217/net40 n4141 VSS VSS nmos W=0.31u L=0.04u
M6961 U4217/net36 g1262 VSS VSS nmos W=0.155u L=0.04u
M6962 U4217/net19 n4149 VDD VDD pmos W=0.205u L=0.04u
M6963 n3524 U4217/net19 U4217/net26 VDD pmos W=0.325u L=0.04u
M6964 U4217/net26 n4141 VDD VDD pmos W=0.41u L=0.04u
M6965 n3524 n4149 U4217/net30 VDD pmos W=0.325u L=0.04u
M6966 U4217/net30 g1262 VDD VDD pmos W=0.205u L=0.04u
M6967 U4218/net7 n4150 U4218/X_u4-net10 VSS nmos W=0.155u L=0.04u
M6968 U4218/X_u4-net10 n4151 U4218/X_u4-net13 VSS nmos W=0.155u L=0.04u
M6969 U4218/X_u4-net13 n4152 VSS VSS nmos W=0.155u L=0.04u
M6970 n4141 U4218/net7 VSS VSS nmos W=0.155u L=0.04u
M6971 U4218/net7 n4152 VDD VDD pmos W=0.205u L=0.04u
M6972 U4218/net7 n4150 VDD VDD pmos W=0.205u L=0.04u
M6973 U4218/net7 n4151 VDD VDD pmos W=0.205u L=0.04u
M6974 n4141 U4218/net7 VDD VDD pmos W=0.205u L=0.04u
M6975 U4219/net19 n3937 VSS VSS nmos W=0.155u L=0.04u
M6976 n4152 n3937 U4219/net40 VSS nmos W=0.155u L=0.04u
M6977 n4152 U4219/net19 U4219/net36 VSS nmos W=0.155u L=0.04u
M6978 U4219/net40 n4154 VSS VSS nmos W=0.31u L=0.04u
M6979 U4219/net36 n4153 VSS VSS nmos W=0.155u L=0.04u
M6980 U4219/net19 n3937 VDD VDD pmos W=0.205u L=0.04u
M6981 n4152 U4219/net19 U4219/net26 VDD pmos W=0.325u L=0.04u
M6982 U4219/net26 n4154 VDD VDD pmos W=0.41u L=0.04u
M6983 n4152 n3937 U4219/net30 VDD pmos W=0.325u L=0.04u
M6984 U4219/net30 n4153 VDD VDD pmos W=0.205u L=0.04u
M6985 n4154 n493 U4220/net15 VSS nmos W=0.155u L=0.04u
M6986 n4154 n4153 U4220/net15 VSS nmos W=0.155u L=0.04u
M6987 U4220/net15 n4155 VSS VSS nmos W=0.155u L=0.04u
M6988 n4154 n4155 VDD VDD pmos W=0.205u L=0.04u
M6989 n4154 n493 U4220/XI16-net11 VDD pmos W=0.205u L=0.04u
M6990 U4220/XI16-net11 n4153 VDD VDD pmos W=0.205u L=0.04u
M6991 U4221/net19 n4149 VSS VSS nmos W=0.155u L=0.04u
M6992 n3523 n4149 U4221/net40 VSS nmos W=0.155u L=0.04u
M6993 n3523 U4221/net19 U4221/net36 VSS nmos W=0.155u L=0.04u
M6994 U4221/net40 n4143 VSS VSS nmos W=0.31u L=0.04u
M6995 U4221/net36 g1265 VSS VSS nmos W=0.155u L=0.04u
M6996 U4221/net19 n4149 VDD VDD pmos W=0.205u L=0.04u
M6997 n3523 U4221/net19 U4221/net26 VDD pmos W=0.325u L=0.04u
M6998 U4221/net26 n4143 VDD VDD pmos W=0.41u L=0.04u
M6999 n3523 n4149 U4221/net30 VDD pmos W=0.325u L=0.04u
M7000 U4221/net30 g1265 VDD VDD pmos W=0.205u L=0.04u
M7001 U4222/net36 n4155 U4222/net24 VSS nmos W=0.155u L=0.04u
M7002 U4222/net24 n4150 VSS VSS nmos W=0.155u L=0.04u
M7003 U4222/net33 n4156 U4222/net36 VSS nmos W=0.155u L=0.04u
M7004 U4222/net33 n4157 U4222/net36 VSS nmos W=0.155u L=0.04u
M7005 n4143 U4222/net33 VSS VSS nmos W=0.155u L=0.04u
M7006 n4143 U4222/net33 VDD VDD pmos W=0.205u L=0.04u
M7007 U4222/net33 n4157 U4222/net35 VDD pmos W=0.205u L=0.04u
M7008 U4222/net35 n4156 VDD VDD pmos W=0.205u L=0.04u
M7009 U4222/net33 n4150 VDD VDD pmos W=0.205u L=0.04u
M7010 U4222/net33 n4155 VDD VDD pmos W=0.205u L=0.04u
M7011 n4150 n4156 U4223/XI0-net10 VSS nmos W=0.155u L=0.04u
M7012 U4223/XI0-net10 n4158 U4223/XI0-net13 VSS nmos W=0.155u L=0.04u
M7013 U4223/XI0-net13 g3229 VSS VSS nmos W=0.155u L=0.04u
M7014 n4150 g3229 VDD VDD pmos W=0.205u L=0.04u
M7015 n4150 n4156 VDD VDD pmos W=0.205u L=0.04u
M7016 n4150 n4158 VDD VDD pmos W=0.205u L=0.04u
M7017 U4224/XU1-net6 n3937 VSS VSS nmos W=0.155u L=0.04u
M7018 n4157 n4158 U4224/XU1-net6 VSS nmos W=0.155u L=0.04u
M7019 n4157 n3937 VDD VDD pmos W=0.155u L=0.04u
M7020 n4157 n4158 VDD VDD pmos W=0.155u L=0.04u
M7021 U4225/net19 n4149 VSS VSS nmos W=0.155u L=0.04u
M7022 n3522 n4149 U4225/net40 VSS nmos W=0.155u L=0.04u
M7023 n3522 U4225/net19 U4225/net36 VSS nmos W=0.155u L=0.04u
M7024 U4225/net40 n4144 VSS VSS nmos W=0.31u L=0.04u
M7025 U4225/net36 g1268 VSS VSS nmos W=0.155u L=0.04u
M7026 U4225/net19 n4149 VDD VDD pmos W=0.205u L=0.04u
M7027 n3522 U4225/net19 U4225/net26 VDD pmos W=0.325u L=0.04u
M7028 U4225/net26 n4144 VDD VDD pmos W=0.41u L=0.04u
M7029 n3522 n4149 U4225/net30 VDD pmos W=0.325u L=0.04u
M7030 U4225/net30 g1268 VDD VDD pmos W=0.205u L=0.04u
M7031 n4144 n4162 VSS VSS nmos W=0.155u L=0.04u
M7032 n4144 n4159 U4226/XI17-net17 VSS nmos W=0.155u L=0.04u
M7033 U4226/XI17-net17 n4161 VSS VSS nmos W=0.155u L=0.04u
M7034 n4144 n4159 U4226/XI10-net17 VSS nmos W=0.155u L=0.04u
M7035 U4226/XI10-net17 n4160 VSS VSS nmos W=0.155u L=0.04u
M7036 U4226/net30 n4159 n4144 VDD pmos W=0.205u L=0.04u
M7037 U4226/net30 n4160 n4144 VDD pmos W=0.205u L=0.04u
M7038 VDD n4162 U4226/net36 VDD pmos W=0.205u L=0.04u
M7039 U4226/net36 n4161 U4226/net30 VDD pmos W=0.205u L=0.04u
M7040 U4226/net36 n4159 U4226/net30 VDD pmos W=0.205u L=0.04u
M7041 VSS n4151 U4227/net22 VSS nmos W=0.155u L=0.04u
M7042 U4227/net22 n4156 n4162 VSS nmos W=0.155u L=0.04u
M7043 U4227/net22 g3229 n4162 VSS nmos W=0.155u L=0.04u
M7044 U4227/net22 n4163 n4162 VSS nmos W=0.155u L=0.04u
M7045 U4227/net38 n4163 VDD VDD pmos W=0.205u L=0.04u
M7046 U4227/net35 g3229 U4227/net38 VDD pmos W=0.205u L=0.04u
M7047 n4162 n4156 U4227/net35 VDD pmos W=0.205u L=0.04u
M7048 n4162 n4151 VDD VDD pmos W=0.205u L=0.04u
M7049 n4151 g3229 U4228/XI0-net10 VSS nmos W=0.155u L=0.04u
M7050 U4228/XI0-net10 n4156 U4228/XI0-net13 VSS nmos W=0.155u L=0.04u
M7051 U4228/XI0-net13 n4164 VSS VSS nmos W=0.155u L=0.04u
M7052 n4151 n4164 VDD VDD pmos W=0.205u L=0.04u
M7053 n4151 g3229 VDD VDD pmos W=0.205u L=0.04u
M7054 n4151 n4156 VDD VDD pmos W=0.205u L=0.04u
M7055 U4229/net19 n4149 VSS VSS nmos W=0.155u L=0.04u
M7056 n3521 n4149 U4229/net40 VSS nmos W=0.155u L=0.04u
M7057 n3521 U4229/net19 U4229/net36 VSS nmos W=0.155u L=0.04u
M7058 U4229/net40 n4145 VSS VSS nmos W=0.31u L=0.04u
M7059 U4229/net36 g1271 VSS VSS nmos W=0.155u L=0.04u
M7060 U4229/net19 n4149 VDD VDD pmos W=0.205u L=0.04u
M7061 n3521 U4229/net19 U4229/net26 VDD pmos W=0.325u L=0.04u
M7062 U4229/net26 n4145 VDD VDD pmos W=0.41u L=0.04u
M7063 n3521 n4149 U4229/net30 VDD pmos W=0.325u L=0.04u
M7064 U4229/net30 g1271 VDD VDD pmos W=0.205u L=0.04u
M7065 n4149 n4139 VSS VSS nmos W=0.155u L=0.04u
M7066 n4149 n3530 VSS VSS nmos W=0.155u L=0.04u
M7067 U4230/XI1-net8 n3530 VDD VDD pmos W=0.205u L=0.04u
M7068 n4149 n4139 U4230/XI1-net8 VDD pmos W=0.205u L=0.04u
M7069 n3530 n4140 U4231/net10 VSS nmos W=0.155u L=0.04u
M7070 U4231/net10 n3950 VSS VSS nmos W=0.155u L=0.04u
M7071 n3530 n4165 U4231/net10 VSS nmos W=0.155u L=0.04u
M7072 U4231/net10 n4166 VSS VSS nmos W=0.155u L=0.04u
M7073 U4231/net30 n3950 VDD VDD pmos W=0.205u L=0.04u
M7074 n3530 n4140 U4231/net24 VDD pmos W=0.205u L=0.04u
M7075 U4231/net24 n4165 VDD VDD pmos W=0.205u L=0.04u
M7076 n3530 n4166 U4231/net30 VDD pmos W=0.205u L=0.04u
M7077 U4232/net7 g1196 U4232/X_u4-net10 VSS nmos W=0.155u L=0.04u
M7078 U4232/X_u4-net10 n4167 U4232/X_u4-net13 VSS nmos W=0.155u L=0.04u
M7079 U4232/X_u4-net13 n4165 VSS VSS nmos W=0.155u L=0.04u
M7080 n4166 U4232/net7 VSS VSS nmos W=0.155u L=0.04u
M7081 U4232/net7 n4165 VDD VDD pmos W=0.205u L=0.04u
M7082 U4232/net7 g1196 VDD VDD pmos W=0.205u L=0.04u
M7083 U4232/net7 n4167 VDD VDD pmos W=0.205u L=0.04u
M7084 n4166 U4232/net7 VDD VDD pmos W=0.205u L=0.04u
M7085 n4145 n4161 U4233/net15 VSS nmos W=0.155u L=0.04u
M7086 n4145 n4160 U4233/net15 VSS nmos W=0.155u L=0.04u
M7087 U4233/net15 n4168 VSS VSS nmos W=0.155u L=0.04u
M7088 n4145 n4168 VDD VDD pmos W=0.205u L=0.04u
M7089 n4145 n4161 U4233/XI16-net11 VDD pmos W=0.205u L=0.04u
M7090 U4233/XI16-net11 n4160 VDD VDD pmos W=0.205u L=0.04u
M7091 n4160 g3229 VSS VSS nmos W=0.155u L=0.04u
M7092 n4160 n493 VSS VSS nmos W=0.155u L=0.04u
M7093 U4234/XI1-net8 n493 VDD VDD pmos W=0.205u L=0.04u
M7094 n4160 g3229 U4234/XI1-net8 VDD pmos W=0.205u L=0.04u
M7095 n4161 n4156 VSS VSS nmos W=0.155u L=0.04u
M7096 n4161 n3937 VSS VSS nmos W=0.155u L=0.04u
M7097 U4235/XI1-net8 n3937 VDD VDD pmos W=0.205u L=0.04u
M7098 n4161 n4156 U4235/XI1-net8 VDD pmos W=0.205u L=0.04u
M7099 U4236/net19 n4139 VSS VSS nmos W=0.155u L=0.04u
M7100 n3520 n4139 U4236/net40 VSS nmos W=0.155u L=0.04u
M7101 n3520 U4236/net19 U4236/net36 VSS nmos W=0.155u L=0.04u
M7102 U4236/net40 g1177 VSS VSS nmos W=0.31u L=0.04u
M7103 U4236/net36 n4147 VSS VSS nmos W=0.155u L=0.04u
M7104 U4236/net19 n4139 VDD VDD pmos W=0.205u L=0.04u
M7105 n3520 U4236/net19 U4236/net26 VDD pmos W=0.325u L=0.04u
M7106 U4236/net26 g1177 VDD VDD pmos W=0.41u L=0.04u
M7107 n3520 n4139 U4236/net30 VDD pmos W=0.325u L=0.04u
M7108 U4236/net30 n4147 VDD VDD pmos W=0.205u L=0.04u
M7109 U4237/net7 g1196 U4237/X_u4-net10 VSS nmos W=0.155u L=0.04u
M7110 U4237/X_u4-net10 n4165 U4237/X_u4-net13 VSS nmos W=0.155u L=0.04u
M7111 U4237/X_u4-net13 n4148 VSS VSS nmos W=0.155u L=0.04u
M7112 n4147 U4237/net7 VSS VSS nmos W=0.155u L=0.04u
M7113 U4237/net7 n4148 VDD VDD pmos W=0.205u L=0.04u
M7114 U4237/net7 g1196 VDD VDD pmos W=0.205u L=0.04u
M7115 U4237/net7 n4165 VDD VDD pmos W=0.205u L=0.04u
M7116 n4147 U4237/net7 VDD VDD pmos W=0.205u L=0.04u
M7117 n4165 g1236 U4238/XI21-net17 VSS nmos W=0.155u L=0.04u
M7118 U4238/XI21-net17 g1183 VSS VSS nmos W=0.155u L=0.04u
M7119 n4165 g6750 U4238/XI6-net17 VSS nmos W=0.155u L=0.04u
M7120 U4238/XI6-net17 g1177 VSS VSS nmos W=0.155u L=0.04u
M7121 n4165 g6944 U4238/XI20-net17 VSS nmos W=0.155u L=0.04u
M7122 U4238/XI20-net17 g1180 VSS VSS nmos W=0.155u L=0.04u
M7123 VDD g1236 U4238/net22 VDD pmos W=0.205u L=0.04u
M7124 VDD g1183 U4238/net22 VDD pmos W=0.205u L=0.04u
M7125 U4238/net16 g6750 n4165 VDD pmos W=0.205u L=0.04u
M7126 U4238/net16 g1177 n4165 VDD pmos W=0.205u L=0.04u
M7127 U4238/net22 g6944 U4238/net16 VDD pmos W=0.205u L=0.04u
M7128 U4238/net22 g1180 U4238/net16 VDD pmos W=0.205u L=0.04u
M7129 n3519 U4239/net28 VSS VSS nmos W=0.155u L=0.04u
M7130 U4239/net47 g978 VSS VSS nmos W=0.155u L=0.04u
M7131 U4239/net28 U4239/net6 U4239/net47 VSS nmos W=0.155u L=0.04u
M7132 U4239/net44 n4169 VSS VSS nmos W=0.155u L=0.04u
M7133 U4239/net28 n3937 U4239/net44 VSS nmos W=0.155u L=0.04u
M7134 U4239/net6 n3937 VSS VSS nmos W=0.155u L=0.04u
M7135 n3519 U4239/net28 VDD VDD pmos W=0.205u L=0.04u
M7136 VDD g978 U4239/net47 VDD pmos W=0.205u L=0.04u
M7137 U4239/net47 n3937 U4239/net28 VDD pmos W=0.205u L=0.04u
M7138 U4239/net44 U4239/net6 U4239/net28 VDD pmos W=0.205u L=0.04u
M7139 VDD n4169 U4239/net44 VDD pmos W=0.205u L=0.04u
M7140 VDD n3937 U4239/net6 VDD pmos W=0.205u L=0.04u
M7141 U4240/net19 g7961 VSS VSS nmos W=0.155u L=0.04u
M7142 n3518 g7961 U4240/net40 VSS nmos W=0.155u L=0.04u
M7143 n3518 U4240/net19 U4240/net36 VSS nmos W=0.155u L=0.04u
M7144 U4240/net40 n4170 VSS VSS nmos W=0.31u L=0.04u
M7145 U4240/net36 g1152 VSS VSS nmos W=0.155u L=0.04u
M7146 U4240/net19 g7961 VDD VDD pmos W=0.205u L=0.04u
M7147 n3518 U4240/net19 U4240/net26 VDD pmos W=0.325u L=0.04u
M7148 U4240/net26 n4170 VDD VDD pmos W=0.41u L=0.04u
M7149 n3518 g7961 U4240/net30 VDD pmos W=0.325u L=0.04u
M7150 U4240/net30 g1152 VDD VDD pmos W=0.205u L=0.04u
M7151 U4241/net19 g8007 VSS VSS nmos W=0.155u L=0.04u
M7152 n3517 g8007 U4241/net40 VSS nmos W=0.155u L=0.04u
M7153 n3517 U4241/net19 U4241/net36 VSS nmos W=0.155u L=0.04u
M7154 U4241/net40 n4170 VSS VSS nmos W=0.31u L=0.04u
M7155 U4241/net36 g1155 VSS VSS nmos W=0.155u L=0.04u
M7156 U4241/net19 g8007 VDD VDD pmos W=0.205u L=0.04u
M7157 n3517 U4241/net19 U4241/net26 VDD pmos W=0.325u L=0.04u
M7158 U4241/net26 n4170 VDD VDD pmos W=0.41u L=0.04u
M7159 n3517 g8007 U4241/net30 VDD pmos W=0.325u L=0.04u
M7160 U4241/net30 g1155 VDD VDD pmos W=0.205u L=0.04u
M7161 U4242/net19 g1172 VSS VSS nmos W=0.155u L=0.04u
M7162 n3516 g1172 U4242/net40 VSS nmos W=0.155u L=0.04u
M7163 n3516 U4242/net19 U4242/net36 VSS nmos W=0.155u L=0.04u
M7164 U4242/net40 n4170 VSS VSS nmos W=0.31u L=0.04u
M7165 U4242/net36 g1158 VSS VSS nmos W=0.155u L=0.04u
M7166 U4242/net19 g1172 VDD VDD pmos W=0.205u L=0.04u
M7167 n3516 U4242/net19 U4242/net26 VDD pmos W=0.325u L=0.04u
M7168 U4242/net26 n4170 VDD VDD pmos W=0.41u L=0.04u
M7169 n3516 g1172 U4242/net30 VDD pmos W=0.325u L=0.04u
M7170 U4242/net30 g1158 VDD VDD pmos W=0.205u L=0.04u
M7171 U4243/net19 g1172 VSS VSS nmos W=0.155u L=0.04u
M7172 n3515 g1172 U4243/net40 VSS nmos W=0.155u L=0.04u
M7173 n3515 U4243/net19 U4243/net36 VSS nmos W=0.155u L=0.04u
M7174 U4243/net40 n4171 VSS VSS nmos W=0.31u L=0.04u
M7175 U4243/net36 g1148 VSS VSS nmos W=0.155u L=0.04u
M7176 U4243/net19 g1172 VDD VDD pmos W=0.205u L=0.04u
M7177 n3515 U4243/net19 U4243/net26 VDD pmos W=0.325u L=0.04u
M7178 U4243/net26 n4171 VDD VDD pmos W=0.41u L=0.04u
M7179 n3515 g1172 U4243/net30 VDD pmos W=0.325u L=0.04u
M7180 U4243/net30 g1148 VDD VDD pmos W=0.205u L=0.04u
M7181 U4244/net19 g7961 VSS VSS nmos W=0.155u L=0.04u
M7182 n3514 g7961 U4244/net40 VSS nmos W=0.155u L=0.04u
M7183 n3514 U4244/net19 U4244/net36 VSS nmos W=0.155u L=0.04u
M7184 U4244/net40 n4171 VSS VSS nmos W=0.31u L=0.04u
M7185 U4244/net36 g1142 VSS VSS nmos W=0.155u L=0.04u
M7186 U4244/net19 g7961 VDD VDD pmos W=0.205u L=0.04u
M7187 n3514 U4244/net19 U4244/net26 VDD pmos W=0.325u L=0.04u
M7188 U4244/net26 n4171 VDD VDD pmos W=0.41u L=0.04u
M7189 n3514 g7961 U4244/net30 VDD pmos W=0.325u L=0.04u
M7190 U4244/net30 g1142 VDD VDD pmos W=0.205u L=0.04u
M7191 U4245/net19 g8007 VSS VSS nmos W=0.155u L=0.04u
M7192 n3513 g8007 U4245/net40 VSS nmos W=0.155u L=0.04u
M7193 n3513 U4245/net19 U4245/net36 VSS nmos W=0.155u L=0.04u
M7194 U4245/net40 n4171 VSS VSS nmos W=0.31u L=0.04u
M7195 U4245/net36 g1145 VSS VSS nmos W=0.155u L=0.04u
M7196 U4245/net19 g8007 VDD VDD pmos W=0.205u L=0.04u
M7197 n3513 U4245/net19 U4245/net26 VDD pmos W=0.325u L=0.04u
M7198 U4245/net26 n4171 VDD VDD pmos W=0.41u L=0.04u
M7199 n3513 g8007 U4245/net30 VDD pmos W=0.325u L=0.04u
M7200 U4245/net30 g1145 VDD VDD pmos W=0.205u L=0.04u
M7201 n4171 n4172 VSS VSS nmos W=0.135u L=0.04u
M7202 n4171 n4172 VDD VDD pmos W=0.205u L=0.04u
M7203 U4247/net19 g7961 VSS VSS nmos W=0.155u L=0.04u
M7204 n3512 g7961 U4247/net40 VSS nmos W=0.155u L=0.04u
M7205 n3512 U4247/net19 U4247/net36 VSS nmos W=0.155u L=0.04u
M7206 U4247/net40 n4173 VSS VSS nmos W=0.31u L=0.04u
M7207 U4247/net36 g1164 VSS VSS nmos W=0.155u L=0.04u
M7208 U4247/net19 g7961 VDD VDD pmos W=0.205u L=0.04u
M7209 n3512 U4247/net19 U4247/net26 VDD pmos W=0.325u L=0.04u
M7210 U4247/net26 n4173 VDD VDD pmos W=0.41u L=0.04u
M7211 n3512 g7961 U4247/net30 VDD pmos W=0.325u L=0.04u
M7212 U4247/net30 g1164 VDD VDD pmos W=0.205u L=0.04u
M7213 U4248/net19 g8007 VSS VSS nmos W=0.155u L=0.04u
M7214 n3511 g8007 U4248/net40 VSS nmos W=0.155u L=0.04u
M7215 n3511 U4248/net19 U4248/net36 VSS nmos W=0.155u L=0.04u
M7216 U4248/net40 n4173 VSS VSS nmos W=0.31u L=0.04u
M7217 U4248/net36 g1165 VSS VSS nmos W=0.155u L=0.04u
M7218 U4248/net19 g8007 VDD VDD pmos W=0.205u L=0.04u
M7219 n3511 U4248/net19 U4248/net26 VDD pmos W=0.325u L=0.04u
M7220 U4248/net26 n4173 VDD VDD pmos W=0.41u L=0.04u
M7221 n3511 g8007 U4248/net30 VDD pmos W=0.325u L=0.04u
M7222 U4248/net30 g1165 VDD VDD pmos W=0.205u L=0.04u
M7223 U4249/net19 g1172 VSS VSS nmos W=0.155u L=0.04u
M7224 n3510 g1172 U4249/net40 VSS nmos W=0.155u L=0.04u
M7225 n3510 U4249/net19 U4249/net36 VSS nmos W=0.155u L=0.04u
M7226 U4249/net40 n4173 VSS VSS nmos W=0.31u L=0.04u
M7227 U4249/net36 g1166 VSS VSS nmos W=0.155u L=0.04u
M7228 U4249/net19 g1172 VDD VDD pmos W=0.205u L=0.04u
M7229 n3510 U4249/net19 U4249/net26 VDD pmos W=0.325u L=0.04u
M7230 U4249/net26 n4173 VDD VDD pmos W=0.41u L=0.04u
M7231 n3510 g1172 U4249/net30 VDD pmos W=0.325u L=0.04u
M7232 U4249/net30 g1166 VDD VDD pmos W=0.205u L=0.04u
M7233 U4250/net19 g8007 VSS VSS nmos W=0.155u L=0.04u
M7234 n3509 g8007 U4250/net40 VSS nmos W=0.155u L=0.04u
M7235 n3509 U4250/net19 U4250/net36 VSS nmos W=0.155u L=0.04u
M7236 U4250/net40 g11902 VSS VSS nmos W=0.31u L=0.04u
M7237 U4250/net36 g1171 VSS VSS nmos W=0.155u L=0.04u
M7238 U4250/net19 g8007 VDD VDD pmos W=0.205u L=0.04u
M7239 n3509 U4250/net19 U4250/net26 VDD pmos W=0.325u L=0.04u
M7240 U4250/net26 g11902 VDD VDD pmos W=0.41u L=0.04u
M7241 n3509 g8007 U4250/net30 VDD pmos W=0.325u L=0.04u
M7242 U4250/net30 g1171 VDD VDD pmos W=0.205u L=0.04u
M7243 U4251/net19 g1172 VSS VSS nmos W=0.155u L=0.04u
M7244 n3508 g1172 U4251/net40 VSS nmos W=0.155u L=0.04u
M7245 n3508 U4251/net19 U4251/net36 VSS nmos W=0.155u L=0.04u
M7246 U4251/net40 g11902 VSS VSS nmos W=0.31u L=0.04u
M7247 U4251/net36 g1151 VSS VSS nmos W=0.155u L=0.04u
M7248 U4251/net19 g1172 VDD VDD pmos W=0.205u L=0.04u
M7249 n3508 U4251/net19 U4251/net26 VDD pmos W=0.325u L=0.04u
M7250 U4251/net26 g11902 VDD VDD pmos W=0.41u L=0.04u
M7251 n3508 g1172 U4251/net30 VDD pmos W=0.325u L=0.04u
M7252 U4251/net30 g1151 VDD VDD pmos W=0.205u L=0.04u
M7253 U4252/net19 g7961 VSS VSS nmos W=0.155u L=0.04u
M7254 n3507 g7961 U4252/net40 VSS nmos W=0.155u L=0.04u
M7255 n3507 U4252/net19 U4252/net36 VSS nmos W=0.155u L=0.04u
M7256 U4252/net40 g11902 VSS VSS nmos W=0.31u L=0.04u
M7257 U4252/net36 g1167 VSS VSS nmos W=0.155u L=0.04u
M7258 U4252/net19 g7961 VDD VDD pmos W=0.205u L=0.04u
M7259 n3507 U4252/net19 U4252/net26 VDD pmos W=0.325u L=0.04u
M7260 U4252/net26 g11902 VDD VDD pmos W=0.41u L=0.04u
M7261 n3507 g7961 U4252/net30 VDD pmos W=0.325u L=0.04u
M7262 U4252/net30 g1167 VDD VDD pmos W=0.205u L=0.04u
M7263 U4253/net19 g7961 VSS VSS nmos W=0.155u L=0.04u
M7264 n3506 g7961 U4253/net40 VSS nmos W=0.155u L=0.04u
M7265 n3506 U4253/net19 U4253/net36 VSS nmos W=0.155u L=0.04u
M7266 U4253/net40 n4174 VSS VSS nmos W=0.31u L=0.04u
M7267 U4253/net36 g1173 VSS VSS nmos W=0.155u L=0.04u
M7268 U4253/net19 g7961 VDD VDD pmos W=0.205u L=0.04u
M7269 n3506 U4253/net19 U4253/net26 VDD pmos W=0.325u L=0.04u
M7270 U4253/net26 n4174 VDD VDD pmos W=0.41u L=0.04u
M7271 n3506 g7961 U4253/net30 VDD pmos W=0.325u L=0.04u
M7272 U4253/net30 g1173 VDD VDD pmos W=0.205u L=0.04u
M7273 U4254/net19 g8007 VSS VSS nmos W=0.155u L=0.04u
M7274 n3505 g8007 U4254/net40 VSS nmos W=0.155u L=0.04u
M7275 n3505 U4254/net19 U4254/net36 VSS nmos W=0.155u L=0.04u
M7276 U4254/net40 n4174 VSS VSS nmos W=0.31u L=0.04u
M7277 U4254/net36 g1174 VSS VSS nmos W=0.155u L=0.04u
M7278 U4254/net19 g8007 VDD VDD pmos W=0.205u L=0.04u
M7279 n3505 U4254/net19 U4254/net26 VDD pmos W=0.325u L=0.04u
M7280 U4254/net26 n4174 VDD VDD pmos W=0.41u L=0.04u
M7281 n3505 g8007 U4254/net30 VDD pmos W=0.325u L=0.04u
M7282 U4254/net30 g1174 VDD VDD pmos W=0.205u L=0.04u
M7283 U4255/net19 g1172 VSS VSS nmos W=0.155u L=0.04u
M7284 n3504 g1172 U4255/net40 VSS nmos W=0.155u L=0.04u
M7285 n3504 U4255/net19 U4255/net36 VSS nmos W=0.155u L=0.04u
M7286 U4255/net40 n4174 VSS VSS nmos W=0.31u L=0.04u
M7287 U4255/net36 g1175 VSS VSS nmos W=0.155u L=0.04u
M7288 U4255/net19 g1172 VDD VDD pmos W=0.205u L=0.04u
M7289 n3504 U4255/net19 U4255/net26 VDD pmos W=0.325u L=0.04u
M7290 U4255/net26 n4174 VDD VDD pmos W=0.41u L=0.04u
M7291 n3504 g1172 U4255/net30 VDD pmos W=0.325u L=0.04u
M7292 U4255/net30 g1175 VDD VDD pmos W=0.205u L=0.04u
M7293 U4256/net19 n4176 VSS VSS nmos W=0.155u L=0.04u
M7294 n3503 n4176 U4256/net40 VSS nmos W=0.155u L=0.04u
M7295 n3503 U4256/net19 U4256/net36 VSS nmos W=0.155u L=0.04u
M7296 U4256/net40 n4175 VSS VSS nmos W=0.31u L=0.04u
M7297 U4256/net36 g852 VSS VSS nmos W=0.155u L=0.04u
M7298 U4256/net19 n4176 VDD VDD pmos W=0.205u L=0.04u
M7299 n3503 U4256/net19 U4256/net26 VDD pmos W=0.325u L=0.04u
M7300 U4256/net26 n4175 VDD VDD pmos W=0.41u L=0.04u
M7301 n3503 n4176 U4256/net30 VDD pmos W=0.325u L=0.04u
M7302 U4256/net30 g852 VDD VDD pmos W=0.205u L=0.04u
M7303 U4257/net19 n4177 VSS VSS nmos W=0.155u L=0.04u
M7304 n3502 n4177 U4257/net40 VSS nmos W=0.155u L=0.04u
M7305 n3502 U4257/net19 U4257/net36 VSS nmos W=0.155u L=0.04u
M7306 U4257/net40 n4175 VSS VSS nmos W=0.31u L=0.04u
M7307 U4257/net36 g850 VSS VSS nmos W=0.155u L=0.04u
M7308 U4257/net19 n4177 VDD VDD pmos W=0.205u L=0.04u
M7309 n3502 U4257/net19 U4257/net26 VDD pmos W=0.325u L=0.04u
M7310 U4257/net26 n4175 VDD VDD pmos W=0.41u L=0.04u
M7311 n3502 n4177 U4257/net30 VDD pmos W=0.325u L=0.04u
M7312 U4257/net30 g850 VDD VDD pmos W=0.205u L=0.04u
M7313 U4258/net19 n4176 VSS VSS nmos W=0.155u L=0.04u
M7314 n3501 n4176 U4258/net40 VSS nmos W=0.155u L=0.04u
M7315 n3501 U4258/net19 U4258/net36 VSS nmos W=0.155u L=0.04u
M7316 U4258/net40 n4178 VSS VSS nmos W=0.31u L=0.04u
M7317 U4258/net36 g849 VSS VSS nmos W=0.155u L=0.04u
M7318 U4258/net19 n4176 VDD VDD pmos W=0.205u L=0.04u
M7319 n3501 U4258/net19 U4258/net26 VDD pmos W=0.325u L=0.04u
M7320 U4258/net26 n4178 VDD VDD pmos W=0.41u L=0.04u
M7321 n3501 n4176 U4258/net30 VDD pmos W=0.325u L=0.04u
M7322 U4258/net30 g849 VDD VDD pmos W=0.205u L=0.04u
M7323 U4259/net19 n4177 VSS VSS nmos W=0.155u L=0.04u
M7324 n3500 n4177 U4259/net40 VSS nmos W=0.155u L=0.04u
M7325 n3500 U4259/net19 U4259/net36 VSS nmos W=0.155u L=0.04u
M7326 U4259/net40 n4178 VSS VSS nmos W=0.31u L=0.04u
M7327 U4259/net36 g847 VSS VSS nmos W=0.155u L=0.04u
M7328 U4259/net19 n4177 VDD VDD pmos W=0.205u L=0.04u
M7329 n3500 U4259/net19 U4259/net26 VDD pmos W=0.325u L=0.04u
M7330 U4259/net26 n4178 VDD VDD pmos W=0.41u L=0.04u
M7331 n3500 n4177 U4259/net30 VDD pmos W=0.325u L=0.04u
M7332 U4259/net30 g847 VDD VDD pmos W=0.205u L=0.04u
M7333 U4260/net19 n4179 VSS VSS nmos W=0.155u L=0.04u
M7334 n3499 n4179 U4260/net40 VSS nmos W=0.155u L=0.04u
M7335 n3499 U4260/net19 U4260/net36 VSS nmos W=0.155u L=0.04u
M7336 U4260/net40 n4178 VSS VSS nmos W=0.31u L=0.04u
M7337 U4260/net36 g848 VSS VSS nmos W=0.155u L=0.04u
M7338 U4260/net19 n4179 VDD VDD pmos W=0.205u L=0.04u
M7339 n3499 U4260/net19 U4260/net26 VDD pmos W=0.325u L=0.04u
M7340 U4260/net26 n4178 VDD VDD pmos W=0.41u L=0.04u
M7341 n3499 n4179 U4260/net30 VDD pmos W=0.325u L=0.04u
M7342 U4260/net30 g848 VDD VDD pmos W=0.205u L=0.04u
M7343 U4261/net19 n4179 VSS VSS nmos W=0.155u L=0.04u
M7344 n3498 n4179 U4261/net40 VSS nmos W=0.155u L=0.04u
M7345 n3498 U4261/net19 U4261/net36 VSS nmos W=0.155u L=0.04u
M7346 U4261/net40 n4175 VSS VSS nmos W=0.31u L=0.04u
M7347 U4261/net36 g851 VSS VSS nmos W=0.155u L=0.04u
M7348 U4261/net19 n4179 VDD VDD pmos W=0.205u L=0.04u
M7349 n3498 U4261/net19 U4261/net26 VDD pmos W=0.325u L=0.04u
M7350 U4261/net26 n4175 VDD VDD pmos W=0.41u L=0.04u
M7351 n3498 n4179 U4261/net30 VDD pmos W=0.325u L=0.04u
M7352 U4261/net30 g851 VDD VDD pmos W=0.205u L=0.04u
M7353 U4262/net19 n4180 VSS VSS nmos W=0.155u L=0.04u
M7354 n3497 n4180 U4262/net40 VSS nmos W=0.155u L=0.04u
M7355 n3497 U4262/net19 U4262/net36 VSS nmos W=0.155u L=0.04u
M7356 U4262/net40 g659 VSS VSS nmos W=0.31u L=0.04u
M7357 U4262/net36 n3852 VSS VSS nmos W=0.155u L=0.04u
M7358 U4262/net19 n4180 VDD VDD pmos W=0.205u L=0.04u
M7359 n3497 U4262/net19 U4262/net26 VDD pmos W=0.325u L=0.04u
M7360 U4262/net26 g659 VDD VDD pmos W=0.41u L=0.04u
M7361 n3497 n4180 U4262/net30 VDD pmos W=0.325u L=0.04u
M7362 U4262/net30 n3852 VDD VDD pmos W=0.205u L=0.04u
M7363 n3852 n3950 VSS VSS nmos W=0.135u L=0.04u
M7364 n3852 n3950 VDD VDD pmos W=0.205u L=0.04u
M7365 U4264/net36 n4182 U4264/net24 VSS nmos W=0.155u L=0.04u
M7366 U4264/net24 n4183 VSS VSS nmos W=0.155u L=0.04u
M7367 n3496 g640 U4264/net36 VSS nmos W=0.155u L=0.04u
M7368 n3496 n4181 U4264/net36 VSS nmos W=0.155u L=0.04u
M7369 n3496 n4181 U4264/net35 VDD pmos W=0.205u L=0.04u
M7370 U4264/net35 g640 VDD VDD pmos W=0.205u L=0.04u
M7371 n3496 n4183 VDD VDD pmos W=0.205u L=0.04u
M7372 n3496 n4182 VDD VDD pmos W=0.205u L=0.04u
M7373 n3495 U4265/net27 VDD VDD pmos W=0.205u L=0.04u
M7374 U4265/net11 n4184 U4265/net27 VDD pmos W=0.205u L=0.04u
M7375 U4265/net11 n4182 U4265/net27 VDD pmos W=0.205u L=0.04u
M7376 U4265/net11 n4185 U4265/XI16-net11 VDD pmos W=0.205u L=0.04u
M7377 U4265/XI16-net11 n4186 VDD VDD pmos W=0.205u L=0.04u
M7378 U4265/net27 n4186 VSS VSS nmos W=0.155u L=0.04u
M7379 U4265/net27 n4185 VSS VSS nmos W=0.155u L=0.04u
M7380 n3495 U4265/net27 VSS VSS nmos W=0.155u L=0.04u
M7381 U4265/net27 n4184 U4265/XI12-net17 VSS nmos W=0.155u L=0.04u
M7382 U4265/XI12-net17 n4182 VSS VSS nmos W=0.155u L=0.04u
M7383 U4266/net36 n4187 U4266/net24 VSS nmos W=0.155u L=0.04u
M7384 U4266/net24 n4183 VSS VSS nmos W=0.155u L=0.04u
M7385 n3494 g653 U4266/net36 VSS nmos W=0.155u L=0.04u
M7386 n3494 n4185 U4266/net36 VSS nmos W=0.155u L=0.04u
M7387 n3494 n4185 U4266/net35 VDD pmos W=0.205u L=0.04u
M7388 U4266/net35 g653 VDD VDD pmos W=0.205u L=0.04u
M7389 n3494 n4183 VDD VDD pmos W=0.205u L=0.04u
M7390 n3494 n4187 VDD VDD pmos W=0.205u L=0.04u
M7391 n3493 U4267/net27 VDD VDD pmos W=0.205u L=0.04u
M7392 U4267/net11 n4188 U4267/net27 VDD pmos W=0.205u L=0.04u
M7393 U4267/net11 n4187 U4267/net27 VDD pmos W=0.205u L=0.04u
M7394 U4267/net11 n4189 U4267/XI16-net11 VDD pmos W=0.205u L=0.04u
M7395 U4267/XI16-net11 n4186 VDD VDD pmos W=0.205u L=0.04u
M7396 U4267/net27 n4186 VSS VSS nmos W=0.155u L=0.04u
M7397 U4267/net27 n4189 VSS VSS nmos W=0.155u L=0.04u
M7398 n3493 U4267/net27 VSS VSS nmos W=0.155u L=0.04u
M7399 U4267/net27 n4188 U4267/XI12-net17 VSS nmos W=0.155u L=0.04u
M7400 U4267/XI12-net17 n4187 VSS VSS nmos W=0.155u L=0.04u
M7401 U4268/net36 n4190 U4268/net24 VSS nmos W=0.155u L=0.04u
M7402 U4268/net24 n4183 VSS VSS nmos W=0.155u L=0.04u
M7403 n3492 g660 U4268/net36 VSS nmos W=0.155u L=0.04u
M7404 n3492 n4189 U4268/net36 VSS nmos W=0.155u L=0.04u
M7405 n3492 n4189 U4268/net35 VDD pmos W=0.205u L=0.04u
M7406 U4268/net35 g660 VDD VDD pmos W=0.205u L=0.04u
M7407 n3492 n4183 VDD VDD pmos W=0.205u L=0.04u
M7408 n3492 n4190 VDD VDD pmos W=0.205u L=0.04u
M7409 n3491 U4269/net27 VDD VDD pmos W=0.205u L=0.04u
M7410 U4269/net11 n4191 U4269/net27 VDD pmos W=0.205u L=0.04u
M7411 U4269/net11 n4190 U4269/net27 VDD pmos W=0.205u L=0.04u
M7412 U4269/net11 n4192 U4269/XI16-net11 VDD pmos W=0.205u L=0.04u
M7413 U4269/XI16-net11 n4186 VDD VDD pmos W=0.205u L=0.04u
M7414 U4269/net27 n4186 VSS VSS nmos W=0.155u L=0.04u
M7415 U4269/net27 n4192 VSS VSS nmos W=0.155u L=0.04u
M7416 n3491 U4269/net27 VSS VSS nmos W=0.155u L=0.04u
M7417 U4269/net27 n4191 U4269/XI12-net17 VSS nmos W=0.155u L=0.04u
M7418 U4269/XI12-net17 n4190 VSS VSS nmos W=0.155u L=0.04u
M7419 n4186 n4183 VSS VSS nmos W=0.135u L=0.04u
M7420 n4186 n4183 VDD VDD pmos W=0.205u L=0.04u
M7421 U4271/net36 n4193 U4271/net24 VSS nmos W=0.155u L=0.04u
M7422 U4271/net24 n4183 VSS VSS nmos W=0.155u L=0.04u
M7423 n3490 g666 U4271/net36 VSS nmos W=0.155u L=0.04u
M7424 n3490 n4192 U4271/net36 VSS nmos W=0.155u L=0.04u
M7425 n3490 n4192 U4271/net35 VDD pmos W=0.205u L=0.04u
M7426 U4271/net35 g666 VDD VDD pmos W=0.205u L=0.04u
M7427 n3490 n4183 VDD VDD pmos W=0.205u L=0.04u
M7428 n3490 n4193 VDD VDD pmos W=0.205u L=0.04u
M7429 U4272/net36 n4195 U4272/net24 VSS nmos W=0.155u L=0.04u
M7430 U4272/net24 n4183 VSS VSS nmos W=0.155u L=0.04u
M7431 n3489 g679 U4272/net36 VSS nmos W=0.155u L=0.04u
M7432 n3489 n4194 U4272/net36 VSS nmos W=0.155u L=0.04u
M7433 n3489 n4194 U4272/net35 VDD pmos W=0.205u L=0.04u
M7434 U4272/net35 g679 VDD VDD pmos W=0.205u L=0.04u
M7435 n3489 n4183 VDD VDD pmos W=0.205u L=0.04u
M7436 n3489 n4195 VDD VDD pmos W=0.205u L=0.04u
M7437 U4273/XU1-net6 n4183 VSS VSS nmos W=0.155u L=0.04u
M7438 n3488 n4196 U4273/XU1-net6 VSS nmos W=0.155u L=0.04u
M7439 n3488 n4183 VDD VDD pmos W=0.155u L=0.04u
M7440 n3488 n4196 VDD VDD pmos W=0.155u L=0.04u
M7441 U4274/net4 n4195 U4274/net14 VSS nmos W=0.155u L=0.04u
M7442 U4274/net6 U4274/net10 U4274/net14 VSS nmos W=0.17u L=0.04u
M7443 U4274/net4 g686 VSS VSS nmos W=0.155u L=0.04u
M7444 U4274/net6 U4274/net4 VSS VSS nmos W=0.17u L=0.04u
M7445 n4196 U4274/net14 VSS VSS nmos W=0.155u L=0.04u
M7446 U4274/net10 n4195 VSS VSS nmos W=0.155u L=0.04u
M7447 U4274/net4 U4274/net10 U4274/net14 VDD pmos W=0.255u L=0.04u
M7448 U4274/net6 n4195 U4274/net14 VDD pmos W=0.28u L=0.04u
M7449 U4274/net4 g686 VDD VDD pmos W=0.205u L=0.04u
M7450 U4274/net6 U4274/net4 VDD VDD pmos W=0.24u L=0.04u
M7451 n4196 U4274/net14 VDD VDD pmos W=0.205u L=0.04u
M7452 U4274/net10 n4195 VDD VDD pmos W=0.205u L=0.04u
M7453 U4275/XU1-net6 n4183 VSS VSS nmos W=0.155u L=0.04u
M7454 n3487 n4197 U4275/XU1-net6 VSS nmos W=0.155u L=0.04u
M7455 n3487 n4183 VDD VDD pmos W=0.155u L=0.04u
M7456 n3487 n4197 VDD VDD pmos W=0.155u L=0.04u
M7457 U4276/net4 n4198 U4276/net14 VSS nmos W=0.155u L=0.04u
M7458 U4276/net6 U4276/net10 U4276/net14 VSS nmos W=0.17u L=0.04u
M7459 U4276/net4 n4199 VSS VSS nmos W=0.155u L=0.04u
M7460 U4276/net6 U4276/net4 VSS VSS nmos W=0.17u L=0.04u
M7461 n4197 U4276/net14 VSS VSS nmos W=0.155u L=0.04u
M7462 U4276/net10 n4198 VSS VSS nmos W=0.155u L=0.04u
M7463 U4276/net4 U4276/net10 U4276/net14 VDD pmos W=0.255u L=0.04u
M7464 U4276/net6 n4198 U4276/net14 VDD pmos W=0.28u L=0.04u
M7465 U4276/net4 n4199 VDD VDD pmos W=0.205u L=0.04u
M7466 U4276/net6 U4276/net4 VDD VDD pmos W=0.24u L=0.04u
M7467 n4197 U4276/net14 VDD VDD pmos W=0.205u L=0.04u
M7468 U4276/net10 n4198 VDD VDD pmos W=0.205u L=0.04u
M7469 n4199 n4200 VSS VSS nmos W=0.155u L=0.04u
M7470 n4199 n4195 VSS VSS nmos W=0.155u L=0.04u
M7471 U4277/XI1-net8 n4195 VDD VDD pmos W=0.205u L=0.04u
M7472 n4199 n4200 U4277/XI1-net8 VDD pmos W=0.205u L=0.04u
M7473 U4278/XU1-net6 n4194 VSS VSS nmos W=0.155u L=0.04u
M7474 n4195 g679 U4278/XU1-net6 VSS nmos W=0.155u L=0.04u
M7475 n4195 n4194 VDD VDD pmos W=0.155u L=0.04u
M7476 n4195 g679 VDD VDD pmos W=0.155u L=0.04u
M7477 n4194 n4193 VSS VSS nmos W=0.135u L=0.04u
M7478 n4194 n4193 VDD VDD pmos W=0.205u L=0.04u
M7479 U4280/XU1-net6 n4192 VSS VSS nmos W=0.155u L=0.04u
M7480 n4193 g666 U4280/XU1-net6 VSS nmos W=0.155u L=0.04u
M7481 n4193 n4192 VDD VDD pmos W=0.155u L=0.04u
M7482 n4193 g666 VDD VDD pmos W=0.155u L=0.04u
M7483 n4192 n4191 VSS VSS nmos W=0.155u L=0.04u
M7484 n4192 n4190 VSS VSS nmos W=0.155u L=0.04u
M7485 U4281/XI1-net8 n4190 VDD VDD pmos W=0.205u L=0.04u
M7486 n4192 n4191 U4281/XI1-net8 VDD pmos W=0.205u L=0.04u
M7487 U4282/XU1-net6 n4189 VSS VSS nmos W=0.155u L=0.04u
M7488 n4190 g660 U4282/XU1-net6 VSS nmos W=0.155u L=0.04u
M7489 n4190 n4189 VDD VDD pmos W=0.155u L=0.04u
M7490 n4190 g660 VDD VDD pmos W=0.155u L=0.04u
M7491 n4189 n4188 VSS VSS nmos W=0.155u L=0.04u
M7492 n4189 n4187 VSS VSS nmos W=0.155u L=0.04u
M7493 U4283/XI1-net8 n4187 VDD VDD pmos W=0.205u L=0.04u
M7494 n4189 n4188 U4283/XI1-net8 VDD pmos W=0.205u L=0.04u
M7495 U4284/XU1-net6 n4185 VSS VSS nmos W=0.155u L=0.04u
M7496 n4187 g653 U4284/XU1-net6 VSS nmos W=0.155u L=0.04u
M7497 n4187 n4185 VDD VDD pmos W=0.155u L=0.04u
M7498 n4187 g653 VDD VDD pmos W=0.155u L=0.04u
M7499 n4185 n4184 VSS VSS nmos W=0.155u L=0.04u
M7500 n4185 n4182 VSS VSS nmos W=0.155u L=0.04u
M7501 U4285/XI1-net8 n4182 VDD VDD pmos W=0.205u L=0.04u
M7502 n4185 n4184 U4285/XI1-net8 VDD pmos W=0.205u L=0.04u
M7503 U4286/XU1-net6 n4181 VSS VSS nmos W=0.155u L=0.04u
M7504 n4182 g640 U4286/XU1-net6 VSS nmos W=0.155u L=0.04u
M7505 n4182 n4181 VDD VDD pmos W=0.155u L=0.04u
M7506 n4182 g640 VDD VDD pmos W=0.155u L=0.04u
M7507 n4181 n4180 VSS VSS nmos W=0.155u L=0.04u
M7508 n4181 g659 VSS VSS nmos W=0.155u L=0.04u
M7509 U4287/XI1-net8 g659 VDD VDD pmos W=0.205u L=0.04u
M7510 n4181 n4180 U4287/XI1-net8 VDD pmos W=0.205u L=0.04u
M7511 n3486 g737 U4288/net15 VSS nmos W=0.155u L=0.04u
M7512 n3486 n4201 U4288/net15 VSS nmos W=0.155u L=0.04u
M7513 U4288/net15 n4202 VSS VSS nmos W=0.155u L=0.04u
M7514 n3486 n4202 VDD VDD pmos W=0.205u L=0.04u
M7515 n3486 g737 U4288/XI16-net11 VDD pmos W=0.205u L=0.04u
M7516 U4288/XI16-net11 n4201 VDD VDD pmos W=0.205u L=0.04u
M7517 n3485 g739 U4289/net15 VSS nmos W=0.155u L=0.04u
M7518 n3485 n4203 U4289/net15 VSS nmos W=0.155u L=0.04u
M7519 U4289/net15 n4183 VSS VSS nmos W=0.155u L=0.04u
M7520 n3485 n4183 VDD VDD pmos W=0.205u L=0.04u
M7521 n3485 g739 U4289/XI16-net11 VDD pmos W=0.205u L=0.04u
M7522 U4289/XI16-net11 n4203 VDD VDD pmos W=0.205u L=0.04u
M7523 n3484 g738 U4290/net15 VSS nmos W=0.155u L=0.04u
M7524 n3484 n4204 U4290/net15 VSS nmos W=0.155u L=0.04u
M7525 U4290/net15 n4205 VSS VSS nmos W=0.155u L=0.04u
M7526 n3484 n4205 VDD VDD pmos W=0.205u L=0.04u
M7527 n3484 g738 U4290/XI16-net11 VDD pmos W=0.205u L=0.04u
M7528 U4290/XI16-net11 n4204 VDD VDD pmos W=0.205u L=0.04u
M7529 U4291/net19 n4201 VSS VSS nmos W=0.155u L=0.04u
M7530 n3483 n4201 U4291/net40 VSS nmos W=0.155u L=0.04u
M7531 n3483 U4291/net19 U4291/net36 VSS nmos W=0.155u L=0.04u
M7532 U4291/net40 n4206 VSS VSS nmos W=0.31u L=0.04u
M7533 U4291/net36 g698 VSS VSS nmos W=0.155u L=0.04u
M7534 U4291/net19 n4201 VDD VDD pmos W=0.205u L=0.04u
M7535 n3483 U4291/net19 U4291/net26 VDD pmos W=0.325u L=0.04u
M7536 U4291/net26 n4206 VDD VDD pmos W=0.41u L=0.04u
M7537 n3483 n4201 U4291/net30 VDD pmos W=0.325u L=0.04u
M7538 U4291/net30 g698 VDD VDD pmos W=0.205u L=0.04u
M7539 U4292/net19 n4201 VSS VSS nmos W=0.155u L=0.04u
M7540 n3482 n4201 U4292/net40 VSS nmos W=0.155u L=0.04u
M7541 n3482 U4292/net19 U4292/net36 VSS nmos W=0.155u L=0.04u
M7542 U4292/net40 n4198 VSS VSS nmos W=0.31u L=0.04u
M7543 U4292/net36 g725 VSS VSS nmos W=0.155u L=0.04u
M7544 U4292/net19 n4201 VDD VDD pmos W=0.205u L=0.04u
M7545 n3482 U4292/net19 U4292/net26 VDD pmos W=0.325u L=0.04u
M7546 U4292/net26 n4198 VDD VDD pmos W=0.41u L=0.04u
M7547 n3482 n4201 U4292/net30 VDD pmos W=0.325u L=0.04u
M7548 U4292/net30 g725 VDD VDD pmos W=0.205u L=0.04u
M7549 U4293/net19 n4201 VSS VSS nmos W=0.155u L=0.04u
M7550 n3481 n4201 U4293/net40 VSS nmos W=0.155u L=0.04u
M7551 n3481 U4293/net19 U4293/net36 VSS nmos W=0.155u L=0.04u
M7552 U4293/net40 n4184 VSS VSS nmos W=0.31u L=0.04u
M7553 U4293/net36 g701 VSS VSS nmos W=0.155u L=0.04u
M7554 U4293/net19 n4201 VDD VDD pmos W=0.205u L=0.04u
M7555 n3481 U4293/net19 U4293/net26 VDD pmos W=0.325u L=0.04u
M7556 U4293/net26 n4184 VDD VDD pmos W=0.41u L=0.04u
M7557 n3481 n4201 U4293/net30 VDD pmos W=0.325u L=0.04u
M7558 U4293/net30 g701 VDD VDD pmos W=0.205u L=0.04u
M7559 U4294/net19 n4201 VSS VSS nmos W=0.155u L=0.04u
M7560 n3480 n4201 U4294/net40 VSS nmos W=0.155u L=0.04u
M7561 n3480 U4294/net19 U4294/net36 VSS nmos W=0.155u L=0.04u
M7562 U4294/net40 n4207 VSS VSS nmos W=0.31u L=0.04u
M7563 U4294/net36 g704 VSS VSS nmos W=0.155u L=0.04u
M7564 U4294/net19 n4201 VDD VDD pmos W=0.205u L=0.04u
M7565 n3480 U4294/net19 U4294/net26 VDD pmos W=0.325u L=0.04u
M7566 U4294/net26 n4207 VDD VDD pmos W=0.41u L=0.04u
M7567 n3480 n4201 U4294/net30 VDD pmos W=0.325u L=0.04u
M7568 U4294/net30 g704 VDD VDD pmos W=0.205u L=0.04u
M7569 U4295/net19 n4201 VSS VSS nmos W=0.155u L=0.04u
M7570 n3479 n4201 U4295/net40 VSS nmos W=0.155u L=0.04u
M7571 n3479 U4295/net19 U4295/net36 VSS nmos W=0.155u L=0.04u
M7572 U4295/net40 n4188 VSS VSS nmos W=0.31u L=0.04u
M7573 U4295/net36 g707 VSS VSS nmos W=0.155u L=0.04u
M7574 U4295/net19 n4201 VDD VDD pmos W=0.205u L=0.04u
M7575 n3479 U4295/net19 U4295/net26 VDD pmos W=0.325u L=0.04u
M7576 U4295/net26 n4188 VDD VDD pmos W=0.41u L=0.04u
M7577 n3479 n4201 U4295/net30 VDD pmos W=0.325u L=0.04u
M7578 U4295/net30 g707 VDD VDD pmos W=0.205u L=0.04u
M7579 U4296/net19 n4201 VSS VSS nmos W=0.155u L=0.04u
M7580 n3478 n4201 U4296/net40 VSS nmos W=0.155u L=0.04u
M7581 n3478 U4296/net19 U4296/net36 VSS nmos W=0.155u L=0.04u
M7582 U4296/net40 n4208 VSS VSS nmos W=0.31u L=0.04u
M7583 U4296/net36 g710 VSS VSS nmos W=0.155u L=0.04u
M7584 U4296/net19 n4201 VDD VDD pmos W=0.205u L=0.04u
M7585 n3478 U4296/net19 U4296/net26 VDD pmos W=0.325u L=0.04u
M7586 U4296/net26 n4208 VDD VDD pmos W=0.41u L=0.04u
M7587 n3478 n4201 U4296/net30 VDD pmos W=0.325u L=0.04u
M7588 U4296/net30 g710 VDD VDD pmos W=0.205u L=0.04u
M7589 U4297/net19 n4201 VSS VSS nmos W=0.155u L=0.04u
M7590 n3477 n4201 U4297/net40 VSS nmos W=0.155u L=0.04u
M7591 n3477 U4297/net19 U4297/net36 VSS nmos W=0.155u L=0.04u
M7592 U4297/net40 n4191 VSS VSS nmos W=0.31u L=0.04u
M7593 U4297/net36 g713 VSS VSS nmos W=0.155u L=0.04u
M7594 U4297/net19 n4201 VDD VDD pmos W=0.205u L=0.04u
M7595 n3477 U4297/net19 U4297/net26 VDD pmos W=0.325u L=0.04u
M7596 U4297/net26 n4191 VDD VDD pmos W=0.41u L=0.04u
M7597 n3477 n4201 U4297/net30 VDD pmos W=0.325u L=0.04u
M7598 U4297/net30 g713 VDD VDD pmos W=0.205u L=0.04u
M7599 U4298/net19 n4201 VSS VSS nmos W=0.155u L=0.04u
M7600 n3476 n4201 U4298/net40 VSS nmos W=0.155u L=0.04u
M7601 n3476 U4298/net19 U4298/net36 VSS nmos W=0.155u L=0.04u
M7602 U4298/net40 n4209 VSS VSS nmos W=0.31u L=0.04u
M7603 U4298/net36 g716 VSS VSS nmos W=0.155u L=0.04u
M7604 U4298/net19 n4201 VDD VDD pmos W=0.205u L=0.04u
M7605 n3476 U4298/net19 U4298/net26 VDD pmos W=0.325u L=0.04u
M7606 U4298/net26 n4209 VDD VDD pmos W=0.41u L=0.04u
M7607 n3476 n4201 U4298/net30 VDD pmos W=0.325u L=0.04u
M7608 U4298/net30 g716 VDD VDD pmos W=0.205u L=0.04u
M7609 U4299/net19 n4201 VSS VSS nmos W=0.155u L=0.04u
M7610 n3475 n4201 U4299/net40 VSS nmos W=0.155u L=0.04u
M7611 n3475 U4299/net19 U4299/net36 VSS nmos W=0.155u L=0.04u
M7612 U4299/net40 n4210 VSS VSS nmos W=0.31u L=0.04u
M7613 U4299/net36 g734 VSS VSS nmos W=0.155u L=0.04u
M7614 U4299/net19 n4201 VDD VDD pmos W=0.205u L=0.04u
M7615 n3475 U4299/net19 U4299/net26 VDD pmos W=0.325u L=0.04u
M7616 U4299/net26 n4210 VDD VDD pmos W=0.41u L=0.04u
M7617 n3475 n4201 U4299/net30 VDD pmos W=0.325u L=0.04u
M7618 U4299/net30 g734 VDD VDD pmos W=0.205u L=0.04u
M7619 U4300/net19 n4201 VSS VSS nmos W=0.155u L=0.04u
M7620 n3474 n4201 U4300/net40 VSS nmos W=0.155u L=0.04u
M7621 n3474 U4300/net19 U4300/net36 VSS nmos W=0.155u L=0.04u
M7622 U4300/net40 n4211 VSS VSS nmos W=0.31u L=0.04u
M7623 U4300/net36 g719 VSS VSS nmos W=0.155u L=0.04u
M7624 U4300/net19 n4201 VDD VDD pmos W=0.205u L=0.04u
M7625 n3474 U4300/net19 U4300/net26 VDD pmos W=0.325u L=0.04u
M7626 U4300/net26 n4211 VDD VDD pmos W=0.41u L=0.04u
M7627 n3474 n4201 U4300/net30 VDD pmos W=0.325u L=0.04u
M7628 U4300/net30 g719 VDD VDD pmos W=0.205u L=0.04u
M7629 U4301/net19 n4201 VSS VSS nmos W=0.155u L=0.04u
M7630 n3473 n4201 U4301/net40 VSS nmos W=0.155u L=0.04u
M7631 n3473 U4301/net19 U4301/net36 VSS nmos W=0.155u L=0.04u
M7632 U4301/net40 n4200 VSS VSS nmos W=0.31u L=0.04u
M7633 U4301/net36 g722 VSS VSS nmos W=0.155u L=0.04u
M7634 U4301/net19 n4201 VDD VDD pmos W=0.205u L=0.04u
M7635 n3473 U4301/net19 U4301/net26 VDD pmos W=0.325u L=0.04u
M7636 U4301/net26 n4200 VDD VDD pmos W=0.41u L=0.04u
M7637 n3473 n4201 U4301/net30 VDD pmos W=0.325u L=0.04u
M7638 U4301/net30 g722 VDD VDD pmos W=0.205u L=0.04u
M7639 n4201 n4212 VSS VSS nmos W=0.155u L=0.04u
M7640 n4201 n4180 VSS VSS nmos W=0.155u L=0.04u
M7641 U4302/XI1-net8 n4180 VDD VDD pmos W=0.205u L=0.04u
M7642 n4201 n4212 U4302/XI1-net8 VDD pmos W=0.205u L=0.04u
M7643 U4303/net19 n4203 VSS VSS nmos W=0.155u L=0.04u
M7644 n3472 n4203 U4303/net40 VSS nmos W=0.155u L=0.04u
M7645 n3472 U4303/net19 U4303/net36 VSS nmos W=0.155u L=0.04u
M7646 U4303/net40 n4206 VSS VSS nmos W=0.31u L=0.04u
M7647 U4303/net36 g700 VSS VSS nmos W=0.155u L=0.04u
M7648 U4303/net19 n4203 VDD VDD pmos W=0.205u L=0.04u
M7649 n3472 U4303/net19 U4303/net26 VDD pmos W=0.325u L=0.04u
M7650 U4303/net26 n4206 VDD VDD pmos W=0.41u L=0.04u
M7651 n3472 n4203 U4303/net30 VDD pmos W=0.325u L=0.04u
M7652 U4303/net30 g700 VDD VDD pmos W=0.205u L=0.04u
M7653 U4304/net19 n4203 VSS VSS nmos W=0.155u L=0.04u
M7654 n3471 n4203 U4304/net40 VSS nmos W=0.155u L=0.04u
M7655 n3471 U4304/net19 U4304/net36 VSS nmos W=0.155u L=0.04u
M7656 U4304/net40 n4198 VSS VSS nmos W=0.31u L=0.04u
M7657 U4304/net36 g727 VSS VSS nmos W=0.155u L=0.04u
M7658 U4304/net19 n4203 VDD VDD pmos W=0.205u L=0.04u
M7659 n3471 U4304/net19 U4304/net26 VDD pmos W=0.325u L=0.04u
M7660 U4304/net26 n4198 VDD VDD pmos W=0.41u L=0.04u
M7661 n3471 n4203 U4304/net30 VDD pmos W=0.325u L=0.04u
M7662 U4304/net30 g727 VDD VDD pmos W=0.205u L=0.04u
M7663 U4305/net19 n4204 VSS VSS nmos W=0.155u L=0.04u
M7664 n3470 n4204 U4305/net40 VSS nmos W=0.155u L=0.04u
M7665 n3470 U4305/net19 U4305/net36 VSS nmos W=0.155u L=0.04u
M7666 U4305/net40 n4206 VSS VSS nmos W=0.31u L=0.04u
M7667 U4305/net36 g699 VSS VSS nmos W=0.155u L=0.04u
M7668 U4305/net19 n4204 VDD VDD pmos W=0.205u L=0.04u
M7669 n3470 U4305/net19 U4305/net26 VDD pmos W=0.325u L=0.04u
M7670 U4305/net26 n4206 VDD VDD pmos W=0.41u L=0.04u
M7671 n3470 n4204 U4305/net30 VDD pmos W=0.325u L=0.04u
M7672 U4305/net30 g699 VDD VDD pmos W=0.205u L=0.04u
M7673 U4306/net19 n4203 VSS VSS nmos W=0.155u L=0.04u
M7674 n3469 n4203 U4306/net40 VSS nmos W=0.155u L=0.04u
M7675 n3469 U4306/net19 U4306/net36 VSS nmos W=0.155u L=0.04u
M7676 U4306/net40 n4184 VSS VSS nmos W=0.31u L=0.04u
M7677 U4306/net36 g703 VSS VSS nmos W=0.155u L=0.04u
M7678 U4306/net19 n4203 VDD VDD pmos W=0.205u L=0.04u
M7679 n3469 U4306/net19 U4306/net26 VDD pmos W=0.325u L=0.04u
M7680 U4306/net26 n4184 VDD VDD pmos W=0.41u L=0.04u
M7681 n3469 n4203 U4306/net30 VDD pmos W=0.325u L=0.04u
M7682 U4306/net30 g703 VDD VDD pmos W=0.205u L=0.04u
M7683 U4307/net19 n4204 VSS VSS nmos W=0.155u L=0.04u
M7684 n3468 n4204 U4307/net40 VSS nmos W=0.155u L=0.04u
M7685 n3468 U4307/net19 U4307/net36 VSS nmos W=0.155u L=0.04u
M7686 U4307/net40 n4198 VSS VSS nmos W=0.31u L=0.04u
M7687 U4307/net36 g726 VSS VSS nmos W=0.155u L=0.04u
M7688 U4307/net19 n4204 VDD VDD pmos W=0.205u L=0.04u
M7689 n3468 U4307/net19 U4307/net26 VDD pmos W=0.325u L=0.04u
M7690 U4307/net26 n4198 VDD VDD pmos W=0.41u L=0.04u
M7691 n3468 n4204 U4307/net30 VDD pmos W=0.325u L=0.04u
M7692 U4307/net30 g726 VDD VDD pmos W=0.205u L=0.04u
M7693 n4198 g692 VSS VSS nmos W=0.135u L=0.04u
M7694 n4198 g692 VDD VDD pmos W=0.205u L=0.04u
M7695 U4309/net19 n4204 VSS VSS nmos W=0.155u L=0.04u
M7696 n3467 n4204 U4309/net40 VSS nmos W=0.155u L=0.04u
M7697 n3467 U4309/net19 U4309/net36 VSS nmos W=0.155u L=0.04u
M7698 U4309/net40 n4184 VSS VSS nmos W=0.31u L=0.04u
M7699 U4309/net36 g702 VSS VSS nmos W=0.155u L=0.04u
M7700 U4309/net19 n4204 VDD VDD pmos W=0.205u L=0.04u
M7701 n3467 U4309/net19 U4309/net26 VDD pmos W=0.325u L=0.04u
M7702 U4309/net26 n4184 VDD VDD pmos W=0.41u L=0.04u
M7703 n3467 n4204 U4309/net30 VDD pmos W=0.325u L=0.04u
M7704 U4309/net30 g702 VDD VDD pmos W=0.205u L=0.04u
M7705 n4184 g633 VSS VSS nmos W=0.135u L=0.04u
M7706 n4184 g633 VDD VDD pmos W=0.205u L=0.04u
M7707 U4311/net19 n4203 VSS VSS nmos W=0.155u L=0.04u
M7708 n3466 n4203 U4311/net40 VSS nmos W=0.155u L=0.04u
M7709 n3466 U4311/net19 U4311/net36 VSS nmos W=0.155u L=0.04u
M7710 U4311/net40 n4207 VSS VSS nmos W=0.31u L=0.04u
M7711 U4311/net36 g706 VSS VSS nmos W=0.155u L=0.04u
M7712 U4311/net19 n4203 VDD VDD pmos W=0.205u L=0.04u
M7713 n3466 U4311/net19 U4311/net26 VDD pmos W=0.325u L=0.04u
M7714 U4311/net26 n4207 VDD VDD pmos W=0.41u L=0.04u
M7715 n3466 n4203 U4311/net30 VDD pmos W=0.325u L=0.04u
M7716 U4311/net30 g706 VDD VDD pmos W=0.205u L=0.04u
M7717 U4312/net19 n4204 VSS VSS nmos W=0.155u L=0.04u
M7718 n3465 n4204 U4312/net40 VSS nmos W=0.155u L=0.04u
M7719 n3465 U4312/net19 U4312/net36 VSS nmos W=0.155u L=0.04u
M7720 U4312/net40 n4207 VSS VSS nmos W=0.31u L=0.04u
M7721 U4312/net36 g705 VSS VSS nmos W=0.155u L=0.04u
M7722 U4312/net19 n4204 VDD VDD pmos W=0.205u L=0.04u
M7723 n3465 U4312/net19 U4312/net26 VDD pmos W=0.325u L=0.04u
M7724 U4312/net26 n4207 VDD VDD pmos W=0.41u L=0.04u
M7725 n3465 n4204 U4312/net30 VDD pmos W=0.325u L=0.04u
M7726 U4312/net30 g705 VDD VDD pmos W=0.205u L=0.04u
M7727 n4207 g653 VSS VSS nmos W=0.135u L=0.04u
M7728 n4207 g653 VDD VDD pmos W=0.205u L=0.04u
M7729 U4314/net19 n4203 VSS VSS nmos W=0.155u L=0.04u
M7730 n3464 n4203 U4314/net40 VSS nmos W=0.155u L=0.04u
M7731 n3464 U4314/net19 U4314/net36 VSS nmos W=0.155u L=0.04u
M7732 U4314/net40 n4188 VSS VSS nmos W=0.31u L=0.04u
M7733 U4314/net36 g709 VSS VSS nmos W=0.155u L=0.04u
M7734 U4314/net19 n4203 VDD VDD pmos W=0.205u L=0.04u
M7735 n3464 U4314/net19 U4314/net26 VDD pmos W=0.325u L=0.04u
M7736 U4314/net26 n4188 VDD VDD pmos W=0.41u L=0.04u
M7737 n3464 n4203 U4314/net30 VDD pmos W=0.325u L=0.04u
M7738 U4314/net30 g709 VDD VDD pmos W=0.205u L=0.04u
M7739 U4315/net19 n4204 VSS VSS nmos W=0.155u L=0.04u
M7740 n3463 n4204 U4315/net40 VSS nmos W=0.155u L=0.04u
M7741 n3463 U4315/net19 U4315/net36 VSS nmos W=0.155u L=0.04u
M7742 U4315/net40 n4188 VSS VSS nmos W=0.31u L=0.04u
M7743 U4315/net36 g708 VSS VSS nmos W=0.155u L=0.04u
M7744 U4315/net19 n4204 VDD VDD pmos W=0.205u L=0.04u
M7745 n3463 U4315/net19 U4315/net26 VDD pmos W=0.325u L=0.04u
M7746 U4315/net26 n4188 VDD VDD pmos W=0.41u L=0.04u
M7747 n3463 n4204 U4315/net30 VDD pmos W=0.325u L=0.04u
M7748 U4315/net30 g708 VDD VDD pmos W=0.205u L=0.04u
M7749 n4188 g646 VSS VSS nmos W=0.135u L=0.04u
M7750 n4188 g646 VDD VDD pmos W=0.205u L=0.04u
M7751 U4317/net19 n4203 VSS VSS nmos W=0.155u L=0.04u
M7752 n3462 n4203 U4317/net40 VSS nmos W=0.155u L=0.04u
M7753 n3462 U4317/net19 U4317/net36 VSS nmos W=0.155u L=0.04u
M7754 U4317/net40 n4208 VSS VSS nmos W=0.31u L=0.04u
M7755 U4317/net36 g712 VSS VSS nmos W=0.155u L=0.04u
M7756 U4317/net19 n4203 VDD VDD pmos W=0.205u L=0.04u
M7757 n3462 U4317/net19 U4317/net26 VDD pmos W=0.325u L=0.04u
M7758 U4317/net26 n4208 VDD VDD pmos W=0.41u L=0.04u
M7759 n3462 n4203 U4317/net30 VDD pmos W=0.325u L=0.04u
M7760 U4317/net30 g712 VDD VDD pmos W=0.205u L=0.04u
M7761 U4318/net19 n4204 VSS VSS nmos W=0.155u L=0.04u
M7762 n3461 n4204 U4318/net40 VSS nmos W=0.155u L=0.04u
M7763 n3461 U4318/net19 U4318/net36 VSS nmos W=0.155u L=0.04u
M7764 U4318/net40 n4208 VSS VSS nmos W=0.31u L=0.04u
M7765 U4318/net36 g711 VSS VSS nmos W=0.155u L=0.04u
M7766 U4318/net19 n4204 VDD VDD pmos W=0.205u L=0.04u
M7767 n3461 U4318/net19 U4318/net26 VDD pmos W=0.325u L=0.04u
M7768 U4318/net26 n4208 VDD VDD pmos W=0.41u L=0.04u
M7769 n3461 n4204 U4318/net30 VDD pmos W=0.325u L=0.04u
M7770 U4318/net30 g711 VDD VDD pmos W=0.205u L=0.04u
M7771 n4208 g660 VSS VSS nmos W=0.135u L=0.04u
M7772 n4208 g660 VDD VDD pmos W=0.205u L=0.04u
M7773 U4320/net19 n4203 VSS VSS nmos W=0.155u L=0.04u
M7774 n3460 n4203 U4320/net40 VSS nmos W=0.155u L=0.04u
M7775 n3460 U4320/net19 U4320/net36 VSS nmos W=0.155u L=0.04u
M7776 U4320/net40 n4191 VSS VSS nmos W=0.31u L=0.04u
M7777 U4320/net36 g715 VSS VSS nmos W=0.155u L=0.04u
M7778 U4320/net19 n4203 VDD VDD pmos W=0.205u L=0.04u
M7779 n3460 U4320/net19 U4320/net26 VDD pmos W=0.325u L=0.04u
M7780 U4320/net26 n4191 VDD VDD pmos W=0.41u L=0.04u
M7781 n3460 n4203 U4320/net30 VDD pmos W=0.325u L=0.04u
M7782 U4320/net30 g715 VDD VDD pmos W=0.205u L=0.04u
M7783 U4321/net19 n4204 VSS VSS nmos W=0.155u L=0.04u
M7784 n3459 n4204 U4321/net40 VSS nmos W=0.155u L=0.04u
M7785 n3459 U4321/net19 U4321/net36 VSS nmos W=0.155u L=0.04u
M7786 U4321/net40 n4191 VSS VSS nmos W=0.31u L=0.04u
M7787 U4321/net36 g714 VSS VSS nmos W=0.155u L=0.04u
M7788 U4321/net19 n4204 VDD VDD pmos W=0.205u L=0.04u
M7789 n3459 U4321/net19 U4321/net26 VDD pmos W=0.325u L=0.04u
M7790 U4321/net26 n4191 VDD VDD pmos W=0.41u L=0.04u
M7791 n3459 n4204 U4321/net30 VDD pmos W=0.325u L=0.04u
M7792 U4321/net30 g714 VDD VDD pmos W=0.205u L=0.04u
M7793 U4322/net19 n4203 VSS VSS nmos W=0.155u L=0.04u
M7794 n3458 n4203 U4322/net40 VSS nmos W=0.155u L=0.04u
M7795 n3458 U4322/net19 U4322/net36 VSS nmos W=0.155u L=0.04u
M7796 U4322/net40 n4209 VSS VSS nmos W=0.31u L=0.04u
M7797 U4322/net36 g718 VSS VSS nmos W=0.155u L=0.04u
M7798 U4322/net19 n4203 VDD VDD pmos W=0.205u L=0.04u
M7799 n3458 U4322/net19 U4322/net26 VDD pmos W=0.325u L=0.04u
M7800 U4322/net26 n4209 VDD VDD pmos W=0.41u L=0.04u
M7801 n3458 n4203 U4322/net30 VDD pmos W=0.325u L=0.04u
M7802 U4322/net30 g718 VDD VDD pmos W=0.205u L=0.04u
M7803 U4323/net19 n4203 VSS VSS nmos W=0.155u L=0.04u
M7804 n3457 n4203 U4323/net40 VSS nmos W=0.155u L=0.04u
M7805 n3457 U4323/net19 U4323/net36 VSS nmos W=0.155u L=0.04u
M7806 U4323/net40 n4210 VSS VSS nmos W=0.31u L=0.04u
M7807 U4323/net36 g736 VSS VSS nmos W=0.155u L=0.04u
M7808 U4323/net19 n4203 VDD VDD pmos W=0.205u L=0.04u
M7809 n3457 U4323/net19 U4323/net26 VDD pmos W=0.325u L=0.04u
M7810 U4323/net26 n4210 VDD VDD pmos W=0.41u L=0.04u
M7811 n3457 n4203 U4323/net30 VDD pmos W=0.325u L=0.04u
M7812 U4323/net30 g736 VDD VDD pmos W=0.205u L=0.04u
M7813 U4324/net19 n4204 VSS VSS nmos W=0.155u L=0.04u
M7814 n3456 n4204 U4324/net40 VSS nmos W=0.155u L=0.04u
M7815 n3456 U4324/net19 U4324/net36 VSS nmos W=0.155u L=0.04u
M7816 U4324/net40 n4209 VSS VSS nmos W=0.31u L=0.04u
M7817 U4324/net36 g717 VSS VSS nmos W=0.155u L=0.04u
M7818 U4324/net19 n4204 VDD VDD pmos W=0.205u L=0.04u
M7819 n3456 U4324/net19 U4324/net26 VDD pmos W=0.325u L=0.04u
M7820 U4324/net26 n4209 VDD VDD pmos W=0.41u L=0.04u
M7821 n3456 n4204 U4324/net30 VDD pmos W=0.325u L=0.04u
M7822 U4324/net30 g717 VDD VDD pmos W=0.205u L=0.04u
M7823 U4325/net19 n4203 VSS VSS nmos W=0.155u L=0.04u
M7824 n3455 n4203 U4325/net40 VSS nmos W=0.155u L=0.04u
M7825 n3455 U4325/net19 U4325/net36 VSS nmos W=0.155u L=0.04u
M7826 U4325/net40 n4211 VSS VSS nmos W=0.31u L=0.04u
M7827 U4325/net36 g721 VSS VSS nmos W=0.155u L=0.04u
M7828 U4325/net19 n4203 VDD VDD pmos W=0.205u L=0.04u
M7829 n3455 U4325/net19 U4325/net26 VDD pmos W=0.325u L=0.04u
M7830 U4325/net26 n4211 VDD VDD pmos W=0.41u L=0.04u
M7831 n3455 n4203 U4325/net30 VDD pmos W=0.325u L=0.04u
M7832 U4325/net30 g721 VDD VDD pmos W=0.205u L=0.04u
M7833 U4326/net19 n4204 VSS VSS nmos W=0.155u L=0.04u
M7834 n3454 n4204 U4326/net40 VSS nmos W=0.155u L=0.04u
M7835 n3454 U4326/net19 U4326/net36 VSS nmos W=0.155u L=0.04u
M7836 U4326/net40 n4210 VSS VSS nmos W=0.31u L=0.04u
M7837 U4326/net36 g735 VSS VSS nmos W=0.155u L=0.04u
M7838 U4326/net19 n4204 VDD VDD pmos W=0.205u L=0.04u
M7839 n3454 U4326/net19 U4326/net26 VDD pmos W=0.325u L=0.04u
M7840 U4326/net26 n4210 VDD VDD pmos W=0.41u L=0.04u
M7841 n3454 n4204 U4326/net30 VDD pmos W=0.325u L=0.04u
M7842 U4326/net30 g735 VDD VDD pmos W=0.205u L=0.04u
M7843 U4327/net36 n4214 U4327/net24 VSS nmos W=0.155u L=0.04u
M7844 U4327/net24 n4215 VSS VSS nmos W=0.155u L=0.04u
M7845 U4327/net33 g729 U4327/net36 VSS nmos W=0.155u L=0.04u
M7846 U4327/net33 n4213 U4327/net36 VSS nmos W=0.155u L=0.04u
M7847 n4210 U4327/net33 VSS VSS nmos W=0.155u L=0.04u
M7848 n4210 U4327/net33 VDD VDD pmos W=0.205u L=0.04u
M7849 U4327/net33 n4213 U4327/net35 VDD pmos W=0.205u L=0.04u
M7850 U4327/net35 g729 VDD VDD pmos W=0.205u L=0.04u
M7851 U4327/net33 n4215 VDD VDD pmos W=0.205u L=0.04u
M7852 U4327/net33 n4214 VDD VDD pmos W=0.205u L=0.04u
M7853 n4215 g629 U4328/XI21-net17 VSS nmos W=0.155u L=0.04u
M7854 U4328/XI21-net17 n4219 VSS VSS nmos W=0.155u L=0.04u
M7855 n4215 n4216 U4328/XI6-net17 VSS nmos W=0.155u L=0.04u
M7856 U4328/XI6-net17 n4217 VSS VSS nmos W=0.155u L=0.04u
M7857 n4215 g6911 U4328/XI20-net17 VSS nmos W=0.155u L=0.04u
M7858 U4328/XI20-net17 n4218 VSS VSS nmos W=0.155u L=0.04u
M7859 VDD g629 U4328/net22 VDD pmos W=0.205u L=0.04u
M7860 VDD n4219 U4328/net22 VDD pmos W=0.205u L=0.04u
M7861 U4328/net16 n4216 n4215 VDD pmos W=0.205u L=0.04u
M7862 U4328/net16 n4217 n4215 VDD pmos W=0.205u L=0.04u
M7863 U4328/net22 g6911 U4328/net16 VDD pmos W=0.205u L=0.04u
M7864 U4328/net22 n4218 U4328/net16 VDD pmos W=0.205u L=0.04u
M7865 n4219 g728 VSS VSS nmos W=0.135u L=0.04u
M7866 n4219 g728 VDD VDD pmos W=0.205u L=0.04u
M7867 n4218 g730 VSS VSS nmos W=0.135u L=0.04u
M7868 n4218 g730 VDD VDD pmos W=0.205u L=0.04u
M7869 n4217 n4223 VSS VSS nmos W=0.155u L=0.04u
M7870 n4217 n4222 VSS VSS nmos W=0.155u L=0.04u
M7871 n4217 n4221 VSS VSS nmos W=0.155u L=0.04u
M7872 n4217 n4220 VSS VSS nmos W=0.155u L=0.04u
M7873 U4331/net49 n4222 U4331/net52 VDD pmos W=0.41u L=0.04u
M7874 U4331/net52 n4223 VDD VDD pmos W=0.41u L=0.04u
M7875 U4331/net46 n4221 U4331/net49 VDD pmos W=0.41u L=0.04u
M7876 n4217 n4220 U4331/net46 VDD pmos W=0.41u L=0.04u
M7877 U4332/net4 n4224 U4332/net14 VSS nmos W=0.155u L=0.04u
M7878 U4332/net6 U4332/net10 U4332/net14 VSS nmos W=0.17u L=0.04u
M7879 U4332/net4 g686 VSS VSS nmos W=0.155u L=0.04u
M7880 U4332/net6 U4332/net4 VSS VSS nmos W=0.17u L=0.04u
M7881 n4223 U4332/net14 VSS VSS nmos W=0.155u L=0.04u
M7882 U4332/net10 n4224 VSS VSS nmos W=0.155u L=0.04u
M7883 U4332/net4 U4332/net10 U4332/net14 VDD pmos W=0.255u L=0.04u
M7884 U4332/net6 n4224 U4332/net14 VDD pmos W=0.28u L=0.04u
M7885 U4332/net4 g686 VDD VDD pmos W=0.205u L=0.04u
M7886 U4332/net6 U4332/net4 VDD VDD pmos W=0.24u L=0.04u
M7887 n4223 U4332/net14 VDD VDD pmos W=0.205u L=0.04u
M7888 U4332/net10 n4224 VDD VDD pmos W=0.205u L=0.04u
M7889 U4333/net4 n4225 U4333/net14 VSS nmos W=0.155u L=0.04u
M7890 U4333/net6 U4333/net10 U4333/net14 VSS nmos W=0.17u L=0.04u
M7891 U4333/net4 g692 VSS VSS nmos W=0.155u L=0.04u
M7892 U4333/net6 U4333/net4 VSS VSS nmos W=0.17u L=0.04u
M7893 n4222 U4333/net14 VSS VSS nmos W=0.155u L=0.04u
M7894 U4333/net10 n4225 VSS VSS nmos W=0.155u L=0.04u
M7895 U4333/net4 U4333/net10 U4333/net14 VDD pmos W=0.255u L=0.04u
M7896 U4333/net6 n4225 U4333/net14 VDD pmos W=0.28u L=0.04u
M7897 U4333/net4 g692 VDD VDD pmos W=0.205u L=0.04u
M7898 U4333/net6 U4333/net4 VDD VDD pmos W=0.24u L=0.04u
M7899 n4222 U4333/net14 VDD VDD pmos W=0.205u L=0.04u
M7900 U4333/net10 n4225 VDD VDD pmos W=0.205u L=0.04u
M7901 U4334/net4 n4226 U4334/net14 VSS nmos W=0.155u L=0.04u
M7902 U4334/net6 U4334/net10 U4334/net14 VSS nmos W=0.17u L=0.04u
M7903 U4334/net4 g653 VSS VSS nmos W=0.155u L=0.04u
M7904 U4334/net6 U4334/net4 VSS VSS nmos W=0.17u L=0.04u
M7905 n4221 U4334/net14 VSS VSS nmos W=0.155u L=0.04u
M7906 U4334/net10 n4226 VSS VSS nmos W=0.155u L=0.04u
M7907 U4334/net4 U4334/net10 U4334/net14 VDD pmos W=0.255u L=0.04u
M7908 U4334/net6 n4226 U4334/net14 VDD pmos W=0.28u L=0.04u
M7909 U4334/net4 g653 VDD VDD pmos W=0.205u L=0.04u
M7910 U4334/net6 U4334/net4 VDD VDD pmos W=0.24u L=0.04u
M7911 n4221 U4334/net14 VDD VDD pmos W=0.205u L=0.04u
M7912 U4334/net10 n4226 VDD VDD pmos W=0.205u L=0.04u
M7913 U4335/XU1-net6 n4228 VSS VSS nmos W=0.155u L=0.04u
M7914 n4220 n4227 U4335/XU1-net6 VSS nmos W=0.155u L=0.04u
M7915 n4220 n4228 VDD VDD pmos W=0.155u L=0.04u
M7916 n4220 n4227 VDD VDD pmos W=0.155u L=0.04u
M7917 U4336/net4 g633 U4336/net14 VSS nmos W=0.155u L=0.04u
M7918 U4336/net6 U4336/net10 U4336/net14 VSS nmos W=0.17u L=0.04u
M7919 U4336/net4 n4229 VSS VSS nmos W=0.155u L=0.04u
M7920 U4336/net6 U4336/net4 VSS VSS nmos W=0.17u L=0.04u
M7921 n4228 U4336/net14 VSS VSS nmos W=0.155u L=0.04u
M7922 U4336/net10 g633 VSS VSS nmos W=0.155u L=0.04u
M7923 U4336/net4 U4336/net10 U4336/net14 VDD pmos W=0.255u L=0.04u
M7924 U4336/net6 g633 U4336/net14 VDD pmos W=0.28u L=0.04u
M7925 U4336/net4 n4229 VDD VDD pmos W=0.205u L=0.04u
M7926 U4336/net6 U4336/net4 VDD VDD pmos W=0.24u L=0.04u
M7927 n4228 U4336/net14 VDD VDD pmos W=0.205u L=0.04u
M7928 U4336/net10 g633 VDD VDD pmos W=0.205u L=0.04u
M7929 U4337/net4 g646 U4337/net14 VSS nmos W=0.155u L=0.04u
M7930 U4337/net6 U4337/net10 U4337/net14 VSS nmos W=0.17u L=0.04u
M7931 U4337/net4 n4230 VSS VSS nmos W=0.155u L=0.04u
M7932 U4337/net6 U4337/net4 VSS VSS nmos W=0.17u L=0.04u
M7933 n4227 U4337/net14 VSS VSS nmos W=0.155u L=0.04u
M7934 U4337/net10 g646 VSS VSS nmos W=0.155u L=0.04u
M7935 U4337/net4 U4337/net10 U4337/net14 VDD pmos W=0.255u L=0.04u
M7936 U4337/net6 g646 U4337/net14 VDD pmos W=0.28u L=0.04u
M7937 U4337/net4 n4230 VDD VDD pmos W=0.205u L=0.04u
M7938 U4337/net6 U4337/net4 VDD VDD pmos W=0.24u L=0.04u
M7939 n4227 U4337/net14 VDD VDD pmos W=0.205u L=0.04u
M7940 U4337/net10 g646 VDD VDD pmos W=0.205u L=0.04u
M7941 n4216 n4234 VSS VSS nmos W=0.155u L=0.04u
M7942 n4216 n4233 VSS VSS nmos W=0.155u L=0.04u
M7943 n4216 n4232 VSS VSS nmos W=0.155u L=0.04u
M7944 n4216 n4231 VSS VSS nmos W=0.155u L=0.04u
M7945 U4338/net49 n4233 U4338/net52 VDD pmos W=0.41u L=0.04u
M7946 U4338/net52 n4234 VDD VDD pmos W=0.41u L=0.04u
M7947 U4338/net46 n4232 U4338/net49 VDD pmos W=0.41u L=0.04u
M7948 n4216 n4231 U4338/net46 VDD pmos W=0.41u L=0.04u
M7949 U4339/net4 n4235 U4339/net14 VSS nmos W=0.155u L=0.04u
M7950 U4339/net6 U4339/net10 U4339/net14 VSS nmos W=0.17u L=0.04u
M7951 U4339/net4 n4209 VSS VSS nmos W=0.155u L=0.04u
M7952 U4339/net6 U4339/net4 VSS VSS nmos W=0.17u L=0.04u
M7953 n4234 U4339/net14 VSS VSS nmos W=0.155u L=0.04u
M7954 U4339/net10 n4235 VSS VSS nmos W=0.155u L=0.04u
M7955 U4339/net4 U4339/net10 U4339/net14 VDD pmos W=0.255u L=0.04u
M7956 U4339/net6 n4235 U4339/net14 VDD pmos W=0.28u L=0.04u
M7957 U4339/net4 n4209 VDD VDD pmos W=0.205u L=0.04u
M7958 U4339/net6 U4339/net4 VDD VDD pmos W=0.24u L=0.04u
M7959 n4234 U4339/net14 VDD VDD pmos W=0.205u L=0.04u
M7960 U4339/net10 n4235 VDD VDD pmos W=0.205u L=0.04u
M7961 n4209 g666 VSS VSS nmos W=0.135u L=0.04u
M7962 n4209 g666 VDD VDD pmos W=0.205u L=0.04u
M7963 U4341/net4 n4236 U4341/net14 VSS nmos W=0.155u L=0.04u
M7964 U4341/net6 U4341/net10 U4341/net14 VSS nmos W=0.17u L=0.04u
M7965 U4341/net4 n4211 VSS VSS nmos W=0.155u L=0.04u
M7966 U4341/net6 U4341/net4 VSS VSS nmos W=0.17u L=0.04u
M7967 n4233 U4341/net14 VSS VSS nmos W=0.155u L=0.04u
M7968 U4341/net10 n4236 VSS VSS nmos W=0.155u L=0.04u
M7969 U4341/net4 U4341/net10 U4341/net14 VDD pmos W=0.255u L=0.04u
M7970 U4341/net6 n4236 U4341/net14 VDD pmos W=0.28u L=0.04u
M7971 U4341/net4 n4211 VDD VDD pmos W=0.205u L=0.04u
M7972 U4341/net6 U4341/net4 VDD VDD pmos W=0.24u L=0.04u
M7973 n4233 U4341/net14 VDD VDD pmos W=0.205u L=0.04u
M7974 U4341/net10 n4236 VDD VDD pmos W=0.205u L=0.04u
M7975 U4342/net4 n4237 U4342/net14 VSS nmos W=0.155u L=0.04u
M7976 U4342/net6 U4342/net10 U4342/net14 VSS nmos W=0.17u L=0.04u
M7977 U4342/net4 g660 VSS VSS nmos W=0.155u L=0.04u
M7978 U4342/net6 U4342/net4 VSS VSS nmos W=0.17u L=0.04u
M7979 n4232 U4342/net14 VSS VSS nmos W=0.155u L=0.04u
M7980 U4342/net10 n4237 VSS VSS nmos W=0.155u L=0.04u
M7981 U4342/net4 U4342/net10 U4342/net14 VDD pmos W=0.255u L=0.04u
M7982 U4342/net6 n4237 U4342/net14 VDD pmos W=0.28u L=0.04u
M7983 U4342/net4 g660 VDD VDD pmos W=0.205u L=0.04u
M7984 U4342/net6 U4342/net4 VDD VDD pmos W=0.24u L=0.04u
M7985 n4232 U4342/net14 VDD VDD pmos W=0.205u L=0.04u
M7986 U4342/net10 n4237 VDD VDD pmos W=0.205u L=0.04u
M7987 U4343/XU1-net6 n4239 VSS VSS nmos W=0.155u L=0.04u
M7988 n4231 n4238 U4343/XU1-net6 VSS nmos W=0.155u L=0.04u
M7989 n4231 n4239 VDD VDD pmos W=0.155u L=0.04u
M7990 n4231 n4238 VDD VDD pmos W=0.155u L=0.04u
M7991 U4344/net4 n4206 U4344/net14 VSS nmos W=0.155u L=0.04u
M7992 U4344/net6 U4344/net10 U4344/net14 VSS nmos W=0.17u L=0.04u
M7993 U4344/net4 n4240 VSS VSS nmos W=0.155u L=0.04u
M7994 U4344/net6 U4344/net4 VSS VSS nmos W=0.17u L=0.04u
M7995 n4239 U4344/net14 VSS VSS nmos W=0.155u L=0.04u
M7996 U4344/net10 n4206 VSS VSS nmos W=0.155u L=0.04u
M7997 U4344/net4 U4344/net10 U4344/net14 VDD pmos W=0.255u L=0.04u
M7998 U4344/net6 n4206 U4344/net14 VDD pmos W=0.28u L=0.04u
M7999 U4344/net4 n4240 VDD VDD pmos W=0.205u L=0.04u
M8000 U4344/net6 U4344/net4 VDD VDD pmos W=0.24u L=0.04u
M8001 n4239 U4344/net14 VDD VDD pmos W=0.205u L=0.04u
M8002 U4344/net10 n4206 VDD VDD pmos W=0.205u L=0.04u
M8003 n4206 g640 VSS VSS nmos W=0.135u L=0.04u
M8004 n4206 g640 VDD VDD pmos W=0.205u L=0.04u
M8005 U4346/net4 n4191 U4346/net14 VSS nmos W=0.155u L=0.04u
M8006 U4346/net6 U4346/net10 U4346/net14 VSS nmos W=0.17u L=0.04u
M8007 U4346/net4 n4241 VSS VSS nmos W=0.155u L=0.04u
M8008 U4346/net6 U4346/net4 VSS VSS nmos W=0.17u L=0.04u
M8009 n4238 U4346/net14 VSS VSS nmos W=0.155u L=0.04u
M8010 U4346/net10 n4191 VSS VSS nmos W=0.155u L=0.04u
M8011 U4346/net4 U4346/net10 U4346/net14 VDD pmos W=0.255u L=0.04u
M8012 U4346/net6 n4191 U4346/net14 VDD pmos W=0.28u L=0.04u
M8013 U4346/net4 n4241 VDD VDD pmos W=0.205u L=0.04u
M8014 U4346/net6 U4346/net4 VDD VDD pmos W=0.24u L=0.04u
M8015 n4238 U4346/net14 VDD VDD pmos W=0.205u L=0.04u
M8016 U4346/net10 n4191 VDD VDD pmos W=0.205u L=0.04u
M8017 n4191 g672 VSS VSS nmos W=0.135u L=0.04u
M8018 n4191 g672 VDD VDD pmos W=0.205u L=0.04u
M8019 n4214 n4242 VSS VSS nmos W=0.135u L=0.04u
M8020 n4214 n4242 VDD VDD pmos W=0.205u L=0.04u
M8021 U4349/net19 n4204 VSS VSS nmos W=0.155u L=0.04u
M8022 n3453 n4204 U4349/net40 VSS nmos W=0.155u L=0.04u
M8023 n3453 U4349/net19 U4349/net36 VSS nmos W=0.155u L=0.04u
M8024 U4349/net40 n4211 VSS VSS nmos W=0.31u L=0.04u
M8025 U4349/net36 g720 VSS VSS nmos W=0.155u L=0.04u
M8026 U4349/net19 n4204 VDD VDD pmos W=0.205u L=0.04u
M8027 n3453 U4349/net19 U4349/net26 VDD pmos W=0.325u L=0.04u
M8028 U4349/net26 n4211 VDD VDD pmos W=0.41u L=0.04u
M8029 n3453 n4204 U4349/net30 VDD pmos W=0.325u L=0.04u
M8030 U4349/net30 g720 VDD VDD pmos W=0.205u L=0.04u
M8031 n4211 g679 VSS VSS nmos W=0.135u L=0.04u
M8032 n4211 g679 VDD VDD pmos W=0.205u L=0.04u
M8033 U4351/net19 n4203 VSS VSS nmos W=0.155u L=0.04u
M8034 n3452 n4203 U4351/net40 VSS nmos W=0.155u L=0.04u
M8035 n3452 U4351/net19 U4351/net36 VSS nmos W=0.155u L=0.04u
M8036 U4351/net40 n4200 VSS VSS nmos W=0.31u L=0.04u
M8037 U4351/net36 g724 VSS VSS nmos W=0.155u L=0.04u
M8038 U4351/net19 n4203 VDD VDD pmos W=0.205u L=0.04u
M8039 n3452 U4351/net19 U4351/net26 VDD pmos W=0.325u L=0.04u
M8040 U4351/net26 n4200 VDD VDD pmos W=0.41u L=0.04u
M8041 n3452 n4203 U4351/net30 VDD pmos W=0.325u L=0.04u
M8042 U4351/net30 g724 VDD VDD pmos W=0.205u L=0.04u
M8043 n4203 n4212 VSS VSS nmos W=0.155u L=0.04u
M8044 n4203 n4243 VSS VSS nmos W=0.155u L=0.04u
M8045 U4352/XI1-net8 n4243 VDD VDD pmos W=0.205u L=0.04u
M8046 n4203 n4212 U4352/XI1-net8 VDD pmos W=0.205u L=0.04u
M8047 U4353/net19 n4204 VSS VSS nmos W=0.155u L=0.04u
M8048 n3451 n4204 U4353/net40 VSS nmos W=0.155u L=0.04u
M8049 n3451 U4353/net19 U4353/net36 VSS nmos W=0.155u L=0.04u
M8050 U4353/net40 n4200 VSS VSS nmos W=0.31u L=0.04u
M8051 U4353/net36 g723 VSS VSS nmos W=0.155u L=0.04u
M8052 U4353/net19 n4204 VDD VDD pmos W=0.205u L=0.04u
M8053 n3451 U4353/net19 U4353/net26 VDD pmos W=0.325u L=0.04u
M8054 U4353/net26 n4200 VDD VDD pmos W=0.41u L=0.04u
M8055 n3451 n4204 U4353/net30 VDD pmos W=0.325u L=0.04u
M8056 U4353/net30 g723 VDD VDD pmos W=0.205u L=0.04u
M8057 n4204 n4213 VSS VSS nmos W=0.155u L=0.04u
M8058 n4204 n4212 VSS VSS nmos W=0.155u L=0.04u
M8059 U4354/XI1-net8 n4212 VDD VDD pmos W=0.205u L=0.04u
M8060 n4204 n4213 U4354/XI1-net8 VDD pmos W=0.205u L=0.04u
M8061 U4355/net30 g659 VSS VSS nmos W=0.155u L=0.04u
M8062 n4212 g538 U4355/net23 VSS nmos W=0.155u L=0.04u
M8063 U4355/net20 U4355/net30 VSS VSS nmos W=0.155u L=0.04u
M8064 U4355/net23 g525 U4355/net20 VSS nmos W=0.155u L=0.04u
M8065 U4355/net30 g659 VDD VDD pmos W=0.205u L=0.04u
M8066 VDD g538 n4212 VDD pmos W=0.205u L=0.04u
M8067 VDD g525 n4212 VDD pmos W=0.205u L=0.04u
M8068 VDD U4355/net30 n4212 VDD pmos W=0.205u L=0.04u
M8069 n4200 g686 VSS VSS nmos W=0.135u L=0.04u
M8070 n4200 g686 VDD VDD pmos W=0.205u L=0.04u
M8071 U4357/net19 n4180 VSS VSS nmos W=0.155u L=0.04u
M8072 n3450 n4180 U4357/net40 VSS nmos W=0.155u L=0.04u
M8073 n3450 U4357/net19 U4357/net36 VSS nmos W=0.155u L=0.04u
M8074 U4357/net40 g630 VSS VSS nmos W=0.31u L=0.04u
M8075 U4357/net36 g510 VSS VSS nmos W=0.155u L=0.04u
M8076 U4357/net19 n4180 VDD VDD pmos W=0.205u L=0.04u
M8077 n3450 U4357/net19 U4357/net26 VDD pmos W=0.325u L=0.04u
M8078 U4357/net26 g630 VDD VDD pmos W=0.41u L=0.04u
M8079 n3450 n4180 U4357/net30 VDD pmos W=0.325u L=0.04u
M8080 U4357/net30 g510 VDD VDD pmos W=0.205u L=0.04u
M8081 U4358/net19 n4244 VSS VSS nmos W=0.155u L=0.04u
M8082 n3449 n4244 U4358/net40 VSS nmos W=0.155u L=0.04u
M8083 n3449 U4358/net19 U4358/net36 VSS nmos W=0.155u L=0.04u
M8084 U4358/net40 g554 VSS VSS nmos W=0.31u L=0.04u
M8085 U4358/net36 n3917 VSS VSS nmos W=0.155u L=0.04u
M8086 U4358/net19 n4244 VDD VDD pmos W=0.205u L=0.04u
M8087 n3449 U4358/net19 U4358/net26 VDD pmos W=0.325u L=0.04u
M8088 U4358/net26 g554 VDD VDD pmos W=0.41u L=0.04u
M8089 n3449 n4244 U4358/net30 VDD pmos W=0.325u L=0.04u
M8090 U4358/net30 n3917 VDD VDD pmos W=0.205u L=0.04u
M8091 n3448 U4359/net28 VSS VSS nmos W=0.155u L=0.04u
M8092 U4359/net47 n4245 VSS VSS nmos W=0.155u L=0.04u
M8093 U4359/net28 U4359/net6 U4359/net47 VSS nmos W=0.155u L=0.04u
M8094 U4359/net44 g554 VSS VSS nmos W=0.155u L=0.04u
M8095 U4359/net28 g550 U4359/net44 VSS nmos W=0.155u L=0.04u
M8096 U4359/net6 g550 VSS VSS nmos W=0.155u L=0.04u
M8097 n3448 U4359/net28 VDD VDD pmos W=0.205u L=0.04u
M8098 VDD n4245 U4359/net47 VDD pmos W=0.205u L=0.04u
M8099 U4359/net47 g550 U4359/net28 VDD pmos W=0.205u L=0.04u
M8100 U4359/net44 U4359/net6 U4359/net28 VDD pmos W=0.205u L=0.04u
M8101 VDD g554 U4359/net44 VDD pmos W=0.205u L=0.04u
M8102 VDD g550 U4359/net6 VDD pmos W=0.205u L=0.04u
M8103 U4360/net19 n4244 VSS VSS nmos W=0.155u L=0.04u
M8104 n3447 n4244 U4360/net40 VSS nmos W=0.155u L=0.04u
M8105 n3447 U4360/net19 U4360/net36 VSS nmos W=0.155u L=0.04u
M8106 U4360/net40 g510 VSS VSS nmos W=0.31u L=0.04u
M8107 U4360/net36 g557 VSS VSS nmos W=0.155u L=0.04u
M8108 U4360/net19 n4244 VDD VDD pmos W=0.205u L=0.04u
M8109 n3447 U4360/net19 U4360/net26 VDD pmos W=0.325u L=0.04u
M8110 U4360/net26 g510 VDD VDD pmos W=0.41u L=0.04u
M8111 n3447 n4244 U4360/net30 VDD pmos W=0.325u L=0.04u
M8112 U4360/net30 g557 VDD VDD pmos W=0.205u L=0.04u
M8113 n3446 n4247 U4361/net27 VSS nmos W=0.155u L=0.04u
M8114 U4361/net39 n4249 VSS VSS nmos W=0.155u L=0.04u
M8115 U4361/net27 g2590 U4361/net39 VSS nmos W=0.155u L=0.04u
M8116 U4361/net27 n4248 U4361/net39 VSS nmos W=0.155u L=0.04u
M8117 n3446 n4246 U4361/net27 VSS nmos W=0.155u L=0.04u
M8118 U4361/net39 g2589 VSS VSS nmos W=0.155u L=0.04u
M8119 n3446 n4249 U4361/net46 VDD pmos W=0.205u L=0.04u
M8120 U4361/net46 g2589 VDD VDD pmos W=0.205u L=0.04u
M8121 n3446 n4246 U4361/net34 VDD pmos W=0.205u L=0.04u
M8122 U4361/net34 n4247 VDD VDD pmos W=0.205u L=0.04u
M8123 n3446 n4248 U4361/net37 VDD pmos W=0.205u L=0.04u
M8124 U4361/net37 g2590 VDD VDD pmos W=0.205u L=0.04u
M8125 n4246 n3445 VSS VSS nmos W=0.135u L=0.04u
M8126 n4246 n3445 VDD VDD pmos W=0.205u L=0.04u
M8127 n3445 n4251 U4363/net27 VSS nmos W=0.155u L=0.04u
M8128 U4363/net39 n4253 VSS VSS nmos W=0.155u L=0.04u
M8129 U4363/net27 g1896 U4363/net39 VSS nmos W=0.155u L=0.04u
M8130 U4363/net27 n4252 U4363/net39 VSS nmos W=0.155u L=0.04u
M8131 n3445 n4250 U4363/net27 VSS nmos W=0.155u L=0.04u
M8132 U4363/net39 g1895 VSS VSS nmos W=0.155u L=0.04u
M8133 n3445 n4253 U4363/net46 VDD pmos W=0.205u L=0.04u
M8134 U4363/net46 g1895 VDD VDD pmos W=0.205u L=0.04u
M8135 n3445 n4250 U4363/net34 VDD pmos W=0.205u L=0.04u
M8136 U4363/net34 n4251 VDD VDD pmos W=0.205u L=0.04u
M8137 n3445 n4252 U4363/net37 VDD pmos W=0.205u L=0.04u
M8138 U4363/net37 g1896 VDD VDD pmos W=0.205u L=0.04u
M8139 n4250 n3444 VSS VSS nmos W=0.135u L=0.04u
M8140 n4250 n3444 VDD VDD pmos W=0.205u L=0.04u
M8141 U4365/PG2 g1201 VSS VSS nmos W=0.31u L=0.04u
M8142 U4365/net55 n4254 VSS VSS nmos W=0.31u L=0.04u
M8143 U4365/net51 g6944 VSS VSS nmos W=0.155u L=0.04u
M8144 U4365/net53 g1202 VSS VSS nmos W=0.155u L=0.04u
M8145 U4365/net29 g1192 VSS VSS nmos W=0.155u L=0.04u
M8146 U4365/net53 U4365/net51 U4365/PG1 VSS nmos W=0.155u L=0.04u
M8147 U4365/net55 g6944 U4365/PG1 VSS nmos W=0.21u L=0.04u
M8148 U4365/PG2 g1192 n3444 VSS nmos W=0.22u L=0.04u
M8149 U4365/PG1 U4365/net29 n3444 VSS nmos W=0.155u L=0.04u
M8150 U4365/PG2 g1201 VDD VDD pmos W=0.41u L=0.04u
M8151 U4365/net55 n4254 VDD VDD pmos W=0.41u L=0.04u
M8152 U4365/net51 g6944 VDD VDD pmos W=0.205u L=0.04u
M8153 U4365/net53 g1202 VDD VDD pmos W=0.28u L=0.04u
M8154 U4365/net29 g1192 VDD VDD pmos W=0.205u L=0.04u
M8155 U4365/net53 g6944 U4365/PG1 VDD pmos W=0.27u L=0.04u
M8156 U4365/net55 U4365/net51 U4365/PG1 VDD pmos W=0.285u L=0.04u
M8157 U4365/PG2 U4365/net29 n3444 VDD pmos W=0.205u L=0.04u
M8158 U4365/PG1 g1192 n3444 VDD pmos W=0.28u L=0.04u
M8159 n4254 n3443 VSS VSS nmos W=0.135u L=0.04u
M8160 n4254 n3443 VDD VDD pmos W=0.205u L=0.04u
M8161 U4367/net29 g506 VSS VSS nmos W=0.155u L=0.04u
M8162 n3443 g515 U4367/net29 VSS nmos W=0.155u L=0.04u
M8163 n3443 g516 U4367/net23 VSS nmos W=0.155u L=0.04u
M8164 U4367/net23 n4255 VSS VSS nmos W=0.155u L=0.04u
M8165 U4367/net20 n4255 n3443 VDD pmos W=0.205u L=0.04u
M8166 U4367/net20 g516 n3443 VDD pmos W=0.205u L=0.04u
M8167 VDD g515 U4367/net20 VDD pmos W=0.205u L=0.04u
M8168 VDD g506 U4367/net20 VDD pmos W=0.205u L=0.04u
M8169 n3442 n4247 U4368/net27 VSS nmos W=0.155u L=0.04u
M8170 U4368/net39 n4249 VSS VSS nmos W=0.155u L=0.04u
M8171 U4368/net27 g2591 U4368/net39 VSS nmos W=0.155u L=0.04u
M8172 U4368/net27 n4248 U4368/net39 VSS nmos W=0.155u L=0.04u
M8173 n3442 n4256 U4368/net27 VSS nmos W=0.155u L=0.04u
M8174 U4368/net39 g2588 VSS VSS nmos W=0.155u L=0.04u
M8175 n3442 n4249 U4368/net46 VDD pmos W=0.205u L=0.04u
M8176 U4368/net46 g2588 VDD VDD pmos W=0.205u L=0.04u
M8177 n3442 n4256 U4368/net34 VDD pmos W=0.205u L=0.04u
M8178 U4368/net34 n4247 VDD VDD pmos W=0.205u L=0.04u
M8179 n3442 n4248 U4368/net37 VDD pmos W=0.205u L=0.04u
M8180 U4368/net37 g2591 VDD VDD pmos W=0.205u L=0.04u
M8181 n4256 n3441 VSS VSS nmos W=0.135u L=0.04u
M8182 n4256 n3441 VDD VDD pmos W=0.205u L=0.04u
M8183 n3441 n4251 U4370/net27 VSS nmos W=0.155u L=0.04u
M8184 U4370/net39 n4253 VSS VSS nmos W=0.155u L=0.04u
M8185 U4370/net27 g1897 U4370/net39 VSS nmos W=0.155u L=0.04u
M8186 U4370/net27 n4252 U4370/net39 VSS nmos W=0.155u L=0.04u
M8187 n3441 n4257 U4370/net27 VSS nmos W=0.155u L=0.04u
M8188 U4370/net39 g1894 VSS VSS nmos W=0.155u L=0.04u
M8189 n3441 n4253 U4370/net46 VDD pmos W=0.205u L=0.04u
M8190 U4370/net46 g1894 VDD VDD pmos W=0.205u L=0.04u
M8191 n3441 n4257 U4370/net34 VDD pmos W=0.205u L=0.04u
M8192 U4370/net34 n4251 VDD VDD pmos W=0.205u L=0.04u
M8193 n3441 n4252 U4370/net37 VDD pmos W=0.205u L=0.04u
M8194 U4370/net37 g1897 VDD VDD pmos W=0.205u L=0.04u
M8195 n4257 n3440 VSS VSS nmos W=0.135u L=0.04u
M8196 n4257 n3440 VDD VDD pmos W=0.205u L=0.04u
M8197 U4372/PG2 g1200 VSS VSS nmos W=0.31u L=0.04u
M8198 U4372/net55 n4258 VSS VSS nmos W=0.31u L=0.04u
M8199 U4372/net51 g6944 VSS VSS nmos W=0.155u L=0.04u
M8200 U4372/net53 g1203 VSS VSS nmos W=0.155u L=0.04u
M8201 U4372/net29 g1192 VSS VSS nmos W=0.155u L=0.04u
M8202 U4372/net53 U4372/net51 U4372/PG1 VSS nmos W=0.155u L=0.04u
M8203 U4372/net55 g6944 U4372/PG1 VSS nmos W=0.21u L=0.04u
M8204 U4372/PG2 g1192 n3440 VSS nmos W=0.22u L=0.04u
M8205 U4372/PG1 U4372/net29 n3440 VSS nmos W=0.155u L=0.04u
M8206 U4372/PG2 g1200 VDD VDD pmos W=0.41u L=0.04u
M8207 U4372/net55 n4258 VDD VDD pmos W=0.41u L=0.04u
M8208 U4372/net51 g6944 VDD VDD pmos W=0.205u L=0.04u
M8209 U4372/net53 g1203 VDD VDD pmos W=0.28u L=0.04u
M8210 U4372/net29 g1192 VDD VDD pmos W=0.205u L=0.04u
M8211 U4372/net53 g6944 U4372/PG1 VDD pmos W=0.27u L=0.04u
M8212 U4372/net55 U4372/net51 U4372/PG1 VDD pmos W=0.285u L=0.04u
M8213 U4372/PG2 U4372/net29 n3440 VDD pmos W=0.205u L=0.04u
M8214 U4372/PG1 g1192 n3440 VDD pmos W=0.28u L=0.04u
M8215 n4258 n3439 VSS VSS nmos W=0.135u L=0.04u
M8216 n4258 n3439 VDD VDD pmos W=0.205u L=0.04u
M8217 U4374/net29 g506 VSS VSS nmos W=0.155u L=0.04u
M8218 n3439 g514 U4374/net29 VSS nmos W=0.155u L=0.04u
M8219 n3439 g517 U4374/net23 VSS nmos W=0.155u L=0.04u
M8220 U4374/net23 n4255 VSS VSS nmos W=0.155u L=0.04u
M8221 U4374/net20 n4255 n3439 VDD pmos W=0.205u L=0.04u
M8222 U4374/net20 g517 n3439 VDD pmos W=0.205u L=0.04u
M8223 VDD g514 U4374/net20 VDD pmos W=0.205u L=0.04u
M8224 VDD g506 U4374/net20 VDD pmos W=0.205u L=0.04u
M8225 n3438 n4247 U4375/net27 VSS nmos W=0.155u L=0.04u
M8226 U4375/net39 n4249 VSS VSS nmos W=0.155u L=0.04u
M8227 U4375/net27 g2592 U4375/net39 VSS nmos W=0.155u L=0.04u
M8228 U4375/net27 n4248 U4375/net39 VSS nmos W=0.155u L=0.04u
M8229 n3438 n4259 U4375/net27 VSS nmos W=0.155u L=0.04u
M8230 U4375/net39 g2583 VSS VSS nmos W=0.155u L=0.04u
M8231 n3438 n4249 U4375/net46 VDD pmos W=0.205u L=0.04u
M8232 U4375/net46 g2583 VDD VDD pmos W=0.205u L=0.04u
M8233 n3438 n4259 U4375/net34 VDD pmos W=0.205u L=0.04u
M8234 U4375/net34 n4247 VDD VDD pmos W=0.205u L=0.04u
M8235 n3438 n4248 U4375/net37 VDD pmos W=0.205u L=0.04u
M8236 U4375/net37 g2592 VDD VDD pmos W=0.205u L=0.04u
M8237 n4259 n3437 VSS VSS nmos W=0.135u L=0.04u
M8238 n4259 n3437 VDD VDD pmos W=0.205u L=0.04u
M8239 n3437 n4251 U4377/net27 VSS nmos W=0.155u L=0.04u
M8240 U4377/net39 n4253 VSS VSS nmos W=0.155u L=0.04u
M8241 U4377/net27 g1898 U4377/net39 VSS nmos W=0.155u L=0.04u
M8242 U4377/net27 n4252 U4377/net39 VSS nmos W=0.155u L=0.04u
M8243 n3437 n4260 U4377/net27 VSS nmos W=0.155u L=0.04u
M8244 U4377/net39 g1889 VSS VSS nmos W=0.155u L=0.04u
M8245 n3437 n4253 U4377/net46 VDD pmos W=0.205u L=0.04u
M8246 U4377/net46 g1889 VDD VDD pmos W=0.205u L=0.04u
M8247 n3437 n4260 U4377/net34 VDD pmos W=0.205u L=0.04u
M8248 U4377/net34 n4251 VDD VDD pmos W=0.205u L=0.04u
M8249 n3437 n4252 U4377/net37 VDD pmos W=0.205u L=0.04u
M8250 U4377/net37 g1898 VDD VDD pmos W=0.205u L=0.04u
M8251 n4260 n3436 VSS VSS nmos W=0.135u L=0.04u
M8252 n4260 n3436 VDD VDD pmos W=0.205u L=0.04u
M8253 U4379/PG2 g1195 VSS VSS nmos W=0.31u L=0.04u
M8254 U4379/net55 n4261 VSS VSS nmos W=0.31u L=0.04u
M8255 U4379/net51 g6944 VSS VSS nmos W=0.155u L=0.04u
M8256 U4379/net53 g1204 VSS VSS nmos W=0.155u L=0.04u
M8257 U4379/net29 g1192 VSS VSS nmos W=0.155u L=0.04u
M8258 U4379/net53 U4379/net51 U4379/PG1 VSS nmos W=0.155u L=0.04u
M8259 U4379/net55 g6944 U4379/PG1 VSS nmos W=0.21u L=0.04u
M8260 U4379/PG2 g1192 n3436 VSS nmos W=0.22u L=0.04u
M8261 U4379/PG1 U4379/net29 n3436 VSS nmos W=0.155u L=0.04u
M8262 U4379/PG2 g1195 VDD VDD pmos W=0.41u L=0.04u
M8263 U4379/net55 n4261 VDD VDD pmos W=0.41u L=0.04u
M8264 U4379/net51 g6944 VDD VDD pmos W=0.205u L=0.04u
M8265 U4379/net53 g1204 VDD VDD pmos W=0.28u L=0.04u
M8266 U4379/net29 g1192 VDD VDD pmos W=0.205u L=0.04u
M8267 U4379/net53 g6944 U4379/PG1 VDD pmos W=0.27u L=0.04u
M8268 U4379/net55 U4379/net51 U4379/PG1 VDD pmos W=0.285u L=0.04u
M8269 U4379/PG2 U4379/net29 n3436 VDD pmos W=0.205u L=0.04u
M8270 U4379/PG1 g1192 n3436 VDD pmos W=0.28u L=0.04u
M8271 n4261 n3435 VSS VSS nmos W=0.135u L=0.04u
M8272 n4261 n3435 VDD VDD pmos W=0.205u L=0.04u
M8273 U4381/net29 g506 VSS VSS nmos W=0.155u L=0.04u
M8274 n3435 g509 U4381/net29 VSS nmos W=0.155u L=0.04u
M8275 n3435 g518 U4381/net23 VSS nmos W=0.155u L=0.04u
M8276 U4381/net23 n4255 VSS VSS nmos W=0.155u L=0.04u
M8277 U4381/net20 n4255 n3435 VDD pmos W=0.205u L=0.04u
M8278 U4381/net20 g518 n3435 VDD pmos W=0.205u L=0.04u
M8279 VDD g509 U4381/net20 VDD pmos W=0.205u L=0.04u
M8280 VDD g506 U4381/net20 VDD pmos W=0.205u L=0.04u
M8281 n3434 n4247 U4382/net27 VSS nmos W=0.155u L=0.04u
M8282 U4382/net39 n4249 VSS VSS nmos W=0.155u L=0.04u
M8283 U4382/net27 g2593 U4382/net39 VSS nmos W=0.155u L=0.04u
M8284 U4382/net27 n4248 U4382/net39 VSS nmos W=0.155u L=0.04u
M8285 n3434 n4262 U4382/net27 VSS nmos W=0.155u L=0.04u
M8286 U4382/net39 g2582 VSS VSS nmos W=0.155u L=0.04u
M8287 n3434 n4249 U4382/net46 VDD pmos W=0.205u L=0.04u
M8288 U4382/net46 g2582 VDD VDD pmos W=0.205u L=0.04u
M8289 n3434 n4262 U4382/net34 VDD pmos W=0.205u L=0.04u
M8290 U4382/net34 n4247 VDD VDD pmos W=0.205u L=0.04u
M8291 n3434 n4248 U4382/net37 VDD pmos W=0.205u L=0.04u
M8292 U4382/net37 g2593 VDD VDD pmos W=0.205u L=0.04u
M8293 n4262 n3433 VSS VSS nmos W=0.135u L=0.04u
M8294 n4262 n3433 VDD VDD pmos W=0.205u L=0.04u
M8295 n3433 n4251 U4384/net27 VSS nmos W=0.155u L=0.04u
M8296 U4384/net39 n4253 VSS VSS nmos W=0.155u L=0.04u
M8297 U4384/net27 g1899 U4384/net39 VSS nmos W=0.155u L=0.04u
M8298 U4384/net27 n4252 U4384/net39 VSS nmos W=0.155u L=0.04u
M8299 n3433 n4263 U4384/net27 VSS nmos W=0.155u L=0.04u
M8300 U4384/net39 g1888 VSS VSS nmos W=0.155u L=0.04u
M8301 n3433 n4253 U4384/net46 VDD pmos W=0.205u L=0.04u
M8302 U4384/net46 g1888 VDD VDD pmos W=0.205u L=0.04u
M8303 n3433 n4263 U4384/net34 VDD pmos W=0.205u L=0.04u
M8304 U4384/net34 n4251 VDD VDD pmos W=0.205u L=0.04u
M8305 n3433 n4252 U4384/net37 VDD pmos W=0.205u L=0.04u
M8306 U4384/net37 g1899 VDD VDD pmos W=0.205u L=0.04u
M8307 n4263 n3432 VSS VSS nmos W=0.135u L=0.04u
M8308 n4263 n3432 VDD VDD pmos W=0.205u L=0.04u
M8309 U4386/PG2 g1194 VSS VSS nmos W=0.31u L=0.04u
M8310 U4386/net55 n4264 VSS VSS nmos W=0.31u L=0.04u
M8311 U4386/net51 g6944 VSS VSS nmos W=0.155u L=0.04u
M8312 U4386/net53 g1205 VSS VSS nmos W=0.155u L=0.04u
M8313 U4386/net29 g1192 VSS VSS nmos W=0.155u L=0.04u
M8314 U4386/net53 U4386/net51 U4386/PG1 VSS nmos W=0.155u L=0.04u
M8315 U4386/net55 g6944 U4386/PG1 VSS nmos W=0.21u L=0.04u
M8316 U4386/PG2 g1192 n3432 VSS nmos W=0.22u L=0.04u
M8317 U4386/PG1 U4386/net29 n3432 VSS nmos W=0.155u L=0.04u
M8318 U4386/PG2 g1194 VDD VDD pmos W=0.41u L=0.04u
M8319 U4386/net55 n4264 VDD VDD pmos W=0.41u L=0.04u
M8320 U4386/net51 g6944 VDD VDD pmos W=0.205u L=0.04u
M8321 U4386/net53 g1205 VDD VDD pmos W=0.28u L=0.04u
M8322 U4386/net29 g1192 VDD VDD pmos W=0.205u L=0.04u
M8323 U4386/net53 g6944 U4386/PG1 VDD pmos W=0.27u L=0.04u
M8324 U4386/net55 U4386/net51 U4386/PG1 VDD pmos W=0.285u L=0.04u
M8325 U4386/PG2 U4386/net29 n3432 VDD pmos W=0.205u L=0.04u
M8326 U4386/PG1 g1192 n3432 VDD pmos W=0.28u L=0.04u
M8327 n4264 n3431 VSS VSS nmos W=0.135u L=0.04u
M8328 n4264 n3431 VDD VDD pmos W=0.205u L=0.04u
M8329 U4388/net29 g506 VSS VSS nmos W=0.155u L=0.04u
M8330 n3431 g508 U4388/net29 VSS nmos W=0.155u L=0.04u
M8331 n3431 g519 U4388/net23 VSS nmos W=0.155u L=0.04u
M8332 U4388/net23 n4255 VSS VSS nmos W=0.155u L=0.04u
M8333 U4388/net20 n4255 n3431 VDD pmos W=0.205u L=0.04u
M8334 U4388/net20 g519 n3431 VDD pmos W=0.205u L=0.04u
M8335 VDD g508 U4388/net20 VDD pmos W=0.205u L=0.04u
M8336 VDD g506 U4388/net20 VDD pmos W=0.205u L=0.04u
M8337 n3430 n4247 U4389/net27 VSS nmos W=0.155u L=0.04u
M8338 U4389/net39 n4249 VSS VSS nmos W=0.155u L=0.04u
M8339 U4389/net27 g16437 U4389/net39 VSS nmos W=0.155u L=0.04u
M8340 U4389/net27 n4248 U4389/net39 VSS nmos W=0.155u L=0.04u
M8341 n3430 n4265 U4389/net27 VSS nmos W=0.155u L=0.04u
M8342 U4389/net39 g2581 VSS VSS nmos W=0.155u L=0.04u
M8343 n3430 n4249 U4389/net46 VDD pmos W=0.205u L=0.04u
M8344 U4389/net46 g2581 VDD VDD pmos W=0.205u L=0.04u
M8345 n3430 n4265 U4389/net34 VDD pmos W=0.205u L=0.04u
M8346 U4389/net34 n4247 VDD VDD pmos W=0.205u L=0.04u
M8347 n3430 n4248 U4389/net37 VDD pmos W=0.205u L=0.04u
M8348 U4389/net37 g16437 VDD VDD pmos W=0.205u L=0.04u
M8349 U4390/XU1-net6 n4249 VSS VSS nmos W=0.155u L=0.04u
M8350 n4248 n3920 U4390/XU1-net6 VSS nmos W=0.155u L=0.04u
M8351 n4248 n4249 VDD VDD pmos W=0.155u L=0.04u
M8352 n4248 n3920 VDD VDD pmos W=0.155u L=0.04u
M8353 U4391/XU1-net6 n4249 VSS VSS nmos W=0.155u L=0.04u
M8354 n4247 g7390 U4391/XU1-net6 VSS nmos W=0.155u L=0.04u
M8355 n4247 n4249 VDD VDD pmos W=0.155u L=0.04u
M8356 n4247 g7390 VDD VDD pmos W=0.155u L=0.04u
M8357 n4249 g2580 VSS VSS nmos W=0.135u L=0.04u
M8358 n4249 g2580 VDD VDD pmos W=0.205u L=0.04u
M8359 n4265 n3429 VSS VSS nmos W=0.135u L=0.04u
M8360 n4265 n3429 VDD VDD pmos W=0.205u L=0.04u
M8361 n3429 n4251 U4394/net27 VSS nmos W=0.155u L=0.04u
M8362 U4394/net39 n4253 VSS VSS nmos W=0.155u L=0.04u
M8363 U4394/net27 g16399 U4394/net39 VSS nmos W=0.155u L=0.04u
M8364 U4394/net27 n4252 U4394/net39 VSS nmos W=0.155u L=0.04u
M8365 n3429 n4266 U4394/net27 VSS nmos W=0.155u L=0.04u
M8366 U4394/net39 g1887 VSS VSS nmos W=0.155u L=0.04u
M8367 n3429 n4253 U4394/net46 VDD pmos W=0.205u L=0.04u
M8368 U4394/net46 g1887 VDD VDD pmos W=0.205u L=0.04u
M8369 n3429 n4266 U4394/net34 VDD pmos W=0.205u L=0.04u
M8370 U4394/net34 n4251 VDD VDD pmos W=0.205u L=0.04u
M8371 n3429 n4252 U4394/net37 VDD pmos W=0.205u L=0.04u
M8372 U4394/net37 g16399 VDD VDD pmos W=0.205u L=0.04u
M8373 U4395/XU1-net6 n4030 VSS VSS nmos W=0.155u L=0.04u
M8374 n4252 n4253 U4395/XU1-net6 VSS nmos W=0.155u L=0.04u
M8375 n4252 n4030 VDD VDD pmos W=0.155u L=0.04u
M8376 n4252 n4253 VDD VDD pmos W=0.155u L=0.04u
M8377 U4396/XU1-net6 n4253 VSS VSS nmos W=0.155u L=0.04u
M8378 n4251 g7194 U4396/XU1-net6 VSS nmos W=0.155u L=0.04u
M8379 n4251 n4253 VDD VDD pmos W=0.155u L=0.04u
M8380 n4251 g7194 VDD VDD pmos W=0.155u L=0.04u
M8381 n4253 g1886 VSS VSS nmos W=0.135u L=0.04u
M8382 n4253 g1886 VDD VDD pmos W=0.205u L=0.04u
M8383 n4266 n3428 VSS VSS nmos W=0.135u L=0.04u
M8384 n4266 n3428 VDD VDD pmos W=0.205u L=0.04u
M8385 U4399/PG2 g1193 VSS VSS nmos W=0.31u L=0.04u
M8386 U4399/net55 n4267 VSS VSS nmos W=0.31u L=0.04u
M8387 U4399/net51 g6944 VSS VSS nmos W=0.155u L=0.04u
M8388 U4399/net53 g16355 VSS VSS nmos W=0.155u L=0.04u
M8389 U4399/net29 g1192 VSS VSS nmos W=0.155u L=0.04u
M8390 U4399/net53 U4399/net51 U4399/PG1 VSS nmos W=0.155u L=0.04u
M8391 U4399/net55 g6944 U4399/PG1 VSS nmos W=0.21u L=0.04u
M8392 U4399/PG2 g1192 n3428 VSS nmos W=0.22u L=0.04u
M8393 U4399/PG1 U4399/net29 n3428 VSS nmos W=0.155u L=0.04u
M8394 U4399/PG2 g1193 VDD VDD pmos W=0.41u L=0.04u
M8395 U4399/net55 n4267 VDD VDD pmos W=0.41u L=0.04u
M8396 U4399/net51 g6944 VDD VDD pmos W=0.205u L=0.04u
M8397 U4399/net53 g16355 VDD VDD pmos W=0.28u L=0.04u
M8398 U4399/net29 g1192 VDD VDD pmos W=0.205u L=0.04u
M8399 U4399/net53 g6944 U4399/PG1 VDD pmos W=0.27u L=0.04u
M8400 U4399/net55 U4399/net51 U4399/PG1 VDD pmos W=0.285u L=0.04u
M8401 U4399/PG2 U4399/net29 n3428 VDD pmos W=0.205u L=0.04u
M8402 U4399/PG1 g1192 n3428 VDD pmos W=0.28u L=0.04u
M8403 n3427 n4267 VSS VSS nmos W=0.135u L=0.04u
M8404 n3427 n4267 VDD VDD pmos W=0.205u L=0.04u
M8405 U4401/net29 n4255 VSS VSS nmos W=0.155u L=0.04u
M8406 n4267 n4269 U4401/net29 VSS nmos W=0.155u L=0.04u
M8407 n4267 n4268 U4401/net23 VSS nmos W=0.155u L=0.04u
M8408 U4401/net23 g506 VSS VSS nmos W=0.155u L=0.04u
M8409 U4401/net20 g506 n4267 VDD pmos W=0.205u L=0.04u
M8410 U4401/net20 n4268 n4267 VDD pmos W=0.205u L=0.04u
M8411 VDD n4269 U4401/net20 VDD pmos W=0.205u L=0.04u
M8412 VDD n4255 U4401/net20 VDD pmos W=0.205u L=0.04u
M8413 n4255 g506 VSS VSS nmos W=0.155u L=0.04u
M8414 n4255 g6642 VSS VSS nmos W=0.155u L=0.04u
M8415 U4402/XI1-net8 g6642 VDD VDD pmos W=0.205u L=0.04u
M8416 n4255 g506 U4402/XI1-net8 VDD pmos W=0.205u L=0.04u
M8417 n4269 g16297 VSS VSS nmos W=0.135u L=0.04u
M8418 n4269 g16297 VDD VDD pmos W=0.205u L=0.04u
M8419 n4268 g507 VSS VSS nmos W=0.135u L=0.04u
M8420 n4268 g507 VDD VDD pmos W=0.205u L=0.04u
M8421 n3426 n4270 U4405/net27 VSS nmos W=0.155u L=0.04u
M8422 U4405/net39 n4244 VSS VSS nmos W=0.155u L=0.04u
M8423 U4405/net27 g464 U4405/net39 VSS nmos W=0.155u L=0.04u
M8424 U4405/net27 n4271 U4405/net39 VSS nmos W=0.155u L=0.04u
M8425 n3426 g480 U4405/net27 VSS nmos W=0.155u L=0.04u
M8426 U4405/net39 g484 VSS VSS nmos W=0.155u L=0.04u
M8427 n3426 n4244 U4405/net46 VDD pmos W=0.205u L=0.04u
M8428 U4405/net46 g484 VDD VDD pmos W=0.205u L=0.04u
M8429 n3426 g480 U4405/net34 VDD pmos W=0.205u L=0.04u
M8430 U4405/net34 n4270 VDD VDD pmos W=0.205u L=0.04u
M8431 n3426 n4271 U4405/net37 VDD pmos W=0.205u L=0.04u
M8432 U4405/net37 g464 VDD VDD pmos W=0.205u L=0.04u
M8433 n3425 n4244 U4406/net27 VSS nmos W=0.155u L=0.04u
M8434 U4406/net39 n4271 VSS VSS nmos W=0.155u L=0.04u
M8435 U4406/net27 g477 U4406/net39 VSS nmos W=0.155u L=0.04u
M8436 U4406/net27 n4270 U4406/net39 VSS nmos W=0.155u L=0.04u
M8437 n3425 g478 U4406/net27 VSS nmos W=0.155u L=0.04u
M8438 U4406/net39 g479 VSS VSS nmos W=0.155u L=0.04u
M8439 n3425 n4271 U4406/net46 VDD pmos W=0.205u L=0.04u
M8440 U4406/net46 g479 VDD VDD pmos W=0.205u L=0.04u
M8441 n3425 g478 U4406/net34 VDD pmos W=0.205u L=0.04u
M8442 U4406/net34 n4244 VDD VDD pmos W=0.205u L=0.04u
M8443 n3425 n4270 U4406/net37 VDD pmos W=0.205u L=0.04u
M8444 U4406/net37 g477 VDD VDD pmos W=0.205u L=0.04u
M8445 n3424 n4244 U4407/net27 VSS nmos W=0.155u L=0.04u
M8446 U4407/net39 n4271 VSS VSS nmos W=0.155u L=0.04u
M8447 U4407/net27 g486 U4407/net39 VSS nmos W=0.155u L=0.04u
M8448 U4407/net27 n4270 U4407/net39 VSS nmos W=0.155u L=0.04u
M8449 n3424 g487 U4407/net27 VSS nmos W=0.155u L=0.04u
M8450 U4407/net39 g488 VSS VSS nmos W=0.155u L=0.04u
M8451 n3424 n4271 U4407/net46 VDD pmos W=0.205u L=0.04u
M8452 U4407/net46 g488 VDD VDD pmos W=0.205u L=0.04u
M8453 n3424 g487 U4407/net34 VDD pmos W=0.205u L=0.04u
M8454 U4407/net34 n4244 VDD VDD pmos W=0.205u L=0.04u
M8455 n3424 n4270 U4407/net37 VDD pmos W=0.205u L=0.04u
M8456 U4407/net37 g486 VDD VDD pmos W=0.205u L=0.04u
M8457 U4408/net19 n4205 VSS VSS nmos W=0.155u L=0.04u
M8458 n3421 n4205 U4408/net40 VSS nmos W=0.155u L=0.04u
M8459 n3421 U4408/net19 U4408/net36 VSS nmos W=0.155u L=0.04u
M8460 U4408/net40 g732 VSS VSS nmos W=0.31u L=0.04u
M8461 U4408/net36 n4272 VSS VSS nmos W=0.155u L=0.04u
M8462 U4408/net19 n4205 VDD VDD pmos W=0.205u L=0.04u
M8463 n3421 U4408/net19 U4408/net26 VDD pmos W=0.325u L=0.04u
M8464 U4408/net26 g732 VDD VDD pmos W=0.41u L=0.04u
M8465 n3421 n4205 U4408/net30 VDD pmos W=0.325u L=0.04u
M8466 U4408/net30 n4272 VDD VDD pmos W=0.205u L=0.04u
M8467 U4409/net19 n4183 VSS VSS nmos W=0.155u L=0.04u
M8468 n3420 n4183 U4409/net40 VSS nmos W=0.155u L=0.04u
M8469 n3420 U4409/net19 U4409/net36 VSS nmos W=0.155u L=0.04u
M8470 U4409/net40 g733 VSS VSS nmos W=0.31u L=0.04u
M8471 U4409/net36 n4272 VSS VSS nmos W=0.155u L=0.04u
M8472 U4409/net19 n4183 VDD VDD pmos W=0.205u L=0.04u
M8473 n3420 U4409/net19 U4409/net26 VDD pmos W=0.325u L=0.04u
M8474 U4409/net26 g733 VDD VDD pmos W=0.41u L=0.04u
M8475 n3420 n4183 U4409/net30 VDD pmos W=0.325u L=0.04u
M8476 U4409/net30 n4272 VDD VDD pmos W=0.205u L=0.04u
M8477 U4410/net19 n4202 VSS VSS nmos W=0.155u L=0.04u
M8478 n3419 n4202 U4410/net40 VSS nmos W=0.155u L=0.04u
M8479 n3419 U4410/net19 U4410/net36 VSS nmos W=0.155u L=0.04u
M8480 U4410/net40 g731 VSS VSS nmos W=0.31u L=0.04u
M8481 U4410/net36 n4272 VSS VSS nmos W=0.155u L=0.04u
M8482 U4410/net19 n4202 VDD VDD pmos W=0.205u L=0.04u
M8483 n3419 U4410/net19 U4410/net26 VDD pmos W=0.325u L=0.04u
M8484 U4410/net26 g731 VDD VDD pmos W=0.41u L=0.04u
M8485 n3419 n4202 U4410/net30 VDD pmos W=0.325u L=0.04u
M8486 U4410/net30 n4272 VDD VDD pmos W=0.205u L=0.04u
M8487 U4411/net19 n4274 VSS VSS nmos W=0.155u L=0.04u
M8488 n3418 n4274 U4411/net40 VSS nmos W=0.155u L=0.04u
M8489 n3418 U4411/net19 U4411/net36 VSS nmos W=0.155u L=0.04u
M8490 U4411/net40 n4273 VSS VSS nmos W=0.31u L=0.04u
M8491 U4411/net36 g575 VSS VSS nmos W=0.155u L=0.04u
M8492 U4411/net19 n4274 VDD VDD pmos W=0.205u L=0.04u
M8493 n3418 U4411/net19 U4411/net26 VDD pmos W=0.325u L=0.04u
M8494 U4411/net26 n4273 VDD VDD pmos W=0.41u L=0.04u
M8495 n3418 n4274 U4411/net30 VDD pmos W=0.325u L=0.04u
M8496 U4411/net30 g575 VDD VDD pmos W=0.205u L=0.04u
M8497 U4412/net19 n4274 VSS VSS nmos W=0.155u L=0.04u
M8498 n3417 n4274 U4412/net40 VSS nmos W=0.155u L=0.04u
M8499 n3417 U4412/net19 U4412/net36 VSS nmos W=0.155u L=0.04u
M8500 U4412/net40 n4275 VSS VSS nmos W=0.31u L=0.04u
M8501 U4412/net36 g578 VSS VSS nmos W=0.155u L=0.04u
M8502 U4412/net19 n4274 VDD VDD pmos W=0.205u L=0.04u
M8503 n3417 U4412/net19 U4412/net26 VDD pmos W=0.325u L=0.04u
M8504 U4412/net26 n4275 VDD VDD pmos W=0.41u L=0.04u
M8505 n3417 n4274 U4412/net30 VDD pmos W=0.325u L=0.04u
M8506 U4412/net30 g578 VDD VDD pmos W=0.205u L=0.04u
M8507 U4413/net19 n4274 VSS VSS nmos W=0.155u L=0.04u
M8508 n3416 n4274 U4413/net40 VSS nmos W=0.155u L=0.04u
M8509 n3416 U4413/net19 U4413/net36 VSS nmos W=0.155u L=0.04u
M8510 U4413/net40 n4276 VSS VSS nmos W=0.31u L=0.04u
M8511 U4413/net36 g581 VSS VSS nmos W=0.155u L=0.04u
M8512 U4413/net19 n4274 VDD VDD pmos W=0.205u L=0.04u
M8513 n3416 U4413/net19 U4413/net26 VDD pmos W=0.325u L=0.04u
M8514 U4413/net26 n4276 VDD VDD pmos W=0.41u L=0.04u
M8515 n3416 n4274 U4413/net30 VDD pmos W=0.325u L=0.04u
M8516 U4413/net30 g581 VDD VDD pmos W=0.205u L=0.04u
M8517 U4414/net19 n4274 VSS VSS nmos W=0.155u L=0.04u
M8518 n3415 n4274 U4414/net40 VSS nmos W=0.155u L=0.04u
M8519 n3415 U4414/net19 U4414/net36 VSS nmos W=0.155u L=0.04u
M8520 U4414/net40 n4277 VSS VSS nmos W=0.31u L=0.04u
M8521 U4414/net36 g584 VSS VSS nmos W=0.155u L=0.04u
M8522 U4414/net19 n4274 VDD VDD pmos W=0.205u L=0.04u
M8523 n3415 U4414/net19 U4414/net26 VDD pmos W=0.325u L=0.04u
M8524 U4414/net26 n4277 VDD VDD pmos W=0.41u L=0.04u
M8525 n3415 n4274 U4414/net30 VDD pmos W=0.325u L=0.04u
M8526 U4414/net30 g584 VDD VDD pmos W=0.205u L=0.04u
M8527 n4274 n4244 VSS VSS nmos W=0.155u L=0.04u
M8528 n4274 n3410 VSS VSS nmos W=0.155u L=0.04u
M8529 U4415/XI1-net8 n3410 VDD VDD pmos W=0.205u L=0.04u
M8530 n4274 n4244 U4415/XI1-net8 VDD pmos W=0.205u L=0.04u
M8531 U4416/net19 n4278 VSS VSS nmos W=0.155u L=0.04u
M8532 n3414 n4278 U4416/net40 VSS nmos W=0.155u L=0.04u
M8533 n3414 U4416/net19 U4416/net36 VSS nmos W=0.155u L=0.04u
M8534 U4416/net40 n4273 VSS VSS nmos W=0.31u L=0.04u
M8535 U4416/net36 g577 VSS VSS nmos W=0.155u L=0.04u
M8536 U4416/net19 n4278 VDD VDD pmos W=0.205u L=0.04u
M8537 n3414 U4416/net19 U4416/net26 VDD pmos W=0.325u L=0.04u
M8538 U4416/net26 n4273 VDD VDD pmos W=0.41u L=0.04u
M8539 n3414 n4278 U4416/net30 VDD pmos W=0.325u L=0.04u
M8540 U4416/net30 g577 VDD VDD pmos W=0.205u L=0.04u
M8541 U4417/net19 n4278 VSS VSS nmos W=0.155u L=0.04u
M8542 n3413 n4278 U4417/net40 VSS nmos W=0.155u L=0.04u
M8543 n3413 U4417/net19 U4417/net36 VSS nmos W=0.155u L=0.04u
M8544 U4417/net40 n4275 VSS VSS nmos W=0.31u L=0.04u
M8545 U4417/net36 g580 VSS VSS nmos W=0.155u L=0.04u
M8546 U4417/net19 n4278 VDD VDD pmos W=0.205u L=0.04u
M8547 n3413 U4417/net19 U4417/net26 VDD pmos W=0.325u L=0.04u
M8548 U4417/net26 n4275 VDD VDD pmos W=0.41u L=0.04u
M8549 n3413 n4278 U4417/net30 VDD pmos W=0.325u L=0.04u
M8550 U4417/net30 g580 VDD VDD pmos W=0.205u L=0.04u
M8551 U4418/net19 n4278 VSS VSS nmos W=0.155u L=0.04u
M8552 n3412 n4278 U4418/net40 VSS nmos W=0.155u L=0.04u
M8553 n3412 U4418/net19 U4418/net36 VSS nmos W=0.155u L=0.04u
M8554 U4418/net40 n4276 VSS VSS nmos W=0.31u L=0.04u
M8555 U4418/net36 g583 VSS VSS nmos W=0.155u L=0.04u
M8556 U4418/net19 n4278 VDD VDD pmos W=0.205u L=0.04u
M8557 n3412 U4418/net19 U4418/net26 VDD pmos W=0.325u L=0.04u
M8558 U4418/net26 n4276 VDD VDD pmos W=0.41u L=0.04u
M8559 n3412 n4278 U4418/net30 VDD pmos W=0.325u L=0.04u
M8560 U4418/net30 g583 VDD VDD pmos W=0.205u L=0.04u
M8561 U4419/net19 n4278 VSS VSS nmos W=0.155u L=0.04u
M8562 n3411 n4278 U4419/net40 VSS nmos W=0.155u L=0.04u
M8563 n3411 U4419/net19 U4419/net36 VSS nmos W=0.155u L=0.04u
M8564 U4419/net40 n4277 VSS VSS nmos W=0.31u L=0.04u
M8565 U4419/net36 g586 VSS VSS nmos W=0.155u L=0.04u
M8566 U4419/net19 n4278 VDD VDD pmos W=0.205u L=0.04u
M8567 n3411 U4419/net19 U4419/net26 VDD pmos W=0.325u L=0.04u
M8568 U4419/net26 n4277 VDD VDD pmos W=0.41u L=0.04u
M8569 n3411 n4278 U4419/net30 VDD pmos W=0.325u L=0.04u
M8570 U4419/net30 g586 VDD VDD pmos W=0.205u L=0.04u
M8571 n4278 n4270 VSS VSS nmos W=0.155u L=0.04u
M8572 n4278 n3410 VSS VSS nmos W=0.155u L=0.04u
M8573 U4420/XI1-net8 n3410 VDD VDD pmos W=0.205u L=0.04u
M8574 n4278 n4270 U4420/XI1-net8 VDD pmos W=0.205u L=0.04u
M8575 U4421/net19 n4270 VSS VSS nmos W=0.155u L=0.04u
M8576 n3409 n4270 U4421/net40 VSS nmos W=0.155u L=0.04u
M8577 n3409 U4421/net19 U4421/net36 VSS nmos W=0.155u L=0.04u
M8578 U4421/net40 g493 VSS VSS nmos W=0.31u L=0.04u
M8579 U4421/net36 n4279 VSS VSS nmos W=0.155u L=0.04u
M8580 U4421/net19 n4270 VDD VDD pmos W=0.205u L=0.04u
M8581 n3409 U4421/net19 U4421/net26 VDD pmos W=0.325u L=0.04u
M8582 U4421/net26 g493 VDD VDD pmos W=0.41u L=0.04u
M8583 n3409 n4270 U4421/net30 VDD pmos W=0.325u L=0.04u
M8584 U4421/net30 n4279 VDD VDD pmos W=0.205u L=0.04u
M8585 U4422/net19 n4244 VSS VSS nmos W=0.155u L=0.04u
M8586 n3408 n4244 U4422/net40 VSS nmos W=0.155u L=0.04u
M8587 n3408 U4422/net19 U4422/net36 VSS nmos W=0.155u L=0.04u
M8588 U4422/net40 g496 VSS VSS nmos W=0.31u L=0.04u
M8589 U4422/net36 n4279 VSS VSS nmos W=0.155u L=0.04u
M8590 U4422/net19 n4244 VDD VDD pmos W=0.205u L=0.04u
M8591 n3408 U4422/net19 U4422/net26 VDD pmos W=0.325u L=0.04u
M8592 U4422/net26 g496 VDD VDD pmos W=0.41u L=0.04u
M8593 n3408 n4244 U4422/net30 VDD pmos W=0.325u L=0.04u
M8594 U4422/net30 n4279 VDD VDD pmos W=0.205u L=0.04u
M8595 U4423/net19 n4205 VSS VSS nmos W=0.155u L=0.04u
M8596 n3407 n4205 U4423/net40 VSS nmos W=0.155u L=0.04u
M8597 n3407 U4423/net19 U4423/net36 VSS nmos W=0.155u L=0.04u
M8598 U4423/net40 g729 VSS VSS nmos W=0.31u L=0.04u
M8599 U4423/net36 n4280 VSS VSS nmos W=0.155u L=0.04u
M8600 U4423/net19 n4205 VDD VDD pmos W=0.205u L=0.04u
M8601 n3407 U4423/net19 U4423/net26 VDD pmos W=0.325u L=0.04u
M8602 U4423/net26 g729 VDD VDD pmos W=0.41u L=0.04u
M8603 n3407 n4205 U4423/net30 VDD pmos W=0.325u L=0.04u
M8604 U4423/net30 n4280 VDD VDD pmos W=0.205u L=0.04u
M8605 U4424/XU1-net6 g630 VSS VSS nmos W=0.155u L=0.04u
M8606 n4205 g6677 U4424/XU1-net6 VSS nmos W=0.155u L=0.04u
M8607 n4205 g630 VDD VDD pmos W=0.155u L=0.04u
M8608 n4205 g6677 VDD VDD pmos W=0.155u L=0.04u
M8609 U4425/net19 n4183 VSS VSS nmos W=0.155u L=0.04u
M8610 n3406 n4183 U4425/net40 VSS nmos W=0.155u L=0.04u
M8611 n3406 U4425/net19 U4425/net36 VSS nmos W=0.155u L=0.04u
M8612 U4425/net40 g730 VSS VSS nmos W=0.31u L=0.04u
M8613 U4425/net36 n4280 VSS VSS nmos W=0.155u L=0.04u
M8614 U4425/net19 n4183 VDD VDD pmos W=0.205u L=0.04u
M8615 n3406 U4425/net19 U4425/net26 VDD pmos W=0.325u L=0.04u
M8616 U4425/net26 g730 VDD VDD pmos W=0.41u L=0.04u
M8617 n3406 n4183 U4425/net30 VDD pmos W=0.325u L=0.04u
M8618 U4425/net30 n4280 VDD VDD pmos W=0.205u L=0.04u
M8619 U4426/XU1-net6 g630 VSS VSS nmos W=0.155u L=0.04u
M8620 n4183 g6911 U4426/XU1-net6 VSS nmos W=0.155u L=0.04u
M8621 n4183 g630 VDD VDD pmos W=0.155u L=0.04u
M8622 n4183 g6911 VDD VDD pmos W=0.155u L=0.04u
M8623 U4427/net19 n4202 VSS VSS nmos W=0.155u L=0.04u
M8624 n3405 n4202 U4427/net40 VSS nmos W=0.155u L=0.04u
M8625 n3405 U4427/net19 U4427/net36 VSS nmos W=0.155u L=0.04u
M8626 U4427/net40 g728 VSS VSS nmos W=0.31u L=0.04u
M8627 U4427/net36 n4280 VSS VSS nmos W=0.155u L=0.04u
M8628 U4427/net19 n4202 VDD VDD pmos W=0.205u L=0.04u
M8629 n3405 U4427/net19 U4427/net26 VDD pmos W=0.325u L=0.04u
M8630 U4427/net26 g728 VDD VDD pmos W=0.41u L=0.04u
M8631 n3405 n4202 U4427/net30 VDD pmos W=0.325u L=0.04u
M8632 U4427/net30 n4280 VDD VDD pmos W=0.205u L=0.04u
M8633 U4428/XU1-net6 g629 VSS VSS nmos W=0.155u L=0.04u
M8634 n4202 g630 U4428/XU1-net6 VSS nmos W=0.155u L=0.04u
M8635 n4202 g629 VDD VDD pmos W=0.155u L=0.04u
M8636 n4202 g630 VDD VDD pmos W=0.155u L=0.04u
M8637 U4429/net19 n4281 VSS VSS nmos W=0.155u L=0.04u
M8638 n3404 n4281 U4429/net40 VSS nmos W=0.155u L=0.04u
M8639 n3404 U4429/net19 U4429/net36 VSS nmos W=0.155u L=0.04u
M8640 U4429/net40 n4273 VSS VSS nmos W=0.31u L=0.04u
M8641 U4429/net36 g576 VSS VSS nmos W=0.155u L=0.04u
M8642 U4429/net19 n4281 VDD VDD pmos W=0.205u L=0.04u
M8643 n3404 U4429/net19 U4429/net26 VDD pmos W=0.325u L=0.04u
M8644 U4429/net26 n4273 VDD VDD pmos W=0.41u L=0.04u
M8645 n3404 n4281 U4429/net30 VDD pmos W=0.325u L=0.04u
M8646 U4429/net30 g576 VDD VDD pmos W=0.205u L=0.04u
M8647 U4430/net7 n4282 U4430/X_u4-net10 VSS nmos W=0.155u L=0.04u
M8648 U4430/X_u4-net10 n4283 U4430/X_u4-net13 VSS nmos W=0.155u L=0.04u
M8649 U4430/X_u4-net13 n4284 VSS VSS nmos W=0.155u L=0.04u
M8650 n4273 U4430/net7 VSS VSS nmos W=0.155u L=0.04u
M8651 U4430/net7 n4284 VDD VDD pmos W=0.205u L=0.04u
M8652 U4430/net7 n4282 VDD VDD pmos W=0.205u L=0.04u
M8653 U4430/net7 n4283 VDD VDD pmos W=0.205u L=0.04u
M8654 n4273 U4430/net7 VDD VDD pmos W=0.205u L=0.04u
M8655 U4431/net19 n3937 VSS VSS nmos W=0.155u L=0.04u
M8656 n4284 n3937 U4431/net40 VSS nmos W=0.155u L=0.04u
M8657 n4284 U4431/net19 U4431/net36 VSS nmos W=0.155u L=0.04u
M8658 U4431/net40 n4286 VSS VSS nmos W=0.31u L=0.04u
M8659 U4431/net36 n4285 VSS VSS nmos W=0.155u L=0.04u
M8660 U4431/net19 n3937 VDD VDD pmos W=0.205u L=0.04u
M8661 n4284 U4431/net19 U4431/net26 VDD pmos W=0.325u L=0.04u
M8662 U4431/net26 n4286 VDD VDD pmos W=0.41u L=0.04u
M8663 n4284 n3937 U4431/net30 VDD pmos W=0.325u L=0.04u
M8664 U4431/net30 n4285 VDD VDD pmos W=0.205u L=0.04u
M8665 n4286 n418 U4432/net15 VSS nmos W=0.155u L=0.04u
M8666 n4286 n4285 U4432/net15 VSS nmos W=0.155u L=0.04u
M8667 U4432/net15 n4287 VSS VSS nmos W=0.155u L=0.04u
M8668 n4286 n4287 VDD VDD pmos W=0.205u L=0.04u
M8669 n4286 n418 U4432/XI16-net11 VDD pmos W=0.205u L=0.04u
M8670 U4432/XI16-net11 n4285 VDD VDD pmos W=0.205u L=0.04u
M8671 U4433/net19 n4281 VSS VSS nmos W=0.155u L=0.04u
M8672 n3403 n4281 U4433/net40 VSS nmos W=0.155u L=0.04u
M8673 n3403 U4433/net19 U4433/net36 VSS nmos W=0.155u L=0.04u
M8674 U4433/net40 n4275 VSS VSS nmos W=0.31u L=0.04u
M8675 U4433/net36 g579 VSS VSS nmos W=0.155u L=0.04u
M8676 U4433/net19 n4281 VDD VDD pmos W=0.205u L=0.04u
M8677 n3403 U4433/net19 U4433/net26 VDD pmos W=0.325u L=0.04u
M8678 U4433/net26 n4275 VDD VDD pmos W=0.41u L=0.04u
M8679 n3403 n4281 U4433/net30 VDD pmos W=0.325u L=0.04u
M8680 U4433/net30 g579 VDD VDD pmos W=0.205u L=0.04u
M8681 U4434/net36 n4287 U4434/net24 VSS nmos W=0.155u L=0.04u
M8682 U4434/net24 n4282 VSS VSS nmos W=0.155u L=0.04u
M8683 U4434/net33 n4288 U4434/net36 VSS nmos W=0.155u L=0.04u
M8684 U4434/net33 n4289 U4434/net36 VSS nmos W=0.155u L=0.04u
M8685 n4275 U4434/net33 VSS VSS nmos W=0.155u L=0.04u
M8686 n4275 U4434/net33 VDD VDD pmos W=0.205u L=0.04u
M8687 U4434/net33 n4289 U4434/net35 VDD pmos W=0.205u L=0.04u
M8688 U4434/net35 n4288 VDD VDD pmos W=0.205u L=0.04u
M8689 U4434/net33 n4282 VDD VDD pmos W=0.205u L=0.04u
M8690 U4434/net33 n4287 VDD VDD pmos W=0.205u L=0.04u
M8691 n4282 n4288 U4435/XI0-net10 VSS nmos W=0.155u L=0.04u
M8692 U4435/XI0-net10 n4290 U4435/XI0-net13 VSS nmos W=0.155u L=0.04u
M8693 U4435/XI0-net13 g3229 VSS VSS nmos W=0.155u L=0.04u
M8694 n4282 g3229 VDD VDD pmos W=0.205u L=0.04u
M8695 n4282 n4288 VDD VDD pmos W=0.205u L=0.04u
M8696 n4282 n4290 VDD VDD pmos W=0.205u L=0.04u
M8697 U4436/XU1-net6 n3937 VSS VSS nmos W=0.155u L=0.04u
M8698 n4289 n4290 U4436/XU1-net6 VSS nmos W=0.155u L=0.04u
M8699 n4289 n3937 VDD VDD pmos W=0.155u L=0.04u
M8700 n4289 n4290 VDD VDD pmos W=0.155u L=0.04u
M8701 U4437/net19 n4281 VSS VSS nmos W=0.155u L=0.04u
M8702 n3402 n4281 U4437/net40 VSS nmos W=0.155u L=0.04u
M8703 n3402 U4437/net19 U4437/net36 VSS nmos W=0.155u L=0.04u
M8704 U4437/net40 n4276 VSS VSS nmos W=0.31u L=0.04u
M8705 U4437/net36 g582 VSS VSS nmos W=0.155u L=0.04u
M8706 U4437/net19 n4281 VDD VDD pmos W=0.205u L=0.04u
M8707 n3402 U4437/net19 U4437/net26 VDD pmos W=0.325u L=0.04u
M8708 U4437/net26 n4276 VDD VDD pmos W=0.41u L=0.04u
M8709 n3402 n4281 U4437/net30 VDD pmos W=0.325u L=0.04u
M8710 U4437/net30 g582 VDD VDD pmos W=0.205u L=0.04u
M8711 n4276 n4294 VSS VSS nmos W=0.155u L=0.04u
M8712 n4276 n4291 U4438/XI17-net17 VSS nmos W=0.155u L=0.04u
M8713 U4438/XI17-net17 n4293 VSS VSS nmos W=0.155u L=0.04u
M8714 n4276 n4291 U4438/XI10-net17 VSS nmos W=0.155u L=0.04u
M8715 U4438/XI10-net17 n4292 VSS VSS nmos W=0.155u L=0.04u
M8716 U4438/net30 n4291 n4276 VDD pmos W=0.205u L=0.04u
M8717 U4438/net30 n4292 n4276 VDD pmos W=0.205u L=0.04u
M8718 VDD n4294 U4438/net36 VDD pmos W=0.205u L=0.04u
M8719 U4438/net36 n4293 U4438/net30 VDD pmos W=0.205u L=0.04u
M8720 U4438/net36 n4291 U4438/net30 VDD pmos W=0.205u L=0.04u
M8721 VSS n4283 U4439/net22 VSS nmos W=0.155u L=0.04u
M8722 U4439/net22 n4288 n4294 VSS nmos W=0.155u L=0.04u
M8723 U4439/net22 g3229 n4294 VSS nmos W=0.155u L=0.04u
M8724 U4439/net22 n4295 n4294 VSS nmos W=0.155u L=0.04u
M8725 U4439/net38 n4295 VDD VDD pmos W=0.205u L=0.04u
M8726 U4439/net35 g3229 U4439/net38 VDD pmos W=0.205u L=0.04u
M8727 n4294 n4288 U4439/net35 VDD pmos W=0.205u L=0.04u
M8728 n4294 n4283 VDD VDD pmos W=0.205u L=0.04u
M8729 n4283 g3229 U4440/XI0-net10 VSS nmos W=0.155u L=0.04u
M8730 U4440/XI0-net10 n4288 U4440/XI0-net13 VSS nmos W=0.155u L=0.04u
M8731 U4440/XI0-net13 n4296 VSS VSS nmos W=0.155u L=0.04u
M8732 n4283 n4296 VDD VDD pmos W=0.205u L=0.04u
M8733 n4283 g3229 VDD VDD pmos W=0.205u L=0.04u
M8734 n4283 n4288 VDD VDD pmos W=0.205u L=0.04u
M8735 U4441/net19 n4281 VSS VSS nmos W=0.155u L=0.04u
M8736 n3401 n4281 U4441/net40 VSS nmos W=0.155u L=0.04u
M8737 n3401 U4441/net19 U4441/net36 VSS nmos W=0.155u L=0.04u
M8738 U4441/net40 n4277 VSS VSS nmos W=0.31u L=0.04u
M8739 U4441/net36 g585 VSS VSS nmos W=0.155u L=0.04u
M8740 U4441/net19 n4281 VDD VDD pmos W=0.205u L=0.04u
M8741 n3401 U4441/net19 U4441/net26 VDD pmos W=0.325u L=0.04u
M8742 U4441/net26 n4277 VDD VDD pmos W=0.41u L=0.04u
M8743 n3401 n4281 U4441/net30 VDD pmos W=0.325u L=0.04u
M8744 U4441/net30 g585 VDD VDD pmos W=0.205u L=0.04u
M8745 n4281 n4271 VSS VSS nmos W=0.155u L=0.04u
M8746 n4281 n3410 VSS VSS nmos W=0.155u L=0.04u
M8747 U4442/XI1-net8 n3410 VDD VDD pmos W=0.205u L=0.04u
M8748 n4281 n4271 U4442/XI1-net8 VDD pmos W=0.205u L=0.04u
M8749 n3410 n4272 U4443/net10 VSS nmos W=0.155u L=0.04u
M8750 U4443/net10 n3950 VSS VSS nmos W=0.155u L=0.04u
M8751 n3410 n4297 U4443/net10 VSS nmos W=0.155u L=0.04u
M8752 U4443/net10 n4298 VSS VSS nmos W=0.155u L=0.04u
M8753 U4443/net30 n3950 VDD VDD pmos W=0.205u L=0.04u
M8754 n3410 n4272 U4443/net24 VDD pmos W=0.205u L=0.04u
M8755 U4443/net24 n4297 VDD VDD pmos W=0.205u L=0.04u
M8756 n3410 n4298 U4443/net30 VDD pmos W=0.205u L=0.04u
M8757 U4444/net20 g3006 VSS VSS nmos W=0.155u L=0.04u
M8758 n3950 n3842 U4444/p0 VSS nmos W=0.155u L=0.04u
M8759 U4444/p2 U4444/net20 VSS VSS nmos W=0.155u L=0.04u
M8760 U4444/p1 n3845 U4444/p2 VSS nmos W=0.155u L=0.04u
M8761 U4444/p0 n4299 U4444/p1 VSS nmos W=0.155u L=0.04u
M8762 U4444/net20 g3006 VDD VDD pmos W=0.205u L=0.04u
M8763 n3950 n3845 VDD VDD pmos W=0.205u L=0.04u
M8764 n3950 n3842 VDD VDD pmos W=0.205u L=0.04u
M8765 n3950 n4299 VDD VDD pmos W=0.205u L=0.04u
M8766 n3950 U4444/net20 VDD VDD pmos W=0.205u L=0.04u
M8767 n3842 g3010 VSS VSS nmos W=0.135u L=0.04u
M8768 n3842 g3010 VDD VDD pmos W=0.205u L=0.04u
M8769 n4299 g3024 VSS VSS nmos W=0.155u L=0.04u
M8770 n4299 g3013 VSS VSS nmos W=0.155u L=0.04u
M8771 U4446/XI1-net8 g3013 VDD VDD pmos W=0.205u L=0.04u
M8772 n4299 g3024 U4446/XI1-net8 VDD pmos W=0.205u L=0.04u
M8773 n3845 g3002 VSS VSS nmos W=0.135u L=0.04u
M8774 n3845 g3002 VDD VDD pmos W=0.205u L=0.04u
M8775 U4448/net7 g510 U4448/X_u4-net10 VSS nmos W=0.155u L=0.04u
M8776 U4448/X_u4-net10 n4300 U4448/X_u4-net13 VSS nmos W=0.155u L=0.04u
M8777 U4448/X_u4-net13 n4297 VSS VSS nmos W=0.155u L=0.04u
M8778 n4298 U4448/net7 VSS VSS nmos W=0.155u L=0.04u
M8779 U4448/net7 n4297 VDD VDD pmos W=0.205u L=0.04u
M8780 U4448/net7 g510 VDD VDD pmos W=0.205u L=0.04u
M8781 U4448/net7 n4300 VDD VDD pmos W=0.205u L=0.04u
M8782 n4298 U4448/net7 VDD VDD pmos W=0.205u L=0.04u
M8783 n4277 n4293 U4449/net15 VSS nmos W=0.155u L=0.04u
M8784 n4277 n4292 U4449/net15 VSS nmos W=0.155u L=0.04u
M8785 U4449/net15 n4301 VSS VSS nmos W=0.155u L=0.04u
M8786 n4277 n4301 VDD VDD pmos W=0.205u L=0.04u
M8787 n4277 n4293 U4449/XI16-net11 VDD pmos W=0.205u L=0.04u
M8788 U4449/XI16-net11 n4292 VDD VDD pmos W=0.205u L=0.04u
M8789 n4292 g3229 VSS VSS nmos W=0.155u L=0.04u
M8790 n4292 n418 VSS VSS nmos W=0.155u L=0.04u
M8791 U4450/XI1-net8 n418 VDD VDD pmos W=0.205u L=0.04u
M8792 n4292 g3229 U4450/XI1-net8 VDD pmos W=0.205u L=0.04u
M8793 n4293 n4288 VSS VSS nmos W=0.155u L=0.04u
M8794 n4293 n3937 VSS VSS nmos W=0.155u L=0.04u
M8795 U4451/XI1-net8 n3937 VDD VDD pmos W=0.205u L=0.04u
M8796 n4293 n4288 U4451/XI1-net8 VDD pmos W=0.205u L=0.04u
M8797 U4452/net19 n4271 VSS VSS nmos W=0.155u L=0.04u
M8798 n3400 n4271 U4452/net40 VSS nmos W=0.155u L=0.04u
M8799 n3400 U4452/net19 U4452/net36 VSS nmos W=0.155u L=0.04u
M8800 U4452/net40 g490 VSS VSS nmos W=0.31u L=0.04u
M8801 U4452/net36 n4279 VSS VSS nmos W=0.155u L=0.04u
M8802 U4452/net19 n4271 VDD VDD pmos W=0.205u L=0.04u
M8803 n3400 U4452/net19 U4452/net26 VDD pmos W=0.325u L=0.04u
M8804 U4452/net26 g490 VDD VDD pmos W=0.41u L=0.04u
M8805 n3400 n4271 U4452/net30 VDD pmos W=0.325u L=0.04u
M8806 U4452/net30 n4279 VDD VDD pmos W=0.205u L=0.04u
M8807 U4453/net7 g510 U4453/X_u4-net10 VSS nmos W=0.155u L=0.04u
M8808 U4453/X_u4-net10 n4297 U4453/X_u4-net13 VSS nmos W=0.155u L=0.04u
M8809 U4453/X_u4-net13 n4280 VSS VSS nmos W=0.155u L=0.04u
M8810 n4279 U4453/net7 VSS VSS nmos W=0.155u L=0.04u
M8811 U4453/net7 n4280 VDD VDD pmos W=0.205u L=0.04u
M8812 U4453/net7 g510 VDD VDD pmos W=0.205u L=0.04u
M8813 U4453/net7 n4297 VDD VDD pmos W=0.205u L=0.04u
M8814 n4279 U4453/net7 VDD VDD pmos W=0.205u L=0.04u
M8815 n4297 g550 U4454/XI21-net17 VSS nmos W=0.155u L=0.04u
M8816 U4454/XI21-net17 g496 VSS VSS nmos W=0.155u L=0.04u
M8817 n4297 g6485 U4454/XI6-net17 VSS nmos W=0.155u L=0.04u
M8818 U4454/XI6-net17 g490 VSS VSS nmos W=0.155u L=0.04u
M8819 n4297 g6642 U4454/XI20-net17 VSS nmos W=0.155u L=0.04u
M8820 U4454/XI20-net17 g493 VSS VSS nmos W=0.155u L=0.04u
M8821 VDD g550 U4454/net22 VDD pmos W=0.205u L=0.04u
M8822 VDD g496 U4454/net22 VDD pmos W=0.205u L=0.04u
M8823 U4454/net16 g6485 n4297 VDD pmos W=0.205u L=0.04u
M8824 U4454/net16 g490 n4297 VDD pmos W=0.205u L=0.04u
M8825 U4454/net22 g6642 U4454/net16 VDD pmos W=0.205u L=0.04u
M8826 U4454/net22 g493 U4454/net16 VDD pmos W=0.205u L=0.04u
M8827 U4455/net19 g3229 VSS VSS nmos W=0.155u L=0.04u
M8828 n3395 g3229 U4455/net40 VSS nmos W=0.155u L=0.04u
M8829 n3395 U4455/net19 U4455/net36 VSS nmos W=0.155u L=0.04u
M8830 U4455/net40 n4302 VSS VSS nmos W=0.31u L=0.04u
M8831 U4455/net36 g305 VSS VSS nmos W=0.155u L=0.04u
M8832 U4455/net19 g3229 VDD VDD pmos W=0.205u L=0.04u
M8833 n3395 U4455/net19 U4455/net26 VDD pmos W=0.325u L=0.04u
M8834 U4455/net26 n4302 VDD VDD pmos W=0.41u L=0.04u
M8835 n3395 g3229 U4455/net30 VDD pmos W=0.325u L=0.04u
M8836 U4455/net30 g305 VDD VDD pmos W=0.205u L=0.04u
M8837 n4302 g291 VSS VSS nmos W=0.135u L=0.04u
M8838 n4302 g291 VDD VDD pmos W=0.205u L=0.04u
M8839 n3393 n4303 U4457/net27 VSS nmos W=0.155u L=0.04u
M8840 U4457/net39 g2374 VSS VSS nmos W=0.155u L=0.04u
M8841 U4457/net27 n4304 U4457/net39 VSS nmos W=0.155u L=0.04u
M8842 U4457/net27 n4305 U4457/net39 VSS nmos W=0.155u L=0.04u
M8843 n3393 g2372 U4457/net27 VSS nmos W=0.155u L=0.04u
M8844 U4457/net39 g2376 VSS VSS nmos W=0.155u L=0.04u
M8845 n3393 g2374 U4457/net46 VDD pmos W=0.205u L=0.04u
M8846 U4457/net46 g2376 VDD VDD pmos W=0.205u L=0.04u
M8847 n3393 g2372 U4457/net34 VDD pmos W=0.205u L=0.04u
M8848 U4457/net34 n4303 VDD VDD pmos W=0.205u L=0.04u
M8849 n3393 n4305 U4457/net37 VDD pmos W=0.205u L=0.04u
M8850 U4457/net37 n4304 VDD VDD pmos W=0.205u L=0.04u
M8851 n4305 n407 VSS VSS nmos W=0.135u L=0.04u
M8852 n4305 n407 VDD VDD pmos W=0.205u L=0.04u
M8853 n407 g1682 U4459/XI21-net17 VSS nmos W=0.155u L=0.04u
M8854 U4459/XI21-net17 n4309 VSS VSS nmos W=0.155u L=0.04u
M8855 n407 n4306 U4459/XI6-net17 VSS nmos W=0.155u L=0.04u
M8856 U4459/XI6-net17 n4307 VSS VSS nmos W=0.155u L=0.04u
M8857 n407 g1678 U4459/XI20-net17 VSS nmos W=0.155u L=0.04u
M8858 U4459/XI20-net17 n4308 VSS VSS nmos W=0.155u L=0.04u
M8859 VDD g1682 U4459/net22 VDD pmos W=0.205u L=0.04u
M8860 VDD n4309 U4459/net22 VDD pmos W=0.205u L=0.04u
M8861 U4459/net16 n4306 n407 VDD pmos W=0.205u L=0.04u
M8862 U4459/net16 n4307 n407 VDD pmos W=0.205u L=0.04u
M8863 U4459/net22 g1678 U4459/net16 VDD pmos W=0.205u L=0.04u
M8864 U4459/net22 n4308 U4459/net16 VDD pmos W=0.205u L=0.04u
M8865 n4307 n3394 VSS VSS nmos W=0.135u L=0.04u
M8866 n4307 n3394 VDD VDD pmos W=0.205u L=0.04u
M8867 n3394 n4311 U4461/net27 VSS nmos W=0.155u L=0.04u
M8868 U4461/net39 g986 VSS VSS nmos W=0.155u L=0.04u
M8869 U4461/net27 g984 U4461/net39 VSS nmos W=0.155u L=0.04u
M8870 U4461/net27 n4312 U4461/net39 VSS nmos W=0.155u L=0.04u
M8871 n3394 n4310 U4461/net27 VSS nmos W=0.155u L=0.04u
M8872 U4461/net39 g988 VSS VSS nmos W=0.155u L=0.04u
M8873 n3394 g986 U4461/net46 VDD pmos W=0.205u L=0.04u
M8874 U4461/net46 g988 VDD VDD pmos W=0.205u L=0.04u
M8875 n3394 n4310 U4461/net34 VDD pmos W=0.205u L=0.04u
M8876 U4461/net34 n4311 VDD VDD pmos W=0.205u L=0.04u
M8877 n3394 n4312 U4461/net37 VDD pmos W=0.205u L=0.04u
M8878 U4461/net37 g984 VDD VDD pmos W=0.205u L=0.04u
M8879 n4311 n3392 VSS VSS nmos W=0.135u L=0.04u
M8880 n4311 n3392 VDD VDD pmos W=0.205u L=0.04u
M8881 U4463/net29 n4314 VSS VSS nmos W=0.155u L=0.04u
M8882 n3392 g297 U4463/net29 VSS nmos W=0.155u L=0.04u
M8883 n3392 g301 U4463/net23 VSS nmos W=0.155u L=0.04u
M8884 U4463/net23 n4313 VSS VSS nmos W=0.155u L=0.04u
M8885 U4463/net20 n4313 n3392 VDD pmos W=0.205u L=0.04u
M8886 U4463/net20 g301 n3392 VDD pmos W=0.205u L=0.04u
M8887 VDD g297 U4463/net20 VDD pmos W=0.205u L=0.04u
M8888 VDD n4314 U4463/net20 VDD pmos W=0.205u L=0.04u
M8889 n3391 n4303 U4464/net27 VSS nmos W=0.155u L=0.04u
M8890 U4464/net39 g2374 VSS VSS nmos W=0.155u L=0.04u
M8891 U4464/net27 n4304 U4464/net39 VSS nmos W=0.155u L=0.04u
M8892 U4464/net27 n4315 U4464/net39 VSS nmos W=0.155u L=0.04u
M8893 n3391 g2383 U4464/net27 VSS nmos W=0.155u L=0.04u
M8894 U4464/net39 g2375 VSS VSS nmos W=0.155u L=0.04u
M8895 n3391 g2374 U4464/net46 VDD pmos W=0.205u L=0.04u
M8896 U4464/net46 g2375 VDD VDD pmos W=0.205u L=0.04u
M8897 n3391 g2383 U4464/net34 VDD pmos W=0.205u L=0.04u
M8898 U4464/net34 n4303 VDD VDD pmos W=0.205u L=0.04u
M8899 n3391 n4315 U4464/net37 VDD pmos W=0.205u L=0.04u
M8900 U4464/net37 n4304 VDD VDD pmos W=0.205u L=0.04u
M8901 n4315 n408 VSS VSS nmos W=0.135u L=0.04u
M8902 n4315 n408 VDD VDD pmos W=0.205u L=0.04u
M8903 n408 g1681 U4466/XI21-net17 VSS nmos W=0.155u L=0.04u
M8904 U4466/XI21-net17 n4309 VSS VSS nmos W=0.155u L=0.04u
M8905 n408 n4306 U4466/XI6-net17 VSS nmos W=0.155u L=0.04u
M8906 U4466/XI6-net17 n4316 VSS VSS nmos W=0.155u L=0.04u
M8907 n408 g1689 U4466/XI20-net17 VSS nmos W=0.155u L=0.04u
M8908 U4466/XI20-net17 n4308 VSS VSS nmos W=0.155u L=0.04u
M8909 VDD g1681 U4466/net22 VDD pmos W=0.205u L=0.04u
M8910 VDD n4309 U4466/net22 VDD pmos W=0.205u L=0.04u
M8911 U4466/net16 n4306 n408 VDD pmos W=0.205u L=0.04u
M8912 U4466/net16 n4316 n408 VDD pmos W=0.205u L=0.04u
M8913 U4466/net22 g1689 U4466/net16 VDD pmos W=0.205u L=0.04u
M8914 U4466/net22 n4308 U4466/net16 VDD pmos W=0.205u L=0.04u
M8915 n4316 n3390 VSS VSS nmos W=0.135u L=0.04u
M8916 n4316 n3390 VDD VDD pmos W=0.205u L=0.04u
M8917 n3390 n4317 U4468/net27 VSS nmos W=0.155u L=0.04u
M8918 U4468/net39 g986 VSS VSS nmos W=0.155u L=0.04u
M8919 U4468/net27 g995 U4468/net39 VSS nmos W=0.155u L=0.04u
M8920 U4468/net27 n4312 U4468/net39 VSS nmos W=0.155u L=0.04u
M8921 n3390 n4310 U4468/net27 VSS nmos W=0.155u L=0.04u
M8922 U4468/net39 g987 VSS VSS nmos W=0.155u L=0.04u
M8923 n3390 g986 U4468/net46 VDD pmos W=0.205u L=0.04u
M8924 U4468/net46 g987 VDD VDD pmos W=0.205u L=0.04u
M8925 n3390 n4310 U4468/net34 VDD pmos W=0.205u L=0.04u
M8926 U4468/net34 n4317 VDD VDD pmos W=0.205u L=0.04u
M8927 n3390 n4312 U4468/net37 VDD pmos W=0.205u L=0.04u
M8928 U4468/net37 g995 VDD VDD pmos W=0.205u L=0.04u
M8929 n4317 n3389 VSS VSS nmos W=0.135u L=0.04u
M8930 n4317 n3389 VDD VDD pmos W=0.205u L=0.04u
M8931 U4470/net29 n4313 VSS VSS nmos W=0.155u L=0.04u
M8932 n3389 g300 U4470/net29 VSS nmos W=0.155u L=0.04u
M8933 n3389 g308 U4470/net23 VSS nmos W=0.155u L=0.04u
M8934 U4470/net23 n4314 VSS VSS nmos W=0.155u L=0.04u
M8935 U4470/net20 n4314 n3389 VDD pmos W=0.205u L=0.04u
M8936 U4470/net20 g308 n3389 VDD pmos W=0.205u L=0.04u
M8937 VDD g300 U4470/net20 VDD pmos W=0.205u L=0.04u
M8938 VDD n4313 U4470/net20 VDD pmos W=0.205u L=0.04u
M8939 n3388 g2380 U4471/net27 VSS nmos W=0.155u L=0.04u
M8940 U4471/net39 g2374 VSS VSS nmos W=0.155u L=0.04u
M8941 U4471/net27 n4318 U4471/net39 VSS nmos W=0.155u L=0.04u
M8942 U4471/net27 n4304 U4471/net39 VSS nmos W=0.155u L=0.04u
M8943 n3388 n4303 U4471/net27 VSS nmos W=0.155u L=0.04u
M8944 U4471/net39 n4319 VSS VSS nmos W=0.155u L=0.04u
M8945 n3388 g2374 U4471/net46 VDD pmos W=0.205u L=0.04u
M8946 U4471/net46 n4319 VDD VDD pmos W=0.205u L=0.04u
M8947 n3388 n4303 U4471/net34 VDD pmos W=0.205u L=0.04u
M8948 U4471/net34 g2380 VDD VDD pmos W=0.205u L=0.04u
M8949 n3388 n4304 U4471/net37 VDD pmos W=0.205u L=0.04u
M8950 U4471/net37 n4318 VDD VDD pmos W=0.205u L=0.04u
M8951 n4319 g2373 VSS VSS nmos W=0.135u L=0.04u
M8952 n4319 g2373 VDD VDD pmos W=0.205u L=0.04u
M8953 n4318 n409 VSS VSS nmos W=0.135u L=0.04u
M8954 n4318 n409 VDD VDD pmos W=0.205u L=0.04u
M8955 n409 n4309 U4474/XI21-net17 VSS nmos W=0.155u L=0.04u
M8956 U4474/XI21-net17 n4321 VSS VSS nmos W=0.155u L=0.04u
M8957 n409 n4320 U4474/XI6-net17 VSS nmos W=0.155u L=0.04u
M8958 U4474/XI6-net17 n4306 VSS VSS nmos W=0.155u L=0.04u
M8959 n409 n4308 U4474/XI20-net17 VSS nmos W=0.155u L=0.04u
M8960 U4474/XI20-net17 g1686 VSS VSS nmos W=0.155u L=0.04u
M8961 VDD n4309 U4474/net22 VDD pmos W=0.205u L=0.04u
M8962 VDD n4321 U4474/net22 VDD pmos W=0.205u L=0.04u
M8963 U4474/net16 n4320 n409 VDD pmos W=0.205u L=0.04u
M8964 U4474/net16 n4306 n409 VDD pmos W=0.205u L=0.04u
M8965 U4474/net22 n4308 U4474/net16 VDD pmos W=0.205u L=0.04u
M8966 U4474/net22 g1686 U4474/net16 VDD pmos W=0.205u L=0.04u
M8967 n4321 g1679 VSS VSS nmos W=0.135u L=0.04u
M8968 n4321 g1679 VDD VDD pmos W=0.205u L=0.04u
M8969 n3387 n4320 VSS VSS nmos W=0.135u L=0.04u
M8970 n3387 n4320 VDD VDD pmos W=0.205u L=0.04u
M8971 U4477/net19 g986 VSS VSS nmos W=0.155u L=0.04u
M8972 n4320 g986 U4477/net40 VSS nmos W=0.155u L=0.04u
M8973 n4320 U4477/net19 U4477/net36 VSS nmos W=0.155u L=0.04u
M8974 U4477/net40 n4322 VSS VSS nmos W=0.31u L=0.04u
M8975 U4477/net36 g985 VSS VSS nmos W=0.155u L=0.04u
M8976 U4477/net19 g986 VDD VDD pmos W=0.205u L=0.04u
M8977 n4320 U4477/net19 U4477/net26 VDD pmos W=0.325u L=0.04u
M8978 U4477/net26 n4322 VDD VDD pmos W=0.41u L=0.04u
M8979 n4320 g986 U4477/net30 VDD pmos W=0.325u L=0.04u
M8980 U4477/net30 g985 VDD VDD pmos W=0.205u L=0.04u
M8981 n4322 U4478/net28 VSS VSS nmos W=0.155u L=0.04u
M8982 U4478/net47 n4169 VSS VSS nmos W=0.155u L=0.04u
M8983 U4478/net28 U4478/net6 U4478/net47 VSS nmos W=0.155u L=0.04u
M8984 U4478/net44 n3386 VSS VSS nmos W=0.155u L=0.04u
M8985 U4478/net28 g6712 U4478/net44 VSS nmos W=0.155u L=0.04u
M8986 U4478/net6 g6712 VSS VSS nmos W=0.155u L=0.04u
M8987 n4322 U4478/net28 VDD VDD pmos W=0.205u L=0.04u
M8988 VDD n4169 U4478/net47 VDD pmos W=0.205u L=0.04u
M8989 U4478/net47 g6712 U4478/net28 VDD pmos W=0.205u L=0.04u
M8990 U4478/net44 U4478/net6 U4478/net28 VDD pmos W=0.205u L=0.04u
M8991 VDD n3386 U4478/net44 VDD pmos W=0.205u L=0.04u
M8992 VDD g6712 U4478/net6 VDD pmos W=0.205u L=0.04u
M8993 n4169 g992 VSS VSS nmos W=0.135u L=0.04u
M8994 n4169 g992 VDD VDD pmos W=0.205u L=0.04u
M8995 U4480/net17 g299 VSS VSS nmos W=0.155u L=0.04u
M8996 U4480/net17 g298 VSS VSS nmos W=0.155u L=0.04u
M8997 U4480/net63 g305 VSS VSS nmos W=0.155u L=0.04u
M8998 n3386 U4480/net17 VSS VSS nmos W=0.155u L=0.04u
M8999 n3386 n4314 U4480/net63 VSS nmos W=0.155u L=0.04u
M9000 n3386 g305 U4480/net31 VDD pmos W=0.205u L=0.04u
M9001 U4480/net39 g299 VDD VDD pmos W=0.195u L=0.04u
M9002 U4480/net31 U4480/net17 VDD VDD pmos W=0.195u L=0.04u
M9003 n3386 n4314 U4480/net31 VDD pmos W=0.195u L=0.04u
M9004 U4480/net17 g298 U4480/net39 VDD pmos W=0.195u L=0.04u
M9005 n3385 n4303 U4481/net27 VSS nmos W=0.155u L=0.04u
M9006 U4481/net39 g2374 VSS VSS nmos W=0.155u L=0.04u
M9007 U4481/net27 n4304 U4481/net39 VSS nmos W=0.155u L=0.04u
M9008 U4481/net27 n4323 U4481/net39 VSS nmos W=0.155u L=0.04u
M9009 n3385 g2369 U4481/net27 VSS nmos W=0.155u L=0.04u
M9010 U4481/net39 g2379 VSS VSS nmos W=0.155u L=0.04u
M9011 n3385 g2374 U4481/net46 VDD pmos W=0.205u L=0.04u
M9012 U4481/net46 g2379 VDD VDD pmos W=0.205u L=0.04u
M9013 n3385 g2369 U4481/net34 VDD pmos W=0.205u L=0.04u
M9014 U4481/net34 n4303 VDD VDD pmos W=0.205u L=0.04u
M9015 n3385 n4323 U4481/net37 VDD pmos W=0.205u L=0.04u
M9016 U4481/net37 n4304 VDD VDD pmos W=0.205u L=0.04u
M9017 n4323 n410 VSS VSS nmos W=0.135u L=0.04u
M9018 n4323 n410 VDD VDD pmos W=0.205u L=0.04u
M9019 n410 g1685 U4483/XI21-net17 VSS nmos W=0.155u L=0.04u
M9020 U4483/XI21-net17 n4309 VSS VSS nmos W=0.155u L=0.04u
M9021 n410 n4306 U4483/XI6-net17 VSS nmos W=0.155u L=0.04u
M9022 U4483/XI6-net17 n4324 VSS VSS nmos W=0.155u L=0.04u
M9023 n410 g1675 U4483/XI20-net17 VSS nmos W=0.155u L=0.04u
M9024 U4483/XI20-net17 n4308 VSS VSS nmos W=0.155u L=0.04u
M9025 VDD g1685 U4483/net22 VDD pmos W=0.205u L=0.04u
M9026 VDD n4309 U4483/net22 VDD pmos W=0.205u L=0.04u
M9027 U4483/net16 n4306 n410 VDD pmos W=0.205u L=0.04u
M9028 U4483/net16 n4324 n410 VDD pmos W=0.205u L=0.04u
M9029 U4483/net22 g1675 U4483/net16 VDD pmos W=0.205u L=0.04u
M9030 U4483/net22 n4308 U4483/net16 VDD pmos W=0.205u L=0.04u
M9031 n4324 n3384 VSS VSS nmos W=0.135u L=0.04u
M9032 n4324 n3384 VDD VDD pmos W=0.205u L=0.04u
M9033 n3384 n4325 U4485/net27 VSS nmos W=0.155u L=0.04u
M9034 U4485/net39 g986 VSS VSS nmos W=0.155u L=0.04u
M9035 U4485/net27 g981 U4485/net39 VSS nmos W=0.155u L=0.04u
M9036 U4485/net27 n4312 U4485/net39 VSS nmos W=0.155u L=0.04u
M9037 n3384 n4310 U4485/net27 VSS nmos W=0.155u L=0.04u
M9038 U4485/net39 g991 VSS VSS nmos W=0.155u L=0.04u
M9039 n3384 g986 U4485/net46 VDD pmos W=0.205u L=0.04u
M9040 U4485/net46 g991 VDD VDD pmos W=0.205u L=0.04u
M9041 n3384 n4310 U4485/net34 VDD pmos W=0.205u L=0.04u
M9042 U4485/net34 n4325 VDD VDD pmos W=0.205u L=0.04u
M9043 n3384 n4312 U4485/net37 VDD pmos W=0.205u L=0.04u
M9044 U4485/net37 g981 VDD VDD pmos W=0.205u L=0.04u
M9045 n4325 n3383 VSS VSS nmos W=0.135u L=0.04u
M9046 n4325 n3383 VDD VDD pmos W=0.205u L=0.04u
M9047 U4487/net29 n4314 VSS VSS nmos W=0.155u L=0.04u
M9048 n3383 g294 U4487/net29 VSS nmos W=0.155u L=0.04u
M9049 n3383 g304 U4487/net23 VSS nmos W=0.155u L=0.04u
M9050 U4487/net23 n4313 VSS VSS nmos W=0.155u L=0.04u
M9051 U4487/net20 n4313 n3383 VDD pmos W=0.205u L=0.04u
M9052 U4487/net20 g304 n3383 VDD pmos W=0.205u L=0.04u
M9053 VDD g294 U4487/net20 VDD pmos W=0.205u L=0.04u
M9054 VDD n4314 U4487/net20 VDD pmos W=0.205u L=0.04u
M9055 n3382 n4303 U4488/net27 VSS nmos W=0.155u L=0.04u
M9056 U4488/net39 g2374 VSS VSS nmos W=0.155u L=0.04u
M9057 U4488/net27 n4304 U4488/net39 VSS nmos W=0.155u L=0.04u
M9058 U4488/net27 n4326 U4488/net39 VSS nmos W=0.155u L=0.04u
M9059 n3382 g2370 U4488/net27 VSS nmos W=0.155u L=0.04u
M9060 U4488/net39 g2378 VSS VSS nmos W=0.155u L=0.04u
M9061 n3382 g2374 U4488/net46 VDD pmos W=0.205u L=0.04u
M9062 U4488/net46 g2378 VDD VDD pmos W=0.205u L=0.04u
M9063 n3382 g2370 U4488/net34 VDD pmos W=0.205u L=0.04u
M9064 U4488/net34 n4303 VDD VDD pmos W=0.205u L=0.04u
M9065 n3382 n4326 U4488/net37 VDD pmos W=0.205u L=0.04u
M9066 U4488/net37 n4304 VDD VDD pmos W=0.205u L=0.04u
M9067 n4326 n411 VSS VSS nmos W=0.135u L=0.04u
M9068 n4326 n411 VDD VDD pmos W=0.205u L=0.04u
M9069 n411 g1684 U4490/XI21-net17 VSS nmos W=0.155u L=0.04u
M9070 U4490/XI21-net17 n4309 VSS VSS nmos W=0.155u L=0.04u
M9071 n411 n4306 U4490/XI6-net17 VSS nmos W=0.155u L=0.04u
M9072 U4490/XI6-net17 n4327 VSS VSS nmos W=0.155u L=0.04u
M9073 n411 g1676 U4490/XI20-net17 VSS nmos W=0.155u L=0.04u
M9074 U4490/XI20-net17 n4308 VSS VSS nmos W=0.155u L=0.04u
M9075 VDD g1684 U4490/net22 VDD pmos W=0.205u L=0.04u
M9076 VDD n4309 U4490/net22 VDD pmos W=0.205u L=0.04u
M9077 U4490/net16 n4306 n411 VDD pmos W=0.205u L=0.04u
M9078 U4490/net16 n4327 n411 VDD pmos W=0.205u L=0.04u
M9079 U4490/net22 g1676 U4490/net16 VDD pmos W=0.205u L=0.04u
M9080 U4490/net22 n4308 U4490/net16 VDD pmos W=0.205u L=0.04u
M9081 n4327 n3381 VSS VSS nmos W=0.135u L=0.04u
M9082 n4327 n3381 VDD VDD pmos W=0.205u L=0.04u
M9083 n3381 n4328 U4492/net27 VSS nmos W=0.155u L=0.04u
M9084 U4492/net39 g986 VSS VSS nmos W=0.155u L=0.04u
M9085 U4492/net27 g982 U4492/net39 VSS nmos W=0.155u L=0.04u
M9086 U4492/net27 n4312 U4492/net39 VSS nmos W=0.155u L=0.04u
M9087 n3381 n4310 U4492/net27 VSS nmos W=0.155u L=0.04u
M9088 U4492/net39 g990 VSS VSS nmos W=0.155u L=0.04u
M9089 n3381 g986 U4492/net46 VDD pmos W=0.205u L=0.04u
M9090 U4492/net46 g990 VDD VDD pmos W=0.205u L=0.04u
M9091 n3381 n4310 U4492/net34 VDD pmos W=0.205u L=0.04u
M9092 U4492/net34 n4328 VDD VDD pmos W=0.205u L=0.04u
M9093 n3381 n4312 U4492/net37 VDD pmos W=0.205u L=0.04u
M9094 U4492/net37 g982 VDD VDD pmos W=0.205u L=0.04u
M9095 n4328 n3380 VSS VSS nmos W=0.135u L=0.04u
M9096 n4328 n3380 VDD VDD pmos W=0.205u L=0.04u
M9097 U4494/net29 n4314 VSS VSS nmos W=0.155u L=0.04u
M9098 n3380 g295 U4494/net29 VSS nmos W=0.155u L=0.04u
M9099 n3380 g303 U4494/net23 VSS nmos W=0.155u L=0.04u
M9100 U4494/net23 n4313 VSS VSS nmos W=0.155u L=0.04u
M9101 U4494/net20 n4313 n3380 VDD pmos W=0.205u L=0.04u
M9102 U4494/net20 g303 n3380 VDD pmos W=0.205u L=0.04u
M9103 VDD g295 U4494/net20 VDD pmos W=0.205u L=0.04u
M9104 VDD n4314 U4494/net20 VDD pmos W=0.205u L=0.04u
M9105 n3377 n4329 U4495/net27 VSS nmos W=0.155u L=0.04u
M9106 U4495/net39 g2374 VSS VSS nmos W=0.155u L=0.04u
M9107 U4495/net27 g2371 U4495/net39 VSS nmos W=0.155u L=0.04u
M9108 U4495/net27 n4303 U4495/net39 VSS nmos W=0.155u L=0.04u
M9109 n3377 n4304 U4495/net27 VSS nmos W=0.155u L=0.04u
M9110 U4495/net39 g2377 VSS VSS nmos W=0.155u L=0.04u
M9111 n3377 g2374 U4495/net46 VDD pmos W=0.205u L=0.04u
M9112 U4495/net46 g2377 VDD VDD pmos W=0.205u L=0.04u
M9113 n3377 n4304 U4495/net34 VDD pmos W=0.205u L=0.04u
M9114 U4495/net34 n4329 VDD VDD pmos W=0.205u L=0.04u
M9115 n3377 n4303 U4495/net37 VDD pmos W=0.205u L=0.04u
M9116 U4495/net37 g2371 VDD VDD pmos W=0.205u L=0.04u
M9117 U4496/XU1-net6 n4330 VSS VSS nmos W=0.155u L=0.04u
M9118 n4303 g2374 U4496/XU1-net6 VSS nmos W=0.155u L=0.04u
M9119 n4303 n4330 VDD VDD pmos W=0.155u L=0.04u
M9120 n4303 g2374 VDD VDD pmos W=0.155u L=0.04u
M9121 n4329 n412 VSS VSS nmos W=0.135u L=0.04u
M9122 n4329 n412 VDD VDD pmos W=0.205u L=0.04u
M9123 n412 g1683 U4498/XI21-net17 VSS nmos W=0.155u L=0.04u
M9124 U4498/XI21-net17 n4309 VSS VSS nmos W=0.155u L=0.04u
M9125 n412 n4306 U4498/XI6-net17 VSS nmos W=0.155u L=0.04u
M9126 U4498/XI6-net17 n4331 VSS VSS nmos W=0.155u L=0.04u
M9127 n412 g1677 U4498/XI20-net17 VSS nmos W=0.155u L=0.04u
M9128 U4498/XI20-net17 n4308 VSS VSS nmos W=0.155u L=0.04u
M9129 VDD g1683 U4498/net22 VDD pmos W=0.205u L=0.04u
M9130 VDD n4309 U4498/net22 VDD pmos W=0.205u L=0.04u
M9131 U4498/net16 n4306 n412 VDD pmos W=0.205u L=0.04u
M9132 U4498/net16 n4331 n412 VDD pmos W=0.205u L=0.04u
M9133 U4498/net22 g1677 U4498/net16 VDD pmos W=0.205u L=0.04u
M9134 U4498/net22 n4308 U4498/net16 VDD pmos W=0.205u L=0.04u
M9135 n4308 n4309 VSS VSS nmos W=0.155u L=0.04u
M9136 n4308 g7014 VSS VSS nmos W=0.155u L=0.04u
M9137 U4499/XI1-net8 g7014 VDD VDD pmos W=0.205u L=0.04u
M9138 n4308 n4309 U4499/XI1-net8 VDD pmos W=0.205u L=0.04u
M9139 n4331 n3378 VSS VSS nmos W=0.135u L=0.04u
M9140 n4331 n3378 VDD VDD pmos W=0.205u L=0.04u
M9141 n3378 n4332 U4501/net27 VSS nmos W=0.155u L=0.04u
M9142 U4501/net39 g986 VSS VSS nmos W=0.155u L=0.04u
M9143 U4501/net27 g983 U4501/net39 VSS nmos W=0.155u L=0.04u
M9144 U4501/net27 n4312 U4501/net39 VSS nmos W=0.155u L=0.04u
M9145 n3378 n4310 U4501/net27 VSS nmos W=0.155u L=0.04u
M9146 U4501/net39 g989 VSS VSS nmos W=0.155u L=0.04u
M9147 n3378 g986 U4501/net46 VDD pmos W=0.205u L=0.04u
M9148 U4501/net46 g989 VDD VDD pmos W=0.205u L=0.04u
M9149 n3378 n4310 U4501/net34 VDD pmos W=0.205u L=0.04u
M9150 U4501/net34 n4332 VDD VDD pmos W=0.205u L=0.04u
M9151 n3378 n4312 U4501/net37 VDD pmos W=0.205u L=0.04u
M9152 U4501/net37 g983 VDD VDD pmos W=0.205u L=0.04u
M9153 U4502/XU1-net6 n4333 VSS VSS nmos W=0.155u L=0.04u
M9154 n4312 g986 U4502/XU1-net6 VSS nmos W=0.155u L=0.04u
M9155 n4312 n4333 VDD VDD pmos W=0.155u L=0.04u
M9156 n4312 g986 VDD VDD pmos W=0.155u L=0.04u
M9157 n4332 n3379 VSS VSS nmos W=0.135u L=0.04u
M9158 n4332 n3379 VDD VDD pmos W=0.205u L=0.04u
M9159 U4504/net29 n4314 VSS VSS nmos W=0.155u L=0.04u
M9160 n3379 g296 U4504/net29 VSS nmos W=0.155u L=0.04u
M9161 n3379 g302 U4504/net23 VSS nmos W=0.155u L=0.04u
M9162 U4504/net23 n4313 VSS VSS nmos W=0.155u L=0.04u
M9163 U4504/net20 n4313 n3379 VDD pmos W=0.205u L=0.04u
M9164 U4504/net20 g302 n3379 VDD pmos W=0.205u L=0.04u
M9165 VDD g296 U4504/net20 VDD pmos W=0.205u L=0.04u
M9166 VDD n4314 U4504/net20 VDD pmos W=0.205u L=0.04u
M9167 n4314 n4313 VSS VSS nmos W=0.155u L=0.04u
M9168 n4314 g6447 VSS VSS nmos W=0.155u L=0.04u
M9169 U4505/XI1-net8 g6447 VDD VDD pmos W=0.205u L=0.04u
M9170 n4314 n4313 U4505/XI1-net8 VDD pmos W=0.205u L=0.04u
M9171 n4313 g299 VSS VSS nmos W=0.135u L=0.04u
M9172 n4313 g299 VDD VDD pmos W=0.205u L=0.04u
M9173 U4507/XU1-net6 g986 VSS VSS nmos W=0.155u L=0.04u
M9174 n4310 g6712 U4507/XU1-net6 VSS nmos W=0.155u L=0.04u
M9175 n4310 g986 VDD VDD pmos W=0.155u L=0.04u
M9176 n4310 g6712 VDD VDD pmos W=0.155u L=0.04u
M9177 n4306 n4334 VSS VSS nmos W=0.155u L=0.04u
M9178 n4306 n4309 VSS VSS nmos W=0.155u L=0.04u
M9179 U4508/XI1-net8 n4309 VDD VDD pmos W=0.205u L=0.04u
M9180 n4306 n4334 U4508/XI1-net8 VDD pmos W=0.205u L=0.04u
M9181 n4309 g1680 VSS VSS nmos W=0.135u L=0.04u
M9182 n4309 g1680 VDD VDD pmos W=0.205u L=0.04u
M9183 U4510/XU1-net6 g7264 VSS VSS nmos W=0.155u L=0.04u
M9184 n4304 g2374 U4510/XU1-net6 VSS nmos W=0.155u L=0.04u
M9185 n4304 g7264 VDD VDD pmos W=0.155u L=0.04u
M9186 n4304 g2374 VDD VDD pmos W=0.155u L=0.04u
M9187 U4511/net19 g7909 VSS VSS nmos W=0.155u L=0.04u
M9188 n3376 g7909 U4511/net40 VSS nmos W=0.155u L=0.04u
M9189 n3376 U4511/net19 U4511/net36 VSS nmos W=0.155u L=0.04u
M9190 U4511/net40 n4335 VSS VSS nmos W=0.31u L=0.04u
M9191 U4511/net36 g465 VSS VSS nmos W=0.155u L=0.04u
M9192 U4511/net19 g7909 VDD VDD pmos W=0.205u L=0.04u
M9193 n3376 U4511/net19 U4511/net26 VDD pmos W=0.325u L=0.04u
M9194 U4511/net26 n4335 VDD VDD pmos W=0.41u L=0.04u
M9195 n3376 g7909 U4511/net30 VDD pmos W=0.325u L=0.04u
M9196 U4511/net30 g465 VDD VDD pmos W=0.205u L=0.04u
M9197 U4512/net19 g7956 VSS VSS nmos W=0.155u L=0.04u
M9198 n3375 g7956 U4512/net40 VSS nmos W=0.155u L=0.04u
M9199 n3375 U4512/net19 U4512/net36 VSS nmos W=0.155u L=0.04u
M9200 U4512/net40 n4335 VSS VSS nmos W=0.31u L=0.04u
M9201 U4512/net36 g468 VSS VSS nmos W=0.155u L=0.04u
M9202 U4512/net19 g7956 VDD VDD pmos W=0.205u L=0.04u
M9203 n3375 U4512/net19 U4512/net26 VDD pmos W=0.325u L=0.04u
M9204 U4512/net26 n4335 VDD VDD pmos W=0.41u L=0.04u
M9205 n3375 g7956 U4512/net30 VDD pmos W=0.325u L=0.04u
M9206 U4512/net30 g468 VDD VDD pmos W=0.205u L=0.04u
M9207 U4513/net19 g485 VSS VSS nmos W=0.155u L=0.04u
M9208 n3374 g485 U4513/net40 VSS nmos W=0.155u L=0.04u
M9209 n3374 U4513/net19 U4513/net36 VSS nmos W=0.155u L=0.04u
M9210 U4513/net40 n4335 VSS VSS nmos W=0.31u L=0.04u
M9211 U4513/net36 g471 VSS VSS nmos W=0.155u L=0.04u
M9212 U4513/net19 g485 VDD VDD pmos W=0.205u L=0.04u
M9213 n3374 U4513/net19 U4513/net26 VDD pmos W=0.325u L=0.04u
M9214 U4513/net26 n4335 VDD VDD pmos W=0.41u L=0.04u
M9215 n3374 g485 U4513/net30 VDD pmos W=0.325u L=0.04u
M9216 U4513/net30 g471 VDD VDD pmos W=0.205u L=0.04u
M9217 U4514/net19 g485 VSS VSS nmos W=0.155u L=0.04u
M9218 n3373 g485 U4514/net40 VSS nmos W=0.155u L=0.04u
M9219 n3373 U4514/net19 U4514/net36 VSS nmos W=0.155u L=0.04u
M9220 U4514/net40 n4336 VSS VSS nmos W=0.31u L=0.04u
M9221 U4514/net36 g461 VSS VSS nmos W=0.155u L=0.04u
M9222 U4514/net19 g485 VDD VDD pmos W=0.205u L=0.04u
M9223 n3373 U4514/net19 U4514/net26 VDD pmos W=0.325u L=0.04u
M9224 U4514/net26 n4336 VDD VDD pmos W=0.41u L=0.04u
M9225 n3373 g485 U4514/net30 VDD pmos W=0.325u L=0.04u
M9226 U4514/net30 g461 VDD VDD pmos W=0.205u L=0.04u
M9227 U4515/net19 g7909 VSS VSS nmos W=0.155u L=0.04u
M9228 n3372 g7909 U4515/net40 VSS nmos W=0.155u L=0.04u
M9229 n3372 U4515/net19 U4515/net36 VSS nmos W=0.155u L=0.04u
M9230 U4515/net40 n4336 VSS VSS nmos W=0.31u L=0.04u
M9231 U4515/net36 g455 VSS VSS nmos W=0.155u L=0.04u
M9232 U4515/net19 g7909 VDD VDD pmos W=0.205u L=0.04u
M9233 n3372 U4515/net19 U4515/net26 VDD pmos W=0.325u L=0.04u
M9234 U4515/net26 n4336 VDD VDD pmos W=0.41u L=0.04u
M9235 n3372 g7909 U4515/net30 VDD pmos W=0.325u L=0.04u
M9236 U4515/net30 g455 VDD VDD pmos W=0.205u L=0.04u
M9237 U4516/net19 g7956 VSS VSS nmos W=0.155u L=0.04u
M9238 n3371 g7956 U4516/net40 VSS nmos W=0.155u L=0.04u
M9239 n3371 U4516/net19 U4516/net36 VSS nmos W=0.155u L=0.04u
M9240 U4516/net40 n4336 VSS VSS nmos W=0.31u L=0.04u
M9241 U4516/net36 g458 VSS VSS nmos W=0.155u L=0.04u
M9242 U4516/net19 g7956 VDD VDD pmos W=0.205u L=0.04u
M9243 n3371 U4516/net19 U4516/net26 VDD pmos W=0.325u L=0.04u
M9244 U4516/net26 n4336 VDD VDD pmos W=0.41u L=0.04u
M9245 n3371 g7956 U4516/net30 VDD pmos W=0.325u L=0.04u
M9246 U4516/net30 g458 VDD VDD pmos W=0.205u L=0.04u
M9247 n4336 n4337 VSS VSS nmos W=0.135u L=0.04u
M9248 n4336 n4337 VDD VDD pmos W=0.205u L=0.04u
M9249 U4518/net19 g7909 VSS VSS nmos W=0.155u L=0.04u
M9250 n3370 g7909 U4518/net40 VSS nmos W=0.155u L=0.04u
M9251 n3370 U4518/net19 U4518/net36 VSS nmos W=0.155u L=0.04u
M9252 U4518/net40 n4338 VSS VSS nmos W=0.31u L=0.04u
M9253 U4518/net36 g477 VSS VSS nmos W=0.155u L=0.04u
M9254 U4518/net19 g7909 VDD VDD pmos W=0.205u L=0.04u
M9255 n3370 U4518/net19 U4518/net26 VDD pmos W=0.325u L=0.04u
M9256 U4518/net26 n4338 VDD VDD pmos W=0.41u L=0.04u
M9257 n3370 g7909 U4518/net30 VDD pmos W=0.325u L=0.04u
M9258 U4518/net30 g477 VDD VDD pmos W=0.205u L=0.04u
M9259 U4519/net19 g7956 VSS VSS nmos W=0.155u L=0.04u
M9260 n3369 g7956 U4519/net40 VSS nmos W=0.155u L=0.04u
M9261 n3369 U4519/net19 U4519/net36 VSS nmos W=0.155u L=0.04u
M9262 U4519/net40 n4338 VSS VSS nmos W=0.31u L=0.04u
M9263 U4519/net36 g478 VSS VSS nmos W=0.155u L=0.04u
M9264 U4519/net19 g7956 VDD VDD pmos W=0.205u L=0.04u
M9265 n3369 U4519/net19 U4519/net26 VDD pmos W=0.325u L=0.04u
M9266 U4519/net26 n4338 VDD VDD pmos W=0.41u L=0.04u
M9267 n3369 g7956 U4519/net30 VDD pmos W=0.325u L=0.04u
M9268 U4519/net30 g478 VDD VDD pmos W=0.205u L=0.04u
M9269 U4520/net19 g485 VSS VSS nmos W=0.155u L=0.04u
M9270 n3368 g485 U4520/net40 VSS nmos W=0.155u L=0.04u
M9271 n3368 U4520/net19 U4520/net36 VSS nmos W=0.155u L=0.04u
M9272 U4520/net40 n4338 VSS VSS nmos W=0.31u L=0.04u
M9273 U4520/net36 g479 VSS VSS nmos W=0.155u L=0.04u
M9274 U4520/net19 g485 VDD VDD pmos W=0.205u L=0.04u
M9275 n3368 U4520/net19 U4520/net26 VDD pmos W=0.325u L=0.04u
M9276 U4520/net26 n4338 VDD VDD pmos W=0.41u L=0.04u
M9277 n3368 g485 U4520/net30 VDD pmos W=0.325u L=0.04u
M9278 U4520/net30 g479 VDD VDD pmos W=0.205u L=0.04u
M9279 U4521/net19 g7956 VSS VSS nmos W=0.155u L=0.04u
M9280 n3367 g7956 U4521/net40 VSS nmos W=0.155u L=0.04u
M9281 n3367 U4521/net19 U4521/net36 VSS nmos W=0.155u L=0.04u
M9282 U4521/net40 g11860 VSS VSS nmos W=0.31u L=0.04u
M9283 U4521/net36 g484 VSS VSS nmos W=0.155u L=0.04u
M9284 U4521/net19 g7956 VDD VDD pmos W=0.205u L=0.04u
M9285 n3367 U4521/net19 U4521/net26 VDD pmos W=0.325u L=0.04u
M9286 U4521/net26 g11860 VDD VDD pmos W=0.41u L=0.04u
M9287 n3367 g7956 U4521/net30 VDD pmos W=0.325u L=0.04u
M9288 U4521/net30 g484 VDD VDD pmos W=0.205u L=0.04u
M9289 U4522/net19 g485 VSS VSS nmos W=0.155u L=0.04u
M9290 n3366 g485 U4522/net40 VSS nmos W=0.155u L=0.04u
M9291 n3366 U4522/net19 U4522/net36 VSS nmos W=0.155u L=0.04u
M9292 U4522/net40 g11860 VSS VSS nmos W=0.31u L=0.04u
M9293 U4522/net36 g464 VSS VSS nmos W=0.155u L=0.04u
M9294 U4522/net19 g485 VDD VDD pmos W=0.205u L=0.04u
M9295 n3366 U4522/net19 U4522/net26 VDD pmos W=0.325u L=0.04u
M9296 U4522/net26 g11860 VDD VDD pmos W=0.41u L=0.04u
M9297 n3366 g485 U4522/net30 VDD pmos W=0.325u L=0.04u
M9298 U4522/net30 g464 VDD VDD pmos W=0.205u L=0.04u
M9299 U4523/net19 g7909 VSS VSS nmos W=0.155u L=0.04u
M9300 n3365 g7909 U4523/net40 VSS nmos W=0.155u L=0.04u
M9301 n3365 U4523/net19 U4523/net36 VSS nmos W=0.155u L=0.04u
M9302 U4523/net40 g11860 VSS VSS nmos W=0.31u L=0.04u
M9303 U4523/net36 g480 VSS VSS nmos W=0.155u L=0.04u
M9304 U4523/net19 g7909 VDD VDD pmos W=0.205u L=0.04u
M9305 n3365 U4523/net19 U4523/net26 VDD pmos W=0.325u L=0.04u
M9306 U4523/net26 g11860 VDD VDD pmos W=0.41u L=0.04u
M9307 n3365 g7909 U4523/net30 VDD pmos W=0.325u L=0.04u
M9308 U4523/net30 g480 VDD VDD pmos W=0.205u L=0.04u
M9309 U4524/net19 g7909 VSS VSS nmos W=0.155u L=0.04u
M9310 n3364 g7909 U4524/net40 VSS nmos W=0.155u L=0.04u
M9311 n3364 U4524/net19 U4524/net36 VSS nmos W=0.155u L=0.04u
M9312 U4524/net40 n4339 VSS VSS nmos W=0.31u L=0.04u
M9313 U4524/net36 g486 VSS VSS nmos W=0.155u L=0.04u
M9314 U4524/net19 g7909 VDD VDD pmos W=0.205u L=0.04u
M9315 n3364 U4524/net19 U4524/net26 VDD pmos W=0.325u L=0.04u
M9316 U4524/net26 n4339 VDD VDD pmos W=0.41u L=0.04u
M9317 n3364 g7909 U4524/net30 VDD pmos W=0.325u L=0.04u
M9318 U4524/net30 g486 VDD VDD pmos W=0.205u L=0.04u
M9319 U4525/net19 g7956 VSS VSS nmos W=0.155u L=0.04u
M9320 n3363 g7956 U4525/net40 VSS nmos W=0.155u L=0.04u
M9321 n3363 U4525/net19 U4525/net36 VSS nmos W=0.155u L=0.04u
M9322 U4525/net40 n4339 VSS VSS nmos W=0.31u L=0.04u
M9323 U4525/net36 g487 VSS VSS nmos W=0.155u L=0.04u
M9324 U4525/net19 g7956 VDD VDD pmos W=0.205u L=0.04u
M9325 n3363 U4525/net19 U4525/net26 VDD pmos W=0.325u L=0.04u
M9326 U4525/net26 n4339 VDD VDD pmos W=0.41u L=0.04u
M9327 n3363 g7956 U4525/net30 VDD pmos W=0.325u L=0.04u
M9328 U4525/net30 g487 VDD VDD pmos W=0.205u L=0.04u
M9329 U4526/net19 g485 VSS VSS nmos W=0.155u L=0.04u
M9330 n3362 g485 U4526/net40 VSS nmos W=0.155u L=0.04u
M9331 n3362 U4526/net19 U4526/net36 VSS nmos W=0.155u L=0.04u
M9332 U4526/net40 n4339 VSS VSS nmos W=0.31u L=0.04u
M9333 U4526/net36 g488 VSS VSS nmos W=0.155u L=0.04u
M9334 U4526/net19 g485 VDD VDD pmos W=0.205u L=0.04u
M9335 n3362 U4526/net19 U4526/net26 VDD pmos W=0.325u L=0.04u
M9336 U4526/net26 n4339 VDD VDD pmos W=0.41u L=0.04u
M9337 n3362 g485 U4526/net30 VDD pmos W=0.325u L=0.04u
M9338 U4526/net30 g488 VDD VDD pmos W=0.205u L=0.04u
M9339 U4527/net19 n4341 VSS VSS nmos W=0.155u L=0.04u
M9340 n3361 n4341 U4527/net40 VSS nmos W=0.155u L=0.04u
M9341 n3361 U4527/net19 U4527/net36 VSS nmos W=0.155u L=0.04u
M9342 U4527/net40 n4340 VSS VSS nmos W=0.31u L=0.04u
M9343 U4527/net36 g164 VSS VSS nmos W=0.155u L=0.04u
M9344 U4527/net19 n4341 VDD VDD pmos W=0.205u L=0.04u
M9345 n3361 U4527/net19 U4527/net26 VDD pmos W=0.325u L=0.04u
M9346 U4527/net26 n4340 VDD VDD pmos W=0.41u L=0.04u
M9347 n3361 n4341 U4527/net30 VDD pmos W=0.325u L=0.04u
M9348 U4527/net30 g164 VDD VDD pmos W=0.205u L=0.04u
M9349 U4528/net19 n4342 VSS VSS nmos W=0.155u L=0.04u
M9350 n3360 n4342 U4528/net40 VSS nmos W=0.155u L=0.04u
M9351 n3360 U4528/net19 U4528/net36 VSS nmos W=0.155u L=0.04u
M9352 U4528/net40 n4340 VSS VSS nmos W=0.31u L=0.04u
M9353 U4528/net36 g162 VSS VSS nmos W=0.155u L=0.04u
M9354 U4528/net19 n4342 VDD VDD pmos W=0.205u L=0.04u
M9355 n3360 U4528/net19 U4528/net26 VDD pmos W=0.325u L=0.04u
M9356 U4528/net26 n4340 VDD VDD pmos W=0.41u L=0.04u
M9357 n3360 n4342 U4528/net30 VDD pmos W=0.325u L=0.04u
M9358 U4528/net30 g162 VDD VDD pmos W=0.205u L=0.04u
M9359 U4529/net19 n4341 VSS VSS nmos W=0.155u L=0.04u
M9360 n3359 n4341 U4529/net40 VSS nmos W=0.155u L=0.04u
M9361 n3359 U4529/net19 U4529/net36 VSS nmos W=0.155u L=0.04u
M9362 U4529/net40 n4343 VSS VSS nmos W=0.31u L=0.04u
M9363 U4529/net36 g161 VSS VSS nmos W=0.155u L=0.04u
M9364 U4529/net19 n4341 VDD VDD pmos W=0.205u L=0.04u
M9365 n3359 U4529/net19 U4529/net26 VDD pmos W=0.325u L=0.04u
M9366 U4529/net26 n4343 VDD VDD pmos W=0.41u L=0.04u
M9367 n3359 n4341 U4529/net30 VDD pmos W=0.325u L=0.04u
M9368 U4529/net30 g161 VDD VDD pmos W=0.205u L=0.04u
M9369 U4530/net19 n4342 VSS VSS nmos W=0.155u L=0.04u
M9370 n3358 n4342 U4530/net40 VSS nmos W=0.155u L=0.04u
M9371 n3358 U4530/net19 U4530/net36 VSS nmos W=0.155u L=0.04u
M9372 U4530/net40 n4343 VSS VSS nmos W=0.31u L=0.04u
M9373 U4530/net36 g159 VSS VSS nmos W=0.155u L=0.04u
M9374 U4530/net19 n4342 VDD VDD pmos W=0.205u L=0.04u
M9375 n3358 U4530/net19 U4530/net26 VDD pmos W=0.325u L=0.04u
M9376 U4530/net26 n4343 VDD VDD pmos W=0.41u L=0.04u
M9377 n3358 n4342 U4530/net30 VDD pmos W=0.325u L=0.04u
M9378 U4530/net30 g159 VDD VDD pmos W=0.205u L=0.04u
M9379 U4531/net19 n4344 VSS VSS nmos W=0.155u L=0.04u
M9380 n3357 n4344 U4531/net40 VSS nmos W=0.155u L=0.04u
M9381 n3357 U4531/net19 U4531/net36 VSS nmos W=0.155u L=0.04u
M9382 U4531/net40 n4343 VSS VSS nmos W=0.31u L=0.04u
M9383 U4531/net36 g160 VSS VSS nmos W=0.155u L=0.04u
M9384 U4531/net19 n4344 VDD VDD pmos W=0.205u L=0.04u
M9385 n3357 U4531/net19 U4531/net26 VDD pmos W=0.325u L=0.04u
M9386 U4531/net26 n4343 VDD VDD pmos W=0.41u L=0.04u
M9387 n3357 n4344 U4531/net30 VDD pmos W=0.325u L=0.04u
M9388 U4531/net30 g160 VDD VDD pmos W=0.205u L=0.04u
M9389 U4532/net19 n4344 VSS VSS nmos W=0.155u L=0.04u
M9390 n3356 n4344 U4532/net40 VSS nmos W=0.155u L=0.04u
M9391 n3356 U4532/net19 U4532/net36 VSS nmos W=0.155u L=0.04u
M9392 U4532/net40 n4340 VSS VSS nmos W=0.31u L=0.04u
M9393 U4532/net36 g163 VSS VSS nmos W=0.155u L=0.04u
M9394 U4532/net19 n4344 VDD VDD pmos W=0.205u L=0.04u
M9395 n3356 U4532/net19 U4532/net26 VDD pmos W=0.325u L=0.04u
M9396 U4532/net26 n4340 VDD VDD pmos W=0.41u L=0.04u
M9397 n3356 n4344 U4532/net30 VDD pmos W=0.325u L=0.04u
M9398 U4532/net30 g163 VDD VDD pmos W=0.205u L=0.04u
M9399 U4533/net19 n4271 VSS VSS nmos W=0.155u L=0.04u
M9400 n3355 n4271 U4533/net40 VSS nmos W=0.155u L=0.04u
M9401 n3355 U4533/net19 U4533/net36 VSS nmos W=0.155u L=0.04u
M9402 U4533/net40 g596 VSS VSS nmos W=0.31u L=0.04u
M9403 U4533/net36 n4345 VSS VSS nmos W=0.155u L=0.04u
M9404 U4533/net19 n4271 VDD VDD pmos W=0.205u L=0.04u
M9405 n3355 U4533/net19 U4533/net26 VDD pmos W=0.325u L=0.04u
M9406 U4533/net26 g596 VDD VDD pmos W=0.41u L=0.04u
M9407 n3355 n4271 U4533/net30 VDD pmos W=0.325u L=0.04u
M9408 U4533/net30 n4345 VDD VDD pmos W=0.205u L=0.04u
M9409 U4534/net19 n4270 VSS VSS nmos W=0.155u L=0.04u
M9410 n3354 n4270 U4534/net40 VSS nmos W=0.155u L=0.04u
M9411 n3354 U4534/net19 U4534/net36 VSS nmos W=0.155u L=0.04u
M9412 U4534/net40 g599 VSS VSS nmos W=0.31u L=0.04u
M9413 U4534/net36 n4345 VSS VSS nmos W=0.155u L=0.04u
M9414 U4534/net19 n4270 VDD VDD pmos W=0.205u L=0.04u
M9415 n3354 U4534/net19 U4534/net26 VDD pmos W=0.325u L=0.04u
M9416 U4534/net26 g599 VDD VDD pmos W=0.41u L=0.04u
M9417 n3354 n4270 U4534/net30 VDD pmos W=0.325u L=0.04u
M9418 U4534/net30 n4345 VDD VDD pmos W=0.205u L=0.04u
M9419 U4535/net19 n4244 VSS VSS nmos W=0.155u L=0.04u
M9420 n3353 n4244 U4535/net40 VSS nmos W=0.155u L=0.04u
M9421 n3353 U4535/net19 U4535/net36 VSS nmos W=0.155u L=0.04u
M9422 U4535/net40 g602 VSS VSS nmos W=0.31u L=0.04u
M9423 U4535/net36 n4345 VSS VSS nmos W=0.155u L=0.04u
M9424 U4535/net19 n4244 VDD VDD pmos W=0.205u L=0.04u
M9425 n3353 U4535/net19 U4535/net26 VDD pmos W=0.325u L=0.04u
M9426 U4535/net26 g602 VDD VDD pmos W=0.41u L=0.04u
M9427 n3353 n4244 U4535/net30 VDD pmos W=0.325u L=0.04u
M9428 U4535/net30 n4345 VDD VDD pmos W=0.205u L=0.04u
M9429 n4345 n4346 VSS VSS nmos W=0.155u L=0.04u
M9430 n4345 n4347 VSS VSS nmos W=0.155u L=0.04u
M9431 U4536/XI1-net8 n4347 VDD VDD pmos W=0.205u L=0.04u
M9432 n4345 n4346 U4536/XI1-net8 VDD pmos W=0.205u L=0.04u
M9433 U4537/net19 n4139 VSS VSS nmos W=0.155u L=0.04u
M9434 n3352 n4139 U4537/net40 VSS nmos W=0.155u L=0.04u
M9435 n3352 U4537/net19 U4537/net36 VSS nmos W=0.155u L=0.04u
M9436 U4537/net40 g1282 VSS VSS nmos W=0.31u L=0.04u
M9437 U4537/net36 n4348 VSS VSS nmos W=0.155u L=0.04u
M9438 U4537/net19 n4139 VDD VDD pmos W=0.205u L=0.04u
M9439 n3352 U4537/net19 U4537/net26 VDD pmos W=0.325u L=0.04u
M9440 U4537/net26 g1282 VDD VDD pmos W=0.41u L=0.04u
M9441 n3352 n4139 U4537/net30 VDD pmos W=0.325u L=0.04u
M9442 U4537/net30 n4348 VDD VDD pmos W=0.205u L=0.04u
M9443 U4538/net19 n4138 VSS VSS nmos W=0.155u L=0.04u
M9444 n3351 n4138 U4538/net40 VSS nmos W=0.155u L=0.04u
M9445 n3351 U4538/net19 U4538/net36 VSS nmos W=0.155u L=0.04u
M9446 U4538/net40 g1285 VSS VSS nmos W=0.31u L=0.04u
M9447 U4538/net36 n4348 VSS VSS nmos W=0.155u L=0.04u
M9448 U4538/net19 n4138 VDD VDD pmos W=0.205u L=0.04u
M9449 n3351 U4538/net19 U4538/net26 VDD pmos W=0.325u L=0.04u
M9450 U4538/net26 g1285 VDD VDD pmos W=0.41u L=0.04u
M9451 n3351 n4138 U4538/net30 VDD pmos W=0.325u L=0.04u
M9452 U4538/net30 n4348 VDD VDD pmos W=0.205u L=0.04u
M9453 U4539/net19 n4136 VSS VSS nmos W=0.155u L=0.04u
M9454 n3350 n4136 U4539/net40 VSS nmos W=0.155u L=0.04u
M9455 n3350 U4539/net19 U4539/net36 VSS nmos W=0.155u L=0.04u
M9456 U4539/net40 g1288 VSS VSS nmos W=0.31u L=0.04u
M9457 U4539/net36 n4348 VSS VSS nmos W=0.155u L=0.04u
M9458 U4539/net19 n4136 VDD VDD pmos W=0.205u L=0.04u
M9459 n3350 U4539/net19 U4539/net26 VDD pmos W=0.325u L=0.04u
M9460 U4539/net26 g1288 VDD VDD pmos W=0.41u L=0.04u
M9461 n3350 n4136 U4539/net30 VDD pmos W=0.325u L=0.04u
M9462 U4539/net30 n4348 VDD VDD pmos W=0.205u L=0.04u
M9463 n4348 n4346 VSS VSS nmos W=0.155u L=0.04u
M9464 n4348 n4349 VSS VSS nmos W=0.155u L=0.04u
M9465 U4540/XI1-net8 n4349 VDD VDD pmos W=0.205u L=0.04u
M9466 n4348 n4346 U4540/XI1-net8 VDD pmos W=0.205u L=0.04u
M9467 U4541/net19 n4031 VSS VSS nmos W=0.155u L=0.04u
M9468 n3349 n4031 U4541/net40 VSS nmos W=0.155u L=0.04u
M9469 n3349 U4541/net19 U4541/net36 VSS nmos W=0.155u L=0.04u
M9470 U4541/net40 g1976 VSS VSS nmos W=0.31u L=0.04u
M9471 U4541/net36 n4350 VSS VSS nmos W=0.155u L=0.04u
M9472 U4541/net19 n4031 VDD VDD pmos W=0.205u L=0.04u
M9473 n3349 U4541/net19 U4541/net26 VDD pmos W=0.325u L=0.04u
M9474 U4541/net26 g1976 VDD VDD pmos W=0.41u L=0.04u
M9475 n3349 n4031 U4541/net30 VDD pmos W=0.325u L=0.04u
M9476 U4541/net30 n4350 VDD VDD pmos W=0.205u L=0.04u
M9477 U4542/net19 n4030 VSS VSS nmos W=0.155u L=0.04u
M9478 n3348 n4030 U4542/net40 VSS nmos W=0.155u L=0.04u
M9479 n3348 U4542/net19 U4542/net36 VSS nmos W=0.155u L=0.04u
M9480 U4542/net40 g1979 VSS VSS nmos W=0.31u L=0.04u
M9481 U4542/net36 n4350 VSS VSS nmos W=0.155u L=0.04u
M9482 U4542/net19 n4030 VDD VDD pmos W=0.205u L=0.04u
M9483 n3348 U4542/net19 U4542/net26 VDD pmos W=0.325u L=0.04u
M9484 U4542/net26 g1979 VDD VDD pmos W=0.41u L=0.04u
M9485 n3348 n4030 U4542/net30 VDD pmos W=0.325u L=0.04u
M9486 U4542/net30 n4350 VDD VDD pmos W=0.205u L=0.04u
M9487 U4543/net19 n4028 VSS VSS nmos W=0.155u L=0.04u
M9488 n3347 n4028 U4543/net40 VSS nmos W=0.155u L=0.04u
M9489 n3347 U4543/net19 U4543/net36 VSS nmos W=0.155u L=0.04u
M9490 U4543/net40 g1982 VSS VSS nmos W=0.31u L=0.04u
M9491 U4543/net36 n4350 VSS VSS nmos W=0.155u L=0.04u
M9492 U4543/net19 n4028 VDD VDD pmos W=0.205u L=0.04u
M9493 n3347 U4543/net19 U4543/net26 VDD pmos W=0.325u L=0.04u
M9494 U4543/net26 g1982 VDD VDD pmos W=0.41u L=0.04u
M9495 n3347 n4028 U4543/net30 VDD pmos W=0.325u L=0.04u
M9496 U4543/net30 n4350 VDD VDD pmos W=0.205u L=0.04u
M9497 n4350 n4346 VSS VSS nmos W=0.155u L=0.04u
M9498 n4350 n4351 VSS VSS nmos W=0.155u L=0.04u
M9499 U4544/XI1-net8 n4351 VDD VDD pmos W=0.205u L=0.04u
M9500 n4350 n4346 U4544/XI1-net8 VDD pmos W=0.205u L=0.04u
M9501 U4545/net19 n4271 VSS VSS nmos W=0.155u L=0.04u
M9502 n3346 n4271 U4545/net40 VSS nmos W=0.155u L=0.04u
M9503 n3346 U4545/net19 U4545/net36 VSS nmos W=0.155u L=0.04u
M9504 U4545/net40 g587 VSS VSS nmos W=0.31u L=0.04u
M9505 U4545/net36 n4352 VSS VSS nmos W=0.155u L=0.04u
M9506 U4545/net19 n4271 VDD VDD pmos W=0.205u L=0.04u
M9507 n3346 U4545/net19 U4545/net26 VDD pmos W=0.325u L=0.04u
M9508 U4545/net26 g587 VDD VDD pmos W=0.41u L=0.04u
M9509 n3346 n4271 U4545/net30 VDD pmos W=0.325u L=0.04u
M9510 U4545/net30 n4352 VDD VDD pmos W=0.205u L=0.04u
M9511 U4546/net19 n4270 VSS VSS nmos W=0.155u L=0.04u
M9512 n3345 n4270 U4546/net40 VSS nmos W=0.155u L=0.04u
M9513 n3345 U4546/net19 U4546/net36 VSS nmos W=0.155u L=0.04u
M9514 U4546/net40 g590 VSS VSS nmos W=0.31u L=0.04u
M9515 U4546/net36 n4352 VSS VSS nmos W=0.155u L=0.04u
M9516 U4546/net19 n4270 VDD VDD pmos W=0.205u L=0.04u
M9517 n3345 U4546/net19 U4546/net26 VDD pmos W=0.325u L=0.04u
M9518 U4546/net26 g590 VDD VDD pmos W=0.41u L=0.04u
M9519 n3345 n4270 U4546/net30 VDD pmos W=0.325u L=0.04u
M9520 U4546/net30 n4352 VDD VDD pmos W=0.205u L=0.04u
M9521 U4547/net19 n4244 VSS VSS nmos W=0.155u L=0.04u
M9522 n3344 n4244 U4547/net40 VSS nmos W=0.155u L=0.04u
M9523 n3344 U4547/net19 U4547/net36 VSS nmos W=0.155u L=0.04u
M9524 U4547/net40 g593 VSS VSS nmos W=0.31u L=0.04u
M9525 U4547/net36 n4352 VSS VSS nmos W=0.155u L=0.04u
M9526 U4547/net19 n4244 VDD VDD pmos W=0.205u L=0.04u
M9527 n3344 U4547/net19 U4547/net26 VDD pmos W=0.325u L=0.04u
M9528 U4547/net26 g593 VDD VDD pmos W=0.41u L=0.04u
M9529 n3344 n4244 U4547/net30 VDD pmos W=0.325u L=0.04u
M9530 U4547/net30 n4352 VDD VDD pmos W=0.205u L=0.04u
M9531 n4352 n4346 VSS VSS nmos W=0.155u L=0.04u
M9532 n4352 n4353 VSS VSS nmos W=0.155u L=0.04u
M9533 U4548/XI1-net8 n4353 VDD VDD pmos W=0.205u L=0.04u
M9534 n4352 n4346 U4548/XI1-net8 VDD pmos W=0.205u L=0.04u
M9535 U4549/net19 n4271 VSS VSS nmos W=0.155u L=0.04u
M9536 n3343 n4271 U4549/net40 VSS nmos W=0.155u L=0.04u
M9537 n3343 U4549/net19 U4549/net36 VSS nmos W=0.155u L=0.04u
M9538 U4549/net40 g605 VSS VSS nmos W=0.31u L=0.04u
M9539 U4549/net36 n4354 VSS VSS nmos W=0.155u L=0.04u
M9540 U4549/net19 n4271 VDD VDD pmos W=0.205u L=0.04u
M9541 n3343 U4549/net19 U4549/net26 VDD pmos W=0.325u L=0.04u
M9542 U4549/net26 g605 VDD VDD pmos W=0.41u L=0.04u
M9543 n3343 n4271 U4549/net30 VDD pmos W=0.325u L=0.04u
M9544 U4549/net30 n4354 VDD VDD pmos W=0.205u L=0.04u
M9545 U4550/net19 n4270 VSS VSS nmos W=0.155u L=0.04u
M9546 n3342 n4270 U4550/net40 VSS nmos W=0.155u L=0.04u
M9547 n3342 U4550/net19 U4550/net36 VSS nmos W=0.155u L=0.04u
M9548 U4550/net40 g608 VSS VSS nmos W=0.31u L=0.04u
M9549 U4550/net36 n4354 VSS VSS nmos W=0.155u L=0.04u
M9550 U4550/net19 n4270 VDD VDD pmos W=0.205u L=0.04u
M9551 n3342 U4550/net19 U4550/net26 VDD pmos W=0.325u L=0.04u
M9552 U4550/net26 g608 VDD VDD pmos W=0.41u L=0.04u
M9553 n3342 n4270 U4550/net30 VDD pmos W=0.325u L=0.04u
M9554 U4550/net30 n4354 VDD VDD pmos W=0.205u L=0.04u
M9555 U4551/net19 n4244 VSS VSS nmos W=0.155u L=0.04u
M9556 n3341 n4244 U4551/net40 VSS nmos W=0.155u L=0.04u
M9557 n3341 U4551/net19 U4551/net36 VSS nmos W=0.155u L=0.04u
M9558 U4551/net40 g611 VSS VSS nmos W=0.31u L=0.04u
M9559 U4551/net36 n4354 VSS VSS nmos W=0.155u L=0.04u
M9560 U4551/net19 n4244 VDD VDD pmos W=0.205u L=0.04u
M9561 n3341 U4551/net19 U4551/net26 VDD pmos W=0.325u L=0.04u
M9562 U4551/net26 g611 VDD VDD pmos W=0.41u L=0.04u
M9563 n3341 n4244 U4551/net30 VDD pmos W=0.325u L=0.04u
M9564 U4551/net30 n4354 VDD VDD pmos W=0.205u L=0.04u
M9565 n4354 U4552/net28 VSS VSS nmos W=0.155u L=0.04u
M9566 U4552/net47 n4355 VSS VSS nmos W=0.155u L=0.04u
M9567 U4552/net28 U4552/net6 U4552/net47 VSS nmos W=0.155u L=0.04u
M9568 U4552/net44 n4356 VSS VSS nmos W=0.155u L=0.04u
M9569 U4552/net28 n4346 U4552/net44 VSS nmos W=0.155u L=0.04u
M9570 U4552/net6 n4346 VSS VSS nmos W=0.155u L=0.04u
M9571 n4354 U4552/net28 VDD VDD pmos W=0.205u L=0.04u
M9572 VDD n4355 U4552/net47 VDD pmos W=0.205u L=0.04u
M9573 U4552/net47 n4346 U4552/net28 VDD pmos W=0.205u L=0.04u
M9574 U4552/net44 U4552/net6 U4552/net28 VDD pmos W=0.205u L=0.04u
M9575 VDD n4356 U4552/net44 VDD pmos W=0.205u L=0.04u
M9576 VDD n4346 U4552/net6 VDD pmos W=0.205u L=0.04u
M9577 n4356 n4357 VSS VSS nmos W=0.155u L=0.04u
M9578 n4356 n4358 VSS VSS nmos W=0.155u L=0.04u
M9579 U4553/XI1-net8 n4358 VDD VDD pmos W=0.205u L=0.04u
M9580 n4356 n4357 U4553/XI1-net8 VDD pmos W=0.205u L=0.04u
M9581 U4554/net19 n4353 VSS VSS nmos W=0.155u L=0.04u
M9582 n4357 n4353 U4554/net40 VSS nmos W=0.155u L=0.04u
M9583 n4357 U4554/net19 U4554/net36 VSS nmos W=0.155u L=0.04u
M9584 U4554/net40 n4359 VSS VSS nmos W=0.31u L=0.04u
M9585 U4554/net36 n4347 VSS VSS nmos W=0.155u L=0.04u
M9586 U4554/net19 n4353 VDD VDD pmos W=0.205u L=0.04u
M9587 n4357 U4554/net19 U4554/net26 VDD pmos W=0.325u L=0.04u
M9588 U4554/net26 n4359 VDD VDD pmos W=0.41u L=0.04u
M9589 n4357 n4353 U4554/net30 VDD pmos W=0.325u L=0.04u
M9590 U4554/net30 n4347 VDD VDD pmos W=0.205u L=0.04u
M9591 U4555/net19 n4271 VSS VSS nmos W=0.155u L=0.04u
M9592 n3340 n4271 U4555/net40 VSS nmos W=0.155u L=0.04u
M9593 n3340 U4555/net19 U4555/net36 VSS nmos W=0.155u L=0.04u
M9594 U4555/net40 g614 VSS VSS nmos W=0.31u L=0.04u
M9595 U4555/net36 n4360 VSS VSS nmos W=0.155u L=0.04u
M9596 U4555/net19 n4271 VDD VDD pmos W=0.205u L=0.04u
M9597 n3340 U4555/net19 U4555/net26 VDD pmos W=0.325u L=0.04u
M9598 U4555/net26 g614 VDD VDD pmos W=0.41u L=0.04u
M9599 n3340 n4271 U4555/net30 VDD pmos W=0.325u L=0.04u
M9600 U4555/net30 n4360 VDD VDD pmos W=0.205u L=0.04u
M9601 U4556/net19 n4270 VSS VSS nmos W=0.155u L=0.04u
M9602 n3339 n4270 U4556/net40 VSS nmos W=0.155u L=0.04u
M9603 n3339 U4556/net19 U4556/net36 VSS nmos W=0.155u L=0.04u
M9604 U4556/net40 g617 VSS VSS nmos W=0.31u L=0.04u
M9605 U4556/net36 n4360 VSS VSS nmos W=0.155u L=0.04u
M9606 U4556/net19 n4270 VDD VDD pmos W=0.205u L=0.04u
M9607 n3339 U4556/net19 U4556/net26 VDD pmos W=0.325u L=0.04u
M9608 U4556/net26 g617 VDD VDD pmos W=0.41u L=0.04u
M9609 n3339 n4270 U4556/net30 VDD pmos W=0.325u L=0.04u
M9610 U4556/net30 n4360 VDD VDD pmos W=0.205u L=0.04u
M9611 U4557/net19 n4244 VSS VSS nmos W=0.155u L=0.04u
M9612 n3338 n4244 U4557/net40 VSS nmos W=0.155u L=0.04u
M9613 n3338 U4557/net19 U4557/net36 VSS nmos W=0.155u L=0.04u
M9614 U4557/net40 g620 VSS VSS nmos W=0.31u L=0.04u
M9615 U4557/net36 n4360 VSS VSS nmos W=0.155u L=0.04u
M9616 U4557/net19 n4244 VDD VDD pmos W=0.205u L=0.04u
M9617 n3338 U4557/net19 U4557/net26 VDD pmos W=0.325u L=0.04u
M9618 U4557/net26 g620 VDD VDD pmos W=0.41u L=0.04u
M9619 n3338 n4244 U4557/net30 VDD pmos W=0.325u L=0.04u
M9620 U4557/net30 n4360 VDD VDD pmos W=0.205u L=0.04u
M9621 n4360 U4558/net28 VSS VSS nmos W=0.155u L=0.04u
M9622 U4558/net47 n4300 VSS VSS nmos W=0.155u L=0.04u
M9623 U4558/net28 U4558/net6 U4558/net47 VSS nmos W=0.155u L=0.04u
M9624 U4558/net44 n4361 VSS VSS nmos W=0.155u L=0.04u
M9625 U4558/net28 n4346 U4558/net44 VSS nmos W=0.155u L=0.04u
M9626 U4558/net6 n4346 VSS VSS nmos W=0.155u L=0.04u
M9627 n4360 U4558/net28 VDD VDD pmos W=0.205u L=0.04u
M9628 VDD n4300 U4558/net47 VDD pmos W=0.205u L=0.04u
M9629 U4558/net47 n4346 U4558/net28 VDD pmos W=0.205u L=0.04u
M9630 U4558/net44 U4558/net6 U4558/net28 VDD pmos W=0.205u L=0.04u
M9631 VDD n4361 U4558/net44 VDD pmos W=0.205u L=0.04u
M9632 VDD n4346 U4558/net6 VDD pmos W=0.205u L=0.04u
M9633 n4361 n4362 VSS VSS nmos W=0.155u L=0.04u
M9634 n4361 n4359 VSS VSS nmos W=0.155u L=0.04u
M9635 U4559/XI1-net8 n4359 VDD VDD pmos W=0.205u L=0.04u
M9636 n4361 n4362 U4559/XI1-net8 VDD pmos W=0.205u L=0.04u
M9637 U4560/XU1-net6 n4364 VSS VSS nmos W=0.155u L=0.04u
M9638 n4359 n4363 U4560/XU1-net6 VSS nmos W=0.155u L=0.04u
M9639 n4359 n4364 VDD VDD pmos W=0.155u L=0.04u
M9640 n4359 n4363 VDD VDD pmos W=0.155u L=0.04u
M9641 U4561/net19 n4367 VSS VSS nmos W=0.155u L=0.04u
M9642 n4364 n4367 U4561/net40 VSS nmos W=0.155u L=0.04u
M9643 n4364 U4561/net19 U4561/net36 VSS nmos W=0.155u L=0.04u
M9644 U4561/net40 n4366 VSS VSS nmos W=0.31u L=0.04u
M9645 U4561/net36 n4365 VSS VSS nmos W=0.155u L=0.04u
M9646 U4561/net19 n4367 VDD VDD pmos W=0.205u L=0.04u
M9647 n4364 U4561/net19 U4561/net26 VDD pmos W=0.325u L=0.04u
M9648 U4561/net26 n4366 VDD VDD pmos W=0.41u L=0.04u
M9649 n4364 n4367 U4561/net30 VDD pmos W=0.325u L=0.04u
M9650 U4561/net30 n4365 VDD VDD pmos W=0.205u L=0.04u
M9651 n4366 U4562/net6 VSS VSS nmos W=0.155u L=0.04u
M9652 U4562/X_u2-net6 n4285 VSS VSS nmos W=0.155u L=0.04u
M9653 U4562/net6 n4368 U4562/X_u2-net6 VSS nmos W=0.155u L=0.04u
M9654 n4366 U4562/net6 VDD VDD pmos W=0.205u L=0.04u
M9655 U4562/net6 n4285 VDD VDD pmos W=0.205u L=0.04u
M9656 U4562/net6 n4368 VDD VDD pmos W=0.205u L=0.04u
M9657 n4365 n4369 VSS VSS nmos W=0.155u L=0.04u
M9658 n4365 n4287 VSS VSS nmos W=0.155u L=0.04u
M9659 U4563/XI1-net8 n4287 VDD VDD pmos W=0.205u L=0.04u
M9660 n4365 n4369 U4563/XI1-net8 VDD pmos W=0.205u L=0.04u
M9661 U4564/net19 n4288 VSS VSS nmos W=0.155u L=0.04u
M9662 n4363 n4288 U4564/net40 VSS nmos W=0.155u L=0.04u
M9663 n4363 U4564/net19 U4564/net36 VSS nmos W=0.155u L=0.04u
M9664 U4564/net40 n4371 VSS VSS nmos W=0.31u L=0.04u
M9665 U4564/net36 n4370 VSS VSS nmos W=0.155u L=0.04u
M9666 U4564/net19 n4288 VDD VDD pmos W=0.205u L=0.04u
M9667 n4363 U4564/net19 U4564/net26 VDD pmos W=0.325u L=0.04u
M9668 U4564/net26 n4371 VDD VDD pmos W=0.41u L=0.04u
M9669 n4363 n4288 U4564/net30 VDD pmos W=0.325u L=0.04u
M9670 U4564/net30 n4370 VDD VDD pmos W=0.205u L=0.04u
M9671 U4565/net8 n4301 U4565/net26 VSS nmos W=0.155u L=0.04u
M9672 U4565/net26 n4373 VSS VSS nmos W=0.155u L=0.04u
M9673 U4565/net29 U4565/net8 VSS VSS nmos W=0.155u L=0.04u
M9674 U4565/net29 n4372 n4371 VSS nmos W=0.155u L=0.04u
M9675 U4565/net29 n4367 n4371 VSS nmos W=0.155u L=0.04u
M9676 U4565/net8 n4373 VDD VDD pmos W=0.205u L=0.04u
M9677 U4565/net8 n4301 VDD VDD pmos W=0.205u L=0.04u
M9678 n4371 U4565/net8 VDD VDD pmos W=0.205u L=0.04u
M9679 n4371 n4372 U4565/net20 VDD pmos W=0.205u L=0.04u
M9680 U4565/net20 n4367 VDD VDD pmos W=0.205u L=0.04u
M9681 n4372 n4375 U4566/XI21-net17 VSS nmos W=0.155u L=0.04u
M9682 U4566/XI21-net17 n4290 VSS VSS nmos W=0.155u L=0.04u
M9683 n4372 n4374 U4566/XI6-net17 VSS nmos W=0.155u L=0.04u
M9684 U4566/XI6-net17 n4291 VSS VSS nmos W=0.155u L=0.04u
M9685 n4372 n4368 U4566/XI20-net17 VSS nmos W=0.155u L=0.04u
M9686 U4566/XI20-net17 n4296 VSS VSS nmos W=0.155u L=0.04u
M9687 VDD n4375 U4566/net22 VDD pmos W=0.205u L=0.04u
M9688 VDD n4290 U4566/net22 VDD pmos W=0.205u L=0.04u
M9689 U4566/net16 n4374 n4372 VDD pmos W=0.205u L=0.04u
M9690 U4566/net16 n4291 n4372 VDD pmos W=0.205u L=0.04u
M9691 U4566/net22 n4368 U4566/net16 VDD pmos W=0.205u L=0.04u
M9692 U4566/net22 n4296 U4566/net16 VDD pmos W=0.205u L=0.04u
M9693 n4370 n4369 U4567/net14 VSS nmos W=0.155u L=0.04u
M9694 U4567/net14 n4377 VSS VSS nmos W=0.155u L=0.04u
M9695 U4567/net14 n4376 VSS VSS nmos W=0.155u L=0.04u
M9696 n4370 n419 U4567/net14 VSS nmos W=0.155u L=0.04u
M9697 n4370 n4374 U4567/net14 VSS nmos W=0.155u L=0.04u
M9698 n4370 n4377 U4567/XI16-net11 VDD pmos W=0.205u L=0.04u
M9699 U4567/XI16-net11 n4376 VDD VDD pmos W=0.205u L=0.04u
M9700 n4370 n419 U4567/XI15-net11 VDD pmos W=0.205u L=0.04u
M9701 U4567/XI15-net11 n4374 U4567/XI15-net18 VDD pmos W=0.205u L=0.04u
M9702 U4567/XI15-net18 n4369 VDD VDD pmos W=0.205u L=0.04u
M9703 n4377 n4374 U4568/XI21-net17 VSS nmos W=0.155u L=0.04u
M9704 U4568/XI21-net17 n4296 VSS VSS nmos W=0.155u L=0.04u
M9705 n4377 n4378 U4568/XI6-net17 VSS nmos W=0.155u L=0.04u
M9706 U4568/XI6-net17 n4290 VSS VSS nmos W=0.155u L=0.04u
M9707 n4377 n4375 U4568/XI20-net17 VSS nmos W=0.155u L=0.04u
M9708 U4568/XI20-net17 n4301 VSS VSS nmos W=0.155u L=0.04u
M9709 VDD n4374 U4568/net22 VDD pmos W=0.205u L=0.04u
M9710 VDD n4296 U4568/net22 VDD pmos W=0.205u L=0.04u
M9711 U4568/net16 n4378 n4377 VDD pmos W=0.205u L=0.04u
M9712 U4568/net16 n4290 n4377 VDD pmos W=0.205u L=0.04u
M9713 U4568/net22 n4375 U4568/net16 VDD pmos W=0.205u L=0.04u
M9714 U4568/net22 n4301 U4568/net16 VDD pmos W=0.205u L=0.04u
M9715 n4296 n4295 VSS VSS nmos W=0.135u L=0.04u
M9716 n4296 n4295 VDD VDD pmos W=0.205u L=0.04u
M9717 U4570/XU1-net6 n419 VSS VSS nmos W=0.155u L=0.04u
M9718 n4295 n421 U4570/XU1-net6 VSS nmos W=0.155u L=0.04u
M9719 n4295 n419 VDD VDD pmos W=0.155u L=0.04u
M9720 n4295 n421 VDD VDD pmos W=0.155u L=0.04u
M9721 U4571/net19 n4347 VSS VSS nmos W=0.155u L=0.04u
M9722 n4362 n4347 U4571/net40 VSS nmos W=0.155u L=0.04u
M9723 n4362 U4571/net19 U4571/net36 VSS nmos W=0.155u L=0.04u
M9724 U4571/net40 n4358 VSS VSS nmos W=0.31u L=0.04u
M9725 U4571/net36 n4353 VSS VSS nmos W=0.155u L=0.04u
M9726 U4571/net19 n4347 VDD VDD pmos W=0.205u L=0.04u
M9727 n4362 U4571/net19 U4571/net26 VDD pmos W=0.325u L=0.04u
M9728 U4571/net26 n4358 VDD VDD pmos W=0.41u L=0.04u
M9729 n4362 n4347 U4571/net30 VDD pmos W=0.325u L=0.04u
M9730 U4571/net30 n4353 VDD VDD pmos W=0.205u L=0.04u
M9731 n4347 n4379 VSS VSS nmos W=0.155u L=0.04u
M9732 n4347 g550 U4572/XI17-net17 VSS nmos W=0.155u L=0.04u
M9733 U4572/XI17-net17 g602 VSS VSS nmos W=0.155u L=0.04u
M9734 n4347 g6642 U4572/XI10-net17 VSS nmos W=0.155u L=0.04u
M9735 U4572/XI10-net17 g599 VSS VSS nmos W=0.155u L=0.04u
M9736 U4572/net30 g6642 n4347 VDD pmos W=0.205u L=0.04u
M9737 U4572/net30 g599 n4347 VDD pmos W=0.205u L=0.04u
M9738 VDD n4379 U4572/net36 VDD pmos W=0.205u L=0.04u
M9739 U4572/net36 g602 U4572/net30 VDD pmos W=0.205u L=0.04u
M9740 U4572/net36 g550 U4572/net30 VDD pmos W=0.205u L=0.04u
M9741 n4379 U4573/net27 VDD VDD pmos W=0.205u L=0.04u
M9742 U4573/net27 g185 U4573/net23 VDD pmos W=0.205u L=0.04u
M9743 U4573/net27 g542 U4573/net23 VDD pmos W=0.205u L=0.04u
M9744 U4573/net27 n3423 U4573/net23 VDD pmos W=0.205u L=0.04u
M9745 U4573/net23 g596 VDD VDD pmos W=0.205u L=0.04u
M9746 U4573/net23 g6485 VDD VDD pmos W=0.205u L=0.04u
M9747 n4379 U4573/net27 VSS VSS nmos W=0.155u L=0.04u
M9748 U4573/XI20-net13 g542 VSS VSS nmos W=0.155u L=0.04u
M9749 U4573/net27 g185 U4573/XI20-net17 VSS nmos W=0.155u L=0.04u
M9750 U4573/XI20-net17 n3423 U4573/XI20-net13 VSS nmos W=0.155u L=0.04u
M9751 U4573/net27 g596 U4573/XI17-net17 VSS nmos W=0.155u L=0.04u
M9752 U4573/XI17-net17 g6485 VSS VSS nmos W=0.155u L=0.04u
M9753 n3423 U4574/net39 VDD VDD pmos W=0.205u L=0.04u
M9754 VDD g567 U4574/net22 VDD pmos W=0.205u L=0.04u
M9755 VDD g6642 U4574/net22 VDD pmos W=0.205u L=0.04u
M9756 U4574/net16 g565 U4574/net39 VDD pmos W=0.205u L=0.04u
M9757 U4574/net16 g6485 U4574/net39 VDD pmos W=0.205u L=0.04u
M9758 U4574/net22 g489 U4574/net16 VDD pmos W=0.205u L=0.04u
M9759 U4574/net22 g550 U4574/net16 VDD pmos W=0.205u L=0.04u
M9760 n3423 U4574/net39 VSS VSS nmos W=0.155u L=0.04u
M9761 U4574/net39 g567 U4574/XI22-net17 VSS nmos W=0.155u L=0.04u
M9762 U4574/XI22-net17 g6642 VSS VSS nmos W=0.155u L=0.04u
M9763 U4574/net39 g565 U4574/XI6-net17 VSS nmos W=0.155u L=0.04u
M9764 U4574/XI6-net17 g6485 VSS VSS nmos W=0.155u L=0.04u
M9765 U4574/net39 g489 U4574/XI21-net17 VSS nmos W=0.155u L=0.04u
M9766 U4574/XI21-net17 g550 VSS VSS nmos W=0.155u L=0.04u
M9767 n4358 n4381 U4575/net26 VSS nmos W=0.155u L=0.04u
M9768 n4358 n4380 U4575/net26 VSS nmos W=0.155u L=0.04u
M9769 U4575/net29 n4383 VSS VSS nmos W=0.155u L=0.04u
M9770 U4575/net26 n420 U4575/net29 VSS nmos W=0.155u L=0.04u
M9771 U4575/net26 n4382 U4575/net29 VSS nmos W=0.155u L=0.04u
M9772 n4358 n4380 U4575/net43 VDD pmos W=0.205u L=0.04u
M9773 n4358 n4382 U4575/net49 VDD pmos W=0.205u L=0.04u
M9774 U4575/net49 n420 VDD VDD pmos W=0.205u L=0.04u
M9775 U4575/net43 n4381 VDD VDD pmos W=0.205u L=0.04u
M9776 n4358 n4383 VDD VDD pmos W=0.205u L=0.04u
M9777 U4576/net19 n4367 VSS VSS nmos W=0.155u L=0.04u
M9778 n4383 n4367 U4576/net40 VSS nmos W=0.155u L=0.04u
M9779 n4383 U4576/net19 U4576/net36 VSS nmos W=0.155u L=0.04u
M9780 U4576/net40 n4385 VSS VSS nmos W=0.31u L=0.04u
M9781 U4576/net36 n4384 VSS VSS nmos W=0.155u L=0.04u
M9782 U4576/net19 n4367 VDD VDD pmos W=0.205u L=0.04u
M9783 n4383 U4576/net19 U4576/net26 VDD pmos W=0.325u L=0.04u
M9784 U4576/net26 n4385 VDD VDD pmos W=0.41u L=0.04u
M9785 n4383 n4367 U4576/net30 VDD pmos W=0.325u L=0.04u
M9786 U4576/net30 n4384 VDD VDD pmos W=0.205u L=0.04u
M9787 n4385 n4386 U4577/net27 VSS nmos W=0.155u L=0.04u
M9788 U4577/net39 n4382 VSS VSS nmos W=0.155u L=0.04u
M9789 U4577/net27 n4387 U4577/net39 VSS nmos W=0.155u L=0.04u
M9790 U4577/net27 n4388 U4577/net39 VSS nmos W=0.155u L=0.04u
M9791 n4385 n4287 U4577/net27 VSS nmos W=0.155u L=0.04u
M9792 U4577/net39 n4285 VSS VSS nmos W=0.155u L=0.04u
M9793 n4385 n4382 U4577/net46 VDD pmos W=0.205u L=0.04u
M9794 U4577/net46 n4285 VDD VDD pmos W=0.205u L=0.04u
M9795 n4385 n4287 U4577/net34 VDD pmos W=0.205u L=0.04u
M9796 U4577/net34 n4386 VDD VDD pmos W=0.205u L=0.04u
M9797 n4385 n4388 U4577/net37 VDD pmos W=0.205u L=0.04u
M9798 U4577/net37 n4387 VDD VDD pmos W=0.205u L=0.04u
M9799 U4578/net14 n4378 U4578/net20 VSS nmos W=0.155u L=0.04u
M9800 U4578/net14 n419 U4578/net20 VSS nmos W=0.155u L=0.04u
M9801 U4578/net20 n4287 VSS VSS nmos W=0.155u L=0.04u
M9802 n4387 U4578/net14 VSS VSS nmos W=0.155u L=0.04u
M9803 n4387 U4578/net14 VDD VDD pmos W=0.205u L=0.04u
M9804 U4578/net14 n4287 VDD VDD pmos W=0.205u L=0.04u
M9805 U4578/net24 n4378 VDD VDD pmos W=0.205u L=0.04u
M9806 U4578/net14 n419 U4578/net24 VDD pmos W=0.205u L=0.04u
M9807 n4386 n4375 VSS VSS nmos W=0.135u L=0.04u
M9808 n4386 n4375 VDD VDD pmos W=0.205u L=0.04u
M9809 n4375 n4378 VSS VSS nmos W=0.155u L=0.04u
M9810 n4375 n4373 VSS VSS nmos W=0.155u L=0.04u
M9811 U4580/XI1-net8 n4373 VDD VDD pmos W=0.205u L=0.04u
M9812 n4375 n4378 U4580/XI1-net8 VDD pmos W=0.205u L=0.04u
M9813 U4581/XU1-net6 n4291 VSS VSS nmos W=0.155u L=0.04u
M9814 n4287 n420 U4581/XU1-net6 VSS nmos W=0.155u L=0.04u
M9815 n4287 n4291 VDD VDD pmos W=0.155u L=0.04u
M9816 n4287 n420 VDD VDD pmos W=0.155u L=0.04u
M9817 n4384 n418 U4582/net14 VSS nmos W=0.155u L=0.04u
M9818 U4582/net14 n4388 VSS VSS nmos W=0.155u L=0.04u
M9819 U4582/net14 n4389 VSS VSS nmos W=0.155u L=0.04u
M9820 n4384 n421 U4582/net14 VSS nmos W=0.155u L=0.04u
M9821 n4384 n4373 U4582/net14 VSS nmos W=0.155u L=0.04u
M9822 n4384 n4388 U4582/XI16-net11 VDD pmos W=0.205u L=0.04u
M9823 U4582/XI16-net11 n4389 VDD VDD pmos W=0.205u L=0.04u
M9824 n4384 n421 U4582/XI15-net11 VDD pmos W=0.205u L=0.04u
M9825 U4582/XI15-net11 n4373 U4582/XI15-net18 VDD pmos W=0.205u L=0.04u
M9826 U4582/XI15-net18 n418 VDD VDD pmos W=0.205u L=0.04u
M9827 n4388 n4374 VSS VSS nmos W=0.135u L=0.04u
M9828 n4388 n4374 VDD VDD pmos W=0.205u L=0.04u
M9829 n4389 n4301 U4584/net27 VSS nmos W=0.155u L=0.04u
M9830 U4584/net27 n4369 VSS VSS nmos W=0.155u L=0.04u
M9831 n4389 n4285 VSS VSS nmos W=0.155u L=0.04u
M9832 n4389 n4369 U4584/net13 VDD pmos W=0.205u L=0.04u
M9833 U4584/net13 n4285 VDD VDD pmos W=0.205u L=0.04u
M9834 n4389 n4301 U4584/net13 VDD pmos W=0.205u L=0.04u
M9835 n4301 n4290 VSS VSS nmos W=0.155u L=0.04u
M9836 n4301 n4291 VSS VSS nmos W=0.155u L=0.04u
M9837 U4585/XI1-net8 n4291 VDD VDD pmos W=0.205u L=0.04u
M9838 n4301 n4290 U4585/XI1-net8 VDD pmos W=0.205u L=0.04u
M9839 n421 n4285 VSS VSS nmos W=0.135u L=0.04u
M9840 n421 n4285 VDD VDD pmos W=0.205u L=0.04u
M9841 n4285 n4271 U4587/net27 VSS nmos W=0.155u L=0.04u
M9842 U4587/net39 n4270 VSS VSS nmos W=0.155u L=0.04u
M9843 U4587/net27 g584 U4587/net39 VSS nmos W=0.155u L=0.04u
M9844 U4587/net27 n4244 U4587/net39 VSS nmos W=0.155u L=0.04u
M9845 n4285 g585 U4587/net27 VSS nmos W=0.155u L=0.04u
M9846 U4587/net39 g586 VSS VSS nmos W=0.155u L=0.04u
M9847 n4285 n4270 U4587/net46 VDD pmos W=0.205u L=0.04u
M9848 U4587/net46 g586 VDD VDD pmos W=0.205u L=0.04u
M9849 n4285 g585 U4587/net34 VDD pmos W=0.205u L=0.04u
M9850 U4587/net34 n4271 VDD VDD pmos W=0.205u L=0.04u
M9851 n4285 n4244 U4587/net37 VDD pmos W=0.205u L=0.04u
M9852 U4587/net37 g584 VDD VDD pmos W=0.205u L=0.04u
M9853 U4588/net19 n418 VSS VSS nmos W=0.155u L=0.04u
M9854 n4382 n418 U4588/net40 VSS nmos W=0.155u L=0.04u
M9855 n4382 U4588/net19 U4588/net36 VSS nmos W=0.155u L=0.04u
M9856 U4588/net40 n4373 VSS VSS nmos W=0.31u L=0.04u
M9857 U4588/net36 n4390 VSS VSS nmos W=0.155u L=0.04u
M9858 U4588/net19 n418 VDD VDD pmos W=0.205u L=0.04u
M9859 n4382 U4588/net19 U4588/net26 VDD pmos W=0.325u L=0.04u
M9860 U4588/net26 n4373 VDD VDD pmos W=0.41u L=0.04u
M9861 n4382 n418 U4588/net30 VDD pmos W=0.325u L=0.04u
M9862 U4588/net30 n4390 VDD VDD pmos W=0.205u L=0.04u
M9863 n418 n4288 VSS VSS nmos W=0.135u L=0.04u
M9864 n418 n4288 VDD VDD pmos W=0.205u L=0.04u
M9865 n4373 g324 U4590/XI21-net17 VSS nmos W=0.155u L=0.04u
M9866 U4590/XI21-net17 g337 VSS VSS nmos W=0.155u L=0.04u
M9867 n4373 g394 U4590/XI6-net17 VSS nmos W=0.155u L=0.04u
M9868 U4590/XI6-net17 g5629 VSS VSS nmos W=0.155u L=0.04u
M9869 n4373 g396 U4590/XI20-net17 VSS nmos W=0.155u L=0.04u
M9870 U4590/XI20-net17 g5648 VSS VSS nmos W=0.155u L=0.04u
M9871 VDD g324 U4590/net22 VDD pmos W=0.205u L=0.04u
M9872 VDD g337 U4590/net22 VDD pmos W=0.205u L=0.04u
M9873 U4590/net16 g394 n4373 VDD pmos W=0.205u L=0.04u
M9874 U4590/net16 g5629 n4373 VDD pmos W=0.205u L=0.04u
M9875 U4590/net22 g396 U4590/net16 VDD pmos W=0.205u L=0.04u
M9876 U4590/net22 g5648 U4590/net16 VDD pmos W=0.205u L=0.04u
M9877 n4390 n4369 VSS VSS nmos W=0.155u L=0.04u
M9878 n4390 n4374 VSS VSS nmos W=0.155u L=0.04u
M9879 U4591/XI1-net8 n4374 VDD VDD pmos W=0.205u L=0.04u
M9880 n4390 n4369 U4591/XI1-net8 VDD pmos W=0.205u L=0.04u
M9881 n4369 n4378 VSS VSS nmos W=0.135u L=0.04u
M9882 n4369 n4378 VDD VDD pmos W=0.205u L=0.04u
M9883 n420 n4290 VSS VSS nmos W=0.135u L=0.04u
M9884 n420 n4290 VDD VDD pmos W=0.205u L=0.04u
M9885 U4594/net19 n4288 VSS VSS nmos W=0.155u L=0.04u
M9886 n4381 n4288 U4594/net40 VSS nmos W=0.155u L=0.04u
M9887 n4381 U4594/net19 U4594/net36 VSS nmos W=0.155u L=0.04u
M9888 U4594/net40 n4378 VSS VSS nmos W=0.31u L=0.04u
M9889 U4594/net36 n4368 VSS VSS nmos W=0.155u L=0.04u
M9890 U4594/net19 n4288 VDD VDD pmos W=0.205u L=0.04u
M9891 n4381 U4594/net19 U4594/net26 VDD pmos W=0.325u L=0.04u
M9892 U4594/net26 n4378 VDD VDD pmos W=0.41u L=0.04u
M9893 n4381 n4288 U4594/net30 VDD pmos W=0.325u L=0.04u
M9894 U4594/net30 n4368 VDD VDD pmos W=0.205u L=0.04u
M9895 n4288 n4271 U4595/net27 VSS nmos W=0.155u L=0.04u
M9896 U4595/net39 n4270 VSS VSS nmos W=0.155u L=0.04u
M9897 U4595/net27 g575 U4595/net39 VSS nmos W=0.155u L=0.04u
M9898 U4595/net27 n4244 U4595/net39 VSS nmos W=0.155u L=0.04u
M9899 n4288 g576 U4595/net27 VSS nmos W=0.155u L=0.04u
M9900 U4595/net39 g577 VSS VSS nmos W=0.155u L=0.04u
M9901 n4288 n4270 U4595/net46 VDD pmos W=0.205u L=0.04u
M9902 U4595/net46 g577 VDD VDD pmos W=0.205u L=0.04u
M9903 n4288 g576 U4595/net34 VDD pmos W=0.205u L=0.04u
M9904 U4595/net34 n4271 VDD VDD pmos W=0.205u L=0.04u
M9905 n4288 n4244 U4595/net37 VDD pmos W=0.205u L=0.04u
M9906 U4595/net37 g575 VDD VDD pmos W=0.205u L=0.04u
M9907 n4368 n4378 VSS VSS nmos W=0.155u L=0.04u
M9908 n4368 n4374 VSS VSS nmos W=0.155u L=0.04u
M9909 U4596/XI1-net8 n4374 VDD VDD pmos W=0.205u L=0.04u
M9910 n4368 n4378 U4596/XI1-net8 VDD pmos W=0.205u L=0.04u
M9911 n4374 g383 U4597/XI21-net17 VSS nmos W=0.155u L=0.04u
M9912 U4597/XI21-net17 g337 VSS VSS nmos W=0.155u L=0.04u
M9913 n4374 g379 U4597/XI6-net17 VSS nmos W=0.155u L=0.04u
M9914 U4597/XI6-net17 g5629 VSS VSS nmos W=0.155u L=0.04u
M9915 n4374 g381 U4597/XI20-net17 VSS nmos W=0.155u L=0.04u
M9916 U4597/XI20-net17 g5648 VSS VSS nmos W=0.155u L=0.04u
M9917 VDD g383 U4597/net22 VDD pmos W=0.205u L=0.04u
M9918 VDD g337 U4597/net22 VDD pmos W=0.205u L=0.04u
M9919 U4597/net16 g379 n4374 VDD pmos W=0.205u L=0.04u
M9920 U4597/net16 g5629 n4374 VDD pmos W=0.205u L=0.04u
M9921 U4597/net22 g381 U4597/net16 VDD pmos W=0.205u L=0.04u
M9922 U4597/net22 g5648 U4597/net16 VDD pmos W=0.205u L=0.04u
M9923 n4378 g368 U4598/XI21-net17 VSS nmos W=0.155u L=0.04u
M9924 U4598/XI21-net17 g337 VSS VSS nmos W=0.155u L=0.04u
M9925 n4378 g364 U4598/XI6-net17 VSS nmos W=0.155u L=0.04u
M9926 U4598/XI6-net17 g5629 VSS VSS nmos W=0.155u L=0.04u
M9927 n4378 g366 U4598/XI20-net17 VSS nmos W=0.155u L=0.04u
M9928 U4598/XI20-net17 g5648 VSS VSS nmos W=0.155u L=0.04u
M9929 VDD g368 U4598/net22 VDD pmos W=0.205u L=0.04u
M9930 VDD g337 U4598/net22 VDD pmos W=0.205u L=0.04u
M9931 U4598/net16 g364 n4378 VDD pmos W=0.205u L=0.04u
M9932 U4598/net16 g5629 n4378 VDD pmos W=0.205u L=0.04u
M9933 U4598/net22 g366 U4598/net16 VDD pmos W=0.205u L=0.04u
M9934 U4598/net22 g5648 U4598/net16 VDD pmos W=0.205u L=0.04u
M9935 U4599/net19 n4367 VSS VSS nmos W=0.155u L=0.04u
M9936 n4380 n4367 U4599/net40 VSS nmos W=0.155u L=0.04u
M9937 n4380 U4599/net19 U4599/net36 VSS nmos W=0.155u L=0.04u
M9938 U4599/net40 n4290 VSS VSS nmos W=0.31u L=0.04u
M9939 U4599/net36 n419 VSS VSS nmos W=0.155u L=0.04u
M9940 U4599/net19 n4367 VDD VDD pmos W=0.205u L=0.04u
M9941 n4380 U4599/net19 U4599/net26 VDD pmos W=0.325u L=0.04u
M9942 U4599/net26 n4290 VDD VDD pmos W=0.41u L=0.04u
M9943 n4380 n4367 U4599/net30 VDD pmos W=0.325u L=0.04u
M9944 U4599/net30 n419 VDD VDD pmos W=0.205u L=0.04u
M9945 n4367 n4376 VSS VSS nmos W=0.135u L=0.04u
M9946 n4367 n4376 VDD VDD pmos W=0.205u L=0.04u
M9947 n4376 g353 U4601/XI21-net17 VSS nmos W=0.155u L=0.04u
M9948 U4601/XI21-net17 g337 VSS VSS nmos W=0.155u L=0.04u
M9949 n4376 g5629 U4601/XI6-net17 VSS nmos W=0.155u L=0.04u
M9950 U4601/XI6-net17 g349 VSS VSS nmos W=0.155u L=0.04u
M9951 n4376 g5648 U4601/XI20-net17 VSS nmos W=0.155u L=0.04u
M9952 U4601/XI20-net17 g351 VSS VSS nmos W=0.155u L=0.04u
M9953 VDD g353 U4601/net22 VDD pmos W=0.205u L=0.04u
M9954 VDD g337 U4601/net22 VDD pmos W=0.205u L=0.04u
M9955 U4601/net16 g5629 n4376 VDD pmos W=0.205u L=0.04u
M9956 U4601/net16 g349 n4376 VDD pmos W=0.205u L=0.04u
M9957 U4601/net22 g5648 U4601/net16 VDD pmos W=0.205u L=0.04u
M9958 U4601/net22 g351 U4601/net16 VDD pmos W=0.205u L=0.04u
M9959 n4290 n4271 U4602/net27 VSS nmos W=0.155u L=0.04u
M9960 U4602/net39 n4270 VSS VSS nmos W=0.155u L=0.04u
M9961 U4602/net27 g581 U4602/net39 VSS nmos W=0.155u L=0.04u
M9962 U4602/net27 n4244 U4602/net39 VSS nmos W=0.155u L=0.04u
M9963 n4290 g582 U4602/net27 VSS nmos W=0.155u L=0.04u
M9964 U4602/net39 g583 VSS VSS nmos W=0.155u L=0.04u
M9965 n4290 n4270 U4602/net46 VDD pmos W=0.205u L=0.04u
M9966 U4602/net46 g583 VDD VDD pmos W=0.205u L=0.04u
M9967 n4290 g582 U4602/net34 VDD pmos W=0.205u L=0.04u
M9968 U4602/net34 n4271 VDD VDD pmos W=0.205u L=0.04u
M9969 n4290 n4244 U4602/net37 VDD pmos W=0.205u L=0.04u
M9970 U4602/net37 g581 VDD VDD pmos W=0.205u L=0.04u
M9971 n419 n4291 VSS VSS nmos W=0.135u L=0.04u
M9972 n419 n4291 VDD VDD pmos W=0.205u L=0.04u
M9973 n4291 n4271 U4604/net27 VSS nmos W=0.155u L=0.04u
M9974 U4604/net39 n4270 VSS VSS nmos W=0.155u L=0.04u
M9975 U4604/net27 g578 U4604/net39 VSS nmos W=0.155u L=0.04u
M9976 U4604/net27 n4244 U4604/net39 VSS nmos W=0.155u L=0.04u
M9977 n4291 g579 U4604/net27 VSS nmos W=0.155u L=0.04u
M9978 U4604/net39 g580 VSS VSS nmos W=0.155u L=0.04u
M9979 n4291 n4270 U4604/net46 VDD pmos W=0.205u L=0.04u
M9980 U4604/net46 g580 VDD VDD pmos W=0.205u L=0.04u
M9981 n4291 g579 U4604/net34 VDD pmos W=0.205u L=0.04u
M9982 U4604/net34 n4271 VDD VDD pmos W=0.205u L=0.04u
M9983 n4291 n4244 U4604/net37 VDD pmos W=0.205u L=0.04u
M9984 U4604/net37 g578 VDD VDD pmos W=0.205u L=0.04u
M9985 n4270 g6642 VSS VSS nmos W=0.135u L=0.04u
M9986 n4270 g6642 VDD VDD pmos W=0.205u L=0.04u
M9987 n4244 g550 VSS VSS nmos W=0.135u L=0.04u
M9988 n4244 g550 VDD VDD pmos W=0.205u L=0.04u
M9989 n4353 n4391 VSS VSS nmos W=0.155u L=0.04u
M9990 n4353 g6485 U4607/XI17-net17 VSS nmos W=0.155u L=0.04u
M9991 U4607/XI17-net17 g587 VSS VSS nmos W=0.155u L=0.04u
M9992 n4353 g6642 U4607/XI10-net17 VSS nmos W=0.155u L=0.04u
M9993 U4607/XI10-net17 g590 VSS VSS nmos W=0.155u L=0.04u
M9994 U4607/net30 g6642 n4353 VDD pmos W=0.205u L=0.04u
M9995 U4607/net30 g590 n4353 VDD pmos W=0.205u L=0.04u
M9996 VDD n4391 U4607/net36 VDD pmos W=0.205u L=0.04u
M9997 U4607/net36 g587 U4607/net30 VDD pmos W=0.205u L=0.04u
M9998 U4607/net36 g6485 U4607/net30 VDD pmos W=0.205u L=0.04u
M9999 n4391 U4608/net27 VDD VDD pmos W=0.205u L=0.04u
M10000 U4608/net27 g185 U4608/net23 VDD pmos W=0.205u L=0.04u
M10001 U4608/net27 g524 U4608/net23 VDD pmos W=0.205u L=0.04u
M10002 U4608/net27 n3422 U4608/net23 VDD pmos W=0.205u L=0.04u
M10003 U4608/net23 g593 VDD VDD pmos W=0.205u L=0.04u
M10004 U4608/net23 g550 VDD VDD pmos W=0.205u L=0.04u
M10005 n4391 U4608/net27 VSS VSS nmos W=0.155u L=0.04u
M10006 U4608/XI20-net13 g524 VSS VSS nmos W=0.155u L=0.04u
M10007 U4608/net27 g185 U4608/XI20-net17 VSS nmos W=0.155u L=0.04u
M10008 U4608/XI20-net17 n3422 U4608/XI20-net13 VSS nmos W=0.155u L=0.04u
M10009 U4608/net27 g593 U4608/XI17-net17 VSS nmos W=0.155u L=0.04u
M10010 U4608/XI17-net17 g550 VSS VSS nmos W=0.155u L=0.04u
M10011 n3422 U4609/net39 VDD VDD pmos W=0.205u L=0.04u
M10012 VDD g571 U4609/net22 VDD pmos W=0.205u L=0.04u
M10013 VDD g6642 U4609/net22 VDD pmos W=0.205u L=0.04u
M10014 U4609/net16 g569 U4609/net39 VDD pmos W=0.205u L=0.04u
M10015 U4609/net16 g6485 U4609/net39 VDD pmos W=0.205u L=0.04u
M10016 U4609/net22 g573 U4609/net16 VDD pmos W=0.205u L=0.04u
M10017 U4609/net22 g550 U4609/net16 VDD pmos W=0.205u L=0.04u
M10018 n3422 U4609/net39 VSS VSS nmos W=0.155u L=0.04u
M10019 U4609/net39 g571 U4609/XI22-net17 VSS nmos W=0.155u L=0.04u
M10020 U4609/XI22-net17 g6642 VSS VSS nmos W=0.155u L=0.04u
M10021 U4609/net39 g569 U4609/XI6-net17 VSS nmos W=0.155u L=0.04u
M10022 U4609/XI6-net17 g6485 VSS VSS nmos W=0.155u L=0.04u
M10023 U4609/net39 g573 U4609/XI21-net17 VSS nmos W=0.155u L=0.04u
M10024 U4609/XI21-net17 g550 VSS VSS nmos W=0.155u L=0.04u
M10025 U4610/net19 n3921 VSS VSS nmos W=0.155u L=0.04u
M10026 n3337 n3921 U4610/net40 VSS nmos W=0.155u L=0.04u
M10027 n3337 U4610/net19 U4610/net36 VSS nmos W=0.155u L=0.04u
M10028 U4610/net40 g2670 VSS VSS nmos W=0.31u L=0.04u
M10029 U4610/net36 n4392 VSS VSS nmos W=0.155u L=0.04u
M10030 U4610/net19 n3921 VDD VDD pmos W=0.205u L=0.04u
M10031 n3337 U4610/net19 U4610/net26 VDD pmos W=0.325u L=0.04u
M10032 U4610/net26 g2670 VDD VDD pmos W=0.41u L=0.04u
M10033 n3337 n3921 U4610/net30 VDD pmos W=0.325u L=0.04u
M10034 U4610/net30 n4392 VDD VDD pmos W=0.205u L=0.04u
M10035 U4611/net19 n3920 VSS VSS nmos W=0.155u L=0.04u
M10036 n3336 n3920 U4611/net40 VSS nmos W=0.155u L=0.04u
M10037 n3336 U4611/net19 U4611/net36 VSS nmos W=0.155u L=0.04u
M10038 U4611/net40 g2673 VSS VSS nmos W=0.31u L=0.04u
M10039 U4611/net36 n4392 VSS VSS nmos W=0.155u L=0.04u
M10040 U4611/net19 n3920 VDD VDD pmos W=0.205u L=0.04u
M10041 n3336 U4611/net19 U4611/net26 VDD pmos W=0.325u L=0.04u
M10042 U4611/net26 g2673 VDD VDD pmos W=0.41u L=0.04u
M10043 n3336 n3920 U4611/net30 VDD pmos W=0.325u L=0.04u
M10044 U4611/net30 n4392 VDD VDD pmos W=0.205u L=0.04u
M10045 U4612/net19 n3918 VSS VSS nmos W=0.155u L=0.04u
M10046 n3335 n3918 U4612/net40 VSS nmos W=0.155u L=0.04u
M10047 n3335 U4612/net19 U4612/net36 VSS nmos W=0.155u L=0.04u
M10048 U4612/net40 g2676 VSS VSS nmos W=0.31u L=0.04u
M10049 U4612/net36 n4392 VSS VSS nmos W=0.155u L=0.04u
M10050 U4612/net19 n3918 VDD VDD pmos W=0.205u L=0.04u
M10051 n3335 U4612/net19 U4612/net26 VDD pmos W=0.325u L=0.04u
M10052 U4612/net26 g2676 VDD VDD pmos W=0.41u L=0.04u
M10053 n3335 n3918 U4612/net30 VDD pmos W=0.325u L=0.04u
M10054 U4612/net30 n4392 VDD VDD pmos W=0.205u L=0.04u
M10055 n4392 n4346 VSS VSS nmos W=0.155u L=0.04u
M10056 n4392 n4393 VSS VSS nmos W=0.155u L=0.04u
M10057 U4613/XI1-net8 n4393 VDD VDD pmos W=0.205u L=0.04u
M10058 n4392 n4346 U4613/XI1-net8 VDD pmos W=0.205u L=0.04u
M10059 U4614/net19 n4139 VSS VSS nmos W=0.155u L=0.04u
M10060 n3334 n4139 U4614/net40 VSS nmos W=0.155u L=0.04u
M10061 n3334 U4614/net19 U4614/net36 VSS nmos W=0.155u L=0.04u
M10062 U4614/net40 g1273 VSS VSS nmos W=0.31u L=0.04u
M10063 U4614/net36 n4394 VSS VSS nmos W=0.155u L=0.04u
M10064 U4614/net19 n4139 VDD VDD pmos W=0.205u L=0.04u
M10065 n3334 U4614/net19 U4614/net26 VDD pmos W=0.325u L=0.04u
M10066 U4614/net26 g1273 VDD VDD pmos W=0.41u L=0.04u
M10067 n3334 n4139 U4614/net30 VDD pmos W=0.325u L=0.04u
M10068 U4614/net30 n4394 VDD VDD pmos W=0.205u L=0.04u
M10069 U4615/net19 n4138 VSS VSS nmos W=0.155u L=0.04u
M10070 n3333 n4138 U4615/net40 VSS nmos W=0.155u L=0.04u
M10071 n3333 U4615/net19 U4615/net36 VSS nmos W=0.155u L=0.04u
M10072 U4615/net40 g1276 VSS VSS nmos W=0.31u L=0.04u
M10073 U4615/net36 n4394 VSS VSS nmos W=0.155u L=0.04u
M10074 U4615/net19 n4138 VDD VDD pmos W=0.205u L=0.04u
M10075 n3333 U4615/net19 U4615/net26 VDD pmos W=0.325u L=0.04u
M10076 U4615/net26 g1276 VDD VDD pmos W=0.41u L=0.04u
M10077 n3333 n4138 U4615/net30 VDD pmos W=0.325u L=0.04u
M10078 U4615/net30 n4394 VDD VDD pmos W=0.205u L=0.04u
M10079 U4616/net19 n4136 VSS VSS nmos W=0.155u L=0.04u
M10080 n3332 n4136 U4616/net40 VSS nmos W=0.155u L=0.04u
M10081 n3332 U4616/net19 U4616/net36 VSS nmos W=0.155u L=0.04u
M10082 U4616/net40 g1279 VSS VSS nmos W=0.31u L=0.04u
M10083 U4616/net36 n4394 VSS VSS nmos W=0.155u L=0.04u
M10084 U4616/net19 n4136 VDD VDD pmos W=0.205u L=0.04u
M10085 n3332 U4616/net19 U4616/net26 VDD pmos W=0.325u L=0.04u
M10086 U4616/net26 g1279 VDD VDD pmos W=0.41u L=0.04u
M10087 n3332 n4136 U4616/net30 VDD pmos W=0.325u L=0.04u
M10088 U4616/net30 n4394 VDD VDD pmos W=0.205u L=0.04u
M10089 n4394 n4346 VSS VSS nmos W=0.155u L=0.04u
M10090 n4394 n4395 VSS VSS nmos W=0.155u L=0.04u
M10091 U4617/XI1-net8 n4395 VDD VDD pmos W=0.205u L=0.04u
M10092 n4394 n4346 U4617/XI1-net8 VDD pmos W=0.205u L=0.04u
M10093 U4618/net19 n4139 VSS VSS nmos W=0.155u L=0.04u
M10094 n3331 n4139 U4618/net40 VSS nmos W=0.155u L=0.04u
M10095 n3331 U4618/net19 U4618/net36 VSS nmos W=0.155u L=0.04u
M10096 U4618/net40 g1291 VSS VSS nmos W=0.31u L=0.04u
M10097 U4618/net36 n4396 VSS VSS nmos W=0.155u L=0.04u
M10098 U4618/net19 n4139 VDD VDD pmos W=0.205u L=0.04u
M10099 n3331 U4618/net19 U4618/net26 VDD pmos W=0.325u L=0.04u
M10100 U4618/net26 g1291 VDD VDD pmos W=0.41u L=0.04u
M10101 n3331 n4139 U4618/net30 VDD pmos W=0.325u L=0.04u
M10102 U4618/net30 n4396 VDD VDD pmos W=0.205u L=0.04u
M10103 U4619/net19 n4138 VSS VSS nmos W=0.155u L=0.04u
M10104 n3330 n4138 U4619/net40 VSS nmos W=0.155u L=0.04u
M10105 n3330 U4619/net19 U4619/net36 VSS nmos W=0.155u L=0.04u
M10106 U4619/net40 g1294 VSS VSS nmos W=0.31u L=0.04u
M10107 U4619/net36 n4396 VSS VSS nmos W=0.155u L=0.04u
M10108 U4619/net19 n4138 VDD VDD pmos W=0.205u L=0.04u
M10109 n3330 U4619/net19 U4619/net26 VDD pmos W=0.325u L=0.04u
M10110 U4619/net26 g1294 VDD VDD pmos W=0.41u L=0.04u
M10111 n3330 n4138 U4619/net30 VDD pmos W=0.325u L=0.04u
M10112 U4619/net30 n4396 VDD VDD pmos W=0.205u L=0.04u
M10113 U4620/net19 n4136 VSS VSS nmos W=0.155u L=0.04u
M10114 n3329 n4136 U4620/net40 VSS nmos W=0.155u L=0.04u
M10115 n3329 U4620/net19 U4620/net36 VSS nmos W=0.155u L=0.04u
M10116 U4620/net40 g1297 VSS VSS nmos W=0.31u L=0.04u
M10117 U4620/net36 n4396 VSS VSS nmos W=0.155u L=0.04u
M10118 U4620/net19 n4136 VDD VDD pmos W=0.205u L=0.04u
M10119 n3329 U4620/net19 U4620/net26 VDD pmos W=0.325u L=0.04u
M10120 U4620/net26 g1297 VDD VDD pmos W=0.41u L=0.04u
M10121 n3329 n4136 U4620/net30 VDD pmos W=0.325u L=0.04u
M10122 U4620/net30 n4396 VDD VDD pmos W=0.205u L=0.04u
M10123 n4396 U4621/net28 VSS VSS nmos W=0.155u L=0.04u
M10124 U4621/net47 n4397 VSS VSS nmos W=0.155u L=0.04u
M10125 U4621/net28 U4621/net6 U4621/net47 VSS nmos W=0.155u L=0.04u
M10126 U4621/net44 n4398 VSS VSS nmos W=0.155u L=0.04u
M10127 U4621/net28 n4346 U4621/net44 VSS nmos W=0.155u L=0.04u
M10128 U4621/net6 n4346 VSS VSS nmos W=0.155u L=0.04u
M10129 n4396 U4621/net28 VDD VDD pmos W=0.205u L=0.04u
M10130 VDD n4397 U4621/net47 VDD pmos W=0.205u L=0.04u
M10131 U4621/net47 n4346 U4621/net28 VDD pmos W=0.205u L=0.04u
M10132 U4621/net44 U4621/net6 U4621/net28 VDD pmos W=0.205u L=0.04u
M10133 VDD n4398 U4621/net44 VDD pmos W=0.205u L=0.04u
M10134 VDD n4346 U4621/net6 VDD pmos W=0.205u L=0.04u
M10135 n4398 n4399 VSS VSS nmos W=0.155u L=0.04u
M10136 n4398 n4400 VSS VSS nmos W=0.155u L=0.04u
M10137 U4622/XI1-net8 n4400 VDD VDD pmos W=0.205u L=0.04u
M10138 n4398 n4399 U4622/XI1-net8 VDD pmos W=0.205u L=0.04u
M10139 U4623/net19 n4395 VSS VSS nmos W=0.155u L=0.04u
M10140 n4399 n4395 U4623/net40 VSS nmos W=0.155u L=0.04u
M10141 n4399 U4623/net19 U4623/net36 VSS nmos W=0.155u L=0.04u
M10142 U4623/net40 n4401 VSS VSS nmos W=0.31u L=0.04u
M10143 U4623/net36 n4349 VSS VSS nmos W=0.155u L=0.04u
M10144 U4623/net19 n4395 VDD VDD pmos W=0.205u L=0.04u
M10145 n4399 U4623/net19 U4623/net26 VDD pmos W=0.325u L=0.04u
M10146 U4623/net26 n4401 VDD VDD pmos W=0.41u L=0.04u
M10147 n4399 n4395 U4623/net30 VDD pmos W=0.325u L=0.04u
M10148 U4623/net30 n4349 VDD VDD pmos W=0.205u L=0.04u
M10149 U4624/net19 n4139 VSS VSS nmos W=0.155u L=0.04u
M10150 n3328 n4139 U4624/net40 VSS nmos W=0.155u L=0.04u
M10151 n3328 U4624/net19 U4624/net36 VSS nmos W=0.155u L=0.04u
M10152 U4624/net40 g1300 VSS VSS nmos W=0.31u L=0.04u
M10153 U4624/net36 n4402 VSS VSS nmos W=0.155u L=0.04u
M10154 U4624/net19 n4139 VDD VDD pmos W=0.205u L=0.04u
M10155 n3328 U4624/net19 U4624/net26 VDD pmos W=0.325u L=0.04u
M10156 U4624/net26 g1300 VDD VDD pmos W=0.41u L=0.04u
M10157 n3328 n4139 U4624/net30 VDD pmos W=0.325u L=0.04u
M10158 U4624/net30 n4402 VDD VDD pmos W=0.205u L=0.04u
M10159 U4625/net19 n4138 VSS VSS nmos W=0.155u L=0.04u
M10160 n3327 n4138 U4625/net40 VSS nmos W=0.155u L=0.04u
M10161 n3327 U4625/net19 U4625/net36 VSS nmos W=0.155u L=0.04u
M10162 U4625/net40 g1303 VSS VSS nmos W=0.31u L=0.04u
M10163 U4625/net36 n4402 VSS VSS nmos W=0.155u L=0.04u
M10164 U4625/net19 n4138 VDD VDD pmos W=0.205u L=0.04u
M10165 n3327 U4625/net19 U4625/net26 VDD pmos W=0.325u L=0.04u
M10166 U4625/net26 g1303 VDD VDD pmos W=0.41u L=0.04u
M10167 n3327 n4138 U4625/net30 VDD pmos W=0.325u L=0.04u
M10168 U4625/net30 n4402 VDD VDD pmos W=0.205u L=0.04u
M10169 U4626/net19 n4136 VSS VSS nmos W=0.155u L=0.04u
M10170 n3326 n4136 U4626/net40 VSS nmos W=0.155u L=0.04u
M10171 n3326 U4626/net19 U4626/net36 VSS nmos W=0.155u L=0.04u
M10172 U4626/net40 g1306 VSS VSS nmos W=0.31u L=0.04u
M10173 U4626/net36 n4402 VSS VSS nmos W=0.155u L=0.04u
M10174 U4626/net19 n4136 VDD VDD pmos W=0.205u L=0.04u
M10175 n3326 U4626/net19 U4626/net26 VDD pmos W=0.325u L=0.04u
M10176 U4626/net26 g1306 VDD VDD pmos W=0.41u L=0.04u
M10177 n3326 n4136 U4626/net30 VDD pmos W=0.325u L=0.04u
M10178 U4626/net30 n4402 VDD VDD pmos W=0.205u L=0.04u
M10179 n4402 U4627/net28 VSS VSS nmos W=0.155u L=0.04u
M10180 U4627/net47 n4167 VSS VSS nmos W=0.155u L=0.04u
M10181 U4627/net28 U4627/net6 U4627/net47 VSS nmos W=0.155u L=0.04u
M10182 U4627/net44 n4403 VSS VSS nmos W=0.155u L=0.04u
M10183 U4627/net28 n4346 U4627/net44 VSS nmos W=0.155u L=0.04u
M10184 U4627/net6 n4346 VSS VSS nmos W=0.155u L=0.04u
M10185 n4402 U4627/net28 VDD VDD pmos W=0.205u L=0.04u
M10186 VDD n4167 U4627/net47 VDD pmos W=0.205u L=0.04u
M10187 U4627/net47 n4346 U4627/net28 VDD pmos W=0.205u L=0.04u
M10188 U4627/net44 U4627/net6 U4627/net28 VDD pmos W=0.205u L=0.04u
M10189 VDD n4403 U4627/net44 VDD pmos W=0.205u L=0.04u
M10190 VDD n4346 U4627/net6 VDD pmos W=0.205u L=0.04u
M10191 n4403 n4404 VSS VSS nmos W=0.155u L=0.04u
M10192 n4403 n4401 VSS VSS nmos W=0.155u L=0.04u
M10193 U4628/XI1-net8 n4401 VDD VDD pmos W=0.205u L=0.04u
M10194 n4403 n4404 U4628/XI1-net8 VDD pmos W=0.205u L=0.04u
M10195 U4629/XU1-net6 n4406 VSS VSS nmos W=0.155u L=0.04u
M10196 n4401 n4405 U4629/XU1-net6 VSS nmos W=0.155u L=0.04u
M10197 n4401 n4406 VDD VDD pmos W=0.155u L=0.04u
M10198 n4401 n4405 VDD VDD pmos W=0.155u L=0.04u
M10199 U4630/net19 n4409 VSS VSS nmos W=0.155u L=0.04u
M10200 n4406 n4409 U4630/net40 VSS nmos W=0.155u L=0.04u
M10201 n4406 U4630/net19 U4630/net36 VSS nmos W=0.155u L=0.04u
M10202 U4630/net40 n4408 VSS VSS nmos W=0.31u L=0.04u
M10203 U4630/net36 n4407 VSS VSS nmos W=0.155u L=0.04u
M10204 U4630/net19 n4409 VDD VDD pmos W=0.205u L=0.04u
M10205 n4406 U4630/net19 U4630/net26 VDD pmos W=0.325u L=0.04u
M10206 U4630/net26 n4408 VDD VDD pmos W=0.41u L=0.04u
M10207 n4406 n4409 U4630/net30 VDD pmos W=0.325u L=0.04u
M10208 U4630/net30 n4407 VDD VDD pmos W=0.205u L=0.04u
M10209 n4408 U4631/net6 VSS VSS nmos W=0.155u L=0.04u
M10210 U4631/X_u2-net6 n4153 VSS VSS nmos W=0.155u L=0.04u
M10211 U4631/net6 n4410 U4631/X_u2-net6 VSS nmos W=0.155u L=0.04u
M10212 n4408 U4631/net6 VDD VDD pmos W=0.205u L=0.04u
M10213 U4631/net6 n4153 VDD VDD pmos W=0.205u L=0.04u
M10214 U4631/net6 n4410 VDD VDD pmos W=0.205u L=0.04u
M10215 n4407 n4411 VSS VSS nmos W=0.155u L=0.04u
M10216 n4407 n4155 VSS VSS nmos W=0.155u L=0.04u
M10217 U4632/XI1-net8 n4155 VDD VDD pmos W=0.205u L=0.04u
M10218 n4407 n4411 U4632/XI1-net8 VDD pmos W=0.205u L=0.04u
M10219 U4633/net19 n4156 VSS VSS nmos W=0.155u L=0.04u
M10220 n4405 n4156 U4633/net40 VSS nmos W=0.155u L=0.04u
M10221 n4405 U4633/net19 U4633/net36 VSS nmos W=0.155u L=0.04u
M10222 U4633/net40 n4413 VSS VSS nmos W=0.31u L=0.04u
M10223 U4633/net36 n4412 VSS VSS nmos W=0.155u L=0.04u
M10224 U4633/net19 n4156 VDD VDD pmos W=0.205u L=0.04u
M10225 n4405 U4633/net19 U4633/net26 VDD pmos W=0.325u L=0.04u
M10226 U4633/net26 n4413 VDD VDD pmos W=0.41u L=0.04u
M10227 n4405 n4156 U4633/net30 VDD pmos W=0.325u L=0.04u
M10228 U4633/net30 n4412 VDD VDD pmos W=0.205u L=0.04u
M10229 U4634/net8 n4168 U4634/net26 VSS nmos W=0.155u L=0.04u
M10230 U4634/net26 n4415 VSS VSS nmos W=0.155u L=0.04u
M10231 U4634/net29 U4634/net8 VSS VSS nmos W=0.155u L=0.04u
M10232 U4634/net29 n4414 n4413 VSS nmos W=0.155u L=0.04u
M10233 U4634/net29 n4409 n4413 VSS nmos W=0.155u L=0.04u
M10234 U4634/net8 n4415 VDD VDD pmos W=0.205u L=0.04u
M10235 U4634/net8 n4168 VDD VDD pmos W=0.205u L=0.04u
M10236 n4413 U4634/net8 VDD VDD pmos W=0.205u L=0.04u
M10237 n4413 n4414 U4634/net20 VDD pmos W=0.205u L=0.04u
M10238 U4634/net20 n4409 VDD VDD pmos W=0.205u L=0.04u
M10239 n4414 n4417 U4635/XI21-net17 VSS nmos W=0.155u L=0.04u
M10240 U4635/XI21-net17 n4158 VSS VSS nmos W=0.155u L=0.04u
M10241 n4414 n4416 U4635/XI6-net17 VSS nmos W=0.155u L=0.04u
M10242 U4635/XI6-net17 n4159 VSS VSS nmos W=0.155u L=0.04u
M10243 n4414 n4410 U4635/XI20-net17 VSS nmos W=0.155u L=0.04u
M10244 U4635/XI20-net17 n4164 VSS VSS nmos W=0.155u L=0.04u
M10245 VDD n4417 U4635/net22 VDD pmos W=0.205u L=0.04u
M10246 VDD n4158 U4635/net22 VDD pmos W=0.205u L=0.04u
M10247 U4635/net16 n4416 n4414 VDD pmos W=0.205u L=0.04u
M10248 U4635/net16 n4159 n4414 VDD pmos W=0.205u L=0.04u
M10249 U4635/net22 n4410 U4635/net16 VDD pmos W=0.205u L=0.04u
M10250 U4635/net22 n4164 U4635/net16 VDD pmos W=0.205u L=0.04u
M10251 n4412 n4411 U4636/net14 VSS nmos W=0.155u L=0.04u
M10252 U4636/net14 n4419 VSS VSS nmos W=0.155u L=0.04u
M10253 U4636/net14 n4418 VSS VSS nmos W=0.155u L=0.04u
M10254 n4412 n494 U4636/net14 VSS nmos W=0.155u L=0.04u
M10255 n4412 n4416 U4636/net14 VSS nmos W=0.155u L=0.04u
M10256 n4412 n4419 U4636/XI16-net11 VDD pmos W=0.205u L=0.04u
M10257 U4636/XI16-net11 n4418 VDD VDD pmos W=0.205u L=0.04u
M10258 n4412 n494 U4636/XI15-net11 VDD pmos W=0.205u L=0.04u
M10259 U4636/XI15-net11 n4416 U4636/XI15-net18 VDD pmos W=0.205u L=0.04u
M10260 U4636/XI15-net18 n4411 VDD VDD pmos W=0.205u L=0.04u
M10261 n4419 n4416 U4637/XI21-net17 VSS nmos W=0.155u L=0.04u
M10262 U4637/XI21-net17 n4164 VSS VSS nmos W=0.155u L=0.04u
M10263 n4419 n4420 U4637/XI6-net17 VSS nmos W=0.155u L=0.04u
M10264 U4637/XI6-net17 n4158 VSS VSS nmos W=0.155u L=0.04u
M10265 n4419 n4417 U4637/XI20-net17 VSS nmos W=0.155u L=0.04u
M10266 U4637/XI20-net17 n4168 VSS VSS nmos W=0.155u L=0.04u
M10267 VDD n4416 U4637/net22 VDD pmos W=0.205u L=0.04u
M10268 VDD n4164 U4637/net22 VDD pmos W=0.205u L=0.04u
M10269 U4637/net16 n4420 n4419 VDD pmos W=0.205u L=0.04u
M10270 U4637/net16 n4158 n4419 VDD pmos W=0.205u L=0.04u
M10271 U4637/net22 n4417 U4637/net16 VDD pmos W=0.205u L=0.04u
M10272 U4637/net22 n4168 U4637/net16 VDD pmos W=0.205u L=0.04u
M10273 n4164 n4163 VSS VSS nmos W=0.135u L=0.04u
M10274 n4164 n4163 VDD VDD pmos W=0.205u L=0.04u
M10275 U4639/XU1-net6 n494 VSS VSS nmos W=0.155u L=0.04u
M10276 n4163 n496 U4639/XU1-net6 VSS nmos W=0.155u L=0.04u
M10277 n4163 n494 VDD VDD pmos W=0.155u L=0.04u
M10278 n4163 n496 VDD VDD pmos W=0.155u L=0.04u
M10279 U4640/net19 n4349 VSS VSS nmos W=0.155u L=0.04u
M10280 n4404 n4349 U4640/net40 VSS nmos W=0.155u L=0.04u
M10281 n4404 U4640/net19 U4640/net36 VSS nmos W=0.155u L=0.04u
M10282 U4640/net40 n4400 VSS VSS nmos W=0.31u L=0.04u
M10283 U4640/net36 n4395 VSS VSS nmos W=0.155u L=0.04u
M10284 U4640/net19 n4349 VDD VDD pmos W=0.205u L=0.04u
M10285 n4404 U4640/net19 U4640/net26 VDD pmos W=0.325u L=0.04u
M10286 U4640/net26 n4400 VDD VDD pmos W=0.41u L=0.04u
M10287 n4404 n4349 U4640/net30 VDD pmos W=0.325u L=0.04u
M10288 U4640/net30 n4395 VDD VDD pmos W=0.205u L=0.04u
M10289 n4349 n4421 VSS VSS nmos W=0.155u L=0.04u
M10290 n4349 g1236 U4641/XI17-net17 VSS nmos W=0.155u L=0.04u
M10291 U4641/XI17-net17 g1288 VSS VSS nmos W=0.155u L=0.04u
M10292 n4349 g6944 U4641/XI10-net17 VSS nmos W=0.155u L=0.04u
M10293 U4641/XI10-net17 g1285 VSS VSS nmos W=0.155u L=0.04u
M10294 U4641/net30 g6944 n4349 VDD pmos W=0.205u L=0.04u
M10295 U4641/net30 g1285 n4349 VDD pmos W=0.205u L=0.04u
M10296 VDD n4421 U4641/net36 VDD pmos W=0.205u L=0.04u
M10297 U4641/net36 g1288 U4641/net30 VDD pmos W=0.205u L=0.04u
M10298 U4641/net36 g1236 U4641/net30 VDD pmos W=0.205u L=0.04u
M10299 n4421 U4642/net27 VDD VDD pmos W=0.205u L=0.04u
M10300 U4642/net27 g185 U4642/net23 VDD pmos W=0.205u L=0.04u
M10301 U4642/net27 g1228 U4642/net23 VDD pmos W=0.205u L=0.04u
M10302 U4642/net27 n3543 U4642/net23 VDD pmos W=0.205u L=0.04u
M10303 U4642/net23 g1282 VDD VDD pmos W=0.205u L=0.04u
M10304 U4642/net23 g6750 VDD VDD pmos W=0.205u L=0.04u
M10305 n4421 U4642/net27 VSS VSS nmos W=0.155u L=0.04u
M10306 U4642/XI20-net13 g1228 VSS VSS nmos W=0.155u L=0.04u
M10307 U4642/net27 g185 U4642/XI20-net17 VSS nmos W=0.155u L=0.04u
M10308 U4642/XI20-net17 n3543 U4642/XI20-net13 VSS nmos W=0.155u L=0.04u
M10309 U4642/net27 g1282 U4642/XI17-net17 VSS nmos W=0.155u L=0.04u
M10310 U4642/XI17-net17 g6750 VSS VSS nmos W=0.155u L=0.04u
M10311 n3543 U4643/net39 VDD VDD pmos W=0.205u L=0.04u
M10312 VDD g1253 U4643/net22 VDD pmos W=0.205u L=0.04u
M10313 VDD g6944 U4643/net22 VDD pmos W=0.205u L=0.04u
M10314 U4643/net16 g1251 U4643/net39 VDD pmos W=0.205u L=0.04u
M10315 U4643/net16 g6750 U4643/net39 VDD pmos W=0.205u L=0.04u
M10316 U4643/net22 g1176 U4643/net16 VDD pmos W=0.205u L=0.04u
M10317 U4643/net22 g1236 U4643/net16 VDD pmos W=0.205u L=0.04u
M10318 n3543 U4643/net39 VSS VSS nmos W=0.155u L=0.04u
M10319 U4643/net39 g1253 U4643/XI22-net17 VSS nmos W=0.155u L=0.04u
M10320 U4643/XI22-net17 g6944 VSS VSS nmos W=0.155u L=0.04u
M10321 U4643/net39 g1251 U4643/XI6-net17 VSS nmos W=0.155u L=0.04u
M10322 U4643/XI6-net17 g6750 VSS VSS nmos W=0.155u L=0.04u
M10323 U4643/net39 g1176 U4643/XI21-net17 VSS nmos W=0.155u L=0.04u
M10324 U4643/XI21-net17 g1236 VSS VSS nmos W=0.155u L=0.04u
M10325 n4400 n4423 U4644/net26 VSS nmos W=0.155u L=0.04u
M10326 n4400 n4422 U4644/net26 VSS nmos W=0.155u L=0.04u
M10327 U4644/net29 n4425 VSS VSS nmos W=0.155u L=0.04u
M10328 U4644/net26 n495 U4644/net29 VSS nmos W=0.155u L=0.04u
M10329 U4644/net26 n4424 U4644/net29 VSS nmos W=0.155u L=0.04u
M10330 n4400 n4422 U4644/net43 VDD pmos W=0.205u L=0.04u
M10331 n4400 n4424 U4644/net49 VDD pmos W=0.205u L=0.04u
M10332 U4644/net49 n495 VDD VDD pmos W=0.205u L=0.04u
M10333 U4644/net43 n4423 VDD VDD pmos W=0.205u L=0.04u
M10334 n4400 n4425 VDD VDD pmos W=0.205u L=0.04u
M10335 U4645/net19 n4409 VSS VSS nmos W=0.155u L=0.04u
M10336 n4425 n4409 U4645/net40 VSS nmos W=0.155u L=0.04u
M10337 n4425 U4645/net19 U4645/net36 VSS nmos W=0.155u L=0.04u
M10338 U4645/net40 n4427 VSS VSS nmos W=0.31u L=0.04u
M10339 U4645/net36 n4426 VSS VSS nmos W=0.155u L=0.04u
M10340 U4645/net19 n4409 VDD VDD pmos W=0.205u L=0.04u
M10341 n4425 U4645/net19 U4645/net26 VDD pmos W=0.325u L=0.04u
M10342 U4645/net26 n4427 VDD VDD pmos W=0.41u L=0.04u
M10343 n4425 n4409 U4645/net30 VDD pmos W=0.325u L=0.04u
M10344 U4645/net30 n4426 VDD VDD pmos W=0.205u L=0.04u
M10345 n4427 n4428 U4646/net27 VSS nmos W=0.155u L=0.04u
M10346 U4646/net39 n4424 VSS VSS nmos W=0.155u L=0.04u
M10347 U4646/net27 n4429 U4646/net39 VSS nmos W=0.155u L=0.04u
M10348 U4646/net27 n4430 U4646/net39 VSS nmos W=0.155u L=0.04u
M10349 n4427 n4155 U4646/net27 VSS nmos W=0.155u L=0.04u
M10350 U4646/net39 n4153 VSS VSS nmos W=0.155u L=0.04u
M10351 n4427 n4424 U4646/net46 VDD pmos W=0.205u L=0.04u
M10352 U4646/net46 n4153 VDD VDD pmos W=0.205u L=0.04u
M10353 n4427 n4155 U4646/net34 VDD pmos W=0.205u L=0.04u
M10354 U4646/net34 n4428 VDD VDD pmos W=0.205u L=0.04u
M10355 n4427 n4430 U4646/net37 VDD pmos W=0.205u L=0.04u
M10356 U4646/net37 n4429 VDD VDD pmos W=0.205u L=0.04u
M10357 U4647/net14 n4420 U4647/net20 VSS nmos W=0.155u L=0.04u
M10358 U4647/net14 n494 U4647/net20 VSS nmos W=0.155u L=0.04u
M10359 U4647/net20 n4155 VSS VSS nmos W=0.155u L=0.04u
M10360 n4429 U4647/net14 VSS VSS nmos W=0.155u L=0.04u
M10361 n4429 U4647/net14 VDD VDD pmos W=0.205u L=0.04u
M10362 U4647/net14 n4155 VDD VDD pmos W=0.205u L=0.04u
M10363 U4647/net24 n4420 VDD VDD pmos W=0.205u L=0.04u
M10364 U4647/net14 n494 U4647/net24 VDD pmos W=0.205u L=0.04u
M10365 n4428 n4417 VSS VSS nmos W=0.135u L=0.04u
M10366 n4428 n4417 VDD VDD pmos W=0.205u L=0.04u
M10367 n4417 n4420 VSS VSS nmos W=0.155u L=0.04u
M10368 n4417 n4415 VSS VSS nmos W=0.155u L=0.04u
M10369 U4649/XI1-net8 n4415 VDD VDD pmos W=0.205u L=0.04u
M10370 n4417 n4420 U4649/XI1-net8 VDD pmos W=0.205u L=0.04u
M10371 U4650/XU1-net6 n4159 VSS VSS nmos W=0.155u L=0.04u
M10372 n4155 n495 U4650/XU1-net6 VSS nmos W=0.155u L=0.04u
M10373 n4155 n4159 VDD VDD pmos W=0.155u L=0.04u
M10374 n4155 n495 VDD VDD pmos W=0.155u L=0.04u
M10375 n4426 n493 U4651/net14 VSS nmos W=0.155u L=0.04u
M10376 U4651/net14 n4430 VSS VSS nmos W=0.155u L=0.04u
M10377 U4651/net14 n4431 VSS VSS nmos W=0.155u L=0.04u
M10378 n4426 n496 U4651/net14 VSS nmos W=0.155u L=0.04u
M10379 n4426 n4415 U4651/net14 VSS nmos W=0.155u L=0.04u
M10380 n4426 n4430 U4651/XI16-net11 VDD pmos W=0.205u L=0.04u
M10381 U4651/XI16-net11 n4431 VDD VDD pmos W=0.205u L=0.04u
M10382 n4426 n496 U4651/XI15-net11 VDD pmos W=0.205u L=0.04u
M10383 U4651/XI15-net11 n4415 U4651/XI15-net18 VDD pmos W=0.205u L=0.04u
M10384 U4651/XI15-net18 n493 VDD VDD pmos W=0.205u L=0.04u
M10385 n4430 n4416 VSS VSS nmos W=0.135u L=0.04u
M10386 n4430 n4416 VDD VDD pmos W=0.205u L=0.04u
M10387 n4431 n4168 U4653/net27 VSS nmos W=0.155u L=0.04u
M10388 U4653/net27 n4411 VSS VSS nmos W=0.155u L=0.04u
M10389 n4431 n4153 VSS VSS nmos W=0.155u L=0.04u
M10390 n4431 n4411 U4653/net13 VDD pmos W=0.205u L=0.04u
M10391 U4653/net13 n4153 VDD VDD pmos W=0.205u L=0.04u
M10392 n4431 n4168 U4653/net13 VDD pmos W=0.205u L=0.04u
M10393 n4168 n4158 VSS VSS nmos W=0.155u L=0.04u
M10394 n4168 n4159 VSS VSS nmos W=0.155u L=0.04u
M10395 U4654/XI1-net8 n4159 VDD VDD pmos W=0.205u L=0.04u
M10396 n4168 n4158 U4654/XI1-net8 VDD pmos W=0.205u L=0.04u
M10397 n496 n4153 VSS VSS nmos W=0.135u L=0.04u
M10398 n496 n4153 VDD VDD pmos W=0.205u L=0.04u
M10399 n4153 n4139 U4656/net27 VSS nmos W=0.155u L=0.04u
M10400 U4656/net39 n4138 VSS VSS nmos W=0.155u L=0.04u
M10401 U4656/net27 g1270 U4656/net39 VSS nmos W=0.155u L=0.04u
M10402 U4656/net27 n4136 U4656/net39 VSS nmos W=0.155u L=0.04u
M10403 n4153 g1271 U4656/net27 VSS nmos W=0.155u L=0.04u
M10404 U4656/net39 g1272 VSS VSS nmos W=0.155u L=0.04u
M10405 n4153 n4138 U4656/net46 VDD pmos W=0.205u L=0.04u
M10406 U4656/net46 g1272 VDD VDD pmos W=0.205u L=0.04u
M10407 n4153 g1271 U4656/net34 VDD pmos W=0.205u L=0.04u
M10408 U4656/net34 n4139 VDD VDD pmos W=0.205u L=0.04u
M10409 n4153 n4136 U4656/net37 VDD pmos W=0.205u L=0.04u
M10410 U4656/net37 g1270 VDD VDD pmos W=0.205u L=0.04u
M10411 U4657/net19 n493 VSS VSS nmos W=0.155u L=0.04u
M10412 n4424 n493 U4657/net40 VSS nmos W=0.155u L=0.04u
M10413 n4424 U4657/net19 U4657/net36 VSS nmos W=0.155u L=0.04u
M10414 U4657/net40 n4415 VSS VSS nmos W=0.31u L=0.04u
M10415 U4657/net36 n4432 VSS VSS nmos W=0.155u L=0.04u
M10416 U4657/net19 n493 VDD VDD pmos W=0.205u L=0.04u
M10417 n4424 U4657/net19 U4657/net26 VDD pmos W=0.325u L=0.04u
M10418 U4657/net26 n4415 VDD VDD pmos W=0.41u L=0.04u
M10419 n4424 n493 U4657/net30 VDD pmos W=0.325u L=0.04u
M10420 U4657/net30 n4432 VDD VDD pmos W=0.205u L=0.04u
M10421 n493 n4156 VSS VSS nmos W=0.135u L=0.04u
M10422 n493 n4156 VDD VDD pmos W=0.205u L=0.04u
M10423 n4415 g1011 U4659/XI21-net17 VSS nmos W=0.155u L=0.04u
M10424 U4659/XI21-net17 g1024 VSS VSS nmos W=0.155u L=0.04u
M10425 n4415 g1081 U4659/XI6-net17 VSS nmos W=0.155u L=0.04u
M10426 U4659/XI6-net17 g5657 VSS VSS nmos W=0.155u L=0.04u
M10427 n4415 g1083 U4659/XI20-net17 VSS nmos W=0.155u L=0.04u
M10428 U4659/XI20-net17 g5686 VSS VSS nmos W=0.155u L=0.04u
M10429 VDD g1011 U4659/net22 VDD pmos W=0.205u L=0.04u
M10430 VDD g1024 U4659/net22 VDD pmos W=0.205u L=0.04u
M10431 U4659/net16 g1081 n4415 VDD pmos W=0.205u L=0.04u
M10432 U4659/net16 g5657 n4415 VDD pmos W=0.205u L=0.04u
M10433 U4659/net22 g1083 U4659/net16 VDD pmos W=0.205u L=0.04u
M10434 U4659/net22 g5686 U4659/net16 VDD pmos W=0.205u L=0.04u
M10435 n4432 n4411 VSS VSS nmos W=0.155u L=0.04u
M10436 n4432 n4416 VSS VSS nmos W=0.155u L=0.04u
M10437 U4660/XI1-net8 n4416 VDD VDD pmos W=0.205u L=0.04u
M10438 n4432 n4411 U4660/XI1-net8 VDD pmos W=0.205u L=0.04u
M10439 n4411 n4420 VSS VSS nmos W=0.135u L=0.04u
M10440 n4411 n4420 VDD VDD pmos W=0.205u L=0.04u
M10441 n495 n4158 VSS VSS nmos W=0.135u L=0.04u
M10442 n495 n4158 VDD VDD pmos W=0.205u L=0.04u
M10443 U4663/net19 n4156 VSS VSS nmos W=0.155u L=0.04u
M10444 n4423 n4156 U4663/net40 VSS nmos W=0.155u L=0.04u
M10445 n4423 U4663/net19 U4663/net36 VSS nmos W=0.155u L=0.04u
M10446 U4663/net40 n4420 VSS VSS nmos W=0.31u L=0.04u
M10447 U4663/net36 n4410 VSS VSS nmos W=0.155u L=0.04u
M10448 U4663/net19 n4156 VDD VDD pmos W=0.205u L=0.04u
M10449 n4423 U4663/net19 U4663/net26 VDD pmos W=0.325u L=0.04u
M10450 U4663/net26 n4420 VDD VDD pmos W=0.41u L=0.04u
M10451 n4423 n4156 U4663/net30 VDD pmos W=0.325u L=0.04u
M10452 U4663/net30 n4410 VDD VDD pmos W=0.205u L=0.04u
M10453 n4156 n4139 U4664/net27 VSS nmos W=0.155u L=0.04u
M10454 U4664/net39 n4138 VSS VSS nmos W=0.155u L=0.04u
M10455 U4664/net27 g1261 U4664/net39 VSS nmos W=0.155u L=0.04u
M10456 U4664/net27 n4136 U4664/net39 VSS nmos W=0.155u L=0.04u
M10457 n4156 g1262 U4664/net27 VSS nmos W=0.155u L=0.04u
M10458 U4664/net39 g1263 VSS VSS nmos W=0.155u L=0.04u
M10459 n4156 n4138 U4664/net46 VDD pmos W=0.205u L=0.04u
M10460 U4664/net46 g1263 VDD VDD pmos W=0.205u L=0.04u
M10461 n4156 g1262 U4664/net34 VDD pmos W=0.205u L=0.04u
M10462 U4664/net34 n4139 VDD VDD pmos W=0.205u L=0.04u
M10463 n4156 n4136 U4664/net37 VDD pmos W=0.205u L=0.04u
M10464 U4664/net37 g1261 VDD VDD pmos W=0.205u L=0.04u
M10465 n4410 n4420 VSS VSS nmos W=0.155u L=0.04u
M10466 n4410 n4416 VSS VSS nmos W=0.155u L=0.04u
M10467 U4665/XI1-net8 n4416 VDD VDD pmos W=0.205u L=0.04u
M10468 n4410 n4420 U4665/XI1-net8 VDD pmos W=0.205u L=0.04u
M10469 n4416 g1070 U4666/XI21-net17 VSS nmos W=0.155u L=0.04u
M10470 U4666/XI21-net17 g1024 VSS VSS nmos W=0.155u L=0.04u
M10471 n4416 g1066 U4666/XI6-net17 VSS nmos W=0.155u L=0.04u
M10472 U4666/XI6-net17 g5657 VSS VSS nmos W=0.155u L=0.04u
M10473 n4416 g1068 U4666/XI20-net17 VSS nmos W=0.155u L=0.04u
M10474 U4666/XI20-net17 g5686 VSS VSS nmos W=0.155u L=0.04u
M10475 VDD g1070 U4666/net22 VDD pmos W=0.205u L=0.04u
M10476 VDD g1024 U4666/net22 VDD pmos W=0.205u L=0.04u
M10477 U4666/net16 g1066 n4416 VDD pmos W=0.205u L=0.04u
M10478 U4666/net16 g5657 n4416 VDD pmos W=0.205u L=0.04u
M10479 U4666/net22 g1068 U4666/net16 VDD pmos W=0.205u L=0.04u
M10480 U4666/net22 g5686 U4666/net16 VDD pmos W=0.205u L=0.04u
M10481 n4420 g1055 U4667/XI21-net17 VSS nmos W=0.155u L=0.04u
M10482 U4667/XI21-net17 g1024 VSS VSS nmos W=0.155u L=0.04u
M10483 n4420 g1051 U4667/XI6-net17 VSS nmos W=0.155u L=0.04u
M10484 U4667/XI6-net17 g5657 VSS VSS nmos W=0.155u L=0.04u
M10485 n4420 g1053 U4667/XI20-net17 VSS nmos W=0.155u L=0.04u
M10486 U4667/XI20-net17 g5686 VSS VSS nmos W=0.155u L=0.04u
M10487 VDD g1055 U4667/net22 VDD pmos W=0.205u L=0.04u
M10488 VDD g1024 U4667/net22 VDD pmos W=0.205u L=0.04u
M10489 U4667/net16 g1051 n4420 VDD pmos W=0.205u L=0.04u
M10490 U4667/net16 g5657 n4420 VDD pmos W=0.205u L=0.04u
M10491 U4667/net22 g1053 U4667/net16 VDD pmos W=0.205u L=0.04u
M10492 U4667/net22 g5686 U4667/net16 VDD pmos W=0.205u L=0.04u
M10493 U4668/net19 n4409 VSS VSS nmos W=0.155u L=0.04u
M10494 n4422 n4409 U4668/net40 VSS nmos W=0.155u L=0.04u
M10495 n4422 U4668/net19 U4668/net36 VSS nmos W=0.155u L=0.04u
M10496 U4668/net40 n4158 VSS VSS nmos W=0.31u L=0.04u
M10497 U4668/net36 n494 VSS VSS nmos W=0.155u L=0.04u
M10498 U4668/net19 n4409 VDD VDD pmos W=0.205u L=0.04u
M10499 n4422 U4668/net19 U4668/net26 VDD pmos W=0.325u L=0.04u
M10500 U4668/net26 n4158 VDD VDD pmos W=0.41u L=0.04u
M10501 n4422 n4409 U4668/net30 VDD pmos W=0.325u L=0.04u
M10502 U4668/net30 n494 VDD VDD pmos W=0.205u L=0.04u
M10503 n4409 n4418 VSS VSS nmos W=0.135u L=0.04u
M10504 n4409 n4418 VDD VDD pmos W=0.205u L=0.04u
M10505 n4418 g1040 U4670/XI21-net17 VSS nmos W=0.155u L=0.04u
M10506 U4670/XI21-net17 g1024 VSS VSS nmos W=0.155u L=0.04u
M10507 n4418 g5657 U4670/XI6-net17 VSS nmos W=0.155u L=0.04u
M10508 U4670/XI6-net17 g1036 VSS VSS nmos W=0.155u L=0.04u
M10509 n4418 g5686 U4670/XI20-net17 VSS nmos W=0.155u L=0.04u
M10510 U4670/XI20-net17 g1038 VSS VSS nmos W=0.155u L=0.04u
M10511 VDD g1040 U4670/net22 VDD pmos W=0.205u L=0.04u
M10512 VDD g1024 U4670/net22 VDD pmos W=0.205u L=0.04u
M10513 U4670/net16 g5657 n4418 VDD pmos W=0.205u L=0.04u
M10514 U4670/net16 g1036 n4418 VDD pmos W=0.205u L=0.04u
M10515 U4670/net22 g5686 U4670/net16 VDD pmos W=0.205u L=0.04u
M10516 U4670/net22 g1038 U4670/net16 VDD pmos W=0.205u L=0.04u
M10517 n4158 n4139 U4671/net27 VSS nmos W=0.155u L=0.04u
M10518 U4671/net39 n4138 VSS VSS nmos W=0.155u L=0.04u
M10519 U4671/net27 g1267 U4671/net39 VSS nmos W=0.155u L=0.04u
M10520 U4671/net27 n4136 U4671/net39 VSS nmos W=0.155u L=0.04u
M10521 n4158 g1268 U4671/net27 VSS nmos W=0.155u L=0.04u
M10522 U4671/net39 g1269 VSS VSS nmos W=0.155u L=0.04u
M10523 n4158 n4138 U4671/net46 VDD pmos W=0.205u L=0.04u
M10524 U4671/net46 g1269 VDD VDD pmos W=0.205u L=0.04u
M10525 n4158 g1268 U4671/net34 VDD pmos W=0.205u L=0.04u
M10526 U4671/net34 n4139 VDD VDD pmos W=0.205u L=0.04u
M10527 n4158 n4136 U4671/net37 VDD pmos W=0.205u L=0.04u
M10528 U4671/net37 g1267 VDD VDD pmos W=0.205u L=0.04u
M10529 n494 n4159 VSS VSS nmos W=0.135u L=0.04u
M10530 n494 n4159 VDD VDD pmos W=0.205u L=0.04u
M10531 n4159 n4139 U4673/net27 VSS nmos W=0.155u L=0.04u
M10532 U4673/net39 n4138 VSS VSS nmos W=0.155u L=0.04u
M10533 U4673/net27 g1264 U4673/net39 VSS nmos W=0.155u L=0.04u
M10534 U4673/net27 n4136 U4673/net39 VSS nmos W=0.155u L=0.04u
M10535 n4159 g1265 U4673/net27 VSS nmos W=0.155u L=0.04u
M10536 U4673/net39 g1266 VSS VSS nmos W=0.155u L=0.04u
M10537 n4159 n4138 U4673/net46 VDD pmos W=0.205u L=0.04u
M10538 U4673/net46 g1266 VDD VDD pmos W=0.205u L=0.04u
M10539 n4159 g1265 U4673/net34 VDD pmos W=0.205u L=0.04u
M10540 U4673/net34 n4139 VDD VDD pmos W=0.205u L=0.04u
M10541 n4159 n4136 U4673/net37 VDD pmos W=0.205u L=0.04u
M10542 U4673/net37 g1264 VDD VDD pmos W=0.205u L=0.04u
M10543 n4138 g6944 VSS VSS nmos W=0.135u L=0.04u
M10544 n4138 g6944 VDD VDD pmos W=0.205u L=0.04u
M10545 n4136 g1236 VSS VSS nmos W=0.135u L=0.04u
M10546 n4136 g1236 VDD VDD pmos W=0.205u L=0.04u
M10547 n4139 g6750 VSS VSS nmos W=0.135u L=0.04u
M10548 n4139 g6750 VDD VDD pmos W=0.205u L=0.04u
M10549 n4395 n4433 VSS VSS nmos W=0.155u L=0.04u
M10550 n4395 g6750 U4677/XI17-net17 VSS nmos W=0.155u L=0.04u
M10551 U4677/XI17-net17 g1273 VSS VSS nmos W=0.155u L=0.04u
M10552 n4395 g6944 U4677/XI10-net17 VSS nmos W=0.155u L=0.04u
M10553 U4677/XI10-net17 g1276 VSS VSS nmos W=0.155u L=0.04u
M10554 U4677/net30 g6944 n4395 VDD pmos W=0.205u L=0.04u
M10555 U4677/net30 g1276 n4395 VDD pmos W=0.205u L=0.04u
M10556 VDD n4433 U4677/net36 VDD pmos W=0.205u L=0.04u
M10557 U4677/net36 g1273 U4677/net30 VDD pmos W=0.205u L=0.04u
M10558 U4677/net36 g6750 U4677/net30 VDD pmos W=0.205u L=0.04u
M10559 n4433 U4678/net27 VDD VDD pmos W=0.205u L=0.04u
M10560 U4678/net27 g185 U4678/net23 VDD pmos W=0.205u L=0.04u
M10561 U4678/net27 g1210 U4678/net23 VDD pmos W=0.205u L=0.04u
M10562 U4678/net27 n3542 U4678/net23 VDD pmos W=0.205u L=0.04u
M10563 U4678/net23 g1279 VDD VDD pmos W=0.205u L=0.04u
M10564 U4678/net23 g1236 VDD VDD pmos W=0.205u L=0.04u
M10565 n4433 U4678/net27 VSS VSS nmos W=0.155u L=0.04u
M10566 U4678/XI20-net13 g1210 VSS VSS nmos W=0.155u L=0.04u
M10567 U4678/net27 g185 U4678/XI20-net17 VSS nmos W=0.155u L=0.04u
M10568 U4678/XI20-net17 n3542 U4678/XI20-net13 VSS nmos W=0.155u L=0.04u
M10569 U4678/net27 g1279 U4678/XI17-net17 VSS nmos W=0.155u L=0.04u
M10570 U4678/XI17-net17 g1236 VSS VSS nmos W=0.155u L=0.04u
M10571 n3542 U4679/net39 VDD VDD pmos W=0.205u L=0.04u
M10572 VDD g1257 U4679/net22 VDD pmos W=0.205u L=0.04u
M10573 VDD g6944 U4679/net22 VDD pmos W=0.205u L=0.04u
M10574 U4679/net16 g1255 U4679/net39 VDD pmos W=0.205u L=0.04u
M10575 U4679/net16 g6750 U4679/net39 VDD pmos W=0.205u L=0.04u
M10576 U4679/net22 g1259 U4679/net16 VDD pmos W=0.205u L=0.04u
M10577 U4679/net22 g1236 U4679/net16 VDD pmos W=0.205u L=0.04u
M10578 n3542 U4679/net39 VSS VSS nmos W=0.155u L=0.04u
M10579 U4679/net39 g1257 U4679/XI22-net17 VSS nmos W=0.155u L=0.04u
M10580 U4679/XI22-net17 g6944 VSS VSS nmos W=0.155u L=0.04u
M10581 U4679/net39 g1255 U4679/XI6-net17 VSS nmos W=0.155u L=0.04u
M10582 U4679/XI6-net17 g6750 VSS VSS nmos W=0.155u L=0.04u
M10583 U4679/net39 g1259 U4679/XI21-net17 VSS nmos W=0.155u L=0.04u
M10584 U4679/XI21-net17 g1236 VSS VSS nmos W=0.155u L=0.04u
M10585 U4680/net19 n4031 VSS VSS nmos W=0.155u L=0.04u
M10586 n3325 n4031 U4680/net40 VSS nmos W=0.155u L=0.04u
M10587 n3325 U4680/net19 U4680/net36 VSS nmos W=0.155u L=0.04u
M10588 U4680/net40 g1967 VSS VSS nmos W=0.31u L=0.04u
M10589 U4680/net36 n4434 VSS VSS nmos W=0.155u L=0.04u
M10590 U4680/net19 n4031 VDD VDD pmos W=0.205u L=0.04u
M10591 n3325 U4680/net19 U4680/net26 VDD pmos W=0.325u L=0.04u
M10592 U4680/net26 g1967 VDD VDD pmos W=0.41u L=0.04u
M10593 n3325 n4031 U4680/net30 VDD pmos W=0.325u L=0.04u
M10594 U4680/net30 n4434 VDD VDD pmos W=0.205u L=0.04u
M10595 U4681/net19 n4030 VSS VSS nmos W=0.155u L=0.04u
M10596 n3324 n4030 U4681/net40 VSS nmos W=0.155u L=0.04u
M10597 n3324 U4681/net19 U4681/net36 VSS nmos W=0.155u L=0.04u
M10598 U4681/net40 g1970 VSS VSS nmos W=0.31u L=0.04u
M10599 U4681/net36 n4434 VSS VSS nmos W=0.155u L=0.04u
M10600 U4681/net19 n4030 VDD VDD pmos W=0.205u L=0.04u
M10601 n3324 U4681/net19 U4681/net26 VDD pmos W=0.325u L=0.04u
M10602 U4681/net26 g1970 VDD VDD pmos W=0.41u L=0.04u
M10603 n3324 n4030 U4681/net30 VDD pmos W=0.325u L=0.04u
M10604 U4681/net30 n4434 VDD VDD pmos W=0.205u L=0.04u
M10605 U4682/net19 n4028 VSS VSS nmos W=0.155u L=0.04u
M10606 n3323 n4028 U4682/net40 VSS nmos W=0.155u L=0.04u
M10607 n3323 U4682/net19 U4682/net36 VSS nmos W=0.155u L=0.04u
M10608 U4682/net40 g1973 VSS VSS nmos W=0.31u L=0.04u
M10609 U4682/net36 n4434 VSS VSS nmos W=0.155u L=0.04u
M10610 U4682/net19 n4028 VDD VDD pmos W=0.205u L=0.04u
M10611 n3323 U4682/net19 U4682/net26 VDD pmos W=0.325u L=0.04u
M10612 U4682/net26 g1973 VDD VDD pmos W=0.41u L=0.04u
M10613 n3323 n4028 U4682/net30 VDD pmos W=0.325u L=0.04u
M10614 U4682/net30 n4434 VDD VDD pmos W=0.205u L=0.04u
M10615 n4434 n4346 VSS VSS nmos W=0.155u L=0.04u
M10616 n4434 n4435 VSS VSS nmos W=0.155u L=0.04u
M10617 U4683/XI1-net8 n4435 VDD VDD pmos W=0.205u L=0.04u
M10618 n4434 n4346 U4683/XI1-net8 VDD pmos W=0.205u L=0.04u
M10619 U4684/net19 n4031 VSS VSS nmos W=0.155u L=0.04u
M10620 n3322 n4031 U4684/net40 VSS nmos W=0.155u L=0.04u
M10621 n3322 U4684/net19 U4684/net36 VSS nmos W=0.155u L=0.04u
M10622 U4684/net40 g1985 VSS VSS nmos W=0.31u L=0.04u
M10623 U4684/net36 n4436 VSS VSS nmos W=0.155u L=0.04u
M10624 U4684/net19 n4031 VDD VDD pmos W=0.205u L=0.04u
M10625 n3322 U4684/net19 U4684/net26 VDD pmos W=0.325u L=0.04u
M10626 U4684/net26 g1985 VDD VDD pmos W=0.41u L=0.04u
M10627 n3322 n4031 U4684/net30 VDD pmos W=0.325u L=0.04u
M10628 U4684/net30 n4436 VDD VDD pmos W=0.205u L=0.04u
M10629 U4685/net19 n4030 VSS VSS nmos W=0.155u L=0.04u
M10630 n3321 n4030 U4685/net40 VSS nmos W=0.155u L=0.04u
M10631 n3321 U4685/net19 U4685/net36 VSS nmos W=0.155u L=0.04u
M10632 U4685/net40 g1988 VSS VSS nmos W=0.31u L=0.04u
M10633 U4685/net36 n4436 VSS VSS nmos W=0.155u L=0.04u
M10634 U4685/net19 n4030 VDD VDD pmos W=0.205u L=0.04u
M10635 n3321 U4685/net19 U4685/net26 VDD pmos W=0.325u L=0.04u
M10636 U4685/net26 g1988 VDD VDD pmos W=0.41u L=0.04u
M10637 n3321 n4030 U4685/net30 VDD pmos W=0.325u L=0.04u
M10638 U4685/net30 n4436 VDD VDD pmos W=0.205u L=0.04u
M10639 U4686/net19 n4028 VSS VSS nmos W=0.155u L=0.04u
M10640 n3320 n4028 U4686/net40 VSS nmos W=0.155u L=0.04u
M10641 n3320 U4686/net19 U4686/net36 VSS nmos W=0.155u L=0.04u
M10642 U4686/net40 g1991 VSS VSS nmos W=0.31u L=0.04u
M10643 U4686/net36 n4436 VSS VSS nmos W=0.155u L=0.04u
M10644 U4686/net19 n4028 VDD VDD pmos W=0.205u L=0.04u
M10645 n3320 U4686/net19 U4686/net26 VDD pmos W=0.325u L=0.04u
M10646 U4686/net26 g1991 VDD VDD pmos W=0.41u L=0.04u
M10647 n3320 n4028 U4686/net30 VDD pmos W=0.325u L=0.04u
M10648 U4686/net30 n4436 VDD VDD pmos W=0.205u L=0.04u
M10649 n4436 U4687/net28 VSS VSS nmos W=0.155u L=0.04u
M10650 U4687/net47 n4437 VSS VSS nmos W=0.155u L=0.04u
M10651 U4687/net28 U4687/net6 U4687/net47 VSS nmos W=0.155u L=0.04u
M10652 U4687/net44 n4438 VSS VSS nmos W=0.155u L=0.04u
M10653 U4687/net28 n4346 U4687/net44 VSS nmos W=0.155u L=0.04u
M10654 U4687/net6 n4346 VSS VSS nmos W=0.155u L=0.04u
M10655 n4436 U4687/net28 VDD VDD pmos W=0.205u L=0.04u
M10656 VDD n4437 U4687/net47 VDD pmos W=0.205u L=0.04u
M10657 U4687/net47 n4346 U4687/net28 VDD pmos W=0.205u L=0.04u
M10658 U4687/net44 U4687/net6 U4687/net28 VDD pmos W=0.205u L=0.04u
M10659 VDD n4438 U4687/net44 VDD pmos W=0.205u L=0.04u
M10660 VDD n4346 U4687/net6 VDD pmos W=0.205u L=0.04u
M10661 n4438 n4439 VSS VSS nmos W=0.155u L=0.04u
M10662 n4438 n4440 VSS VSS nmos W=0.155u L=0.04u
M10663 U4688/XI1-net8 n4440 VDD VDD pmos W=0.205u L=0.04u
M10664 n4438 n4439 U4688/XI1-net8 VDD pmos W=0.205u L=0.04u
M10665 U4689/net19 n4435 VSS VSS nmos W=0.155u L=0.04u
M10666 n4439 n4435 U4689/net40 VSS nmos W=0.155u L=0.04u
M10667 n4439 U4689/net19 U4689/net36 VSS nmos W=0.155u L=0.04u
M10668 U4689/net40 n4441 VSS VSS nmos W=0.31u L=0.04u
M10669 U4689/net36 n4351 VSS VSS nmos W=0.155u L=0.04u
M10670 U4689/net19 n4435 VDD VDD pmos W=0.205u L=0.04u
M10671 n4439 U4689/net19 U4689/net26 VDD pmos W=0.325u L=0.04u
M10672 U4689/net26 n4441 VDD VDD pmos W=0.41u L=0.04u
M10673 n4439 n4435 U4689/net30 VDD pmos W=0.325u L=0.04u
M10674 U4689/net30 n4351 VDD VDD pmos W=0.205u L=0.04u
M10675 U4690/net19 n4031 VSS VSS nmos W=0.155u L=0.04u
M10676 n3319 n4031 U4690/net40 VSS nmos W=0.155u L=0.04u
M10677 n3319 U4690/net19 U4690/net36 VSS nmos W=0.155u L=0.04u
M10678 U4690/net40 g1994 VSS VSS nmos W=0.31u L=0.04u
M10679 U4690/net36 n4442 VSS VSS nmos W=0.155u L=0.04u
M10680 U4690/net19 n4031 VDD VDD pmos W=0.205u L=0.04u
M10681 n3319 U4690/net19 U4690/net26 VDD pmos W=0.325u L=0.04u
M10682 U4690/net26 g1994 VDD VDD pmos W=0.41u L=0.04u
M10683 n3319 n4031 U4690/net30 VDD pmos W=0.325u L=0.04u
M10684 U4690/net30 n4442 VDD VDD pmos W=0.205u L=0.04u
M10685 U4691/net19 n4030 VSS VSS nmos W=0.155u L=0.04u
M10686 n3318 n4030 U4691/net40 VSS nmos W=0.155u L=0.04u
M10687 n3318 U4691/net19 U4691/net36 VSS nmos W=0.155u L=0.04u
M10688 U4691/net40 g1997 VSS VSS nmos W=0.31u L=0.04u
M10689 U4691/net36 n4442 VSS VSS nmos W=0.155u L=0.04u
M10690 U4691/net19 n4030 VDD VDD pmos W=0.205u L=0.04u
M10691 n3318 U4691/net19 U4691/net26 VDD pmos W=0.325u L=0.04u
M10692 U4691/net26 g1997 VDD VDD pmos W=0.41u L=0.04u
M10693 n3318 n4030 U4691/net30 VDD pmos W=0.325u L=0.04u
M10694 U4691/net30 n4442 VDD VDD pmos W=0.205u L=0.04u
M10695 U4692/net19 n4028 VSS VSS nmos W=0.155u L=0.04u
M10696 n3317 n4028 U4692/net40 VSS nmos W=0.155u L=0.04u
M10697 n3317 U4692/net19 U4692/net36 VSS nmos W=0.155u L=0.04u
M10698 U4692/net40 g2000 VSS VSS nmos W=0.31u L=0.04u
M10699 U4692/net36 n4442 VSS VSS nmos W=0.155u L=0.04u
M10700 U4692/net19 n4028 VDD VDD pmos W=0.205u L=0.04u
M10701 n3317 U4692/net19 U4692/net26 VDD pmos W=0.325u L=0.04u
M10702 U4692/net26 g2000 VDD VDD pmos W=0.41u L=0.04u
M10703 n3317 n4028 U4692/net30 VDD pmos W=0.325u L=0.04u
M10704 U4692/net30 n4442 VDD VDD pmos W=0.205u L=0.04u
M10705 n4442 U4693/net28 VSS VSS nmos W=0.155u L=0.04u
M10706 U4693/net47 n4059 VSS VSS nmos W=0.155u L=0.04u
M10707 U4693/net28 U4693/net6 U4693/net47 VSS nmos W=0.155u L=0.04u
M10708 U4693/net44 n4443 VSS VSS nmos W=0.155u L=0.04u
M10709 U4693/net28 n4346 U4693/net44 VSS nmos W=0.155u L=0.04u
M10710 U4693/net6 n4346 VSS VSS nmos W=0.155u L=0.04u
M10711 n4442 U4693/net28 VDD VDD pmos W=0.205u L=0.04u
M10712 VDD n4059 U4693/net47 VDD pmos W=0.205u L=0.04u
M10713 U4693/net47 n4346 U4693/net28 VDD pmos W=0.205u L=0.04u
M10714 U4693/net44 U4693/net6 U4693/net28 VDD pmos W=0.205u L=0.04u
M10715 VDD n4443 U4693/net44 VDD pmos W=0.205u L=0.04u
M10716 VDD n4346 U4693/net6 VDD pmos W=0.205u L=0.04u
M10717 n4443 n4444 VSS VSS nmos W=0.155u L=0.04u
M10718 n4443 n4441 VSS VSS nmos W=0.155u L=0.04u
M10719 U4694/XI1-net8 n4441 VDD VDD pmos W=0.205u L=0.04u
M10720 n4443 n4444 U4694/XI1-net8 VDD pmos W=0.205u L=0.04u
M10721 U4695/XU1-net6 n4446 VSS VSS nmos W=0.155u L=0.04u
M10722 n4441 n4445 U4695/XU1-net6 VSS nmos W=0.155u L=0.04u
M10723 n4441 n4446 VDD VDD pmos W=0.155u L=0.04u
M10724 n4441 n4445 VDD VDD pmos W=0.155u L=0.04u
M10725 U4696/net19 n4449 VSS VSS nmos W=0.155u L=0.04u
M10726 n4446 n4449 U4696/net40 VSS nmos W=0.155u L=0.04u
M10727 n4446 U4696/net19 U4696/net36 VSS nmos W=0.155u L=0.04u
M10728 U4696/net40 n4448 VSS VSS nmos W=0.31u L=0.04u
M10729 U4696/net36 n4447 VSS VSS nmos W=0.155u L=0.04u
M10730 U4696/net19 n4449 VDD VDD pmos W=0.205u L=0.04u
M10731 n4446 U4696/net19 U4696/net26 VDD pmos W=0.325u L=0.04u
M10732 U4696/net26 n4448 VDD VDD pmos W=0.41u L=0.04u
M10733 n4446 n4449 U4696/net30 VDD pmos W=0.325u L=0.04u
M10734 U4696/net30 n4447 VDD VDD pmos W=0.205u L=0.04u
M10735 n4448 U4697/net6 VSS VSS nmos W=0.155u L=0.04u
M10736 U4697/X_u2-net6 n4045 VSS VSS nmos W=0.155u L=0.04u
M10737 U4697/net6 n4450 U4697/X_u2-net6 VSS nmos W=0.155u L=0.04u
M10738 n4448 U4697/net6 VDD VDD pmos W=0.205u L=0.04u
M10739 U4697/net6 n4045 VDD VDD pmos W=0.205u L=0.04u
M10740 U4697/net6 n4450 VDD VDD pmos W=0.205u L=0.04u
M10741 n4447 n4451 VSS VSS nmos W=0.155u L=0.04u
M10742 n4447 n4047 VSS VSS nmos W=0.155u L=0.04u
M10743 U4698/XI1-net8 n4047 VDD VDD pmos W=0.205u L=0.04u
M10744 n4447 n4451 U4698/XI1-net8 VDD pmos W=0.205u L=0.04u
M10745 U4699/net19 n4048 VSS VSS nmos W=0.155u L=0.04u
M10746 n4445 n4048 U4699/net40 VSS nmos W=0.155u L=0.04u
M10747 n4445 U4699/net19 U4699/net36 VSS nmos W=0.155u L=0.04u
M10748 U4699/net40 n4453 VSS VSS nmos W=0.31u L=0.04u
M10749 U4699/net36 n4452 VSS VSS nmos W=0.155u L=0.04u
M10750 U4699/net19 n4048 VDD VDD pmos W=0.205u L=0.04u
M10751 n4445 U4699/net19 U4699/net26 VDD pmos W=0.325u L=0.04u
M10752 U4699/net26 n4453 VDD VDD pmos W=0.41u L=0.04u
M10753 n4445 n4048 U4699/net30 VDD pmos W=0.325u L=0.04u
M10754 U4699/net30 n4452 VDD VDD pmos W=0.205u L=0.04u
M10755 U4700/net8 n4060 U4700/net26 VSS nmos W=0.155u L=0.04u
M10756 U4700/net26 n4455 VSS VSS nmos W=0.155u L=0.04u
M10757 U4700/net29 U4700/net8 VSS VSS nmos W=0.155u L=0.04u
M10758 U4700/net29 n4454 n4453 VSS nmos W=0.155u L=0.04u
M10759 U4700/net29 n4449 n4453 VSS nmos W=0.155u L=0.04u
M10760 U4700/net8 n4455 VDD VDD pmos W=0.205u L=0.04u
M10761 U4700/net8 n4060 VDD VDD pmos W=0.205u L=0.04u
M10762 n4453 U4700/net8 VDD VDD pmos W=0.205u L=0.04u
M10763 n4453 n4454 U4700/net20 VDD pmos W=0.205u L=0.04u
M10764 U4700/net20 n4449 VDD VDD pmos W=0.205u L=0.04u
M10765 n4454 n4457 U4701/XI21-net17 VSS nmos W=0.155u L=0.04u
M10766 U4701/XI21-net17 n4050 VSS VSS nmos W=0.155u L=0.04u
M10767 n4454 n4456 U4701/XI6-net17 VSS nmos W=0.155u L=0.04u
M10768 U4701/XI6-net17 n4051 VSS VSS nmos W=0.155u L=0.04u
M10769 n4454 n4450 U4701/XI20-net17 VSS nmos W=0.155u L=0.04u
M10770 U4701/XI20-net17 n4056 VSS VSS nmos W=0.155u L=0.04u
M10771 VDD n4457 U4701/net22 VDD pmos W=0.205u L=0.04u
M10772 VDD n4050 U4701/net22 VDD pmos W=0.205u L=0.04u
M10773 U4701/net16 n4456 n4454 VDD pmos W=0.205u L=0.04u
M10774 U4701/net16 n4051 n4454 VDD pmos W=0.205u L=0.04u
M10775 U4701/net22 n4450 U4701/net16 VDD pmos W=0.205u L=0.04u
M10776 U4701/net22 n4056 U4701/net16 VDD pmos W=0.205u L=0.04u
M10777 n4452 n4451 U4702/net14 VSS nmos W=0.155u L=0.04u
M10778 U4702/net14 n4459 VSS VSS nmos W=0.155u L=0.04u
M10779 U4702/net14 n4458 VSS VSS nmos W=0.155u L=0.04u
M10780 n4452 n553 U4702/net14 VSS nmos W=0.155u L=0.04u
M10781 n4452 n4456 U4702/net14 VSS nmos W=0.155u L=0.04u
M10782 n4452 n4459 U4702/XI16-net11 VDD pmos W=0.205u L=0.04u
M10783 U4702/XI16-net11 n4458 VDD VDD pmos W=0.205u L=0.04u
M10784 n4452 n553 U4702/XI15-net11 VDD pmos W=0.205u L=0.04u
M10785 U4702/XI15-net11 n4456 U4702/XI15-net18 VDD pmos W=0.205u L=0.04u
M10786 U4702/XI15-net18 n4451 VDD VDD pmos W=0.205u L=0.04u
M10787 n4459 n4456 U4703/XI21-net17 VSS nmos W=0.155u L=0.04u
M10788 U4703/XI21-net17 n4056 VSS VSS nmos W=0.155u L=0.04u
M10789 n4459 n4460 U4703/XI6-net17 VSS nmos W=0.155u L=0.04u
M10790 U4703/XI6-net17 n4050 VSS VSS nmos W=0.155u L=0.04u
M10791 n4459 n4457 U4703/XI20-net17 VSS nmos W=0.155u L=0.04u
M10792 U4703/XI20-net17 n4060 VSS VSS nmos W=0.155u L=0.04u
M10793 VDD n4456 U4703/net22 VDD pmos W=0.205u L=0.04u
M10794 VDD n4056 U4703/net22 VDD pmos W=0.205u L=0.04u
M10795 U4703/net16 n4460 n4459 VDD pmos W=0.205u L=0.04u
M10796 U4703/net16 n4050 n4459 VDD pmos W=0.205u L=0.04u
M10797 U4703/net22 n4457 U4703/net16 VDD pmos W=0.205u L=0.04u
M10798 U4703/net22 n4060 U4703/net16 VDD pmos W=0.205u L=0.04u
M10799 n4056 n4055 VSS VSS nmos W=0.135u L=0.04u
M10800 n4056 n4055 VDD VDD pmos W=0.205u L=0.04u
M10801 U4705/XU1-net6 n553 VSS VSS nmos W=0.155u L=0.04u
M10802 n4055 n555 U4705/XU1-net6 VSS nmos W=0.155u L=0.04u
M10803 n4055 n553 VDD VDD pmos W=0.155u L=0.04u
M10804 n4055 n555 VDD VDD pmos W=0.155u L=0.04u
M10805 U4706/net19 n4351 VSS VSS nmos W=0.155u L=0.04u
M10806 n4444 n4351 U4706/net40 VSS nmos W=0.155u L=0.04u
M10807 n4444 U4706/net19 U4706/net36 VSS nmos W=0.155u L=0.04u
M10808 U4706/net40 n4440 VSS VSS nmos W=0.31u L=0.04u
M10809 U4706/net36 n4435 VSS VSS nmos W=0.155u L=0.04u
M10810 U4706/net19 n4351 VDD VDD pmos W=0.205u L=0.04u
M10811 n4444 U4706/net19 U4706/net26 VDD pmos W=0.325u L=0.04u
M10812 U4706/net26 n4440 VDD VDD pmos W=0.41u L=0.04u
M10813 n4444 n4351 U4706/net30 VDD pmos W=0.325u L=0.04u
M10814 U4706/net30 n4435 VDD VDD pmos W=0.205u L=0.04u
M10815 n4351 n4461 VSS VSS nmos W=0.155u L=0.04u
M10816 n4351 g1930 U4707/XI17-net17 VSS nmos W=0.155u L=0.04u
M10817 U4707/XI17-net17 g1982 VSS VSS nmos W=0.155u L=0.04u
M10818 n4351 g7194 U4707/XI10-net17 VSS nmos W=0.155u L=0.04u
M10819 U4707/XI10-net17 g1979 VSS VSS nmos W=0.155u L=0.04u
M10820 U4707/net30 g7194 n4351 VDD pmos W=0.205u L=0.04u
M10821 U4707/net30 g1979 n4351 VDD pmos W=0.205u L=0.04u
M10822 VDD n4461 U4707/net36 VDD pmos W=0.205u L=0.04u
M10823 U4707/net36 g1982 U4707/net30 VDD pmos W=0.205u L=0.04u
M10824 U4707/net36 g1930 U4707/net30 VDD pmos W=0.205u L=0.04u
M10825 n4461 U4708/net27 VDD VDD pmos W=0.205u L=0.04u
M10826 U4708/net27 g185 U4708/net23 VDD pmos W=0.205u L=0.04u
M10827 U4708/net27 g1922 U4708/net23 VDD pmos W=0.205u L=0.04u
M10828 U4708/net27 n3643 U4708/net23 VDD pmos W=0.205u L=0.04u
M10829 U4708/net23 g1976 VDD VDD pmos W=0.205u L=0.04u
M10830 U4708/net23 g7052 VDD VDD pmos W=0.205u L=0.04u
M10831 n4461 U4708/net27 VSS VSS nmos W=0.155u L=0.04u
M10832 U4708/XI20-net13 g1922 VSS VSS nmos W=0.155u L=0.04u
M10833 U4708/net27 g185 U4708/XI20-net17 VSS nmos W=0.155u L=0.04u
M10834 U4708/XI20-net17 n3643 U4708/XI20-net13 VSS nmos W=0.155u L=0.04u
M10835 U4708/net27 g1976 U4708/XI17-net17 VSS nmos W=0.155u L=0.04u
M10836 U4708/XI17-net17 g7052 VSS VSS nmos W=0.155u L=0.04u
M10837 n3643 U4709/net39 VDD VDD pmos W=0.205u L=0.04u
M10838 VDD g1947 U4709/net22 VDD pmos W=0.205u L=0.04u
M10839 VDD g7194 U4709/net22 VDD pmos W=0.205u L=0.04u
M10840 U4709/net16 g1945 U4709/net39 VDD pmos W=0.205u L=0.04u
M10841 U4709/net16 g7052 U4709/net39 VDD pmos W=0.205u L=0.04u
M10842 U4709/net22 g1870 U4709/net16 VDD pmos W=0.205u L=0.04u
M10843 U4709/net22 g1930 U4709/net16 VDD pmos W=0.205u L=0.04u
M10844 n3643 U4709/net39 VSS VSS nmos W=0.155u L=0.04u
M10845 U4709/net39 g1947 U4709/XI22-net17 VSS nmos W=0.155u L=0.04u
M10846 U4709/XI22-net17 g7194 VSS VSS nmos W=0.155u L=0.04u
M10847 U4709/net39 g1945 U4709/XI6-net17 VSS nmos W=0.155u L=0.04u
M10848 U4709/XI6-net17 g7052 VSS VSS nmos W=0.155u L=0.04u
M10849 U4709/net39 g1870 U4709/XI21-net17 VSS nmos W=0.155u L=0.04u
M10850 U4709/XI21-net17 g1930 VSS VSS nmos W=0.155u L=0.04u
M10851 n4440 n4463 U4710/net26 VSS nmos W=0.155u L=0.04u
M10852 n4440 n4462 U4710/net26 VSS nmos W=0.155u L=0.04u
M10853 U4710/net29 n4465 VSS VSS nmos W=0.155u L=0.04u
M10854 U4710/net26 n554 U4710/net29 VSS nmos W=0.155u L=0.04u
M10855 U4710/net26 n4464 U4710/net29 VSS nmos W=0.155u L=0.04u
M10856 n4440 n4462 U4710/net43 VDD pmos W=0.205u L=0.04u
M10857 n4440 n4464 U4710/net49 VDD pmos W=0.205u L=0.04u
M10858 U4710/net49 n554 VDD VDD pmos W=0.205u L=0.04u
M10859 U4710/net43 n4463 VDD VDD pmos W=0.205u L=0.04u
M10860 n4440 n4465 VDD VDD pmos W=0.205u L=0.04u
M10861 U4711/net19 n4449 VSS VSS nmos W=0.155u L=0.04u
M10862 n4465 n4449 U4711/net40 VSS nmos W=0.155u L=0.04u
M10863 n4465 U4711/net19 U4711/net36 VSS nmos W=0.155u L=0.04u
M10864 U4711/net40 n4467 VSS VSS nmos W=0.31u L=0.04u
M10865 U4711/net36 n4466 VSS VSS nmos W=0.155u L=0.04u
M10866 U4711/net19 n4449 VDD VDD pmos W=0.205u L=0.04u
M10867 n4465 U4711/net19 U4711/net26 VDD pmos W=0.325u L=0.04u
M10868 U4711/net26 n4467 VDD VDD pmos W=0.41u L=0.04u
M10869 n4465 n4449 U4711/net30 VDD pmos W=0.325u L=0.04u
M10870 U4711/net30 n4466 VDD VDD pmos W=0.205u L=0.04u
M10871 n4467 n4468 U4712/net27 VSS nmos W=0.155u L=0.04u
M10872 U4712/net39 n4464 VSS VSS nmos W=0.155u L=0.04u
M10873 U4712/net27 n4469 U4712/net39 VSS nmos W=0.155u L=0.04u
M10874 U4712/net27 n4470 U4712/net39 VSS nmos W=0.155u L=0.04u
M10875 n4467 n4047 U4712/net27 VSS nmos W=0.155u L=0.04u
M10876 U4712/net39 n4045 VSS VSS nmos W=0.155u L=0.04u
M10877 n4467 n4464 U4712/net46 VDD pmos W=0.205u L=0.04u
M10878 U4712/net46 n4045 VDD VDD pmos W=0.205u L=0.04u
M10879 n4467 n4047 U4712/net34 VDD pmos W=0.205u L=0.04u
M10880 U4712/net34 n4468 VDD VDD pmos W=0.205u L=0.04u
M10881 n4467 n4470 U4712/net37 VDD pmos W=0.205u L=0.04u
M10882 U4712/net37 n4469 VDD VDD pmos W=0.205u L=0.04u
M10883 U4713/net14 n4460 U4713/net20 VSS nmos W=0.155u L=0.04u
M10884 U4713/net14 n553 U4713/net20 VSS nmos W=0.155u L=0.04u
M10885 U4713/net20 n4047 VSS VSS nmos W=0.155u L=0.04u
M10886 n4469 U4713/net14 VSS VSS nmos W=0.155u L=0.04u
M10887 n4469 U4713/net14 VDD VDD pmos W=0.205u L=0.04u
M10888 U4713/net14 n4047 VDD VDD pmos W=0.205u L=0.04u
M10889 U4713/net24 n4460 VDD VDD pmos W=0.205u L=0.04u
M10890 U4713/net14 n553 U4713/net24 VDD pmos W=0.205u L=0.04u
M10891 n4468 n4457 VSS VSS nmos W=0.135u L=0.04u
M10892 n4468 n4457 VDD VDD pmos W=0.205u L=0.04u
M10893 n4457 n4460 VSS VSS nmos W=0.155u L=0.04u
M10894 n4457 n4455 VSS VSS nmos W=0.155u L=0.04u
M10895 U4715/XI1-net8 n4455 VDD VDD pmos W=0.205u L=0.04u
M10896 n4457 n4460 U4715/XI1-net8 VDD pmos W=0.205u L=0.04u
M10897 U4716/XU1-net6 n4051 VSS VSS nmos W=0.155u L=0.04u
M10898 n4047 n554 U4716/XU1-net6 VSS nmos W=0.155u L=0.04u
M10899 n4047 n4051 VDD VDD pmos W=0.155u L=0.04u
M10900 n4047 n554 VDD VDD pmos W=0.155u L=0.04u
M10901 n4466 n552 U4717/net14 VSS nmos W=0.155u L=0.04u
M10902 U4717/net14 n4470 VSS VSS nmos W=0.155u L=0.04u
M10903 U4717/net14 n4471 VSS VSS nmos W=0.155u L=0.04u
M10904 n4466 n555 U4717/net14 VSS nmos W=0.155u L=0.04u
M10905 n4466 n4455 U4717/net14 VSS nmos W=0.155u L=0.04u
M10906 n4466 n4470 U4717/XI16-net11 VDD pmos W=0.205u L=0.04u
M10907 U4717/XI16-net11 n4471 VDD VDD pmos W=0.205u L=0.04u
M10908 n4466 n555 U4717/XI15-net11 VDD pmos W=0.205u L=0.04u
M10909 U4717/XI15-net11 n4455 U4717/XI15-net18 VDD pmos W=0.205u L=0.04u
M10910 U4717/XI15-net18 n552 VDD VDD pmos W=0.205u L=0.04u
M10911 n4470 n4456 VSS VSS nmos W=0.135u L=0.04u
M10912 n4470 n4456 VDD VDD pmos W=0.205u L=0.04u
M10913 n4471 n4060 U4719/net27 VSS nmos W=0.155u L=0.04u
M10914 U4719/net27 n4451 VSS VSS nmos W=0.155u L=0.04u
M10915 n4471 n4045 VSS VSS nmos W=0.155u L=0.04u
M10916 n4471 n4451 U4719/net13 VDD pmos W=0.205u L=0.04u
M10917 U4719/net13 n4045 VDD VDD pmos W=0.205u L=0.04u
M10918 n4471 n4060 U4719/net13 VDD pmos W=0.205u L=0.04u
M10919 n4060 n4050 VSS VSS nmos W=0.155u L=0.04u
M10920 n4060 n4051 VSS VSS nmos W=0.155u L=0.04u
M10921 U4720/XI1-net8 n4051 VDD VDD pmos W=0.205u L=0.04u
M10922 n4060 n4050 U4720/XI1-net8 VDD pmos W=0.205u L=0.04u
M10923 n555 n4045 VSS VSS nmos W=0.135u L=0.04u
M10924 n555 n4045 VDD VDD pmos W=0.205u L=0.04u
M10925 n4045 n4031 U4722/net27 VSS nmos W=0.155u L=0.04u
M10926 U4722/net39 n4030 VSS VSS nmos W=0.155u L=0.04u
M10927 U4722/net27 g1964 U4722/net39 VSS nmos W=0.155u L=0.04u
M10928 U4722/net27 n4028 U4722/net39 VSS nmos W=0.155u L=0.04u
M10929 n4045 g1965 U4722/net27 VSS nmos W=0.155u L=0.04u
M10930 U4722/net39 g1966 VSS VSS nmos W=0.155u L=0.04u
M10931 n4045 n4030 U4722/net46 VDD pmos W=0.205u L=0.04u
M10932 U4722/net46 g1966 VDD VDD pmos W=0.205u L=0.04u
M10933 n4045 g1965 U4722/net34 VDD pmos W=0.205u L=0.04u
M10934 U4722/net34 n4031 VDD VDD pmos W=0.205u L=0.04u
M10935 n4045 n4028 U4722/net37 VDD pmos W=0.205u L=0.04u
M10936 U4722/net37 g1964 VDD VDD pmos W=0.205u L=0.04u
M10937 U4723/net19 n552 VSS VSS nmos W=0.155u L=0.04u
M10938 n4464 n552 U4723/net40 VSS nmos W=0.155u L=0.04u
M10939 n4464 U4723/net19 U4723/net36 VSS nmos W=0.155u L=0.04u
M10940 U4723/net40 n4455 VSS VSS nmos W=0.31u L=0.04u
M10941 U4723/net36 n4472 VSS VSS nmos W=0.155u L=0.04u
M10942 U4723/net19 n552 VDD VDD pmos W=0.205u L=0.04u
M10943 n4464 U4723/net19 U4723/net26 VDD pmos W=0.325u L=0.04u
M10944 U4723/net26 n4455 VDD VDD pmos W=0.41u L=0.04u
M10945 n4464 n552 U4723/net30 VDD pmos W=0.325u L=0.04u
M10946 U4723/net30 n4472 VDD VDD pmos W=0.205u L=0.04u
M10947 n552 n4048 VSS VSS nmos W=0.135u L=0.04u
M10948 n552 n4048 VDD VDD pmos W=0.205u L=0.04u
M10949 n4455 g1705 U4725/XI21-net17 VSS nmos W=0.155u L=0.04u
M10950 U4725/XI21-net17 g1718 VSS VSS nmos W=0.155u L=0.04u
M10951 n4455 g1775 U4725/XI6-net17 VSS nmos W=0.155u L=0.04u
M10952 U4725/XI6-net17 g5695 VSS VSS nmos W=0.155u L=0.04u
M10953 n4455 g1777 U4725/XI20-net17 VSS nmos W=0.155u L=0.04u
M10954 U4725/XI20-net17 g5738 VSS VSS nmos W=0.155u L=0.04u
M10955 VDD g1705 U4725/net22 VDD pmos W=0.205u L=0.04u
M10956 VDD g1718 U4725/net22 VDD pmos W=0.205u L=0.04u
M10957 U4725/net16 g1775 n4455 VDD pmos W=0.205u L=0.04u
M10958 U4725/net16 g5695 n4455 VDD pmos W=0.205u L=0.04u
M10959 U4725/net22 g1777 U4725/net16 VDD pmos W=0.205u L=0.04u
M10960 U4725/net22 g5738 U4725/net16 VDD pmos W=0.205u L=0.04u
M10961 n4472 n4451 VSS VSS nmos W=0.155u L=0.04u
M10962 n4472 n4456 VSS VSS nmos W=0.155u L=0.04u
M10963 U4726/XI1-net8 n4456 VDD VDD pmos W=0.205u L=0.04u
M10964 n4472 n4451 U4726/XI1-net8 VDD pmos W=0.205u L=0.04u
M10965 n4451 n4460 VSS VSS nmos W=0.135u L=0.04u
M10966 n4451 n4460 VDD VDD pmos W=0.205u L=0.04u
M10967 n554 n4050 VSS VSS nmos W=0.135u L=0.04u
M10968 n554 n4050 VDD VDD pmos W=0.205u L=0.04u
M10969 U4729/net19 n4048 VSS VSS nmos W=0.155u L=0.04u
M10970 n4463 n4048 U4729/net40 VSS nmos W=0.155u L=0.04u
M10971 n4463 U4729/net19 U4729/net36 VSS nmos W=0.155u L=0.04u
M10972 U4729/net40 n4460 VSS VSS nmos W=0.31u L=0.04u
M10973 U4729/net36 n4450 VSS VSS nmos W=0.155u L=0.04u
M10974 U4729/net19 n4048 VDD VDD pmos W=0.205u L=0.04u
M10975 n4463 U4729/net19 U4729/net26 VDD pmos W=0.325u L=0.04u
M10976 U4729/net26 n4460 VDD VDD pmos W=0.41u L=0.04u
M10977 n4463 n4048 U4729/net30 VDD pmos W=0.325u L=0.04u
M10978 U4729/net30 n4450 VDD VDD pmos W=0.205u L=0.04u
M10979 n4048 n4031 U4730/net27 VSS nmos W=0.155u L=0.04u
M10980 U4730/net39 n4030 VSS VSS nmos W=0.155u L=0.04u
M10981 U4730/net27 g1955 U4730/net39 VSS nmos W=0.155u L=0.04u
M10982 U4730/net27 n4028 U4730/net39 VSS nmos W=0.155u L=0.04u
M10983 n4048 g1956 U4730/net27 VSS nmos W=0.155u L=0.04u
M10984 U4730/net39 g1957 VSS VSS nmos W=0.155u L=0.04u
M10985 n4048 n4030 U4730/net46 VDD pmos W=0.205u L=0.04u
M10986 U4730/net46 g1957 VDD VDD pmos W=0.205u L=0.04u
M10987 n4048 g1956 U4730/net34 VDD pmos W=0.205u L=0.04u
M10988 U4730/net34 n4031 VDD VDD pmos W=0.205u L=0.04u
M10989 n4048 n4028 U4730/net37 VDD pmos W=0.205u L=0.04u
M10990 U4730/net37 g1955 VDD VDD pmos W=0.205u L=0.04u
M10991 n4450 n4460 VSS VSS nmos W=0.155u L=0.04u
M10992 n4450 n4456 VSS VSS nmos W=0.155u L=0.04u
M10993 U4731/XI1-net8 n4456 VDD VDD pmos W=0.205u L=0.04u
M10994 n4450 n4460 U4731/XI1-net8 VDD pmos W=0.205u L=0.04u
M10995 n4456 g1764 U4732/XI21-net17 VSS nmos W=0.155u L=0.04u
M10996 U4732/XI21-net17 g1718 VSS VSS nmos W=0.155u L=0.04u
M10997 n4456 g1760 U4732/XI6-net17 VSS nmos W=0.155u L=0.04u
M10998 U4732/XI6-net17 g5695 VSS VSS nmos W=0.155u L=0.04u
M10999 n4456 g1762 U4732/XI20-net17 VSS nmos W=0.155u L=0.04u
M11000 U4732/XI20-net17 g5738 VSS VSS nmos W=0.155u L=0.04u
M11001 VDD g1764 U4732/net22 VDD pmos W=0.205u L=0.04u
M11002 VDD g1718 U4732/net22 VDD pmos W=0.205u L=0.04u
M11003 U4732/net16 g1760 n4456 VDD pmos W=0.205u L=0.04u
M11004 U4732/net16 g5695 n4456 VDD pmos W=0.205u L=0.04u
M11005 U4732/net22 g1762 U4732/net16 VDD pmos W=0.205u L=0.04u
M11006 U4732/net22 g5738 U4732/net16 VDD pmos W=0.205u L=0.04u
M11007 n4460 g1749 U4733/XI21-net17 VSS nmos W=0.155u L=0.04u
M11008 U4733/XI21-net17 g1718 VSS VSS nmos W=0.155u L=0.04u
M11009 n4460 g1745 U4733/XI6-net17 VSS nmos W=0.155u L=0.04u
M11010 U4733/XI6-net17 g5695 VSS VSS nmos W=0.155u L=0.04u
M11011 n4460 g1747 U4733/XI20-net17 VSS nmos W=0.155u L=0.04u
M11012 U4733/XI20-net17 g5738 VSS VSS nmos W=0.155u L=0.04u
M11013 VDD g1749 U4733/net22 VDD pmos W=0.205u L=0.04u
M11014 VDD g1718 U4733/net22 VDD pmos W=0.205u L=0.04u
M11015 U4733/net16 g1745 n4460 VDD pmos W=0.205u L=0.04u
M11016 U4733/net16 g5695 n4460 VDD pmos W=0.205u L=0.04u
M11017 U4733/net22 g1747 U4733/net16 VDD pmos W=0.205u L=0.04u
M11018 U4733/net22 g5738 U4733/net16 VDD pmos W=0.205u L=0.04u
M11019 U4734/net19 n4449 VSS VSS nmos W=0.155u L=0.04u
M11020 n4462 n4449 U4734/net40 VSS nmos W=0.155u L=0.04u
M11021 n4462 U4734/net19 U4734/net36 VSS nmos W=0.155u L=0.04u
M11022 U4734/net40 n4050 VSS VSS nmos W=0.31u L=0.04u
M11023 U4734/net36 n553 VSS VSS nmos W=0.155u L=0.04u
M11024 U4734/net19 n4449 VDD VDD pmos W=0.205u L=0.04u
M11025 n4462 U4734/net19 U4734/net26 VDD pmos W=0.325u L=0.04u
M11026 U4734/net26 n4050 VDD VDD pmos W=0.41u L=0.04u
M11027 n4462 n4449 U4734/net30 VDD pmos W=0.325u L=0.04u
M11028 U4734/net30 n553 VDD VDD pmos W=0.205u L=0.04u
M11029 n4449 n4458 VSS VSS nmos W=0.135u L=0.04u
M11030 n4449 n4458 VDD VDD pmos W=0.205u L=0.04u
M11031 n4458 g1734 U4736/XI21-net17 VSS nmos W=0.155u L=0.04u
M11032 U4736/XI21-net17 g1718 VSS VSS nmos W=0.155u L=0.04u
M11033 n4458 g5695 U4736/XI6-net17 VSS nmos W=0.155u L=0.04u
M11034 U4736/XI6-net17 g1730 VSS VSS nmos W=0.155u L=0.04u
M11035 n4458 g5738 U4736/XI20-net17 VSS nmos W=0.155u L=0.04u
M11036 U4736/XI20-net17 g1732 VSS VSS nmos W=0.155u L=0.04u
M11037 VDD g1734 U4736/net22 VDD pmos W=0.205u L=0.04u
M11038 VDD g1718 U4736/net22 VDD pmos W=0.205u L=0.04u
M11039 U4736/net16 g5695 n4458 VDD pmos W=0.205u L=0.04u
M11040 U4736/net16 g1730 n4458 VDD pmos W=0.205u L=0.04u
M11041 U4736/net22 g5738 U4736/net16 VDD pmos W=0.205u L=0.04u
M11042 U4736/net22 g1732 U4736/net16 VDD pmos W=0.205u L=0.04u
M11043 n4050 n4031 U4737/net27 VSS nmos W=0.155u L=0.04u
M11044 U4737/net39 n4030 VSS VSS nmos W=0.155u L=0.04u
M11045 U4737/net27 g1961 U4737/net39 VSS nmos W=0.155u L=0.04u
M11046 U4737/net27 n4028 U4737/net39 VSS nmos W=0.155u L=0.04u
M11047 n4050 g1962 U4737/net27 VSS nmos W=0.155u L=0.04u
M11048 U4737/net39 g1963 VSS VSS nmos W=0.155u L=0.04u
M11049 n4050 n4030 U4737/net46 VDD pmos W=0.205u L=0.04u
M11050 U4737/net46 g1963 VDD VDD pmos W=0.205u L=0.04u
M11051 n4050 g1962 U4737/net34 VDD pmos W=0.205u L=0.04u
M11052 U4737/net34 n4031 VDD VDD pmos W=0.205u L=0.04u
M11053 n4050 n4028 U4737/net37 VDD pmos W=0.205u L=0.04u
M11054 U4737/net37 g1961 VDD VDD pmos W=0.205u L=0.04u
M11055 n553 n4051 VSS VSS nmos W=0.135u L=0.04u
M11056 n553 n4051 VDD VDD pmos W=0.205u L=0.04u
M11057 n4051 n4031 U4739/net27 VSS nmos W=0.155u L=0.04u
M11058 U4739/net39 n4030 VSS VSS nmos W=0.155u L=0.04u
M11059 U4739/net27 g1958 U4739/net39 VSS nmos W=0.155u L=0.04u
M11060 U4739/net27 n4028 U4739/net39 VSS nmos W=0.155u L=0.04u
M11061 n4051 g1959 U4739/net27 VSS nmos W=0.155u L=0.04u
M11062 U4739/net39 g1960 VSS VSS nmos W=0.155u L=0.04u
M11063 n4051 n4030 U4739/net46 VDD pmos W=0.205u L=0.04u
M11064 U4739/net46 g1960 VDD VDD pmos W=0.205u L=0.04u
M11065 n4051 g1959 U4739/net34 VDD pmos W=0.205u L=0.04u
M11066 U4739/net34 n4031 VDD VDD pmos W=0.205u L=0.04u
M11067 n4051 n4028 U4739/net37 VDD pmos W=0.205u L=0.04u
M11068 U4739/net37 g1958 VDD VDD pmos W=0.205u L=0.04u
M11069 n4030 g7194 VSS VSS nmos W=0.135u L=0.04u
M11070 n4030 g7194 VDD VDD pmos W=0.205u L=0.04u
M11071 n4028 g1930 VSS VSS nmos W=0.135u L=0.04u
M11072 n4028 g1930 VDD VDD pmos W=0.205u L=0.04u
M11073 n4031 g7052 VSS VSS nmos W=0.135u L=0.04u
M11074 n4031 g7052 VDD VDD pmos W=0.205u L=0.04u
M11075 n4435 n4473 VSS VSS nmos W=0.155u L=0.04u
M11076 n4435 g7052 U4743/XI17-net17 VSS nmos W=0.155u L=0.04u
M11077 U4743/XI17-net17 g1967 VSS VSS nmos W=0.155u L=0.04u
M11078 n4435 g7194 U4743/XI10-net17 VSS nmos W=0.155u L=0.04u
M11079 U4743/XI10-net17 g1970 VSS VSS nmos W=0.155u L=0.04u
M11080 U4743/net30 g7194 n4435 VDD pmos W=0.205u L=0.04u
M11081 U4743/net30 g1970 n4435 VDD pmos W=0.205u L=0.04u
M11082 VDD n4473 U4743/net36 VDD pmos W=0.205u L=0.04u
M11083 U4743/net36 g1967 U4743/net30 VDD pmos W=0.205u L=0.04u
M11084 U4743/net36 g7052 U4743/net30 VDD pmos W=0.205u L=0.04u
M11085 n4473 U4744/net27 VDD VDD pmos W=0.205u L=0.04u
M11086 U4744/net27 g185 U4744/net23 VDD pmos W=0.205u L=0.04u
M11087 U4744/net27 g1904 U4744/net23 VDD pmos W=0.205u L=0.04u
M11088 U4744/net27 n3642 U4744/net23 VDD pmos W=0.205u L=0.04u
M11089 U4744/net23 g1973 VDD VDD pmos W=0.205u L=0.04u
M11090 U4744/net23 g1930 VDD VDD pmos W=0.205u L=0.04u
M11091 n4473 U4744/net27 VSS VSS nmos W=0.155u L=0.04u
M11092 U4744/XI20-net13 g1904 VSS VSS nmos W=0.155u L=0.04u
M11093 U4744/net27 g185 U4744/XI20-net17 VSS nmos W=0.155u L=0.04u
M11094 U4744/XI20-net17 n3642 U4744/XI20-net13 VSS nmos W=0.155u L=0.04u
M11095 U4744/net27 g1973 U4744/XI17-net17 VSS nmos W=0.155u L=0.04u
M11096 U4744/XI17-net17 g1930 VSS VSS nmos W=0.155u L=0.04u
M11097 n3642 U4745/net39 VDD VDD pmos W=0.205u L=0.04u
M11098 VDD g1951 U4745/net22 VDD pmos W=0.205u L=0.04u
M11099 VDD g7194 U4745/net22 VDD pmos W=0.205u L=0.04u
M11100 U4745/net16 g1949 U4745/net39 VDD pmos W=0.205u L=0.04u
M11101 U4745/net16 g7052 U4745/net39 VDD pmos W=0.205u L=0.04u
M11102 U4745/net22 g1953 U4745/net16 VDD pmos W=0.205u L=0.04u
M11103 U4745/net22 g1930 U4745/net16 VDD pmos W=0.205u L=0.04u
M11104 n3642 U4745/net39 VSS VSS nmos W=0.155u L=0.04u
M11105 U4745/net39 g1951 U4745/XI22-net17 VSS nmos W=0.155u L=0.04u
M11106 U4745/XI22-net17 g7194 VSS VSS nmos W=0.155u L=0.04u
M11107 U4745/net39 g1949 U4745/XI6-net17 VSS nmos W=0.155u L=0.04u
M11108 U4745/XI6-net17 g7052 VSS VSS nmos W=0.155u L=0.04u
M11109 U4745/net39 g1953 U4745/XI21-net17 VSS nmos W=0.155u L=0.04u
M11110 U4745/XI21-net17 g1930 VSS VSS nmos W=0.155u L=0.04u
M11111 U4746/net19 n3921 VSS VSS nmos W=0.155u L=0.04u
M11112 n3316 n3921 U4746/net40 VSS nmos W=0.155u L=0.04u
M11113 n3316 U4746/net19 U4746/net36 VSS nmos W=0.155u L=0.04u
M11114 U4746/net40 g2661 VSS VSS nmos W=0.31u L=0.04u
M11115 U4746/net36 n4474 VSS VSS nmos W=0.155u L=0.04u
M11116 U4746/net19 n3921 VDD VDD pmos W=0.205u L=0.04u
M11117 n3316 U4746/net19 U4746/net26 VDD pmos W=0.325u L=0.04u
M11118 U4746/net26 g2661 VDD VDD pmos W=0.41u L=0.04u
M11119 n3316 n3921 U4746/net30 VDD pmos W=0.325u L=0.04u
M11120 U4746/net30 n4474 VDD VDD pmos W=0.205u L=0.04u
M11121 U4747/net19 n3920 VSS VSS nmos W=0.155u L=0.04u
M11122 n3315 n3920 U4747/net40 VSS nmos W=0.155u L=0.04u
M11123 n3315 U4747/net19 U4747/net36 VSS nmos W=0.155u L=0.04u
M11124 U4747/net40 g2664 VSS VSS nmos W=0.31u L=0.04u
M11125 U4747/net36 n4474 VSS VSS nmos W=0.155u L=0.04u
M11126 U4747/net19 n3920 VDD VDD pmos W=0.205u L=0.04u
M11127 n3315 U4747/net19 U4747/net26 VDD pmos W=0.325u L=0.04u
M11128 U4747/net26 g2664 VDD VDD pmos W=0.41u L=0.04u
M11129 n3315 n3920 U4747/net30 VDD pmos W=0.325u L=0.04u
M11130 U4747/net30 n4474 VDD VDD pmos W=0.205u L=0.04u
M11131 U4748/net19 n3918 VSS VSS nmos W=0.155u L=0.04u
M11132 n3314 n3918 U4748/net40 VSS nmos W=0.155u L=0.04u
M11133 n3314 U4748/net19 U4748/net36 VSS nmos W=0.155u L=0.04u
M11134 U4748/net40 g2667 VSS VSS nmos W=0.31u L=0.04u
M11135 U4748/net36 n4474 VSS VSS nmos W=0.155u L=0.04u
M11136 U4748/net19 n3918 VDD VDD pmos W=0.205u L=0.04u
M11137 n3314 U4748/net19 U4748/net26 VDD pmos W=0.325u L=0.04u
M11138 U4748/net26 g2667 VDD VDD pmos W=0.41u L=0.04u
M11139 n3314 n3918 U4748/net30 VDD pmos W=0.325u L=0.04u
M11140 U4748/net30 n4474 VDD VDD pmos W=0.205u L=0.04u
M11141 n4474 n4346 VSS VSS nmos W=0.155u L=0.04u
M11142 n4474 n4475 VSS VSS nmos W=0.155u L=0.04u
M11143 U4749/XI1-net8 n4475 VDD VDD pmos W=0.205u L=0.04u
M11144 n4474 n4346 U4749/XI1-net8 VDD pmos W=0.205u L=0.04u
M11145 U4750/net19 n3921 VSS VSS nmos W=0.155u L=0.04u
M11146 n3313 n3921 U4750/net40 VSS nmos W=0.155u L=0.04u
M11147 n3313 U4750/net19 U4750/net36 VSS nmos W=0.155u L=0.04u
M11148 U4750/net40 g2679 VSS VSS nmos W=0.31u L=0.04u
M11149 U4750/net36 n4476 VSS VSS nmos W=0.155u L=0.04u
M11150 U4750/net19 n3921 VDD VDD pmos W=0.205u L=0.04u
M11151 n3313 U4750/net19 U4750/net26 VDD pmos W=0.325u L=0.04u
M11152 U4750/net26 g2679 VDD VDD pmos W=0.41u L=0.04u
M11153 n3313 n3921 U4750/net30 VDD pmos W=0.325u L=0.04u
M11154 U4750/net30 n4476 VDD VDD pmos W=0.205u L=0.04u
M11155 U4751/net19 n3920 VSS VSS nmos W=0.155u L=0.04u
M11156 n3312 n3920 U4751/net40 VSS nmos W=0.155u L=0.04u
M11157 n3312 U4751/net19 U4751/net36 VSS nmos W=0.155u L=0.04u
M11158 U4751/net40 g2682 VSS VSS nmos W=0.31u L=0.04u
M11159 U4751/net36 n4476 VSS VSS nmos W=0.155u L=0.04u
M11160 U4751/net19 n3920 VDD VDD pmos W=0.205u L=0.04u
M11161 n3312 U4751/net19 U4751/net26 VDD pmos W=0.325u L=0.04u
M11162 U4751/net26 g2682 VDD VDD pmos W=0.41u L=0.04u
M11163 n3312 n3920 U4751/net30 VDD pmos W=0.325u L=0.04u
M11164 U4751/net30 n4476 VDD VDD pmos W=0.205u L=0.04u
M11165 U4752/net19 n3918 VSS VSS nmos W=0.155u L=0.04u
M11166 n3311 n3918 U4752/net40 VSS nmos W=0.155u L=0.04u
M11167 n3311 U4752/net19 U4752/net36 VSS nmos W=0.155u L=0.04u
M11168 U4752/net40 g2685 VSS VSS nmos W=0.31u L=0.04u
M11169 U4752/net36 n4476 VSS VSS nmos W=0.155u L=0.04u
M11170 U4752/net19 n3918 VDD VDD pmos W=0.205u L=0.04u
M11171 n3311 U4752/net19 U4752/net26 VDD pmos W=0.325u L=0.04u
M11172 U4752/net26 g2685 VDD VDD pmos W=0.41u L=0.04u
M11173 n3311 n3918 U4752/net30 VDD pmos W=0.325u L=0.04u
M11174 U4752/net30 n4476 VDD VDD pmos W=0.205u L=0.04u
M11175 n4476 U4753/net28 VSS VSS nmos W=0.155u L=0.04u
M11176 U4753/net47 n4477 VSS VSS nmos W=0.155u L=0.04u
M11177 U4753/net28 U4753/net6 U4753/net47 VSS nmos W=0.155u L=0.04u
M11178 U4753/net44 n4478 VSS VSS nmos W=0.155u L=0.04u
M11179 U4753/net28 n4346 U4753/net44 VSS nmos W=0.155u L=0.04u
M11180 U4753/net6 n4346 VSS VSS nmos W=0.155u L=0.04u
M11181 n4476 U4753/net28 VDD VDD pmos W=0.205u L=0.04u
M11182 VDD n4477 U4753/net47 VDD pmos W=0.205u L=0.04u
M11183 U4753/net47 n4346 U4753/net28 VDD pmos W=0.205u L=0.04u
M11184 U4753/net44 U4753/net6 U4753/net28 VDD pmos W=0.205u L=0.04u
M11185 VDD n4478 U4753/net44 VDD pmos W=0.205u L=0.04u
M11186 VDD n4346 U4753/net6 VDD pmos W=0.205u L=0.04u
M11187 n4478 n4479 VSS VSS nmos W=0.155u L=0.04u
M11188 n4478 n4480 VSS VSS nmos W=0.155u L=0.04u
M11189 U4754/XI1-net8 n4480 VDD VDD pmos W=0.205u L=0.04u
M11190 n4478 n4479 U4754/XI1-net8 VDD pmos W=0.205u L=0.04u
M11191 U4755/net19 n4475 VSS VSS nmos W=0.155u L=0.04u
M11192 n4479 n4475 U4755/net40 VSS nmos W=0.155u L=0.04u
M11193 n4479 U4755/net19 U4755/net36 VSS nmos W=0.155u L=0.04u
M11194 U4755/net40 n4481 VSS VSS nmos W=0.31u L=0.04u
M11195 U4755/net36 n4393 VSS VSS nmos W=0.155u L=0.04u
M11196 U4755/net19 n4475 VDD VDD pmos W=0.205u L=0.04u
M11197 n4479 U4755/net19 U4755/net26 VDD pmos W=0.325u L=0.04u
M11198 U4755/net26 n4481 VDD VDD pmos W=0.41u L=0.04u
M11199 n4479 n4475 U4755/net30 VDD pmos W=0.325u L=0.04u
M11200 U4755/net30 n4393 VDD VDD pmos W=0.205u L=0.04u
M11201 U4756/net19 n3921 VSS VSS nmos W=0.155u L=0.04u
M11202 n3310 n3921 U4756/net40 VSS nmos W=0.155u L=0.04u
M11203 n3310 U4756/net19 U4756/net36 VSS nmos W=0.155u L=0.04u
M11204 U4756/net40 g2688 VSS VSS nmos W=0.31u L=0.04u
M11205 U4756/net36 n4482 VSS VSS nmos W=0.155u L=0.04u
M11206 U4756/net19 n3921 VDD VDD pmos W=0.205u L=0.04u
M11207 n3310 U4756/net19 U4756/net26 VDD pmos W=0.325u L=0.04u
M11208 U4756/net26 g2688 VDD VDD pmos W=0.41u L=0.04u
M11209 n3310 n3921 U4756/net30 VDD pmos W=0.325u L=0.04u
M11210 U4756/net30 n4482 VDD VDD pmos W=0.205u L=0.04u
M11211 U4757/net19 n3920 VSS VSS nmos W=0.155u L=0.04u
M11212 n3309 n3920 U4757/net40 VSS nmos W=0.155u L=0.04u
M11213 n3309 U4757/net19 U4757/net36 VSS nmos W=0.155u L=0.04u
M11214 U4757/net40 g2691 VSS VSS nmos W=0.31u L=0.04u
M11215 U4757/net36 n4482 VSS VSS nmos W=0.155u L=0.04u
M11216 U4757/net19 n3920 VDD VDD pmos W=0.205u L=0.04u
M11217 n3309 U4757/net19 U4757/net26 VDD pmos W=0.325u L=0.04u
M11218 U4757/net26 g2691 VDD VDD pmos W=0.41u L=0.04u
M11219 n3309 n3920 U4757/net30 VDD pmos W=0.325u L=0.04u
M11220 U4757/net30 n4482 VDD VDD pmos W=0.205u L=0.04u
M11221 U4758/net19 n3918 VSS VSS nmos W=0.155u L=0.04u
M11222 n3308 n3918 U4758/net40 VSS nmos W=0.155u L=0.04u
M11223 n3308 U4758/net19 U4758/net36 VSS nmos W=0.155u L=0.04u
M11224 U4758/net40 g2694 VSS VSS nmos W=0.31u L=0.04u
M11225 U4758/net36 n4482 VSS VSS nmos W=0.155u L=0.04u
M11226 U4758/net19 n3918 VDD VDD pmos W=0.205u L=0.04u
M11227 n3308 U4758/net19 U4758/net26 VDD pmos W=0.325u L=0.04u
M11228 U4758/net26 g2694 VDD VDD pmos W=0.41u L=0.04u
M11229 n3308 n3918 U4758/net30 VDD pmos W=0.325u L=0.04u
M11230 U4758/net30 n4482 VDD VDD pmos W=0.205u L=0.04u
M11231 n4482 U4759/net28 VSS VSS nmos W=0.155u L=0.04u
M11232 U4759/net47 n3951 VSS VSS nmos W=0.155u L=0.04u
M11233 U4759/net28 U4759/net6 U4759/net47 VSS nmos W=0.155u L=0.04u
M11234 U4759/net44 n4483 VSS VSS nmos W=0.155u L=0.04u
M11235 U4759/net28 n4346 U4759/net44 VSS nmos W=0.155u L=0.04u
M11236 U4759/net6 n4346 VSS VSS nmos W=0.155u L=0.04u
M11237 n4482 U4759/net28 VDD VDD pmos W=0.205u L=0.04u
M11238 VDD n3951 U4759/net47 VDD pmos W=0.205u L=0.04u
M11239 U4759/net47 n4346 U4759/net28 VDD pmos W=0.205u L=0.04u
M11240 U4759/net44 U4759/net6 U4759/net28 VDD pmos W=0.205u L=0.04u
M11241 VDD n4483 U4759/net44 VDD pmos W=0.205u L=0.04u
M11242 VDD n4346 U4759/net6 VDD pmos W=0.205u L=0.04u
M11243 n4346 n3917 VSS VSS nmos W=0.135u L=0.04u
M11244 n4346 n3917 VDD VDD pmos W=0.205u L=0.04u
M11245 U4761/p2 g3018 VSS VSS nmos W=0.155u L=0.04u
M11246 U4761/p0 n4484 U4761/p1 VSS nmos W=0.155u L=0.04u
M11247 U4761/p1 n4485 U4761/p2 VSS nmos W=0.155u L=0.04u
M11248 n3917 g3028 U4761/p0 VSS nmos W=0.155u L=0.04u
M11249 n3917 n4485 VDD VDD pmos W=0.205u L=0.04u
M11250 n3917 n4484 VDD VDD pmos W=0.205u L=0.04u
M11251 n3917 g3028 VDD VDD pmos W=0.205u L=0.04u
M11252 n3917 g3018 VDD VDD pmos W=0.205u L=0.04u
M11253 n4485 g3036 VSS VSS nmos W=0.155u L=0.04u
M11254 n4485 g3032 VSS VSS nmos W=0.155u L=0.04u
M11255 U4762/XI1-net8 g3032 VDD VDD pmos W=0.205u L=0.04u
M11256 n4485 g3036 U4762/XI1-net8 VDD pmos W=0.205u L=0.04u
M11257 n4483 n4486 VSS VSS nmos W=0.155u L=0.04u
M11258 n4483 n4481 VSS VSS nmos W=0.155u L=0.04u
M11259 U4763/XI1-net8 n4481 VDD VDD pmos W=0.205u L=0.04u
M11260 n4483 n4486 U4763/XI1-net8 VDD pmos W=0.205u L=0.04u
M11261 U4764/XU1-net6 n4488 VSS VSS nmos W=0.155u L=0.04u
M11262 n4481 n4487 U4764/XU1-net6 VSS nmos W=0.155u L=0.04u
M11263 n4481 n4488 VDD VDD pmos W=0.155u L=0.04u
M11264 n4481 n4487 VDD VDD pmos W=0.155u L=0.04u
M11265 U4765/net19 n3939 VSS VSS nmos W=0.155u L=0.04u
M11266 n4488 n3939 U4765/net40 VSS nmos W=0.155u L=0.04u
M11267 n4488 U4765/net19 U4765/net36 VSS nmos W=0.155u L=0.04u
M11268 U4765/net40 n4490 VSS VSS nmos W=0.31u L=0.04u
M11269 U4765/net36 n4489 VSS VSS nmos W=0.155u L=0.04u
M11270 U4765/net19 n3939 VDD VDD pmos W=0.205u L=0.04u
M11271 n4488 U4765/net19 U4765/net26 VDD pmos W=0.325u L=0.04u
M11272 U4765/net26 n4490 VDD VDD pmos W=0.41u L=0.04u
M11273 n4488 n3939 U4765/net30 VDD pmos W=0.325u L=0.04u
M11274 U4765/net30 n4489 VDD VDD pmos W=0.205u L=0.04u
M11275 n4490 n4491 VSS VSS nmos W=0.155u L=0.04u
M11276 n4490 n4492 VSS VSS nmos W=0.155u L=0.04u
M11277 U4766/XI1-net8 n4492 VDD VDD pmos W=0.205u L=0.04u
M11278 n4490 n4491 U4766/XI1-net8 VDD pmos W=0.205u L=0.04u
M11279 n4489 n612 VSS VSS nmos W=0.155u L=0.04u
M11280 n4489 n4494 VSS VSS nmos W=0.155u L=0.04u
M11281 n4489 n4493 VSS VSS nmos W=0.155u L=0.04u
M11282 U4767/net25 n612 VDD VDD pmos W=0.41u L=0.04u
M11283 U4767/net28 n4494 U4767/net25 VDD pmos W=0.41u L=0.04u
M11284 n4489 n4493 U4767/net28 VDD pmos W=0.41u L=0.04u
M11285 U4768/net19 n4497 VSS VSS nmos W=0.155u L=0.04u
M11286 n4487 n4497 U4768/net40 VSS nmos W=0.155u L=0.04u
M11287 n4487 U4768/net19 U4768/net36 VSS nmos W=0.155u L=0.04u
M11288 U4768/net40 n4496 VSS VSS nmos W=0.31u L=0.04u
M11289 U4768/net36 n4495 VSS VSS nmos W=0.155u L=0.04u
M11290 U4768/net19 n4497 VDD VDD pmos W=0.205u L=0.04u
M11291 n4487 U4768/net19 U4768/net26 VDD pmos W=0.325u L=0.04u
M11292 U4768/net26 n4496 VDD VDD pmos W=0.41u L=0.04u
M11293 n4487 n4497 U4768/net30 VDD pmos W=0.325u L=0.04u
M11294 U4768/net30 n4495 VDD VDD pmos W=0.205u L=0.04u
M11295 n4496 n4493 U4769/net10 VSS nmos W=0.155u L=0.04u
M11296 U4769/net10 n4498 VSS VSS nmos W=0.155u L=0.04u
M11297 n4496 n3938 U4769/net10 VSS nmos W=0.155u L=0.04u
M11298 U4769/net10 n611 VSS VSS nmos W=0.155u L=0.04u
M11299 U4769/net30 n4498 VDD VDD pmos W=0.205u L=0.04u
M11300 n4496 n4493 U4769/net24 VDD pmos W=0.205u L=0.04u
M11301 U4769/net24 n3938 VDD VDD pmos W=0.205u L=0.04u
M11302 n4496 n611 U4769/net30 VDD pmos W=0.205u L=0.04u
M11303 n4498 n4500 U4770/XI21-net17 VSS nmos W=0.155u L=0.04u
M11304 U4770/XI21-net17 n3947 VSS VSS nmos W=0.155u L=0.04u
M11305 n4498 n4494 U4770/XI6-net17 VSS nmos W=0.155u L=0.04u
M11306 U4770/XI6-net17 n3942 VSS VSS nmos W=0.155u L=0.04u
M11307 n4498 n4499 U4770/XI20-net17 VSS nmos W=0.155u L=0.04u
M11308 U4770/XI20-net17 n3941 VSS VSS nmos W=0.155u L=0.04u
M11309 VDD n4500 U4770/net22 VDD pmos W=0.205u L=0.04u
M11310 VDD n3947 U4770/net22 VDD pmos W=0.205u L=0.04u
M11311 U4770/net16 n4494 n4498 VDD pmos W=0.205u L=0.04u
M11312 U4770/net16 n3942 n4498 VDD pmos W=0.205u L=0.04u
M11313 U4770/net22 n4499 U4770/net16 VDD pmos W=0.205u L=0.04u
M11314 U4770/net22 n3941 U4770/net16 VDD pmos W=0.205u L=0.04u
M11315 n611 n3939 VSS VSS nmos W=0.135u L=0.04u
M11316 n611 n3939 VDD VDD pmos W=0.205u L=0.04u
M11317 U4772/net8 n3935 U4772/net26 VSS nmos W=0.155u L=0.04u
M11318 U4772/net26 n4500 VSS VSS nmos W=0.155u L=0.04u
M11319 U4772/net29 U4772/net8 VSS VSS nmos W=0.155u L=0.04u
M11320 U4772/net29 n4501 n4495 VSS nmos W=0.155u L=0.04u
M11321 U4772/net29 n3939 n4495 VSS nmos W=0.155u L=0.04u
M11322 U4772/net8 n4500 VDD VDD pmos W=0.205u L=0.04u
M11323 U4772/net8 n3935 VDD VDD pmos W=0.205u L=0.04u
M11324 n4495 U4772/net8 VDD VDD pmos W=0.205u L=0.04u
M11325 n4495 n4501 U4772/net20 VDD pmos W=0.205u L=0.04u
M11326 U4772/net20 n3939 VDD VDD pmos W=0.205u L=0.04u
M11327 n4501 n4494 U4773/XI21-net17 VSS nmos W=0.155u L=0.04u
M11328 U4773/XI21-net17 n3947 VSS VSS nmos W=0.155u L=0.04u
M11329 n4501 n4502 U4773/XI6-net17 VSS nmos W=0.155u L=0.04u
M11330 U4773/XI6-net17 n3941 VSS VSS nmos W=0.155u L=0.04u
M11331 n4501 n4499 U4773/XI20-net17 VSS nmos W=0.155u L=0.04u
M11332 U4773/XI20-net17 n3952 VSS VSS nmos W=0.155u L=0.04u
M11333 VDD n4494 U4773/net22 VDD pmos W=0.205u L=0.04u
M11334 VDD n3947 U4773/net22 VDD pmos W=0.205u L=0.04u
M11335 U4773/net16 n4502 n4501 VDD pmos W=0.205u L=0.04u
M11336 U4773/net16 n3941 n4501 VDD pmos W=0.205u L=0.04u
M11337 U4773/net22 n4499 U4773/net16 VDD pmos W=0.205u L=0.04u
M11338 U4773/net22 n3952 U4773/net16 VDD pmos W=0.205u L=0.04u
M11339 n3947 n3946 VSS VSS nmos W=0.135u L=0.04u
M11340 n3947 n3946 VDD VDD pmos W=0.205u L=0.04u
M11341 U4775/XU1-net6 n612 VSS VSS nmos W=0.155u L=0.04u
M11342 n3946 n614 U4775/XU1-net6 VSS nmos W=0.155u L=0.04u
M11343 n3946 n612 VDD VDD pmos W=0.155u L=0.04u
M11344 n3946 n614 VDD VDD pmos W=0.155u L=0.04u
M11345 n4499 n4503 VSS VSS nmos W=0.135u L=0.04u
M11346 n4499 n4503 VDD VDD pmos W=0.205u L=0.04u
M11347 U4777/net19 n4393 VSS VSS nmos W=0.155u L=0.04u
M11348 n4486 n4393 U4777/net40 VSS nmos W=0.155u L=0.04u
M11349 n4486 U4777/net19 U4777/net36 VSS nmos W=0.155u L=0.04u
M11350 U4777/net40 n4480 VSS VSS nmos W=0.31u L=0.04u
M11351 U4777/net36 n4475 VSS VSS nmos W=0.155u L=0.04u
M11352 U4777/net19 n4393 VDD VDD pmos W=0.205u L=0.04u
M11353 n4486 U4777/net19 U4777/net26 VDD pmos W=0.325u L=0.04u
M11354 U4777/net26 n4480 VDD VDD pmos W=0.41u L=0.04u
M11355 n4486 n4393 U4777/net30 VDD pmos W=0.325u L=0.04u
M11356 U4777/net30 n4475 VDD VDD pmos W=0.205u L=0.04u
M11357 n4393 n4504 VSS VSS nmos W=0.155u L=0.04u
M11358 n4393 g2624 U4778/XI17-net17 VSS nmos W=0.155u L=0.04u
M11359 U4778/XI17-net17 g2676 VSS VSS nmos W=0.155u L=0.04u
M11360 n4393 g7390 U4778/XI10-net17 VSS nmos W=0.155u L=0.04u
M11361 U4778/XI10-net17 g2673 VSS VSS nmos W=0.155u L=0.04u
M11362 U4778/net30 g7390 n4393 VDD pmos W=0.205u L=0.04u
M11363 U4778/net30 g2673 n4393 VDD pmos W=0.205u L=0.04u
M11364 VDD n4504 U4778/net36 VDD pmos W=0.205u L=0.04u
M11365 U4778/net36 g2676 U4778/net30 VDD pmos W=0.205u L=0.04u
M11366 U4778/net36 g2624 U4778/net30 VDD pmos W=0.205u L=0.04u
M11367 n4504 U4779/net27 VDD VDD pmos W=0.205u L=0.04u
M11368 U4779/net27 g185 U4779/net23 VDD pmos W=0.205u L=0.04u
M11369 U4779/net27 g2616 U4779/net23 VDD pmos W=0.205u L=0.04u
M11370 U4779/net27 n3743 U4779/net23 VDD pmos W=0.205u L=0.04u
M11371 U4779/net23 g2670 VDD VDD pmos W=0.205u L=0.04u
M11372 U4779/net23 g7302 VDD VDD pmos W=0.205u L=0.04u
M11373 n4504 U4779/net27 VSS VSS nmos W=0.155u L=0.04u
M11374 U4779/XI20-net13 g2616 VSS VSS nmos W=0.155u L=0.04u
M11375 U4779/net27 g185 U4779/XI20-net17 VSS nmos W=0.155u L=0.04u
M11376 U4779/XI20-net17 n3743 U4779/XI20-net13 VSS nmos W=0.155u L=0.04u
M11377 U4779/net27 g2670 U4779/XI17-net17 VSS nmos W=0.155u L=0.04u
M11378 U4779/XI17-net17 g7302 VSS VSS nmos W=0.155u L=0.04u
M11379 n3743 U4780/net39 VDD VDD pmos W=0.205u L=0.04u
M11380 VDD g2641 U4780/net22 VDD pmos W=0.205u L=0.04u
M11381 VDD g7390 U4780/net22 VDD pmos W=0.205u L=0.04u
M11382 U4780/net16 g2639 U4780/net39 VDD pmos W=0.205u L=0.04u
M11383 U4780/net16 g7302 U4780/net39 VDD pmos W=0.205u L=0.04u
M11384 U4780/net22 g2564 U4780/net16 VDD pmos W=0.205u L=0.04u
M11385 U4780/net22 g2624 U4780/net16 VDD pmos W=0.205u L=0.04u
M11386 n3743 U4780/net39 VSS VSS nmos W=0.155u L=0.04u
M11387 U4780/net39 g2641 U4780/XI22-net17 VSS nmos W=0.155u L=0.04u
M11388 U4780/XI22-net17 g7390 VSS VSS nmos W=0.155u L=0.04u
M11389 U4780/net39 g2639 U4780/XI6-net17 VSS nmos W=0.155u L=0.04u
M11390 U4780/XI6-net17 g7302 VSS VSS nmos W=0.155u L=0.04u
M11391 U4780/net39 g2564 U4780/XI21-net17 VSS nmos W=0.155u L=0.04u
M11392 U4780/XI21-net17 g2624 VSS VSS nmos W=0.155u L=0.04u
M11393 U4781/XU35-net6 n4505 VSS VSS nmos W=0.155u L=0.04u
M11394 U4781/net5 n3941 U4781/XU35-net6 VSS nmos W=0.155u L=0.04u
M11395 U4781/XU36-net6 U4781/net5 VSS VSS nmos W=0.155u L=0.04u
M11396 n4480 n4506 U4781/XU36-net6 VSS nmos W=0.155u L=0.04u
M11397 U4781/net5 n4505 VDD VDD pmos W=0.205u L=0.04u
M11398 U4781/net5 n3941 VDD VDD pmos W=0.205u L=0.04u
M11399 n4480 U4781/net5 VDD VDD pmos W=0.205u L=0.04u
M11400 n4480 n4506 VDD VDD pmos W=0.205u L=0.04u
M11401 U4782/net19 n4497 VSS VSS nmos W=0.155u L=0.04u
M11402 n4506 n4497 U4782/net40 VSS nmos W=0.155u L=0.04u
M11403 n4506 U4782/net19 U4782/net36 VSS nmos W=0.155u L=0.04u
M11404 U4782/net40 n4508 VSS VSS nmos W=0.31u L=0.04u
M11405 U4782/net36 n4507 VSS VSS nmos W=0.155u L=0.04u
M11406 U4782/net19 n4497 VDD VDD pmos W=0.205u L=0.04u
M11407 n4506 U4782/net19 U4782/net26 VDD pmos W=0.325u L=0.04u
M11408 U4782/net26 n4508 VDD VDD pmos W=0.41u L=0.04u
M11409 n4506 n4497 U4782/net30 VDD pmos W=0.325u L=0.04u
M11410 U4782/net30 n4507 VDD VDD pmos W=0.205u L=0.04u
M11411 n4497 g2428 U4783/XI21-net17 VSS nmos W=0.155u L=0.04u
M11412 U4783/XI21-net17 g2412 VSS VSS nmos W=0.155u L=0.04u
M11413 n4497 g2424 U4783/XI6-net17 VSS nmos W=0.155u L=0.04u
M11414 U4783/XI6-net17 g5747 VSS VSS nmos W=0.155u L=0.04u
M11415 n4497 g2426 U4783/XI20-net17 VSS nmos W=0.155u L=0.04u
M11416 U4783/XI20-net17 g5796 VSS VSS nmos W=0.155u L=0.04u
M11417 VDD g2428 U4783/net22 VDD pmos W=0.205u L=0.04u
M11418 VDD g2412 U4783/net22 VDD pmos W=0.205u L=0.04u
M11419 U4783/net16 g2424 n4497 VDD pmos W=0.205u L=0.04u
M11420 U4783/net16 g5747 n4497 VDD pmos W=0.205u L=0.04u
M11421 U4783/net22 g2426 U4783/net16 VDD pmos W=0.205u L=0.04u
M11422 U4783/net22 g5796 U4783/net16 VDD pmos W=0.205u L=0.04u
M11423 n4508 n4509 U4784/net15 VSS nmos W=0.155u L=0.04u
M11424 n4508 n3942 U4784/net15 VSS nmos W=0.155u L=0.04u
M11425 U4784/net15 n4510 VSS VSS nmos W=0.155u L=0.04u
M11426 n4508 n4510 VDD VDD pmos W=0.205u L=0.04u
M11427 n4508 n4509 U4784/XI16-net11 VDD pmos W=0.205u L=0.04u
M11428 U4784/XI16-net11 n3942 VDD VDD pmos W=0.205u L=0.04u
M11429 n4510 n3935 U4785/net23 VDD pmos W=0.205u L=0.04u
M11430 n4510 n3939 U4785/net23 VDD pmos W=0.205u L=0.04u
M11431 n4510 n4492 U4785/net23 VDD pmos W=0.205u L=0.04u
M11432 U4785/net23 n4494 VDD VDD pmos W=0.205u L=0.04u
M11433 U4785/net23 n4511 VDD VDD pmos W=0.205u L=0.04u
M11434 U4785/XI20-net13 n3939 VSS VSS nmos W=0.155u L=0.04u
M11435 n4510 n3935 U4785/XI20-net17 VSS nmos W=0.155u L=0.04u
M11436 U4785/XI20-net17 n4492 U4785/XI20-net13 VSS nmos W=0.155u L=0.04u
M11437 n4510 n4494 U4785/XI17-net17 VSS nmos W=0.155u L=0.04u
M11438 U4785/XI17-net17 n4511 VSS VSS nmos W=0.155u L=0.04u
M11439 n4511 n4502 U4786/net15 VSS nmos W=0.155u L=0.04u
M11440 n4511 n4491 U4786/net15 VSS nmos W=0.155u L=0.04u
M11441 U4786/net15 n614 VSS VSS nmos W=0.155u L=0.04u
M11442 n4511 n614 VDD VDD pmos W=0.205u L=0.04u
M11443 n4511 n4502 U4786/XI16-net11 VDD pmos W=0.205u L=0.04u
M11444 U4786/XI16-net11 n4491 VDD VDD pmos W=0.205u L=0.04u
M11445 n4491 n3952 VSS VSS nmos W=0.135u L=0.04u
M11446 n4491 n3952 VDD VDD pmos W=0.205u L=0.04u
M11447 n3952 n3941 VSS VSS nmos W=0.155u L=0.04u
M11448 n3952 n3942 VSS VSS nmos W=0.155u L=0.04u
M11449 U4788/XI1-net8 n3942 VDD VDD pmos W=0.205u L=0.04u
M11450 n3952 n3941 U4788/XI1-net8 VDD pmos W=0.205u L=0.04u
M11451 n4507 n4513 U4789/net26 VSS nmos W=0.155u L=0.04u
M11452 n4507 n4512 U4789/net26 VSS nmos W=0.155u L=0.04u
M11453 U4789/net29 n4514 VSS VSS nmos W=0.155u L=0.04u
M11454 U4789/net26 n3938 U4789/net29 VSS nmos W=0.155u L=0.04u
M11455 U4789/net26 n4503 U4789/net29 VSS nmos W=0.155u L=0.04u
M11456 n4507 n4512 U4789/net43 VDD pmos W=0.205u L=0.04u
M11457 n4507 n4503 U4789/net49 VDD pmos W=0.205u L=0.04u
M11458 U4789/net49 n3938 VDD VDD pmos W=0.205u L=0.04u
M11459 U4789/net43 n4513 VDD VDD pmos W=0.205u L=0.04u
M11460 n4507 n4514 VDD VDD pmos W=0.205u L=0.04u
M11461 U4790/net17 n613 VSS VSS nmos W=0.155u L=0.04u
M11462 U4790/net17 n4509 VSS VSS nmos W=0.155u L=0.04u
M11463 U4790/net63 n614 VSS VSS nmos W=0.155u L=0.04u
M11464 n4514 U4790/net17 VSS VSS nmos W=0.155u L=0.04u
M11465 n4514 n4505 U4790/net63 VSS nmos W=0.155u L=0.04u
M11466 n4514 n614 U4790/net31 VDD pmos W=0.205u L=0.04u
M11467 U4790/net39 n613 VDD VDD pmos W=0.195u L=0.04u
M11468 U4790/net31 U4790/net17 VDD VDD pmos W=0.195u L=0.04u
M11469 n4514 n4505 U4790/net31 VDD pmos W=0.195u L=0.04u
M11470 U4790/net17 n4509 U4790/net39 VDD pmos W=0.195u L=0.04u
M11471 U4791/net19 n3939 VSS VSS nmos W=0.155u L=0.04u
M11472 n4509 n3939 U4791/net40 VSS nmos W=0.155u L=0.04u
M11473 n4509 U4791/net19 U4791/net36 VSS nmos W=0.155u L=0.04u
M11474 U4791/net40 n4502 VSS VSS nmos W=0.31u L=0.04u
M11475 U4791/net36 n4500 VSS VSS nmos W=0.155u L=0.04u
M11476 U4791/net19 n3939 VDD VDD pmos W=0.205u L=0.04u
M11477 n4509 U4791/net19 U4791/net26 VDD pmos W=0.325u L=0.04u
M11478 U4791/net26 n4502 VDD VDD pmos W=0.41u L=0.04u
M11479 n4509 n3939 U4791/net30 VDD pmos W=0.325u L=0.04u
M11480 U4791/net30 n4500 VDD VDD pmos W=0.205u L=0.04u
M11481 n4500 n4494 VSS VSS nmos W=0.155u L=0.04u
M11482 n4500 n4502 VSS VSS nmos W=0.155u L=0.04u
M11483 U4792/XI1-net8 n4502 VDD VDD pmos W=0.205u L=0.04u
M11484 n4500 n4494 U4792/XI1-net8 VDD pmos W=0.205u L=0.04u
M11485 n614 n3935 VSS VSS nmos W=0.135u L=0.04u
M11486 n614 n3935 VDD VDD pmos W=0.205u L=0.04u
M11487 n3935 n3921 U4794/net27 VSS nmos W=0.155u L=0.04u
M11488 U4794/net39 n3920 VSS VSS nmos W=0.155u L=0.04u
M11489 U4794/net27 g2658 U4794/net39 VSS nmos W=0.155u L=0.04u
M11490 U4794/net27 n3918 U4794/net39 VSS nmos W=0.155u L=0.04u
M11491 n3935 g2659 U4794/net27 VSS nmos W=0.155u L=0.04u
M11492 U4794/net39 g2660 VSS VSS nmos W=0.155u L=0.04u
M11493 n3935 n3920 U4794/net46 VDD pmos W=0.205u L=0.04u
M11494 U4794/net46 g2660 VDD VDD pmos W=0.205u L=0.04u
M11495 n3935 g2659 U4794/net34 VDD pmos W=0.205u L=0.04u
M11496 U4794/net34 n3921 VDD VDD pmos W=0.205u L=0.04u
M11497 n3935 n3918 U4794/net37 VDD pmos W=0.205u L=0.04u
M11498 U4794/net37 g2658 VDD VDD pmos W=0.205u L=0.04u
M11499 U4795/XU1-net6 n4493 VSS VSS nmos W=0.155u L=0.04u
M11500 n4503 n4492 U4795/XU1-net6 VSS nmos W=0.155u L=0.04u
M11501 n4503 n4493 VDD VDD pmos W=0.155u L=0.04u
M11502 n4503 n4492 VDD VDD pmos W=0.155u L=0.04u
M11503 n4493 n4502 VSS VSS nmos W=0.135u L=0.04u
M11504 n4493 n4502 VDD VDD pmos W=0.205u L=0.04u
M11505 U4797/net14 n4502 U4797/net20 VSS nmos W=0.155u L=0.04u
M11506 U4797/net14 n612 U4797/net20 VSS nmos W=0.155u L=0.04u
M11507 U4797/net20 n3938 VSS VSS nmos W=0.155u L=0.04u
M11508 n4512 U4797/net14 VSS VSS nmos W=0.155u L=0.04u
M11509 n4512 U4797/net14 VDD VDD pmos W=0.205u L=0.04u
M11510 U4797/net14 n3938 VDD VDD pmos W=0.205u L=0.04u
M11511 U4797/net24 n4502 VDD VDD pmos W=0.205u L=0.04u
M11512 U4797/net14 n612 U4797/net24 VDD pmos W=0.205u L=0.04u
M11513 U4798/XU1-net6 n3942 VSS VSS nmos W=0.155u L=0.04u
M11514 n3938 n613 U4798/XU1-net6 VSS nmos W=0.155u L=0.04u
M11515 n3938 n3942 VDD VDD pmos W=0.155u L=0.04u
M11516 n3938 n613 VDD VDD pmos W=0.155u L=0.04u
M11517 n613 n3941 VSS VSS nmos W=0.135u L=0.04u
M11518 n613 n3941 VDD VDD pmos W=0.205u L=0.04u
M11519 n612 n3942 VSS VSS nmos W=0.135u L=0.04u
M11520 n612 n3942 VDD VDD pmos W=0.205u L=0.04u
M11521 n3942 n3921 U4801/net27 VSS nmos W=0.155u L=0.04u
M11522 U4801/net39 n3920 VSS VSS nmos W=0.155u L=0.04u
M11523 U4801/net27 g2652 U4801/net39 VSS nmos W=0.155u L=0.04u
M11524 U4801/net27 n3918 U4801/net39 VSS nmos W=0.155u L=0.04u
M11525 n3942 g2653 U4801/net27 VSS nmos W=0.155u L=0.04u
M11526 U4801/net39 g2654 VSS VSS nmos W=0.155u L=0.04u
M11527 n3942 n3920 U4801/net46 VDD pmos W=0.205u L=0.04u
M11528 U4801/net46 g2654 VDD VDD pmos W=0.205u L=0.04u
M11529 n3942 g2653 U4801/net34 VDD pmos W=0.205u L=0.04u
M11530 U4801/net34 n3921 VDD VDD pmos W=0.205u L=0.04u
M11531 n3942 n3918 U4801/net37 VDD pmos W=0.205u L=0.04u
M11532 U4801/net37 g2652 VDD VDD pmos W=0.205u L=0.04u
M11533 U4802/net19 n3939 VSS VSS nmos W=0.155u L=0.04u
M11534 n4505 n3939 U4802/net40 VSS nmos W=0.155u L=0.04u
M11535 n4505 U4802/net19 U4802/net36 VSS nmos W=0.155u L=0.04u
M11536 U4802/net40 n4515 VSS VSS nmos W=0.31u L=0.04u
M11537 U4802/net36 n4492 VSS VSS nmos W=0.155u L=0.04u
M11538 U4802/net19 n3939 VDD VDD pmos W=0.205u L=0.04u
M11539 n4505 U4802/net19 U4802/net26 VDD pmos W=0.325u L=0.04u
M11540 U4802/net26 n4515 VDD VDD pmos W=0.41u L=0.04u
M11541 n4505 n3939 U4802/net30 VDD pmos W=0.325u L=0.04u
M11542 U4802/net30 n4492 VDD VDD pmos W=0.205u L=0.04u
M11543 n3939 n3921 U4803/net27 VSS nmos W=0.155u L=0.04u
M11544 U4803/net39 n3920 VSS VSS nmos W=0.155u L=0.04u
M11545 U4803/net27 g2649 U4803/net39 VSS nmos W=0.155u L=0.04u
M11546 U4803/net27 n3918 U4803/net39 VSS nmos W=0.155u L=0.04u
M11547 n3939 g2650 U4803/net27 VSS nmos W=0.155u L=0.04u
M11548 U4803/net39 g2651 VSS VSS nmos W=0.155u L=0.04u
M11549 n3939 n3920 U4803/net46 VDD pmos W=0.205u L=0.04u
M11550 U4803/net46 g2651 VDD VDD pmos W=0.205u L=0.04u
M11551 n3939 g2650 U4803/net34 VDD pmos W=0.205u L=0.04u
M11552 U4803/net34 n3921 VDD VDD pmos W=0.205u L=0.04u
M11553 n3939 n3918 U4803/net37 VDD pmos W=0.205u L=0.04u
M11554 U4803/net37 g2649 VDD VDD pmos W=0.205u L=0.04u
M11555 U4804/XU1-net6 n4513 VSS VSS nmos W=0.155u L=0.04u
M11556 n4515 n4502 U4804/XU1-net6 VSS nmos W=0.155u L=0.04u
M11557 n4515 n4513 VDD VDD pmos W=0.155u L=0.04u
M11558 n4515 n4502 VDD VDD pmos W=0.155u L=0.04u
M11559 n4513 n4494 VSS VSS nmos W=0.135u L=0.04u
M11560 n4513 n4494 VDD VDD pmos W=0.205u L=0.04u
M11561 n4494 g2458 U4806/XI21-net17 VSS nmos W=0.155u L=0.04u
M11562 U4806/XI21-net17 g2412 VSS VSS nmos W=0.155u L=0.04u
M11563 n4494 g2454 U4806/XI6-net17 VSS nmos W=0.155u L=0.04u
M11564 U4806/XI6-net17 g5747 VSS VSS nmos W=0.155u L=0.04u
M11565 n4494 g2456 U4806/XI20-net17 VSS nmos W=0.155u L=0.04u
M11566 U4806/XI20-net17 g5796 VSS VSS nmos W=0.155u L=0.04u
M11567 VDD g2458 U4806/net22 VDD pmos W=0.205u L=0.04u
M11568 VDD g2412 U4806/net22 VDD pmos W=0.205u L=0.04u
M11569 U4806/net16 g2454 n4494 VDD pmos W=0.205u L=0.04u
M11570 U4806/net16 g5747 n4494 VDD pmos W=0.205u L=0.04u
M11571 U4806/net22 g2456 U4806/net16 VDD pmos W=0.205u L=0.04u
M11572 U4806/net22 g5796 U4806/net16 VDD pmos W=0.205u L=0.04u
M11573 n4502 g2443 U4807/XI21-net17 VSS nmos W=0.155u L=0.04u
M11574 U4807/XI21-net17 g2412 VSS VSS nmos W=0.155u L=0.04u
M11575 n4502 g5747 U4807/XI6-net17 VSS nmos W=0.155u L=0.04u
M11576 U4807/XI6-net17 g2439 VSS VSS nmos W=0.155u L=0.04u
M11577 n4502 g5796 U4807/XI20-net17 VSS nmos W=0.155u L=0.04u
M11578 U4807/XI20-net17 g2441 VSS VSS nmos W=0.155u L=0.04u
M11579 VDD g2443 U4807/net22 VDD pmos W=0.205u L=0.04u
M11580 VDD g2412 U4807/net22 VDD pmos W=0.205u L=0.04u
M11581 U4807/net16 g5747 n4502 VDD pmos W=0.205u L=0.04u
M11582 U4807/net16 g2439 n4502 VDD pmos W=0.205u L=0.04u
M11583 U4807/net22 g5796 U4807/net16 VDD pmos W=0.205u L=0.04u
M11584 U4807/net22 g2441 U4807/net16 VDD pmos W=0.205u L=0.04u
M11585 n4492 U4808/net39 VDD VDD pmos W=0.205u L=0.04u
M11586 VDD g2399 U4808/net22 VDD pmos W=0.205u L=0.04u
M11587 VDD g2412 U4808/net22 VDD pmos W=0.205u L=0.04u
M11588 U4808/net16 g2469 U4808/net39 VDD pmos W=0.205u L=0.04u
M11589 U4808/net16 g5747 U4808/net39 VDD pmos W=0.205u L=0.04u
M11590 U4808/net22 g2471 U4808/net16 VDD pmos W=0.205u L=0.04u
M11591 U4808/net22 g5796 U4808/net16 VDD pmos W=0.205u L=0.04u
M11592 n4492 U4808/net39 VSS VSS nmos W=0.155u L=0.04u
M11593 U4808/net39 g2399 U4808/XI22-net17 VSS nmos W=0.155u L=0.04u
M11594 U4808/XI22-net17 g2412 VSS VSS nmos W=0.155u L=0.04u
M11595 U4808/net39 g2469 U4808/XI6-net17 VSS nmos W=0.155u L=0.04u
M11596 U4808/XI6-net17 g5747 VSS VSS nmos W=0.155u L=0.04u
M11597 U4808/net39 g2471 U4808/XI21-net17 VSS nmos W=0.155u L=0.04u
M11598 U4808/XI21-net17 g5796 VSS VSS nmos W=0.155u L=0.04u
M11599 n3941 n3921 U4809/net27 VSS nmos W=0.155u L=0.04u
M11600 U4809/net39 n3920 VSS VSS nmos W=0.155u L=0.04u
M11601 U4809/net27 g2655 U4809/net39 VSS nmos W=0.155u L=0.04u
M11602 U4809/net27 n3918 U4809/net39 VSS nmos W=0.155u L=0.04u
M11603 n3941 g2656 U4809/net27 VSS nmos W=0.155u L=0.04u
M11604 U4809/net39 g2657 VSS VSS nmos W=0.155u L=0.04u
M11605 n3941 n3920 U4809/net46 VDD pmos W=0.205u L=0.04u
M11606 U4809/net46 g2657 VDD VDD pmos W=0.205u L=0.04u
M11607 n3941 g2656 U4809/net34 VDD pmos W=0.205u L=0.04u
M11608 U4809/net34 n3921 VDD VDD pmos W=0.205u L=0.04u
M11609 n3941 n3918 U4809/net37 VDD pmos W=0.205u L=0.04u
M11610 U4809/net37 g2655 VDD VDD pmos W=0.205u L=0.04u
M11611 n3920 g7390 VSS VSS nmos W=0.135u L=0.04u
M11612 n3920 g7390 VDD VDD pmos W=0.205u L=0.04u
M11613 n3918 g2624 VSS VSS nmos W=0.135u L=0.04u
M11614 n3918 g2624 VDD VDD pmos W=0.205u L=0.04u
M11615 n3921 g7302 VSS VSS nmos W=0.135u L=0.04u
M11616 n3921 g7302 VDD VDD pmos W=0.205u L=0.04u
M11617 n4475 n4516 VSS VSS nmos W=0.155u L=0.04u
M11618 n4475 g7302 U4813/XI17-net17 VSS nmos W=0.155u L=0.04u
M11619 U4813/XI17-net17 g2661 VSS VSS nmos W=0.155u L=0.04u
M11620 n4475 g7390 U4813/XI10-net17 VSS nmos W=0.155u L=0.04u
M11621 U4813/XI10-net17 g2664 VSS VSS nmos W=0.155u L=0.04u
M11622 U4813/net30 g7390 n4475 VDD pmos W=0.205u L=0.04u
M11623 U4813/net30 g2664 n4475 VDD pmos W=0.205u L=0.04u
M11624 VDD n4516 U4813/net36 VDD pmos W=0.205u L=0.04u
M11625 U4813/net36 g2661 U4813/net30 VDD pmos W=0.205u L=0.04u
M11626 U4813/net36 g7302 U4813/net30 VDD pmos W=0.205u L=0.04u
M11627 n4516 U4814/net27 VDD VDD pmos W=0.205u L=0.04u
M11628 U4814/net27 g185 U4814/net23 VDD pmos W=0.205u L=0.04u
M11629 U4814/net27 g2598 U4814/net23 VDD pmos W=0.205u L=0.04u
M11630 U4814/net27 n3742 U4814/net23 VDD pmos W=0.205u L=0.04u
M11631 U4814/net23 g2667 VDD VDD pmos W=0.205u L=0.04u
M11632 U4814/net23 g2624 VDD VDD pmos W=0.205u L=0.04u
M11633 n4516 U4814/net27 VSS VSS nmos W=0.155u L=0.04u
M11634 U4814/XI20-net13 g2598 VSS VSS nmos W=0.155u L=0.04u
M11635 U4814/net27 g185 U4814/XI20-net17 VSS nmos W=0.155u L=0.04u
M11636 U4814/XI20-net17 n3742 U4814/XI20-net13 VSS nmos W=0.155u L=0.04u
M11637 U4814/net27 g2667 U4814/XI17-net17 VSS nmos W=0.155u L=0.04u
M11638 U4814/XI17-net17 g2624 VSS VSS nmos W=0.155u L=0.04u
M11639 n3742 U4815/net39 VDD VDD pmos W=0.205u L=0.04u
M11640 VDD g2645 U4815/net22 VDD pmos W=0.205u L=0.04u
M11641 VDD g7390 U4815/net22 VDD pmos W=0.205u L=0.04u
M11642 U4815/net16 g2643 U4815/net39 VDD pmos W=0.205u L=0.04u
M11643 U4815/net16 g7302 U4815/net39 VDD pmos W=0.205u L=0.04u
M11644 U4815/net22 g2647 U4815/net16 VDD pmos W=0.205u L=0.04u
M11645 U4815/net22 g2624 U4815/net16 VDD pmos W=0.205u L=0.04u
M11646 n3742 U4815/net39 VSS VSS nmos W=0.155u L=0.04u
M11647 U4815/net39 g2645 U4815/XI22-net17 VSS nmos W=0.155u L=0.04u
M11648 U4815/XI22-net17 g7390 VSS VSS nmos W=0.155u L=0.04u
M11649 U4815/net39 g2643 U4815/XI6-net17 VSS nmos W=0.155u L=0.04u
M11650 U4815/XI6-net17 g7302 VSS VSS nmos W=0.155u L=0.04u
M11651 U4815/net39 g2647 U4815/XI21-net17 VSS nmos W=0.155u L=0.04u
M11652 U4815/XI21-net17 g2624 VSS VSS nmos W=0.155u L=0.04u
M11653 n3305 g26135 VSS VSS nmos W=0.135u L=0.04u
M11654 n3305 g26135 VDD VDD pmos W=0.205u L=0.04u
M11655 U4817/net19 g3109 VSS VSS nmos W=0.155u L=0.04u
M11656 n3304 g3109 U4817/net40 VSS nmos W=0.155u L=0.04u
M11657 n3304 U4817/net19 U4817/net36 VSS nmos W=0.155u L=0.04u
M11658 U4817/net40 g559 VSS VSS nmos W=0.31u L=0.04u
M11659 U4817/net36 g3084 VSS VSS nmos W=0.155u L=0.04u
M11660 U4817/net19 g3109 VDD VDD pmos W=0.205u L=0.04u
M11661 n3304 U4817/net19 U4817/net26 VDD pmos W=0.325u L=0.04u
M11662 U4817/net26 g559 VDD VDD pmos W=0.41u L=0.04u
M11663 n3304 g3109 U4817/net30 VDD pmos W=0.325u L=0.04u
M11664 U4817/net30 g3084 VDD VDD pmos W=0.205u L=0.04u
M11665 U4818/net19 g3109 VSS VSS nmos W=0.155u L=0.04u
M11666 n3303 g3109 U4818/net40 VSS nmos W=0.155u L=0.04u
M11667 n3303 U4818/net19 U4818/net36 VSS nmos W=0.155u L=0.04u
M11668 U4818/net40 g1245 VSS VSS nmos W=0.31u L=0.04u
M11669 U4818/net36 g3087 VSS VSS nmos W=0.155u L=0.04u
M11670 U4818/net19 g3109 VDD VDD pmos W=0.205u L=0.04u
M11671 n3303 U4818/net19 U4818/net26 VDD pmos W=0.325u L=0.04u
M11672 U4818/net26 g1245 VDD VDD pmos W=0.41u L=0.04u
M11673 n3303 g3109 U4818/net30 VDD pmos W=0.325u L=0.04u
M11674 U4818/net30 g3087 VDD VDD pmos W=0.205u L=0.04u
M11675 U4819/net19 g3109 VSS VSS nmos W=0.155u L=0.04u
M11676 n3302 g3109 U4819/net40 VSS nmos W=0.155u L=0.04u
M11677 n3302 U4819/net19 U4819/net36 VSS nmos W=0.155u L=0.04u
M11678 U4819/net40 g1939 VSS VSS nmos W=0.31u L=0.04u
M11679 U4819/net36 g3093 VSS VSS nmos W=0.155u L=0.04u
M11680 U4819/net19 g3109 VDD VDD pmos W=0.205u L=0.04u
M11681 n3302 U4819/net19 U4819/net26 VDD pmos W=0.325u L=0.04u
M11682 U4819/net26 g1939 VDD VDD pmos W=0.41u L=0.04u
M11683 n3302 g3109 U4819/net30 VDD pmos W=0.325u L=0.04u
M11684 U4819/net30 g3093 VDD VDD pmos W=0.205u L=0.04u
M11685 U4820/net19 g3109 VSS VSS nmos W=0.155u L=0.04u
M11686 n3301 g3109 U4820/net40 VSS nmos W=0.155u L=0.04u
M11687 n3301 U4820/net19 U4820/net36 VSS nmos W=0.155u L=0.04u
M11688 U4820/net40 g2633 VSS VSS nmos W=0.31u L=0.04u
M11689 U4820/net36 g3096 VSS VSS nmos W=0.155u L=0.04u
M11690 U4820/net19 g3109 VDD VDD pmos W=0.205u L=0.04u
M11691 n3301 U4820/net19 U4820/net26 VDD pmos W=0.325u L=0.04u
M11692 U4820/net26 g2633 VDD VDD pmos W=0.41u L=0.04u
M11693 n3301 g3109 U4820/net30 VDD pmos W=0.325u L=0.04u
M11694 U4820/net30 g3096 VDD VDD pmos W=0.205u L=0.04u
M11695 U4821/net19 g3109 VSS VSS nmos W=0.155u L=0.04u
M11696 n3300 g3109 U4821/net40 VSS nmos W=0.155u L=0.04u
M11697 n3300 U4821/net19 U4821/net36 VSS nmos W=0.155u L=0.04u
M11698 U4821/net40 n4517 VSS VSS nmos W=0.31u L=0.04u
M11699 U4821/net36 g3099 VSS VSS nmos W=0.155u L=0.04u
M11700 U4821/net19 g3109 VDD VDD pmos W=0.205u L=0.04u
M11701 n3300 U4821/net19 U4821/net26 VDD pmos W=0.325u L=0.04u
M11702 U4821/net26 n4517 VDD VDD pmos W=0.41u L=0.04u
M11703 n3300 g3109 U4821/net30 VDD pmos W=0.325u L=0.04u
M11704 U4821/net30 g3099 VDD VDD pmos W=0.205u L=0.04u
M11705 U4822/net19 g3109 VSS VSS nmos W=0.155u L=0.04u
M11706 n3299 g3109 U4822/net40 VSS nmos W=0.155u L=0.04u
M11707 n3299 U4822/net19 U4822/net36 VSS nmos W=0.155u L=0.04u
M11708 U4822/net40 g499 VSS VSS nmos W=0.31u L=0.04u
M11709 U4822/net36 g3161 VSS VSS nmos W=0.155u L=0.04u
M11710 U4822/net19 g3109 VDD VDD pmos W=0.205u L=0.04u
M11711 n3299 U4822/net19 U4822/net26 VDD pmos W=0.325u L=0.04u
M11712 U4822/net26 g499 VDD VDD pmos W=0.41u L=0.04u
M11713 n3299 g3109 U4822/net30 VDD pmos W=0.325u L=0.04u
M11714 U4822/net30 g3161 VDD VDD pmos W=0.205u L=0.04u
M11715 U4823/net19 g3109 VSS VSS nmos W=0.155u L=0.04u
M11716 n3298 g3109 U4823/net40 VSS nmos W=0.155u L=0.04u
M11717 n3298 U4823/net19 U4823/net36 VSS nmos W=0.155u L=0.04u
M11718 U4823/net40 n4518 VSS VSS nmos W=0.31u L=0.04u
M11719 U4823/net36 g3102 VSS VSS nmos W=0.155u L=0.04u
M11720 U4823/net19 g3109 VDD VDD pmos W=0.205u L=0.04u
M11721 n3298 U4823/net19 U4823/net26 VDD pmos W=0.325u L=0.04u
M11722 U4823/net26 n4518 VDD VDD pmos W=0.41u L=0.04u
M11723 n3298 g3109 U4823/net30 VDD pmos W=0.325u L=0.04u
M11724 U4823/net30 g3102 VDD VDD pmos W=0.205u L=0.04u
M11725 U4824/net19 g3109 VSS VSS nmos W=0.155u L=0.04u
M11726 n3297 g3109 U4824/net40 VSS nmos W=0.155u L=0.04u
M11727 n3297 U4824/net19 U4824/net36 VSS nmos W=0.155u L=0.04u
M11728 U4824/net40 g1186 VSS VSS nmos W=0.31u L=0.04u
M11729 U4824/net36 g3170 VSS VSS nmos W=0.155u L=0.04u
M11730 U4824/net19 g3109 VDD VDD pmos W=0.205u L=0.04u
M11731 n3297 U4824/net19 U4824/net26 VDD pmos W=0.325u L=0.04u
M11732 U4824/net26 g1186 VDD VDD pmos W=0.41u L=0.04u
M11733 n3297 g3109 U4824/net30 VDD pmos W=0.325u L=0.04u
M11734 U4824/net30 g3170 VDD VDD pmos W=0.205u L=0.04u
M11735 U4825/net19 g3109 VSS VSS nmos W=0.155u L=0.04u
M11736 n3296 g3109 U4825/net40 VSS nmos W=0.155u L=0.04u
M11737 n3296 U4825/net19 U4825/net36 VSS nmos W=0.155u L=0.04u
M11738 U4825/net40 n4519 VSS VSS nmos W=0.31u L=0.04u
M11739 U4825/net36 g3105 VSS VSS nmos W=0.155u L=0.04u
M11740 U4825/net19 g3109 VDD VDD pmos W=0.205u L=0.04u
M11741 n3296 U4825/net19 U4825/net26 VDD pmos W=0.325u L=0.04u
M11742 U4825/net26 n4519 VDD VDD pmos W=0.41u L=0.04u
M11743 n3296 g3109 U4825/net30 VDD pmos W=0.325u L=0.04u
M11744 U4825/net30 g3105 VDD VDD pmos W=0.205u L=0.04u
M11745 U4826/net19 g3109 VSS VSS nmos W=0.155u L=0.04u
M11746 n3295 g3109 U4826/net40 VSS nmos W=0.155u L=0.04u
M11747 n3295 U4826/net19 U4826/net36 VSS nmos W=0.155u L=0.04u
M11748 U4826/net40 g1880 VSS VSS nmos W=0.31u L=0.04u
M11749 U4826/net36 g3179 VSS VSS nmos W=0.155u L=0.04u
M11750 U4826/net19 g3109 VDD VDD pmos W=0.205u L=0.04u
M11751 n3295 U4826/net19 U4826/net26 VDD pmos W=0.325u L=0.04u
M11752 U4826/net26 g1880 VDD VDD pmos W=0.41u L=0.04u
M11753 n3295 g3109 U4826/net30 VDD pmos W=0.325u L=0.04u
M11754 U4826/net30 g3179 VDD VDD pmos W=0.205u L=0.04u
M11755 U4827/net19 g3109 VSS VSS nmos W=0.155u L=0.04u
M11756 n3294 g3109 U4827/net40 VSS nmos W=0.155u L=0.04u
M11757 n3294 U4827/net19 U4827/net36 VSS nmos W=0.155u L=0.04u
M11758 U4827/net40 n4520 VSS VSS nmos W=0.31u L=0.04u
M11759 U4827/net36 g3108 VSS VSS nmos W=0.155u L=0.04u
M11760 U4827/net19 g3109 VDD VDD pmos W=0.205u L=0.04u
M11761 n3294 U4827/net19 U4827/net26 VDD pmos W=0.325u L=0.04u
M11762 U4827/net26 n4520 VDD VDD pmos W=0.41u L=0.04u
M11763 n3294 g3109 U4827/net30 VDD pmos W=0.325u L=0.04u
M11764 U4827/net30 g3108 VDD VDD pmos W=0.205u L=0.04u
M11765 U4828/net19 g3109 VSS VSS nmos W=0.155u L=0.04u
M11766 n3293 g3109 U4828/net40 VSS nmos W=0.155u L=0.04u
M11767 n3293 U4828/net19 U4828/net36 VSS nmos W=0.155u L=0.04u
M11768 U4828/net40 g2574 VSS VSS nmos W=0.31u L=0.04u
M11769 U4828/net36 g3088 VSS VSS nmos W=0.155u L=0.04u
M11770 U4828/net19 g3109 VDD VDD pmos W=0.205u L=0.04u
M11771 n3293 U4828/net19 U4828/net26 VDD pmos W=0.325u L=0.04u
M11772 U4828/net26 g2574 VDD VDD pmos W=0.41u L=0.04u
M11773 n3293 g3109 U4828/net30 VDD pmos W=0.325u L=0.04u
M11774 U4828/net30 g3088 VDD VDD pmos W=0.205u L=0.04u
M11775 U4829/net19 g8030 VSS VSS nmos W=0.155u L=0.04u
M11776 n3292 g8030 U4829/net40 VSS nmos W=0.155u L=0.04u
M11777 n3292 U4829/net19 U4829/net36 VSS nmos W=0.155u L=0.04u
M11778 U4829/net40 g1245 VSS VSS nmos W=0.31u L=0.04u
M11779 U4829/net36 g3086 VSS VSS nmos W=0.155u L=0.04u
M11780 U4829/net19 g8030 VDD VDD pmos W=0.205u L=0.04u
M11781 n3292 U4829/net19 U4829/net26 VDD pmos W=0.325u L=0.04u
M11782 U4829/net26 g1245 VDD VDD pmos W=0.41u L=0.04u
M11783 n3292 g8030 U4829/net30 VDD pmos W=0.325u L=0.04u
M11784 U4829/net30 g3086 VDD VDD pmos W=0.205u L=0.04u
M11785 U4830/net19 g8030 VSS VSS nmos W=0.155u L=0.04u
M11786 n3291 g8030 U4830/net40 VSS nmos W=0.155u L=0.04u
M11787 n3291 U4830/net19 U4830/net36 VSS nmos W=0.155u L=0.04u
M11788 U4830/net40 g1939 VSS VSS nmos W=0.31u L=0.04u
M11789 U4830/net36 g3092 VSS VSS nmos W=0.155u L=0.04u
M11790 U4830/net19 g8030 VDD VDD pmos W=0.205u L=0.04u
M11791 n3291 U4830/net19 U4830/net26 VDD pmos W=0.325u L=0.04u
M11792 U4830/net26 g1939 VDD VDD pmos W=0.41u L=0.04u
M11793 n3291 g8030 U4830/net30 VDD pmos W=0.325u L=0.04u
M11794 U4830/net30 g3092 VDD VDD pmos W=0.205u L=0.04u
M11795 U4831/net19 g8030 VSS VSS nmos W=0.155u L=0.04u
M11796 n3290 g8030 U4831/net40 VSS nmos W=0.155u L=0.04u
M11797 n3290 U4831/net19 U4831/net36 VSS nmos W=0.155u L=0.04u
M11798 U4831/net40 g2633 VSS VSS nmos W=0.31u L=0.04u
M11799 U4831/net36 g3095 VSS VSS nmos W=0.155u L=0.04u
M11800 U4831/net19 g8030 VDD VDD pmos W=0.205u L=0.04u
M11801 n3290 U4831/net19 U4831/net26 VDD pmos W=0.325u L=0.04u
M11802 U4831/net26 g2633 VDD VDD pmos W=0.41u L=0.04u
M11803 n3290 g8030 U4831/net30 VDD pmos W=0.325u L=0.04u
M11804 U4831/net30 g3095 VDD VDD pmos W=0.205u L=0.04u
M11805 U4832/net19 g8030 VSS VSS nmos W=0.155u L=0.04u
M11806 n3289 g8030 U4832/net40 VSS nmos W=0.155u L=0.04u
M11807 n3289 U4832/net19 U4832/net36 VSS nmos W=0.155u L=0.04u
M11808 U4832/net40 n4517 VSS VSS nmos W=0.31u L=0.04u
M11809 U4832/net36 g3098 VSS VSS nmos W=0.155u L=0.04u
M11810 U4832/net19 g8030 VDD VDD pmos W=0.205u L=0.04u
M11811 n3289 U4832/net19 U4832/net26 VDD pmos W=0.325u L=0.04u
M11812 U4832/net26 n4517 VDD VDD pmos W=0.41u L=0.04u
M11813 n3289 g8030 U4832/net30 VDD pmos W=0.325u L=0.04u
M11814 U4832/net30 g3098 VDD VDD pmos W=0.205u L=0.04u
M11815 U4833/net19 g8030 VSS VSS nmos W=0.155u L=0.04u
M11816 n3288 g8030 U4833/net40 VSS nmos W=0.155u L=0.04u
M11817 n3288 U4833/net19 U4833/net36 VSS nmos W=0.155u L=0.04u
M11818 U4833/net40 g499 VSS VSS nmos W=0.31u L=0.04u
M11819 U4833/net36 g3158 VSS VSS nmos W=0.155u L=0.04u
M11820 U4833/net19 g8030 VDD VDD pmos W=0.205u L=0.04u
M11821 n3288 U4833/net19 U4833/net26 VDD pmos W=0.325u L=0.04u
M11822 U4833/net26 g499 VDD VDD pmos W=0.41u L=0.04u
M11823 n3288 g8030 U4833/net30 VDD pmos W=0.325u L=0.04u
M11824 U4833/net30 g3158 VDD VDD pmos W=0.205u L=0.04u
M11825 U4834/net19 g8030 VSS VSS nmos W=0.155u L=0.04u
M11826 n3287 g8030 U4834/net40 VSS nmos W=0.155u L=0.04u
M11827 n3287 U4834/net19 U4834/net36 VSS nmos W=0.155u L=0.04u
M11828 U4834/net40 n4518 VSS VSS nmos W=0.31u L=0.04u
M11829 U4834/net36 g3101 VSS VSS nmos W=0.155u L=0.04u
M11830 U4834/net19 g8030 VDD VDD pmos W=0.205u L=0.04u
M11831 n3287 U4834/net19 U4834/net26 VDD pmos W=0.325u L=0.04u
M11832 U4834/net26 n4518 VDD VDD pmos W=0.41u L=0.04u
M11833 n3287 g8030 U4834/net30 VDD pmos W=0.325u L=0.04u
M11834 U4834/net30 g3101 VDD VDD pmos W=0.205u L=0.04u
M11835 U4835/net19 g8030 VSS VSS nmos W=0.155u L=0.04u
M11836 n3286 g8030 U4835/net40 VSS nmos W=0.155u L=0.04u
M11837 n3286 U4835/net19 U4835/net36 VSS nmos W=0.155u L=0.04u
M11838 U4835/net40 g1186 VSS VSS nmos W=0.31u L=0.04u
M11839 U4835/net36 g3167 VSS VSS nmos W=0.155u L=0.04u
M11840 U4835/net19 g8030 VDD VDD pmos W=0.205u L=0.04u
M11841 n3286 U4835/net19 U4835/net26 VDD pmos W=0.325u L=0.04u
M11842 U4835/net26 g1186 VDD VDD pmos W=0.41u L=0.04u
M11843 n3286 g8030 U4835/net30 VDD pmos W=0.325u L=0.04u
M11844 U4835/net30 g3167 VDD VDD pmos W=0.205u L=0.04u
M11845 U4836/net19 g8030 VSS VSS nmos W=0.155u L=0.04u
M11846 n3285 g8030 U4836/net40 VSS nmos W=0.155u L=0.04u
M11847 n3285 U4836/net19 U4836/net36 VSS nmos W=0.155u L=0.04u
M11848 U4836/net40 n4519 VSS VSS nmos W=0.31u L=0.04u
M11849 U4836/net36 g3104 VSS VSS nmos W=0.155u L=0.04u
M11850 U4836/net19 g8030 VDD VDD pmos W=0.205u L=0.04u
M11851 n3285 U4836/net19 U4836/net26 VDD pmos W=0.325u L=0.04u
M11852 U4836/net26 n4519 VDD VDD pmos W=0.41u L=0.04u
M11853 n3285 g8030 U4836/net30 VDD pmos W=0.325u L=0.04u
M11854 U4836/net30 g3104 VDD VDD pmos W=0.205u L=0.04u
M11855 U4837/net19 g8030 VSS VSS nmos W=0.155u L=0.04u
M11856 n3284 g8030 U4837/net40 VSS nmos W=0.155u L=0.04u
M11857 n3284 U4837/net19 U4837/net36 VSS nmos W=0.155u L=0.04u
M11858 U4837/net40 g1880 VSS VSS nmos W=0.31u L=0.04u
M11859 U4837/net36 g3176 VSS VSS nmos W=0.155u L=0.04u
M11860 U4837/net19 g8030 VDD VDD pmos W=0.205u L=0.04u
M11861 n3284 U4837/net19 U4837/net26 VDD pmos W=0.325u L=0.04u
M11862 U4837/net26 g1880 VDD VDD pmos W=0.41u L=0.04u
M11863 n3284 g8030 U4837/net30 VDD pmos W=0.325u L=0.04u
M11864 U4837/net30 g3176 VDD VDD pmos W=0.205u L=0.04u
M11865 U4838/net19 g8030 VSS VSS nmos W=0.155u L=0.04u
M11866 n3283 g8030 U4838/net40 VSS nmos W=0.155u L=0.04u
M11867 n3283 U4838/net19 U4838/net36 VSS nmos W=0.155u L=0.04u
M11868 U4838/net40 n4520 VSS VSS nmos W=0.31u L=0.04u
M11869 U4838/net36 g3107 VSS VSS nmos W=0.155u L=0.04u
M11870 U4838/net19 g8030 VDD VDD pmos W=0.205u L=0.04u
M11871 n3283 U4838/net19 U4838/net26 VDD pmos W=0.325u L=0.04u
M11872 U4838/net26 n4520 VDD VDD pmos W=0.41u L=0.04u
M11873 n3283 g8030 U4838/net30 VDD pmos W=0.325u L=0.04u
M11874 U4838/net30 g3107 VDD VDD pmos W=0.205u L=0.04u
M11875 U4839/net19 g8030 VSS VSS nmos W=0.155u L=0.04u
M11876 n3282 g8030 U4839/net40 VSS nmos W=0.155u L=0.04u
M11877 n3282 U4839/net19 U4839/net36 VSS nmos W=0.155u L=0.04u
M11878 U4839/net40 g2574 VSS VSS nmos W=0.31u L=0.04u
M11879 U4839/net36 g3185 VSS VSS nmos W=0.155u L=0.04u
M11880 U4839/net19 g8030 VDD VDD pmos W=0.205u L=0.04u
M11881 n3282 U4839/net19 U4839/net26 VDD pmos W=0.325u L=0.04u
M11882 U4839/net26 g2574 VDD VDD pmos W=0.41u L=0.04u
M11883 n3282 g8030 U4839/net30 VDD pmos W=0.325u L=0.04u
M11884 U4839/net30 g3185 VDD VDD pmos W=0.205u L=0.04u
M11885 U4840/net19 g8030 VSS VSS nmos W=0.155u L=0.04u
M11886 n3281 g8030 U4840/net40 VSS nmos W=0.155u L=0.04u
M11887 n3281 U4840/net19 U4840/net36 VSS nmos W=0.155u L=0.04u
M11888 U4840/net40 g559 VSS VSS nmos W=0.31u L=0.04u
M11889 U4840/net36 g3211 VSS VSS nmos W=0.155u L=0.04u
M11890 U4840/net19 g8030 VDD VDD pmos W=0.205u L=0.04u
M11891 n3281 U4840/net19 U4840/net26 VDD pmos W=0.325u L=0.04u
M11892 U4840/net26 g559 VDD VDD pmos W=0.41u L=0.04u
M11893 n3281 g8030 U4840/net30 VDD pmos W=0.325u L=0.04u
M11894 U4840/net30 g3211 VDD VDD pmos W=0.205u L=0.04u
M11895 U4841/net19 g8106 VSS VSS nmos W=0.155u L=0.04u
M11896 n3280 g8106 U4841/net40 VSS nmos W=0.155u L=0.04u
M11897 n3280 U4841/net19 U4841/net36 VSS nmos W=0.155u L=0.04u
M11898 U4841/net40 g1245 VSS VSS nmos W=0.31u L=0.04u
M11899 U4841/net36 g3085 VSS VSS nmos W=0.155u L=0.04u
M11900 U4841/net19 g8106 VDD VDD pmos W=0.205u L=0.04u
M11901 n3280 U4841/net19 U4841/net26 VDD pmos W=0.325u L=0.04u
M11902 U4841/net26 g1245 VDD VDD pmos W=0.41u L=0.04u
M11903 n3280 g8106 U4841/net30 VDD pmos W=0.325u L=0.04u
M11904 U4841/net30 g3085 VDD VDD pmos W=0.205u L=0.04u
M11905 n328 g25490 VSS VSS nmos W=0.135u L=0.04u
M11906 n328 g25490 VDD VDD pmos W=0.205u L=0.04u
M11907 U4843/net19 g8106 VSS VSS nmos W=0.155u L=0.04u
M11908 n3279 g8106 U4843/net40 VSS nmos W=0.155u L=0.04u
M11909 n3279 U4843/net19 U4843/net36 VSS nmos W=0.155u L=0.04u
M11910 U4843/net40 g1939 VSS VSS nmos W=0.31u L=0.04u
M11911 U4843/net36 g3091 VSS VSS nmos W=0.155u L=0.04u
M11912 U4843/net19 g8106 VDD VDD pmos W=0.205u L=0.04u
M11913 n3279 U4843/net19 U4843/net26 VDD pmos W=0.325u L=0.04u
M11914 U4843/net26 g1939 VDD VDD pmos W=0.41u L=0.04u
M11915 n3279 g8106 U4843/net30 VDD pmos W=0.325u L=0.04u
M11916 U4843/net30 g3091 VDD VDD pmos W=0.205u L=0.04u
M11917 U4844/net19 g8106 VSS VSS nmos W=0.155u L=0.04u
M11918 n3278 g8106 U4844/net40 VSS nmos W=0.155u L=0.04u
M11919 n3278 U4844/net19 U4844/net36 VSS nmos W=0.155u L=0.04u
M11920 U4844/net40 g2633 VSS VSS nmos W=0.31u L=0.04u
M11921 U4844/net36 g3094 VSS VSS nmos W=0.155u L=0.04u
M11922 U4844/net19 g8106 VDD VDD pmos W=0.205u L=0.04u
M11923 n3278 U4844/net19 U4844/net26 VDD pmos W=0.325u L=0.04u
M11924 U4844/net26 g2633 VDD VDD pmos W=0.41u L=0.04u
M11925 n3278 g8106 U4844/net30 VDD pmos W=0.325u L=0.04u
M11926 U4844/net30 g3094 VDD VDD pmos W=0.205u L=0.04u
M11927 U4845/net19 g8106 VSS VSS nmos W=0.155u L=0.04u
M11928 n3277 g8106 U4845/net40 VSS nmos W=0.155u L=0.04u
M11929 n3277 U4845/net19 U4845/net36 VSS nmos W=0.155u L=0.04u
M11930 U4845/net40 n4517 VSS VSS nmos W=0.31u L=0.04u
M11931 U4845/net36 g3097 VSS VSS nmos W=0.155u L=0.04u
M11932 U4845/net19 g8106 VDD VDD pmos W=0.205u L=0.04u
M11933 n3277 U4845/net19 U4845/net26 VDD pmos W=0.325u L=0.04u
M11934 U4845/net26 n4517 VDD VDD pmos W=0.41u L=0.04u
M11935 n3277 g8106 U4845/net30 VDD pmos W=0.325u L=0.04u
M11936 U4845/net30 g3097 VDD VDD pmos W=0.205u L=0.04u
M11937 U4846/net19 g8106 VSS VSS nmos W=0.155u L=0.04u
M11938 n3276 g8106 U4846/net40 VSS nmos W=0.155u L=0.04u
M11939 n3276 U4846/net19 U4846/net36 VSS nmos W=0.155u L=0.04u
M11940 U4846/net40 g499 VSS VSS nmos W=0.31u L=0.04u
M11941 U4846/net36 g3155 VSS VSS nmos W=0.155u L=0.04u
M11942 U4846/net19 g8106 VDD VDD pmos W=0.205u L=0.04u
M11943 n3276 U4846/net19 U4846/net26 VDD pmos W=0.325u L=0.04u
M11944 U4846/net26 g499 VDD VDD pmos W=0.41u L=0.04u
M11945 n3276 g8106 U4846/net30 VDD pmos W=0.325u L=0.04u
M11946 U4846/net30 g3155 VDD VDD pmos W=0.205u L=0.04u
M11947 U4847/net19 g8106 VSS VSS nmos W=0.155u L=0.04u
M11948 n3275 g8106 U4847/net40 VSS nmos W=0.155u L=0.04u
M11949 n3275 U4847/net19 U4847/net36 VSS nmos W=0.155u L=0.04u
M11950 U4847/net40 n4518 VSS VSS nmos W=0.31u L=0.04u
M11951 U4847/net36 g3100 VSS VSS nmos W=0.155u L=0.04u
M11952 U4847/net19 g8106 VDD VDD pmos W=0.205u L=0.04u
M11953 n3275 U4847/net19 U4847/net26 VDD pmos W=0.325u L=0.04u
M11954 U4847/net26 n4518 VDD VDD pmos W=0.41u L=0.04u
M11955 n3275 g8106 U4847/net30 VDD pmos W=0.325u L=0.04u
M11956 U4847/net30 g3100 VDD VDD pmos W=0.205u L=0.04u
M11957 U4848/net19 g8106 VSS VSS nmos W=0.155u L=0.04u
M11958 n3274 g8106 U4848/net40 VSS nmos W=0.155u L=0.04u
M11959 n3274 U4848/net19 U4848/net36 VSS nmos W=0.155u L=0.04u
M11960 U4848/net40 g1186 VSS VSS nmos W=0.31u L=0.04u
M11961 U4848/net36 g3164 VSS VSS nmos W=0.155u L=0.04u
M11962 U4848/net19 g8106 VDD VDD pmos W=0.205u L=0.04u
M11963 n3274 U4848/net19 U4848/net26 VDD pmos W=0.325u L=0.04u
M11964 U4848/net26 g1186 VDD VDD pmos W=0.41u L=0.04u
M11965 n3274 g8106 U4848/net30 VDD pmos W=0.325u L=0.04u
M11966 U4848/net30 g3164 VDD VDD pmos W=0.205u L=0.04u
M11967 U4849/net19 g8106 VSS VSS nmos W=0.155u L=0.04u
M11968 n3273 g8106 U4849/net40 VSS nmos W=0.155u L=0.04u
M11969 n3273 U4849/net19 U4849/net36 VSS nmos W=0.155u L=0.04u
M11970 U4849/net40 n4519 VSS VSS nmos W=0.31u L=0.04u
M11971 U4849/net36 g3103 VSS VSS nmos W=0.155u L=0.04u
M11972 U4849/net19 g8106 VDD VDD pmos W=0.205u L=0.04u
M11973 n3273 U4849/net19 U4849/net26 VDD pmos W=0.325u L=0.04u
M11974 U4849/net26 n4519 VDD VDD pmos W=0.41u L=0.04u
M11975 n3273 g8106 U4849/net30 VDD pmos W=0.325u L=0.04u
M11976 U4849/net30 g3103 VDD VDD pmos W=0.205u L=0.04u
M11977 U4850/net19 g8106 VSS VSS nmos W=0.155u L=0.04u
M11978 n3272 g8106 U4850/net40 VSS nmos W=0.155u L=0.04u
M11979 n3272 U4850/net19 U4850/net36 VSS nmos W=0.155u L=0.04u
M11980 U4850/net40 g1880 VSS VSS nmos W=0.31u L=0.04u
M11981 U4850/net36 g3173 VSS VSS nmos W=0.155u L=0.04u
M11982 U4850/net19 g8106 VDD VDD pmos W=0.205u L=0.04u
M11983 n3272 U4850/net19 U4850/net26 VDD pmos W=0.325u L=0.04u
M11984 U4850/net26 g1880 VDD VDD pmos W=0.41u L=0.04u
M11985 n3272 g8106 U4850/net30 VDD pmos W=0.325u L=0.04u
M11986 U4850/net30 g3173 VDD VDD pmos W=0.205u L=0.04u
M11987 U4851/net19 g8106 VSS VSS nmos W=0.155u L=0.04u
M11988 n3271 g8106 U4851/net40 VSS nmos W=0.155u L=0.04u
M11989 n3271 U4851/net19 U4851/net36 VSS nmos W=0.155u L=0.04u
M11990 U4851/net40 n4520 VSS VSS nmos W=0.31u L=0.04u
M11991 U4851/net36 g3106 VSS VSS nmos W=0.155u L=0.04u
M11992 U4851/net19 g8106 VDD VDD pmos W=0.205u L=0.04u
M11993 n3271 U4851/net19 U4851/net26 VDD pmos W=0.325u L=0.04u
M11994 U4851/net26 n4520 VDD VDD pmos W=0.41u L=0.04u
M11995 n3271 g8106 U4851/net30 VDD pmos W=0.325u L=0.04u
M11996 U4851/net30 g3106 VDD VDD pmos W=0.205u L=0.04u
M11997 U4852/net19 g8106 VSS VSS nmos W=0.155u L=0.04u
M11998 n3270 g8106 U4852/net40 VSS nmos W=0.155u L=0.04u
M11999 n3270 U4852/net19 U4852/net36 VSS nmos W=0.155u L=0.04u
M12000 U4852/net40 g2574 VSS VSS nmos W=0.31u L=0.04u
M12001 U4852/net36 g3182 VSS VSS nmos W=0.155u L=0.04u
M12002 U4852/net19 g8106 VDD VDD pmos W=0.205u L=0.04u
M12003 n3270 U4852/net19 U4852/net26 VDD pmos W=0.325u L=0.04u
M12004 U4852/net26 g2574 VDD VDD pmos W=0.41u L=0.04u
M12005 n3270 g8106 U4852/net30 VDD pmos W=0.325u L=0.04u
M12006 U4852/net30 g3182 VDD VDD pmos W=0.205u L=0.04u
M12007 U4853/net19 g8106 VSS VSS nmos W=0.155u L=0.04u
M12008 n3269 g8106 U4853/net40 VSS nmos W=0.155u L=0.04u
M12009 n3269 U4853/net19 U4853/net36 VSS nmos W=0.155u L=0.04u
M12010 U4853/net40 g559 VSS VSS nmos W=0.31u L=0.04u
M12011 U4853/net36 g3210 VSS VSS nmos W=0.155u L=0.04u
M12012 U4853/net19 g8106 VDD VDD pmos W=0.205u L=0.04u
M12013 n3269 U4853/net19 U4853/net26 VDD pmos W=0.325u L=0.04u
M12014 U4853/net26 g559 VDD VDD pmos W=0.41u L=0.04u
M12015 n3269 g8106 U4853/net30 VDD pmos W=0.325u L=0.04u
M12016 U4853/net30 g3210 VDD VDD pmos W=0.205u L=0.04u
M12017 U4854/net19 n3963 VSS VSS nmos W=0.155u L=0.04u
M12018 n3268 n3963 U4854/net40 VSS nmos W=0.155u L=0.04u
M12019 n3268 U4854/net19 U4854/net36 VSS nmos W=0.155u L=0.04u
M12020 U4854/net40 n4521 VSS VSS nmos W=0.31u L=0.04u
M12021 U4854/net36 g2206 VSS VSS nmos W=0.155u L=0.04u
M12022 U4854/net19 n3963 VDD VDD pmos W=0.205u L=0.04u
M12023 n3268 U4854/net19 U4854/net26 VDD pmos W=0.325u L=0.04u
M12024 U4854/net26 n4521 VDD VDD pmos W=0.41u L=0.04u
M12025 n3268 n3963 U4854/net30 VDD pmos W=0.325u L=0.04u
M12026 U4854/net30 g2206 VDD VDD pmos W=0.205u L=0.04u
M12027 U4855/net19 n3960 VSS VSS nmos W=0.155u L=0.04u
M12028 n3267 n3960 U4855/net40 VSS nmos W=0.155u L=0.04u
M12029 n3267 U4855/net19 U4855/net36 VSS nmos W=0.155u L=0.04u
M12030 U4855/net40 n4521 VSS VSS nmos W=0.31u L=0.04u
M12031 U4855/net36 g2207 VSS VSS nmos W=0.155u L=0.04u
M12032 U4855/net19 n3960 VDD VDD pmos W=0.205u L=0.04u
M12033 n3267 U4855/net19 U4855/net26 VDD pmos W=0.325u L=0.04u
M12034 U4855/net26 n4521 VDD VDD pmos W=0.41u L=0.04u
M12035 n3267 n3960 U4855/net30 VDD pmos W=0.325u L=0.04u
M12036 U4855/net30 g2207 VDD VDD pmos W=0.205u L=0.04u
M12037 U4856/net19 n3961 VSS VSS nmos W=0.155u L=0.04u
M12038 n3266 n3961 U4856/net40 VSS nmos W=0.155u L=0.04u
M12039 n3266 U4856/net19 U4856/net36 VSS nmos W=0.155u L=0.04u
M12040 U4856/net40 n4521 VSS VSS nmos W=0.31u L=0.04u
M12041 U4856/net36 g2205 VSS VSS nmos W=0.155u L=0.04u
M12042 U4856/net19 n3961 VDD VDD pmos W=0.205u L=0.04u
M12043 n3266 U4856/net19 U4856/net26 VDD pmos W=0.325u L=0.04u
M12044 U4856/net26 n4521 VDD VDD pmos W=0.41u L=0.04u
M12045 n3266 n3961 U4856/net30 VDD pmos W=0.325u L=0.04u
M12046 U4856/net30 g2205 VDD VDD pmos W=0.205u L=0.04u
M12047 U4857/net19 n3963 VSS VSS nmos W=0.155u L=0.04u
M12048 n3265 n3963 U4857/net40 VSS nmos W=0.155u L=0.04u
M12049 n3265 U4857/net19 U4857/net36 VSS nmos W=0.155u L=0.04u
M12050 U4857/net40 n4522 VSS VSS nmos W=0.31u L=0.04u
M12051 U4857/net36 g2209 VSS VSS nmos W=0.155u L=0.04u
M12052 U4857/net19 n3963 VDD VDD pmos W=0.205u L=0.04u
M12053 n3265 U4857/net19 U4857/net26 VDD pmos W=0.325u L=0.04u
M12054 U4857/net26 n4522 VDD VDD pmos W=0.41u L=0.04u
M12055 n3265 n3963 U4857/net30 VDD pmos W=0.325u L=0.04u
M12056 U4857/net30 g2209 VDD VDD pmos W=0.205u L=0.04u
M12057 U4858/net19 n3960 VSS VSS nmos W=0.155u L=0.04u
M12058 n3264 n3960 U4858/net40 VSS nmos W=0.155u L=0.04u
M12059 n3264 U4858/net19 U4858/net36 VSS nmos W=0.155u L=0.04u
M12060 U4858/net40 n4522 VSS VSS nmos W=0.31u L=0.04u
M12061 U4858/net36 g2210 VSS VSS nmos W=0.155u L=0.04u
M12062 U4858/net19 n3960 VDD VDD pmos W=0.205u L=0.04u
M12063 n3264 U4858/net19 U4858/net26 VDD pmos W=0.325u L=0.04u
M12064 U4858/net26 n4522 VDD VDD pmos W=0.41u L=0.04u
M12065 n3264 n3960 U4858/net30 VDD pmos W=0.325u L=0.04u
M12066 U4858/net30 g2210 VDD VDD pmos W=0.205u L=0.04u
M12067 U4859/net19 n3961 VSS VSS nmos W=0.155u L=0.04u
M12068 n3263 n3961 U4859/net40 VSS nmos W=0.155u L=0.04u
M12069 n3263 U4859/net19 U4859/net36 VSS nmos W=0.155u L=0.04u
M12070 U4859/net40 n4522 VSS VSS nmos W=0.31u L=0.04u
M12071 U4859/net36 g2208 VSS VSS nmos W=0.155u L=0.04u
M12072 U4859/net19 n3961 VDD VDD pmos W=0.205u L=0.04u
M12073 n3263 U4859/net19 U4859/net26 VDD pmos W=0.325u L=0.04u
M12074 U4859/net26 n4522 VDD VDD pmos W=0.41u L=0.04u
M12075 n3263 n3961 U4859/net30 VDD pmos W=0.325u L=0.04u
M12076 U4859/net30 g2208 VDD VDD pmos W=0.205u L=0.04u
M12077 U4860/net19 n3963 VSS VSS nmos W=0.155u L=0.04u
M12078 n3262 n3963 U4860/net40 VSS nmos W=0.155u L=0.04u
M12079 n3262 U4860/net19 U4860/net36 VSS nmos W=0.155u L=0.04u
M12080 U4860/net40 n4523 VSS VSS nmos W=0.31u L=0.04u
M12081 U4860/net36 g2218 VSS VSS nmos W=0.155u L=0.04u
M12082 U4860/net19 n3963 VDD VDD pmos W=0.205u L=0.04u
M12083 n3262 U4860/net19 U4860/net26 VDD pmos W=0.325u L=0.04u
M12084 U4860/net26 n4523 VDD VDD pmos W=0.41u L=0.04u
M12085 n3262 n3963 U4860/net30 VDD pmos W=0.325u L=0.04u
M12086 U4860/net30 g2218 VDD VDD pmos W=0.205u L=0.04u
M12087 U4861/net19 n3960 VSS VSS nmos W=0.155u L=0.04u
M12088 n3261 n3960 U4861/net40 VSS nmos W=0.155u L=0.04u
M12089 n3261 U4861/net19 U4861/net36 VSS nmos W=0.155u L=0.04u
M12090 U4861/net40 n4523 VSS VSS nmos W=0.31u L=0.04u
M12091 U4861/net36 g2219 VSS VSS nmos W=0.155u L=0.04u
M12092 U4861/net19 n3960 VDD VDD pmos W=0.205u L=0.04u
M12093 n3261 U4861/net19 U4861/net26 VDD pmos W=0.325u L=0.04u
M12094 U4861/net26 n4523 VDD VDD pmos W=0.41u L=0.04u
M12095 n3261 n3960 U4861/net30 VDD pmos W=0.325u L=0.04u
M12096 U4861/net30 g2219 VDD VDD pmos W=0.205u L=0.04u
M12097 U4862/net19 n3961 VSS VSS nmos W=0.155u L=0.04u
M12098 n3260 n3961 U4862/net40 VSS nmos W=0.155u L=0.04u
M12099 n3260 U4862/net19 U4862/net36 VSS nmos W=0.155u L=0.04u
M12100 U4862/net40 n4523 VSS VSS nmos W=0.31u L=0.04u
M12101 U4862/net36 g2217 VSS VSS nmos W=0.155u L=0.04u
M12102 U4862/net19 n3961 VDD VDD pmos W=0.205u L=0.04u
M12103 n3260 U4862/net19 U4862/net26 VDD pmos W=0.325u L=0.04u
M12104 U4862/net26 n4523 VDD VDD pmos W=0.41u L=0.04u
M12105 n3260 n3961 U4862/net30 VDD pmos W=0.325u L=0.04u
M12106 U4862/net30 g2217 VDD VDD pmos W=0.205u L=0.04u
M12107 U4863/net19 n3963 VSS VSS nmos W=0.155u L=0.04u
M12108 n3259 n3963 U4863/net40 VSS nmos W=0.155u L=0.04u
M12109 n3259 U4863/net19 U4863/net36 VSS nmos W=0.155u L=0.04u
M12110 U4863/net40 n4524 VSS VSS nmos W=0.31u L=0.04u
M12111 U4863/net36 g2221 VSS VSS nmos W=0.155u L=0.04u
M12112 U4863/net19 n3963 VDD VDD pmos W=0.205u L=0.04u
M12113 n3259 U4863/net19 U4863/net26 VDD pmos W=0.325u L=0.04u
M12114 U4863/net26 n4524 VDD VDD pmos W=0.41u L=0.04u
M12115 n3259 n3963 U4863/net30 VDD pmos W=0.325u L=0.04u
M12116 U4863/net30 g2221 VDD VDD pmos W=0.205u L=0.04u
M12117 U4864/net19 n3960 VSS VSS nmos W=0.155u L=0.04u
M12118 n3258 n3960 U4864/net40 VSS nmos W=0.155u L=0.04u
M12119 n3258 U4864/net19 U4864/net36 VSS nmos W=0.155u L=0.04u
M12120 U4864/net40 n4524 VSS VSS nmos W=0.31u L=0.04u
M12121 U4864/net36 g2222 VSS VSS nmos W=0.155u L=0.04u
M12122 U4864/net19 n3960 VDD VDD pmos W=0.205u L=0.04u
M12123 n3258 U4864/net19 U4864/net26 VDD pmos W=0.325u L=0.04u
M12124 U4864/net26 n4524 VDD VDD pmos W=0.41u L=0.04u
M12125 n3258 n3960 U4864/net30 VDD pmos W=0.325u L=0.04u
M12126 U4864/net30 g2222 VDD VDD pmos W=0.205u L=0.04u
M12127 U4865/net19 n3961 VSS VSS nmos W=0.155u L=0.04u
M12128 n3257 n3961 U4865/net40 VSS nmos W=0.155u L=0.04u
M12129 n3257 U4865/net19 U4865/net36 VSS nmos W=0.155u L=0.04u
M12130 U4865/net40 n4524 VSS VSS nmos W=0.31u L=0.04u
M12131 U4865/net36 g2220 VSS VSS nmos W=0.155u L=0.04u
M12132 U4865/net19 n3961 VDD VDD pmos W=0.205u L=0.04u
M12133 n3257 U4865/net19 U4865/net26 VDD pmos W=0.325u L=0.04u
M12134 U4865/net26 n4524 VDD VDD pmos W=0.41u L=0.04u
M12135 n3257 n3961 U4865/net30 VDD pmos W=0.325u L=0.04u
M12136 U4865/net30 g2220 VDD VDD pmos W=0.205u L=0.04u
M12137 U4866/net19 n3963 VSS VSS nmos W=0.155u L=0.04u
M12138 n3256 n3963 U4866/net40 VSS nmos W=0.155u L=0.04u
M12139 n3256 U4866/net19 U4866/net36 VSS nmos W=0.155u L=0.04u
M12140 U4866/net40 n4525 VSS VSS nmos W=0.31u L=0.04u
M12141 U4866/net36 g2224 VSS VSS nmos W=0.155u L=0.04u
M12142 U4866/net19 n3963 VDD VDD pmos W=0.205u L=0.04u
M12143 n3256 U4866/net19 U4866/net26 VDD pmos W=0.325u L=0.04u
M12144 U4866/net26 n4525 VDD VDD pmos W=0.41u L=0.04u
M12145 n3256 n3963 U4866/net30 VDD pmos W=0.325u L=0.04u
M12146 U4866/net30 g2224 VDD VDD pmos W=0.205u L=0.04u
M12147 U4867/net19 n3960 VSS VSS nmos W=0.155u L=0.04u
M12148 n3255 n3960 U4867/net40 VSS nmos W=0.155u L=0.04u
M12149 n3255 U4867/net19 U4867/net36 VSS nmos W=0.155u L=0.04u
M12150 U4867/net40 n4525 VSS VSS nmos W=0.31u L=0.04u
M12151 U4867/net36 g2225 VSS VSS nmos W=0.155u L=0.04u
M12152 U4867/net19 n3960 VDD VDD pmos W=0.205u L=0.04u
M12153 n3255 U4867/net19 U4867/net26 VDD pmos W=0.325u L=0.04u
M12154 U4867/net26 n4525 VDD VDD pmos W=0.41u L=0.04u
M12155 n3255 n3960 U4867/net30 VDD pmos W=0.325u L=0.04u
M12156 U4867/net30 g2225 VDD VDD pmos W=0.205u L=0.04u
M12157 U4868/net19 n3961 VSS VSS nmos W=0.155u L=0.04u
M12158 n3254 n3961 U4868/net40 VSS nmos W=0.155u L=0.04u
M12159 n3254 U4868/net19 U4868/net36 VSS nmos W=0.155u L=0.04u
M12160 U4868/net40 n4525 VSS VSS nmos W=0.31u L=0.04u
M12161 U4868/net36 g2223 VSS VSS nmos W=0.155u L=0.04u
M12162 U4868/net19 n3961 VDD VDD pmos W=0.205u L=0.04u
M12163 n3254 U4868/net19 U4868/net26 VDD pmos W=0.325u L=0.04u
M12164 U4868/net26 n4525 VDD VDD pmos W=0.41u L=0.04u
M12165 n3254 n3961 U4868/net30 VDD pmos W=0.325u L=0.04u
M12166 U4868/net30 g2223 VDD VDD pmos W=0.205u L=0.04u
M12167 U4869/net19 n3963 VSS VSS nmos W=0.155u L=0.04u
M12168 n3253 n3963 U4869/net40 VSS nmos W=0.155u L=0.04u
M12169 n3253 U4869/net19 U4869/net36 VSS nmos W=0.155u L=0.04u
M12170 U4869/net40 n4526 VSS VSS nmos W=0.31u L=0.04u
M12171 U4869/net36 g2227 VSS VSS nmos W=0.155u L=0.04u
M12172 U4869/net19 n3963 VDD VDD pmos W=0.205u L=0.04u
M12173 n3253 U4869/net19 U4869/net26 VDD pmos W=0.325u L=0.04u
M12174 U4869/net26 n4526 VDD VDD pmos W=0.41u L=0.04u
M12175 n3253 n3963 U4869/net30 VDD pmos W=0.325u L=0.04u
M12176 U4869/net30 g2227 VDD VDD pmos W=0.205u L=0.04u
M12177 U4870/net19 n3960 VSS VSS nmos W=0.155u L=0.04u
M12178 n3252 n3960 U4870/net40 VSS nmos W=0.155u L=0.04u
M12179 n3252 U4870/net19 U4870/net36 VSS nmos W=0.155u L=0.04u
M12180 U4870/net40 n4526 VSS VSS nmos W=0.31u L=0.04u
M12181 U4870/net36 g2228 VSS VSS nmos W=0.155u L=0.04u
M12182 U4870/net19 n3960 VDD VDD pmos W=0.205u L=0.04u
M12183 n3252 U4870/net19 U4870/net26 VDD pmos W=0.325u L=0.04u
M12184 U4870/net26 n4526 VDD VDD pmos W=0.41u L=0.04u
M12185 n3252 n3960 U4870/net30 VDD pmos W=0.325u L=0.04u
M12186 U4870/net30 g2228 VDD VDD pmos W=0.205u L=0.04u
M12187 U4871/net19 n3961 VSS VSS nmos W=0.155u L=0.04u
M12188 n3251 n3961 U4871/net40 VSS nmos W=0.155u L=0.04u
M12189 n3251 U4871/net19 U4871/net36 VSS nmos W=0.155u L=0.04u
M12190 U4871/net40 n4526 VSS VSS nmos W=0.31u L=0.04u
M12191 U4871/net36 g2226 VSS VSS nmos W=0.155u L=0.04u
M12192 U4871/net19 n3961 VDD VDD pmos W=0.205u L=0.04u
M12193 n3251 U4871/net19 U4871/net26 VDD pmos W=0.325u L=0.04u
M12194 U4871/net26 n4526 VDD VDD pmos W=0.41u L=0.04u
M12195 n3251 n3961 U4871/net30 VDD pmos W=0.325u L=0.04u
M12196 U4871/net30 g2226 VDD VDD pmos W=0.205u L=0.04u
M12197 U4872/net19 n3963 VSS VSS nmos W=0.155u L=0.04u
M12198 n3250 n3963 U4872/net40 VSS nmos W=0.155u L=0.04u
M12199 n3250 U4872/net19 U4872/net36 VSS nmos W=0.155u L=0.04u
M12200 U4872/net40 n4527 VSS VSS nmos W=0.31u L=0.04u
M12201 U4872/net36 g2230 VSS VSS nmos W=0.155u L=0.04u
M12202 U4872/net19 n3963 VDD VDD pmos W=0.205u L=0.04u
M12203 n3250 U4872/net19 U4872/net26 VDD pmos W=0.325u L=0.04u
M12204 U4872/net26 n4527 VDD VDD pmos W=0.41u L=0.04u
M12205 n3250 n3963 U4872/net30 VDD pmos W=0.325u L=0.04u
M12206 U4872/net30 g2230 VDD VDD pmos W=0.205u L=0.04u
M12207 U4873/net19 n3960 VSS VSS nmos W=0.155u L=0.04u
M12208 n3249 n3960 U4873/net40 VSS nmos W=0.155u L=0.04u
M12209 n3249 U4873/net19 U4873/net36 VSS nmos W=0.155u L=0.04u
M12210 U4873/net40 n4527 VSS VSS nmos W=0.31u L=0.04u
M12211 U4873/net36 g2231 VSS VSS nmos W=0.155u L=0.04u
M12212 U4873/net19 n3960 VDD VDD pmos W=0.205u L=0.04u
M12213 n3249 U4873/net19 U4873/net26 VDD pmos W=0.325u L=0.04u
M12214 U4873/net26 n4527 VDD VDD pmos W=0.41u L=0.04u
M12215 n3249 n3960 U4873/net30 VDD pmos W=0.325u L=0.04u
M12216 U4873/net30 g2231 VDD VDD pmos W=0.205u L=0.04u
M12217 U4874/net19 n3961 VSS VSS nmos W=0.155u L=0.04u
M12218 n3248 n3961 U4874/net40 VSS nmos W=0.155u L=0.04u
M12219 n3248 U4874/net19 U4874/net36 VSS nmos W=0.155u L=0.04u
M12220 U4874/net40 n4527 VSS VSS nmos W=0.31u L=0.04u
M12221 U4874/net36 g2229 VSS VSS nmos W=0.155u L=0.04u
M12222 U4874/net19 n3961 VDD VDD pmos W=0.205u L=0.04u
M12223 n3248 U4874/net19 U4874/net26 VDD pmos W=0.325u L=0.04u
M12224 U4874/net26 n4527 VDD VDD pmos W=0.41u L=0.04u
M12225 n3248 n3961 U4874/net30 VDD pmos W=0.325u L=0.04u
M12226 U4874/net30 g2229 VDD VDD pmos W=0.205u L=0.04u
M12227 U4875/net19 n4529 VSS VSS nmos W=0.155u L=0.04u
M12228 n3247 n4529 U4875/net40 VSS nmos W=0.155u L=0.04u
M12229 n3247 U4875/net19 U4875/net36 VSS nmos W=0.155u L=0.04u
M12230 U4875/net40 g2504 VSS VSS nmos W=0.31u L=0.04u
M12231 U4875/net36 n4528 VSS VSS nmos W=0.155u L=0.04u
M12232 U4875/net19 n4529 VDD VDD pmos W=0.205u L=0.04u
M12233 n3247 U4875/net19 U4875/net26 VDD pmos W=0.325u L=0.04u
M12234 U4875/net26 g2504 VDD VDD pmos W=0.41u L=0.04u
M12235 n3247 n4529 U4875/net30 VDD pmos W=0.325u L=0.04u
M12236 U4875/net30 n4528 VDD VDD pmos W=0.205u L=0.04u
M12237 U4876/net19 n4330 VSS VSS nmos W=0.155u L=0.04u
M12238 n3246 n4330 U4876/net40 VSS nmos W=0.155u L=0.04u
M12239 n3246 U4876/net19 U4876/net36 VSS nmos W=0.155u L=0.04u
M12240 U4876/net40 g2507 VSS VSS nmos W=0.31u L=0.04u
M12241 U4876/net36 n4528 VSS VSS nmos W=0.155u L=0.04u
M12242 U4876/net19 n4330 VDD VDD pmos W=0.205u L=0.04u
M12243 n3246 U4876/net19 U4876/net26 VDD pmos W=0.325u L=0.04u
M12244 U4876/net26 g2507 VDD VDD pmos W=0.41u L=0.04u
M12245 n3246 n4330 U4876/net30 VDD pmos W=0.325u L=0.04u
M12246 U4876/net30 n4528 VDD VDD pmos W=0.205u L=0.04u
M12247 U4877/net19 n4530 VSS VSS nmos W=0.155u L=0.04u
M12248 n3245 n4530 U4877/net40 VSS nmos W=0.155u L=0.04u
M12249 n3245 U4877/net19 U4877/net36 VSS nmos W=0.155u L=0.04u
M12250 U4877/net40 g2510 VSS VSS nmos W=0.31u L=0.04u
M12251 U4877/net36 n4528 VSS VSS nmos W=0.155u L=0.04u
M12252 U4877/net19 n4530 VDD VDD pmos W=0.205u L=0.04u
M12253 n3245 U4877/net19 U4877/net26 VDD pmos W=0.325u L=0.04u
M12254 U4877/net26 g2510 VDD VDD pmos W=0.41u L=0.04u
M12255 n3245 n4530 U4877/net30 VDD pmos W=0.325u L=0.04u
M12256 U4877/net30 n4528 VDD VDD pmos W=0.205u L=0.04u
M12257 U4878/net19 g2384 VSS VSS nmos W=0.155u L=0.04u
M12258 n4528 g2384 U4878/net40 VSS nmos W=0.155u L=0.04u
M12259 n4528 U4878/net19 U4878/net36 VSS nmos W=0.155u L=0.04u
M12260 U4878/net40 n4532 VSS VSS nmos W=0.31u L=0.04u
M12261 U4878/net36 n4531 VSS VSS nmos W=0.155u L=0.04u
M12262 U4878/net19 g2384 VDD VDD pmos W=0.205u L=0.04u
M12263 n4528 U4878/net19 U4878/net26 VDD pmos W=0.325u L=0.04u
M12264 U4878/net26 n4532 VDD VDD pmos W=0.41u L=0.04u
M12265 n4528 g2384 U4878/net30 VDD pmos W=0.325u L=0.04u
M12266 U4878/net30 n4531 VDD VDD pmos W=0.205u L=0.04u
M12267 U4879/net19 n4529 VSS VSS nmos W=0.155u L=0.04u
M12268 n3244 n4529 U4879/net40 VSS nmos W=0.155u L=0.04u
M12269 n3244 U4879/net19 U4879/net36 VSS nmos W=0.155u L=0.04u
M12270 U4879/net40 g2513 VSS VSS nmos W=0.31u L=0.04u
M12271 U4879/net36 n4533 VSS VSS nmos W=0.155u L=0.04u
M12272 U4879/net19 n4529 VDD VDD pmos W=0.205u L=0.04u
M12273 n3244 U4879/net19 U4879/net26 VDD pmos W=0.325u L=0.04u
M12274 U4879/net26 g2513 VDD VDD pmos W=0.41u L=0.04u
M12275 n3244 n4529 U4879/net30 VDD pmos W=0.325u L=0.04u
M12276 U4879/net30 n4533 VDD VDD pmos W=0.205u L=0.04u
M12277 U4880/net19 n4330 VSS VSS nmos W=0.155u L=0.04u
M12278 n3243 n4330 U4880/net40 VSS nmos W=0.155u L=0.04u
M12279 n3243 U4880/net19 U4880/net36 VSS nmos W=0.155u L=0.04u
M12280 U4880/net40 g2516 VSS VSS nmos W=0.31u L=0.04u
M12281 U4880/net36 n4533 VSS VSS nmos W=0.155u L=0.04u
M12282 U4880/net19 n4330 VDD VDD pmos W=0.205u L=0.04u
M12283 n3243 U4880/net19 U4880/net26 VDD pmos W=0.325u L=0.04u
M12284 U4880/net26 g2516 VDD VDD pmos W=0.41u L=0.04u
M12285 n3243 n4330 U4880/net30 VDD pmos W=0.325u L=0.04u
M12286 U4880/net30 n4533 VDD VDD pmos W=0.205u L=0.04u
M12287 U4881/net19 n4530 VSS VSS nmos W=0.155u L=0.04u
M12288 n3242 n4530 U4881/net40 VSS nmos W=0.155u L=0.04u
M12289 n3242 U4881/net19 U4881/net36 VSS nmos W=0.155u L=0.04u
M12290 U4881/net40 g2519 VSS VSS nmos W=0.31u L=0.04u
M12291 U4881/net36 n4533 VSS VSS nmos W=0.155u L=0.04u
M12292 U4881/net19 n4530 VDD VDD pmos W=0.205u L=0.04u
M12293 n3242 U4881/net19 U4881/net26 VDD pmos W=0.325u L=0.04u
M12294 U4881/net26 g2519 VDD VDD pmos W=0.41u L=0.04u
M12295 n3242 n4530 U4881/net30 VDD pmos W=0.325u L=0.04u
M12296 U4881/net30 n4533 VDD VDD pmos W=0.205u L=0.04u
M12297 U4882/net4 n4534 U4882/net14 VSS nmos W=0.155u L=0.04u
M12298 U4882/net6 U4882/net10 U4882/net14 VSS nmos W=0.17u L=0.04u
M12299 U4882/net4 n4535 VSS VSS nmos W=0.155u L=0.04u
M12300 U4882/net6 U4882/net4 VSS VSS nmos W=0.17u L=0.04u
M12301 n4533 U4882/net14 VSS VSS nmos W=0.155u L=0.04u
M12302 U4882/net10 n4534 VSS VSS nmos W=0.155u L=0.04u
M12303 U4882/net4 U4882/net10 U4882/net14 VDD pmos W=0.255u L=0.04u
M12304 U4882/net6 n4534 U4882/net14 VDD pmos W=0.28u L=0.04u
M12305 U4882/net4 n4535 VDD VDD pmos W=0.205u L=0.04u
M12306 U4882/net6 U4882/net4 VDD VDD pmos W=0.24u L=0.04u
M12307 n4533 U4882/net14 VDD VDD pmos W=0.205u L=0.04u
M12308 U4882/net10 n4534 VDD VDD pmos W=0.205u L=0.04u
M12309 n4534 n4538 VSS VSS nmos W=0.155u L=0.04u
M12310 n4534 n4537 VSS VSS nmos W=0.155u L=0.04u
M12311 n4534 n4536 VSS VSS nmos W=0.155u L=0.04u
M12312 U4883/net25 n4538 VDD VDD pmos W=0.41u L=0.04u
M12313 U4883/net28 n4537 U4883/net25 VDD pmos W=0.41u L=0.04u
M12314 n4534 n4536 U4883/net28 VDD pmos W=0.41u L=0.04u
M12315 n3241 n4530 U4884/net10 VSS nmos W=0.155u L=0.04u
M12316 U4884/net10 n4540 VSS VSS nmos W=0.155u L=0.04u
M12317 n3241 n4539 U4884/net10 VSS nmos W=0.155u L=0.04u
M12318 U4884/net10 g2522 VSS VSS nmos W=0.155u L=0.04u
M12319 U4884/net30 n4540 VDD VDD pmos W=0.205u L=0.04u
M12320 n3241 n4530 U4884/net24 VDD pmos W=0.205u L=0.04u
M12321 U4884/net24 n4539 VDD VDD pmos W=0.205u L=0.04u
M12322 n3241 g2522 U4884/net30 VDD pmos W=0.205u L=0.04u
M12323 n4540 n4530 VSS VSS nmos W=0.155u L=0.04u
M12324 n4540 n4541 VSS VSS nmos W=0.155u L=0.04u
M12325 U4885/XI1-net8 n4541 VDD VDD pmos W=0.205u L=0.04u
M12326 n4540 n4530 U4885/XI1-net8 VDD pmos W=0.205u L=0.04u
M12327 n3240 n4330 U4886/net10 VSS nmos W=0.155u L=0.04u
M12328 U4886/net10 n4542 VSS VSS nmos W=0.155u L=0.04u
M12329 n3240 n4539 U4886/net10 VSS nmos W=0.155u L=0.04u
M12330 U4886/net10 g2524 VSS VSS nmos W=0.155u L=0.04u
M12331 U4886/net30 n4542 VDD VDD pmos W=0.205u L=0.04u
M12332 n3240 n4330 U4886/net24 VDD pmos W=0.205u L=0.04u
M12333 U4886/net24 n4539 VDD VDD pmos W=0.205u L=0.04u
M12334 n3240 g2524 U4886/net30 VDD pmos W=0.205u L=0.04u
M12335 n4542 n4330 VSS VSS nmos W=0.155u L=0.04u
M12336 n4542 n4541 VSS VSS nmos W=0.155u L=0.04u
M12337 U4887/XI1-net8 n4541 VDD VDD pmos W=0.205u L=0.04u
M12338 n4542 n4330 U4887/XI1-net8 VDD pmos W=0.205u L=0.04u
M12339 n3239 n4529 U4888/net10 VSS nmos W=0.155u L=0.04u
M12340 U4888/net10 n4543 VSS VSS nmos W=0.155u L=0.04u
M12341 n3239 n4539 U4888/net10 VSS nmos W=0.155u L=0.04u
M12342 U4888/net10 g2523 VSS VSS nmos W=0.155u L=0.04u
M12343 U4888/net30 n4543 VDD VDD pmos W=0.205u L=0.04u
M12344 n3239 n4529 U4888/net24 VDD pmos W=0.205u L=0.04u
M12345 U4888/net24 n4539 VDD VDD pmos W=0.205u L=0.04u
M12346 n3239 g2523 U4888/net30 VDD pmos W=0.205u L=0.04u
M12347 n4543 n4529 VSS VSS nmos W=0.155u L=0.04u
M12348 n4543 n4541 VSS VSS nmos W=0.155u L=0.04u
M12349 U4889/XI1-net8 n4541 VDD VDD pmos W=0.205u L=0.04u
M12350 n4543 n4529 U4889/XI1-net8 VDD pmos W=0.205u L=0.04u
M12351 U4890/net36 g2384 U4890/net24 VSS nmos W=0.155u L=0.04u
M12352 U4890/net24 n4544 VSS VSS nmos W=0.155u L=0.04u
M12353 n4541 n4531 U4890/net36 VSS nmos W=0.155u L=0.04u
M12354 n4541 n4532 U4890/net36 VSS nmos W=0.155u L=0.04u
M12355 n4541 n4532 U4890/net35 VDD pmos W=0.205u L=0.04u
M12356 U4890/net35 n4531 VDD VDD pmos W=0.205u L=0.04u
M12357 n4541 n4544 VDD VDD pmos W=0.205u L=0.04u
M12358 n4541 g2384 VDD VDD pmos W=0.205u L=0.04u
M12359 U4891/net19 n3958 VSS VSS nmos W=0.155u L=0.04u
M12360 n4544 n3958 U4891/net40 VSS nmos W=0.155u L=0.04u
M12361 n4544 U4891/net19 U4891/net36 VSS nmos W=0.155u L=0.04u
M12362 U4891/net40 n4531 VSS VSS nmos W=0.31u L=0.04u
M12363 U4891/net36 n4532 VSS VSS nmos W=0.155u L=0.04u
M12364 U4891/net19 n3958 VDD VDD pmos W=0.205u L=0.04u
M12365 n4544 U4891/net19 U4891/net26 VDD pmos W=0.325u L=0.04u
M12366 U4891/net26 n4531 VDD VDD pmos W=0.41u L=0.04u
M12367 n4544 n3958 U4891/net30 VDD pmos W=0.325u L=0.04u
M12368 U4891/net30 n4532 VDD VDD pmos W=0.205u L=0.04u
M12369 n3958 n4535 VSS VSS nmos W=0.135u L=0.04u
M12370 n3958 n4535 VDD VDD pmos W=0.205u L=0.04u
M12371 U4893/net30 n4536 VSS VSS nmos W=0.155u L=0.04u
M12372 n4539 n4537 U4893/net23 VSS nmos W=0.155u L=0.04u
M12373 U4893/net20 U4893/net30 VSS VSS nmos W=0.155u L=0.04u
M12374 U4893/net23 g2384 U4893/net20 VSS nmos W=0.155u L=0.04u
M12375 U4893/net30 n4536 VDD VDD pmos W=0.205u L=0.04u
M12376 VDD n4537 n4539 VDD pmos W=0.205u L=0.04u
M12377 VDD g2384 n4539 VDD pmos W=0.205u L=0.04u
M12378 VDD U4893/net30 n4539 VDD pmos W=0.205u L=0.04u
M12379 U4894/net36 n4529 U4894/net27 VSS nmos W=0.155u L=0.04u
M12380 U4894/net39 n4330 VSS VSS nmos W=0.155u L=0.04u
M12381 U4894/net27 g2522 U4894/net39 VSS nmos W=0.155u L=0.04u
M12382 U4894/net27 n4530 U4894/net39 VSS nmos W=0.155u L=0.04u
M12383 U4894/net36 g2523 U4894/net27 VSS nmos W=0.155u L=0.04u
M12384 U4894/net39 g2524 VSS VSS nmos W=0.155u L=0.04u
M12385 n4537 U4894/net36 VSS VSS nmos W=0.155u L=0.04u
M12386 n4537 U4894/net36 VDD VDD pmos W=0.205u L=0.04u
M12387 U4894/net36 n4330 U4894/net46 VDD pmos W=0.205u L=0.04u
M12388 U4894/net46 g2524 VDD VDD pmos W=0.205u L=0.04u
M12389 U4894/net36 g2523 U4894/net34 VDD pmos W=0.205u L=0.04u
M12390 U4894/net34 n4529 VDD VDD pmos W=0.205u L=0.04u
M12391 U4894/net36 n4530 U4894/net37 VDD pmos W=0.205u L=0.04u
M12392 U4894/net37 g2522 VDD VDD pmos W=0.205u L=0.04u
M12393 n4536 n4535 U4895/net15 VSS nmos W=0.155u L=0.04u
M12394 n4536 n4531 U4895/net15 VSS nmos W=0.155u L=0.04u
M12395 U4895/net15 n4545 VSS VSS nmos W=0.155u L=0.04u
M12396 n4536 n4545 VDD VDD pmos W=0.205u L=0.04u
M12397 n4536 n4535 U4895/XI16-net11 VDD pmos W=0.205u L=0.04u
M12398 U4895/XI16-net11 n4531 VDD VDD pmos W=0.205u L=0.04u
M12399 U4896/net19 n4532 VSS VSS nmos W=0.155u L=0.04u
M12400 n4545 n4532 U4896/net40 VSS nmos W=0.155u L=0.04u
M12401 n4545 U4896/net19 U4896/net36 VSS nmos W=0.155u L=0.04u
M12402 U4896/net40 n4535 VSS VSS nmos W=0.31u L=0.04u
M12403 U4896/net36 n4531 VSS VSS nmos W=0.155u L=0.04u
M12404 U4896/net19 n4532 VDD VDD pmos W=0.205u L=0.04u
M12405 n4545 U4896/net19 U4896/net26 VDD pmos W=0.325u L=0.04u
M12406 U4896/net26 n4535 VDD VDD pmos W=0.41u L=0.04u
M12407 n4545 n4532 U4896/net30 VDD pmos W=0.325u L=0.04u
M12408 U4896/net30 n4531 VDD VDD pmos W=0.205u L=0.04u
M12409 U4897/net13 n4546 VSS VSS nmos W=0.155u L=0.04u
M12410 U4897/net16 U4897/net13 VSS VSS nmos W=0.155u L=0.04u
M12411 n4532 n4547 U4897/net16 VSS nmos W=0.155u L=0.04u
M12412 U4897/net13 n4546 VDD VDD pmos W=0.205u L=0.04u
M12413 VDD U4897/net13 n4532 VDD pmos W=0.205u L=0.04u
M12414 VDD n4547 n4532 VDD pmos W=0.205u L=0.04u
M12415 n4547 n4548 U4898/net27 VSS nmos W=0.155u L=0.04u
M12416 U4898/net39 n4550 VSS VSS nmos W=0.155u L=0.04u
M12417 U4898/net27 g2253 U4898/net39 VSS nmos W=0.155u L=0.04u
M12418 U4898/net27 n4549 U4898/net39 VSS nmos W=0.155u L=0.04u
M12419 n4547 g2254 U4898/net27 VSS nmos W=0.155u L=0.04u
M12420 U4898/net39 g2255 VSS VSS nmos W=0.155u L=0.04u
M12421 n4547 n4550 U4898/net46 VDD pmos W=0.205u L=0.04u
M12422 U4898/net46 g2255 VDD VDD pmos W=0.205u L=0.04u
M12423 n4547 g2254 U4898/net34 VDD pmos W=0.205u L=0.04u
M12424 U4898/net34 n4548 VDD VDD pmos W=0.205u L=0.04u
M12425 n4547 n4549 U4898/net37 VDD pmos W=0.205u L=0.04u
M12426 U4898/net37 g2253 VDD VDD pmos W=0.205u L=0.04u
M12427 n4531 g2476 U4899/XI21-net17 VSS nmos W=0.155u L=0.04u
M12428 U4899/XI21-net17 g2510 VSS VSS nmos W=0.155u L=0.04u
M12429 n4531 g5555 U4899/XI6-net17 VSS nmos W=0.155u L=0.04u
M12430 U4899/XI6-net17 g2504 VSS VSS nmos W=0.155u L=0.04u
M12431 n4531 g7264 U4899/XI20-net17 VSS nmos W=0.155u L=0.04u
M12432 U4899/XI20-net17 g2507 VSS VSS nmos W=0.155u L=0.04u
M12433 VDD g2476 U4899/net22 VDD pmos W=0.205u L=0.04u
M12434 VDD g2510 U4899/net22 VDD pmos W=0.205u L=0.04u
M12435 U4899/net16 g5555 n4531 VDD pmos W=0.205u L=0.04u
M12436 U4899/net16 g2504 n4531 VDD pmos W=0.205u L=0.04u
M12437 U4899/net22 g7264 U4899/net16 VDD pmos W=0.205u L=0.04u
M12438 U4899/net22 g2507 U4899/net16 VDD pmos W=0.205u L=0.04u
M12439 n4535 g2476 U4900/XI21-net17 VSS nmos W=0.155u L=0.04u
M12440 U4900/XI21-net17 g2519 VSS VSS nmos W=0.155u L=0.04u
M12441 n4535 g5555 U4900/XI6-net17 VSS nmos W=0.155u L=0.04u
M12442 U4900/XI6-net17 g2513 VSS VSS nmos W=0.155u L=0.04u
M12443 n4535 g7264 U4900/XI20-net17 VSS nmos W=0.155u L=0.04u
M12444 U4900/XI20-net17 g2516 VSS VSS nmos W=0.155u L=0.04u
M12445 VDD g2476 U4900/net22 VDD pmos W=0.205u L=0.04u
M12446 VDD g2519 U4900/net22 VDD pmos W=0.205u L=0.04u
M12447 U4900/net16 g5555 n4535 VDD pmos W=0.205u L=0.04u
M12448 U4900/net16 g2513 n4535 VDD pmos W=0.205u L=0.04u
M12449 U4900/net22 g7264 U4900/net16 VDD pmos W=0.205u L=0.04u
M12450 U4900/net22 g2516 U4900/net16 VDD pmos W=0.205u L=0.04u
M12451 U4901/net19 n4529 VSS VSS nmos W=0.155u L=0.04u
M12452 n3238 n4529 U4901/net40 VSS nmos W=0.155u L=0.04u
M12453 n3238 U4901/net19 U4901/net36 VSS nmos W=0.155u L=0.04u
M12454 U4901/net40 g2492 VSS VSS nmos W=0.31u L=0.04u
M12455 U4901/net36 n4551 VSS VSS nmos W=0.155u L=0.04u
M12456 U4901/net19 n4529 VDD VDD pmos W=0.205u L=0.04u
M12457 n3238 U4901/net19 U4901/net26 VDD pmos W=0.325u L=0.04u
M12458 U4901/net26 g2492 VDD VDD pmos W=0.41u L=0.04u
M12459 n3238 n4529 U4901/net30 VDD pmos W=0.325u L=0.04u
M12460 U4901/net30 n4551 VDD VDD pmos W=0.205u L=0.04u
M12461 U4902/net19 n4330 VSS VSS nmos W=0.155u L=0.04u
M12462 n3237 n4330 U4902/net40 VSS nmos W=0.155u L=0.04u
M12463 n3237 U4902/net19 U4902/net36 VSS nmos W=0.155u L=0.04u
M12464 U4902/net40 g2495 VSS VSS nmos W=0.31u L=0.04u
M12465 U4902/net36 n4551 VSS VSS nmos W=0.155u L=0.04u
M12466 U4902/net19 n4330 VDD VDD pmos W=0.205u L=0.04u
M12467 n3237 U4902/net19 U4902/net26 VDD pmos W=0.325u L=0.04u
M12468 U4902/net26 g2495 VDD VDD pmos W=0.41u L=0.04u
M12469 n3237 n4330 U4902/net30 VDD pmos W=0.325u L=0.04u
M12470 U4902/net30 n4551 VDD VDD pmos W=0.205u L=0.04u
M12471 U4903/net19 n4530 VSS VSS nmos W=0.155u L=0.04u
M12472 n3236 n4530 U4903/net40 VSS nmos W=0.155u L=0.04u
M12473 n3236 U4903/net19 U4903/net36 VSS nmos W=0.155u L=0.04u
M12474 U4903/net40 g2498 VSS VSS nmos W=0.31u L=0.04u
M12475 U4903/net36 n4551 VSS VSS nmos W=0.155u L=0.04u
M12476 U4903/net19 n4530 VDD VDD pmos W=0.205u L=0.04u
M12477 n3236 U4903/net19 U4903/net26 VDD pmos W=0.325u L=0.04u
M12478 U4903/net26 g2498 VDD VDD pmos W=0.41u L=0.04u
M12479 n3236 n4530 U4903/net30 VDD pmos W=0.325u L=0.04u
M12480 U4903/net30 n4551 VDD VDD pmos W=0.205u L=0.04u
M12481 U4904/net4 g12005 U4904/net14 VSS nmos W=0.155u L=0.04u
M12482 U4904/net6 U4904/net10 U4904/net14 VSS nmos W=0.17u L=0.04u
M12483 U4904/net4 n4552 VSS VSS nmos W=0.155u L=0.04u
M12484 U4904/net6 U4904/net4 VSS VSS nmos W=0.17u L=0.04u
M12485 n4551 U4904/net14 VSS VSS nmos W=0.155u L=0.04u
M12486 U4904/net10 g12005 VSS VSS nmos W=0.155u L=0.04u
M12487 U4904/net4 U4904/net10 U4904/net14 VDD pmos W=0.255u L=0.04u
M12488 U4904/net6 g12005 U4904/net14 VDD pmos W=0.28u L=0.04u
M12489 U4904/net4 n4552 VDD VDD pmos W=0.205u L=0.04u
M12490 U4904/net6 U4904/net4 VDD VDD pmos W=0.24u L=0.04u
M12491 n4551 U4904/net14 VDD VDD pmos W=0.205u L=0.04u
M12492 U4904/net10 g12005 VDD VDD pmos W=0.205u L=0.04u
M12493 n4552 n4553 U4905/net14 VSS nmos W=0.155u L=0.04u
M12494 U4905/net14 n4557 VSS VSS nmos W=0.155u L=0.04u
M12495 U4905/net14 n4556 VSS VSS nmos W=0.155u L=0.04u
M12496 n4552 n4555 U4905/net14 VSS nmos W=0.155u L=0.04u
M12497 n4552 n4554 U4905/net14 VSS nmos W=0.155u L=0.04u
M12498 n4552 n4557 U4905/XI16-net11 VDD pmos W=0.205u L=0.04u
M12499 U4905/XI16-net11 n4556 VDD VDD pmos W=0.205u L=0.04u
M12500 n4552 n4555 U4905/XI15-net11 VDD pmos W=0.205u L=0.04u
M12501 U4905/XI15-net11 n4554 U4905/XI15-net18 VDD pmos W=0.205u L=0.04u
M12502 U4905/XI15-net18 n4553 VDD VDD pmos W=0.205u L=0.04u
M12503 n4556 n4558 U4906/net23 VDD pmos W=0.205u L=0.04u
M12504 n4556 g12005 U4906/net23 VDD pmos W=0.205u L=0.04u
M12505 n4556 n4559 U4906/net23 VDD pmos W=0.205u L=0.04u
M12506 U4906/net23 n4560 VDD VDD pmos W=0.205u L=0.04u
M12507 U4906/net23 n4561 VDD VDD pmos W=0.205u L=0.04u
M12508 U4906/XI20-net13 g12005 VSS VSS nmos W=0.155u L=0.04u
M12509 n4556 n4558 U4906/XI20-net17 VSS nmos W=0.155u L=0.04u
M12510 U4906/XI20-net17 n4559 U4906/XI20-net13 VSS nmos W=0.155u L=0.04u
M12511 n4556 n4560 U4906/XI17-net17 VSS nmos W=0.155u L=0.04u
M12512 U4906/XI17-net17 n4561 VSS VSS nmos W=0.155u L=0.04u
M12513 n4559 U4907/net7 VSS VSS nmos W=0.155u L=0.04u
M12514 U4907/net7 n4561 VSS VSS nmos W=0.155u L=0.04u
M12515 U4907/net7 n4562 VSS VSS nmos W=0.155u L=0.04u
M12516 n4559 U4907/net7 VDD VDD pmos W=0.205u L=0.04u
M12517 U4907/X_u7-net8 n4562 VDD VDD pmos W=0.205u L=0.04u
M12518 U4907/net7 n4561 U4907/X_u7-net8 VDD pmos W=0.205u L=0.04u
M12519 n4555 g12005 VSS VSS nmos W=0.135u L=0.04u
M12520 n4555 g12005 VDD VDD pmos W=0.205u L=0.04u
M12521 U4909/XU1-net6 n4563 VSS VSS nmos W=0.155u L=0.04u
M12522 n4553 n4558 U4909/XU1-net6 VSS nmos W=0.155u L=0.04u
M12523 n4553 n4563 VDD VDD pmos W=0.155u L=0.04u
M12524 n4553 n4558 VDD VDD pmos W=0.155u L=0.04u
M12525 n3235 n4529 U4910/net10 VSS nmos W=0.155u L=0.04u
M12526 U4910/net10 n4565 VSS VSS nmos W=0.155u L=0.04u
M12527 n3235 n4564 U4910/net10 VSS nmos W=0.155u L=0.04u
M12528 U4910/net10 g2502 VSS VSS nmos W=0.155u L=0.04u
M12529 U4910/net30 n4565 VDD VDD pmos W=0.205u L=0.04u
M12530 n3235 n4529 U4910/net24 VDD pmos W=0.205u L=0.04u
M12531 U4910/net24 n4564 VDD VDD pmos W=0.205u L=0.04u
M12532 n3235 g2502 U4910/net30 VDD pmos W=0.205u L=0.04u
M12533 n4565 n4529 VSS VSS nmos W=0.155u L=0.04u
M12534 n4565 n4566 VSS VSS nmos W=0.155u L=0.04u
M12535 U4911/XI1-net8 n4566 VDD VDD pmos W=0.205u L=0.04u
M12536 n4565 n4529 U4911/XI1-net8 VDD pmos W=0.205u L=0.04u
M12537 n3234 n4330 U4912/net10 VSS nmos W=0.155u L=0.04u
M12538 U4912/net10 n4567 VSS VSS nmos W=0.155u L=0.04u
M12539 n3234 n4564 U4912/net10 VSS nmos W=0.155u L=0.04u
M12540 U4912/net10 g2503 VSS VSS nmos W=0.155u L=0.04u
M12541 U4912/net30 n4567 VDD VDD pmos W=0.205u L=0.04u
M12542 n3234 n4330 U4912/net24 VDD pmos W=0.205u L=0.04u
M12543 U4912/net24 n4564 VDD VDD pmos W=0.205u L=0.04u
M12544 n3234 g2503 U4912/net30 VDD pmos W=0.205u L=0.04u
M12545 n4567 n4330 VSS VSS nmos W=0.155u L=0.04u
M12546 n4567 n4566 VSS VSS nmos W=0.155u L=0.04u
M12547 U4913/XI1-net8 n4566 VDD VDD pmos W=0.205u L=0.04u
M12548 n4567 n4330 U4913/XI1-net8 VDD pmos W=0.205u L=0.04u
M12549 n3233 n4530 U4914/net10 VSS nmos W=0.155u L=0.04u
M12550 U4914/net10 n4568 VSS VSS nmos W=0.155u L=0.04u
M12551 n3233 n4564 U4914/net10 VSS nmos W=0.155u L=0.04u
M12552 U4914/net10 g2501 VSS VSS nmos W=0.155u L=0.04u
M12553 U4914/net30 n4568 VDD VDD pmos W=0.205u L=0.04u
M12554 n3233 n4530 U4914/net24 VDD pmos W=0.205u L=0.04u
M12555 U4914/net24 n4564 VDD VDD pmos W=0.205u L=0.04u
M12556 n3233 g2501 U4914/net30 VDD pmos W=0.205u L=0.04u
M12557 n4568 n4530 VSS VSS nmos W=0.155u L=0.04u
M12558 n4568 n4566 VSS VSS nmos W=0.155u L=0.04u
M12559 U4915/XI1-net8 n4566 VDD VDD pmos W=0.205u L=0.04u
M12560 n4568 n4530 U4915/XI1-net8 VDD pmos W=0.205u L=0.04u
M12561 U4916/net13 n4557 VSS VSS nmos W=0.155u L=0.04u
M12562 U4916/net16 U4916/net13 VSS VSS nmos W=0.155u L=0.04u
M12563 n4564 n4569 U4916/net16 VSS nmos W=0.155u L=0.04u
M12564 U4916/net13 n4557 VDD VDD pmos W=0.205u L=0.04u
M12565 VDD U4916/net13 n4564 VDD pmos W=0.205u L=0.04u
M12566 VDD n4569 n4564 VDD pmos W=0.205u L=0.04u
M12567 U4917/net19 n4529 VSS VSS nmos W=0.155u L=0.04u
M12568 n3232 n4529 U4917/net40 VSS nmos W=0.155u L=0.04u
M12569 n3232 U4917/net19 U4917/net36 VSS nmos W=0.155u L=0.04u
M12570 U4917/net40 g2483 VSS VSS nmos W=0.31u L=0.04u
M12571 U4917/net36 n4570 VSS VSS nmos W=0.155u L=0.04u
M12572 U4917/net19 n4529 VDD VDD pmos W=0.205u L=0.04u
M12573 n3232 U4917/net19 U4917/net26 VDD pmos W=0.325u L=0.04u
M12574 U4917/net26 g2483 VDD VDD pmos W=0.41u L=0.04u
M12575 n3232 n4529 U4917/net30 VDD pmos W=0.325u L=0.04u
M12576 U4917/net30 n4570 VDD VDD pmos W=0.205u L=0.04u
M12577 U4918/net19 n4330 VSS VSS nmos W=0.155u L=0.04u
M12578 n3231 n4330 U4918/net40 VSS nmos W=0.155u L=0.04u
M12579 n3231 U4918/net19 U4918/net36 VSS nmos W=0.155u L=0.04u
M12580 U4918/net40 g2486 VSS VSS nmos W=0.31u L=0.04u
M12581 U4918/net36 n4570 VSS VSS nmos W=0.155u L=0.04u
M12582 U4918/net19 n4330 VDD VDD pmos W=0.205u L=0.04u
M12583 n3231 U4918/net19 U4918/net26 VDD pmos W=0.325u L=0.04u
M12584 U4918/net26 g2486 VDD VDD pmos W=0.41u L=0.04u
M12585 n3231 n4330 U4918/net30 VDD pmos W=0.325u L=0.04u
M12586 U4918/net30 n4570 VDD VDD pmos W=0.205u L=0.04u
M12587 U4919/net19 n4530 VSS VSS nmos W=0.155u L=0.04u
M12588 n3230 n4530 U4919/net40 VSS nmos W=0.155u L=0.04u
M12589 n3230 U4919/net19 U4919/net36 VSS nmos W=0.155u L=0.04u
M12590 U4919/net40 g2489 VSS VSS nmos W=0.31u L=0.04u
M12591 U4919/net36 n4570 VSS VSS nmos W=0.155u L=0.04u
M12592 U4919/net19 n4530 VDD VDD pmos W=0.205u L=0.04u
M12593 n3230 U4919/net19 U4919/net26 VDD pmos W=0.325u L=0.04u
M12594 U4919/net26 g2489 VDD VDD pmos W=0.41u L=0.04u
M12595 n3230 n4530 U4919/net30 VDD pmos W=0.325u L=0.04u
M12596 U4919/net30 n4570 VDD VDD pmos W=0.205u L=0.04u
M12597 U4920/net4 n4571 U4920/net14 VSS nmos W=0.155u L=0.04u
M12598 U4920/net6 U4920/net10 U4920/net14 VSS nmos W=0.17u L=0.04u
M12599 U4920/net4 n4572 VSS VSS nmos W=0.155u L=0.04u
M12600 U4920/net6 U4920/net4 VSS VSS nmos W=0.17u L=0.04u
M12601 n4570 U4920/net14 VSS VSS nmos W=0.155u L=0.04u
M12602 U4920/net10 n4571 VSS VSS nmos W=0.155u L=0.04u
M12603 U4920/net4 U4920/net10 U4920/net14 VDD pmos W=0.255u L=0.04u
M12604 U4920/net6 n4571 U4920/net14 VDD pmos W=0.28u L=0.04u
M12605 U4920/net4 n4572 VDD VDD pmos W=0.205u L=0.04u
M12606 U4920/net6 U4920/net4 VDD VDD pmos W=0.24u L=0.04u
M12607 n4570 U4920/net14 VDD VDD pmos W=0.205u L=0.04u
M12608 U4920/net10 n4571 VDD VDD pmos W=0.205u L=0.04u
M12609 U4921/net14 n4569 U4921/net20 VSS nmos W=0.155u L=0.04u
M12610 U4921/net14 n4557 U4921/net20 VSS nmos W=0.155u L=0.04u
M12611 U4921/net20 n4566 VSS VSS nmos W=0.155u L=0.04u
M12612 n4571 U4921/net14 VSS VSS nmos W=0.155u L=0.04u
M12613 n4571 U4921/net14 VDD VDD pmos W=0.205u L=0.04u
M12614 U4921/net14 n4566 VDD VDD pmos W=0.205u L=0.04u
M12615 U4921/net24 n4569 VDD VDD pmos W=0.205u L=0.04u
M12616 U4921/net14 n4557 U4921/net24 VDD pmos W=0.205u L=0.04u
M12617 U4922/XU1-net6 n4573 VSS VSS nmos W=0.155u L=0.04u
M12618 n4566 n4563 U4922/XU1-net6 VSS nmos W=0.155u L=0.04u
M12619 n4566 n4573 VDD VDD pmos W=0.155u L=0.04u
M12620 n4566 n4563 VDD VDD pmos W=0.155u L=0.04u
M12621 n4563 n4572 VSS VSS nmos W=0.155u L=0.04u
M12622 n4563 n4538 VSS VSS nmos W=0.155u L=0.04u
M12623 U4923/XI1-net8 n4538 VDD VDD pmos W=0.205u L=0.04u
M12624 n4563 n4572 U4923/XI1-net8 VDD pmos W=0.205u L=0.04u
M12625 n4569 n4561 VSS VSS nmos W=0.155u L=0.04u
M12626 n4569 U4924/net4 VSS VSS nmos W=0.155u L=0.04u
M12627 U4924/net4 n4573 VSS VSS nmos W=0.155u L=0.04u
M12628 U4924/XU1-net8 U4924/net4 VDD VDD pmos W=0.205u L=0.04u
M12629 n4569 n4561 U4924/XU1-net8 VDD pmos W=0.205u L=0.04u
M12630 U4924/net4 n4573 VDD VDD pmos W=0.205u L=0.04u
M12631 n4561 n4529 U4925/net27 VSS nmos W=0.155u L=0.04u
M12632 U4925/net39 n4330 VSS VSS nmos W=0.155u L=0.04u
M12633 U4925/net27 g2501 U4925/net39 VSS nmos W=0.155u L=0.04u
M12634 U4925/net27 n4530 U4925/net39 VSS nmos W=0.155u L=0.04u
M12635 n4561 g2502 U4925/net27 VSS nmos W=0.155u L=0.04u
M12636 U4925/net39 g2503 VSS VSS nmos W=0.155u L=0.04u
M12637 n4561 n4330 U4925/net46 VDD pmos W=0.205u L=0.04u
M12638 U4925/net46 g2503 VDD VDD pmos W=0.205u L=0.04u
M12639 n4561 g2502 U4925/net34 VDD pmos W=0.205u L=0.04u
M12640 U4925/net34 n4529 VDD VDD pmos W=0.205u L=0.04u
M12641 n4561 n4530 U4925/net37 VDD pmos W=0.205u L=0.04u
M12642 U4925/net37 g2501 VDD VDD pmos W=0.205u L=0.04u
M12643 n4573 U4926/net26 VDD VDD pmos W=0.205u L=0.04u
M12644 U4926/net26 g12005 U4926/net19 VDD pmos W=0.205u L=0.04u
M12645 U4926/net26 n4554 U4926/net19 VDD pmos W=0.205u L=0.04u
M12646 U4926/net26 n4558 U4926/net19 VDD pmos W=0.205u L=0.04u
M12647 U4926/net19 n4560 VDD VDD pmos W=0.205u L=0.04u
M12648 U4926/net26 n4560 VSS VSS nmos W=0.155u L=0.04u
M12649 n4573 U4926/net26 VSS VSS nmos W=0.155u L=0.04u
M12650 U4926/XI20-net13 n4558 VSS VSS nmos W=0.155u L=0.04u
M12651 U4926/net26 g12005 U4926/XI20-net17 VSS nmos W=0.155u L=0.04u
M12652 U4926/XI20-net17 n4554 U4926/XI20-net13 VSS nmos W=0.155u L=0.04u
M12653 n4560 n4558 VSS VSS nmos W=0.155u L=0.04u
M12654 n4560 g12005 VSS VSS nmos W=0.155u L=0.04u
M12655 U4927/XI1-net8 g12005 VDD VDD pmos W=0.205u L=0.04u
M12656 n4560 n4558 U4927/XI1-net8 VDD pmos W=0.205u L=0.04u
M12657 n4558 n4546 VSS VSS nmos W=0.155u L=0.04u
M12658 n4558 n3959 VSS VSS nmos W=0.155u L=0.04u
M12659 n4558 n3962 VSS VSS nmos W=0.155u L=0.04u
M12660 U4928/net25 n4546 VDD VDD pmos W=0.41u L=0.04u
M12661 U4928/net28 n3959 U4928/net25 VDD pmos W=0.41u L=0.04u
M12662 n4558 n3962 U4928/net28 VDD pmos W=0.41u L=0.04u
M12663 n3959 n4574 VSS VSS nmos W=0.135u L=0.04u
M12664 n3959 n4574 VDD VDD pmos W=0.205u L=0.04u
M12665 U4930/XU1-net6 n4572 VSS VSS nmos W=0.155u L=0.04u
M12666 n4557 g2384 U4930/XU1-net6 VSS nmos W=0.155u L=0.04u
M12667 n4557 n4572 VDD VDD pmos W=0.155u L=0.04u
M12668 n4557 g2384 VDD VDD pmos W=0.155u L=0.04u
M12669 n4572 U4931/net39 VDD VDD pmos W=0.205u L=0.04u
M12670 VDD g2476 U4931/net22 VDD pmos W=0.205u L=0.04u
M12671 VDD g2489 U4931/net22 VDD pmos W=0.205u L=0.04u
M12672 U4931/net16 g5555 U4931/net39 VDD pmos W=0.205u L=0.04u
M12673 U4931/net16 g2483 U4931/net39 VDD pmos W=0.205u L=0.04u
M12674 U4931/net22 g7264 U4931/net16 VDD pmos W=0.205u L=0.04u
M12675 U4931/net22 g2486 U4931/net16 VDD pmos W=0.205u L=0.04u
M12676 n4572 U4931/net39 VSS VSS nmos W=0.155u L=0.04u
M12677 U4931/net39 g2476 U4931/XI22-net17 VSS nmos W=0.155u L=0.04u
M12678 U4931/XI22-net17 g2489 VSS VSS nmos W=0.155u L=0.04u
M12679 U4931/net39 g5555 U4931/XI6-net17 VSS nmos W=0.155u L=0.04u
M12680 U4931/XI6-net17 g2483 VSS VSS nmos W=0.155u L=0.04u
M12681 U4931/net39 g7264 U4931/XI21-net17 VSS nmos W=0.155u L=0.04u
M12682 U4931/XI21-net17 g2486 VSS VSS nmos W=0.155u L=0.04u
M12683 U4932/net19 n3963 VSS VSS nmos W=0.155u L=0.04u
M12684 n3229 n3963 U4932/net40 VSS nmos W=0.155u L=0.04u
M12685 n3229 U4932/net19 U4932/net36 VSS nmos W=0.155u L=0.04u
M12686 U4932/net40 n4575 VSS VSS nmos W=0.31u L=0.04u
M12687 U4932/net36 g2233 VSS VSS nmos W=0.155u L=0.04u
M12688 U4932/net19 n3963 VDD VDD pmos W=0.205u L=0.04u
M12689 n3229 U4932/net19 U4932/net26 VDD pmos W=0.325u L=0.04u
M12690 U4932/net26 n4575 VDD VDD pmos W=0.41u L=0.04u
M12691 n3229 n3963 U4932/net30 VDD pmos W=0.325u L=0.04u
M12692 U4932/net30 g2233 VDD VDD pmos W=0.205u L=0.04u
M12693 n3963 U4933/net6 VSS VSS nmos W=0.155u L=0.04u
M12694 U4933/X_u2-net6 g6837 VSS VSS nmos W=0.155u L=0.04u
M12695 U4933/net6 g2257 U4933/X_u2-net6 VSS nmos W=0.155u L=0.04u
M12696 n3963 U4933/net6 VDD VDD pmos W=0.205u L=0.04u
M12697 U4933/net6 g6837 VDD VDD pmos W=0.205u L=0.04u
M12698 U4933/net6 g2257 VDD VDD pmos W=0.205u L=0.04u
M12699 U4934/net19 n3960 VSS VSS nmos W=0.155u L=0.04u
M12700 n3228 n3960 U4934/net40 VSS nmos W=0.155u L=0.04u
M12701 n3228 U4934/net19 U4934/net36 VSS nmos W=0.155u L=0.04u
M12702 U4934/net40 n4575 VSS VSS nmos W=0.31u L=0.04u
M12703 U4934/net36 g2234 VSS VSS nmos W=0.155u L=0.04u
M12704 U4934/net19 n3960 VDD VDD pmos W=0.205u L=0.04u
M12705 n3228 U4934/net19 U4934/net26 VDD pmos W=0.325u L=0.04u
M12706 U4934/net26 n4575 VDD VDD pmos W=0.41u L=0.04u
M12707 n3228 n3960 U4934/net30 VDD pmos W=0.325u L=0.04u
M12708 U4934/net30 g2234 VDD VDD pmos W=0.205u L=0.04u
M12709 n3960 U4935/net6 VSS VSS nmos W=0.155u L=0.04u
M12710 U4935/X_u2-net6 g7084 VSS VSS nmos W=0.155u L=0.04u
M12711 U4935/net6 g2257 U4935/X_u2-net6 VSS nmos W=0.155u L=0.04u
M12712 n3960 U4935/net6 VDD VDD pmos W=0.205u L=0.04u
M12713 U4935/net6 g7084 VDD VDD pmos W=0.205u L=0.04u
M12714 U4935/net6 g2257 VDD VDD pmos W=0.205u L=0.04u
M12715 U4936/net19 n3961 VSS VSS nmos W=0.155u L=0.04u
M12716 n3227 n3961 U4936/net40 VSS nmos W=0.155u L=0.04u
M12717 n3227 U4936/net19 U4936/net36 VSS nmos W=0.155u L=0.04u
M12718 U4936/net40 n4575 VSS VSS nmos W=0.31u L=0.04u
M12719 U4936/net36 g2232 VSS VSS nmos W=0.155u L=0.04u
M12720 U4936/net19 n3961 VDD VDD pmos W=0.205u L=0.04u
M12721 n3227 U4936/net19 U4936/net26 VDD pmos W=0.325u L=0.04u
M12722 U4936/net26 n4575 VDD VDD pmos W=0.41u L=0.04u
M12723 n3227 n3961 U4936/net30 VDD pmos W=0.325u L=0.04u
M12724 U4936/net30 g2232 VDD VDD pmos W=0.205u L=0.04u
M12725 n3226 n4529 U4937/net10 VSS nmos W=0.155u L=0.04u
M12726 U4937/net10 n4577 VSS VSS nmos W=0.155u L=0.04u
M12727 n3226 n4576 U4937/net10 VSS nmos W=0.155u L=0.04u
M12728 U4937/net10 g2478 VSS VSS nmos W=0.155u L=0.04u
M12729 U4937/net30 n4577 VDD VDD pmos W=0.205u L=0.04u
M12730 n3226 n4529 U4937/net24 VDD pmos W=0.205u L=0.04u
M12731 U4937/net24 n4576 VDD VDD pmos W=0.205u L=0.04u
M12732 n3226 g2478 U4937/net30 VDD pmos W=0.205u L=0.04u
M12733 n4577 n4529 VSS VSS nmos W=0.155u L=0.04u
M12734 n4577 n4538 VSS VSS nmos W=0.155u L=0.04u
M12735 U4938/XI1-net8 n4538 VDD VDD pmos W=0.205u L=0.04u
M12736 n4577 n4529 U4938/XI1-net8 VDD pmos W=0.205u L=0.04u
M12737 n3225 n4330 U4939/net10 VSS nmos W=0.155u L=0.04u
M12738 U4939/net10 n4578 VSS VSS nmos W=0.155u L=0.04u
M12739 n3225 n4576 U4939/net10 VSS nmos W=0.155u L=0.04u
M12740 U4939/net10 g2479 VSS VSS nmos W=0.155u L=0.04u
M12741 U4939/net30 n4578 VDD VDD pmos W=0.205u L=0.04u
M12742 n3225 n4330 U4939/net24 VDD pmos W=0.205u L=0.04u
M12743 U4939/net24 n4576 VDD VDD pmos W=0.205u L=0.04u
M12744 n3225 g2479 U4939/net30 VDD pmos W=0.205u L=0.04u
M12745 n4578 n4330 VSS VSS nmos W=0.155u L=0.04u
M12746 n4578 n4538 VSS VSS nmos W=0.155u L=0.04u
M12747 U4940/XI1-net8 n4538 VDD VDD pmos W=0.205u L=0.04u
M12748 n4578 n4330 U4940/XI1-net8 VDD pmos W=0.205u L=0.04u
M12749 n3224 n4530 U4941/net10 VSS nmos W=0.155u L=0.04u
M12750 U4941/net10 n4579 VSS VSS nmos W=0.155u L=0.04u
M12751 n3224 n4576 U4941/net10 VSS nmos W=0.155u L=0.04u
M12752 U4941/net10 g2477 VSS VSS nmos W=0.155u L=0.04u
M12753 U4941/net30 n4579 VDD VDD pmos W=0.205u L=0.04u
M12754 n3224 n4530 U4941/net24 VDD pmos W=0.205u L=0.04u
M12755 U4941/net24 n4576 VDD VDD pmos W=0.205u L=0.04u
M12756 n3224 g2477 U4941/net30 VDD pmos W=0.205u L=0.04u
M12757 n4579 n4530 VSS VSS nmos W=0.155u L=0.04u
M12758 n4579 n4538 VSS VSS nmos W=0.155u L=0.04u
M12759 U4942/XI1-net8 n4538 VDD VDD pmos W=0.205u L=0.04u
M12760 n4579 n4530 U4942/XI1-net8 VDD pmos W=0.205u L=0.04u
M12761 U4943/net30 n4580 VSS VSS nmos W=0.155u L=0.04u
M12762 n4576 n4581 U4943/net23 VSS nmos W=0.155u L=0.04u
M12763 U4943/net20 U4943/net30 VSS VSS nmos W=0.155u L=0.04u
M12764 U4943/net23 g2384 U4943/net20 VSS nmos W=0.155u L=0.04u
M12765 U4943/net30 n4580 VDD VDD pmos W=0.205u L=0.04u
M12766 VDD n4581 n4576 VDD pmos W=0.205u L=0.04u
M12767 VDD g2384 n4576 VDD pmos W=0.205u L=0.04u
M12768 VDD U4943/net30 n4576 VDD pmos W=0.205u L=0.04u
M12769 U4944/net19 n4529 VSS VSS nmos W=0.155u L=0.04u
M12770 n3223 n4529 U4944/net40 VSS nmos W=0.155u L=0.04u
M12771 n3223 U4944/net19 U4944/net36 VSS nmos W=0.155u L=0.04u
M12772 U4944/net40 g2387 VSS VSS nmos W=0.31u L=0.04u
M12773 U4944/net36 n4582 VSS VSS nmos W=0.155u L=0.04u
M12774 U4944/net19 n4529 VDD VDD pmos W=0.205u L=0.04u
M12775 n3223 U4944/net19 U4944/net26 VDD pmos W=0.325u L=0.04u
M12776 U4944/net26 g2387 VDD VDD pmos W=0.41u L=0.04u
M12777 n3223 n4529 U4944/net30 VDD pmos W=0.325u L=0.04u
M12778 U4944/net30 n4582 VDD VDD pmos W=0.205u L=0.04u
M12779 U4945/net19 n4330 VSS VSS nmos W=0.155u L=0.04u
M12780 n3222 n4330 U4945/net40 VSS nmos W=0.155u L=0.04u
M12781 n3222 U4945/net19 U4945/net36 VSS nmos W=0.155u L=0.04u
M12782 U4945/net40 g2388 VSS VSS nmos W=0.31u L=0.04u
M12783 U4945/net36 n4582 VSS VSS nmos W=0.155u L=0.04u
M12784 U4945/net19 n4330 VDD VDD pmos W=0.205u L=0.04u
M12785 n3222 U4945/net19 U4945/net26 VDD pmos W=0.325u L=0.04u
M12786 U4945/net26 g2388 VDD VDD pmos W=0.41u L=0.04u
M12787 n3222 n4330 U4945/net30 VDD pmos W=0.325u L=0.04u
M12788 U4945/net30 n4582 VDD VDD pmos W=0.205u L=0.04u
M12789 U4946/net19 n4530 VSS VSS nmos W=0.155u L=0.04u
M12790 n3221 n4530 U4946/net40 VSS nmos W=0.155u L=0.04u
M12791 n3221 U4946/net19 U4946/net36 VSS nmos W=0.155u L=0.04u
M12792 U4946/net40 g2389 VSS VSS nmos W=0.31u L=0.04u
M12793 U4946/net36 n4582 VSS VSS nmos W=0.155u L=0.04u
M12794 U4946/net19 n4530 VDD VDD pmos W=0.205u L=0.04u
M12795 n3221 U4946/net19 U4946/net26 VDD pmos W=0.325u L=0.04u
M12796 U4946/net26 g2389 VDD VDD pmos W=0.41u L=0.04u
M12797 n3221 n4530 U4946/net30 VDD pmos W=0.325u L=0.04u
M12798 U4946/net30 n4582 VDD VDD pmos W=0.205u L=0.04u
M12799 n4582 U4947/net6 VSS VSS nmos W=0.155u L=0.04u
M12800 U4947/X_u2-net6 n4584 VSS VSS nmos W=0.155u L=0.04u
M12801 U4947/net6 n4583 U4947/X_u2-net6 VSS nmos W=0.155u L=0.04u
M12802 n4582 U4947/net6 VDD VDD pmos W=0.205u L=0.04u
M12803 U4947/net6 n4584 VDD VDD pmos W=0.205u L=0.04u
M12804 U4947/net6 n4583 VDD VDD pmos W=0.205u L=0.04u
M12805 n4583 U4948/net26 VDD VDD pmos W=0.205u L=0.04u
M12806 U4948/net26 n4585 U4948/net19 VDD pmos W=0.205u L=0.04u
M12807 U4948/net26 n4586 U4948/net19 VDD pmos W=0.205u L=0.04u
M12808 U4948/net26 n4587 U4948/net19 VDD pmos W=0.205u L=0.04u
M12809 U4948/net19 n4588 VDD VDD pmos W=0.205u L=0.04u
M12810 U4948/net26 n4588 VSS VSS nmos W=0.155u L=0.04u
M12811 n4583 U4948/net26 VSS VSS nmos W=0.155u L=0.04u
M12812 U4948/XI20-net13 n4587 VSS VSS nmos W=0.155u L=0.04u
M12813 U4948/net26 n4585 U4948/XI20-net17 VSS nmos W=0.155u L=0.04u
M12814 U4948/XI20-net17 n4586 U4948/XI20-net13 VSS nmos W=0.155u L=0.04u
M12815 U4949/net19 n4548 VSS VSS nmos W=0.155u L=0.04u
M12816 n3220 n4548 U4949/net40 VSS nmos W=0.155u L=0.04u
M12817 n3220 U4949/net19 U4949/net36 VSS nmos W=0.155u L=0.04u
M12818 U4949/net40 g2288 VSS VSS nmos W=0.31u L=0.04u
M12819 U4949/net36 n4589 VSS VSS nmos W=0.155u L=0.04u
M12820 U4949/net19 n4548 VDD VDD pmos W=0.205u L=0.04u
M12821 n3220 U4949/net19 U4949/net26 VDD pmos W=0.325u L=0.04u
M12822 U4949/net26 g2288 VDD VDD pmos W=0.41u L=0.04u
M12823 n3220 n4548 U4949/net30 VDD pmos W=0.325u L=0.04u
M12824 U4949/net30 n4589 VDD VDD pmos W=0.205u L=0.04u
M12825 U4950/net19 n4550 VSS VSS nmos W=0.155u L=0.04u
M12826 n3219 n4550 U4950/net40 VSS nmos W=0.155u L=0.04u
M12827 n3219 U4950/net19 U4950/net36 VSS nmos W=0.155u L=0.04u
M12828 U4950/net40 g2291 VSS VSS nmos W=0.31u L=0.04u
M12829 U4950/net36 n4589 VSS VSS nmos W=0.155u L=0.04u
M12830 U4950/net19 n4550 VDD VDD pmos W=0.205u L=0.04u
M12831 n3219 U4950/net19 U4950/net26 VDD pmos W=0.325u L=0.04u
M12832 U4950/net26 g2291 VDD VDD pmos W=0.41u L=0.04u
M12833 n3219 n4550 U4950/net30 VDD pmos W=0.325u L=0.04u
M12834 U4950/net30 n4589 VDD VDD pmos W=0.205u L=0.04u
M12835 U4951/net19 n4549 VSS VSS nmos W=0.155u L=0.04u
M12836 n3218 n4549 U4951/net40 VSS nmos W=0.155u L=0.04u
M12837 n3218 U4951/net19 U4951/net36 VSS nmos W=0.155u L=0.04u
M12838 U4951/net40 g2294 VSS VSS nmos W=0.31u L=0.04u
M12839 U4951/net36 n4589 VSS VSS nmos W=0.155u L=0.04u
M12840 U4951/net19 n4549 VDD VDD pmos W=0.205u L=0.04u
M12841 n3218 U4951/net19 U4951/net26 VDD pmos W=0.325u L=0.04u
M12842 U4951/net26 g2294 VDD VDD pmos W=0.41u L=0.04u
M12843 n3218 n4549 U4951/net30 VDD pmos W=0.325u L=0.04u
M12844 U4951/net30 n4589 VDD VDD pmos W=0.205u L=0.04u
M12845 n4589 n4527 U4952/net10 VSS nmos W=0.155u L=0.04u
M12846 U4952/net10 n4592 VSS VSS nmos W=0.155u L=0.04u
M12847 n4589 n4590 U4952/net10 VSS nmos W=0.155u L=0.04u
M12848 U4952/net10 n4591 VSS VSS nmos W=0.155u L=0.04u
M12849 U4952/net30 n4592 VDD VDD pmos W=0.205u L=0.04u
M12850 n4589 n4527 U4952/net24 VDD pmos W=0.205u L=0.04u
M12851 U4952/net24 n4590 VDD VDD pmos W=0.205u L=0.04u
M12852 n4589 n4591 U4952/net30 VDD pmos W=0.205u L=0.04u
M12853 U4953/net4 n4593 U4953/net14 VSS nmos W=0.155u L=0.04u
M12854 U4953/net6 U4953/net10 U4953/net14 VSS nmos W=0.17u L=0.04u
M12855 U4953/net4 n4594 VSS VSS nmos W=0.155u L=0.04u
M12856 U4953/net6 U4953/net4 VSS VSS nmos W=0.17u L=0.04u
M12857 n4592 U4953/net14 VSS VSS nmos W=0.155u L=0.04u
M12858 U4953/net10 n4593 VSS VSS nmos W=0.155u L=0.04u
M12859 U4953/net4 U4953/net10 U4953/net14 VDD pmos W=0.255u L=0.04u
M12860 U4953/net6 n4593 U4953/net14 VDD pmos W=0.28u L=0.04u
M12861 U4953/net4 n4594 VDD VDD pmos W=0.205u L=0.04u
M12862 U4953/net6 U4953/net4 VDD VDD pmos W=0.24u L=0.04u
M12863 n4592 U4953/net14 VDD VDD pmos W=0.205u L=0.04u
M12864 U4953/net10 n4593 VDD VDD pmos W=0.205u L=0.04u
M12865 U4954/net19 n4549 VSS VSS nmos W=0.155u L=0.04u
M12866 n3217 n4549 U4954/net40 VSS nmos W=0.155u L=0.04u
M12867 n3217 U4954/net19 U4954/net36 VSS nmos W=0.155u L=0.04u
M12868 U4954/net40 g2330 VSS VSS nmos W=0.31u L=0.04u
M12869 U4954/net36 n4595 VSS VSS nmos W=0.155u L=0.04u
M12870 U4954/net19 n4549 VDD VDD pmos W=0.205u L=0.04u
M12871 n3217 U4954/net19 U4954/net26 VDD pmos W=0.325u L=0.04u
M12872 U4954/net26 g2330 VDD VDD pmos W=0.41u L=0.04u
M12873 n3217 n4549 U4954/net30 VDD pmos W=0.325u L=0.04u
M12874 U4954/net30 n4595 VDD VDD pmos W=0.205u L=0.04u
M12875 U4955/net19 n4548 VSS VSS nmos W=0.155u L=0.04u
M12876 n3216 n4548 U4955/net40 VSS nmos W=0.155u L=0.04u
M12877 n3216 U4955/net19 U4955/net36 VSS nmos W=0.155u L=0.04u
M12878 U4955/net40 g2324 VSS VSS nmos W=0.31u L=0.04u
M12879 U4955/net36 n4595 VSS VSS nmos W=0.155u L=0.04u
M12880 U4955/net19 n4548 VDD VDD pmos W=0.205u L=0.04u
M12881 n3216 U4955/net19 U4955/net26 VDD pmos W=0.325u L=0.04u
M12882 U4955/net26 g2324 VDD VDD pmos W=0.41u L=0.04u
M12883 n3216 n4548 U4955/net30 VDD pmos W=0.325u L=0.04u
M12884 U4955/net30 n4595 VDD VDD pmos W=0.205u L=0.04u
M12885 U4956/net19 n4550 VSS VSS nmos W=0.155u L=0.04u
M12886 n3215 n4550 U4956/net40 VSS nmos W=0.155u L=0.04u
M12887 n3215 U4956/net19 U4956/net36 VSS nmos W=0.155u L=0.04u
M12888 U4956/net40 g2327 VSS VSS nmos W=0.31u L=0.04u
M12889 U4956/net36 n4595 VSS VSS nmos W=0.155u L=0.04u
M12890 U4956/net19 n4550 VDD VDD pmos W=0.205u L=0.04u
M12891 n3215 U4956/net19 U4956/net26 VDD pmos W=0.325u L=0.04u
M12892 U4956/net26 g2327 VDD VDD pmos W=0.41u L=0.04u
M12893 n3215 n4550 U4956/net30 VDD pmos W=0.325u L=0.04u
M12894 U4956/net30 n4595 VDD VDD pmos W=0.205u L=0.04u
M12895 n4595 n4526 U4957/net10 VSS nmos W=0.155u L=0.04u
M12896 U4957/net10 n4596 VSS VSS nmos W=0.155u L=0.04u
M12897 n4595 n4590 U4957/net10 VSS nmos W=0.155u L=0.04u
M12898 U4957/net10 n4591 VSS VSS nmos W=0.155u L=0.04u
M12899 U4957/net30 n4596 VDD VDD pmos W=0.205u L=0.04u
M12900 n4595 n4526 U4957/net24 VDD pmos W=0.205u L=0.04u
M12901 U4957/net24 n4590 VDD VDD pmos W=0.205u L=0.04u
M12902 n4595 n4591 U4957/net30 VDD pmos W=0.205u L=0.04u
M12903 U4958/net4 n4597 U4958/net14 VSS nmos W=0.155u L=0.04u
M12904 U4958/net6 U4958/net10 U4958/net14 VSS nmos W=0.17u L=0.04u
M12905 U4958/net4 n4598 VSS VSS nmos W=0.155u L=0.04u
M12906 U4958/net6 U4958/net4 VSS VSS nmos W=0.17u L=0.04u
M12907 n4596 U4958/net14 VSS VSS nmos W=0.155u L=0.04u
M12908 U4958/net10 n4597 VSS VSS nmos W=0.155u L=0.04u
M12909 U4958/net4 U4958/net10 U4958/net14 VDD pmos W=0.255u L=0.04u
M12910 U4958/net6 n4597 U4958/net14 VDD pmos W=0.28u L=0.04u
M12911 U4958/net4 n4598 VDD VDD pmos W=0.205u L=0.04u
M12912 U4958/net6 U4958/net4 VDD VDD pmos W=0.24u L=0.04u
M12913 n4596 U4958/net14 VDD VDD pmos W=0.205u L=0.04u
M12914 U4958/net10 n4597 VDD VDD pmos W=0.205u L=0.04u
M12915 U4959/XU1-net6 n4600 VSS VSS nmos W=0.155u L=0.04u
M12916 n4597 n4599 U4959/XU1-net6 VSS nmos W=0.155u L=0.04u
M12917 n4597 n4600 VDD VDD pmos W=0.155u L=0.04u
M12918 n4597 n4599 VDD VDD pmos W=0.155u L=0.04u
M12919 U4960/net19 n4548 VSS VSS nmos W=0.155u L=0.04u
M12920 n3214 n4548 U4960/net40 VSS nmos W=0.155u L=0.04u
M12921 n3214 U4960/net19 U4960/net36 VSS nmos W=0.155u L=0.04u
M12922 U4960/net40 g2279 VSS VSS nmos W=0.31u L=0.04u
M12923 U4960/net36 n4601 VSS VSS nmos W=0.155u L=0.04u
M12924 U4960/net19 n4548 VDD VDD pmos W=0.205u L=0.04u
M12925 n3214 U4960/net19 U4960/net26 VDD pmos W=0.325u L=0.04u
M12926 U4960/net26 g2279 VDD VDD pmos W=0.41u L=0.04u
M12927 n3214 n4548 U4960/net30 VDD pmos W=0.325u L=0.04u
M12928 U4960/net30 n4601 VDD VDD pmos W=0.205u L=0.04u
M12929 U4961/net19 n4550 VSS VSS nmos W=0.155u L=0.04u
M12930 n3213 n4550 U4961/net40 VSS nmos W=0.155u L=0.04u
M12931 n3213 U4961/net19 U4961/net36 VSS nmos W=0.155u L=0.04u
M12932 U4961/net40 g2282 VSS VSS nmos W=0.31u L=0.04u
M12933 U4961/net36 n4601 VSS VSS nmos W=0.155u L=0.04u
M12934 U4961/net19 n4550 VDD VDD pmos W=0.205u L=0.04u
M12935 n3213 U4961/net19 U4961/net26 VDD pmos W=0.325u L=0.04u
M12936 U4961/net26 g2282 VDD VDD pmos W=0.41u L=0.04u
M12937 n3213 n4550 U4961/net30 VDD pmos W=0.325u L=0.04u
M12938 U4961/net30 n4601 VDD VDD pmos W=0.205u L=0.04u
M12939 U4962/net19 n4549 VSS VSS nmos W=0.155u L=0.04u
M12940 n3212 n4549 U4962/net40 VSS nmos W=0.155u L=0.04u
M12941 n3212 U4962/net19 U4962/net36 VSS nmos W=0.155u L=0.04u
M12942 U4962/net40 g2285 VSS VSS nmos W=0.31u L=0.04u
M12943 U4962/net36 n4601 VSS VSS nmos W=0.155u L=0.04u
M12944 U4962/net19 n4549 VDD VDD pmos W=0.205u L=0.04u
M12945 n3212 U4962/net19 U4962/net26 VDD pmos W=0.325u L=0.04u
M12946 U4962/net26 g2285 VDD VDD pmos W=0.41u L=0.04u
M12947 n3212 n4549 U4962/net30 VDD pmos W=0.325u L=0.04u
M12948 U4962/net30 n4601 VDD VDD pmos W=0.205u L=0.04u
M12949 n4601 n4525 U4963/net10 VSS nmos W=0.155u L=0.04u
M12950 U4963/net10 n4602 VSS VSS nmos W=0.155u L=0.04u
M12951 n4601 n4590 U4963/net10 VSS nmos W=0.155u L=0.04u
M12952 U4963/net10 n4591 VSS VSS nmos W=0.155u L=0.04u
M12953 U4963/net30 n4602 VDD VDD pmos W=0.205u L=0.04u
M12954 n4601 n4525 U4963/net24 VDD pmos W=0.205u L=0.04u
M12955 U4963/net24 n4590 VDD VDD pmos W=0.205u L=0.04u
M12956 n4601 n4591 U4963/net30 VDD pmos W=0.205u L=0.04u
M12957 U4964/net4 n4603 U4964/net14 VSS nmos W=0.155u L=0.04u
M12958 U4964/net6 U4964/net10 U4964/net14 VSS nmos W=0.17u L=0.04u
M12959 U4964/net4 n4599 VSS VSS nmos W=0.155u L=0.04u
M12960 U4964/net6 U4964/net4 VSS VSS nmos W=0.17u L=0.04u
M12961 n4602 U4964/net14 VSS VSS nmos W=0.155u L=0.04u
M12962 U4964/net10 n4603 VSS VSS nmos W=0.155u L=0.04u
M12963 U4964/net4 U4964/net10 U4964/net14 VDD pmos W=0.255u L=0.04u
M12964 U4964/net6 n4603 U4964/net14 VDD pmos W=0.28u L=0.04u
M12965 U4964/net4 n4599 VDD VDD pmos W=0.205u L=0.04u
M12966 U4964/net6 U4964/net4 VDD VDD pmos W=0.24u L=0.04u
M12967 n4602 U4964/net14 VDD VDD pmos W=0.205u L=0.04u
M12968 U4964/net10 n4603 VDD VDD pmos W=0.205u L=0.04u
M12969 U4965/net19 n4548 VSS VSS nmos W=0.155u L=0.04u
M12970 n3211 n4548 U4965/net40 VSS nmos W=0.155u L=0.04u
M12971 n3211 U4965/net19 U4965/net36 VSS nmos W=0.155u L=0.04u
M12972 U4965/net40 g2261 VSS VSS nmos W=0.31u L=0.04u
M12973 U4965/net36 n4604 VSS VSS nmos W=0.155u L=0.04u
M12974 U4965/net19 n4548 VDD VDD pmos W=0.205u L=0.04u
M12975 n3211 U4965/net19 U4965/net26 VDD pmos W=0.325u L=0.04u
M12976 U4965/net26 g2261 VDD VDD pmos W=0.41u L=0.04u
M12977 n3211 n4548 U4965/net30 VDD pmos W=0.325u L=0.04u
M12978 U4965/net30 n4604 VDD VDD pmos W=0.205u L=0.04u
M12979 U4966/net19 n4550 VSS VSS nmos W=0.155u L=0.04u
M12980 n3210 n4550 U4966/net40 VSS nmos W=0.155u L=0.04u
M12981 n3210 U4966/net19 U4966/net36 VSS nmos W=0.155u L=0.04u
M12982 U4966/net40 g2264 VSS VSS nmos W=0.31u L=0.04u
M12983 U4966/net36 n4604 VSS VSS nmos W=0.155u L=0.04u
M12984 U4966/net19 n4550 VDD VDD pmos W=0.205u L=0.04u
M12985 n3210 U4966/net19 U4966/net26 VDD pmos W=0.325u L=0.04u
M12986 U4966/net26 g2264 VDD VDD pmos W=0.41u L=0.04u
M12987 n3210 n4550 U4966/net30 VDD pmos W=0.325u L=0.04u
M12988 U4966/net30 n4604 VDD VDD pmos W=0.205u L=0.04u
M12989 U4967/net19 n4549 VSS VSS nmos W=0.155u L=0.04u
M12990 n3209 n4549 U4967/net40 VSS nmos W=0.155u L=0.04u
M12991 n3209 U4967/net19 U4967/net36 VSS nmos W=0.155u L=0.04u
M12992 U4967/net40 g2267 VSS VSS nmos W=0.31u L=0.04u
M12993 U4967/net36 n4604 VSS VSS nmos W=0.155u L=0.04u
M12994 U4967/net19 n4549 VDD VDD pmos W=0.205u L=0.04u
M12995 n3209 U4967/net19 U4967/net26 VDD pmos W=0.325u L=0.04u
M12996 U4967/net26 g2267 VDD VDD pmos W=0.41u L=0.04u
M12997 n3209 n4549 U4967/net30 VDD pmos W=0.325u L=0.04u
M12998 U4967/net30 n4604 VDD VDD pmos W=0.205u L=0.04u
M12999 n4604 n4521 U4968/net10 VSS nmos W=0.155u L=0.04u
M13000 U4968/net10 n4591 VSS VSS nmos W=0.155u L=0.04u
M13001 n4604 n4590 U4968/net10 VSS nmos W=0.155u L=0.04u
M13002 U4968/net10 n4605 VSS VSS nmos W=0.155u L=0.04u
M13003 U4968/net30 n4591 VDD VDD pmos W=0.205u L=0.04u
M13004 n4604 n4521 U4968/net24 VDD pmos W=0.205u L=0.04u
M13005 U4968/net24 n4590 VDD VDD pmos W=0.205u L=0.04u
M13006 n4604 n4605 U4968/net30 VDD pmos W=0.205u L=0.04u
M13007 U4969/net4 n4606 U4969/net14 VSS nmos W=0.155u L=0.04u
M13008 U4969/net6 U4969/net10 U4969/net14 VSS nmos W=0.17u L=0.04u
M13009 U4969/net4 n4607 VSS VSS nmos W=0.155u L=0.04u
M13010 U4969/net6 U4969/net4 VSS VSS nmos W=0.17u L=0.04u
M13011 n4605 U4969/net14 VSS VSS nmos W=0.155u L=0.04u
M13012 U4969/net10 n4606 VSS VSS nmos W=0.155u L=0.04u
M13013 U4969/net4 U4969/net10 U4969/net14 VDD pmos W=0.255u L=0.04u
M13014 U4969/net6 n4606 U4969/net14 VDD pmos W=0.28u L=0.04u
M13015 U4969/net4 n4607 VDD VDD pmos W=0.205u L=0.04u
M13016 U4969/net6 U4969/net4 VDD VDD pmos W=0.24u L=0.04u
M13017 n4605 U4969/net14 VDD VDD pmos W=0.205u L=0.04u
M13018 U4969/net10 n4606 VDD VDD pmos W=0.205u L=0.04u
M13019 U4970/net19 n4548 VSS VSS nmos W=0.155u L=0.04u
M13020 n3208 n4548 U4970/net40 VSS nmos W=0.155u L=0.04u
M13021 n3208 U4970/net19 U4970/net36 VSS nmos W=0.155u L=0.04u
M13022 U4970/net40 g2342 VSS VSS nmos W=0.31u L=0.04u
M13023 U4970/net36 n4608 VSS VSS nmos W=0.155u L=0.04u
M13024 U4970/net19 n4548 VDD VDD pmos W=0.205u L=0.04u
M13025 n3208 U4970/net19 U4970/net26 VDD pmos W=0.325u L=0.04u
M13026 U4970/net26 g2342 VDD VDD pmos W=0.41u L=0.04u
M13027 n3208 n4548 U4970/net30 VDD pmos W=0.325u L=0.04u
M13028 U4970/net30 n4608 VDD VDD pmos W=0.205u L=0.04u
M13029 U4971/net19 n4550 VSS VSS nmos W=0.155u L=0.04u
M13030 n3207 n4550 U4971/net40 VSS nmos W=0.155u L=0.04u
M13031 n3207 U4971/net19 U4971/net36 VSS nmos W=0.155u L=0.04u
M13032 U4971/net40 g2345 VSS VSS nmos W=0.31u L=0.04u
M13033 U4971/net36 n4608 VSS VSS nmos W=0.155u L=0.04u
M13034 U4971/net19 n4550 VDD VDD pmos W=0.205u L=0.04u
M13035 n3207 U4971/net19 U4971/net26 VDD pmos W=0.325u L=0.04u
M13036 U4971/net26 g2345 VDD VDD pmos W=0.41u L=0.04u
M13037 n3207 n4550 U4971/net30 VDD pmos W=0.325u L=0.04u
M13038 U4971/net30 n4608 VDD VDD pmos W=0.205u L=0.04u
M13039 U4972/net19 n4549 VSS VSS nmos W=0.155u L=0.04u
M13040 n3206 n4549 U4972/net40 VSS nmos W=0.155u L=0.04u
M13041 n3206 U4972/net19 U4972/net36 VSS nmos W=0.155u L=0.04u
M13042 U4972/net40 g2348 VSS VSS nmos W=0.31u L=0.04u
M13043 U4972/net36 n4608 VSS VSS nmos W=0.155u L=0.04u
M13044 U4972/net19 n4549 VDD VDD pmos W=0.205u L=0.04u
M13045 n3206 U4972/net19 U4972/net26 VDD pmos W=0.325u L=0.04u
M13046 U4972/net26 g2348 VDD VDD pmos W=0.41u L=0.04u
M13047 n3206 n4549 U4972/net30 VDD pmos W=0.325u L=0.04u
M13048 U4972/net30 n4608 VDD VDD pmos W=0.205u L=0.04u
M13049 U4973/net32 n4590 U4973/net26 VSS nmos W=0.155u L=0.04u
M13050 U4973/net32 n4574 U4973/net26 VSS nmos W=0.155u L=0.04u
M13051 U4973/net29 n4610 VSS VSS nmos W=0.155u L=0.04u
M13052 U4973/net26 n4609 U4973/net29 VSS nmos W=0.155u L=0.04u
M13053 U4973/net26 n4591 U4973/net29 VSS nmos W=0.155u L=0.04u
M13054 n4608 U4973/net32 VSS VSS nmos W=0.155u L=0.04u
M13055 n4608 U4973/net32 VDD VDD pmos W=0.205u L=0.04u
M13056 U4973/net32 n4574 U4973/net43 VDD pmos W=0.205u L=0.04u
M13057 U4973/net32 n4591 U4973/net49 VDD pmos W=0.205u L=0.04u
M13058 U4973/net49 n4609 VDD VDD pmos W=0.205u L=0.04u
M13059 U4973/net43 n4590 VDD VDD pmos W=0.205u L=0.04u
M13060 U4973/net32 n4610 VDD VDD pmos W=0.205u L=0.04u
M13061 U4974/net4 n4611 U4974/net14 VSS nmos W=0.155u L=0.04u
M13062 U4974/net6 U4974/net10 U4974/net14 VSS nmos W=0.17u L=0.04u
M13063 U4974/net4 n4612 VSS VSS nmos W=0.155u L=0.04u
M13064 U4974/net6 U4974/net4 VSS VSS nmos W=0.17u L=0.04u
M13065 n4609 U4974/net14 VSS VSS nmos W=0.155u L=0.04u
M13066 U4974/net10 n4611 VSS VSS nmos W=0.155u L=0.04u
M13067 U4974/net4 U4974/net10 U4974/net14 VDD pmos W=0.255u L=0.04u
M13068 U4974/net6 n4611 U4974/net14 VDD pmos W=0.28u L=0.04u
M13069 U4974/net4 n4612 VDD VDD pmos W=0.205u L=0.04u
M13070 U4974/net6 U4974/net4 VDD VDD pmos W=0.24u L=0.04u
M13071 n4609 U4974/net14 VDD VDD pmos W=0.205u L=0.04u
M13072 U4974/net10 n4611 VDD VDD pmos W=0.205u L=0.04u
M13073 n4611 n4613 VSS VSS nmos W=0.155u L=0.04u
M13074 n4611 n4614 VSS VSS nmos W=0.155u L=0.04u
M13075 U4975/XI1-net8 n4614 VDD VDD pmos W=0.205u L=0.04u
M13076 n4611 n4613 U4975/XI1-net8 VDD pmos W=0.205u L=0.04u
M13077 U4976/net4 n4588 U4976/net14 VSS nmos W=0.155u L=0.04u
M13078 U4976/net6 U4976/net10 U4976/net14 VSS nmos W=0.17u L=0.04u
M13079 U4976/net4 n4615 VSS VSS nmos W=0.155u L=0.04u
M13080 U4976/net6 U4976/net4 VSS VSS nmos W=0.17u L=0.04u
M13081 n4613 U4976/net14 VSS VSS nmos W=0.155u L=0.04u
M13082 U4976/net10 n4588 VSS VSS nmos W=0.155u L=0.04u
M13083 U4976/net4 U4976/net10 U4976/net14 VDD pmos W=0.255u L=0.04u
M13084 U4976/net6 n4588 U4976/net14 VDD pmos W=0.28u L=0.04u
M13085 U4976/net4 n4615 VDD VDD pmos W=0.205u L=0.04u
M13086 U4976/net6 U4976/net4 VDD VDD pmos W=0.24u L=0.04u
M13087 n4613 U4976/net14 VDD VDD pmos W=0.205u L=0.04u
M13088 U4976/net10 n4588 VDD VDD pmos W=0.205u L=0.04u
M13089 U4977/net19 n4548 VSS VSS nmos W=0.155u L=0.04u
M13090 n3205 n4548 U4977/net40 VSS nmos W=0.155u L=0.04u
M13091 n3205 U4977/net19 U4977/net36 VSS nmos W=0.155u L=0.04u
M13092 U4977/net40 g2297 VSS VSS nmos W=0.31u L=0.04u
M13093 U4977/net36 n4616 VSS VSS nmos W=0.155u L=0.04u
M13094 U4977/net19 n4548 VDD VDD pmos W=0.205u L=0.04u
M13095 n3205 U4977/net19 U4977/net26 VDD pmos W=0.325u L=0.04u
M13096 U4977/net26 g2297 VDD VDD pmos W=0.41u L=0.04u
M13097 n3205 n4548 U4977/net30 VDD pmos W=0.325u L=0.04u
M13098 U4977/net30 n4616 VDD VDD pmos W=0.205u L=0.04u
M13099 U4978/net19 n4550 VSS VSS nmos W=0.155u L=0.04u
M13100 n3204 n4550 U4978/net40 VSS nmos W=0.155u L=0.04u
M13101 n3204 U4978/net19 U4978/net36 VSS nmos W=0.155u L=0.04u
M13102 U4978/net40 g2300 VSS VSS nmos W=0.31u L=0.04u
M13103 U4978/net36 n4616 VSS VSS nmos W=0.155u L=0.04u
M13104 U4978/net19 n4550 VDD VDD pmos W=0.205u L=0.04u
M13105 n3204 U4978/net19 U4978/net26 VDD pmos W=0.325u L=0.04u
M13106 U4978/net26 g2300 VDD VDD pmos W=0.41u L=0.04u
M13107 n3204 n4550 U4978/net30 VDD pmos W=0.325u L=0.04u
M13108 U4978/net30 n4616 VDD VDD pmos W=0.205u L=0.04u
M13109 U4979/net19 n4549 VSS VSS nmos W=0.155u L=0.04u
M13110 n3203 n4549 U4979/net40 VSS nmos W=0.155u L=0.04u
M13111 n3203 U4979/net19 U4979/net36 VSS nmos W=0.155u L=0.04u
M13112 U4979/net40 g2303 VSS VSS nmos W=0.31u L=0.04u
M13113 U4979/net36 n4616 VSS VSS nmos W=0.155u L=0.04u
M13114 U4979/net19 n4549 VDD VDD pmos W=0.205u L=0.04u
M13115 n3203 U4979/net19 U4979/net26 VDD pmos W=0.325u L=0.04u
M13116 U4979/net26 g2303 VDD VDD pmos W=0.41u L=0.04u
M13117 n3203 n4549 U4979/net30 VDD pmos W=0.325u L=0.04u
M13118 U4979/net30 n4616 VDD VDD pmos W=0.205u L=0.04u
M13119 n4616 n4590 U4980/net27 VSS nmos W=0.155u L=0.04u
M13120 U4980/net39 n4618 VSS VSS nmos W=0.155u L=0.04u
M13121 U4980/net27 n4591 U4980/net39 VSS nmos W=0.155u L=0.04u
M13122 U4980/net27 n4617 U4980/net39 VSS nmos W=0.155u L=0.04u
M13123 n4616 n3962 U4980/net27 VSS nmos W=0.155u L=0.04u
M13124 U4980/net39 n4588 VSS VSS nmos W=0.155u L=0.04u
M13125 n4616 n4618 U4980/net46 VDD pmos W=0.205u L=0.04u
M13126 U4980/net46 n4588 VDD VDD pmos W=0.205u L=0.04u
M13127 n4616 n3962 U4980/net34 VDD pmos W=0.205u L=0.04u
M13128 U4980/net34 n4590 VDD VDD pmos W=0.205u L=0.04u
M13129 n4616 n4617 U4980/net37 VDD pmos W=0.205u L=0.04u
M13130 U4980/net37 n4591 VDD VDD pmos W=0.205u L=0.04u
M13131 U4981/net4 n4614 U4981/net14 VSS nmos W=0.155u L=0.04u
M13132 U4981/net6 U4981/net10 U4981/net14 VSS nmos W=0.17u L=0.04u
M13133 U4981/net4 n4615 VSS VSS nmos W=0.155u L=0.04u
M13134 U4981/net6 U4981/net4 VSS VSS nmos W=0.17u L=0.04u
M13135 n4617 U4981/net14 VSS VSS nmos W=0.155u L=0.04u
M13136 U4981/net10 n4614 VSS VSS nmos W=0.155u L=0.04u
M13137 U4981/net4 U4981/net10 U4981/net14 VDD pmos W=0.255u L=0.04u
M13138 U4981/net6 n4614 U4981/net14 VDD pmos W=0.28u L=0.04u
M13139 U4981/net4 n4615 VDD VDD pmos W=0.205u L=0.04u
M13140 U4981/net6 U4981/net4 VDD VDD pmos W=0.24u L=0.04u
M13141 n4617 U4981/net14 VDD VDD pmos W=0.205u L=0.04u
M13142 U4981/net10 n4614 VDD VDD pmos W=0.205u L=0.04u
M13143 U4982/XU1-net6 n4620 VSS VSS nmos W=0.155u L=0.04u
M13144 n4614 n4619 U4982/XU1-net6 VSS nmos W=0.155u L=0.04u
M13145 n4614 n4620 VDD VDD pmos W=0.155u L=0.04u
M13146 n4614 n4619 VDD VDD pmos W=0.155u L=0.04u
M13147 U4983/net19 n4621 VSS VSS nmos W=0.155u L=0.04u
M13148 n4619 n4621 U4983/net40 VSS nmos W=0.155u L=0.04u
M13149 n4619 U4983/net19 U4983/net36 VSS nmos W=0.155u L=0.04u
M13150 U4983/net40 n4594 VSS VSS nmos W=0.31u L=0.04u
M13151 U4983/net36 n4588 VSS VSS nmos W=0.155u L=0.04u
M13152 U4983/net19 n4621 VDD VDD pmos W=0.205u L=0.04u
M13153 n4619 U4983/net19 U4983/net26 VDD pmos W=0.325u L=0.04u
M13154 U4983/net26 n4594 VDD VDD pmos W=0.41u L=0.04u
M13155 n4619 n4621 U4983/net30 VDD pmos W=0.325u L=0.04u
M13156 U4983/net30 n4588 VDD VDD pmos W=0.205u L=0.04u
M13157 U4984/net19 n4548 VSS VSS nmos W=0.155u L=0.04u
M13158 n3202 n4548 U4984/net40 VSS nmos W=0.155u L=0.04u
M13159 n3202 U4984/net19 U4984/net36 VSS nmos W=0.155u L=0.04u
M13160 U4984/net40 g2315 VSS VSS nmos W=0.31u L=0.04u
M13161 U4984/net36 n4622 VSS VSS nmos W=0.155u L=0.04u
M13162 U4984/net19 n4548 VDD VDD pmos W=0.205u L=0.04u
M13163 n3202 U4984/net19 U4984/net26 VDD pmos W=0.325u L=0.04u
M13164 U4984/net26 g2315 VDD VDD pmos W=0.41u L=0.04u
M13165 n3202 n4548 U4984/net30 VDD pmos W=0.325u L=0.04u
M13166 U4984/net30 n4622 VDD VDD pmos W=0.205u L=0.04u
M13167 U4985/net19 n4550 VSS VSS nmos W=0.155u L=0.04u
M13168 n3201 n4550 U4985/net40 VSS nmos W=0.155u L=0.04u
M13169 n3201 U4985/net19 U4985/net36 VSS nmos W=0.155u L=0.04u
M13170 U4985/net40 g2318 VSS VSS nmos W=0.31u L=0.04u
M13171 U4985/net36 n4622 VSS VSS nmos W=0.155u L=0.04u
M13172 U4985/net19 n4550 VDD VDD pmos W=0.205u L=0.04u
M13173 n3201 U4985/net19 U4985/net26 VDD pmos W=0.325u L=0.04u
M13174 U4985/net26 g2318 VDD VDD pmos W=0.41u L=0.04u
M13175 n3201 n4550 U4985/net30 VDD pmos W=0.325u L=0.04u
M13176 U4985/net30 n4622 VDD VDD pmos W=0.205u L=0.04u
M13177 U4986/net19 n4549 VSS VSS nmos W=0.155u L=0.04u
M13178 n3200 n4549 U4986/net40 VSS nmos W=0.155u L=0.04u
M13179 n3200 U4986/net19 U4986/net36 VSS nmos W=0.155u L=0.04u
M13180 U4986/net40 g2321 VSS VSS nmos W=0.31u L=0.04u
M13181 U4986/net36 n4622 VSS VSS nmos W=0.155u L=0.04u
M13182 U4986/net19 n4549 VDD VDD pmos W=0.205u L=0.04u
M13183 n3200 U4986/net19 U4986/net26 VDD pmos W=0.325u L=0.04u
M13184 U4986/net26 g2321 VDD VDD pmos W=0.41u L=0.04u
M13185 n3200 n4549 U4986/net30 VDD pmos W=0.325u L=0.04u
M13186 U4986/net30 n4622 VDD VDD pmos W=0.205u L=0.04u
M13187 U4987/net32 n4590 U4987/net26 VSS nmos W=0.155u L=0.04u
M13188 U4987/net32 g2180 U4987/net26 VSS nmos W=0.155u L=0.04u
M13189 U4987/net29 n4610 VSS VSS nmos W=0.155u L=0.04u
M13190 U4987/net26 n4623 U4987/net29 VSS nmos W=0.155u L=0.04u
M13191 U4987/net26 n4591 U4987/net29 VSS nmos W=0.155u L=0.04u
M13192 n4622 U4987/net32 VSS VSS nmos W=0.155u L=0.04u
M13193 n4622 U4987/net32 VDD VDD pmos W=0.205u L=0.04u
M13194 U4987/net32 g2180 U4987/net43 VDD pmos W=0.205u L=0.04u
M13195 U4987/net32 n4591 U4987/net49 VDD pmos W=0.205u L=0.04u
M13196 U4987/net49 n4623 VDD VDD pmos W=0.205u L=0.04u
M13197 U4987/net43 n4590 VDD VDD pmos W=0.205u L=0.04u
M13198 U4987/net32 n4610 VDD VDD pmos W=0.205u L=0.04u
M13199 U4988/net4 n4624 U4988/net14 VSS nmos W=0.155u L=0.04u
M13200 U4988/net6 U4988/net10 U4988/net14 VSS nmos W=0.17u L=0.04u
M13201 U4988/net4 n4625 VSS VSS nmos W=0.155u L=0.04u
M13202 U4988/net6 U4988/net4 VSS VSS nmos W=0.17u L=0.04u
M13203 n4623 U4988/net14 VSS VSS nmos W=0.155u L=0.04u
M13204 U4988/net10 n4624 VSS VSS nmos W=0.155u L=0.04u
M13205 U4988/net4 U4988/net10 U4988/net14 VDD pmos W=0.255u L=0.04u
M13206 U4988/net6 n4624 U4988/net14 VDD pmos W=0.28u L=0.04u
M13207 U4988/net4 n4625 VDD VDD pmos W=0.205u L=0.04u
M13208 U4988/net6 U4988/net4 VDD VDD pmos W=0.24u L=0.04u
M13209 n4623 U4988/net14 VDD VDD pmos W=0.205u L=0.04u
M13210 U4988/net10 n4624 VDD VDD pmos W=0.205u L=0.04u
M13211 n4624 n4588 U4989/net27 VSS nmos W=0.155u L=0.04u
M13212 U4989/net27 n4626 VSS VSS nmos W=0.155u L=0.04u
M13213 n4624 n4627 VSS VSS nmos W=0.155u L=0.04u
M13214 n4624 n4626 U4989/net13 VDD pmos W=0.205u L=0.04u
M13215 U4989/net13 n4627 VDD VDD pmos W=0.205u L=0.04u
M13216 n4624 n4588 U4989/net13 VDD pmos W=0.205u L=0.04u
M13217 U4990/net19 n4548 VSS VSS nmos W=0.155u L=0.04u
M13218 n3199 n4548 U4990/net40 VSS nmos W=0.155u L=0.04u
M13219 n3199 U4990/net19 U4990/net36 VSS nmos W=0.155u L=0.04u
M13220 U4990/net40 g2270 VSS VSS nmos W=0.31u L=0.04u
M13221 U4990/net36 n4628 VSS VSS nmos W=0.155u L=0.04u
M13222 U4990/net19 n4548 VDD VDD pmos W=0.205u L=0.04u
M13223 n3199 U4990/net19 U4990/net26 VDD pmos W=0.325u L=0.04u
M13224 U4990/net26 g2270 VDD VDD pmos W=0.41u L=0.04u
M13225 n3199 n4548 U4990/net30 VDD pmos W=0.325u L=0.04u
M13226 U4990/net30 n4628 VDD VDD pmos W=0.205u L=0.04u
M13227 U4991/net19 n4550 VSS VSS nmos W=0.155u L=0.04u
M13228 n3198 n4550 U4991/net40 VSS nmos W=0.155u L=0.04u
M13229 n3198 U4991/net19 U4991/net36 VSS nmos W=0.155u L=0.04u
M13230 U4991/net40 g2273 VSS VSS nmos W=0.31u L=0.04u
M13231 U4991/net36 n4628 VSS VSS nmos W=0.155u L=0.04u
M13232 U4991/net19 n4550 VDD VDD pmos W=0.205u L=0.04u
M13233 n3198 U4991/net19 U4991/net26 VDD pmos W=0.325u L=0.04u
M13234 U4991/net26 g2273 VDD VDD pmos W=0.41u L=0.04u
M13235 n3198 n4550 U4991/net30 VDD pmos W=0.325u L=0.04u
M13236 U4991/net30 n4628 VDD VDD pmos W=0.205u L=0.04u
M13237 U4992/net19 n4549 VSS VSS nmos W=0.155u L=0.04u
M13238 n3197 n4549 U4992/net40 VSS nmos W=0.155u L=0.04u
M13239 n3197 U4992/net19 U4992/net36 VSS nmos W=0.155u L=0.04u
M13240 U4992/net40 g2276 VSS VSS nmos W=0.31u L=0.04u
M13241 U4992/net36 n4628 VSS VSS nmos W=0.155u L=0.04u
M13242 U4992/net19 n4549 VDD VDD pmos W=0.205u L=0.04u
M13243 n3197 U4992/net19 U4992/net26 VDD pmos W=0.325u L=0.04u
M13244 U4992/net26 g2276 VDD VDD pmos W=0.41u L=0.04u
M13245 n3197 n4549 U4992/net30 VDD pmos W=0.325u L=0.04u
M13246 U4992/net30 n4628 VDD VDD pmos W=0.205u L=0.04u
M13247 n4628 n4590 U4993/net27 VSS nmos W=0.155u L=0.04u
M13248 U4993/net39 n4618 VSS VSS nmos W=0.155u L=0.04u
M13249 U4993/net27 n4591 U4993/net39 VSS nmos W=0.155u L=0.04u
M13250 U4993/net27 n4629 U4993/net39 VSS nmos W=0.155u L=0.04u
M13251 n4628 n4523 U4993/net27 VSS nmos W=0.155u L=0.04u
M13252 U4993/net39 n4588 VSS VSS nmos W=0.155u L=0.04u
M13253 n4628 n4618 U4993/net46 VDD pmos W=0.205u L=0.04u
M13254 U4993/net46 n4588 VDD VDD pmos W=0.205u L=0.04u
M13255 n4628 n4523 U4993/net34 VDD pmos W=0.205u L=0.04u
M13256 U4993/net34 n4590 VDD VDD pmos W=0.205u L=0.04u
M13257 n4628 n4629 U4993/net37 VDD pmos W=0.205u L=0.04u
M13258 U4993/net37 n4591 VDD VDD pmos W=0.205u L=0.04u
M13259 U4994/net4 U4994/net10 U4994/net14 VSS nmos W=0.155u L=0.04u
M13260 U4994/net6 n4626 U4994/net14 VSS nmos W=0.155u L=0.04u
M13261 U4994/net4 n4630 VSS VSS nmos W=0.155u L=0.04u
M13262 U4994/net6 U4994/net4 VSS VSS nmos W=0.155u L=0.04u
M13263 n4629 U4994/net14 VSS VSS nmos W=0.155u L=0.04u
M13264 U4994/net10 n4626 VSS VSS nmos W=0.155u L=0.04u
M13265 U4994/net4 n4626 U4994/net14 VDD pmos W=0.205u L=0.04u
M13266 U4994/net6 U4994/net10 U4994/net14 VDD pmos W=0.205u L=0.04u
M13267 U4994/net4 n4630 VDD VDD pmos W=0.205u L=0.04u
M13268 U4994/net6 U4994/net4 VDD VDD pmos W=0.205u L=0.04u
M13269 n4629 U4994/net14 VDD VDD pmos W=0.205u L=0.04u
M13270 U4994/net10 n4626 VDD VDD pmos W=0.205u L=0.04u
M13271 U4995/net19 n4548 VSS VSS nmos W=0.155u L=0.04u
M13272 n3196 n4548 U4995/net40 VSS nmos W=0.155u L=0.04u
M13273 n3196 U4995/net19 U4995/net36 VSS nmos W=0.155u L=0.04u
M13274 U4995/net40 g2306 VSS VSS nmos W=0.31u L=0.04u
M13275 U4995/net36 n4631 VSS VSS nmos W=0.155u L=0.04u
M13276 U4995/net19 n4548 VDD VDD pmos W=0.205u L=0.04u
M13277 n3196 U4995/net19 U4995/net26 VDD pmos W=0.325u L=0.04u
M13278 U4995/net26 g2306 VDD VDD pmos W=0.41u L=0.04u
M13279 n3196 n4548 U4995/net30 VDD pmos W=0.325u L=0.04u
M13280 U4995/net30 n4631 VDD VDD pmos W=0.205u L=0.04u
M13281 U4996/net19 n4550 VSS VSS nmos W=0.155u L=0.04u
M13282 n3195 n4550 U4996/net40 VSS nmos W=0.155u L=0.04u
M13283 n3195 U4996/net19 U4996/net36 VSS nmos W=0.155u L=0.04u
M13284 U4996/net40 g2309 VSS VSS nmos W=0.31u L=0.04u
M13285 U4996/net36 n4631 VSS VSS nmos W=0.155u L=0.04u
M13286 U4996/net19 n4550 VDD VDD pmos W=0.205u L=0.04u
M13287 n3195 U4996/net19 U4996/net26 VDD pmos W=0.325u L=0.04u
M13288 U4996/net26 g2309 VDD VDD pmos W=0.41u L=0.04u
M13289 n3195 n4550 U4996/net30 VDD pmos W=0.325u L=0.04u
M13290 U4996/net30 n4631 VDD VDD pmos W=0.205u L=0.04u
M13291 U4997/net19 n4549 VSS VSS nmos W=0.155u L=0.04u
M13292 n3194 n4549 U4997/net40 VSS nmos W=0.155u L=0.04u
M13293 n3194 U4997/net19 U4997/net36 VSS nmos W=0.155u L=0.04u
M13294 U4997/net40 g2312 VSS VSS nmos W=0.31u L=0.04u
M13295 U4997/net36 n4631 VSS VSS nmos W=0.155u L=0.04u
M13296 U4997/net19 n4549 VDD VDD pmos W=0.205u L=0.04u
M13297 n3194 U4997/net19 U4997/net26 VDD pmos W=0.325u L=0.04u
M13298 U4997/net26 g2312 VDD VDD pmos W=0.41u L=0.04u
M13299 n3194 n4549 U4997/net30 VDD pmos W=0.325u L=0.04u
M13300 U4997/net30 n4631 VDD VDD pmos W=0.205u L=0.04u
M13301 U4998/net32 n4590 U4998/net26 VSS nmos W=0.155u L=0.04u
M13302 U4998/net32 g2170 U4998/net26 VSS nmos W=0.155u L=0.04u
M13303 U4998/net29 n4610 VSS VSS nmos W=0.155u L=0.04u
M13304 U4998/net26 n4632 U4998/net29 VSS nmos W=0.155u L=0.04u
M13305 U4998/net26 n4591 U4998/net29 VSS nmos W=0.155u L=0.04u
M13306 n4631 U4998/net32 VSS VSS nmos W=0.155u L=0.04u
M13307 n4631 U4998/net32 VDD VDD pmos W=0.205u L=0.04u
M13308 U4998/net32 g2170 U4998/net43 VDD pmos W=0.205u L=0.04u
M13309 U4998/net32 n4591 U4998/net49 VDD pmos W=0.205u L=0.04u
M13310 U4998/net49 n4632 VDD VDD pmos W=0.205u L=0.04u
M13311 U4998/net43 n4590 VDD VDD pmos W=0.205u L=0.04u
M13312 U4998/net32 n4610 VDD VDD pmos W=0.205u L=0.04u
M13313 U4999/net13 n4618 VSS VSS nmos W=0.155u L=0.04u
M13314 U4999/net16 U4999/net13 VSS VSS nmos W=0.155u L=0.04u
M13315 n4610 n4588 U4999/net16 VSS nmos W=0.155u L=0.04u
M13316 U4999/net13 n4618 VDD VDD pmos W=0.205u L=0.04u
M13317 VDD U4999/net13 n4610 VDD pmos W=0.205u L=0.04u
M13318 VDD n4588 n4610 VDD pmos W=0.205u L=0.04u
M13319 U5000/net4 n4633 U5000/net14 VSS nmos W=0.155u L=0.04u
M13320 U5000/net6 U5000/net10 U5000/net14 VSS nmos W=0.17u L=0.04u
M13321 U5000/net4 n4634 VSS VSS nmos W=0.155u L=0.04u
M13322 U5000/net6 U5000/net4 VSS VSS nmos W=0.17u L=0.04u
M13323 n4632 U5000/net14 VSS VSS nmos W=0.155u L=0.04u
M13324 U5000/net10 n4633 VSS VSS nmos W=0.155u L=0.04u
M13325 U5000/net4 U5000/net10 U5000/net14 VDD pmos W=0.255u L=0.04u
M13326 U5000/net6 n4633 U5000/net14 VDD pmos W=0.28u L=0.04u
M13327 U5000/net4 n4634 VDD VDD pmos W=0.205u L=0.04u
M13328 U5000/net6 U5000/net4 VDD VDD pmos W=0.24u L=0.04u
M13329 n4632 U5000/net14 VDD VDD pmos W=0.205u L=0.04u
M13330 U5000/net10 n4633 VDD VDD pmos W=0.205u L=0.04u
M13331 n4633 U5001/net6 VSS VSS nmos W=0.155u L=0.04u
M13332 U5001/X_u2-net6 n4636 VSS VSS nmos W=0.155u L=0.04u
M13333 U5001/net6 n4635 U5001/X_u2-net6 VSS nmos W=0.155u L=0.04u
M13334 n4633 U5001/net6 VDD VDD pmos W=0.205u L=0.04u
M13335 U5001/net6 n4636 VDD VDD pmos W=0.205u L=0.04u
M13336 U5001/net6 n4635 VDD VDD pmos W=0.205u L=0.04u
M13337 n3193 n4330 U5002/net10 VSS nmos W=0.155u L=0.04u
M13338 U5002/net10 n4638 VSS VSS nmos W=0.155u L=0.04u
M13339 n3193 n4637 U5002/net10 VSS nmos W=0.155u L=0.04u
M13340 U5002/net10 g2398 VSS VSS nmos W=0.155u L=0.04u
M13341 U5002/net30 n4638 VDD VDD pmos W=0.205u L=0.04u
M13342 n3193 n4330 U5002/net24 VDD pmos W=0.205u L=0.04u
M13343 U5002/net24 n4637 VDD VDD pmos W=0.205u L=0.04u
M13344 n3193 g2398 U5002/net30 VDD pmos W=0.205u L=0.04u
M13345 n4638 n4330 VSS VSS nmos W=0.155u L=0.04u
M13346 n4638 n4639 VSS VSS nmos W=0.155u L=0.04u
M13347 U5003/XI1-net8 n4639 VDD VDD pmos W=0.205u L=0.04u
M13348 n4638 n4330 U5003/XI1-net8 VDD pmos W=0.205u L=0.04u
M13349 n3192 n4529 U5004/net10 VSS nmos W=0.155u L=0.04u
M13350 U5004/net10 n4640 VSS VSS nmos W=0.155u L=0.04u
M13351 n3192 n4637 U5004/net10 VSS nmos W=0.155u L=0.04u
M13352 U5004/net10 g2397 VSS VSS nmos W=0.155u L=0.04u
M13353 U5004/net30 n4640 VDD VDD pmos W=0.205u L=0.04u
M13354 n3192 n4529 U5004/net24 VDD pmos W=0.205u L=0.04u
M13355 U5004/net24 n4637 VDD VDD pmos W=0.205u L=0.04u
M13356 n3192 g2397 U5004/net30 VDD pmos W=0.205u L=0.04u
M13357 n4640 n4529 VSS VSS nmos W=0.155u L=0.04u
M13358 n4640 n4639 VSS VSS nmos W=0.155u L=0.04u
M13359 U5005/XI1-net8 n4639 VDD VDD pmos W=0.205u L=0.04u
M13360 n4640 n4529 U5005/XI1-net8 VDD pmos W=0.205u L=0.04u
M13361 n3191 n4530 U5006/net10 VSS nmos W=0.155u L=0.04u
M13362 U5006/net10 n4641 VSS VSS nmos W=0.155u L=0.04u
M13363 n3191 n4637 U5006/net10 VSS nmos W=0.155u L=0.04u
M13364 U5006/net10 g2396 VSS VSS nmos W=0.155u L=0.04u
M13365 U5006/net30 n4641 VDD VDD pmos W=0.205u L=0.04u
M13366 n3191 n4530 U5006/net24 VDD pmos W=0.205u L=0.04u
M13367 U5006/net24 n4637 VDD VDD pmos W=0.205u L=0.04u
M13368 n3191 g2396 U5006/net30 VDD pmos W=0.205u L=0.04u
M13369 n4641 n4530 VSS VSS nmos W=0.155u L=0.04u
M13370 n4641 n4639 VSS VSS nmos W=0.155u L=0.04u
M13371 U5007/XI1-net8 n4639 VDD VDD pmos W=0.205u L=0.04u
M13372 n4641 n4530 U5007/XI1-net8 VDD pmos W=0.205u L=0.04u
M13373 n4637 U5008/net7 VSS VSS nmos W=0.155u L=0.04u
M13374 U5008/net7 n4642 VSS VSS nmos W=0.155u L=0.04u
M13375 U5008/net7 n4639 VSS VSS nmos W=0.155u L=0.04u
M13376 n4637 U5008/net7 VDD VDD pmos W=0.205u L=0.04u
M13377 U5008/X_u7-net8 n4639 VDD VDD pmos W=0.205u L=0.04u
M13378 U5008/net7 n4642 U5008/X_u7-net8 VDD pmos W=0.205u L=0.04u
M13379 n4639 U5009/net28 VSS VSS nmos W=0.155u L=0.04u
M13380 U5009/net47 n4643 VSS VSS nmos W=0.155u L=0.04u
M13381 U5009/net28 U5009/net6 U5009/net47 VSS nmos W=0.155u L=0.04u
M13382 U5009/net44 n4538 VSS VSS nmos W=0.155u L=0.04u
M13383 U5009/net28 n3957 U5009/net44 VSS nmos W=0.155u L=0.04u
M13384 U5009/net6 n3957 VSS VSS nmos W=0.155u L=0.04u
M13385 n4639 U5009/net28 VDD VDD pmos W=0.205u L=0.04u
M13386 VDD n4643 U5009/net47 VDD pmos W=0.205u L=0.04u
M13387 U5009/net47 n3957 U5009/net28 VDD pmos W=0.205u L=0.04u
M13388 U5009/net44 U5009/net6 U5009/net28 VDD pmos W=0.205u L=0.04u
M13389 VDD n4538 U5009/net44 VDD pmos W=0.205u L=0.04u
M13390 VDD n3957 U5009/net6 VDD pmos W=0.205u L=0.04u
M13391 n4642 n4644 U5010/net23 VDD pmos W=0.205u L=0.04u
M13392 n4642 n4645 U5010/net23 VDD pmos W=0.205u L=0.04u
M13393 n4642 n4587 U5010/net23 VDD pmos W=0.205u L=0.04u
M13394 U5010/net23 n4581 VDD VDD pmos W=0.205u L=0.04u
M13395 U5010/net23 n3957 VDD VDD pmos W=0.205u L=0.04u
M13396 U5010/XI20-net13 n4645 VSS VSS nmos W=0.155u L=0.04u
M13397 n4642 n4644 U5010/XI20-net17 VSS nmos W=0.155u L=0.04u
M13398 U5010/XI20-net17 n4587 U5010/XI20-net13 VSS nmos W=0.155u L=0.04u
M13399 n4642 n4581 U5010/XI17-net17 VSS nmos W=0.155u L=0.04u
M13400 U5010/XI17-net17 n3957 VSS VSS nmos W=0.155u L=0.04u
M13401 U5011/net19 n4529 VSS VSS nmos W=0.155u L=0.04u
M13402 n3190 n4529 U5011/net40 VSS nmos W=0.155u L=0.04u
M13403 n3190 U5011/net19 U5011/net36 VSS nmos W=0.155u L=0.04u
M13404 U5011/net40 g2393 VSS VSS nmos W=0.31u L=0.04u
M13405 U5011/net36 n4646 VSS VSS nmos W=0.155u L=0.04u
M13406 U5011/net19 n4529 VDD VDD pmos W=0.205u L=0.04u
M13407 n3190 U5011/net19 U5011/net26 VDD pmos W=0.325u L=0.04u
M13408 U5011/net26 g2393 VDD VDD pmos W=0.41u L=0.04u
M13409 n3190 n4529 U5011/net30 VDD pmos W=0.325u L=0.04u
M13410 U5011/net30 n4646 VDD VDD pmos W=0.205u L=0.04u
M13411 U5012/net19 n4330 VSS VSS nmos W=0.155u L=0.04u
M13412 n3189 n4330 U5012/net40 VSS nmos W=0.155u L=0.04u
M13413 n3189 U5012/net19 U5012/net36 VSS nmos W=0.155u L=0.04u
M13414 U5012/net40 g2394 VSS VSS nmos W=0.31u L=0.04u
M13415 U5012/net36 n4646 VSS VSS nmos W=0.155u L=0.04u
M13416 U5012/net19 n4330 VDD VDD pmos W=0.205u L=0.04u
M13417 n3189 U5012/net19 U5012/net26 VDD pmos W=0.325u L=0.04u
M13418 U5012/net26 g2394 VDD VDD pmos W=0.41u L=0.04u
M13419 n3189 n4330 U5012/net30 VDD pmos W=0.325u L=0.04u
M13420 U5012/net30 n4646 VDD VDD pmos W=0.205u L=0.04u
M13421 U5013/net19 n4530 VSS VSS nmos W=0.155u L=0.04u
M13422 n3188 n4530 U5013/net40 VSS nmos W=0.155u L=0.04u
M13423 n3188 U5013/net19 U5013/net36 VSS nmos W=0.155u L=0.04u
M13424 U5013/net40 g2395 VSS VSS nmos W=0.31u L=0.04u
M13425 U5013/net36 n4646 VSS VSS nmos W=0.155u L=0.04u
M13426 U5013/net19 n4530 VDD VDD pmos W=0.205u L=0.04u
M13427 n3188 U5013/net19 U5013/net26 VDD pmos W=0.325u L=0.04u
M13428 U5013/net26 g2395 VDD VDD pmos W=0.41u L=0.04u
M13429 n3188 n4530 U5013/net30 VDD pmos W=0.325u L=0.04u
M13430 U5013/net30 n4646 VDD VDD pmos W=0.205u L=0.04u
M13431 n4646 U5014/net6 VSS VSS nmos W=0.155u L=0.04u
M13432 U5014/X_u2-net6 n4584 VSS VSS nmos W=0.155u L=0.04u
M13433 U5014/net6 n4647 U5014/X_u2-net6 VSS nmos W=0.155u L=0.04u
M13434 n4646 U5014/net6 VDD VDD pmos W=0.205u L=0.04u
M13435 U5014/net6 n4584 VDD VDD pmos W=0.205u L=0.04u
M13436 U5014/net6 n4647 VDD VDD pmos W=0.205u L=0.04u
M13437 U5015/net4 n4648 U5015/net14 VSS nmos W=0.155u L=0.04u
M13438 U5015/net6 U5015/net10 U5015/net14 VSS nmos W=0.17u L=0.04u
M13439 U5015/net4 n4645 VSS VSS nmos W=0.155u L=0.04u
M13440 U5015/net6 U5015/net4 VSS VSS nmos W=0.17u L=0.04u
M13441 n4647 U5015/net14 VSS VSS nmos W=0.155u L=0.04u
M13442 U5015/net10 n4648 VSS VSS nmos W=0.155u L=0.04u
M13443 U5015/net4 U5015/net10 U5015/net14 VDD pmos W=0.255u L=0.04u
M13444 U5015/net6 n4648 U5015/net14 VDD pmos W=0.28u L=0.04u
M13445 U5015/net4 n4645 VDD VDD pmos W=0.205u L=0.04u
M13446 U5015/net6 U5015/net4 VDD VDD pmos W=0.24u L=0.04u
M13447 n4647 U5015/net14 VDD VDD pmos W=0.205u L=0.04u
M13448 U5015/net10 n4648 VDD VDD pmos W=0.205u L=0.04u
M13449 n4648 n4649 U5016/net23 VDD pmos W=0.205u L=0.04u
M13450 n4648 n4650 U5016/net23 VDD pmos W=0.205u L=0.04u
M13451 n4648 n4587 U5016/net23 VDD pmos W=0.205u L=0.04u
M13452 U5016/net23 n4645 VDD VDD pmos W=0.205u L=0.04u
M13453 U5016/net23 n4651 VDD VDD pmos W=0.205u L=0.04u
M13454 U5016/XI20-net13 n4650 VSS VSS nmos W=0.155u L=0.04u
M13455 n4648 n4649 U5016/XI20-net17 VSS nmos W=0.155u L=0.04u
M13456 U5016/XI20-net17 n4587 U5016/XI20-net13 VSS nmos W=0.155u L=0.04u
M13457 n4648 n4645 U5016/XI17-net17 VSS nmos W=0.155u L=0.04u
M13458 U5016/XI17-net17 n4651 VSS VSS nmos W=0.155u L=0.04u
M13459 VSS n4587 U5017/net22 VSS nmos W=0.155u L=0.04u
M13460 U5017/net22 n4538 n4651 VSS nmos W=0.155u L=0.04u
M13461 U5017/net22 n4652 n4651 VSS nmos W=0.155u L=0.04u
M13462 U5017/net22 n4585 n4651 VSS nmos W=0.155u L=0.04u
M13463 U5017/net38 n4585 VDD VDD pmos W=0.205u L=0.04u
M13464 U5017/net35 n4652 U5017/net38 VDD pmos W=0.205u L=0.04u
M13465 n4651 n4538 U5017/net35 VDD pmos W=0.205u L=0.04u
M13466 n4651 n4587 VDD VDD pmos W=0.205u L=0.04u
M13467 n4538 g2384 VSS VSS nmos W=0.135u L=0.04u
M13468 n4538 g2384 VDD VDD pmos W=0.205u L=0.04u
M13469 n4650 n4643 U5019/net27 VSS nmos W=0.155u L=0.04u
M13470 U5019/net27 n4653 VSS VSS nmos W=0.155u L=0.04u
M13471 n4650 n4654 VSS VSS nmos W=0.155u L=0.04u
M13472 n4650 n4653 U5019/net13 VDD pmos W=0.205u L=0.04u
M13473 U5019/net13 n4654 VDD VDD pmos W=0.205u L=0.04u
M13474 n4650 n4643 U5019/net13 VDD pmos W=0.205u L=0.04u
M13475 U5020/net19 n4529 VSS VSS nmos W=0.155u L=0.04u
M13476 n3187 n4529 U5020/net40 VSS nmos W=0.155u L=0.04u
M13477 n3187 U5020/net19 U5020/net36 VSS nmos W=0.155u L=0.04u
M13478 U5020/net40 g2390 VSS VSS nmos W=0.31u L=0.04u
M13479 U5020/net36 n4655 VSS VSS nmos W=0.155u L=0.04u
M13480 U5020/net19 n4529 VDD VDD pmos W=0.205u L=0.04u
M13481 n3187 U5020/net19 U5020/net26 VDD pmos W=0.325u L=0.04u
M13482 U5020/net26 g2390 VDD VDD pmos W=0.41u L=0.04u
M13483 n3187 n4529 U5020/net30 VDD pmos W=0.325u L=0.04u
M13484 U5020/net30 n4655 VDD VDD pmos W=0.205u L=0.04u
M13485 U5021/net19 n4330 VSS VSS nmos W=0.155u L=0.04u
M13486 n3186 n4330 U5021/net40 VSS nmos W=0.155u L=0.04u
M13487 n3186 U5021/net19 U5021/net36 VSS nmos W=0.155u L=0.04u
M13488 U5021/net40 g2391 VSS VSS nmos W=0.31u L=0.04u
M13489 U5021/net36 n4655 VSS VSS nmos W=0.155u L=0.04u
M13490 U5021/net19 n4330 VDD VDD pmos W=0.205u L=0.04u
M13491 n3186 U5021/net19 U5021/net26 VDD pmos W=0.325u L=0.04u
M13492 U5021/net26 g2391 VDD VDD pmos W=0.41u L=0.04u
M13493 n3186 n4330 U5021/net30 VDD pmos W=0.325u L=0.04u
M13494 U5021/net30 n4655 VDD VDD pmos W=0.205u L=0.04u
M13495 U5022/net19 n4530 VSS VSS nmos W=0.155u L=0.04u
M13496 n3185 n4530 U5022/net40 VSS nmos W=0.155u L=0.04u
M13497 n3185 U5022/net19 U5022/net36 VSS nmos W=0.155u L=0.04u
M13498 U5022/net40 g2392 VSS VSS nmos W=0.31u L=0.04u
M13499 U5022/net36 n4655 VSS VSS nmos W=0.155u L=0.04u
M13500 U5022/net19 n4530 VDD VDD pmos W=0.205u L=0.04u
M13501 n3185 U5022/net19 U5022/net26 VDD pmos W=0.325u L=0.04u
M13502 U5022/net26 g2392 VDD VDD pmos W=0.41u L=0.04u
M13503 n3185 n4530 U5022/net30 VDD pmos W=0.325u L=0.04u
M13504 U5022/net30 n4655 VDD VDD pmos W=0.205u L=0.04u
M13505 n4655 U5023/net6 VSS VSS nmos W=0.155u L=0.04u
M13506 U5023/X_u2-net6 n4584 VSS VSS nmos W=0.155u L=0.04u
M13507 U5023/net6 n4656 U5023/X_u2-net6 VSS nmos W=0.155u L=0.04u
M13508 n4655 U5023/net6 VDD VDD pmos W=0.205u L=0.04u
M13509 U5023/net6 n4584 VDD VDD pmos W=0.205u L=0.04u
M13510 U5023/net6 n4656 VDD VDD pmos W=0.205u L=0.04u
M13511 U5024/net4 n4657 U5024/net14 VSS nmos W=0.155u L=0.04u
M13512 U5024/net6 U5024/net10 U5024/net14 VSS nmos W=0.17u L=0.04u
M13513 U5024/net4 n4652 VSS VSS nmos W=0.155u L=0.04u
M13514 U5024/net6 U5024/net4 VSS VSS nmos W=0.17u L=0.04u
M13515 n4656 U5024/net14 VSS VSS nmos W=0.155u L=0.04u
M13516 U5024/net10 n4657 VSS VSS nmos W=0.155u L=0.04u
M13517 U5024/net4 U5024/net10 U5024/net14 VDD pmos W=0.255u L=0.04u
M13518 U5024/net6 n4657 U5024/net14 VDD pmos W=0.28u L=0.04u
M13519 U5024/net4 n4652 VDD VDD pmos W=0.205u L=0.04u
M13520 U5024/net6 U5024/net4 VDD VDD pmos W=0.24u L=0.04u
M13521 n4656 U5024/net14 VDD VDD pmos W=0.205u L=0.04u
M13522 U5024/net10 n4657 VDD VDD pmos W=0.205u L=0.04u
M13523 n4657 n4658 VSS VSS nmos W=0.155u L=0.04u
M13524 n4657 n4659 VSS VSS nmos W=0.155u L=0.04u
M13525 U5025/XI1-net8 n4659 VDD VDD pmos W=0.205u L=0.04u
M13526 n4657 n4658 U5025/XI1-net8 VDD pmos W=0.205u L=0.04u
M13527 U5026/PG2 n4645 VSS VSS nmos W=0.31u L=0.04u
M13528 U5026/net55 n4661 VSS VSS nmos W=0.31u L=0.04u
M13529 U5026/net51 n4652 VSS VSS nmos W=0.155u L=0.04u
M13530 U5026/net53 n4660 VSS VSS nmos W=0.155u L=0.04u
M13531 U5026/net29 n4662 VSS VSS nmos W=0.155u L=0.04u
M13532 U5026/net53 U5026/net51 U5026/PG1 VSS nmos W=0.155u L=0.04u
M13533 U5026/net55 n4652 U5026/PG1 VSS nmos W=0.21u L=0.04u
M13534 U5026/PG2 n4662 n4659 VSS nmos W=0.22u L=0.04u
M13535 U5026/PG1 U5026/net29 n4659 VSS nmos W=0.155u L=0.04u
M13536 U5026/PG2 n4645 VDD VDD pmos W=0.41u L=0.04u
M13537 U5026/net55 n4661 VDD VDD pmos W=0.41u L=0.04u
M13538 U5026/net51 n4652 VDD VDD pmos W=0.205u L=0.04u
M13539 U5026/net53 n4660 VDD VDD pmos W=0.28u L=0.04u
M13540 U5026/net29 n4662 VDD VDD pmos W=0.205u L=0.04u
M13541 U5026/net53 n4652 U5026/PG1 VDD pmos W=0.27u L=0.04u
M13542 U5026/net55 U5026/net51 U5026/PG1 VDD pmos W=0.285u L=0.04u
M13543 U5026/PG2 U5026/net29 n4659 VDD pmos W=0.205u L=0.04u
M13544 U5026/PG1 n4662 n4659 VDD pmos W=0.28u L=0.04u
M13545 VSS n4664 U5027/net22 VSS nmos W=0.155u L=0.04u
M13546 U5027/net22 n4653 n4661 VSS nmos W=0.155u L=0.04u
M13547 U5027/net22 n4663 n4661 VSS nmos W=0.155u L=0.04u
M13548 U5027/net22 n4643 n4661 VSS nmos W=0.155u L=0.04u
M13549 U5027/net38 n4643 VDD VDD pmos W=0.205u L=0.04u
M13550 U5027/net35 n4663 U5027/net38 VDD pmos W=0.205u L=0.04u
M13551 n4661 n4653 U5027/net35 VDD pmos W=0.205u L=0.04u
M13552 n4661 n4664 VDD VDD pmos W=0.205u L=0.04u
M13553 U5028/XU1-net6 n4666 VSS VSS nmos W=0.155u L=0.04u
M13554 n4643 n4665 U5028/XU1-net6 VSS nmos W=0.155u L=0.04u
M13555 n4643 n4666 VDD VDD pmos W=0.155u L=0.04u
M13556 n4643 n4665 VDD VDD pmos W=0.155u L=0.04u
M13557 n4660 n4653 U5029/net23 VDD pmos W=0.205u L=0.04u
M13558 n4660 n4667 U5029/net23 VDD pmos W=0.205u L=0.04u
M13559 n4660 n4554 U5029/net23 VDD pmos W=0.205u L=0.04u
M13560 U5029/net23 n4668 VDD VDD pmos W=0.205u L=0.04u
M13561 U5029/net23 n4669 VDD VDD pmos W=0.205u L=0.04u
M13562 U5029/XI20-net13 n4667 VSS VSS nmos W=0.155u L=0.04u
M13563 n4660 n4653 U5029/XI20-net17 VSS nmos W=0.155u L=0.04u
M13564 U5029/XI20-net17 n4554 U5029/XI20-net13 VSS nmos W=0.155u L=0.04u
M13565 n4660 n4668 U5029/XI17-net17 VSS nmos W=0.155u L=0.04u
M13566 U5029/XI17-net17 n4669 VSS VSS nmos W=0.155u L=0.04u
M13567 n4669 n4649 VSS VSS nmos W=0.135u L=0.04u
M13568 n4669 n4649 VDD VDD pmos W=0.205u L=0.04u
M13569 U5031/net36 n4554 U5031/net24 VSS nmos W=0.155u L=0.04u
M13570 U5031/net24 n4645 VSS VSS nmos W=0.155u L=0.04u
M13571 n4649 n4670 U5031/net36 VSS nmos W=0.155u L=0.04u
M13572 n4649 n4666 U5031/net36 VSS nmos W=0.155u L=0.04u
M13573 n4649 n4666 U5031/net35 VDD pmos W=0.205u L=0.04u
M13574 U5031/net35 n4670 VDD VDD pmos W=0.205u L=0.04u
M13575 n4649 n4645 VDD VDD pmos W=0.205u L=0.04u
M13576 n4649 n4554 VDD VDD pmos W=0.205u L=0.04u
M13577 U5032/p2 n4674 VSS VSS nmos W=0.155u L=0.04u
M13578 U5032/p0 n4672 U5032/p1 VSS nmos W=0.155u L=0.04u
M13579 U5032/p1 n4673 U5032/p2 VSS nmos W=0.155u L=0.04u
M13580 n4666 n4671 U5032/p0 VSS nmos W=0.155u L=0.04u
M13581 n4666 n4673 VDD VDD pmos W=0.205u L=0.04u
M13582 n4666 n4672 VDD VDD pmos W=0.205u L=0.04u
M13583 n4666 n4671 VDD VDD pmos W=0.205u L=0.04u
M13584 n4666 n4674 VDD VDD pmos W=0.205u L=0.04u
M13585 U5033/net7 n4675 U5033/X_u4-net10 VSS nmos W=0.155u L=0.04u
M13586 U5033/X_u4-net10 n4676 U5033/X_u4-net13 VSS nmos W=0.155u L=0.04u
M13587 U5033/X_u4-net13 n4677 VSS VSS nmos W=0.155u L=0.04u
M13588 n4674 U5033/net7 VSS VSS nmos W=0.155u L=0.04u
M13589 U5033/net7 n4677 VDD VDD pmos W=0.205u L=0.04u
M13590 U5033/net7 n4675 VDD VDD pmos W=0.205u L=0.04u
M13591 U5033/net7 n4676 VDD VDD pmos W=0.205u L=0.04u
M13592 n4674 U5033/net7 VDD VDD pmos W=0.205u L=0.04u
M13593 n4668 n4644 U5034/net27 VSS nmos W=0.155u L=0.04u
M13594 U5034/net27 n4678 VSS VSS nmos W=0.155u L=0.04u
M13595 n4668 n4663 VSS VSS nmos W=0.155u L=0.04u
M13596 n4668 n4678 U5034/net13 VDD pmos W=0.205u L=0.04u
M13597 U5034/net13 n4663 VDD VDD pmos W=0.205u L=0.04u
M13598 n4668 n4644 U5034/net13 VDD pmos W=0.205u L=0.04u
M13599 n4663 n4679 VSS VSS nmos W=0.135u L=0.04u
M13600 n4663 n4679 VDD VDD pmos W=0.205u L=0.04u
M13601 n4554 n4562 VSS VSS nmos W=0.135u L=0.04u
M13602 n4554 n4562 VDD VDD pmos W=0.205u L=0.04u
M13603 U5037/net19 n4550 VSS VSS nmos W=0.155u L=0.04u
M13604 n3184 n4550 U5037/net40 VSS nmos W=0.155u L=0.04u
M13605 n3184 U5037/net19 U5037/net36 VSS nmos W=0.155u L=0.04u
M13606 U5037/net40 g2336 VSS VSS nmos W=0.31u L=0.04u
M13607 U5037/net36 n4680 VSS VSS nmos W=0.155u L=0.04u
M13608 U5037/net19 n4550 VDD VDD pmos W=0.205u L=0.04u
M13609 n3184 U5037/net19 U5037/net26 VDD pmos W=0.325u L=0.04u
M13610 U5037/net26 g2336 VDD VDD pmos W=0.41u L=0.04u
M13611 n3184 n4550 U5037/net30 VDD pmos W=0.325u L=0.04u
M13612 U5037/net30 n4680 VDD VDD pmos W=0.205u L=0.04u
M13613 U5038/net19 n4549 VSS VSS nmos W=0.155u L=0.04u
M13614 n3183 n4549 U5038/net40 VSS nmos W=0.155u L=0.04u
M13615 n3183 U5038/net19 U5038/net36 VSS nmos W=0.155u L=0.04u
M13616 U5038/net40 g2339 VSS VSS nmos W=0.31u L=0.04u
M13617 U5038/net36 n4680 VSS VSS nmos W=0.155u L=0.04u
M13618 U5038/net19 n4549 VDD VDD pmos W=0.205u L=0.04u
M13619 n3183 U5038/net19 U5038/net26 VDD pmos W=0.325u L=0.04u
M13620 U5038/net26 g2339 VDD VDD pmos W=0.41u L=0.04u
M13621 n3183 n4549 U5038/net30 VDD pmos W=0.325u L=0.04u
M13622 U5038/net30 n4680 VDD VDD pmos W=0.205u L=0.04u
M13623 U5039/net19 n4548 VSS VSS nmos W=0.155u L=0.04u
M13624 n3182 n4548 U5039/net40 VSS nmos W=0.155u L=0.04u
M13625 n3182 U5039/net19 U5039/net36 VSS nmos W=0.155u L=0.04u
M13626 U5039/net40 g2333 VSS VSS nmos W=0.31u L=0.04u
M13627 U5039/net36 n4680 VSS VSS nmos W=0.155u L=0.04u
M13628 U5039/net19 n4548 VDD VDD pmos W=0.205u L=0.04u
M13629 n3182 U5039/net19 U5039/net26 VDD pmos W=0.325u L=0.04u
M13630 U5039/net26 g2333 VDD VDD pmos W=0.41u L=0.04u
M13631 n3182 n4548 U5039/net30 VDD pmos W=0.325u L=0.04u
M13632 U5039/net30 n4680 VDD VDD pmos W=0.205u L=0.04u
M13633 n4680 n4575 U5040/net10 VSS nmos W=0.155u L=0.04u
M13634 U5040/net10 n4681 VSS VSS nmos W=0.155u L=0.04u
M13635 n4680 n4590 U5040/net10 VSS nmos W=0.155u L=0.04u
M13636 U5040/net10 n4591 VSS VSS nmos W=0.155u L=0.04u
M13637 U5040/net30 n4681 VDD VDD pmos W=0.205u L=0.04u
M13638 n4680 n4575 U5040/net24 VDD pmos W=0.205u L=0.04u
M13639 U5040/net24 n4590 VDD VDD pmos W=0.205u L=0.04u
M13640 n4680 n4591 U5040/net30 VDD pmos W=0.205u L=0.04u
M13641 U5041/net4 n4682 U5041/net14 VSS nmos W=0.155u L=0.04u
M13642 U5041/net6 U5041/net10 U5041/net14 VSS nmos W=0.17u L=0.04u
M13643 U5041/net4 n4683 VSS VSS nmos W=0.155u L=0.04u
M13644 U5041/net6 U5041/net4 VSS VSS nmos W=0.17u L=0.04u
M13645 n4681 U5041/net14 VSS VSS nmos W=0.155u L=0.04u
M13646 U5041/net10 n4682 VSS VSS nmos W=0.155u L=0.04u
M13647 U5041/net4 U5041/net10 U5041/net14 VDD pmos W=0.255u L=0.04u
M13648 U5041/net6 n4682 U5041/net14 VDD pmos W=0.28u L=0.04u
M13649 U5041/net4 n4683 VDD VDD pmos W=0.205u L=0.04u
M13650 U5041/net6 U5041/net4 VDD VDD pmos W=0.24u L=0.04u
M13651 n4681 U5041/net14 VDD VDD pmos W=0.205u L=0.04u
M13652 U5041/net10 n4682 VDD VDD pmos W=0.205u L=0.04u
M13653 n4682 n4684 U5042/net15 VSS nmos W=0.155u L=0.04u
M13654 n4682 n4685 U5042/net15 VSS nmos W=0.155u L=0.04u
M13655 U5042/net15 n4620 VSS VSS nmos W=0.155u L=0.04u
M13656 n4682 n4620 VDD VDD pmos W=0.205u L=0.04u
M13657 n4682 n4684 U5042/XI16-net11 VDD pmos W=0.205u L=0.04u
M13658 U5042/XI16-net11 n4685 VDD VDD pmos W=0.205u L=0.04u
M13659 n4620 n4684 U5043/net27 VSS nmos W=0.155u L=0.04u
M13660 U5043/net27 n4685 VSS VSS nmos W=0.155u L=0.04u
M13661 n4620 n4593 VSS VSS nmos W=0.155u L=0.04u
M13662 n4620 n4685 U5043/net13 VDD pmos W=0.205u L=0.04u
M13663 U5043/net13 n4593 VDD VDD pmos W=0.205u L=0.04u
M13664 n4620 n4684 U5043/net13 VDD pmos W=0.205u L=0.04u
M13665 n4593 n4600 U5044/XI0-net10 VSS nmos W=0.155u L=0.04u
M13666 U5044/XI0-net10 n4686 U5044/XI0-net13 VSS nmos W=0.155u L=0.04u
M13667 U5044/XI0-net13 n4599 VSS VSS nmos W=0.155u L=0.04u
M13668 n4593 n4599 VDD VDD pmos W=0.205u L=0.04u
M13669 n4593 n4600 VDD VDD pmos W=0.205u L=0.04u
M13670 n4593 n4686 VDD VDD pmos W=0.205u L=0.04u
M13671 n4599 n4627 VSS VSS nmos W=0.155u L=0.04u
M13672 n4599 U5045/net4 VSS VSS nmos W=0.155u L=0.04u
M13673 U5045/net4 n4687 VSS VSS nmos W=0.155u L=0.04u
M13674 U5045/XU1-net8 U5045/net4 VDD VDD pmos W=0.205u L=0.04u
M13675 n4599 n4627 U5045/XU1-net8 VDD pmos W=0.205u L=0.04u
M13676 U5045/net4 n4687 VDD VDD pmos W=0.205u L=0.04u
M13677 n4627 n4626 U5046/net15 VSS nmos W=0.155u L=0.04u
M13678 n4627 n4588 U5046/net15 VSS nmos W=0.155u L=0.04u
M13679 U5046/net15 n4630 VSS VSS nmos W=0.155u L=0.04u
M13680 n4627 n4630 VDD VDD pmos W=0.205u L=0.04u
M13681 n4627 n4626 U5046/XI16-net11 VDD pmos W=0.205u L=0.04u
M13682 U5046/XI16-net11 n4588 VDD VDD pmos W=0.205u L=0.04u
M13683 U5047/net7 n4688 U5047/X_u4-net10 VSS nmos W=0.155u L=0.04u
M13684 U5047/X_u4-net10 n4636 U5047/X_u4-net13 VSS nmos W=0.155u L=0.04u
M13685 U5047/X_u4-net13 n4635 VSS VSS nmos W=0.155u L=0.04u
M13686 n4630 U5047/net7 VSS VSS nmos W=0.155u L=0.04u
M13687 U5047/net7 n4635 VDD VDD pmos W=0.205u L=0.04u
M13688 U5047/net7 n4688 VDD VDD pmos W=0.205u L=0.04u
M13689 U5047/net7 n4636 VDD VDD pmos W=0.205u L=0.04u
M13690 n4630 U5047/net7 VDD VDD pmos W=0.205u L=0.04u
M13691 U5048/net4 n4685 U5048/net14 VSS nmos W=0.155u L=0.04u
M13692 U5048/net6 U5048/net10 U5048/net14 VSS nmos W=0.17u L=0.04u
M13693 U5048/net4 n4607 VSS VSS nmos W=0.155u L=0.04u
M13694 U5048/net6 U5048/net4 VSS VSS nmos W=0.17u L=0.04u
M13695 n4635 U5048/net14 VSS VSS nmos W=0.155u L=0.04u
M13696 U5048/net10 n4685 VSS VSS nmos W=0.155u L=0.04u
M13697 U5048/net4 U5048/net10 U5048/net14 VDD pmos W=0.255u L=0.04u
M13698 U5048/net6 n4685 U5048/net14 VDD pmos W=0.28u L=0.04u
M13699 U5048/net4 n4607 VDD VDD pmos W=0.205u L=0.04u
M13700 U5048/net6 U5048/net4 VDD VDD pmos W=0.24u L=0.04u
M13701 n4635 U5048/net14 VDD VDD pmos W=0.205u L=0.04u
M13702 U5048/net10 n4685 VDD VDD pmos W=0.205u L=0.04u
M13703 U5049/net4 n4588 U5049/net14 VSS nmos W=0.155u L=0.04u
M13704 U5049/net6 U5049/net10 U5049/net14 VSS nmos W=0.17u L=0.04u
M13705 U5049/net4 n4689 VSS VSS nmos W=0.155u L=0.04u
M13706 U5049/net6 U5049/net4 VSS VSS nmos W=0.17u L=0.04u
M13707 n4688 U5049/net14 VSS VSS nmos W=0.155u L=0.04u
M13708 U5049/net10 n4588 VSS VSS nmos W=0.155u L=0.04u
M13709 U5049/net4 U5049/net10 U5049/net14 VDD pmos W=0.255u L=0.04u
M13710 U5049/net6 n4588 U5049/net14 VDD pmos W=0.28u L=0.04u
M13711 U5049/net4 n4689 VDD VDD pmos W=0.205u L=0.04u
M13712 U5049/net6 U5049/net4 VDD VDD pmos W=0.24u L=0.04u
M13713 n4688 U5049/net14 VDD VDD pmos W=0.205u L=0.04u
M13714 U5049/net10 n4588 VDD VDD pmos W=0.205u L=0.04u
M13715 U5050/net19 n4690 VSS VSS nmos W=0.155u L=0.04u
M13716 n4687 n4690 U5050/net40 VSS nmos W=0.155u L=0.04u
M13717 n4687 U5050/net19 U5050/net36 VSS nmos W=0.155u L=0.04u
M13718 U5050/net40 n4626 VSS VSS nmos W=0.31u L=0.04u
M13719 U5050/net36 n4588 VSS VSS nmos W=0.155u L=0.04u
M13720 U5050/net19 n4690 VDD VDD pmos W=0.205u L=0.04u
M13721 n4687 U5050/net19 U5050/net26 VDD pmos W=0.325u L=0.04u
M13722 U5050/net26 n4626 VDD VDD pmos W=0.41u L=0.04u
M13723 n4687 n4690 U5050/net30 VDD pmos W=0.325u L=0.04u
M13724 U5050/net30 n4588 VDD VDD pmos W=0.205u L=0.04u
M13725 U5051/net4 n4588 U5051/net14 VSS nmos W=0.155u L=0.04u
M13726 U5051/net6 U5051/net10 U5051/net14 VSS nmos W=0.17u L=0.04u
M13727 U5051/net4 n4691 VSS VSS nmos W=0.155u L=0.04u
M13728 U5051/net6 U5051/net4 VSS VSS nmos W=0.17u L=0.04u
M13729 n4686 U5051/net14 VSS VSS nmos W=0.155u L=0.04u
M13730 U5051/net10 n4588 VSS VSS nmos W=0.155u L=0.04u
M13731 U5051/net4 U5051/net10 U5051/net14 VDD pmos W=0.255u L=0.04u
M13732 U5051/net6 n4588 U5051/net14 VDD pmos W=0.28u L=0.04u
M13733 U5051/net4 n4691 VDD VDD pmos W=0.205u L=0.04u
M13734 U5051/net6 U5051/net4 VDD VDD pmos W=0.24u L=0.04u
M13735 n4686 U5051/net14 VDD VDD pmos W=0.205u L=0.04u
M13736 U5051/net10 n4588 VDD VDD pmos W=0.205u L=0.04u
M13737 U5052/net4 n4588 U5052/net14 VSS nmos W=0.155u L=0.04u
M13738 U5052/net6 U5052/net10 U5052/net14 VSS nmos W=0.17u L=0.04u
M13739 U5052/net4 n4603 VSS VSS nmos W=0.155u L=0.04u
M13740 U5052/net6 U5052/net4 VSS VSS nmos W=0.17u L=0.04u
M13741 n4600 U5052/net14 VSS VSS nmos W=0.155u L=0.04u
M13742 U5052/net10 n4588 VSS VSS nmos W=0.155u L=0.04u
M13743 U5052/net4 U5052/net10 U5052/net14 VDD pmos W=0.255u L=0.04u
M13744 U5052/net6 n4588 U5052/net14 VDD pmos W=0.28u L=0.04u
M13745 U5052/net4 n4603 VDD VDD pmos W=0.205u L=0.04u
M13746 U5052/net6 U5052/net4 VDD VDD pmos W=0.24u L=0.04u
M13747 n4600 U5052/net14 VDD VDD pmos W=0.205u L=0.04u
M13748 U5052/net10 n4588 VDD VDD pmos W=0.205u L=0.04u
M13749 U5053/XU1-net6 n4618 VSS VSS nmos W=0.155u L=0.04u
M13750 n4590 n4591 U5053/XU1-net6 VSS nmos W=0.155u L=0.04u
M13751 n4590 n4618 VDD VDD pmos W=0.155u L=0.04u
M13752 n4590 n4591 VDD VDD pmos W=0.155u L=0.04u
M13753 U5054/net36 n4636 U5054/net24 VSS nmos W=0.155u L=0.04u
M13754 U5054/net24 n4694 VSS VSS nmos W=0.155u L=0.04u
M13755 n4618 n4692 U5054/net36 VSS nmos W=0.155u L=0.04u
M13756 n4618 n4693 U5054/net36 VSS nmos W=0.155u L=0.04u
M13757 n4618 n4693 U5054/net35 VDD pmos W=0.205u L=0.04u
M13758 U5054/net35 n4692 VDD VDD pmos W=0.205u L=0.04u
M13759 n4618 n4694 VDD VDD pmos W=0.205u L=0.04u
M13760 n4618 n4636 VDD VDD pmos W=0.205u L=0.04u
M13761 n4636 n4606 VSS VSS nmos W=0.135u L=0.04u
M13762 n4636 n4606 VDD VDD pmos W=0.205u L=0.04u
M13763 n4591 n4606 U5056/net15 VSS nmos W=0.155u L=0.04u
M13764 n4591 n4695 U5056/net15 VSS nmos W=0.155u L=0.04u
M13765 U5056/net15 n4694 VSS VSS nmos W=0.155u L=0.04u
M13766 n4591 n4694 VDD VDD pmos W=0.205u L=0.04u
M13767 n4591 n4606 U5056/XI16-net11 VDD pmos W=0.205u L=0.04u
M13768 U5056/XI16-net11 n4695 VDD VDD pmos W=0.205u L=0.04u
M13769 U5057/net32 n4696 U5057/net26 VSS nmos W=0.155u L=0.04u
M13770 U5057/net32 n4662 U5057/net26 VSS nmos W=0.155u L=0.04u
M13771 U5057/net29 n4584 VSS VSS nmos W=0.155u L=0.04u
M13772 U5057/net26 n4667 U5057/net29 VSS nmos W=0.155u L=0.04u
M13773 U5057/net26 n4586 U5057/net29 VSS nmos W=0.155u L=0.04u
M13774 n4694 U5057/net32 VSS VSS nmos W=0.155u L=0.04u
M13775 n4694 U5057/net32 VDD VDD pmos W=0.205u L=0.04u
M13776 U5057/net32 n4662 U5057/net43 VDD pmos W=0.205u L=0.04u
M13777 U5057/net32 n4586 U5057/net49 VDD pmos W=0.205u L=0.04u
M13778 U5057/net49 n4667 VDD VDD pmos W=0.205u L=0.04u
M13779 U5057/net43 n4696 VDD VDD pmos W=0.205u L=0.04u
M13780 U5057/net32 n4584 VDD VDD pmos W=0.205u L=0.04u
M13781 U5058/XU1-net6 n4580 VSS VSS nmos W=0.155u L=0.04u
M13782 n4584 n4581 U5058/XU1-net6 VSS nmos W=0.155u L=0.04u
M13783 n4584 n4580 VDD VDD pmos W=0.155u L=0.04u
M13784 n4584 n4581 VDD VDD pmos W=0.155u L=0.04u
M13785 n4580 n4529 U5059/net27 VSS nmos W=0.155u L=0.04u
M13786 U5059/net39 n4330 VSS VSS nmos W=0.155u L=0.04u
M13787 U5059/net27 g2477 U5059/net39 VSS nmos W=0.155u L=0.04u
M13788 U5059/net27 n4530 U5059/net39 VSS nmos W=0.155u L=0.04u
M13789 n4580 g2478 U5059/net27 VSS nmos W=0.155u L=0.04u
M13790 U5059/net39 g2479 VSS VSS nmos W=0.155u L=0.04u
M13791 n4580 n4330 U5059/net46 VDD pmos W=0.205u L=0.04u
M13792 U5059/net46 g2479 VDD VDD pmos W=0.205u L=0.04u
M13793 n4580 g2478 U5059/net34 VDD pmos W=0.205u L=0.04u
M13794 U5059/net34 n4529 VDD VDD pmos W=0.205u L=0.04u
M13795 n4580 n4530 U5059/net37 VDD pmos W=0.205u L=0.04u
M13796 U5059/net37 g2477 VDD VDD pmos W=0.205u L=0.04u
M13797 n4586 n3957 VSS VSS nmos W=0.135u L=0.04u
M13798 n4586 n3957 VDD VDD pmos W=0.205u L=0.04u
M13799 n3957 n4652 VSS VSS nmos W=0.155u L=0.04u
M13800 n3957 n4645 VSS VSS nmos W=0.155u L=0.04u
M13801 n3957 n4662 VSS VSS nmos W=0.155u L=0.04u
M13802 U5061/net25 n4652 VDD VDD pmos W=0.41u L=0.04u
M13803 U5061/net28 n4645 U5061/net25 VDD pmos W=0.41u L=0.04u
M13804 n3957 n4662 U5061/net28 VDD pmos W=0.41u L=0.04u
M13805 U5062/XU1-net6 n4678 VSS VSS nmos W=0.155u L=0.04u
M13806 n4667 n4581 U5062/XU1-net6 VSS nmos W=0.155u L=0.04u
M13807 n4667 n4678 VDD VDD pmos W=0.155u L=0.04u
M13808 n4667 n4581 VDD VDD pmos W=0.155u L=0.04u
M13809 n4581 n4697 VSS VSS nmos W=0.135u L=0.04u
M13810 n4581 n4697 VDD VDD pmos W=0.205u L=0.04u
M13811 n4696 n4654 U5064/net19 VDD pmos W=0.205u L=0.04u
M13812 n4696 n4644 U5064/net19 VDD pmos W=0.205u L=0.04u
M13813 n4696 n4678 U5064/net19 VDD pmos W=0.205u L=0.04u
M13814 U5064/net19 n4562 VDD VDD pmos W=0.205u L=0.04u
M13815 n4696 n4562 VSS VSS nmos W=0.155u L=0.04u
M13816 U5064/XI20-net13 n4644 VSS VSS nmos W=0.155u L=0.04u
M13817 n4696 n4654 U5064/XI20-net17 VSS nmos W=0.155u L=0.04u
M13818 U5064/XI20-net17 n4678 U5064/XI20-net13 VSS nmos W=0.155u L=0.04u
M13819 n4562 n4698 VSS VSS nmos W=0.155u L=0.04u
M13820 n4562 U5065/net4 VSS VSS nmos W=0.155u L=0.04u
M13821 U5065/net4 g2257 VSS VSS nmos W=0.155u L=0.04u
M13822 U5065/XU1-net8 U5065/net4 VDD VDD pmos W=0.205u L=0.04u
M13823 n4562 n4698 U5065/XU1-net8 VDD pmos W=0.205u L=0.04u
M13824 U5065/net4 g2257 VDD VDD pmos W=0.205u L=0.04u
M13825 n4644 n4585 VSS VSS nmos W=0.155u L=0.04u
M13826 n4644 n4697 VSS VSS nmos W=0.155u L=0.04u
M13827 U5066/XI1-net8 n4697 VDD VDD pmos W=0.205u L=0.04u
M13828 n4644 n4585 U5066/XI1-net8 VDD pmos W=0.205u L=0.04u
M13829 U5067/p2 n4702 VSS VSS nmos W=0.155u L=0.04u
M13830 U5067/p0 n4700 U5067/p1 VSS nmos W=0.155u L=0.04u
M13831 U5067/p1 n4701 U5067/p2 VSS nmos W=0.155u L=0.04u
M13832 n4697 n4699 U5067/p0 VSS nmos W=0.155u L=0.04u
M13833 n4697 n4701 VDD VDD pmos W=0.205u L=0.04u
M13834 n4697 n4700 VDD VDD pmos W=0.205u L=0.04u
M13835 n4697 n4699 VDD VDD pmos W=0.205u L=0.04u
M13836 n4697 n4702 VDD VDD pmos W=0.205u L=0.04u
M13837 n4702 n4706 VSS VSS nmos W=0.155u L=0.04u
M13838 n4702 n4705 VSS VSS nmos W=0.155u L=0.04u
M13839 n4702 n4704 VSS VSS nmos W=0.155u L=0.04u
M13840 n4702 n4703 VSS VSS nmos W=0.155u L=0.04u
M13841 U5068/net49 n4705 U5068/net52 VDD pmos W=0.41u L=0.04u
M13842 U5068/net52 n4706 VDD VDD pmos W=0.41u L=0.04u
M13843 U5068/net46 n4704 U5068/net49 VDD pmos W=0.41u L=0.04u
M13844 n4702 n4703 U5068/net46 VDD pmos W=0.41u L=0.04u
M13845 U5069/net4 n4707 U5069/net14 VSS nmos W=0.155u L=0.04u
M13846 U5069/net6 U5069/net10 U5069/net14 VSS nmos W=0.17u L=0.04u
M13847 U5069/net4 g2170 VSS VSS nmos W=0.155u L=0.04u
M13848 U5069/net6 U5069/net4 VSS VSS nmos W=0.17u L=0.04u
M13849 n4706 U5069/net14 VSS VSS nmos W=0.155u L=0.04u
M13850 U5069/net10 n4707 VSS VSS nmos W=0.155u L=0.04u
M13851 U5069/net4 U5069/net10 U5069/net14 VDD pmos W=0.255u L=0.04u
M13852 U5069/net6 n4707 U5069/net14 VDD pmos W=0.28u L=0.04u
M13853 U5069/net4 g2170 VDD VDD pmos W=0.205u L=0.04u
M13854 U5069/net6 U5069/net4 VDD VDD pmos W=0.24u L=0.04u
M13855 n4706 U5069/net14 VDD VDD pmos W=0.205u L=0.04u
M13856 U5069/net10 n4707 VDD VDD pmos W=0.205u L=0.04u
M13857 U5070/net36 g2208 U5070/net27 VSS nmos W=0.155u L=0.04u
M13858 U5070/net39 g2209 VSS VSS nmos W=0.155u L=0.04u
M13859 U5070/net27 n4550 U5070/net39 VSS nmos W=0.155u L=0.04u
M13860 U5070/net27 g2210 U5070/net39 VSS nmos W=0.155u L=0.04u
M13861 U5070/net36 n4549 U5070/net27 VSS nmos W=0.155u L=0.04u
M13862 U5070/net39 n4548 VSS VSS nmos W=0.155u L=0.04u
M13863 n4707 U5070/net36 VSS VSS nmos W=0.155u L=0.04u
M13864 n4707 U5070/net36 VDD VDD pmos W=0.205u L=0.04u
M13865 U5070/net36 g2209 U5070/net46 VDD pmos W=0.205u L=0.04u
M13866 U5070/net46 n4548 VDD VDD pmos W=0.205u L=0.04u
M13867 U5070/net36 n4549 U5070/net34 VDD pmos W=0.205u L=0.04u
M13868 U5070/net34 g2208 VDD VDD pmos W=0.205u L=0.04u
M13869 U5070/net36 g2210 U5070/net37 VDD pmos W=0.205u L=0.04u
M13870 U5070/net37 n4550 VDD VDD pmos W=0.205u L=0.04u
M13871 U5071/net4 n4708 U5071/net14 VSS nmos W=0.155u L=0.04u
M13872 U5071/net6 U5071/net10 U5071/net14 VSS nmos W=0.17u L=0.04u
M13873 U5071/net4 g2180 VSS VSS nmos W=0.155u L=0.04u
M13874 U5071/net6 U5071/net4 VSS VSS nmos W=0.17u L=0.04u
M13875 n4705 U5071/net14 VSS VSS nmos W=0.155u L=0.04u
M13876 U5071/net10 n4708 VSS VSS nmos W=0.155u L=0.04u
M13877 U5071/net4 U5071/net10 U5071/net14 VDD pmos W=0.255u L=0.04u
M13878 U5071/net6 n4708 U5071/net14 VDD pmos W=0.28u L=0.04u
M13879 U5071/net4 g2180 VDD VDD pmos W=0.205u L=0.04u
M13880 U5071/net6 U5071/net4 VDD VDD pmos W=0.24u L=0.04u
M13881 n4705 U5071/net14 VDD VDD pmos W=0.205u L=0.04u
M13882 U5071/net10 n4708 VDD VDD pmos W=0.205u L=0.04u
M13883 U5072/net36 g2220 U5072/net27 VSS nmos W=0.155u L=0.04u
M13884 U5072/net39 g2221 VSS VSS nmos W=0.155u L=0.04u
M13885 U5072/net27 n4550 U5072/net39 VSS nmos W=0.155u L=0.04u
M13886 U5072/net27 g2222 U5072/net39 VSS nmos W=0.155u L=0.04u
M13887 U5072/net36 n4549 U5072/net27 VSS nmos W=0.155u L=0.04u
M13888 U5072/net39 n4548 VSS VSS nmos W=0.155u L=0.04u
M13889 n4708 U5072/net36 VSS VSS nmos W=0.155u L=0.04u
M13890 n4708 U5072/net36 VDD VDD pmos W=0.205u L=0.04u
M13891 U5072/net36 g2221 U5072/net46 VDD pmos W=0.205u L=0.04u
M13892 U5072/net46 n4548 VDD VDD pmos W=0.205u L=0.04u
M13893 U5072/net36 n4549 U5072/net34 VDD pmos W=0.205u L=0.04u
M13894 U5072/net34 g2220 VDD VDD pmos W=0.205u L=0.04u
M13895 U5072/net36 g2222 U5072/net37 VDD pmos W=0.205u L=0.04u
M13896 U5072/net37 n4550 VDD VDD pmos W=0.205u L=0.04u
M13897 U5073/net4 n4709 U5073/net14 VSS nmos W=0.155u L=0.04u
M13898 U5073/net6 U5073/net10 U5073/net14 VSS nmos W=0.17u L=0.04u
M13899 U5073/net4 g2195 VSS VSS nmos W=0.155u L=0.04u
M13900 U5073/net6 U5073/net4 VSS VSS nmos W=0.17u L=0.04u
M13901 n4704 U5073/net14 VSS VSS nmos W=0.155u L=0.04u
M13902 U5073/net10 n4709 VSS VSS nmos W=0.155u L=0.04u
M13903 U5073/net4 U5073/net10 U5073/net14 VDD pmos W=0.255u L=0.04u
M13904 U5073/net6 n4709 U5073/net14 VDD pmos W=0.28u L=0.04u
M13905 U5073/net4 g2195 VDD VDD pmos W=0.205u L=0.04u
M13906 U5073/net6 U5073/net4 VDD VDD pmos W=0.24u L=0.04u
M13907 n4704 U5073/net14 VDD VDD pmos W=0.205u L=0.04u
M13908 U5073/net10 n4709 VDD VDD pmos W=0.205u L=0.04u
M13909 U5074/net36 g2229 U5074/net27 VSS nmos W=0.155u L=0.04u
M13910 U5074/net39 g2230 VSS VSS nmos W=0.155u L=0.04u
M13911 U5074/net27 n4550 U5074/net39 VSS nmos W=0.155u L=0.04u
M13912 U5074/net27 g2231 U5074/net39 VSS nmos W=0.155u L=0.04u
M13913 U5074/net36 n4549 U5074/net27 VSS nmos W=0.155u L=0.04u
M13914 U5074/net39 n4548 VSS VSS nmos W=0.155u L=0.04u
M13915 n4709 U5074/net36 VSS VSS nmos W=0.155u L=0.04u
M13916 n4709 U5074/net36 VDD VDD pmos W=0.205u L=0.04u
M13917 U5074/net36 g2230 U5074/net46 VDD pmos W=0.205u L=0.04u
M13918 U5074/net46 n4548 VDD VDD pmos W=0.205u L=0.04u
M13919 U5074/net36 n4549 U5074/net34 VDD pmos W=0.205u L=0.04u
M13920 U5074/net34 g2229 VDD VDD pmos W=0.205u L=0.04u
M13921 U5074/net36 g2231 U5074/net37 VDD pmos W=0.205u L=0.04u
M13922 U5074/net37 n4550 VDD VDD pmos W=0.205u L=0.04u
M13923 n4703 n4710 U5075/XI0-net10 VSS nmos W=0.155u L=0.04u
M13924 U5075/XI0-net10 n4711 U5075/XI0-net13 VSS nmos W=0.155u L=0.04u
M13925 U5075/XI0-net13 n4712 VSS VSS nmos W=0.155u L=0.04u
M13926 n4703 n4712 VDD VDD pmos W=0.205u L=0.04u
M13927 n4703 n4710 VDD VDD pmos W=0.205u L=0.04u
M13928 n4703 n4711 VDD VDD pmos W=0.205u L=0.04u
M13929 U5076/net4 n4521 U5076/net14 VSS nmos W=0.155u L=0.04u
M13930 U5076/net6 U5076/net10 U5076/net14 VSS nmos W=0.17u L=0.04u
M13931 U5076/net4 n4713 VSS VSS nmos W=0.155u L=0.04u
M13932 U5076/net6 U5076/net4 VSS VSS nmos W=0.17u L=0.04u
M13933 n4712 U5076/net14 VSS VSS nmos W=0.155u L=0.04u
M13934 U5076/net10 n4521 VSS VSS nmos W=0.155u L=0.04u
M13935 U5076/net4 U5076/net10 U5076/net14 VDD pmos W=0.255u L=0.04u
M13936 U5076/net6 n4521 U5076/net14 VDD pmos W=0.28u L=0.04u
M13937 U5076/net4 n4713 VDD VDD pmos W=0.205u L=0.04u
M13938 U5076/net6 U5076/net4 VDD VDD pmos W=0.24u L=0.04u
M13939 n4712 U5076/net14 VDD VDD pmos W=0.205u L=0.04u
M13940 U5076/net10 n4521 VDD VDD pmos W=0.205u L=0.04u
M13941 U5077/net36 g2205 U5077/net27 VSS nmos W=0.155u L=0.04u
M13942 U5077/net39 g2206 VSS VSS nmos W=0.155u L=0.04u
M13943 U5077/net27 n4550 U5077/net39 VSS nmos W=0.155u L=0.04u
M13944 U5077/net27 g2207 U5077/net39 VSS nmos W=0.155u L=0.04u
M13945 U5077/net36 n4549 U5077/net27 VSS nmos W=0.155u L=0.04u
M13946 U5077/net39 n4548 VSS VSS nmos W=0.155u L=0.04u
M13947 n4713 U5077/net36 VSS VSS nmos W=0.155u L=0.04u
M13948 n4713 U5077/net36 VDD VDD pmos W=0.205u L=0.04u
M13949 U5077/net36 g2206 U5077/net46 VDD pmos W=0.205u L=0.04u
M13950 U5077/net46 n4548 VDD VDD pmos W=0.205u L=0.04u
M13951 U5077/net36 n4549 U5077/net34 VDD pmos W=0.205u L=0.04u
M13952 U5077/net34 g2205 VDD VDD pmos W=0.205u L=0.04u
M13953 U5077/net36 g2207 U5077/net37 VDD pmos W=0.205u L=0.04u
M13954 U5077/net37 n4550 VDD VDD pmos W=0.205u L=0.04u
M13955 U5078/net4 n4575 U5078/net14 VSS nmos W=0.155u L=0.04u
M13956 U5078/net6 U5078/net10 U5078/net14 VSS nmos W=0.17u L=0.04u
M13957 U5078/net4 n4714 VSS VSS nmos W=0.155u L=0.04u
M13958 U5078/net6 U5078/net4 VSS VSS nmos W=0.17u L=0.04u
M13959 n4711 U5078/net14 VSS VSS nmos W=0.155u L=0.04u
M13960 U5078/net10 n4575 VSS VSS nmos W=0.155u L=0.04u
M13961 U5078/net4 U5078/net10 U5078/net14 VDD pmos W=0.255u L=0.04u
M13962 U5078/net6 n4575 U5078/net14 VDD pmos W=0.28u L=0.04u
M13963 U5078/net4 n4714 VDD VDD pmos W=0.205u L=0.04u
M13964 U5078/net6 U5078/net4 VDD VDD pmos W=0.24u L=0.04u
M13965 n4711 U5078/net14 VDD VDD pmos W=0.205u L=0.04u
M13966 U5078/net10 n4575 VDD VDD pmos W=0.205u L=0.04u
M13967 U5079/net36 g2232 U5079/net27 VSS nmos W=0.155u L=0.04u
M13968 U5079/net39 g2233 VSS VSS nmos W=0.155u L=0.04u
M13969 U5079/net27 n4550 U5079/net39 VSS nmos W=0.155u L=0.04u
M13970 U5079/net27 g2234 U5079/net39 VSS nmos W=0.155u L=0.04u
M13971 U5079/net36 n4549 U5079/net27 VSS nmos W=0.155u L=0.04u
M13972 U5079/net39 n4548 VSS VSS nmos W=0.155u L=0.04u
M13973 n4714 U5079/net36 VSS VSS nmos W=0.155u L=0.04u
M13974 n4714 U5079/net36 VDD VDD pmos W=0.205u L=0.04u
M13975 U5079/net36 g2233 U5079/net46 VDD pmos W=0.205u L=0.04u
M13976 U5079/net46 n4548 VDD VDD pmos W=0.205u L=0.04u
M13977 U5079/net36 n4549 U5079/net34 VDD pmos W=0.205u L=0.04u
M13978 U5079/net34 g2232 VDD VDD pmos W=0.205u L=0.04u
M13979 U5079/net36 g2234 U5079/net37 VDD pmos W=0.205u L=0.04u
M13980 U5079/net37 n4550 VDD VDD pmos W=0.205u L=0.04u
M13981 U5080/net4 n4525 U5080/net14 VSS nmos W=0.155u L=0.04u
M13982 U5080/net6 U5080/net10 U5080/net14 VSS nmos W=0.17u L=0.04u
M13983 U5080/net4 n4715 VSS VSS nmos W=0.155u L=0.04u
M13984 U5080/net6 U5080/net4 VSS VSS nmos W=0.17u L=0.04u
M13985 n4710 U5080/net14 VSS VSS nmos W=0.155u L=0.04u
M13986 U5080/net10 n4525 VSS VSS nmos W=0.155u L=0.04u
M13987 U5080/net4 U5080/net10 U5080/net14 VDD pmos W=0.255u L=0.04u
M13988 U5080/net6 n4525 U5080/net14 VDD pmos W=0.28u L=0.04u
M13989 U5080/net4 n4715 VDD VDD pmos W=0.205u L=0.04u
M13990 U5080/net6 U5080/net4 VDD VDD pmos W=0.24u L=0.04u
M13991 n4710 U5080/net14 VDD VDD pmos W=0.205u L=0.04u
M13992 U5080/net10 n4525 VDD VDD pmos W=0.205u L=0.04u
M13993 U5081/net36 g2223 U5081/net27 VSS nmos W=0.155u L=0.04u
M13994 U5081/net39 g2224 VSS VSS nmos W=0.155u L=0.04u
M13995 U5081/net27 n4550 U5081/net39 VSS nmos W=0.155u L=0.04u
M13996 U5081/net27 g2225 U5081/net39 VSS nmos W=0.155u L=0.04u
M13997 U5081/net36 n4549 U5081/net27 VSS nmos W=0.155u L=0.04u
M13998 U5081/net39 n4548 VSS VSS nmos W=0.155u L=0.04u
M13999 n4715 U5081/net36 VSS VSS nmos W=0.155u L=0.04u
M14000 n4715 U5081/net36 VDD VDD pmos W=0.205u L=0.04u
M14001 U5081/net36 g2224 U5081/net46 VDD pmos W=0.205u L=0.04u
M14002 U5081/net46 n4548 VDD VDD pmos W=0.205u L=0.04u
M14003 U5081/net36 n4549 U5081/net34 VDD pmos W=0.205u L=0.04u
M14004 U5081/net34 g2223 VDD VDD pmos W=0.205u L=0.04u
M14005 U5081/net36 g2225 U5081/net37 VDD pmos W=0.205u L=0.04u
M14006 U5081/net37 n4550 VDD VDD pmos W=0.205u L=0.04u
M14007 n4701 n4717 VSS VSS nmos W=0.155u L=0.04u
M14008 n4701 n4716 VSS VSS nmos W=0.155u L=0.04u
M14009 n4701 n4670 VSS VSS nmos W=0.155u L=0.04u
M14010 U5082/net25 n4717 VDD VDD pmos W=0.41u L=0.04u
M14011 U5082/net28 n4716 U5082/net25 VDD pmos W=0.41u L=0.04u
M14012 n4701 n4670 U5082/net28 VDD pmos W=0.41u L=0.04u
M14013 U5083/net4 n4718 U5083/net14 VSS nmos W=0.155u L=0.04u
M14014 U5083/net6 U5083/net10 U5083/net14 VSS nmos W=0.17u L=0.04u
M14015 U5083/net4 g2190 VSS VSS nmos W=0.155u L=0.04u
M14016 U5083/net6 U5083/net4 VSS VSS nmos W=0.17u L=0.04u
M14017 n4717 U5083/net14 VSS VSS nmos W=0.155u L=0.04u
M14018 U5083/net10 n4718 VSS VSS nmos W=0.155u L=0.04u
M14019 U5083/net4 U5083/net10 U5083/net14 VDD pmos W=0.255u L=0.04u
M14020 U5083/net6 n4718 U5083/net14 VDD pmos W=0.28u L=0.04u
M14021 U5083/net4 g2190 VDD VDD pmos W=0.205u L=0.04u
M14022 U5083/net6 U5083/net4 VDD VDD pmos W=0.24u L=0.04u
M14023 n4717 U5083/net14 VDD VDD pmos W=0.205u L=0.04u
M14024 U5083/net10 n4718 VDD VDD pmos W=0.205u L=0.04u
M14025 U5084/net36 g2226 U5084/net27 VSS nmos W=0.155u L=0.04u
M14026 U5084/net39 g2227 VSS VSS nmos W=0.155u L=0.04u
M14027 U5084/net27 n4550 U5084/net39 VSS nmos W=0.155u L=0.04u
M14028 U5084/net27 g2228 U5084/net39 VSS nmos W=0.155u L=0.04u
M14029 U5084/net36 n4549 U5084/net27 VSS nmos W=0.155u L=0.04u
M14030 U5084/net39 n4548 VSS VSS nmos W=0.155u L=0.04u
M14031 n4718 U5084/net36 VSS VSS nmos W=0.155u L=0.04u
M14032 n4718 U5084/net36 VDD VDD pmos W=0.205u L=0.04u
M14033 U5084/net36 g2227 U5084/net46 VDD pmos W=0.205u L=0.04u
M14034 U5084/net46 n4548 VDD VDD pmos W=0.205u L=0.04u
M14035 U5084/net36 n4549 U5084/net34 VDD pmos W=0.205u L=0.04u
M14036 U5084/net34 g2226 VDD VDD pmos W=0.205u L=0.04u
M14037 U5084/net36 g2228 U5084/net37 VDD pmos W=0.205u L=0.04u
M14038 U5084/net37 n4550 VDD VDD pmos W=0.205u L=0.04u
M14039 U5085/net4 n4719 U5085/net14 VSS nmos W=0.155u L=0.04u
M14040 U5085/net6 U5085/net10 U5085/net14 VSS nmos W=0.17u L=0.04u
M14041 U5085/net4 g2175 VSS VSS nmos W=0.155u L=0.04u
M14042 U5085/net6 U5085/net4 VSS VSS nmos W=0.17u L=0.04u
M14043 n4716 U5085/net14 VSS VSS nmos W=0.155u L=0.04u
M14044 U5085/net10 n4719 VSS VSS nmos W=0.155u L=0.04u
M14045 U5085/net4 U5085/net10 U5085/net14 VDD pmos W=0.255u L=0.04u
M14046 U5085/net6 n4719 U5085/net14 VDD pmos W=0.28u L=0.04u
M14047 U5085/net4 g2175 VDD VDD pmos W=0.205u L=0.04u
M14048 U5085/net6 U5085/net4 VDD VDD pmos W=0.24u L=0.04u
M14049 n4716 U5085/net14 VDD VDD pmos W=0.205u L=0.04u
M14050 U5085/net10 n4719 VDD VDD pmos W=0.205u L=0.04u
M14051 U5086/net36 g2217 U5086/net27 VSS nmos W=0.155u L=0.04u
M14052 U5086/net39 g2218 VSS VSS nmos W=0.155u L=0.04u
M14053 U5086/net27 n4550 U5086/net39 VSS nmos W=0.155u L=0.04u
M14054 U5086/net27 g2219 U5086/net39 VSS nmos W=0.155u L=0.04u
M14055 U5086/net36 n4549 U5086/net27 VSS nmos W=0.155u L=0.04u
M14056 U5086/net39 n4548 VSS VSS nmos W=0.155u L=0.04u
M14057 n4719 U5086/net36 VSS VSS nmos W=0.155u L=0.04u
M14058 n4719 U5086/net36 VDD VDD pmos W=0.205u L=0.04u
M14059 U5086/net36 g2218 U5086/net46 VDD pmos W=0.205u L=0.04u
M14060 U5086/net46 n4548 VDD VDD pmos W=0.205u L=0.04u
M14061 U5086/net36 n4549 U5086/net34 VDD pmos W=0.205u L=0.04u
M14062 U5086/net34 g2217 VDD VDD pmos W=0.205u L=0.04u
M14063 U5086/net36 g2219 U5086/net37 VDD pmos W=0.205u L=0.04u
M14064 U5086/net37 n4550 VDD VDD pmos W=0.205u L=0.04u
M14065 U5087/net4 n4574 U5087/net14 VSS nmos W=0.155u L=0.04u
M14066 U5087/net6 U5087/net10 U5087/net14 VSS nmos W=0.17u L=0.04u
M14067 U5087/net4 n4720 VSS VSS nmos W=0.155u L=0.04u
M14068 U5087/net6 U5087/net4 VSS VSS nmos W=0.17u L=0.04u
M14069 n4700 U5087/net14 VSS VSS nmos W=0.155u L=0.04u
M14070 U5087/net10 n4574 VSS VSS nmos W=0.155u L=0.04u
M14071 U5087/net4 U5087/net10 U5087/net14 VDD pmos W=0.255u L=0.04u
M14072 U5087/net6 n4574 U5087/net14 VDD pmos W=0.28u L=0.04u
M14073 U5087/net4 n4720 VDD VDD pmos W=0.205u L=0.04u
M14074 U5087/net6 U5087/net4 VDD VDD pmos W=0.24u L=0.04u
M14075 n4700 U5087/net14 VDD VDD pmos W=0.205u L=0.04u
M14076 U5087/net10 n4574 VDD VDD pmos W=0.205u L=0.04u
M14077 n4720 n4548 U5088/net27 VSS nmos W=0.155u L=0.04u
M14078 U5088/net39 n4550 VSS VSS nmos W=0.155u L=0.04u
M14079 U5088/net27 g2238 U5088/net39 VSS nmos W=0.155u L=0.04u
M14080 U5088/net27 n4549 U5088/net39 VSS nmos W=0.155u L=0.04u
M14081 n4720 g2239 U5088/net27 VSS nmos W=0.155u L=0.04u
M14082 U5088/net39 g2240 VSS VSS nmos W=0.155u L=0.04u
M14083 n4720 n4550 U5088/net46 VDD pmos W=0.205u L=0.04u
M14084 U5088/net46 g2240 VDD VDD pmos W=0.205u L=0.04u
M14085 n4720 g2239 U5088/net34 VDD pmos W=0.205u L=0.04u
M14086 U5088/net34 n4548 VDD VDD pmos W=0.205u L=0.04u
M14087 n4720 n4549 U5088/net37 VDD pmos W=0.205u L=0.04u
M14088 U5088/net37 g2238 VDD VDD pmos W=0.205u L=0.04u
M14089 U5089/net4 n4721 U5089/net14 VSS nmos W=0.155u L=0.04u
M14090 U5089/net6 U5089/net10 U5089/net14 VSS nmos W=0.17u L=0.04u
M14091 U5089/net4 n4722 VSS VSS nmos W=0.155u L=0.04u
M14092 U5089/net6 U5089/net4 VSS VSS nmos W=0.17u L=0.04u
M14093 n4699 U5089/net14 VSS VSS nmos W=0.155u L=0.04u
M14094 U5089/net10 n4721 VSS VSS nmos W=0.155u L=0.04u
M14095 U5089/net4 U5089/net10 U5089/net14 VDD pmos W=0.255u L=0.04u
M14096 U5089/net6 n4721 U5089/net14 VDD pmos W=0.28u L=0.04u
M14097 U5089/net4 n4722 VDD VDD pmos W=0.205u L=0.04u
M14098 U5089/net6 U5089/net4 VDD VDD pmos W=0.24u L=0.04u
M14099 n4699 U5089/net14 VDD VDD pmos W=0.205u L=0.04u
M14100 U5089/net10 n4721 VDD VDD pmos W=0.205u L=0.04u
M14101 n4722 n4548 U5090/net27 VSS nmos W=0.155u L=0.04u
M14102 U5090/net39 n4550 VSS VSS nmos W=0.155u L=0.04u
M14103 U5090/net27 g2235 U5090/net39 VSS nmos W=0.155u L=0.04u
M14104 U5090/net27 n4549 U5090/net39 VSS nmos W=0.155u L=0.04u
M14105 n4722 g2236 U5090/net27 VSS nmos W=0.155u L=0.04u
M14106 U5090/net39 g2237 VSS VSS nmos W=0.155u L=0.04u
M14107 n4722 n4550 U5090/net46 VDD pmos W=0.205u L=0.04u
M14108 U5090/net46 g2237 VDD VDD pmos W=0.205u L=0.04u
M14109 n4722 g2236 U5090/net34 VDD pmos W=0.205u L=0.04u
M14110 U5090/net34 n4548 VDD VDD pmos W=0.205u L=0.04u
M14111 n4722 n4549 U5090/net37 VDD pmos W=0.205u L=0.04u
M14112 U5090/net37 g2235 VDD VDD pmos W=0.205u L=0.04u
M14113 U5091/XU1-net6 n4679 VSS VSS nmos W=0.155u L=0.04u
M14114 n4585 n4664 U5091/XU1-net6 VSS nmos W=0.155u L=0.04u
M14115 n4585 n4679 VDD VDD pmos W=0.155u L=0.04u
M14116 n4585 n4664 VDD VDD pmos W=0.155u L=0.04u
M14117 n4679 n4723 U5092/net15 VSS nmos W=0.155u L=0.04u
M14118 n4679 n4724 U5092/net15 VSS nmos W=0.155u L=0.04u
M14119 U5092/net15 n4665 VSS VSS nmos W=0.155u L=0.04u
M14120 n4679 n4665 VDD VDD pmos W=0.205u L=0.04u
M14121 n4679 n4723 U5092/XI16-net11 VDD pmos W=0.205u L=0.04u
M14122 U5092/XI16-net11 n4724 VDD VDD pmos W=0.205u L=0.04u
M14123 n4724 n4676 U5093/net14 VSS nmos W=0.155u L=0.04u
M14124 U5093/net14 n4726 VSS VSS nmos W=0.155u L=0.04u
M14125 U5093/net14 n4725 VSS VSS nmos W=0.155u L=0.04u
M14126 n4724 n4675 U5093/net14 VSS nmos W=0.155u L=0.04u
M14127 n4724 n4671 U5093/net14 VSS nmos W=0.155u L=0.04u
M14128 n4724 n4726 U5093/XI16-net11 VDD pmos W=0.205u L=0.04u
M14129 U5093/XI16-net11 n4725 VDD VDD pmos W=0.205u L=0.04u
M14130 n4724 n4675 U5093/XI15-net11 VDD pmos W=0.205u L=0.04u
M14131 U5093/XI15-net11 n4671 U5093/XI15-net18 VDD pmos W=0.205u L=0.04u
M14132 U5093/XI15-net18 n4676 VDD VDD pmos W=0.205u L=0.04u
M14133 U5094/net29 n4676 VSS VSS nmos W=0.155u L=0.04u
M14134 U5094/net26 n4728 U5094/net20 VSS nmos W=0.155u L=0.04u
M14135 U5094/net20 n4729 VSS VSS nmos W=0.155u L=0.04u
M14136 U5094/net26 n4727 U5094/net29 VSS nmos W=0.155u L=0.04u
M14137 n4726 U5094/net26 VSS VSS nmos W=0.155u L=0.04u
M14138 n4726 U5094/net26 VDD VDD pmos W=0.205u L=0.04u
M14139 U5094/net26 n4727 U5094/net40 VDD pmos W=0.205u L=0.04u
M14140 U5094/net26 n4676 U5094/net40 VDD pmos W=0.205u L=0.04u
M14141 U5094/net40 n4729 VDD VDD pmos W=0.205u L=0.04u
M14142 U5094/net40 n4728 VDD VDD pmos W=0.205u L=0.04u
M14143 n4675 U5095/net6 VSS VSS nmos W=0.155u L=0.04u
M14144 U5095/X_u2-net6 n4728 VSS VSS nmos W=0.155u L=0.04u
M14145 U5095/net6 n4727 U5095/X_u2-net6 VSS nmos W=0.155u L=0.04u
M14146 n4675 U5095/net6 VDD VDD pmos W=0.205u L=0.04u
M14147 U5095/net6 n4728 VDD VDD pmos W=0.205u L=0.04u
M14148 U5095/net6 n4727 VDD VDD pmos W=0.205u L=0.04u
M14149 n4671 U5096/net6 VSS VSS nmos W=0.155u L=0.04u
M14150 U5096/X_u2-net6 n4729 VSS VSS nmos W=0.155u L=0.04u
M14151 U5096/net6 n4725 U5096/X_u2-net6 VSS nmos W=0.155u L=0.04u
M14152 n4671 U5096/net6 VDD VDD pmos W=0.205u L=0.04u
M14153 U5096/net6 n4729 VDD VDD pmos W=0.205u L=0.04u
M14154 U5096/net6 n4725 VDD VDD pmos W=0.205u L=0.04u
M14155 n4723 n4728 VSS VSS nmos W=0.155u L=0.04u
M14156 n4723 n4729 U5097/XI17-net17 VSS nmos W=0.155u L=0.04u
M14157 U5097/XI17-net17 n4676 VSS VSS nmos W=0.155u L=0.04u
M14158 n4723 n4725 U5097/XI10-net17 VSS nmos W=0.155u L=0.04u
M14159 U5097/XI10-net17 n4727 VSS VSS nmos W=0.155u L=0.04u
M14160 U5097/net30 n4725 n4723 VDD pmos W=0.205u L=0.04u
M14161 U5097/net30 n4727 n4723 VDD pmos W=0.205u L=0.04u
M14162 VDD n4728 U5097/net36 VDD pmos W=0.205u L=0.04u
M14163 U5097/net36 n4676 U5097/net30 VDD pmos W=0.205u L=0.04u
M14164 U5097/net36 n4729 U5097/net30 VDD pmos W=0.205u L=0.04u
M14165 U5098/net4 U5098/net10 U5098/net14 VSS nmos W=0.155u L=0.04u
M14166 U5098/net6 n4689 U5098/net14 VSS nmos W=0.155u L=0.04u
M14167 U5098/net4 n4522 VSS VSS nmos W=0.155u L=0.04u
M14168 U5098/net6 U5098/net4 VSS VSS nmos W=0.155u L=0.04u
M14169 n4728 U5098/net14 VSS VSS nmos W=0.155u L=0.04u
M14170 U5098/net10 n4689 VSS VSS nmos W=0.155u L=0.04u
M14171 U5098/net4 n4689 U5098/net14 VDD pmos W=0.205u L=0.04u
M14172 U5098/net6 U5098/net10 U5098/net14 VDD pmos W=0.205u L=0.04u
M14173 U5098/net4 n4522 VDD VDD pmos W=0.205u L=0.04u
M14174 U5098/net6 U5098/net4 VDD VDD pmos W=0.205u L=0.04u
M14175 n4728 U5098/net14 VDD VDD pmos W=0.205u L=0.04u
M14176 U5098/net10 n4689 VDD VDD pmos W=0.205u L=0.04u
M14177 U5099/net4 U5099/net10 U5099/net14 VSS nmos W=0.155u L=0.04u
M14178 U5099/net6 n4691 U5099/net14 VSS nmos W=0.155u L=0.04u
M14179 U5099/net4 n4526 VSS VSS nmos W=0.155u L=0.04u
M14180 U5099/net6 U5099/net4 VSS VSS nmos W=0.155u L=0.04u
M14181 n4676 U5099/net14 VSS VSS nmos W=0.155u L=0.04u
M14182 U5099/net10 n4691 VSS VSS nmos W=0.155u L=0.04u
M14183 U5099/net4 n4691 U5099/net14 VDD pmos W=0.205u L=0.04u
M14184 U5099/net6 U5099/net10 U5099/net14 VDD pmos W=0.205u L=0.04u
M14185 U5099/net4 n4526 VDD VDD pmos W=0.205u L=0.04u
M14186 U5099/net6 U5099/net4 VDD VDD pmos W=0.205u L=0.04u
M14187 n4676 U5099/net14 VDD VDD pmos W=0.205u L=0.04u
M14188 U5099/net10 n4691 VDD VDD pmos W=0.205u L=0.04u
M14189 U5100/net4 n4690 U5100/net14 VSS nmos W=0.155u L=0.04u
M14190 U5100/net6 U5100/net10 U5100/net14 VSS nmos W=0.17u L=0.04u
M14191 U5100/net4 g2180 VSS VSS nmos W=0.155u L=0.04u
M14192 U5100/net6 U5100/net4 VSS VSS nmos W=0.17u L=0.04u
M14193 n4729 U5100/net14 VSS VSS nmos W=0.155u L=0.04u
M14194 U5100/net10 n4690 VSS VSS nmos W=0.155u L=0.04u
M14195 U5100/net4 U5100/net10 U5100/net14 VDD pmos W=0.255u L=0.04u
M14196 U5100/net6 n4690 U5100/net14 VDD pmos W=0.28u L=0.04u
M14197 U5100/net4 g2180 VDD VDD pmos W=0.205u L=0.04u
M14198 U5100/net6 U5100/net4 VDD VDD pmos W=0.24u L=0.04u
M14199 n4729 U5100/net14 VDD VDD pmos W=0.205u L=0.04u
M14200 U5100/net10 n4690 VDD VDD pmos W=0.205u L=0.04u
M14201 U5101/net4 U5101/net10 U5101/net14 VSS nmos W=0.155u L=0.04u
M14202 U5101/net6 n4621 U5101/net14 VSS nmos W=0.155u L=0.04u
M14203 U5101/net4 n4575 VSS VSS nmos W=0.155u L=0.04u
M14204 U5101/net6 U5101/net4 VSS VSS nmos W=0.155u L=0.04u
M14205 n4727 U5101/net14 VSS VSS nmos W=0.155u L=0.04u
M14206 U5101/net10 n4621 VSS VSS nmos W=0.155u L=0.04u
M14207 U5101/net4 n4621 U5101/net14 VDD pmos W=0.205u L=0.04u
M14208 U5101/net6 U5101/net10 U5101/net14 VDD pmos W=0.205u L=0.04u
M14209 U5101/net4 n4575 VDD VDD pmos W=0.205u L=0.04u
M14210 U5101/net6 U5101/net4 VDD VDD pmos W=0.205u L=0.04u
M14211 n4727 U5101/net14 VDD VDD pmos W=0.205u L=0.04u
M14212 U5101/net10 n4621 VDD VDD pmos W=0.205u L=0.04u
M14213 U5102/net4 n4574 U5102/net14 VSS nmos W=0.155u L=0.04u
M14214 U5102/net6 U5102/net10 U5102/net14 VSS nmos W=0.17u L=0.04u
M14215 U5102/net4 n4730 VSS VSS nmos W=0.155u L=0.04u
M14216 U5102/net6 U5102/net4 VSS VSS nmos W=0.17u L=0.04u
M14217 n4725 U5102/net14 VSS VSS nmos W=0.155u L=0.04u
M14218 U5102/net10 n4574 VSS VSS nmos W=0.155u L=0.04u
M14219 U5102/net4 U5102/net10 U5102/net14 VDD pmos W=0.255u L=0.04u
M14220 U5102/net6 n4574 U5102/net14 VDD pmos W=0.28u L=0.04u
M14221 U5102/net4 n4730 VDD VDD pmos W=0.205u L=0.04u
M14222 U5102/net6 U5102/net4 VDD VDD pmos W=0.24u L=0.04u
M14223 n4725 U5102/net14 VDD VDD pmos W=0.205u L=0.04u
M14224 U5102/net10 n4574 VDD VDD pmos W=0.205u L=0.04u
M14225 n4574 n4548 U5103/net27 VSS nmos W=0.155u L=0.04u
M14226 U5103/net39 n4550 VSS VSS nmos W=0.155u L=0.04u
M14227 U5103/net27 g2247 U5103/net39 VSS nmos W=0.155u L=0.04u
M14228 U5103/net27 n4549 U5103/net39 VSS nmos W=0.155u L=0.04u
M14229 n4574 g2248 U5103/net27 VSS nmos W=0.155u L=0.04u
M14230 U5103/net39 g2249 VSS VSS nmos W=0.155u L=0.04u
M14231 n4574 n4550 U5103/net46 VDD pmos W=0.205u L=0.04u
M14232 U5103/net46 g2249 VDD VDD pmos W=0.205u L=0.04u
M14233 n4574 g2248 U5103/net34 VDD pmos W=0.205u L=0.04u
M14234 U5103/net34 n4548 VDD VDD pmos W=0.205u L=0.04u
M14235 n4574 n4549 U5103/net37 VDD pmos W=0.205u L=0.04u
M14236 U5103/net37 g2247 VDD VDD pmos W=0.205u L=0.04u
M14237 n4664 n4731 U5104/net15 VSS nmos W=0.155u L=0.04u
M14238 n4664 n4732 U5104/net15 VSS nmos W=0.155u L=0.04u
M14239 U5104/net15 n4665 VSS VSS nmos W=0.155u L=0.04u
M14240 n4664 n4665 VDD VDD pmos W=0.205u L=0.04u
M14241 n4664 n4731 U5104/XI16-net11 VDD pmos W=0.205u L=0.04u
M14242 U5104/XI16-net11 n4732 VDD VDD pmos W=0.205u L=0.04u
M14243 n4665 n4670 VSS VSS nmos W=0.135u L=0.04u
M14244 n4665 n4670 VDD VDD pmos W=0.205u L=0.04u
M14245 U5106/XU1-net6 n4698 VSS VSS nmos W=0.155u L=0.04u
M14246 n4670 g2257 U5106/XU1-net6 VSS nmos W=0.155u L=0.04u
M14247 n4670 n4698 VDD VDD pmos W=0.155u L=0.04u
M14248 n4670 g2257 VDD VDD pmos W=0.155u L=0.04u
M14249 n4698 n4548 U5107/net27 VSS nmos W=0.155u L=0.04u
M14250 U5107/net39 n4550 VSS VSS nmos W=0.155u L=0.04u
M14251 U5107/net27 g2244 U5107/net39 VSS nmos W=0.155u L=0.04u
M14252 U5107/net27 n4549 U5107/net39 VSS nmos W=0.155u L=0.04u
M14253 n4698 g2245 U5107/net27 VSS nmos W=0.155u L=0.04u
M14254 U5107/net39 g2246 VSS VSS nmos W=0.155u L=0.04u
M14255 n4698 n4550 U5107/net46 VDD pmos W=0.205u L=0.04u
M14256 U5107/net46 g2246 VDD VDD pmos W=0.205u L=0.04u
M14257 n4698 g2245 U5107/net34 VDD pmos W=0.205u L=0.04u
M14258 U5107/net34 n4548 VDD VDD pmos W=0.205u L=0.04u
M14259 n4698 n4549 U5107/net37 VDD pmos W=0.205u L=0.04u
M14260 U5107/net37 g2244 VDD VDD pmos W=0.205u L=0.04u
M14261 n4732 n4677 U5108/net14 VSS nmos W=0.155u L=0.04u
M14262 U5108/net14 n4734 VSS VSS nmos W=0.155u L=0.04u
M14263 U5108/net14 n4733 VSS VSS nmos W=0.155u L=0.04u
M14264 n4732 n4672 U5108/net14 VSS nmos W=0.155u L=0.04u
M14265 n4732 n4673 U5108/net14 VSS nmos W=0.155u L=0.04u
M14266 n4732 n4734 U5108/XI16-net11 VDD pmos W=0.205u L=0.04u
M14267 U5108/XI16-net11 n4733 VDD VDD pmos W=0.205u L=0.04u
M14268 n4732 n4672 U5108/XI15-net11 VDD pmos W=0.205u L=0.04u
M14269 U5108/XI15-net11 n4673 U5108/XI15-net18 VDD pmos W=0.205u L=0.04u
M14270 U5108/XI15-net18 n4677 VDD VDD pmos W=0.205u L=0.04u
M14271 U5109/net29 n4677 VSS VSS nmos W=0.155u L=0.04u
M14272 U5109/net26 n4736 U5109/net20 VSS nmos W=0.155u L=0.04u
M14273 U5109/net20 n4737 VSS VSS nmos W=0.155u L=0.04u
M14274 U5109/net26 n4735 U5109/net29 VSS nmos W=0.155u L=0.04u
M14275 n4734 U5109/net26 VSS VSS nmos W=0.155u L=0.04u
M14276 n4734 U5109/net26 VDD VDD pmos W=0.205u L=0.04u
M14277 U5109/net26 n4735 U5109/net40 VDD pmos W=0.205u L=0.04u
M14278 U5109/net26 n4677 U5109/net40 VDD pmos W=0.205u L=0.04u
M14279 U5109/net40 n4737 VDD VDD pmos W=0.205u L=0.04u
M14280 U5109/net40 n4736 VDD VDD pmos W=0.205u L=0.04u
M14281 n4672 U5110/net6 VSS VSS nmos W=0.155u L=0.04u
M14282 U5110/X_u2-net6 n4736 VSS VSS nmos W=0.155u L=0.04u
M14283 U5110/net6 n4735 U5110/X_u2-net6 VSS nmos W=0.155u L=0.04u
M14284 n4672 U5110/net6 VDD VDD pmos W=0.205u L=0.04u
M14285 U5110/net6 n4736 VDD VDD pmos W=0.205u L=0.04u
M14286 U5110/net6 n4735 VDD VDD pmos W=0.205u L=0.04u
M14287 n4673 U5111/net6 VSS VSS nmos W=0.155u L=0.04u
M14288 U5111/X_u2-net6 n4737 VSS VSS nmos W=0.155u L=0.04u
M14289 U5111/net6 n4733 U5111/X_u2-net6 VSS nmos W=0.155u L=0.04u
M14290 n4673 U5111/net6 VDD VDD pmos W=0.205u L=0.04u
M14291 U5111/net6 n4737 VDD VDD pmos W=0.205u L=0.04u
M14292 U5111/net6 n4733 VDD VDD pmos W=0.205u L=0.04u
M14293 n4731 n4736 VSS VSS nmos W=0.155u L=0.04u
M14294 n4731 n4737 U5112/XI17-net17 VSS nmos W=0.155u L=0.04u
M14295 U5112/XI17-net17 n4677 VSS VSS nmos W=0.155u L=0.04u
M14296 n4731 n4733 U5112/XI10-net17 VSS nmos W=0.155u L=0.04u
M14297 U5112/XI10-net17 n4735 VSS VSS nmos W=0.155u L=0.04u
M14298 U5112/net30 n4733 n4731 VDD pmos W=0.205u L=0.04u
M14299 U5112/net30 n4735 n4731 VDD pmos W=0.205u L=0.04u
M14300 VDD n4736 U5112/net36 VDD pmos W=0.205u L=0.04u
M14301 U5112/net36 n4677 U5112/net30 VDD pmos W=0.205u L=0.04u
M14302 U5112/net36 n4737 U5112/net30 VDD pmos W=0.205u L=0.04u
M14303 U5113/net4 U5113/net10 U5113/net14 VSS nmos W=0.155u L=0.04u
M14304 U5113/net6 n4607 U5113/net14 VSS nmos W=0.155u L=0.04u
M14305 U5113/net4 g2165 VSS VSS nmos W=0.155u L=0.04u
M14306 U5113/net6 U5113/net4 VSS VSS nmos W=0.155u L=0.04u
M14307 n4736 U5113/net14 VSS VSS nmos W=0.155u L=0.04u
M14308 U5113/net10 n4607 VSS VSS nmos W=0.155u L=0.04u
M14309 U5113/net4 n4607 U5113/net14 VDD pmos W=0.205u L=0.04u
M14310 U5113/net6 U5113/net10 U5113/net14 VDD pmos W=0.205u L=0.04u
M14311 U5113/net4 g2165 VDD VDD pmos W=0.205u L=0.04u
M14312 U5113/net6 U5113/net4 VDD VDD pmos W=0.205u L=0.04u
M14313 n4736 U5113/net14 VDD VDD pmos W=0.205u L=0.04u
M14314 U5113/net10 n4607 VDD VDD pmos W=0.205u L=0.04u
M14315 U5114/net4 U5114/net10 U5114/net14 VSS nmos W=0.155u L=0.04u
M14316 U5114/net6 n4603 U5114/net14 VSS nmos W=0.155u L=0.04u
M14317 U5114/net4 n4525 VSS VSS nmos W=0.155u L=0.04u
M14318 U5114/net6 U5114/net4 VSS VSS nmos W=0.155u L=0.04u
M14319 n4677 U5114/net14 VSS VSS nmos W=0.155u L=0.04u
M14320 U5114/net10 n4603 VSS VSS nmos W=0.155u L=0.04u
M14321 U5114/net4 n4603 U5114/net14 VDD pmos W=0.205u L=0.04u
M14322 U5114/net6 U5114/net10 U5114/net14 VDD pmos W=0.205u L=0.04u
M14323 U5114/net4 n4525 VDD VDD pmos W=0.205u L=0.04u
M14324 U5114/net6 U5114/net4 VDD VDD pmos W=0.205u L=0.04u
M14325 n4677 U5114/net14 VDD VDD pmos W=0.205u L=0.04u
M14326 U5114/net10 n4603 VDD VDD pmos W=0.205u L=0.04u
M14327 n4603 n4738 VSS VSS nmos W=0.135u L=0.04u
M14328 n4603 n4738 VDD VDD pmos W=0.205u L=0.04u
M14329 U5116/net4 U5116/net10 U5116/net14 VSS nmos W=0.155u L=0.04u
M14330 U5116/net6 n4626 U5116/net14 VSS nmos W=0.155u L=0.04u
M14331 U5116/net4 g2175 VSS VSS nmos W=0.155u L=0.04u
M14332 U5116/net6 U5116/net4 VSS VSS nmos W=0.155u L=0.04u
M14333 n4737 U5116/net14 VSS VSS nmos W=0.155u L=0.04u
M14334 U5116/net10 n4626 VSS VSS nmos W=0.155u L=0.04u
M14335 U5116/net4 n4626 U5116/net14 VDD pmos W=0.205u L=0.04u
M14336 U5116/net6 U5116/net10 U5116/net14 VDD pmos W=0.205u L=0.04u
M14337 U5116/net4 g2175 VDD VDD pmos W=0.205u L=0.04u
M14338 U5116/net6 U5116/net4 VDD VDD pmos W=0.205u L=0.04u
M14339 n4737 U5116/net14 VDD VDD pmos W=0.205u L=0.04u
M14340 U5116/net10 n4626 VDD VDD pmos W=0.205u L=0.04u
M14341 U5117/net4 U5117/net10 U5117/net14 VSS nmos W=0.155u L=0.04u
M14342 U5117/net6 n4684 U5117/net14 VSS nmos W=0.155u L=0.04u
M14343 U5117/net4 n4527 VSS VSS nmos W=0.155u L=0.04u
M14344 U5117/net6 U5117/net4 VSS VSS nmos W=0.155u L=0.04u
M14345 n4735 U5117/net14 VSS VSS nmos W=0.155u L=0.04u
M14346 U5117/net10 n4684 VSS VSS nmos W=0.155u L=0.04u
M14347 U5117/net4 n4684 U5117/net14 VDD pmos W=0.205u L=0.04u
M14348 U5117/net6 U5117/net10 U5117/net14 VDD pmos W=0.205u L=0.04u
M14349 U5117/net4 n4527 VDD VDD pmos W=0.205u L=0.04u
M14350 U5117/net6 U5117/net4 VDD VDD pmos W=0.205u L=0.04u
M14351 n4735 U5117/net14 VDD VDD pmos W=0.205u L=0.04u
M14352 U5117/net10 n4684 VDD VDD pmos W=0.205u L=0.04u
M14353 U5118/net4 n4615 U5118/net14 VSS nmos W=0.155u L=0.04u
M14354 U5118/net6 U5118/net10 U5118/net14 VSS nmos W=0.17u L=0.04u
M14355 U5118/net4 n3962 VSS VSS nmos W=0.155u L=0.04u
M14356 U5118/net6 U5118/net4 VSS VSS nmos W=0.17u L=0.04u
M14357 n4733 U5118/net14 VSS VSS nmos W=0.155u L=0.04u
M14358 U5118/net10 n4615 VSS VSS nmos W=0.155u L=0.04u
M14359 U5118/net4 U5118/net10 U5118/net14 VDD pmos W=0.255u L=0.04u
M14360 U5118/net6 n4615 U5118/net14 VDD pmos W=0.28u L=0.04u
M14361 U5118/net4 n3962 VDD VDD pmos W=0.205u L=0.04u
M14362 U5118/net6 U5118/net4 VDD VDD pmos W=0.24u L=0.04u
M14363 n4733 U5118/net14 VDD VDD pmos W=0.205u L=0.04u
M14364 U5118/net10 n4615 VDD VDD pmos W=0.205u L=0.04u
M14365 n3962 n4721 VSS VSS nmos W=0.135u L=0.04u
M14366 n3962 n4721 VDD VDD pmos W=0.205u L=0.04u
M14367 n4721 n4548 U5120/net27 VSS nmos W=0.155u L=0.04u
M14368 U5120/net39 n4550 VSS VSS nmos W=0.155u L=0.04u
M14369 U5120/net27 g2250 U5120/net39 VSS nmos W=0.155u L=0.04u
M14370 U5120/net27 n4549 U5120/net39 VSS nmos W=0.155u L=0.04u
M14371 n4721 g2251 U5120/net27 VSS nmos W=0.155u L=0.04u
M14372 U5120/net39 g2252 VSS VSS nmos W=0.155u L=0.04u
M14373 n4721 n4550 U5120/net46 VDD pmos W=0.205u L=0.04u
M14374 U5120/net46 g2252 VDD VDD pmos W=0.205u L=0.04u
M14375 n4721 g2251 U5120/net34 VDD pmos W=0.205u L=0.04u
M14376 U5120/net34 n4548 VDD VDD pmos W=0.205u L=0.04u
M14377 n4721 n4549 U5120/net37 VDD pmos W=0.205u L=0.04u
M14378 U5120/net37 g2250 VDD VDD pmos W=0.205u L=0.04u
M14379 n4678 n4529 U5121/net27 VSS nmos W=0.155u L=0.04u
M14380 U5121/net39 n4330 VSS VSS nmos W=0.155u L=0.04u
M14381 U5121/net27 g2396 U5121/net39 VSS nmos W=0.155u L=0.04u
M14382 U5121/net27 n4530 U5121/net39 VSS nmos W=0.155u L=0.04u
M14383 n4678 g2397 U5121/net27 VSS nmos W=0.155u L=0.04u
M14384 U5121/net39 g2398 VSS VSS nmos W=0.155u L=0.04u
M14385 n4678 n4330 U5121/net46 VDD pmos W=0.205u L=0.04u
M14386 U5121/net46 g2398 VDD VDD pmos W=0.205u L=0.04u
M14387 n4678 g2397 U5121/net34 VDD pmos W=0.205u L=0.04u
M14388 U5121/net34 n4529 VDD VDD pmos W=0.205u L=0.04u
M14389 n4678 n4530 U5121/net37 VDD pmos W=0.205u L=0.04u
M14390 U5121/net37 g2396 VDD VDD pmos W=0.205u L=0.04u
M14391 n4662 n4587 VSS VSS nmos W=0.135u L=0.04u
M14392 n4662 n4587 VDD VDD pmos W=0.205u L=0.04u
M14393 n4695 n4693 U5123/net27 VSS nmos W=0.155u L=0.04u
M14394 U5123/net27 n4685 VSS VSS nmos W=0.155u L=0.04u
M14395 n4695 n4692 VSS VSS nmos W=0.155u L=0.04u
M14396 n4695 n4685 U5123/net13 VDD pmos W=0.205u L=0.04u
M14397 U5123/net13 n4692 VDD VDD pmos W=0.205u L=0.04u
M14398 n4695 n4693 U5123/net13 VDD pmos W=0.205u L=0.04u
M14399 n4692 U5124/net6 VSS VSS nmos W=0.155u L=0.04u
M14400 U5124/net6 n4739 U5124/XU30-net23 VSS nmos W=0.155u L=0.04u
M14401 U5124/XU30-net23 n4690 U5124/XU30-net26 VSS nmos W=0.155u L=0.04u
M14402 U5124/XU30-net26 n4588 U5124/XU30-net29 VSS nmos W=0.155u L=0.04u
M14403 U5124/XU30-net29 n4740 VSS VSS nmos W=0.155u L=0.04u
M14404 n4692 U5124/net6 VDD VDD pmos W=0.205u L=0.04u
M14405 U5124/net6 n4740 VDD VDD pmos W=0.205u L=0.04u
M14406 U5124/net6 n4588 VDD VDD pmos W=0.205u L=0.04u
M14407 U5124/net6 n4690 VDD VDD pmos W=0.205u L=0.04u
M14408 U5124/net6 n4739 VDD VDD pmos W=0.205u L=0.04u
M14409 n4740 n4634 VSS VSS nmos W=0.155u L=0.04u
M14410 n4740 n4612 VSS VSS nmos W=0.155u L=0.04u
M14411 n4740 n4626 VSS VSS nmos W=0.155u L=0.04u
M14412 n4740 n4615 VSS VSS nmos W=0.155u L=0.04u
M14413 U5125/net49 n4612 U5125/net52 VDD pmos W=0.41u L=0.04u
M14414 U5125/net52 n4634 VDD VDD pmos W=0.41u L=0.04u
M14415 U5125/net46 n4626 U5125/net49 VDD pmos W=0.41u L=0.04u
M14416 n4740 n4615 U5125/net46 VDD pmos W=0.41u L=0.04u
M14417 n4606 n4588 VSS VSS nmos W=0.155u L=0.04u
M14418 n4606 n3954 VSS VSS nmos W=0.155u L=0.04u
M14419 U5126/XI1-net8 n3954 VDD VDD pmos W=0.205u L=0.04u
M14420 n4606 n4588 U5126/XI1-net8 VDD pmos W=0.205u L=0.04u
M14421 n4588 n4685 VSS VSS nmos W=0.135u L=0.04u
M14422 n4588 n4685 VDD VDD pmos W=0.205u L=0.04u
M14423 U5128/XU1-net6 n4645 VSS VSS nmos W=0.155u L=0.04u
M14424 n4685 n4658 U5128/XU1-net6 VSS nmos W=0.155u L=0.04u
M14425 n4685 n4645 VDD VDD pmos W=0.155u L=0.04u
M14426 n4685 n4658 VDD VDD pmos W=0.155u L=0.04u
M14427 n4645 n4653 VSS VSS nmos W=0.135u L=0.04u
M14428 n4645 n4653 VDD VDD pmos W=0.205u L=0.04u
M14429 U5130/net19 n4344 VSS VSS nmos W=0.155u L=0.04u
M14430 n3181 n4344 U5130/net40 VSS nmos W=0.155u L=0.04u
M14431 n3181 U5130/net19 U5130/net36 VSS nmos W=0.155u L=0.04u
M14432 U5130/net40 n4741 VSS VSS nmos W=0.31u L=0.04u
M14433 U5130/net36 g130 VSS VSS nmos W=0.155u L=0.04u
M14434 U5130/net19 n4344 VDD VDD pmos W=0.205u L=0.04u
M14435 n3181 U5130/net19 U5130/net26 VDD pmos W=0.325u L=0.04u
M14436 U5130/net26 n4741 VDD VDD pmos W=0.41u L=0.04u
M14437 n3181 n4344 U5130/net30 VDD pmos W=0.325u L=0.04u
M14438 U5130/net30 g130 VDD VDD pmos W=0.205u L=0.04u
M14439 U5131/net19 n4341 VSS VSS nmos W=0.155u L=0.04u
M14440 n3180 n4341 U5131/net40 VSS nmos W=0.155u L=0.04u
M14441 n3180 U5131/net19 U5131/net36 VSS nmos W=0.155u L=0.04u
M14442 U5131/net40 n4741 VSS VSS nmos W=0.31u L=0.04u
M14443 U5131/net36 g131 VSS VSS nmos W=0.155u L=0.04u
M14444 U5131/net19 n4341 VDD VDD pmos W=0.205u L=0.04u
M14445 n3180 U5131/net19 U5131/net26 VDD pmos W=0.325u L=0.04u
M14446 U5131/net26 n4741 VDD VDD pmos W=0.41u L=0.04u
M14447 n3180 n4341 U5131/net30 VDD pmos W=0.325u L=0.04u
M14448 U5131/net30 g131 VDD VDD pmos W=0.205u L=0.04u
M14449 U5132/net19 n4342 VSS VSS nmos W=0.155u L=0.04u
M14450 n3179 n4342 U5132/net40 VSS nmos W=0.155u L=0.04u
M14451 n3179 U5132/net19 U5132/net36 VSS nmos W=0.155u L=0.04u
M14452 U5132/net40 n4741 VSS VSS nmos W=0.31u L=0.04u
M14453 U5132/net36 g129 VSS VSS nmos W=0.155u L=0.04u
M14454 U5132/net19 n4342 VDD VDD pmos W=0.205u L=0.04u
M14455 n3179 U5132/net19 U5132/net26 VDD pmos W=0.325u L=0.04u
M14456 U5132/net26 n4741 VDD VDD pmos W=0.41u L=0.04u
M14457 n3179 n4342 U5132/net30 VDD pmos W=0.325u L=0.04u
M14458 U5132/net30 g129 VDD VDD pmos W=0.205u L=0.04u
M14459 U5133/net19 n4344 VSS VSS nmos W=0.155u L=0.04u
M14460 n3178 n4344 U5133/net40 VSS nmos W=0.155u L=0.04u
M14461 n3178 U5133/net19 U5133/net36 VSS nmos W=0.155u L=0.04u
M14462 U5133/net40 n4742 VSS VSS nmos W=0.31u L=0.04u
M14463 U5133/net36 g133 VSS VSS nmos W=0.155u L=0.04u
M14464 U5133/net19 n4344 VDD VDD pmos W=0.205u L=0.04u
M14465 n3178 U5133/net19 U5133/net26 VDD pmos W=0.325u L=0.04u
M14466 U5133/net26 n4742 VDD VDD pmos W=0.41u L=0.04u
M14467 n3178 n4344 U5133/net30 VDD pmos W=0.325u L=0.04u
M14468 U5133/net30 g133 VDD VDD pmos W=0.205u L=0.04u
M14469 U5134/net19 n4341 VSS VSS nmos W=0.155u L=0.04u
M14470 n3177 n4341 U5134/net40 VSS nmos W=0.155u L=0.04u
M14471 n3177 U5134/net19 U5134/net36 VSS nmos W=0.155u L=0.04u
M14472 U5134/net40 n4742 VSS VSS nmos W=0.31u L=0.04u
M14473 U5134/net36 g134 VSS VSS nmos W=0.155u L=0.04u
M14474 U5134/net19 n4341 VDD VDD pmos W=0.205u L=0.04u
M14475 n3177 U5134/net19 U5134/net26 VDD pmos W=0.325u L=0.04u
M14476 U5134/net26 n4742 VDD VDD pmos W=0.41u L=0.04u
M14477 n3177 n4341 U5134/net30 VDD pmos W=0.325u L=0.04u
M14478 U5134/net30 g134 VDD VDD pmos W=0.205u L=0.04u
M14479 U5135/net19 n4342 VSS VSS nmos W=0.155u L=0.04u
M14480 n3176 n4342 U5135/net40 VSS nmos W=0.155u L=0.04u
M14481 n3176 U5135/net19 U5135/net36 VSS nmos W=0.155u L=0.04u
M14482 U5135/net40 n4742 VSS VSS nmos W=0.31u L=0.04u
M14483 U5135/net36 g132 VSS VSS nmos W=0.155u L=0.04u
M14484 U5135/net19 n4342 VDD VDD pmos W=0.205u L=0.04u
M14485 n3176 U5135/net19 U5135/net26 VDD pmos W=0.325u L=0.04u
M14486 U5135/net26 n4742 VDD VDD pmos W=0.41u L=0.04u
M14487 n3176 n4342 U5135/net30 VDD pmos W=0.325u L=0.04u
M14488 U5135/net30 g132 VDD VDD pmos W=0.205u L=0.04u
M14489 U5136/net19 n4344 VSS VSS nmos W=0.155u L=0.04u
M14490 n3175 n4344 U5136/net40 VSS nmos W=0.155u L=0.04u
M14491 n3175 U5136/net19 U5136/net36 VSS nmos W=0.155u L=0.04u
M14492 U5136/net40 n4743 VSS VSS nmos W=0.31u L=0.04u
M14493 U5136/net36 g142 VSS VSS nmos W=0.155u L=0.04u
M14494 U5136/net19 n4344 VDD VDD pmos W=0.205u L=0.04u
M14495 n3175 U5136/net19 U5136/net26 VDD pmos W=0.325u L=0.04u
M14496 U5136/net26 n4743 VDD VDD pmos W=0.41u L=0.04u
M14497 n3175 n4344 U5136/net30 VDD pmos W=0.325u L=0.04u
M14498 U5136/net30 g142 VDD VDD pmos W=0.205u L=0.04u
M14499 U5137/net19 n4341 VSS VSS nmos W=0.155u L=0.04u
M14500 n3174 n4341 U5137/net40 VSS nmos W=0.155u L=0.04u
M14501 n3174 U5137/net19 U5137/net36 VSS nmos W=0.155u L=0.04u
M14502 U5137/net40 n4743 VSS VSS nmos W=0.31u L=0.04u
M14503 U5137/net36 g143 VSS VSS nmos W=0.155u L=0.04u
M14504 U5137/net19 n4341 VDD VDD pmos W=0.205u L=0.04u
M14505 n3174 U5137/net19 U5137/net26 VDD pmos W=0.325u L=0.04u
M14506 U5137/net26 n4743 VDD VDD pmos W=0.41u L=0.04u
M14507 n3174 n4341 U5137/net30 VDD pmos W=0.325u L=0.04u
M14508 U5137/net30 g143 VDD VDD pmos W=0.205u L=0.04u
M14509 U5138/net19 n4342 VSS VSS nmos W=0.155u L=0.04u
M14510 n3173 n4342 U5138/net40 VSS nmos W=0.155u L=0.04u
M14511 n3173 U5138/net19 U5138/net36 VSS nmos W=0.155u L=0.04u
M14512 U5138/net40 n4743 VSS VSS nmos W=0.31u L=0.04u
M14513 U5138/net36 g141 VSS VSS nmos W=0.155u L=0.04u
M14514 U5138/net19 n4342 VDD VDD pmos W=0.205u L=0.04u
M14515 n3173 U5138/net19 U5138/net26 VDD pmos W=0.325u L=0.04u
M14516 U5138/net26 n4743 VDD VDD pmos W=0.41u L=0.04u
M14517 n3173 n4342 U5138/net30 VDD pmos W=0.325u L=0.04u
M14518 U5138/net30 g141 VDD VDD pmos W=0.205u L=0.04u
M14519 U5139/net19 n4344 VSS VSS nmos W=0.155u L=0.04u
M14520 n3172 n4344 U5139/net40 VSS nmos W=0.155u L=0.04u
M14521 n3172 U5139/net19 U5139/net36 VSS nmos W=0.155u L=0.04u
M14522 U5139/net40 n4744 VSS VSS nmos W=0.31u L=0.04u
M14523 U5139/net36 g145 VSS VSS nmos W=0.155u L=0.04u
M14524 U5139/net19 n4344 VDD VDD pmos W=0.205u L=0.04u
M14525 n3172 U5139/net19 U5139/net26 VDD pmos W=0.325u L=0.04u
M14526 U5139/net26 n4744 VDD VDD pmos W=0.41u L=0.04u
M14527 n3172 n4344 U5139/net30 VDD pmos W=0.325u L=0.04u
M14528 U5139/net30 g145 VDD VDD pmos W=0.205u L=0.04u
M14529 U5140/net19 n4341 VSS VSS nmos W=0.155u L=0.04u
M14530 n3171 n4341 U5140/net40 VSS nmos W=0.155u L=0.04u
M14531 n3171 U5140/net19 U5140/net36 VSS nmos W=0.155u L=0.04u
M14532 U5140/net40 n4744 VSS VSS nmos W=0.31u L=0.04u
M14533 U5140/net36 g146 VSS VSS nmos W=0.155u L=0.04u
M14534 U5140/net19 n4341 VDD VDD pmos W=0.205u L=0.04u
M14535 n3171 U5140/net19 U5140/net26 VDD pmos W=0.325u L=0.04u
M14536 U5140/net26 n4744 VDD VDD pmos W=0.41u L=0.04u
M14537 n3171 n4341 U5140/net30 VDD pmos W=0.325u L=0.04u
M14538 U5140/net30 g146 VDD VDD pmos W=0.205u L=0.04u
M14539 U5141/net19 n4342 VSS VSS nmos W=0.155u L=0.04u
M14540 n3170 n4342 U5141/net40 VSS nmos W=0.155u L=0.04u
M14541 n3170 U5141/net19 U5141/net36 VSS nmos W=0.155u L=0.04u
M14542 U5141/net40 n4744 VSS VSS nmos W=0.31u L=0.04u
M14543 U5141/net36 g144 VSS VSS nmos W=0.155u L=0.04u
M14544 U5141/net19 n4342 VDD VDD pmos W=0.205u L=0.04u
M14545 n3170 U5141/net19 U5141/net26 VDD pmos W=0.325u L=0.04u
M14546 U5141/net26 n4744 VDD VDD pmos W=0.41u L=0.04u
M14547 n3170 n4342 U5141/net30 VDD pmos W=0.325u L=0.04u
M14548 U5141/net30 g144 VDD VDD pmos W=0.205u L=0.04u
M14549 U5142/net19 n4344 VSS VSS nmos W=0.155u L=0.04u
M14550 n3169 n4344 U5142/net40 VSS nmos W=0.155u L=0.04u
M14551 n3169 U5142/net19 U5142/net36 VSS nmos W=0.155u L=0.04u
M14552 U5142/net40 n4745 VSS VSS nmos W=0.31u L=0.04u
M14553 U5142/net36 g148 VSS VSS nmos W=0.155u L=0.04u
M14554 U5142/net19 n4344 VDD VDD pmos W=0.205u L=0.04u
M14555 n3169 U5142/net19 U5142/net26 VDD pmos W=0.325u L=0.04u
M14556 U5142/net26 n4745 VDD VDD pmos W=0.41u L=0.04u
M14557 n3169 n4344 U5142/net30 VDD pmos W=0.325u L=0.04u
M14558 U5142/net30 g148 VDD VDD pmos W=0.205u L=0.04u
M14559 U5143/net19 n4341 VSS VSS nmos W=0.155u L=0.04u
M14560 n3168 n4341 U5143/net40 VSS nmos W=0.155u L=0.04u
M14561 n3168 U5143/net19 U5143/net36 VSS nmos W=0.155u L=0.04u
M14562 U5143/net40 n4745 VSS VSS nmos W=0.31u L=0.04u
M14563 U5143/net36 g149 VSS VSS nmos W=0.155u L=0.04u
M14564 U5143/net19 n4341 VDD VDD pmos W=0.205u L=0.04u
M14565 n3168 U5143/net19 U5143/net26 VDD pmos W=0.325u L=0.04u
M14566 U5143/net26 n4745 VDD VDD pmos W=0.41u L=0.04u
M14567 n3168 n4341 U5143/net30 VDD pmos W=0.325u L=0.04u
M14568 U5143/net30 g149 VDD VDD pmos W=0.205u L=0.04u
M14569 U5144/net19 n4342 VSS VSS nmos W=0.155u L=0.04u
M14570 n3167 n4342 U5144/net40 VSS nmos W=0.155u L=0.04u
M14571 n3167 U5144/net19 U5144/net36 VSS nmos W=0.155u L=0.04u
M14572 U5144/net40 n4745 VSS VSS nmos W=0.31u L=0.04u
M14573 U5144/net36 g147 VSS VSS nmos W=0.155u L=0.04u
M14574 U5144/net19 n4342 VDD VDD pmos W=0.205u L=0.04u
M14575 n3167 U5144/net19 U5144/net26 VDD pmos W=0.325u L=0.04u
M14576 U5144/net26 n4745 VDD VDD pmos W=0.41u L=0.04u
M14577 n3167 n4342 U5144/net30 VDD pmos W=0.325u L=0.04u
M14578 U5144/net30 g147 VDD VDD pmos W=0.205u L=0.04u
M14579 U5145/net19 n4344 VSS VSS nmos W=0.155u L=0.04u
M14580 n3166 n4344 U5145/net40 VSS nmos W=0.155u L=0.04u
M14581 n3166 U5145/net19 U5145/net36 VSS nmos W=0.155u L=0.04u
M14582 U5145/net40 n4746 VSS VSS nmos W=0.31u L=0.04u
M14583 U5145/net36 g151 VSS VSS nmos W=0.155u L=0.04u
M14584 U5145/net19 n4344 VDD VDD pmos W=0.205u L=0.04u
M14585 n3166 U5145/net19 U5145/net26 VDD pmos W=0.325u L=0.04u
M14586 U5145/net26 n4746 VDD VDD pmos W=0.41u L=0.04u
M14587 n3166 n4344 U5145/net30 VDD pmos W=0.325u L=0.04u
M14588 U5145/net30 g151 VDD VDD pmos W=0.205u L=0.04u
M14589 U5146/net19 n4341 VSS VSS nmos W=0.155u L=0.04u
M14590 n3165 n4341 U5146/net40 VSS nmos W=0.155u L=0.04u
M14591 n3165 U5146/net19 U5146/net36 VSS nmos W=0.155u L=0.04u
M14592 U5146/net40 n4746 VSS VSS nmos W=0.31u L=0.04u
M14593 U5146/net36 g152 VSS VSS nmos W=0.155u L=0.04u
M14594 U5146/net19 n4341 VDD VDD pmos W=0.205u L=0.04u
M14595 n3165 U5146/net19 U5146/net26 VDD pmos W=0.325u L=0.04u
M14596 U5146/net26 n4746 VDD VDD pmos W=0.41u L=0.04u
M14597 n3165 n4341 U5146/net30 VDD pmos W=0.325u L=0.04u
M14598 U5146/net30 g152 VDD VDD pmos W=0.205u L=0.04u
M14599 U5147/net19 n4342 VSS VSS nmos W=0.155u L=0.04u
M14600 n3164 n4342 U5147/net40 VSS nmos W=0.155u L=0.04u
M14601 n3164 U5147/net19 U5147/net36 VSS nmos W=0.155u L=0.04u
M14602 U5147/net40 n4746 VSS VSS nmos W=0.31u L=0.04u
M14603 U5147/net36 g150 VSS VSS nmos W=0.155u L=0.04u
M14604 U5147/net19 n4342 VDD VDD pmos W=0.205u L=0.04u
M14605 n3164 U5147/net19 U5147/net26 VDD pmos W=0.325u L=0.04u
M14606 U5147/net26 n4746 VDD VDD pmos W=0.41u L=0.04u
M14607 n3164 n4342 U5147/net30 VDD pmos W=0.325u L=0.04u
M14608 U5147/net30 g150 VDD VDD pmos W=0.205u L=0.04u
M14609 U5148/net19 n4344 VSS VSS nmos W=0.155u L=0.04u
M14610 n3163 n4344 U5148/net40 VSS nmos W=0.155u L=0.04u
M14611 n3163 U5148/net19 U5148/net36 VSS nmos W=0.155u L=0.04u
M14612 U5148/net40 n4747 VSS VSS nmos W=0.31u L=0.04u
M14613 U5148/net36 g154 VSS VSS nmos W=0.155u L=0.04u
M14614 U5148/net19 n4344 VDD VDD pmos W=0.205u L=0.04u
M14615 n3163 U5148/net19 U5148/net26 VDD pmos W=0.325u L=0.04u
M14616 U5148/net26 n4747 VDD VDD pmos W=0.41u L=0.04u
M14617 n3163 n4344 U5148/net30 VDD pmos W=0.325u L=0.04u
M14618 U5148/net30 g154 VDD VDD pmos W=0.205u L=0.04u
M14619 U5149/net19 n4341 VSS VSS nmos W=0.155u L=0.04u
M14620 n3162 n4341 U5149/net40 VSS nmos W=0.155u L=0.04u
M14621 n3162 U5149/net19 U5149/net36 VSS nmos W=0.155u L=0.04u
M14622 U5149/net40 n4747 VSS VSS nmos W=0.31u L=0.04u
M14623 U5149/net36 g155 VSS VSS nmos W=0.155u L=0.04u
M14624 U5149/net19 n4341 VDD VDD pmos W=0.205u L=0.04u
M14625 n3162 U5149/net19 U5149/net26 VDD pmos W=0.325u L=0.04u
M14626 U5149/net26 n4747 VDD VDD pmos W=0.41u L=0.04u
M14627 n3162 n4341 U5149/net30 VDD pmos W=0.325u L=0.04u
M14628 U5149/net30 g155 VDD VDD pmos W=0.205u L=0.04u
M14629 U5150/net19 n4342 VSS VSS nmos W=0.155u L=0.04u
M14630 n3161 n4342 U5150/net40 VSS nmos W=0.155u L=0.04u
M14631 n3161 U5150/net19 U5150/net36 VSS nmos W=0.155u L=0.04u
M14632 U5150/net40 n4747 VSS VSS nmos W=0.31u L=0.04u
M14633 U5150/net36 g153 VSS VSS nmos W=0.155u L=0.04u
M14634 U5150/net19 n4342 VDD VDD pmos W=0.205u L=0.04u
M14635 n3161 U5150/net19 U5150/net26 VDD pmos W=0.325u L=0.04u
M14636 U5150/net26 n4747 VDD VDD pmos W=0.41u L=0.04u
M14637 n3161 n4342 U5150/net30 VDD pmos W=0.325u L=0.04u
M14638 U5150/net30 g153 VDD VDD pmos W=0.205u L=0.04u
M14639 U5151/net19 n4749 VSS VSS nmos W=0.155u L=0.04u
M14640 n3160 n4749 U5151/net40 VSS nmos W=0.155u L=0.04u
M14641 n3160 U5151/net19 U5151/net36 VSS nmos W=0.155u L=0.04u
M14642 U5151/net40 g429 VSS VSS nmos W=0.31u L=0.04u
M14643 U5151/net36 n4748 VSS VSS nmos W=0.155u L=0.04u
M14644 U5151/net19 n4749 VDD VDD pmos W=0.205u L=0.04u
M14645 n3160 U5151/net19 U5151/net26 VDD pmos W=0.325u L=0.04u
M14646 U5151/net26 g429 VDD VDD pmos W=0.41u L=0.04u
M14647 n3160 n4749 U5151/net30 VDD pmos W=0.325u L=0.04u
M14648 U5151/net30 n4748 VDD VDD pmos W=0.205u L=0.04u
M14649 U5152/net19 n4750 VSS VSS nmos W=0.155u L=0.04u
M14650 n3159 n4750 U5152/net40 VSS nmos W=0.155u L=0.04u
M14651 n3159 U5152/net19 U5152/net36 VSS nmos W=0.155u L=0.04u
M14652 U5152/net40 g432 VSS VSS nmos W=0.31u L=0.04u
M14653 U5152/net36 n4748 VSS VSS nmos W=0.155u L=0.04u
M14654 U5152/net19 n4750 VDD VDD pmos W=0.205u L=0.04u
M14655 n3159 U5152/net19 U5152/net26 VDD pmos W=0.325u L=0.04u
M14656 U5152/net26 g432 VDD VDD pmos W=0.41u L=0.04u
M14657 n3159 n4750 U5152/net30 VDD pmos W=0.325u L=0.04u
M14658 U5152/net30 n4748 VDD VDD pmos W=0.205u L=0.04u
M14659 U5153/net19 n4751 VSS VSS nmos W=0.155u L=0.04u
M14660 n3158 n4751 U5153/net40 VSS nmos W=0.155u L=0.04u
M14661 n3158 U5153/net19 U5153/net36 VSS nmos W=0.155u L=0.04u
M14662 U5153/net40 g435 VSS VSS nmos W=0.31u L=0.04u
M14663 U5153/net36 n4748 VSS VSS nmos W=0.155u L=0.04u
M14664 U5153/net19 n4751 VDD VDD pmos W=0.205u L=0.04u
M14665 n3158 U5153/net19 U5153/net26 VDD pmos W=0.325u L=0.04u
M14666 U5153/net26 g435 VDD VDD pmos W=0.41u L=0.04u
M14667 n3158 n4751 U5153/net30 VDD pmos W=0.325u L=0.04u
M14668 U5153/net30 n4748 VDD VDD pmos W=0.205u L=0.04u
M14669 U5154/net19 g309 VSS VSS nmos W=0.155u L=0.04u
M14670 n4748 g309 U5154/net40 VSS nmos W=0.155u L=0.04u
M14671 n4748 U5154/net19 U5154/net36 VSS nmos W=0.155u L=0.04u
M14672 U5154/net40 n4753 VSS VSS nmos W=0.31u L=0.04u
M14673 U5154/net36 n4752 VSS VSS nmos W=0.155u L=0.04u
M14674 U5154/net19 g309 VDD VDD pmos W=0.205u L=0.04u
M14675 n4748 U5154/net19 U5154/net26 VDD pmos W=0.325u L=0.04u
M14676 U5154/net26 n4753 VDD VDD pmos W=0.41u L=0.04u
M14677 n4748 g309 U5154/net30 VDD pmos W=0.325u L=0.04u
M14678 U5154/net30 n4752 VDD VDD pmos W=0.205u L=0.04u
M14679 U5155/net19 n4749 VSS VSS nmos W=0.155u L=0.04u
M14680 n3157 n4749 U5155/net40 VSS nmos W=0.155u L=0.04u
M14681 n3157 U5155/net19 U5155/net36 VSS nmos W=0.155u L=0.04u
M14682 U5155/net40 g438 VSS VSS nmos W=0.31u L=0.04u
M14683 U5155/net36 n4754 VSS VSS nmos W=0.155u L=0.04u
M14684 U5155/net19 n4749 VDD VDD pmos W=0.205u L=0.04u
M14685 n3157 U5155/net19 U5155/net26 VDD pmos W=0.325u L=0.04u
M14686 U5155/net26 g438 VDD VDD pmos W=0.41u L=0.04u
M14687 n3157 n4749 U5155/net30 VDD pmos W=0.325u L=0.04u
M14688 U5155/net30 n4754 VDD VDD pmos W=0.205u L=0.04u
M14689 U5156/net19 n4750 VSS VSS nmos W=0.155u L=0.04u
M14690 n3156 n4750 U5156/net40 VSS nmos W=0.155u L=0.04u
M14691 n3156 U5156/net19 U5156/net36 VSS nmos W=0.155u L=0.04u
M14692 U5156/net40 g441 VSS VSS nmos W=0.31u L=0.04u
M14693 U5156/net36 n4754 VSS VSS nmos W=0.155u L=0.04u
M14694 U5156/net19 n4750 VDD VDD pmos W=0.205u L=0.04u
M14695 n3156 U5156/net19 U5156/net26 VDD pmos W=0.325u L=0.04u
M14696 U5156/net26 g441 VDD VDD pmos W=0.41u L=0.04u
M14697 n3156 n4750 U5156/net30 VDD pmos W=0.325u L=0.04u
M14698 U5156/net30 n4754 VDD VDD pmos W=0.205u L=0.04u
M14699 U5157/net19 n4751 VSS VSS nmos W=0.155u L=0.04u
M14700 n3155 n4751 U5157/net40 VSS nmos W=0.155u L=0.04u
M14701 n3155 U5157/net19 U5157/net36 VSS nmos W=0.155u L=0.04u
M14702 U5157/net40 g444 VSS VSS nmos W=0.31u L=0.04u
M14703 U5157/net36 n4754 VSS VSS nmos W=0.155u L=0.04u
M14704 U5157/net19 n4751 VDD VDD pmos W=0.205u L=0.04u
M14705 n3155 U5157/net19 U5157/net26 VDD pmos W=0.325u L=0.04u
M14706 U5157/net26 g444 VDD VDD pmos W=0.41u L=0.04u
M14707 n3155 n4751 U5157/net30 VDD pmos W=0.325u L=0.04u
M14708 U5157/net30 n4754 VDD VDD pmos W=0.205u L=0.04u
M14709 U5158/net4 n4755 U5158/net14 VSS nmos W=0.155u L=0.04u
M14710 U5158/net6 U5158/net10 U5158/net14 VSS nmos W=0.17u L=0.04u
M14711 U5158/net4 n4756 VSS VSS nmos W=0.155u L=0.04u
M14712 U5158/net6 U5158/net4 VSS VSS nmos W=0.17u L=0.04u
M14713 n4754 U5158/net14 VSS VSS nmos W=0.155u L=0.04u
M14714 U5158/net10 n4755 VSS VSS nmos W=0.155u L=0.04u
M14715 U5158/net4 U5158/net10 U5158/net14 VDD pmos W=0.255u L=0.04u
M14716 U5158/net6 n4755 U5158/net14 VDD pmos W=0.28u L=0.04u
M14717 U5158/net4 n4756 VDD VDD pmos W=0.205u L=0.04u
M14718 U5158/net6 U5158/net4 VDD VDD pmos W=0.24u L=0.04u
M14719 n4754 U5158/net14 VDD VDD pmos W=0.205u L=0.04u
M14720 U5158/net10 n4755 VDD VDD pmos W=0.205u L=0.04u
M14721 n4755 n4759 VSS VSS nmos W=0.155u L=0.04u
M14722 n4755 n4758 VSS VSS nmos W=0.155u L=0.04u
M14723 n4755 n4757 VSS VSS nmos W=0.155u L=0.04u
M14724 U5159/net25 n4759 VDD VDD pmos W=0.41u L=0.04u
M14725 U5159/net28 n4758 U5159/net25 VDD pmos W=0.41u L=0.04u
M14726 n4755 n4757 U5159/net28 VDD pmos W=0.41u L=0.04u
M14727 n3154 n4751 U5160/net10 VSS nmos W=0.155u L=0.04u
M14728 U5160/net10 n4761 VSS VSS nmos W=0.155u L=0.04u
M14729 n3154 n4760 U5160/net10 VSS nmos W=0.155u L=0.04u
M14730 U5160/net10 g447 VSS VSS nmos W=0.155u L=0.04u
M14731 U5160/net30 n4761 VDD VDD pmos W=0.205u L=0.04u
M14732 n3154 n4751 U5160/net24 VDD pmos W=0.205u L=0.04u
M14733 U5160/net24 n4760 VDD VDD pmos W=0.205u L=0.04u
M14734 n3154 g447 U5160/net30 VDD pmos W=0.205u L=0.04u
M14735 n4761 n4751 VSS VSS nmos W=0.155u L=0.04u
M14736 n4761 n4762 VSS VSS nmos W=0.155u L=0.04u
M14737 U5161/XI1-net8 n4762 VDD VDD pmos W=0.205u L=0.04u
M14738 n4761 n4751 U5161/XI1-net8 VDD pmos W=0.205u L=0.04u
M14739 n3153 n4750 U5162/net10 VSS nmos W=0.155u L=0.04u
M14740 U5162/net10 n4763 VSS VSS nmos W=0.155u L=0.04u
M14741 n3153 n4760 U5162/net10 VSS nmos W=0.155u L=0.04u
M14742 U5162/net10 g449 VSS VSS nmos W=0.155u L=0.04u
M14743 U5162/net30 n4763 VDD VDD pmos W=0.205u L=0.04u
M14744 n3153 n4750 U5162/net24 VDD pmos W=0.205u L=0.04u
M14745 U5162/net24 n4760 VDD VDD pmos W=0.205u L=0.04u
M14746 n3153 g449 U5162/net30 VDD pmos W=0.205u L=0.04u
M14747 n4763 n4750 VSS VSS nmos W=0.155u L=0.04u
M14748 n4763 n4762 VSS VSS nmos W=0.155u L=0.04u
M14749 U5163/XI1-net8 n4762 VDD VDD pmos W=0.205u L=0.04u
M14750 n4763 n4750 U5163/XI1-net8 VDD pmos W=0.205u L=0.04u
M14751 n3152 n4749 U5164/net10 VSS nmos W=0.155u L=0.04u
M14752 U5164/net10 n4764 VSS VSS nmos W=0.155u L=0.04u
M14753 n3152 n4760 U5164/net10 VSS nmos W=0.155u L=0.04u
M14754 U5164/net10 g448 VSS VSS nmos W=0.155u L=0.04u
M14755 U5164/net30 n4764 VDD VDD pmos W=0.205u L=0.04u
M14756 n3152 n4749 U5164/net24 VDD pmos W=0.205u L=0.04u
M14757 U5164/net24 n4760 VDD VDD pmos W=0.205u L=0.04u
M14758 n3152 g448 U5164/net30 VDD pmos W=0.205u L=0.04u
M14759 n4764 n4749 VSS VSS nmos W=0.155u L=0.04u
M14760 n4764 n4762 VSS VSS nmos W=0.155u L=0.04u
M14761 U5165/XI1-net8 n4762 VDD VDD pmos W=0.205u L=0.04u
M14762 n4764 n4749 U5165/XI1-net8 VDD pmos W=0.205u L=0.04u
M14763 U5166/net36 g309 U5166/net24 VSS nmos W=0.155u L=0.04u
M14764 U5166/net24 n4765 VSS VSS nmos W=0.155u L=0.04u
M14765 n4762 n4752 U5166/net36 VSS nmos W=0.155u L=0.04u
M14766 n4762 n4753 U5166/net36 VSS nmos W=0.155u L=0.04u
M14767 n4762 n4753 U5166/net35 VDD pmos W=0.205u L=0.04u
M14768 U5166/net35 n4752 VDD VDD pmos W=0.205u L=0.04u
M14769 n4762 n4765 VDD VDD pmos W=0.205u L=0.04u
M14770 n4762 g309 VDD VDD pmos W=0.205u L=0.04u
M14771 U5167/net19 n4339 VSS VSS nmos W=0.155u L=0.04u
M14772 n4765 n4339 U5167/net40 VSS nmos W=0.155u L=0.04u
M14773 n4765 U5167/net19 U5167/net36 VSS nmos W=0.155u L=0.04u
M14774 U5167/net40 n4752 VSS VSS nmos W=0.31u L=0.04u
M14775 U5167/net36 n4753 VSS VSS nmos W=0.155u L=0.04u
M14776 U5167/net19 n4339 VDD VDD pmos W=0.205u L=0.04u
M14777 n4765 U5167/net19 U5167/net26 VDD pmos W=0.325u L=0.04u
M14778 U5167/net26 n4752 VDD VDD pmos W=0.41u L=0.04u
M14779 n4765 n4339 U5167/net30 VDD pmos W=0.325u L=0.04u
M14780 U5167/net30 n4753 VDD VDD pmos W=0.205u L=0.04u
M14781 n4339 n4756 VSS VSS nmos W=0.135u L=0.04u
M14782 n4339 n4756 VDD VDD pmos W=0.205u L=0.04u
M14783 U5169/net30 n4757 VSS VSS nmos W=0.155u L=0.04u
M14784 n4760 n4758 U5169/net23 VSS nmos W=0.155u L=0.04u
M14785 U5169/net20 U5169/net30 VSS VSS nmos W=0.155u L=0.04u
M14786 U5169/net23 g309 U5169/net20 VSS nmos W=0.155u L=0.04u
M14787 U5169/net30 n4757 VDD VDD pmos W=0.205u L=0.04u
M14788 VDD n4758 n4760 VDD pmos W=0.205u L=0.04u
M14789 VDD g309 n4760 VDD pmos W=0.205u L=0.04u
M14790 VDD U5169/net30 n4760 VDD pmos W=0.205u L=0.04u
M14791 U5170/net36 n4749 U5170/net27 VSS nmos W=0.155u L=0.04u
M14792 U5170/net39 n4750 VSS VSS nmos W=0.155u L=0.04u
M14793 U5170/net27 g447 U5170/net39 VSS nmos W=0.155u L=0.04u
M14794 U5170/net27 n4751 U5170/net39 VSS nmos W=0.155u L=0.04u
M14795 U5170/net36 g448 U5170/net27 VSS nmos W=0.155u L=0.04u
M14796 U5170/net39 g449 VSS VSS nmos W=0.155u L=0.04u
M14797 n4758 U5170/net36 VSS VSS nmos W=0.155u L=0.04u
M14798 n4758 U5170/net36 VDD VDD pmos W=0.205u L=0.04u
M14799 U5170/net36 n4750 U5170/net46 VDD pmos W=0.205u L=0.04u
M14800 U5170/net46 g449 VDD VDD pmos W=0.205u L=0.04u
M14801 U5170/net36 g448 U5170/net34 VDD pmos W=0.205u L=0.04u
M14802 U5170/net34 n4749 VDD VDD pmos W=0.205u L=0.04u
M14803 U5170/net36 n4751 U5170/net37 VDD pmos W=0.205u L=0.04u
M14804 U5170/net37 g447 VDD VDD pmos W=0.205u L=0.04u
M14805 n4757 n4756 U5171/net15 VSS nmos W=0.155u L=0.04u
M14806 n4757 n4752 U5171/net15 VSS nmos W=0.155u L=0.04u
M14807 U5171/net15 n4766 VSS VSS nmos W=0.155u L=0.04u
M14808 n4757 n4766 VDD VDD pmos W=0.205u L=0.04u
M14809 n4757 n4756 U5171/XI16-net11 VDD pmos W=0.205u L=0.04u
M14810 U5171/XI16-net11 n4752 VDD VDD pmos W=0.205u L=0.04u
M14811 U5172/net19 n4753 VSS VSS nmos W=0.155u L=0.04u
M14812 n4766 n4753 U5172/net40 VSS nmos W=0.155u L=0.04u
M14813 n4766 U5172/net19 U5172/net36 VSS nmos W=0.155u L=0.04u
M14814 U5172/net40 n4756 VSS VSS nmos W=0.31u L=0.04u
M14815 U5172/net36 n4752 VSS VSS nmos W=0.155u L=0.04u
M14816 U5172/net19 n4753 VDD VDD pmos W=0.205u L=0.04u
M14817 n4766 U5172/net19 U5172/net26 VDD pmos W=0.325u L=0.04u
M14818 U5172/net26 n4756 VDD VDD pmos W=0.41u L=0.04u
M14819 n4766 n4753 U5172/net30 VDD pmos W=0.325u L=0.04u
M14820 U5172/net30 n4752 VDD VDD pmos W=0.205u L=0.04u
M14821 U5173/net13 n4767 VSS VSS nmos W=0.155u L=0.04u
M14822 U5173/net16 U5173/net13 VSS VSS nmos W=0.155u L=0.04u
M14823 n4753 n4768 U5173/net16 VSS nmos W=0.155u L=0.04u
M14824 U5173/net13 n4767 VDD VDD pmos W=0.205u L=0.04u
M14825 VDD U5173/net13 n4753 VDD pmos W=0.205u L=0.04u
M14826 VDD n4768 n4753 VDD pmos W=0.205u L=0.04u
M14827 n4768 n4769 U5174/net27 VSS nmos W=0.155u L=0.04u
M14828 U5174/net39 n4771 VSS VSS nmos W=0.155u L=0.04u
M14829 U5174/net27 g177 U5174/net39 VSS nmos W=0.155u L=0.04u
M14830 U5174/net27 n4770 U5174/net39 VSS nmos W=0.155u L=0.04u
M14831 n4768 g178 U5174/net27 VSS nmos W=0.155u L=0.04u
M14832 U5174/net39 g179 VSS VSS nmos W=0.155u L=0.04u
M14833 n4768 n4771 U5174/net46 VDD pmos W=0.205u L=0.04u
M14834 U5174/net46 g179 VDD VDD pmos W=0.205u L=0.04u
M14835 n4768 g178 U5174/net34 VDD pmos W=0.205u L=0.04u
M14836 U5174/net34 n4769 VDD VDD pmos W=0.205u L=0.04u
M14837 n4768 n4770 U5174/net37 VDD pmos W=0.205u L=0.04u
M14838 U5174/net37 g177 VDD VDD pmos W=0.205u L=0.04u
M14839 n4752 g401 U5175/XI21-net17 VSS nmos W=0.155u L=0.04u
M14840 U5175/XI21-net17 g435 VSS VSS nmos W=0.155u L=0.04u
M14841 n4752 g5437 U5175/XI6-net17 VSS nmos W=0.155u L=0.04u
M14842 U5175/XI6-net17 g429 VSS VSS nmos W=0.155u L=0.04u
M14843 n4752 g6447 U5175/XI20-net17 VSS nmos W=0.155u L=0.04u
M14844 U5175/XI20-net17 g432 VSS VSS nmos W=0.155u L=0.04u
M14845 VDD g401 U5175/net22 VDD pmos W=0.205u L=0.04u
M14846 VDD g435 U5175/net22 VDD pmos W=0.205u L=0.04u
M14847 U5175/net16 g5437 n4752 VDD pmos W=0.205u L=0.04u
M14848 U5175/net16 g429 n4752 VDD pmos W=0.205u L=0.04u
M14849 U5175/net22 g6447 U5175/net16 VDD pmos W=0.205u L=0.04u
M14850 U5175/net22 g432 U5175/net16 VDD pmos W=0.205u L=0.04u
M14851 n4756 g401 U5176/XI21-net17 VSS nmos W=0.155u L=0.04u
M14852 U5176/XI21-net17 g444 VSS VSS nmos W=0.155u L=0.04u
M14853 n4756 g5437 U5176/XI6-net17 VSS nmos W=0.155u L=0.04u
M14854 U5176/XI6-net17 g438 VSS VSS nmos W=0.155u L=0.04u
M14855 n4756 g6447 U5176/XI20-net17 VSS nmos W=0.155u L=0.04u
M14856 U5176/XI20-net17 g441 VSS VSS nmos W=0.155u L=0.04u
M14857 VDD g401 U5176/net22 VDD pmos W=0.205u L=0.04u
M14858 VDD g444 U5176/net22 VDD pmos W=0.205u L=0.04u
M14859 U5176/net16 g5437 n4756 VDD pmos W=0.205u L=0.04u
M14860 U5176/net16 g438 n4756 VDD pmos W=0.205u L=0.04u
M14861 U5176/net22 g6447 U5176/net16 VDD pmos W=0.205u L=0.04u
M14862 U5176/net22 g441 U5176/net16 VDD pmos W=0.205u L=0.04u
M14863 U5177/net19 n4749 VSS VSS nmos W=0.155u L=0.04u
M14864 n3151 n4749 U5177/net40 VSS nmos W=0.155u L=0.04u
M14865 n3151 U5177/net19 U5177/net36 VSS nmos W=0.155u L=0.04u
M14866 U5177/net40 g417 VSS VSS nmos W=0.31u L=0.04u
M14867 U5177/net36 n4772 VSS VSS nmos W=0.155u L=0.04u
M14868 U5177/net19 n4749 VDD VDD pmos W=0.205u L=0.04u
M14869 n3151 U5177/net19 U5177/net26 VDD pmos W=0.325u L=0.04u
M14870 U5177/net26 g417 VDD VDD pmos W=0.41u L=0.04u
M14871 n3151 n4749 U5177/net30 VDD pmos W=0.325u L=0.04u
M14872 U5177/net30 n4772 VDD VDD pmos W=0.205u L=0.04u
M14873 U5178/net19 n4750 VSS VSS nmos W=0.155u L=0.04u
M14874 n3150 n4750 U5178/net40 VSS nmos W=0.155u L=0.04u
M14875 n3150 U5178/net19 U5178/net36 VSS nmos W=0.155u L=0.04u
M14876 U5178/net40 g420 VSS VSS nmos W=0.31u L=0.04u
M14877 U5178/net36 n4772 VSS VSS nmos W=0.155u L=0.04u
M14878 U5178/net19 n4750 VDD VDD pmos W=0.205u L=0.04u
M14879 n3150 U5178/net19 U5178/net26 VDD pmos W=0.325u L=0.04u
M14880 U5178/net26 g420 VDD VDD pmos W=0.41u L=0.04u
M14881 n3150 n4750 U5178/net30 VDD pmos W=0.325u L=0.04u
M14882 U5178/net30 n4772 VDD VDD pmos W=0.205u L=0.04u
M14883 U5179/net19 n4751 VSS VSS nmos W=0.155u L=0.04u
M14884 n3149 n4751 U5179/net40 VSS nmos W=0.155u L=0.04u
M14885 n3149 U5179/net19 U5179/net36 VSS nmos W=0.155u L=0.04u
M14886 U5179/net40 g423 VSS VSS nmos W=0.31u L=0.04u
M14887 U5179/net36 n4772 VSS VSS nmos W=0.155u L=0.04u
M14888 U5179/net19 n4751 VDD VDD pmos W=0.205u L=0.04u
M14889 n3149 U5179/net19 U5179/net26 VDD pmos W=0.325u L=0.04u
M14890 U5179/net26 g423 VDD VDD pmos W=0.41u L=0.04u
M14891 n3149 n4751 U5179/net30 VDD pmos W=0.325u L=0.04u
M14892 U5179/net30 n4772 VDD VDD pmos W=0.205u L=0.04u
M14893 U5180/net4 g11860 U5180/net14 VSS nmos W=0.155u L=0.04u
M14894 U5180/net6 U5180/net10 U5180/net14 VSS nmos W=0.17u L=0.04u
M14895 U5180/net4 n4773 VSS VSS nmos W=0.155u L=0.04u
M14896 U5180/net6 U5180/net4 VSS VSS nmos W=0.17u L=0.04u
M14897 n4772 U5180/net14 VSS VSS nmos W=0.155u L=0.04u
M14898 U5180/net10 g11860 VSS VSS nmos W=0.155u L=0.04u
M14899 U5180/net4 U5180/net10 U5180/net14 VDD pmos W=0.255u L=0.04u
M14900 U5180/net6 g11860 U5180/net14 VDD pmos W=0.28u L=0.04u
M14901 U5180/net4 n4773 VDD VDD pmos W=0.205u L=0.04u
M14902 U5180/net6 U5180/net4 VDD VDD pmos W=0.24u L=0.04u
M14903 n4772 U5180/net14 VDD VDD pmos W=0.205u L=0.04u
M14904 U5180/net10 g11860 VDD VDD pmos W=0.205u L=0.04u
M14905 n4773 n4774 U5181/net14 VSS nmos W=0.155u L=0.04u
M14906 U5181/net14 n4778 VSS VSS nmos W=0.155u L=0.04u
M14907 U5181/net14 n4777 VSS VSS nmos W=0.155u L=0.04u
M14908 n4773 n4776 U5181/net14 VSS nmos W=0.155u L=0.04u
M14909 n4773 n4775 U5181/net14 VSS nmos W=0.155u L=0.04u
M14910 n4773 n4778 U5181/XI16-net11 VDD pmos W=0.205u L=0.04u
M14911 U5181/XI16-net11 n4777 VDD VDD pmos W=0.205u L=0.04u
M14912 n4773 n4776 U5181/XI15-net11 VDD pmos W=0.205u L=0.04u
M14913 U5181/XI15-net11 n4775 U5181/XI15-net18 VDD pmos W=0.205u L=0.04u
M14914 U5181/XI15-net18 n4774 VDD VDD pmos W=0.205u L=0.04u
M14915 n4777 n4779 U5182/net23 VDD pmos W=0.205u L=0.04u
M14916 n4777 g11860 U5182/net23 VDD pmos W=0.205u L=0.04u
M14917 n4777 n4780 U5182/net23 VDD pmos W=0.205u L=0.04u
M14918 U5182/net23 n4781 VDD VDD pmos W=0.205u L=0.04u
M14919 U5182/net23 n4782 VDD VDD pmos W=0.205u L=0.04u
M14920 U5182/XI20-net13 g11860 VSS VSS nmos W=0.155u L=0.04u
M14921 n4777 n4779 U5182/XI20-net17 VSS nmos W=0.155u L=0.04u
M14922 U5182/XI20-net17 n4780 U5182/XI20-net13 VSS nmos W=0.155u L=0.04u
M14923 n4777 n4781 U5182/XI17-net17 VSS nmos W=0.155u L=0.04u
M14924 U5182/XI17-net17 n4782 VSS VSS nmos W=0.155u L=0.04u
M14925 n4780 U5183/net7 VSS VSS nmos W=0.155u L=0.04u
M14926 U5183/net7 n4782 VSS VSS nmos W=0.155u L=0.04u
M14927 U5183/net7 n4783 VSS VSS nmos W=0.155u L=0.04u
M14928 n4780 U5183/net7 VDD VDD pmos W=0.205u L=0.04u
M14929 U5183/X_u7-net8 n4783 VDD VDD pmos W=0.205u L=0.04u
M14930 U5183/net7 n4782 U5183/X_u7-net8 VDD pmos W=0.205u L=0.04u
M14931 n4776 g11860 VSS VSS nmos W=0.135u L=0.04u
M14932 n4776 g11860 VDD VDD pmos W=0.205u L=0.04u
M14933 U5185/XU1-net6 n4784 VSS VSS nmos W=0.155u L=0.04u
M14934 n4774 n4779 U5185/XU1-net6 VSS nmos W=0.155u L=0.04u
M14935 n4774 n4784 VDD VDD pmos W=0.155u L=0.04u
M14936 n4774 n4779 VDD VDD pmos W=0.155u L=0.04u
M14937 n3148 n4749 U5186/net10 VSS nmos W=0.155u L=0.04u
M14938 U5186/net10 n4786 VSS VSS nmos W=0.155u L=0.04u
M14939 n3148 n4785 U5186/net10 VSS nmos W=0.155u L=0.04u
M14940 U5186/net10 g427 VSS VSS nmos W=0.155u L=0.04u
M14941 U5186/net30 n4786 VDD VDD pmos W=0.205u L=0.04u
M14942 n3148 n4749 U5186/net24 VDD pmos W=0.205u L=0.04u
M14943 U5186/net24 n4785 VDD VDD pmos W=0.205u L=0.04u
M14944 n3148 g427 U5186/net30 VDD pmos W=0.205u L=0.04u
M14945 n4786 n4749 VSS VSS nmos W=0.155u L=0.04u
M14946 n4786 n4787 VSS VSS nmos W=0.155u L=0.04u
M14947 U5187/XI1-net8 n4787 VDD VDD pmos W=0.205u L=0.04u
M14948 n4786 n4749 U5187/XI1-net8 VDD pmos W=0.205u L=0.04u
M14949 n3147 n4750 U5188/net10 VSS nmos W=0.155u L=0.04u
M14950 U5188/net10 n4788 VSS VSS nmos W=0.155u L=0.04u
M14951 n3147 n4785 U5188/net10 VSS nmos W=0.155u L=0.04u
M14952 U5188/net10 g428 VSS VSS nmos W=0.155u L=0.04u
M14953 U5188/net30 n4788 VDD VDD pmos W=0.205u L=0.04u
M14954 n3147 n4750 U5188/net24 VDD pmos W=0.205u L=0.04u
M14955 U5188/net24 n4785 VDD VDD pmos W=0.205u L=0.04u
M14956 n3147 g428 U5188/net30 VDD pmos W=0.205u L=0.04u
M14957 n4788 n4750 VSS VSS nmos W=0.155u L=0.04u
M14958 n4788 n4787 VSS VSS nmos W=0.155u L=0.04u
M14959 U5189/XI1-net8 n4787 VDD VDD pmos W=0.205u L=0.04u
M14960 n4788 n4750 U5189/XI1-net8 VDD pmos W=0.205u L=0.04u
M14961 n3146 n4751 U5190/net10 VSS nmos W=0.155u L=0.04u
M14962 U5190/net10 n4789 VSS VSS nmos W=0.155u L=0.04u
M14963 n3146 n4785 U5190/net10 VSS nmos W=0.155u L=0.04u
M14964 U5190/net10 g426 VSS VSS nmos W=0.155u L=0.04u
M14965 U5190/net30 n4789 VDD VDD pmos W=0.205u L=0.04u
M14966 n3146 n4751 U5190/net24 VDD pmos W=0.205u L=0.04u
M14967 U5190/net24 n4785 VDD VDD pmos W=0.205u L=0.04u
M14968 n3146 g426 U5190/net30 VDD pmos W=0.205u L=0.04u
M14969 n4789 n4751 VSS VSS nmos W=0.155u L=0.04u
M14970 n4789 n4787 VSS VSS nmos W=0.155u L=0.04u
M14971 U5191/XI1-net8 n4787 VDD VDD pmos W=0.205u L=0.04u
M14972 n4789 n4751 U5191/XI1-net8 VDD pmos W=0.205u L=0.04u
M14973 U5192/net13 n4778 VSS VSS nmos W=0.155u L=0.04u
M14974 U5192/net16 U5192/net13 VSS VSS nmos W=0.155u L=0.04u
M14975 n4785 n4790 U5192/net16 VSS nmos W=0.155u L=0.04u
M14976 U5192/net13 n4778 VDD VDD pmos W=0.205u L=0.04u
M14977 VDD U5192/net13 n4785 VDD pmos W=0.205u L=0.04u
M14978 VDD n4790 n4785 VDD pmos W=0.205u L=0.04u
M14979 U5193/net19 n4749 VSS VSS nmos W=0.155u L=0.04u
M14980 n3145 n4749 U5193/net40 VSS nmos W=0.155u L=0.04u
M14981 n3145 U5193/net19 U5193/net36 VSS nmos W=0.155u L=0.04u
M14982 U5193/net40 g408 VSS VSS nmos W=0.31u L=0.04u
M14983 U5193/net36 n4791 VSS VSS nmos W=0.155u L=0.04u
M14984 U5193/net19 n4749 VDD VDD pmos W=0.205u L=0.04u
M14985 n3145 U5193/net19 U5193/net26 VDD pmos W=0.325u L=0.04u
M14986 U5193/net26 g408 VDD VDD pmos W=0.41u L=0.04u
M14987 n3145 n4749 U5193/net30 VDD pmos W=0.325u L=0.04u
M14988 U5193/net30 n4791 VDD VDD pmos W=0.205u L=0.04u
M14989 U5194/net19 n4750 VSS VSS nmos W=0.155u L=0.04u
M14990 n3144 n4750 U5194/net40 VSS nmos W=0.155u L=0.04u
M14991 n3144 U5194/net19 U5194/net36 VSS nmos W=0.155u L=0.04u
M14992 U5194/net40 g411 VSS VSS nmos W=0.31u L=0.04u
M14993 U5194/net36 n4791 VSS VSS nmos W=0.155u L=0.04u
M14994 U5194/net19 n4750 VDD VDD pmos W=0.205u L=0.04u
M14995 n3144 U5194/net19 U5194/net26 VDD pmos W=0.325u L=0.04u
M14996 U5194/net26 g411 VDD VDD pmos W=0.41u L=0.04u
M14997 n3144 n4750 U5194/net30 VDD pmos W=0.325u L=0.04u
M14998 U5194/net30 n4791 VDD VDD pmos W=0.205u L=0.04u
M14999 U5195/net19 n4751 VSS VSS nmos W=0.155u L=0.04u
M15000 n3143 n4751 U5195/net40 VSS nmos W=0.155u L=0.04u
M15001 n3143 U5195/net19 U5195/net36 VSS nmos W=0.155u L=0.04u
M15002 U5195/net40 g414 VSS VSS nmos W=0.31u L=0.04u
M15003 U5195/net36 n4791 VSS VSS nmos W=0.155u L=0.04u
M15004 U5195/net19 n4751 VDD VDD pmos W=0.205u L=0.04u
M15005 n3143 U5195/net19 U5195/net26 VDD pmos W=0.325u L=0.04u
M15006 U5195/net26 g414 VDD VDD pmos W=0.41u L=0.04u
M15007 n3143 n4751 U5195/net30 VDD pmos W=0.325u L=0.04u
M15008 U5195/net30 n4791 VDD VDD pmos W=0.205u L=0.04u
M15009 U5196/net4 n4792 U5196/net14 VSS nmos W=0.155u L=0.04u
M15010 U5196/net6 U5196/net10 U5196/net14 VSS nmos W=0.17u L=0.04u
M15011 U5196/net4 n4793 VSS VSS nmos W=0.155u L=0.04u
M15012 U5196/net6 U5196/net4 VSS VSS nmos W=0.17u L=0.04u
M15013 n4791 U5196/net14 VSS VSS nmos W=0.155u L=0.04u
M15014 U5196/net10 n4792 VSS VSS nmos W=0.155u L=0.04u
M15015 U5196/net4 U5196/net10 U5196/net14 VDD pmos W=0.255u L=0.04u
M15016 U5196/net6 n4792 U5196/net14 VDD pmos W=0.28u L=0.04u
M15017 U5196/net4 n4793 VDD VDD pmos W=0.205u L=0.04u
M15018 U5196/net6 U5196/net4 VDD VDD pmos W=0.24u L=0.04u
M15019 n4791 U5196/net14 VDD VDD pmos W=0.205u L=0.04u
M15020 U5196/net10 n4792 VDD VDD pmos W=0.205u L=0.04u
M15021 U5197/net14 n4790 U5197/net20 VSS nmos W=0.155u L=0.04u
M15022 U5197/net14 n4778 U5197/net20 VSS nmos W=0.155u L=0.04u
M15023 U5197/net20 n4787 VSS VSS nmos W=0.155u L=0.04u
M15024 n4792 U5197/net14 VSS VSS nmos W=0.155u L=0.04u
M15025 n4792 U5197/net14 VDD VDD pmos W=0.205u L=0.04u
M15026 U5197/net14 n4787 VDD VDD pmos W=0.205u L=0.04u
M15027 U5197/net24 n4790 VDD VDD pmos W=0.205u L=0.04u
M15028 U5197/net14 n4778 U5197/net24 VDD pmos W=0.205u L=0.04u
M15029 U5198/XU1-net6 n4794 VSS VSS nmos W=0.155u L=0.04u
M15030 n4787 n4784 U5198/XU1-net6 VSS nmos W=0.155u L=0.04u
M15031 n4787 n4794 VDD VDD pmos W=0.155u L=0.04u
M15032 n4787 n4784 VDD VDD pmos W=0.155u L=0.04u
M15033 n4784 n4793 VSS VSS nmos W=0.155u L=0.04u
M15034 n4784 n4759 VSS VSS nmos W=0.155u L=0.04u
M15035 U5199/XI1-net8 n4759 VDD VDD pmos W=0.205u L=0.04u
M15036 n4784 n4793 U5199/XI1-net8 VDD pmos W=0.205u L=0.04u
M15037 n4790 n4782 VSS VSS nmos W=0.155u L=0.04u
M15038 n4790 U5200/net4 VSS VSS nmos W=0.155u L=0.04u
M15039 U5200/net4 n4794 VSS VSS nmos W=0.155u L=0.04u
M15040 U5200/XU1-net8 U5200/net4 VDD VDD pmos W=0.205u L=0.04u
M15041 n4790 n4782 U5200/XU1-net8 VDD pmos W=0.205u L=0.04u
M15042 U5200/net4 n4794 VDD VDD pmos W=0.205u L=0.04u
M15043 n4782 n4749 U5201/net27 VSS nmos W=0.155u L=0.04u
M15044 U5201/net39 n4750 VSS VSS nmos W=0.155u L=0.04u
M15045 U5201/net27 g426 U5201/net39 VSS nmos W=0.155u L=0.04u
M15046 U5201/net27 n4751 U5201/net39 VSS nmos W=0.155u L=0.04u
M15047 n4782 g427 U5201/net27 VSS nmos W=0.155u L=0.04u
M15048 U5201/net39 g428 VSS VSS nmos W=0.155u L=0.04u
M15049 n4782 n4750 U5201/net46 VDD pmos W=0.205u L=0.04u
M15050 U5201/net46 g428 VDD VDD pmos W=0.205u L=0.04u
M15051 n4782 g427 U5201/net34 VDD pmos W=0.205u L=0.04u
M15052 U5201/net34 n4749 VDD VDD pmos W=0.205u L=0.04u
M15053 n4782 n4751 U5201/net37 VDD pmos W=0.205u L=0.04u
M15054 U5201/net37 g426 VDD VDD pmos W=0.205u L=0.04u
M15055 n4794 U5202/net26 VDD VDD pmos W=0.205u L=0.04u
M15056 U5202/net26 g11860 U5202/net19 VDD pmos W=0.205u L=0.04u
M15057 U5202/net26 n4775 U5202/net19 VDD pmos W=0.205u L=0.04u
M15058 U5202/net26 n4779 U5202/net19 VDD pmos W=0.205u L=0.04u
M15059 U5202/net19 n4781 VDD VDD pmos W=0.205u L=0.04u
M15060 U5202/net26 n4781 VSS VSS nmos W=0.155u L=0.04u
M15061 n4794 U5202/net26 VSS VSS nmos W=0.155u L=0.04u
M15062 U5202/XI20-net13 n4779 VSS VSS nmos W=0.155u L=0.04u
M15063 U5202/net26 g11860 U5202/XI20-net17 VSS nmos W=0.155u L=0.04u
M15064 U5202/XI20-net17 n4775 U5202/XI20-net13 VSS nmos W=0.155u L=0.04u
M15065 n4781 n4779 VSS VSS nmos W=0.155u L=0.04u
M15066 n4781 g11860 VSS VSS nmos W=0.155u L=0.04u
M15067 U5203/XI1-net8 g11860 VDD VDD pmos W=0.205u L=0.04u
M15068 n4781 n4779 U5203/XI1-net8 VDD pmos W=0.205u L=0.04u
M15069 n4779 n4767 VSS VSS nmos W=0.155u L=0.04u
M15070 n4779 n4340 VSS VSS nmos W=0.155u L=0.04u
M15071 n4779 n4343 VSS VSS nmos W=0.155u L=0.04u
M15072 U5204/net25 n4767 VDD VDD pmos W=0.41u L=0.04u
M15073 U5204/net28 n4340 U5204/net25 VDD pmos W=0.41u L=0.04u
M15074 n4779 n4343 U5204/net28 VDD pmos W=0.41u L=0.04u
M15075 n4340 n4795 VSS VSS nmos W=0.135u L=0.04u
M15076 n4340 n4795 VDD VDD pmos W=0.205u L=0.04u
M15077 U5206/XU1-net6 n4793 VSS VSS nmos W=0.155u L=0.04u
M15078 n4778 g309 U5206/XU1-net6 VSS nmos W=0.155u L=0.04u
M15079 n4778 n4793 VDD VDD pmos W=0.155u L=0.04u
M15080 n4778 g309 VDD VDD pmos W=0.155u L=0.04u
M15081 n4793 U5207/net39 VDD VDD pmos W=0.205u L=0.04u
M15082 VDD g401 U5207/net22 VDD pmos W=0.205u L=0.04u
M15083 VDD g414 U5207/net22 VDD pmos W=0.205u L=0.04u
M15084 U5207/net16 g5437 U5207/net39 VDD pmos W=0.205u L=0.04u
M15085 U5207/net16 g408 U5207/net39 VDD pmos W=0.205u L=0.04u
M15086 U5207/net22 g6447 U5207/net16 VDD pmos W=0.205u L=0.04u
M15087 U5207/net22 g411 U5207/net16 VDD pmos W=0.205u L=0.04u
M15088 n4793 U5207/net39 VSS VSS nmos W=0.155u L=0.04u
M15089 U5207/net39 g401 U5207/XI22-net17 VSS nmos W=0.155u L=0.04u
M15090 U5207/XI22-net17 g414 VSS VSS nmos W=0.155u L=0.04u
M15091 U5207/net39 g5437 U5207/XI6-net17 VSS nmos W=0.155u L=0.04u
M15092 U5207/XI6-net17 g408 VSS VSS nmos W=0.155u L=0.04u
M15093 U5207/net39 g6447 U5207/XI21-net17 VSS nmos W=0.155u L=0.04u
M15094 U5207/XI21-net17 g411 VSS VSS nmos W=0.155u L=0.04u
M15095 U5208/net19 n4344 VSS VSS nmos W=0.155u L=0.04u
M15096 n3142 n4344 U5208/net40 VSS nmos W=0.155u L=0.04u
M15097 n3142 U5208/net19 U5208/net36 VSS nmos W=0.155u L=0.04u
M15098 U5208/net40 n4796 VSS VSS nmos W=0.31u L=0.04u
M15099 U5208/net36 g157 VSS VSS nmos W=0.155u L=0.04u
M15100 U5208/net19 n4344 VDD VDD pmos W=0.205u L=0.04u
M15101 n3142 U5208/net19 U5208/net26 VDD pmos W=0.325u L=0.04u
M15102 U5208/net26 n4796 VDD VDD pmos W=0.41u L=0.04u
M15103 n3142 n4344 U5208/net30 VDD pmos W=0.325u L=0.04u
M15104 U5208/net30 g157 VDD VDD pmos W=0.205u L=0.04u
M15105 n4344 U5209/net6 VSS VSS nmos W=0.155u L=0.04u
M15106 U5209/X_u2-net6 g6231 VSS VSS nmos W=0.155u L=0.04u
M15107 U5209/net6 g181 U5209/X_u2-net6 VSS nmos W=0.155u L=0.04u
M15108 n4344 U5209/net6 VDD VDD pmos W=0.205u L=0.04u
M15109 U5209/net6 g6231 VDD VDD pmos W=0.205u L=0.04u
M15110 U5209/net6 g181 VDD VDD pmos W=0.205u L=0.04u
M15111 U5210/net19 n4341 VSS VSS nmos W=0.155u L=0.04u
M15112 n3141 n4341 U5210/net40 VSS nmos W=0.155u L=0.04u
M15113 n3141 U5210/net19 U5210/net36 VSS nmos W=0.155u L=0.04u
M15114 U5210/net40 n4796 VSS VSS nmos W=0.31u L=0.04u
M15115 U5210/net36 g158 VSS VSS nmos W=0.155u L=0.04u
M15116 U5210/net19 n4341 VDD VDD pmos W=0.205u L=0.04u
M15117 n3141 U5210/net19 U5210/net26 VDD pmos W=0.325u L=0.04u
M15118 U5210/net26 n4796 VDD VDD pmos W=0.41u L=0.04u
M15119 n3141 n4341 U5210/net30 VDD pmos W=0.325u L=0.04u
M15120 U5210/net30 g158 VDD VDD pmos W=0.205u L=0.04u
M15121 n4341 U5211/net6 VSS VSS nmos W=0.155u L=0.04u
M15122 U5211/X_u2-net6 g6313 VSS VSS nmos W=0.155u L=0.04u
M15123 U5211/net6 g181 U5211/X_u2-net6 VSS nmos W=0.155u L=0.04u
M15124 n4341 U5211/net6 VDD VDD pmos W=0.205u L=0.04u
M15125 U5211/net6 g6313 VDD VDD pmos W=0.205u L=0.04u
M15126 U5211/net6 g181 VDD VDD pmos W=0.205u L=0.04u
M15127 U5212/net19 n4342 VSS VSS nmos W=0.155u L=0.04u
M15128 n3140 n4342 U5212/net40 VSS nmos W=0.155u L=0.04u
M15129 n3140 U5212/net19 U5212/net36 VSS nmos W=0.155u L=0.04u
M15130 U5212/net40 n4796 VSS VSS nmos W=0.31u L=0.04u
M15131 U5212/net36 g156 VSS VSS nmos W=0.155u L=0.04u
M15132 U5212/net19 n4342 VDD VDD pmos W=0.205u L=0.04u
M15133 n3140 U5212/net19 U5212/net26 VDD pmos W=0.325u L=0.04u
M15134 U5212/net26 n4796 VDD VDD pmos W=0.41u L=0.04u
M15135 n3140 n4342 U5212/net30 VDD pmos W=0.325u L=0.04u
M15136 U5212/net30 g156 VDD VDD pmos W=0.205u L=0.04u
M15137 n3139 n4749 U5213/net10 VSS nmos W=0.155u L=0.04u
M15138 U5213/net10 n4798 VSS VSS nmos W=0.155u L=0.04u
M15139 n3139 n4797 U5213/net10 VSS nmos W=0.155u L=0.04u
M15140 U5213/net10 g403 VSS VSS nmos W=0.155u L=0.04u
M15141 U5213/net30 n4798 VDD VDD pmos W=0.205u L=0.04u
M15142 n3139 n4749 U5213/net24 VDD pmos W=0.205u L=0.04u
M15143 U5213/net24 n4797 VDD VDD pmos W=0.205u L=0.04u
M15144 n3139 g403 U5213/net30 VDD pmos W=0.205u L=0.04u
M15145 n4798 n4749 VSS VSS nmos W=0.155u L=0.04u
M15146 n4798 n4759 VSS VSS nmos W=0.155u L=0.04u
M15147 U5214/XI1-net8 n4759 VDD VDD pmos W=0.205u L=0.04u
M15148 n4798 n4749 U5214/XI1-net8 VDD pmos W=0.205u L=0.04u
M15149 n3138 n4750 U5215/net10 VSS nmos W=0.155u L=0.04u
M15150 U5215/net10 n4799 VSS VSS nmos W=0.155u L=0.04u
M15151 n3138 n4797 U5215/net10 VSS nmos W=0.155u L=0.04u
M15152 U5215/net10 g404 VSS VSS nmos W=0.155u L=0.04u
M15153 U5215/net30 n4799 VDD VDD pmos W=0.205u L=0.04u
M15154 n3138 n4750 U5215/net24 VDD pmos W=0.205u L=0.04u
M15155 U5215/net24 n4797 VDD VDD pmos W=0.205u L=0.04u
M15156 n3138 g404 U5215/net30 VDD pmos W=0.205u L=0.04u
M15157 n4799 n4750 VSS VSS nmos W=0.155u L=0.04u
M15158 n4799 n4759 VSS VSS nmos W=0.155u L=0.04u
M15159 U5216/XI1-net8 n4759 VDD VDD pmos W=0.205u L=0.04u
M15160 n4799 n4750 U5216/XI1-net8 VDD pmos W=0.205u L=0.04u
M15161 n3137 n4751 U5217/net10 VSS nmos W=0.155u L=0.04u
M15162 U5217/net10 n4800 VSS VSS nmos W=0.155u L=0.04u
M15163 n3137 n4797 U5217/net10 VSS nmos W=0.155u L=0.04u
M15164 U5217/net10 g402 VSS VSS nmos W=0.155u L=0.04u
M15165 U5217/net30 n4800 VDD VDD pmos W=0.205u L=0.04u
M15166 n3137 n4751 U5217/net24 VDD pmos W=0.205u L=0.04u
M15167 U5217/net24 n4797 VDD VDD pmos W=0.205u L=0.04u
M15168 n3137 g402 U5217/net30 VDD pmos W=0.205u L=0.04u
M15169 n4800 n4751 VSS VSS nmos W=0.155u L=0.04u
M15170 n4800 n4759 VSS VSS nmos W=0.155u L=0.04u
M15171 U5218/XI1-net8 n4759 VDD VDD pmos W=0.205u L=0.04u
M15172 n4800 n4751 U5218/XI1-net8 VDD pmos W=0.205u L=0.04u
M15173 U5219/net30 n4801 VSS VSS nmos W=0.155u L=0.04u
M15174 n4797 n4802 U5219/net23 VSS nmos W=0.155u L=0.04u
M15175 U5219/net20 U5219/net30 VSS VSS nmos W=0.155u L=0.04u
M15176 U5219/net23 g309 U5219/net20 VSS nmos W=0.155u L=0.04u
M15177 U5219/net30 n4801 VDD VDD pmos W=0.205u L=0.04u
M15178 VDD n4802 n4797 VDD pmos W=0.205u L=0.04u
M15179 VDD g309 n4797 VDD pmos W=0.205u L=0.04u
M15180 VDD U5219/net30 n4797 VDD pmos W=0.205u L=0.04u
M15181 U5220/net19 n4749 VSS VSS nmos W=0.155u L=0.04u
M15182 n3136 n4749 U5220/net40 VSS nmos W=0.155u L=0.04u
M15183 n3136 U5220/net19 U5220/net36 VSS nmos W=0.155u L=0.04u
M15184 U5220/net40 g312 VSS VSS nmos W=0.31u L=0.04u
M15185 U5220/net36 n4803 VSS VSS nmos W=0.155u L=0.04u
M15186 U5220/net19 n4749 VDD VDD pmos W=0.205u L=0.04u
M15187 n3136 U5220/net19 U5220/net26 VDD pmos W=0.325u L=0.04u
M15188 U5220/net26 g312 VDD VDD pmos W=0.41u L=0.04u
M15189 n3136 n4749 U5220/net30 VDD pmos W=0.325u L=0.04u
M15190 U5220/net30 n4803 VDD VDD pmos W=0.205u L=0.04u
M15191 U5221/net19 n4750 VSS VSS nmos W=0.155u L=0.04u
M15192 n3135 n4750 U5221/net40 VSS nmos W=0.155u L=0.04u
M15193 n3135 U5221/net19 U5221/net36 VSS nmos W=0.155u L=0.04u
M15194 U5221/net40 g313 VSS VSS nmos W=0.31u L=0.04u
M15195 U5221/net36 n4803 VSS VSS nmos W=0.155u L=0.04u
M15196 U5221/net19 n4750 VDD VDD pmos W=0.205u L=0.04u
M15197 n3135 U5221/net19 U5221/net26 VDD pmos W=0.325u L=0.04u
M15198 U5221/net26 g313 VDD VDD pmos W=0.41u L=0.04u
M15199 n3135 n4750 U5221/net30 VDD pmos W=0.325u L=0.04u
M15200 U5221/net30 n4803 VDD VDD pmos W=0.205u L=0.04u
M15201 U5222/net19 n4751 VSS VSS nmos W=0.155u L=0.04u
M15202 n3134 n4751 U5222/net40 VSS nmos W=0.155u L=0.04u
M15203 n3134 U5222/net19 U5222/net36 VSS nmos W=0.155u L=0.04u
M15204 U5222/net40 g314 VSS VSS nmos W=0.31u L=0.04u
M15205 U5222/net36 n4803 VSS VSS nmos W=0.155u L=0.04u
M15206 U5222/net19 n4751 VDD VDD pmos W=0.205u L=0.04u
M15207 n3134 U5222/net19 U5222/net26 VDD pmos W=0.325u L=0.04u
M15208 U5222/net26 g314 VDD VDD pmos W=0.41u L=0.04u
M15209 n3134 n4751 U5222/net30 VDD pmos W=0.325u L=0.04u
M15210 U5222/net30 n4803 VDD VDD pmos W=0.205u L=0.04u
M15211 n4803 U5223/net6 VSS VSS nmos W=0.155u L=0.04u
M15212 U5223/X_u2-net6 n4805 VSS VSS nmos W=0.155u L=0.04u
M15213 U5223/net6 n4804 U5223/X_u2-net6 VSS nmos W=0.155u L=0.04u
M15214 n4803 U5223/net6 VDD VDD pmos W=0.205u L=0.04u
M15215 U5223/net6 n4805 VDD VDD pmos W=0.205u L=0.04u
M15216 U5223/net6 n4804 VDD VDD pmos W=0.205u L=0.04u
M15217 n4804 U5224/net26 VDD VDD pmos W=0.205u L=0.04u
M15218 U5224/net26 n4806 U5224/net19 VDD pmos W=0.205u L=0.04u
M15219 U5224/net26 n4807 U5224/net19 VDD pmos W=0.205u L=0.04u
M15220 U5224/net26 n4808 U5224/net19 VDD pmos W=0.205u L=0.04u
M15221 U5224/net19 n4809 VDD VDD pmos W=0.205u L=0.04u
M15222 U5224/net26 n4809 VSS VSS nmos W=0.155u L=0.04u
M15223 n4804 U5224/net26 VSS VSS nmos W=0.155u L=0.04u
M15224 U5224/XI20-net13 n4808 VSS VSS nmos W=0.155u L=0.04u
M15225 U5224/net26 n4806 U5224/XI20-net17 VSS nmos W=0.155u L=0.04u
M15226 U5224/XI20-net17 n4807 U5224/XI20-net13 VSS nmos W=0.155u L=0.04u
M15227 U5225/net19 n4769 VSS VSS nmos W=0.155u L=0.04u
M15228 n3133 n4769 U5225/net40 VSS nmos W=0.155u L=0.04u
M15229 n3133 U5225/net19 U5225/net36 VSS nmos W=0.155u L=0.04u
M15230 U5225/net40 g213 VSS VSS nmos W=0.31u L=0.04u
M15231 U5225/net36 n4810 VSS VSS nmos W=0.155u L=0.04u
M15232 U5225/net19 n4769 VDD VDD pmos W=0.205u L=0.04u
M15233 n3133 U5225/net19 U5225/net26 VDD pmos W=0.325u L=0.04u
M15234 U5225/net26 g213 VDD VDD pmos W=0.41u L=0.04u
M15235 n3133 n4769 U5225/net30 VDD pmos W=0.325u L=0.04u
M15236 U5225/net30 n4810 VDD VDD pmos W=0.205u L=0.04u
M15237 U5226/net19 n4771 VSS VSS nmos W=0.155u L=0.04u
M15238 n3132 n4771 U5226/net40 VSS nmos W=0.155u L=0.04u
M15239 n3132 U5226/net19 U5226/net36 VSS nmos W=0.155u L=0.04u
M15240 U5226/net40 g216 VSS VSS nmos W=0.31u L=0.04u
M15241 U5226/net36 n4810 VSS VSS nmos W=0.155u L=0.04u
M15242 U5226/net19 n4771 VDD VDD pmos W=0.205u L=0.04u
M15243 n3132 U5226/net19 U5226/net26 VDD pmos W=0.325u L=0.04u
M15244 U5226/net26 g216 VDD VDD pmos W=0.41u L=0.04u
M15245 n3132 n4771 U5226/net30 VDD pmos W=0.325u L=0.04u
M15246 U5226/net30 n4810 VDD VDD pmos W=0.205u L=0.04u
M15247 U5227/net19 n4770 VSS VSS nmos W=0.155u L=0.04u
M15248 n3131 n4770 U5227/net40 VSS nmos W=0.155u L=0.04u
M15249 n3131 U5227/net19 U5227/net36 VSS nmos W=0.155u L=0.04u
M15250 U5227/net40 g219 VSS VSS nmos W=0.31u L=0.04u
M15251 U5227/net36 n4810 VSS VSS nmos W=0.155u L=0.04u
M15252 U5227/net19 n4770 VDD VDD pmos W=0.205u L=0.04u
M15253 n3131 U5227/net19 U5227/net26 VDD pmos W=0.325u L=0.04u
M15254 U5227/net26 g219 VDD VDD pmos W=0.41u L=0.04u
M15255 n3131 n4770 U5227/net30 VDD pmos W=0.325u L=0.04u
M15256 U5227/net30 n4810 VDD VDD pmos W=0.205u L=0.04u
M15257 n4810 n4747 U5228/net10 VSS nmos W=0.155u L=0.04u
M15258 U5228/net10 n4813 VSS VSS nmos W=0.155u L=0.04u
M15259 n4810 n4811 U5228/net10 VSS nmos W=0.155u L=0.04u
M15260 U5228/net10 n4812 VSS VSS nmos W=0.155u L=0.04u
M15261 U5228/net30 n4813 VDD VDD pmos W=0.205u L=0.04u
M15262 n4810 n4747 U5228/net24 VDD pmos W=0.205u L=0.04u
M15263 U5228/net24 n4811 VDD VDD pmos W=0.205u L=0.04u
M15264 n4810 n4812 U5228/net30 VDD pmos W=0.205u L=0.04u
M15265 U5229/net4 n4814 U5229/net14 VSS nmos W=0.155u L=0.04u
M15266 U5229/net6 U5229/net10 U5229/net14 VSS nmos W=0.17u L=0.04u
M15267 U5229/net4 n4815 VSS VSS nmos W=0.155u L=0.04u
M15268 U5229/net6 U5229/net4 VSS VSS nmos W=0.17u L=0.04u
M15269 n4813 U5229/net14 VSS VSS nmos W=0.155u L=0.04u
M15270 U5229/net10 n4814 VSS VSS nmos W=0.155u L=0.04u
M15271 U5229/net4 U5229/net10 U5229/net14 VDD pmos W=0.255u L=0.04u
M15272 U5229/net6 n4814 U5229/net14 VDD pmos W=0.28u L=0.04u
M15273 U5229/net4 n4815 VDD VDD pmos W=0.205u L=0.04u
M15274 U5229/net6 U5229/net4 VDD VDD pmos W=0.24u L=0.04u
M15275 n4813 U5229/net14 VDD VDD pmos W=0.205u L=0.04u
M15276 U5229/net10 n4814 VDD VDD pmos W=0.205u L=0.04u
M15277 U5230/net19 n4769 VSS VSS nmos W=0.155u L=0.04u
M15278 n3130 n4769 U5230/net40 VSS nmos W=0.155u L=0.04u
M15279 n3130 U5230/net19 U5230/net36 VSS nmos W=0.155u L=0.04u
M15280 U5230/net40 g249 VSS VSS nmos W=0.31u L=0.04u
M15281 U5230/net36 n4816 VSS VSS nmos W=0.155u L=0.04u
M15282 U5230/net19 n4769 VDD VDD pmos W=0.205u L=0.04u
M15283 n3130 U5230/net19 U5230/net26 VDD pmos W=0.325u L=0.04u
M15284 U5230/net26 g249 VDD VDD pmos W=0.41u L=0.04u
M15285 n3130 n4769 U5230/net30 VDD pmos W=0.325u L=0.04u
M15286 U5230/net30 n4816 VDD VDD pmos W=0.205u L=0.04u
M15287 U5231/net19 n4771 VSS VSS nmos W=0.155u L=0.04u
M15288 n3129 n4771 U5231/net40 VSS nmos W=0.155u L=0.04u
M15289 n3129 U5231/net19 U5231/net36 VSS nmos W=0.155u L=0.04u
M15290 U5231/net40 g252 VSS VSS nmos W=0.31u L=0.04u
M15291 U5231/net36 n4816 VSS VSS nmos W=0.155u L=0.04u
M15292 U5231/net19 n4771 VDD VDD pmos W=0.205u L=0.04u
M15293 n3129 U5231/net19 U5231/net26 VDD pmos W=0.325u L=0.04u
M15294 U5231/net26 g252 VDD VDD pmos W=0.41u L=0.04u
M15295 n3129 n4771 U5231/net30 VDD pmos W=0.325u L=0.04u
M15296 U5231/net30 n4816 VDD VDD pmos W=0.205u L=0.04u
M15297 U5232/net19 n4770 VSS VSS nmos W=0.155u L=0.04u
M15298 n3128 n4770 U5232/net40 VSS nmos W=0.155u L=0.04u
M15299 n3128 U5232/net19 U5232/net36 VSS nmos W=0.155u L=0.04u
M15300 U5232/net40 g255 VSS VSS nmos W=0.31u L=0.04u
M15301 U5232/net36 n4816 VSS VSS nmos W=0.155u L=0.04u
M15302 U5232/net19 n4770 VDD VDD pmos W=0.205u L=0.04u
M15303 n3128 U5232/net19 U5232/net26 VDD pmos W=0.325u L=0.04u
M15304 U5232/net26 g255 VDD VDD pmos W=0.41u L=0.04u
M15305 n3128 n4770 U5232/net30 VDD pmos W=0.325u L=0.04u
M15306 U5232/net30 n4816 VDD VDD pmos W=0.205u L=0.04u
M15307 n4816 n4746 U5233/net10 VSS nmos W=0.155u L=0.04u
M15308 U5233/net10 n4817 VSS VSS nmos W=0.155u L=0.04u
M15309 n4816 n4811 U5233/net10 VSS nmos W=0.155u L=0.04u
M15310 U5233/net10 n4812 VSS VSS nmos W=0.155u L=0.04u
M15311 U5233/net30 n4817 VDD VDD pmos W=0.205u L=0.04u
M15312 n4816 n4746 U5233/net24 VDD pmos W=0.205u L=0.04u
M15313 U5233/net24 n4811 VDD VDD pmos W=0.205u L=0.04u
M15314 n4816 n4812 U5233/net30 VDD pmos W=0.205u L=0.04u
M15315 U5234/net4 n4818 U5234/net14 VSS nmos W=0.155u L=0.04u
M15316 U5234/net6 U5234/net10 U5234/net14 VSS nmos W=0.17u L=0.04u
M15317 U5234/net4 n4819 VSS VSS nmos W=0.155u L=0.04u
M15318 U5234/net6 U5234/net4 VSS VSS nmos W=0.17u L=0.04u
M15319 n4817 U5234/net14 VSS VSS nmos W=0.155u L=0.04u
M15320 U5234/net10 n4818 VSS VSS nmos W=0.155u L=0.04u
M15321 U5234/net4 U5234/net10 U5234/net14 VDD pmos W=0.255u L=0.04u
M15322 U5234/net6 n4818 U5234/net14 VDD pmos W=0.28u L=0.04u
M15323 U5234/net4 n4819 VDD VDD pmos W=0.205u L=0.04u
M15324 U5234/net6 U5234/net4 VDD VDD pmos W=0.24u L=0.04u
M15325 n4817 U5234/net14 VDD VDD pmos W=0.205u L=0.04u
M15326 U5234/net10 n4818 VDD VDD pmos W=0.205u L=0.04u
M15327 U5235/XU1-net6 n4821 VSS VSS nmos W=0.155u L=0.04u
M15328 n4818 n4820 U5235/XU1-net6 VSS nmos W=0.155u L=0.04u
M15329 n4818 n4821 VDD VDD pmos W=0.155u L=0.04u
M15330 n4818 n4820 VDD VDD pmos W=0.155u L=0.04u
M15331 U5236/net19 n4771 VSS VSS nmos W=0.155u L=0.04u
M15332 n3127 n4771 U5236/net40 VSS nmos W=0.155u L=0.04u
M15333 n3127 U5236/net19 U5236/net36 VSS nmos W=0.155u L=0.04u
M15334 U5236/net40 g207 VSS VSS nmos W=0.31u L=0.04u
M15335 U5236/net36 n4822 VSS VSS nmos W=0.155u L=0.04u
M15336 U5236/net19 n4771 VDD VDD pmos W=0.205u L=0.04u
M15337 n3127 U5236/net19 U5236/net26 VDD pmos W=0.325u L=0.04u
M15338 U5236/net26 g207 VDD VDD pmos W=0.41u L=0.04u
M15339 n3127 n4771 U5236/net30 VDD pmos W=0.325u L=0.04u
M15340 U5236/net30 n4822 VDD VDD pmos W=0.205u L=0.04u
M15341 U5237/net19 n4770 VSS VSS nmos W=0.155u L=0.04u
M15342 n3126 n4770 U5237/net40 VSS nmos W=0.155u L=0.04u
M15343 n3126 U5237/net19 U5237/net36 VSS nmos W=0.155u L=0.04u
M15344 U5237/net40 g210 VSS VSS nmos W=0.31u L=0.04u
M15345 U5237/net36 n4822 VSS VSS nmos W=0.155u L=0.04u
M15346 U5237/net19 n4770 VDD VDD pmos W=0.205u L=0.04u
M15347 n3126 U5237/net19 U5237/net26 VDD pmos W=0.325u L=0.04u
M15348 U5237/net26 g210 VDD VDD pmos W=0.41u L=0.04u
M15349 n3126 n4770 U5237/net30 VDD pmos W=0.325u L=0.04u
M15350 U5237/net30 n4822 VDD VDD pmos W=0.205u L=0.04u
M15351 U5238/net19 n4769 VSS VSS nmos W=0.155u L=0.04u
M15352 n3125 n4769 U5238/net40 VSS nmos W=0.155u L=0.04u
M15353 n3125 U5238/net19 U5238/net36 VSS nmos W=0.155u L=0.04u
M15354 U5238/net40 g204 VSS VSS nmos W=0.31u L=0.04u
M15355 U5238/net36 n4822 VSS VSS nmos W=0.155u L=0.04u
M15356 U5238/net19 n4769 VDD VDD pmos W=0.205u L=0.04u
M15357 n3125 U5238/net19 U5238/net26 VDD pmos W=0.325u L=0.04u
M15358 U5238/net26 g204 VDD VDD pmos W=0.41u L=0.04u
M15359 n3125 n4769 U5238/net30 VDD pmos W=0.325u L=0.04u
M15360 U5238/net30 n4822 VDD VDD pmos W=0.205u L=0.04u
M15361 n4822 n4745 U5239/net10 VSS nmos W=0.155u L=0.04u
M15362 U5239/net10 n4823 VSS VSS nmos W=0.155u L=0.04u
M15363 n4822 n4811 U5239/net10 VSS nmos W=0.155u L=0.04u
M15364 U5239/net10 n4812 VSS VSS nmos W=0.155u L=0.04u
M15365 U5239/net30 n4823 VDD VDD pmos W=0.205u L=0.04u
M15366 n4822 n4745 U5239/net24 VDD pmos W=0.205u L=0.04u
M15367 U5239/net24 n4811 VDD VDD pmos W=0.205u L=0.04u
M15368 n4822 n4812 U5239/net30 VDD pmos W=0.205u L=0.04u
M15369 U5240/net4 n4824 U5240/net14 VSS nmos W=0.155u L=0.04u
M15370 U5240/net6 U5240/net10 U5240/net14 VSS nmos W=0.17u L=0.04u
M15371 U5240/net4 n4820 VSS VSS nmos W=0.155u L=0.04u
M15372 U5240/net6 U5240/net4 VSS VSS nmos W=0.17u L=0.04u
M15373 n4823 U5240/net14 VSS VSS nmos W=0.155u L=0.04u
M15374 U5240/net10 n4824 VSS VSS nmos W=0.155u L=0.04u
M15375 U5240/net4 U5240/net10 U5240/net14 VDD pmos W=0.255u L=0.04u
M15376 U5240/net6 n4824 U5240/net14 VDD pmos W=0.28u L=0.04u
M15377 U5240/net4 n4820 VDD VDD pmos W=0.205u L=0.04u
M15378 U5240/net6 U5240/net4 VDD VDD pmos W=0.24u L=0.04u
M15379 n4823 U5240/net14 VDD VDD pmos W=0.205u L=0.04u
M15380 U5240/net10 n4824 VDD VDD pmos W=0.205u L=0.04u
M15381 U5241/net19 n4769 VSS VSS nmos W=0.155u L=0.04u
M15382 n3124 n4769 U5241/net40 VSS nmos W=0.155u L=0.04u
M15383 n3124 U5241/net19 U5241/net36 VSS nmos W=0.155u L=0.04u
M15384 U5241/net40 g186 VSS VSS nmos W=0.31u L=0.04u
M15385 U5241/net36 n4825 VSS VSS nmos W=0.155u L=0.04u
M15386 U5241/net19 n4769 VDD VDD pmos W=0.205u L=0.04u
M15387 n3124 U5241/net19 U5241/net26 VDD pmos W=0.325u L=0.04u
M15388 U5241/net26 g186 VDD VDD pmos W=0.41u L=0.04u
M15389 n3124 n4769 U5241/net30 VDD pmos W=0.325u L=0.04u
M15390 U5241/net30 n4825 VDD VDD pmos W=0.205u L=0.04u
M15391 U5242/net19 n4771 VSS VSS nmos W=0.155u L=0.04u
M15392 n3123 n4771 U5242/net40 VSS nmos W=0.155u L=0.04u
M15393 n3123 U5242/net19 U5242/net36 VSS nmos W=0.155u L=0.04u
M15394 U5242/net40 g189 VSS VSS nmos W=0.31u L=0.04u
M15395 U5242/net36 n4825 VSS VSS nmos W=0.155u L=0.04u
M15396 U5242/net19 n4771 VDD VDD pmos W=0.205u L=0.04u
M15397 n3123 U5242/net19 U5242/net26 VDD pmos W=0.325u L=0.04u
M15398 U5242/net26 g189 VDD VDD pmos W=0.41u L=0.04u
M15399 n3123 n4771 U5242/net30 VDD pmos W=0.325u L=0.04u
M15400 U5242/net30 n4825 VDD VDD pmos W=0.205u L=0.04u
M15401 U5243/net19 n4770 VSS VSS nmos W=0.155u L=0.04u
M15402 n3122 n4770 U5243/net40 VSS nmos W=0.155u L=0.04u
M15403 n3122 U5243/net19 U5243/net36 VSS nmos W=0.155u L=0.04u
M15404 U5243/net40 g192 VSS VSS nmos W=0.31u L=0.04u
M15405 U5243/net36 n4825 VSS VSS nmos W=0.155u L=0.04u
M15406 U5243/net19 n4770 VDD VDD pmos W=0.205u L=0.04u
M15407 n3122 U5243/net19 U5243/net26 VDD pmos W=0.325u L=0.04u
M15408 U5243/net26 g192 VDD VDD pmos W=0.41u L=0.04u
M15409 n3122 n4770 U5243/net30 VDD pmos W=0.325u L=0.04u
M15410 U5243/net30 n4825 VDD VDD pmos W=0.205u L=0.04u
M15411 n4825 n4741 U5244/net10 VSS nmos W=0.155u L=0.04u
M15412 U5244/net10 n4812 VSS VSS nmos W=0.155u L=0.04u
M15413 n4825 n4811 U5244/net10 VSS nmos W=0.155u L=0.04u
M15414 U5244/net10 n4826 VSS VSS nmos W=0.155u L=0.04u
M15415 U5244/net30 n4812 VDD VDD pmos W=0.205u L=0.04u
M15416 n4825 n4741 U5244/net24 VDD pmos W=0.205u L=0.04u
M15417 U5244/net24 n4811 VDD VDD pmos W=0.205u L=0.04u
M15418 n4825 n4826 U5244/net30 VDD pmos W=0.205u L=0.04u
M15419 U5245/net4 n4827 U5245/net14 VSS nmos W=0.155u L=0.04u
M15420 U5245/net6 U5245/net10 U5245/net14 VSS nmos W=0.17u L=0.04u
M15421 U5245/net4 n4828 VSS VSS nmos W=0.155u L=0.04u
M15422 U5245/net6 U5245/net4 VSS VSS nmos W=0.17u L=0.04u
M15423 n4826 U5245/net14 VSS VSS nmos W=0.155u L=0.04u
M15424 U5245/net10 n4827 VSS VSS nmos W=0.155u L=0.04u
M15425 U5245/net4 U5245/net10 U5245/net14 VDD pmos W=0.255u L=0.04u
M15426 U5245/net6 n4827 U5245/net14 VDD pmos W=0.28u L=0.04u
M15427 U5245/net4 n4828 VDD VDD pmos W=0.205u L=0.04u
M15428 U5245/net6 U5245/net4 VDD VDD pmos W=0.24u L=0.04u
M15429 n4826 U5245/net14 VDD VDD pmos W=0.205u L=0.04u
M15430 U5245/net10 n4827 VDD VDD pmos W=0.205u L=0.04u
M15431 U5246/net19 n4769 VSS VSS nmos W=0.155u L=0.04u
M15432 n3121 n4769 U5246/net40 VSS nmos W=0.155u L=0.04u
M15433 n3121 U5246/net19 U5246/net36 VSS nmos W=0.155u L=0.04u
M15434 U5246/net40 g267 VSS VSS nmos W=0.31u L=0.04u
M15435 U5246/net36 n4829 VSS VSS nmos W=0.155u L=0.04u
M15436 U5246/net19 n4769 VDD VDD pmos W=0.205u L=0.04u
M15437 n3121 U5246/net19 U5246/net26 VDD pmos W=0.325u L=0.04u
M15438 U5246/net26 g267 VDD VDD pmos W=0.41u L=0.04u
M15439 n3121 n4769 U5246/net30 VDD pmos W=0.325u L=0.04u
M15440 U5246/net30 n4829 VDD VDD pmos W=0.205u L=0.04u
M15441 U5247/net19 n4771 VSS VSS nmos W=0.155u L=0.04u
M15442 n3120 n4771 U5247/net40 VSS nmos W=0.155u L=0.04u
M15443 n3120 U5247/net19 U5247/net36 VSS nmos W=0.155u L=0.04u
M15444 U5247/net40 g270 VSS VSS nmos W=0.31u L=0.04u
M15445 U5247/net36 n4829 VSS VSS nmos W=0.155u L=0.04u
M15446 U5247/net19 n4771 VDD VDD pmos W=0.205u L=0.04u
M15447 n3120 U5247/net19 U5247/net26 VDD pmos W=0.325u L=0.04u
M15448 U5247/net26 g270 VDD VDD pmos W=0.41u L=0.04u
M15449 n3120 n4771 U5247/net30 VDD pmos W=0.325u L=0.04u
M15450 U5247/net30 n4829 VDD VDD pmos W=0.205u L=0.04u
M15451 U5248/net19 n4770 VSS VSS nmos W=0.155u L=0.04u
M15452 n3119 n4770 U5248/net40 VSS nmos W=0.155u L=0.04u
M15453 n3119 U5248/net19 U5248/net36 VSS nmos W=0.155u L=0.04u
M15454 U5248/net40 g273 VSS VSS nmos W=0.31u L=0.04u
M15455 U5248/net36 n4829 VSS VSS nmos W=0.155u L=0.04u
M15456 U5248/net19 n4770 VDD VDD pmos W=0.205u L=0.04u
M15457 n3119 U5248/net19 U5248/net26 VDD pmos W=0.325u L=0.04u
M15458 U5248/net26 g273 VDD VDD pmos W=0.41u L=0.04u
M15459 n3119 n4770 U5248/net30 VDD pmos W=0.325u L=0.04u
M15460 U5248/net30 n4829 VDD VDD pmos W=0.205u L=0.04u
M15461 U5249/net32 n4811 U5249/net26 VSS nmos W=0.155u L=0.04u
M15462 U5249/net32 n4795 U5249/net26 VSS nmos W=0.155u L=0.04u
M15463 U5249/net29 n4831 VSS VSS nmos W=0.155u L=0.04u
M15464 U5249/net26 n4830 U5249/net29 VSS nmos W=0.155u L=0.04u
M15465 U5249/net26 n4812 U5249/net29 VSS nmos W=0.155u L=0.04u
M15466 n4829 U5249/net32 VSS VSS nmos W=0.155u L=0.04u
M15467 n4829 U5249/net32 VDD VDD pmos W=0.205u L=0.04u
M15468 U5249/net32 n4795 U5249/net43 VDD pmos W=0.205u L=0.04u
M15469 U5249/net32 n4812 U5249/net49 VDD pmos W=0.205u L=0.04u
M15470 U5249/net49 n4830 VDD VDD pmos W=0.205u L=0.04u
M15471 U5249/net43 n4811 VDD VDD pmos W=0.205u L=0.04u
M15472 U5249/net32 n4831 VDD VDD pmos W=0.205u L=0.04u
M15473 U5250/net4 n4832 U5250/net14 VSS nmos W=0.155u L=0.04u
M15474 U5250/net6 U5250/net10 U5250/net14 VSS nmos W=0.17u L=0.04u
M15475 U5250/net4 n4833 VSS VSS nmos W=0.155u L=0.04u
M15476 U5250/net6 U5250/net4 VSS VSS nmos W=0.17u L=0.04u
M15477 n4830 U5250/net14 VSS VSS nmos W=0.155u L=0.04u
M15478 U5250/net10 n4832 VSS VSS nmos W=0.155u L=0.04u
M15479 U5250/net4 U5250/net10 U5250/net14 VDD pmos W=0.255u L=0.04u
M15480 U5250/net6 n4832 U5250/net14 VDD pmos W=0.28u L=0.04u
M15481 U5250/net4 n4833 VDD VDD pmos W=0.205u L=0.04u
M15482 U5250/net6 U5250/net4 VDD VDD pmos W=0.24u L=0.04u
M15483 n4830 U5250/net14 VDD VDD pmos W=0.205u L=0.04u
M15484 U5250/net10 n4832 VDD VDD pmos W=0.205u L=0.04u
M15485 n4832 n4834 VSS VSS nmos W=0.155u L=0.04u
M15486 n4832 n4835 VSS VSS nmos W=0.155u L=0.04u
M15487 U5251/XI1-net8 n4835 VDD VDD pmos W=0.205u L=0.04u
M15488 n4832 n4834 U5251/XI1-net8 VDD pmos W=0.205u L=0.04u
M15489 U5252/net4 n4809 U5252/net14 VSS nmos W=0.155u L=0.04u
M15490 U5252/net6 U5252/net10 U5252/net14 VSS nmos W=0.17u L=0.04u
M15491 U5252/net4 n4836 VSS VSS nmos W=0.155u L=0.04u
M15492 U5252/net6 U5252/net4 VSS VSS nmos W=0.17u L=0.04u
M15493 n4834 U5252/net14 VSS VSS nmos W=0.155u L=0.04u
M15494 U5252/net10 n4809 VSS VSS nmos W=0.155u L=0.04u
M15495 U5252/net4 U5252/net10 U5252/net14 VDD pmos W=0.255u L=0.04u
M15496 U5252/net6 n4809 U5252/net14 VDD pmos W=0.28u L=0.04u
M15497 U5252/net4 n4836 VDD VDD pmos W=0.205u L=0.04u
M15498 U5252/net6 U5252/net4 VDD VDD pmos W=0.24u L=0.04u
M15499 n4834 U5252/net14 VDD VDD pmos W=0.205u L=0.04u
M15500 U5252/net10 n4809 VDD VDD pmos W=0.205u L=0.04u
M15501 U5253/net19 n4769 VSS VSS nmos W=0.155u L=0.04u
M15502 n3118 n4769 U5253/net40 VSS nmos W=0.155u L=0.04u
M15503 n3118 U5253/net19 U5253/net36 VSS nmos W=0.155u L=0.04u
M15504 U5253/net40 g222 VSS VSS nmos W=0.31u L=0.04u
M15505 U5253/net36 n4837 VSS VSS nmos W=0.155u L=0.04u
M15506 U5253/net19 n4769 VDD VDD pmos W=0.205u L=0.04u
M15507 n3118 U5253/net19 U5253/net26 VDD pmos W=0.325u L=0.04u
M15508 U5253/net26 g222 VDD VDD pmos W=0.41u L=0.04u
M15509 n3118 n4769 U5253/net30 VDD pmos W=0.325u L=0.04u
M15510 U5253/net30 n4837 VDD VDD pmos W=0.205u L=0.04u
M15511 U5254/net19 n4771 VSS VSS nmos W=0.155u L=0.04u
M15512 n3117 n4771 U5254/net40 VSS nmos W=0.155u L=0.04u
M15513 n3117 U5254/net19 U5254/net36 VSS nmos W=0.155u L=0.04u
M15514 U5254/net40 g225 VSS VSS nmos W=0.31u L=0.04u
M15515 U5254/net36 n4837 VSS VSS nmos W=0.155u L=0.04u
M15516 U5254/net19 n4771 VDD VDD pmos W=0.205u L=0.04u
M15517 n3117 U5254/net19 U5254/net26 VDD pmos W=0.325u L=0.04u
M15518 U5254/net26 g225 VDD VDD pmos W=0.41u L=0.04u
M15519 n3117 n4771 U5254/net30 VDD pmos W=0.325u L=0.04u
M15520 U5254/net30 n4837 VDD VDD pmos W=0.205u L=0.04u
M15521 U5255/net19 n4770 VSS VSS nmos W=0.155u L=0.04u
M15522 n3116 n4770 U5255/net40 VSS nmos W=0.155u L=0.04u
M15523 n3116 U5255/net19 U5255/net36 VSS nmos W=0.155u L=0.04u
M15524 U5255/net40 g228 VSS VSS nmos W=0.31u L=0.04u
M15525 U5255/net36 n4837 VSS VSS nmos W=0.155u L=0.04u
M15526 U5255/net19 n4770 VDD VDD pmos W=0.205u L=0.04u
M15527 n3116 U5255/net19 U5255/net26 VDD pmos W=0.325u L=0.04u
M15528 U5255/net26 g228 VDD VDD pmos W=0.41u L=0.04u
M15529 n3116 n4770 U5255/net30 VDD pmos W=0.325u L=0.04u
M15530 U5255/net30 n4837 VDD VDD pmos W=0.205u L=0.04u
M15531 n4837 n4811 U5256/net27 VSS nmos W=0.155u L=0.04u
M15532 U5256/net39 n4839 VSS VSS nmos W=0.155u L=0.04u
M15533 U5256/net27 n4812 U5256/net39 VSS nmos W=0.155u L=0.04u
M15534 U5256/net27 n4838 U5256/net39 VSS nmos W=0.155u L=0.04u
M15535 n4837 n4343 U5256/net27 VSS nmos W=0.155u L=0.04u
M15536 U5256/net39 n4809 VSS VSS nmos W=0.155u L=0.04u
M15537 n4837 n4839 U5256/net46 VDD pmos W=0.205u L=0.04u
M15538 U5256/net46 n4809 VDD VDD pmos W=0.205u L=0.04u
M15539 n4837 n4343 U5256/net34 VDD pmos W=0.205u L=0.04u
M15540 U5256/net34 n4811 VDD VDD pmos W=0.205u L=0.04u
M15541 n4837 n4838 U5256/net37 VDD pmos W=0.205u L=0.04u
M15542 U5256/net37 n4812 VDD VDD pmos W=0.205u L=0.04u
M15543 U5257/net4 n4835 U5257/net14 VSS nmos W=0.155u L=0.04u
M15544 U5257/net6 U5257/net10 U5257/net14 VSS nmos W=0.17u L=0.04u
M15545 U5257/net4 n4836 VSS VSS nmos W=0.155u L=0.04u
M15546 U5257/net6 U5257/net4 VSS VSS nmos W=0.17u L=0.04u
M15547 n4838 U5257/net14 VSS VSS nmos W=0.155u L=0.04u
M15548 U5257/net10 n4835 VSS VSS nmos W=0.155u L=0.04u
M15549 U5257/net4 U5257/net10 U5257/net14 VDD pmos W=0.255u L=0.04u
M15550 U5257/net6 n4835 U5257/net14 VDD pmos W=0.28u L=0.04u
M15551 U5257/net4 n4836 VDD VDD pmos W=0.205u L=0.04u
M15552 U5257/net6 U5257/net4 VDD VDD pmos W=0.24u L=0.04u
M15553 n4838 U5257/net14 VDD VDD pmos W=0.205u L=0.04u
M15554 U5257/net10 n4835 VDD VDD pmos W=0.205u L=0.04u
M15555 U5258/XU1-net6 n4841 VSS VSS nmos W=0.155u L=0.04u
M15556 n4835 n4840 U5258/XU1-net6 VSS nmos W=0.155u L=0.04u
M15557 n4835 n4841 VDD VDD pmos W=0.155u L=0.04u
M15558 n4835 n4840 VDD VDD pmos W=0.155u L=0.04u
M15559 U5259/net19 n4842 VSS VSS nmos W=0.155u L=0.04u
M15560 n4840 n4842 U5259/net40 VSS nmos W=0.155u L=0.04u
M15561 n4840 U5259/net19 U5259/net36 VSS nmos W=0.155u L=0.04u
M15562 U5259/net40 n4815 VSS VSS nmos W=0.31u L=0.04u
M15563 U5259/net36 n4809 VSS VSS nmos W=0.155u L=0.04u
M15564 U5259/net19 n4842 VDD VDD pmos W=0.205u L=0.04u
M15565 n4840 U5259/net19 U5259/net26 VDD pmos W=0.325u L=0.04u
M15566 U5259/net26 n4815 VDD VDD pmos W=0.41u L=0.04u
M15567 n4840 n4842 U5259/net30 VDD pmos W=0.325u L=0.04u
M15568 U5259/net30 n4809 VDD VDD pmos W=0.205u L=0.04u
M15569 U5260/net19 n4769 VSS VSS nmos W=0.155u L=0.04u
M15570 n3115 n4769 U5260/net40 VSS nmos W=0.155u L=0.04u
M15571 n3115 U5260/net19 U5260/net36 VSS nmos W=0.155u L=0.04u
M15572 U5260/net40 g240 VSS VSS nmos W=0.31u L=0.04u
M15573 U5260/net36 n4843 VSS VSS nmos W=0.155u L=0.04u
M15574 U5260/net19 n4769 VDD VDD pmos W=0.205u L=0.04u
M15575 n3115 U5260/net19 U5260/net26 VDD pmos W=0.325u L=0.04u
M15576 U5260/net26 g240 VDD VDD pmos W=0.41u L=0.04u
M15577 n3115 n4769 U5260/net30 VDD pmos W=0.325u L=0.04u
M15578 U5260/net30 n4843 VDD VDD pmos W=0.205u L=0.04u
M15579 U5261/net19 n4771 VSS VSS nmos W=0.155u L=0.04u
M15580 n3114 n4771 U5261/net40 VSS nmos W=0.155u L=0.04u
M15581 n3114 U5261/net19 U5261/net36 VSS nmos W=0.155u L=0.04u
M15582 U5261/net40 g243 VSS VSS nmos W=0.31u L=0.04u
M15583 U5261/net36 n4843 VSS VSS nmos W=0.155u L=0.04u
M15584 U5261/net19 n4771 VDD VDD pmos W=0.205u L=0.04u
M15585 n3114 U5261/net19 U5261/net26 VDD pmos W=0.325u L=0.04u
M15586 U5261/net26 g243 VDD VDD pmos W=0.41u L=0.04u
M15587 n3114 n4771 U5261/net30 VDD pmos W=0.325u L=0.04u
M15588 U5261/net30 n4843 VDD VDD pmos W=0.205u L=0.04u
M15589 U5262/net19 n4770 VSS VSS nmos W=0.155u L=0.04u
M15590 n3113 n4770 U5262/net40 VSS nmos W=0.155u L=0.04u
M15591 n3113 U5262/net19 U5262/net36 VSS nmos W=0.155u L=0.04u
M15592 U5262/net40 g246 VSS VSS nmos W=0.31u L=0.04u
M15593 U5262/net36 n4843 VSS VSS nmos W=0.155u L=0.04u
M15594 U5262/net19 n4770 VDD VDD pmos W=0.205u L=0.04u
M15595 n3113 U5262/net19 U5262/net26 VDD pmos W=0.325u L=0.04u
M15596 U5262/net26 g246 VDD VDD pmos W=0.41u L=0.04u
M15597 n3113 n4770 U5262/net30 VDD pmos W=0.325u L=0.04u
M15598 U5262/net30 n4843 VDD VDD pmos W=0.205u L=0.04u
M15599 U5263/net32 n4811 U5263/net26 VSS nmos W=0.155u L=0.04u
M15600 U5263/net32 g109 U5263/net26 VSS nmos W=0.155u L=0.04u
M15601 U5263/net29 n4831 VSS VSS nmos W=0.155u L=0.04u
M15602 U5263/net26 n4844 U5263/net29 VSS nmos W=0.155u L=0.04u
M15603 U5263/net26 n4812 U5263/net29 VSS nmos W=0.155u L=0.04u
M15604 n4843 U5263/net32 VSS VSS nmos W=0.155u L=0.04u
M15605 n4843 U5263/net32 VDD VDD pmos W=0.205u L=0.04u
M15606 U5263/net32 g109 U5263/net43 VDD pmos W=0.205u L=0.04u
M15607 U5263/net32 n4812 U5263/net49 VDD pmos W=0.205u L=0.04u
M15608 U5263/net49 n4844 VDD VDD pmos W=0.205u L=0.04u
M15609 U5263/net43 n4811 VDD VDD pmos W=0.205u L=0.04u
M15610 U5263/net32 n4831 VDD VDD pmos W=0.205u L=0.04u
M15611 U5264/net4 n4845 U5264/net14 VSS nmos W=0.155u L=0.04u
M15612 U5264/net6 U5264/net10 U5264/net14 VSS nmos W=0.17u L=0.04u
M15613 U5264/net4 n4846 VSS VSS nmos W=0.155u L=0.04u
M15614 U5264/net6 U5264/net4 VSS VSS nmos W=0.17u L=0.04u
M15615 n4844 U5264/net14 VSS VSS nmos W=0.155u L=0.04u
M15616 U5264/net10 n4845 VSS VSS nmos W=0.155u L=0.04u
M15617 U5264/net4 U5264/net10 U5264/net14 VDD pmos W=0.255u L=0.04u
M15618 U5264/net6 n4845 U5264/net14 VDD pmos W=0.28u L=0.04u
M15619 U5264/net4 n4846 VDD VDD pmos W=0.205u L=0.04u
M15620 U5264/net6 U5264/net4 VDD VDD pmos W=0.24u L=0.04u
M15621 n4844 U5264/net14 VDD VDD pmos W=0.205u L=0.04u
M15622 U5264/net10 n4845 VDD VDD pmos W=0.205u L=0.04u
M15623 n4845 n4809 U5265/net27 VSS nmos W=0.155u L=0.04u
M15624 U5265/net27 n4847 VSS VSS nmos W=0.155u L=0.04u
M15625 n4845 n4848 VSS VSS nmos W=0.155u L=0.04u
M15626 n4845 n4847 U5265/net13 VDD pmos W=0.205u L=0.04u
M15627 U5265/net13 n4848 VDD VDD pmos W=0.205u L=0.04u
M15628 n4845 n4809 U5265/net13 VDD pmos W=0.205u L=0.04u
M15629 U5266/net19 n4770 VSS VSS nmos W=0.155u L=0.04u
M15630 n3112 n4770 U5266/net40 VSS nmos W=0.155u L=0.04u
M15631 n3112 U5266/net19 U5266/net36 VSS nmos W=0.155u L=0.04u
M15632 U5266/net40 g201 VSS VSS nmos W=0.31u L=0.04u
M15633 U5266/net36 n4849 VSS VSS nmos W=0.155u L=0.04u
M15634 U5266/net19 n4770 VDD VDD pmos W=0.205u L=0.04u
M15635 n3112 U5266/net19 U5266/net26 VDD pmos W=0.325u L=0.04u
M15636 U5266/net26 g201 VDD VDD pmos W=0.41u L=0.04u
M15637 n3112 n4770 U5266/net30 VDD pmos W=0.325u L=0.04u
M15638 U5266/net30 n4849 VDD VDD pmos W=0.205u L=0.04u
M15639 U5267/net19 n4769 VSS VSS nmos W=0.155u L=0.04u
M15640 n3111 n4769 U5267/net40 VSS nmos W=0.155u L=0.04u
M15641 n3111 U5267/net19 U5267/net36 VSS nmos W=0.155u L=0.04u
M15642 U5267/net40 g195 VSS VSS nmos W=0.31u L=0.04u
M15643 U5267/net36 n4849 VSS VSS nmos W=0.155u L=0.04u
M15644 U5267/net19 n4769 VDD VDD pmos W=0.205u L=0.04u
M15645 n3111 U5267/net19 U5267/net26 VDD pmos W=0.325u L=0.04u
M15646 U5267/net26 g195 VDD VDD pmos W=0.41u L=0.04u
M15647 n3111 n4769 U5267/net30 VDD pmos W=0.325u L=0.04u
M15648 U5267/net30 n4849 VDD VDD pmos W=0.205u L=0.04u
M15649 U5268/net19 n4771 VSS VSS nmos W=0.155u L=0.04u
M15650 n3110 n4771 U5268/net40 VSS nmos W=0.155u L=0.04u
M15651 n3110 U5268/net19 U5268/net36 VSS nmos W=0.155u L=0.04u
M15652 U5268/net40 g198 VSS VSS nmos W=0.31u L=0.04u
M15653 U5268/net36 n4849 VSS VSS nmos W=0.155u L=0.04u
M15654 U5268/net19 n4771 VDD VDD pmos W=0.205u L=0.04u
M15655 n3110 U5268/net19 U5268/net26 VDD pmos W=0.325u L=0.04u
M15656 U5268/net26 g198 VDD VDD pmos W=0.41u L=0.04u
M15657 n3110 n4771 U5268/net30 VDD pmos W=0.325u L=0.04u
M15658 U5268/net30 n4849 VDD VDD pmos W=0.205u L=0.04u
M15659 n4849 n4811 U5269/net27 VSS nmos W=0.155u L=0.04u
M15660 U5269/net39 n4839 VSS VSS nmos W=0.155u L=0.04u
M15661 U5269/net27 n4812 U5269/net39 VSS nmos W=0.155u L=0.04u
M15662 U5269/net27 n4850 U5269/net39 VSS nmos W=0.155u L=0.04u
M15663 n4849 n4743 U5269/net27 VSS nmos W=0.155u L=0.04u
M15664 U5269/net39 n4809 VSS VSS nmos W=0.155u L=0.04u
M15665 n4849 n4839 U5269/net46 VDD pmos W=0.205u L=0.04u
M15666 U5269/net46 n4809 VDD VDD pmos W=0.205u L=0.04u
M15667 n4849 n4743 U5269/net34 VDD pmos W=0.205u L=0.04u
M15668 U5269/net34 n4811 VDD VDD pmos W=0.205u L=0.04u
M15669 n4849 n4850 U5269/net37 VDD pmos W=0.205u L=0.04u
M15670 U5269/net37 n4812 VDD VDD pmos W=0.205u L=0.04u
M15671 U5270/net4 U5270/net10 U5270/net14 VSS nmos W=0.155u L=0.04u
M15672 U5270/net6 n4847 U5270/net14 VSS nmos W=0.155u L=0.04u
M15673 U5270/net4 n4851 VSS VSS nmos W=0.155u L=0.04u
M15674 U5270/net6 U5270/net4 VSS VSS nmos W=0.155u L=0.04u
M15675 n4850 U5270/net14 VSS VSS nmos W=0.155u L=0.04u
M15676 U5270/net10 n4847 VSS VSS nmos W=0.155u L=0.04u
M15677 U5270/net4 n4847 U5270/net14 VDD pmos W=0.205u L=0.04u
M15678 U5270/net6 U5270/net10 U5270/net14 VDD pmos W=0.205u L=0.04u
M15679 U5270/net4 n4851 VDD VDD pmos W=0.205u L=0.04u
M15680 U5270/net6 U5270/net4 VDD VDD pmos W=0.205u L=0.04u
M15681 n4850 U5270/net14 VDD VDD pmos W=0.205u L=0.04u
M15682 U5270/net10 n4847 VDD VDD pmos W=0.205u L=0.04u
M15683 U5271/net19 n4769 VSS VSS nmos W=0.155u L=0.04u
M15684 n3109 n4769 U5271/net40 VSS nmos W=0.155u L=0.04u
M15685 n3109 U5271/net19 U5271/net36 VSS nmos W=0.155u L=0.04u
M15686 U5271/net40 g231 VSS VSS nmos W=0.31u L=0.04u
M15687 U5271/net36 n4852 VSS VSS nmos W=0.155u L=0.04u
M15688 U5271/net19 n4769 VDD VDD pmos W=0.205u L=0.04u
M15689 n3109 U5271/net19 U5271/net26 VDD pmos W=0.325u L=0.04u
M15690 U5271/net26 g231 VDD VDD pmos W=0.41u L=0.04u
M15691 n3109 n4769 U5271/net30 VDD pmos W=0.325u L=0.04u
M15692 U5271/net30 n4852 VDD VDD pmos W=0.205u L=0.04u
M15693 U5272/net19 n4771 VSS VSS nmos W=0.155u L=0.04u
M15694 n3108 n4771 U5272/net40 VSS nmos W=0.155u L=0.04u
M15695 n3108 U5272/net19 U5272/net36 VSS nmos W=0.155u L=0.04u
M15696 U5272/net40 g234 VSS VSS nmos W=0.31u L=0.04u
M15697 U5272/net36 n4852 VSS VSS nmos W=0.155u L=0.04u
M15698 U5272/net19 n4771 VDD VDD pmos W=0.205u L=0.04u
M15699 n3108 U5272/net19 U5272/net26 VDD pmos W=0.325u L=0.04u
M15700 U5272/net26 g234 VDD VDD pmos W=0.41u L=0.04u
M15701 n3108 n4771 U5272/net30 VDD pmos W=0.325u L=0.04u
M15702 U5272/net30 n4852 VDD VDD pmos W=0.205u L=0.04u
M15703 U5273/net19 n4770 VSS VSS nmos W=0.155u L=0.04u
M15704 n3107 n4770 U5273/net40 VSS nmos W=0.155u L=0.04u
M15705 n3107 U5273/net19 U5273/net36 VSS nmos W=0.155u L=0.04u
M15706 U5273/net40 g237 VSS VSS nmos W=0.31u L=0.04u
M15707 U5273/net36 n4852 VSS VSS nmos W=0.155u L=0.04u
M15708 U5273/net19 n4770 VDD VDD pmos W=0.205u L=0.04u
M15709 n3107 U5273/net19 U5273/net26 VDD pmos W=0.325u L=0.04u
M15710 U5273/net26 g237 VDD VDD pmos W=0.41u L=0.04u
M15711 n3107 n4770 U5273/net30 VDD pmos W=0.325u L=0.04u
M15712 U5273/net30 n4852 VDD VDD pmos W=0.205u L=0.04u
M15713 U5274/net32 n4811 U5274/net26 VSS nmos W=0.155u L=0.04u
M15714 U5274/net32 g101 U5274/net26 VSS nmos W=0.155u L=0.04u
M15715 U5274/net29 n4831 VSS VSS nmos W=0.155u L=0.04u
M15716 U5274/net26 n4853 U5274/net29 VSS nmos W=0.155u L=0.04u
M15717 U5274/net26 n4812 U5274/net29 VSS nmos W=0.155u L=0.04u
M15718 n4852 U5274/net32 VSS VSS nmos W=0.155u L=0.04u
M15719 n4852 U5274/net32 VDD VDD pmos W=0.205u L=0.04u
M15720 U5274/net32 g101 U5274/net43 VDD pmos W=0.205u L=0.04u
M15721 U5274/net32 n4812 U5274/net49 VDD pmos W=0.205u L=0.04u
M15722 U5274/net49 n4853 VDD VDD pmos W=0.205u L=0.04u
M15723 U5274/net43 n4811 VDD VDD pmos W=0.205u L=0.04u
M15724 U5274/net32 n4831 VDD VDD pmos W=0.205u L=0.04u
M15725 U5275/net13 n4839 VSS VSS nmos W=0.155u L=0.04u
M15726 U5275/net16 U5275/net13 VSS VSS nmos W=0.155u L=0.04u
M15727 n4831 n4809 U5275/net16 VSS nmos W=0.155u L=0.04u
M15728 U5275/net13 n4839 VDD VDD pmos W=0.205u L=0.04u
M15729 VDD U5275/net13 n4831 VDD pmos W=0.205u L=0.04u
M15730 VDD n4809 n4831 VDD pmos W=0.205u L=0.04u
M15731 U5276/net4 n4854 U5276/net14 VSS nmos W=0.155u L=0.04u
M15732 U5276/net6 U5276/net10 U5276/net14 VSS nmos W=0.17u L=0.04u
M15733 U5276/net4 n4855 VSS VSS nmos W=0.155u L=0.04u
M15734 U5276/net6 U5276/net4 VSS VSS nmos W=0.17u L=0.04u
M15735 n4853 U5276/net14 VSS VSS nmos W=0.155u L=0.04u
M15736 U5276/net10 n4854 VSS VSS nmos W=0.155u L=0.04u
M15737 U5276/net4 U5276/net10 U5276/net14 VDD pmos W=0.255u L=0.04u
M15738 U5276/net6 n4854 U5276/net14 VDD pmos W=0.28u L=0.04u
M15739 U5276/net4 n4855 VDD VDD pmos W=0.205u L=0.04u
M15740 U5276/net6 U5276/net4 VDD VDD pmos W=0.24u L=0.04u
M15741 n4853 U5276/net14 VDD VDD pmos W=0.205u L=0.04u
M15742 U5276/net10 n4854 VDD VDD pmos W=0.205u L=0.04u
M15743 n4854 U5277/net6 VSS VSS nmos W=0.155u L=0.04u
M15744 U5277/X_u2-net6 n4857 VSS VSS nmos W=0.155u L=0.04u
M15745 U5277/net6 n4856 U5277/X_u2-net6 VSS nmos W=0.155u L=0.04u
M15746 n4854 U5277/net6 VDD VDD pmos W=0.205u L=0.04u
M15747 U5277/net6 n4857 VDD VDD pmos W=0.205u L=0.04u
M15748 U5277/net6 n4856 VDD VDD pmos W=0.205u L=0.04u
M15749 n3106 n4750 U5278/net10 VSS nmos W=0.155u L=0.04u
M15750 U5278/net10 n4859 VSS VSS nmos W=0.155u L=0.04u
M15751 n3106 n4858 U5278/net10 VSS nmos W=0.155u L=0.04u
M15752 U5278/net10 g323 VSS VSS nmos W=0.155u L=0.04u
M15753 U5278/net30 n4859 VDD VDD pmos W=0.205u L=0.04u
M15754 n3106 n4750 U5278/net24 VDD pmos W=0.205u L=0.04u
M15755 U5278/net24 n4858 VDD VDD pmos W=0.205u L=0.04u
M15756 n3106 g323 U5278/net30 VDD pmos W=0.205u L=0.04u
M15757 n4859 n4750 VSS VSS nmos W=0.155u L=0.04u
M15758 n4859 n4860 VSS VSS nmos W=0.155u L=0.04u
M15759 U5279/XI1-net8 n4860 VDD VDD pmos W=0.205u L=0.04u
M15760 n4859 n4750 U5279/XI1-net8 VDD pmos W=0.205u L=0.04u
M15761 n3105 n4749 U5280/net10 VSS nmos W=0.155u L=0.04u
M15762 U5280/net10 n4861 VSS VSS nmos W=0.155u L=0.04u
M15763 n3105 n4858 U5280/net10 VSS nmos W=0.155u L=0.04u
M15764 U5280/net10 g322 VSS VSS nmos W=0.155u L=0.04u
M15765 U5280/net30 n4861 VDD VDD pmos W=0.205u L=0.04u
M15766 n3105 n4749 U5280/net24 VDD pmos W=0.205u L=0.04u
M15767 U5280/net24 n4858 VDD VDD pmos W=0.205u L=0.04u
M15768 n3105 g322 U5280/net30 VDD pmos W=0.205u L=0.04u
M15769 n4861 n4749 VSS VSS nmos W=0.155u L=0.04u
M15770 n4861 n4860 VSS VSS nmos W=0.155u L=0.04u
M15771 U5281/XI1-net8 n4860 VDD VDD pmos W=0.205u L=0.04u
M15772 n4861 n4749 U5281/XI1-net8 VDD pmos W=0.205u L=0.04u
M15773 n3104 n4751 U5282/net10 VSS nmos W=0.155u L=0.04u
M15774 U5282/net10 n4862 VSS VSS nmos W=0.155u L=0.04u
M15775 n3104 n4858 U5282/net10 VSS nmos W=0.155u L=0.04u
M15776 U5282/net10 g321 VSS VSS nmos W=0.155u L=0.04u
M15777 U5282/net30 n4862 VDD VDD pmos W=0.205u L=0.04u
M15778 n3104 n4751 U5282/net24 VDD pmos W=0.205u L=0.04u
M15779 U5282/net24 n4858 VDD VDD pmos W=0.205u L=0.04u
M15780 n3104 g321 U5282/net30 VDD pmos W=0.205u L=0.04u
M15781 n4862 n4751 VSS VSS nmos W=0.155u L=0.04u
M15782 n4862 n4860 VSS VSS nmos W=0.155u L=0.04u
M15783 U5283/XI1-net8 n4860 VDD VDD pmos W=0.205u L=0.04u
M15784 n4862 n4751 U5283/XI1-net8 VDD pmos W=0.205u L=0.04u
M15785 n4858 U5284/net7 VSS VSS nmos W=0.155u L=0.04u
M15786 U5284/net7 n4863 VSS VSS nmos W=0.155u L=0.04u
M15787 U5284/net7 n4860 VSS VSS nmos W=0.155u L=0.04u
M15788 n4858 U5284/net7 VDD VDD pmos W=0.205u L=0.04u
M15789 U5284/X_u7-net8 n4860 VDD VDD pmos W=0.205u L=0.04u
M15790 U5284/net7 n4863 U5284/X_u7-net8 VDD pmos W=0.205u L=0.04u
M15791 n4860 U5285/net28 VSS VSS nmos W=0.155u L=0.04u
M15792 U5285/net47 n4864 VSS VSS nmos W=0.155u L=0.04u
M15793 U5285/net28 U5285/net6 U5285/net47 VSS nmos W=0.155u L=0.04u
M15794 U5285/net44 n4759 VSS VSS nmos W=0.155u L=0.04u
M15795 U5285/net28 n4338 U5285/net44 VSS nmos W=0.155u L=0.04u
M15796 U5285/net6 n4338 VSS VSS nmos W=0.155u L=0.04u
M15797 n4860 U5285/net28 VDD VDD pmos W=0.205u L=0.04u
M15798 VDD n4864 U5285/net47 VDD pmos W=0.205u L=0.04u
M15799 U5285/net47 n4338 U5285/net28 VDD pmos W=0.205u L=0.04u
M15800 U5285/net44 U5285/net6 U5285/net28 VDD pmos W=0.205u L=0.04u
M15801 VDD n4759 U5285/net44 VDD pmos W=0.205u L=0.04u
M15802 VDD n4338 U5285/net6 VDD pmos W=0.205u L=0.04u
M15803 n4863 n4865 U5286/net23 VDD pmos W=0.205u L=0.04u
M15804 n4863 n4866 U5286/net23 VDD pmos W=0.205u L=0.04u
M15805 n4863 n4808 U5286/net23 VDD pmos W=0.205u L=0.04u
M15806 U5286/net23 n4802 VDD VDD pmos W=0.205u L=0.04u
M15807 U5286/net23 n4338 VDD VDD pmos W=0.205u L=0.04u
M15808 U5286/XI20-net13 n4866 VSS VSS nmos W=0.155u L=0.04u
M15809 n4863 n4865 U5286/XI20-net17 VSS nmos W=0.155u L=0.04u
M15810 U5286/XI20-net17 n4808 U5286/XI20-net13 VSS nmos W=0.155u L=0.04u
M15811 n4863 n4802 U5286/XI17-net17 VSS nmos W=0.155u L=0.04u
M15812 U5286/XI17-net17 n4338 VSS VSS nmos W=0.155u L=0.04u
M15813 U5287/net19 n4749 VSS VSS nmos W=0.155u L=0.04u
M15814 n3103 n4749 U5287/net40 VSS nmos W=0.155u L=0.04u
M15815 n3103 U5287/net19 U5287/net36 VSS nmos W=0.155u L=0.04u
M15816 U5287/net40 g318 VSS VSS nmos W=0.31u L=0.04u
M15817 U5287/net36 n4867 VSS VSS nmos W=0.155u L=0.04u
M15818 U5287/net19 n4749 VDD VDD pmos W=0.205u L=0.04u
M15819 n3103 U5287/net19 U5287/net26 VDD pmos W=0.325u L=0.04u
M15820 U5287/net26 g318 VDD VDD pmos W=0.41u L=0.04u
M15821 n3103 n4749 U5287/net30 VDD pmos W=0.325u L=0.04u
M15822 U5287/net30 n4867 VDD VDD pmos W=0.205u L=0.04u
M15823 U5288/net19 n4750 VSS VSS nmos W=0.155u L=0.04u
M15824 n3102 n4750 U5288/net40 VSS nmos W=0.155u L=0.04u
M15825 n3102 U5288/net19 U5288/net36 VSS nmos W=0.155u L=0.04u
M15826 U5288/net40 g319 VSS VSS nmos W=0.31u L=0.04u
M15827 U5288/net36 n4867 VSS VSS nmos W=0.155u L=0.04u
M15828 U5288/net19 n4750 VDD VDD pmos W=0.205u L=0.04u
M15829 n3102 U5288/net19 U5288/net26 VDD pmos W=0.325u L=0.04u
M15830 U5288/net26 g319 VDD VDD pmos W=0.41u L=0.04u
M15831 n3102 n4750 U5288/net30 VDD pmos W=0.325u L=0.04u
M15832 U5288/net30 n4867 VDD VDD pmos W=0.205u L=0.04u
M15833 U5289/net19 n4751 VSS VSS nmos W=0.155u L=0.04u
M15834 n3101 n4751 U5289/net40 VSS nmos W=0.155u L=0.04u
M15835 n3101 U5289/net19 U5289/net36 VSS nmos W=0.155u L=0.04u
M15836 U5289/net40 g320 VSS VSS nmos W=0.31u L=0.04u
M15837 U5289/net36 n4867 VSS VSS nmos W=0.155u L=0.04u
M15838 U5289/net19 n4751 VDD VDD pmos W=0.205u L=0.04u
M15839 n3101 U5289/net19 U5289/net26 VDD pmos W=0.325u L=0.04u
M15840 U5289/net26 g320 VDD VDD pmos W=0.41u L=0.04u
M15841 n3101 n4751 U5289/net30 VDD pmos W=0.325u L=0.04u
M15842 U5289/net30 n4867 VDD VDD pmos W=0.205u L=0.04u
M15843 n4867 U5290/net6 VSS VSS nmos W=0.155u L=0.04u
M15844 U5290/X_u2-net6 n4805 VSS VSS nmos W=0.155u L=0.04u
M15845 U5290/net6 n4868 U5290/X_u2-net6 VSS nmos W=0.155u L=0.04u
M15846 n4867 U5290/net6 VDD VDD pmos W=0.205u L=0.04u
M15847 U5290/net6 n4805 VDD VDD pmos W=0.205u L=0.04u
M15848 U5290/net6 n4868 VDD VDD pmos W=0.205u L=0.04u
M15849 U5291/net4 n4869 U5291/net14 VSS nmos W=0.155u L=0.04u
M15850 U5291/net6 U5291/net10 U5291/net14 VSS nmos W=0.17u L=0.04u
M15851 U5291/net4 n4866 VSS VSS nmos W=0.155u L=0.04u
M15852 U5291/net6 U5291/net4 VSS VSS nmos W=0.17u L=0.04u
M15853 n4868 U5291/net14 VSS VSS nmos W=0.155u L=0.04u
M15854 U5291/net10 n4869 VSS VSS nmos W=0.155u L=0.04u
M15855 U5291/net4 U5291/net10 U5291/net14 VDD pmos W=0.255u L=0.04u
M15856 U5291/net6 n4869 U5291/net14 VDD pmos W=0.28u L=0.04u
M15857 U5291/net4 n4866 VDD VDD pmos W=0.205u L=0.04u
M15858 U5291/net6 U5291/net4 VDD VDD pmos W=0.24u L=0.04u
M15859 n4868 U5291/net14 VDD VDD pmos W=0.205u L=0.04u
M15860 U5291/net10 n4869 VDD VDD pmos W=0.205u L=0.04u
M15861 n4869 n4870 U5292/net23 VDD pmos W=0.205u L=0.04u
M15862 n4869 n4871 U5292/net23 VDD pmos W=0.205u L=0.04u
M15863 n4869 n4808 U5292/net23 VDD pmos W=0.205u L=0.04u
M15864 U5292/net23 n4866 VDD VDD pmos W=0.205u L=0.04u
M15865 U5292/net23 n4872 VDD VDD pmos W=0.205u L=0.04u
M15866 U5292/XI20-net13 n4871 VSS VSS nmos W=0.155u L=0.04u
M15867 n4869 n4870 U5292/XI20-net17 VSS nmos W=0.155u L=0.04u
M15868 U5292/XI20-net17 n4808 U5292/XI20-net13 VSS nmos W=0.155u L=0.04u
M15869 n4869 n4866 U5292/XI17-net17 VSS nmos W=0.155u L=0.04u
M15870 U5292/XI17-net17 n4872 VSS VSS nmos W=0.155u L=0.04u
M15871 VSS n4808 U5293/net22 VSS nmos W=0.155u L=0.04u
M15872 U5293/net22 n4759 n4872 VSS nmos W=0.155u L=0.04u
M15873 U5293/net22 n4873 n4872 VSS nmos W=0.155u L=0.04u
M15874 U5293/net22 n4806 n4872 VSS nmos W=0.155u L=0.04u
M15875 U5293/net38 n4806 VDD VDD pmos W=0.205u L=0.04u
M15876 U5293/net35 n4873 U5293/net38 VDD pmos W=0.205u L=0.04u
M15877 n4872 n4759 U5293/net35 VDD pmos W=0.205u L=0.04u
M15878 n4872 n4808 VDD VDD pmos W=0.205u L=0.04u
M15879 n4759 g309 VSS VSS nmos W=0.135u L=0.04u
M15880 n4759 g309 VDD VDD pmos W=0.205u L=0.04u
M15881 n4871 n4864 U5295/net27 VSS nmos W=0.155u L=0.04u
M15882 U5295/net27 n4874 VSS VSS nmos W=0.155u L=0.04u
M15883 n4871 n4875 VSS VSS nmos W=0.155u L=0.04u
M15884 n4871 n4874 U5295/net13 VDD pmos W=0.205u L=0.04u
M15885 U5295/net13 n4875 VDD VDD pmos W=0.205u L=0.04u
M15886 n4871 n4864 U5295/net13 VDD pmos W=0.205u L=0.04u
M15887 U5296/net19 n4749 VSS VSS nmos W=0.155u L=0.04u
M15888 n3100 n4749 U5296/net40 VSS nmos W=0.155u L=0.04u
M15889 n3100 U5296/net19 U5296/net36 VSS nmos W=0.155u L=0.04u
M15890 U5296/net40 g315 VSS VSS nmos W=0.31u L=0.04u
M15891 U5296/net36 n4876 VSS VSS nmos W=0.155u L=0.04u
M15892 U5296/net19 n4749 VDD VDD pmos W=0.205u L=0.04u
M15893 n3100 U5296/net19 U5296/net26 VDD pmos W=0.325u L=0.04u
M15894 U5296/net26 g315 VDD VDD pmos W=0.41u L=0.04u
M15895 n3100 n4749 U5296/net30 VDD pmos W=0.325u L=0.04u
M15896 U5296/net30 n4876 VDD VDD pmos W=0.205u L=0.04u
M15897 U5297/net19 n4750 VSS VSS nmos W=0.155u L=0.04u
M15898 n3099 n4750 U5297/net40 VSS nmos W=0.155u L=0.04u
M15899 n3099 U5297/net19 U5297/net36 VSS nmos W=0.155u L=0.04u
M15900 U5297/net40 g316 VSS VSS nmos W=0.31u L=0.04u
M15901 U5297/net36 n4876 VSS VSS nmos W=0.155u L=0.04u
M15902 U5297/net19 n4750 VDD VDD pmos W=0.205u L=0.04u
M15903 n3099 U5297/net19 U5297/net26 VDD pmos W=0.325u L=0.04u
M15904 U5297/net26 g316 VDD VDD pmos W=0.41u L=0.04u
M15905 n3099 n4750 U5297/net30 VDD pmos W=0.325u L=0.04u
M15906 U5297/net30 n4876 VDD VDD pmos W=0.205u L=0.04u
M15907 U5298/net19 n4751 VSS VSS nmos W=0.155u L=0.04u
M15908 n3098 n4751 U5298/net40 VSS nmos W=0.155u L=0.04u
M15909 n3098 U5298/net19 U5298/net36 VSS nmos W=0.155u L=0.04u
M15910 U5298/net40 g317 VSS VSS nmos W=0.31u L=0.04u
M15911 U5298/net36 n4876 VSS VSS nmos W=0.155u L=0.04u
M15912 U5298/net19 n4751 VDD VDD pmos W=0.205u L=0.04u
M15913 n3098 U5298/net19 U5298/net26 VDD pmos W=0.325u L=0.04u
M15914 U5298/net26 g317 VDD VDD pmos W=0.41u L=0.04u
M15915 n3098 n4751 U5298/net30 VDD pmos W=0.325u L=0.04u
M15916 U5298/net30 n4876 VDD VDD pmos W=0.205u L=0.04u
M15917 n4876 U5299/net6 VSS VSS nmos W=0.155u L=0.04u
M15918 U5299/X_u2-net6 n4805 VSS VSS nmos W=0.155u L=0.04u
M15919 U5299/net6 n4877 U5299/X_u2-net6 VSS nmos W=0.155u L=0.04u
M15920 n4876 U5299/net6 VDD VDD pmos W=0.205u L=0.04u
M15921 U5299/net6 n4805 VDD VDD pmos W=0.205u L=0.04u
M15922 U5299/net6 n4877 VDD VDD pmos W=0.205u L=0.04u
M15923 U5300/net4 n4878 U5300/net14 VSS nmos W=0.155u L=0.04u
M15924 U5300/net6 U5300/net10 U5300/net14 VSS nmos W=0.17u L=0.04u
M15925 U5300/net4 n4873 VSS VSS nmos W=0.155u L=0.04u
M15926 U5300/net6 U5300/net4 VSS VSS nmos W=0.17u L=0.04u
M15927 n4877 U5300/net14 VSS VSS nmos W=0.155u L=0.04u
M15928 U5300/net10 n4878 VSS VSS nmos W=0.155u L=0.04u
M15929 U5300/net4 U5300/net10 U5300/net14 VDD pmos W=0.255u L=0.04u
M15930 U5300/net6 n4878 U5300/net14 VDD pmos W=0.28u L=0.04u
M15931 U5300/net4 n4873 VDD VDD pmos W=0.205u L=0.04u
M15932 U5300/net6 U5300/net4 VDD VDD pmos W=0.24u L=0.04u
M15933 n4877 U5300/net14 VDD VDD pmos W=0.205u L=0.04u
M15934 U5300/net10 n4878 VDD VDD pmos W=0.205u L=0.04u
M15935 n4878 n4879 VSS VSS nmos W=0.155u L=0.04u
M15936 n4878 n4880 VSS VSS nmos W=0.155u L=0.04u
M15937 U5301/XI1-net8 n4880 VDD VDD pmos W=0.205u L=0.04u
M15938 n4878 n4879 U5301/XI1-net8 VDD pmos W=0.205u L=0.04u
M15939 U5302/PG2 n4866 VSS VSS nmos W=0.31u L=0.04u
M15940 U5302/net55 n4882 VSS VSS nmos W=0.31u L=0.04u
M15941 U5302/net51 n4873 VSS VSS nmos W=0.155u L=0.04u
M15942 U5302/net53 n4881 VSS VSS nmos W=0.155u L=0.04u
M15943 U5302/net29 n4883 VSS VSS nmos W=0.155u L=0.04u
M15944 U5302/net53 U5302/net51 U5302/PG1 VSS nmos W=0.155u L=0.04u
M15945 U5302/net55 n4873 U5302/PG1 VSS nmos W=0.21u L=0.04u
M15946 U5302/PG2 n4883 n4880 VSS nmos W=0.22u L=0.04u
M15947 U5302/PG1 U5302/net29 n4880 VSS nmos W=0.155u L=0.04u
M15948 U5302/PG2 n4866 VDD VDD pmos W=0.41u L=0.04u
M15949 U5302/net55 n4882 VDD VDD pmos W=0.41u L=0.04u
M15950 U5302/net51 n4873 VDD VDD pmos W=0.205u L=0.04u
M15951 U5302/net53 n4881 VDD VDD pmos W=0.28u L=0.04u
M15952 U5302/net29 n4883 VDD VDD pmos W=0.205u L=0.04u
M15953 U5302/net53 n4873 U5302/PG1 VDD pmos W=0.27u L=0.04u
M15954 U5302/net55 U5302/net51 U5302/PG1 VDD pmos W=0.285u L=0.04u
M15955 U5302/PG2 U5302/net29 n4880 VDD pmos W=0.205u L=0.04u
M15956 U5302/PG1 n4883 n4880 VDD pmos W=0.28u L=0.04u
M15957 VSS n4885 U5303/net22 VSS nmos W=0.155u L=0.04u
M15958 U5303/net22 n4874 n4882 VSS nmos W=0.155u L=0.04u
M15959 U5303/net22 n4884 n4882 VSS nmos W=0.155u L=0.04u
M15960 U5303/net22 n4864 n4882 VSS nmos W=0.155u L=0.04u
M15961 U5303/net38 n4864 VDD VDD pmos W=0.205u L=0.04u
M15962 U5303/net35 n4884 U5303/net38 VDD pmos W=0.205u L=0.04u
M15963 n4882 n4874 U5303/net35 VDD pmos W=0.205u L=0.04u
M15964 n4882 n4885 VDD VDD pmos W=0.205u L=0.04u
M15965 U5304/XU1-net6 n4887 VSS VSS nmos W=0.155u L=0.04u
M15966 n4864 n4886 U5304/XU1-net6 VSS nmos W=0.155u L=0.04u
M15967 n4864 n4887 VDD VDD pmos W=0.155u L=0.04u
M15968 n4864 n4886 VDD VDD pmos W=0.155u L=0.04u
M15969 n4881 n4874 U5305/net23 VDD pmos W=0.205u L=0.04u
M15970 n4881 n4888 U5305/net23 VDD pmos W=0.205u L=0.04u
M15971 n4881 n4775 U5305/net23 VDD pmos W=0.205u L=0.04u
M15972 U5305/net23 n4889 VDD VDD pmos W=0.205u L=0.04u
M15973 U5305/net23 n4890 VDD VDD pmos W=0.205u L=0.04u
M15974 U5305/XI20-net13 n4888 VSS VSS nmos W=0.155u L=0.04u
M15975 n4881 n4874 U5305/XI20-net17 VSS nmos W=0.155u L=0.04u
M15976 U5305/XI20-net17 n4775 U5305/XI20-net13 VSS nmos W=0.155u L=0.04u
M15977 n4881 n4889 U5305/XI17-net17 VSS nmos W=0.155u L=0.04u
M15978 U5305/XI17-net17 n4890 VSS VSS nmos W=0.155u L=0.04u
M15979 n4890 n4870 VSS VSS nmos W=0.135u L=0.04u
M15980 n4890 n4870 VDD VDD pmos W=0.205u L=0.04u
M15981 U5307/net36 n4775 U5307/net24 VSS nmos W=0.155u L=0.04u
M15982 U5307/net24 n4866 VSS VSS nmos W=0.155u L=0.04u
M15983 n4870 n4891 U5307/net36 VSS nmos W=0.155u L=0.04u
M15984 n4870 n4887 U5307/net36 VSS nmos W=0.155u L=0.04u
M15985 n4870 n4887 U5307/net35 VDD pmos W=0.205u L=0.04u
M15986 U5307/net35 n4891 VDD VDD pmos W=0.205u L=0.04u
M15987 n4870 n4866 VDD VDD pmos W=0.205u L=0.04u
M15988 n4870 n4775 VDD VDD pmos W=0.205u L=0.04u
M15989 U5308/p2 n4895 VSS VSS nmos W=0.155u L=0.04u
M15990 U5308/p0 n4893 U5308/p1 VSS nmos W=0.155u L=0.04u
M15991 U5308/p1 n4894 U5308/p2 VSS nmos W=0.155u L=0.04u
M15992 n4887 n4892 U5308/p0 VSS nmos W=0.155u L=0.04u
M15993 n4887 n4894 VDD VDD pmos W=0.205u L=0.04u
M15994 n4887 n4893 VDD VDD pmos W=0.205u L=0.04u
M15995 n4887 n4892 VDD VDD pmos W=0.205u L=0.04u
M15996 n4887 n4895 VDD VDD pmos W=0.205u L=0.04u
M15997 U5309/net7 n4896 U5309/X_u4-net10 VSS nmos W=0.155u L=0.04u
M15998 U5309/X_u4-net10 n4897 U5309/X_u4-net13 VSS nmos W=0.155u L=0.04u
M15999 U5309/X_u4-net13 n4898 VSS VSS nmos W=0.155u L=0.04u
M16000 n4895 U5309/net7 VSS VSS nmos W=0.155u L=0.04u
M16001 U5309/net7 n4898 VDD VDD pmos W=0.205u L=0.04u
M16002 U5309/net7 n4896 VDD VDD pmos W=0.205u L=0.04u
M16003 U5309/net7 n4897 VDD VDD pmos W=0.205u L=0.04u
M16004 n4895 U5309/net7 VDD VDD pmos W=0.205u L=0.04u
M16005 n4889 n4865 U5310/net27 VSS nmos W=0.155u L=0.04u
M16006 U5310/net27 n4899 VSS VSS nmos W=0.155u L=0.04u
M16007 n4889 n4884 VSS VSS nmos W=0.155u L=0.04u
M16008 n4889 n4899 U5310/net13 VDD pmos W=0.205u L=0.04u
M16009 U5310/net13 n4884 VDD VDD pmos W=0.205u L=0.04u
M16010 n4889 n4865 U5310/net13 VDD pmos W=0.205u L=0.04u
M16011 n4884 n4900 VSS VSS nmos W=0.135u L=0.04u
M16012 n4884 n4900 VDD VDD pmos W=0.205u L=0.04u
M16013 n4775 n4783 VSS VSS nmos W=0.135u L=0.04u
M16014 n4775 n4783 VDD VDD pmos W=0.205u L=0.04u
M16015 U5313/net19 n4769 VSS VSS nmos W=0.155u L=0.04u
M16016 n3097 n4769 U5313/net40 VSS nmos W=0.155u L=0.04u
M16017 n3097 U5313/net19 U5313/net36 VSS nmos W=0.155u L=0.04u
M16018 U5313/net40 g258 VSS VSS nmos W=0.31u L=0.04u
M16019 U5313/net36 n4901 VSS VSS nmos W=0.155u L=0.04u
M16020 U5313/net19 n4769 VDD VDD pmos W=0.205u L=0.04u
M16021 n3097 U5313/net19 U5313/net26 VDD pmos W=0.325u L=0.04u
M16022 U5313/net26 g258 VDD VDD pmos W=0.41u L=0.04u
M16023 n3097 n4769 U5313/net30 VDD pmos W=0.325u L=0.04u
M16024 U5313/net30 n4901 VDD VDD pmos W=0.205u L=0.04u
M16025 U5314/net19 n4771 VSS VSS nmos W=0.155u L=0.04u
M16026 n3096 n4771 U5314/net40 VSS nmos W=0.155u L=0.04u
M16027 n3096 U5314/net19 U5314/net36 VSS nmos W=0.155u L=0.04u
M16028 U5314/net40 g261 VSS VSS nmos W=0.31u L=0.04u
M16029 U5314/net36 n4901 VSS VSS nmos W=0.155u L=0.04u
M16030 U5314/net19 n4771 VDD VDD pmos W=0.205u L=0.04u
M16031 n3096 U5314/net19 U5314/net26 VDD pmos W=0.325u L=0.04u
M16032 U5314/net26 g261 VDD VDD pmos W=0.41u L=0.04u
M16033 n3096 n4771 U5314/net30 VDD pmos W=0.325u L=0.04u
M16034 U5314/net30 n4901 VDD VDD pmos W=0.205u L=0.04u
M16035 U5315/net19 n4770 VSS VSS nmos W=0.155u L=0.04u
M16036 n3095 n4770 U5315/net40 VSS nmos W=0.155u L=0.04u
M16037 n3095 U5315/net19 U5315/net36 VSS nmos W=0.155u L=0.04u
M16038 U5315/net40 g264 VSS VSS nmos W=0.31u L=0.04u
M16039 U5315/net36 n4901 VSS VSS nmos W=0.155u L=0.04u
M16040 U5315/net19 n4770 VDD VDD pmos W=0.205u L=0.04u
M16041 n3095 U5315/net19 U5315/net26 VDD pmos W=0.325u L=0.04u
M16042 U5315/net26 g264 VDD VDD pmos W=0.41u L=0.04u
M16043 n3095 n4770 U5315/net30 VDD pmos W=0.325u L=0.04u
M16044 U5315/net30 n4901 VDD VDD pmos W=0.205u L=0.04u
M16045 n4901 n4796 U5316/net10 VSS nmos W=0.155u L=0.04u
M16046 U5316/net10 n4902 VSS VSS nmos W=0.155u L=0.04u
M16047 n4901 n4811 U5316/net10 VSS nmos W=0.155u L=0.04u
M16048 U5316/net10 n4812 VSS VSS nmos W=0.155u L=0.04u
M16049 U5316/net30 n4902 VDD VDD pmos W=0.205u L=0.04u
M16050 n4901 n4796 U5316/net24 VDD pmos W=0.205u L=0.04u
M16051 U5316/net24 n4811 VDD VDD pmos W=0.205u L=0.04u
M16052 n4901 n4812 U5316/net30 VDD pmos W=0.205u L=0.04u
M16053 U5317/net4 n4903 U5317/net14 VSS nmos W=0.155u L=0.04u
M16054 U5317/net6 U5317/net10 U5317/net14 VSS nmos W=0.17u L=0.04u
M16055 U5317/net4 n4904 VSS VSS nmos W=0.155u L=0.04u
M16056 U5317/net6 U5317/net4 VSS VSS nmos W=0.17u L=0.04u
M16057 n4902 U5317/net14 VSS VSS nmos W=0.155u L=0.04u
M16058 U5317/net10 n4903 VSS VSS nmos W=0.155u L=0.04u
M16059 U5317/net4 U5317/net10 U5317/net14 VDD pmos W=0.255u L=0.04u
M16060 U5317/net6 n4903 U5317/net14 VDD pmos W=0.28u L=0.04u
M16061 U5317/net4 n4904 VDD VDD pmos W=0.205u L=0.04u
M16062 U5317/net6 U5317/net4 VDD VDD pmos W=0.24u L=0.04u
M16063 n4902 U5317/net14 VDD VDD pmos W=0.205u L=0.04u
M16064 U5317/net10 n4903 VDD VDD pmos W=0.205u L=0.04u
M16065 n4903 n4905 U5318/net15 VSS nmos W=0.155u L=0.04u
M16066 n4903 n4906 U5318/net15 VSS nmos W=0.155u L=0.04u
M16067 U5318/net15 n4841 VSS VSS nmos W=0.155u L=0.04u
M16068 n4903 n4841 VDD VDD pmos W=0.205u L=0.04u
M16069 n4903 n4905 U5318/XI16-net11 VDD pmos W=0.205u L=0.04u
M16070 U5318/XI16-net11 n4906 VDD VDD pmos W=0.205u L=0.04u
M16071 n4841 n4905 U5319/net27 VSS nmos W=0.155u L=0.04u
M16072 U5319/net27 n4906 VSS VSS nmos W=0.155u L=0.04u
M16073 n4841 n4814 VSS VSS nmos W=0.155u L=0.04u
M16074 n4841 n4906 U5319/net13 VDD pmos W=0.205u L=0.04u
M16075 U5319/net13 n4814 VDD VDD pmos W=0.205u L=0.04u
M16076 n4841 n4905 U5319/net13 VDD pmos W=0.205u L=0.04u
M16077 n4814 n4821 U5320/XI0-net10 VSS nmos W=0.155u L=0.04u
M16078 U5320/XI0-net10 n4907 U5320/XI0-net13 VSS nmos W=0.155u L=0.04u
M16079 U5320/XI0-net13 n4820 VSS VSS nmos W=0.155u L=0.04u
M16080 n4814 n4820 VDD VDD pmos W=0.205u L=0.04u
M16081 n4814 n4821 VDD VDD pmos W=0.205u L=0.04u
M16082 n4814 n4907 VDD VDD pmos W=0.205u L=0.04u
M16083 n4820 n4848 VSS VSS nmos W=0.155u L=0.04u
M16084 n4820 U5321/net4 VSS VSS nmos W=0.155u L=0.04u
M16085 U5321/net4 n4908 VSS VSS nmos W=0.155u L=0.04u
M16086 U5321/XU1-net8 U5321/net4 VDD VDD pmos W=0.205u L=0.04u
M16087 n4820 n4848 U5321/XU1-net8 VDD pmos W=0.205u L=0.04u
M16088 U5321/net4 n4908 VDD VDD pmos W=0.205u L=0.04u
M16089 n4848 n4847 U5322/net15 VSS nmos W=0.155u L=0.04u
M16090 n4848 n4809 U5322/net15 VSS nmos W=0.155u L=0.04u
M16091 U5322/net15 n4851 VSS VSS nmos W=0.155u L=0.04u
M16092 n4848 n4851 VDD VDD pmos W=0.205u L=0.04u
M16093 n4848 n4847 U5322/XI16-net11 VDD pmos W=0.205u L=0.04u
M16094 U5322/XI16-net11 n4809 VDD VDD pmos W=0.205u L=0.04u
M16095 U5323/net7 n4909 U5323/X_u4-net10 VSS nmos W=0.155u L=0.04u
M16096 U5323/X_u4-net10 n4857 U5323/X_u4-net13 VSS nmos W=0.155u L=0.04u
M16097 U5323/X_u4-net13 n4856 VSS VSS nmos W=0.155u L=0.04u
M16098 n4851 U5323/net7 VSS VSS nmos W=0.155u L=0.04u
M16099 U5323/net7 n4856 VDD VDD pmos W=0.205u L=0.04u
M16100 U5323/net7 n4909 VDD VDD pmos W=0.205u L=0.04u
M16101 U5323/net7 n4857 VDD VDD pmos W=0.205u L=0.04u
M16102 n4851 U5323/net7 VDD VDD pmos W=0.205u L=0.04u
M16103 U5324/net4 n4906 U5324/net14 VSS nmos W=0.155u L=0.04u
M16104 U5324/net6 U5324/net10 U5324/net14 VSS nmos W=0.17u L=0.04u
M16105 U5324/net4 n4828 VSS VSS nmos W=0.155u L=0.04u
M16106 U5324/net6 U5324/net4 VSS VSS nmos W=0.17u L=0.04u
M16107 n4856 U5324/net14 VSS VSS nmos W=0.155u L=0.04u
M16108 U5324/net10 n4906 VSS VSS nmos W=0.155u L=0.04u
M16109 U5324/net4 U5324/net10 U5324/net14 VDD pmos W=0.255u L=0.04u
M16110 U5324/net6 n4906 U5324/net14 VDD pmos W=0.28u L=0.04u
M16111 U5324/net4 n4828 VDD VDD pmos W=0.205u L=0.04u
M16112 U5324/net6 U5324/net4 VDD VDD pmos W=0.24u L=0.04u
M16113 n4856 U5324/net14 VDD VDD pmos W=0.205u L=0.04u
M16114 U5324/net10 n4906 VDD VDD pmos W=0.205u L=0.04u
M16115 U5325/net4 n4809 U5325/net14 VSS nmos W=0.155u L=0.04u
M16116 U5325/net6 U5325/net10 U5325/net14 VSS nmos W=0.17u L=0.04u
M16117 U5325/net4 n4910 VSS VSS nmos W=0.155u L=0.04u
M16118 U5325/net6 U5325/net4 VSS VSS nmos W=0.17u L=0.04u
M16119 n4909 U5325/net14 VSS VSS nmos W=0.155u L=0.04u
M16120 U5325/net10 n4809 VSS VSS nmos W=0.155u L=0.04u
M16121 U5325/net4 U5325/net10 U5325/net14 VDD pmos W=0.255u L=0.04u
M16122 U5325/net6 n4809 U5325/net14 VDD pmos W=0.28u L=0.04u
M16123 U5325/net4 n4910 VDD VDD pmos W=0.205u L=0.04u
M16124 U5325/net6 U5325/net4 VDD VDD pmos W=0.24u L=0.04u
M16125 n4909 U5325/net14 VDD VDD pmos W=0.205u L=0.04u
M16126 U5325/net10 n4809 VDD VDD pmos W=0.205u L=0.04u
M16127 U5326/net19 n4911 VSS VSS nmos W=0.155u L=0.04u
M16128 n4908 n4911 U5326/net40 VSS nmos W=0.155u L=0.04u
M16129 n4908 U5326/net19 U5326/net36 VSS nmos W=0.155u L=0.04u
M16130 U5326/net40 n4847 VSS VSS nmos W=0.31u L=0.04u
M16131 U5326/net36 n4809 VSS VSS nmos W=0.155u L=0.04u
M16132 U5326/net19 n4911 VDD VDD pmos W=0.205u L=0.04u
M16133 n4908 U5326/net19 U5326/net26 VDD pmos W=0.325u L=0.04u
M16134 U5326/net26 n4847 VDD VDD pmos W=0.41u L=0.04u
M16135 n4908 n4911 U5326/net30 VDD pmos W=0.325u L=0.04u
M16136 U5326/net30 n4809 VDD VDD pmos W=0.205u L=0.04u
M16137 U5327/net4 n4809 U5327/net14 VSS nmos W=0.155u L=0.04u
M16138 U5327/net6 U5327/net10 U5327/net14 VSS nmos W=0.17u L=0.04u
M16139 U5327/net4 n4912 VSS VSS nmos W=0.155u L=0.04u
M16140 U5327/net6 U5327/net4 VSS VSS nmos W=0.17u L=0.04u
M16141 n4907 U5327/net14 VSS VSS nmos W=0.155u L=0.04u
M16142 U5327/net10 n4809 VSS VSS nmos W=0.155u L=0.04u
M16143 U5327/net4 U5327/net10 U5327/net14 VDD pmos W=0.255u L=0.04u
M16144 U5327/net6 n4809 U5327/net14 VDD pmos W=0.28u L=0.04u
M16145 U5327/net4 n4912 VDD VDD pmos W=0.205u L=0.04u
M16146 U5327/net6 U5327/net4 VDD VDD pmos W=0.24u L=0.04u
M16147 n4907 U5327/net14 VDD VDD pmos W=0.205u L=0.04u
M16148 U5327/net10 n4809 VDD VDD pmos W=0.205u L=0.04u
M16149 U5328/net4 n4809 U5328/net14 VSS nmos W=0.155u L=0.04u
M16150 U5328/net6 U5328/net10 U5328/net14 VSS nmos W=0.17u L=0.04u
M16151 U5328/net4 n4824 VSS VSS nmos W=0.155u L=0.04u
M16152 U5328/net6 U5328/net4 VSS VSS nmos W=0.17u L=0.04u
M16153 n4821 U5328/net14 VSS VSS nmos W=0.155u L=0.04u
M16154 U5328/net10 n4809 VSS VSS nmos W=0.155u L=0.04u
M16155 U5328/net4 U5328/net10 U5328/net14 VDD pmos W=0.255u L=0.04u
M16156 U5328/net6 n4809 U5328/net14 VDD pmos W=0.28u L=0.04u
M16157 U5328/net4 n4824 VDD VDD pmos W=0.205u L=0.04u
M16158 U5328/net6 U5328/net4 VDD VDD pmos W=0.24u L=0.04u
M16159 n4821 U5328/net14 VDD VDD pmos W=0.205u L=0.04u
M16160 U5328/net10 n4809 VDD VDD pmos W=0.205u L=0.04u
M16161 U5329/XU1-net6 n4839 VSS VSS nmos W=0.155u L=0.04u
M16162 n4811 n4812 U5329/XU1-net6 VSS nmos W=0.155u L=0.04u
M16163 n4811 n4839 VDD VDD pmos W=0.155u L=0.04u
M16164 n4811 n4812 VDD VDD pmos W=0.155u L=0.04u
M16165 U5330/net36 n4857 U5330/net24 VSS nmos W=0.155u L=0.04u
M16166 U5330/net24 n4915 VSS VSS nmos W=0.155u L=0.04u
M16167 n4839 n4913 U5330/net36 VSS nmos W=0.155u L=0.04u
M16168 n4839 n4914 U5330/net36 VSS nmos W=0.155u L=0.04u
M16169 n4839 n4914 U5330/net35 VDD pmos W=0.205u L=0.04u
M16170 U5330/net35 n4913 VDD VDD pmos W=0.205u L=0.04u
M16171 n4839 n4915 VDD VDD pmos W=0.205u L=0.04u
M16172 n4839 n4857 VDD VDD pmos W=0.205u L=0.04u
M16173 n4857 n4827 VSS VSS nmos W=0.135u L=0.04u
M16174 n4857 n4827 VDD VDD pmos W=0.205u L=0.04u
M16175 n4812 n4827 U5332/net15 VSS nmos W=0.155u L=0.04u
M16176 n4812 n4916 U5332/net15 VSS nmos W=0.155u L=0.04u
M16177 U5332/net15 n4915 VSS VSS nmos W=0.155u L=0.04u
M16178 n4812 n4915 VDD VDD pmos W=0.205u L=0.04u
M16179 n4812 n4827 U5332/XI16-net11 VDD pmos W=0.205u L=0.04u
M16180 U5332/XI16-net11 n4916 VDD VDD pmos W=0.205u L=0.04u
M16181 U5333/net32 n4917 U5333/net26 VSS nmos W=0.155u L=0.04u
M16182 U5333/net32 n4883 U5333/net26 VSS nmos W=0.155u L=0.04u
M16183 U5333/net29 n4805 VSS VSS nmos W=0.155u L=0.04u
M16184 U5333/net26 n4888 U5333/net29 VSS nmos W=0.155u L=0.04u
M16185 U5333/net26 n4807 U5333/net29 VSS nmos W=0.155u L=0.04u
M16186 n4915 U5333/net32 VSS VSS nmos W=0.155u L=0.04u
M16187 n4915 U5333/net32 VDD VDD pmos W=0.205u L=0.04u
M16188 U5333/net32 n4883 U5333/net43 VDD pmos W=0.205u L=0.04u
M16189 U5333/net32 n4807 U5333/net49 VDD pmos W=0.205u L=0.04u
M16190 U5333/net49 n4888 VDD VDD pmos W=0.205u L=0.04u
M16191 U5333/net43 n4917 VDD VDD pmos W=0.205u L=0.04u
M16192 U5333/net32 n4805 VDD VDD pmos W=0.205u L=0.04u
M16193 U5334/XU1-net6 n4801 VSS VSS nmos W=0.155u L=0.04u
M16194 n4805 n4802 U5334/XU1-net6 VSS nmos W=0.155u L=0.04u
M16195 n4805 n4801 VDD VDD pmos W=0.155u L=0.04u
M16196 n4805 n4802 VDD VDD pmos W=0.155u L=0.04u
M16197 n4801 n4749 U5335/net27 VSS nmos W=0.155u L=0.04u
M16198 U5335/net39 n4750 VSS VSS nmos W=0.155u L=0.04u
M16199 U5335/net27 g402 U5335/net39 VSS nmos W=0.155u L=0.04u
M16200 U5335/net27 n4751 U5335/net39 VSS nmos W=0.155u L=0.04u
M16201 n4801 g403 U5335/net27 VSS nmos W=0.155u L=0.04u
M16202 U5335/net39 g404 VSS VSS nmos W=0.155u L=0.04u
M16203 n4801 n4750 U5335/net46 VDD pmos W=0.205u L=0.04u
M16204 U5335/net46 g404 VDD VDD pmos W=0.205u L=0.04u
M16205 n4801 g403 U5335/net34 VDD pmos W=0.205u L=0.04u
M16206 U5335/net34 n4749 VDD VDD pmos W=0.205u L=0.04u
M16207 n4801 n4751 U5335/net37 VDD pmos W=0.205u L=0.04u
M16208 U5335/net37 g402 VDD VDD pmos W=0.205u L=0.04u
M16209 n4807 n4338 VSS VSS nmos W=0.135u L=0.04u
M16210 n4807 n4338 VDD VDD pmos W=0.205u L=0.04u
M16211 n4338 n4873 VSS VSS nmos W=0.155u L=0.04u
M16212 n4338 n4866 VSS VSS nmos W=0.155u L=0.04u
M16213 n4338 n4883 VSS VSS nmos W=0.155u L=0.04u
M16214 U5337/net25 n4873 VDD VDD pmos W=0.41u L=0.04u
M16215 U5337/net28 n4866 U5337/net25 VDD pmos W=0.41u L=0.04u
M16216 n4338 n4883 U5337/net28 VDD pmos W=0.41u L=0.04u
M16217 U5338/XU1-net6 n4899 VSS VSS nmos W=0.155u L=0.04u
M16218 n4888 n4802 U5338/XU1-net6 VSS nmos W=0.155u L=0.04u
M16219 n4888 n4899 VDD VDD pmos W=0.155u L=0.04u
M16220 n4888 n4802 VDD VDD pmos W=0.155u L=0.04u
M16221 n4802 n4918 VSS VSS nmos W=0.135u L=0.04u
M16222 n4802 n4918 VDD VDD pmos W=0.205u L=0.04u
M16223 n4917 n4875 U5340/net19 VDD pmos W=0.205u L=0.04u
M16224 n4917 n4865 U5340/net19 VDD pmos W=0.205u L=0.04u
M16225 n4917 n4899 U5340/net19 VDD pmos W=0.205u L=0.04u
M16226 U5340/net19 n4783 VDD VDD pmos W=0.205u L=0.04u
M16227 n4917 n4783 VSS VSS nmos W=0.155u L=0.04u
M16228 U5340/XI20-net13 n4865 VSS VSS nmos W=0.155u L=0.04u
M16229 n4917 n4875 U5340/XI20-net17 VSS nmos W=0.155u L=0.04u
M16230 U5340/XI20-net17 n4899 U5340/XI20-net13 VSS nmos W=0.155u L=0.04u
M16231 n4783 n4919 VSS VSS nmos W=0.155u L=0.04u
M16232 n4783 U5341/net4 VSS VSS nmos W=0.155u L=0.04u
M16233 U5341/net4 g181 VSS VSS nmos W=0.155u L=0.04u
M16234 U5341/XU1-net8 U5341/net4 VDD VDD pmos W=0.205u L=0.04u
M16235 n4783 n4919 U5341/XU1-net8 VDD pmos W=0.205u L=0.04u
M16236 U5341/net4 g181 VDD VDD pmos W=0.205u L=0.04u
M16237 n4865 n4806 VSS VSS nmos W=0.155u L=0.04u
M16238 n4865 n4918 VSS VSS nmos W=0.155u L=0.04u
M16239 U5342/XI1-net8 n4918 VDD VDD pmos W=0.205u L=0.04u
M16240 n4865 n4806 U5342/XI1-net8 VDD pmos W=0.205u L=0.04u
M16241 U5343/p2 n4923 VSS VSS nmos W=0.155u L=0.04u
M16242 U5343/p0 n4921 U5343/p1 VSS nmos W=0.155u L=0.04u
M16243 U5343/p1 n4922 U5343/p2 VSS nmos W=0.155u L=0.04u
M16244 n4918 n4920 U5343/p0 VSS nmos W=0.155u L=0.04u
M16245 n4918 n4922 VDD VDD pmos W=0.205u L=0.04u
M16246 n4918 n4921 VDD VDD pmos W=0.205u L=0.04u
M16247 n4918 n4920 VDD VDD pmos W=0.205u L=0.04u
M16248 n4918 n4923 VDD VDD pmos W=0.205u L=0.04u
M16249 n4923 n4927 VSS VSS nmos W=0.155u L=0.04u
M16250 n4923 n4926 VSS VSS nmos W=0.155u L=0.04u
M16251 n4923 n4925 VSS VSS nmos W=0.155u L=0.04u
M16252 n4923 n4924 VSS VSS nmos W=0.155u L=0.04u
M16253 U5344/net49 n4926 U5344/net52 VDD pmos W=0.41u L=0.04u
M16254 U5344/net52 n4927 VDD VDD pmos W=0.41u L=0.04u
M16255 U5344/net46 n4925 U5344/net49 VDD pmos W=0.41u L=0.04u
M16256 n4923 n4924 U5344/net46 VDD pmos W=0.41u L=0.04u
M16257 U5345/net4 n4928 U5345/net14 VSS nmos W=0.155u L=0.04u
M16258 U5345/net6 U5345/net10 U5345/net14 VSS nmos W=0.17u L=0.04u
M16259 U5345/net4 g101 VSS VSS nmos W=0.155u L=0.04u
M16260 U5345/net6 U5345/net4 VSS VSS nmos W=0.17u L=0.04u
M16261 n4927 U5345/net14 VSS VSS nmos W=0.155u L=0.04u
M16262 U5345/net10 n4928 VSS VSS nmos W=0.155u L=0.04u
M16263 U5345/net4 U5345/net10 U5345/net14 VDD pmos W=0.255u L=0.04u
M16264 U5345/net6 n4928 U5345/net14 VDD pmos W=0.28u L=0.04u
M16265 U5345/net4 g101 VDD VDD pmos W=0.205u L=0.04u
M16266 U5345/net6 U5345/net4 VDD VDD pmos W=0.24u L=0.04u
M16267 n4927 U5345/net14 VDD VDD pmos W=0.205u L=0.04u
M16268 U5345/net10 n4928 VDD VDD pmos W=0.205u L=0.04u
M16269 U5346/net36 g132 U5346/net27 VSS nmos W=0.155u L=0.04u
M16270 U5346/net39 g133 VSS VSS nmos W=0.155u L=0.04u
M16271 U5346/net27 n4771 U5346/net39 VSS nmos W=0.155u L=0.04u
M16272 U5346/net27 g134 U5346/net39 VSS nmos W=0.155u L=0.04u
M16273 U5346/net36 n4770 U5346/net27 VSS nmos W=0.155u L=0.04u
M16274 U5346/net39 n4769 VSS VSS nmos W=0.155u L=0.04u
M16275 n4928 U5346/net36 VSS VSS nmos W=0.155u L=0.04u
M16276 n4928 U5346/net36 VDD VDD pmos W=0.205u L=0.04u
M16277 U5346/net36 g133 U5346/net46 VDD pmos W=0.205u L=0.04u
M16278 U5346/net46 n4769 VDD VDD pmos W=0.205u L=0.04u
M16279 U5346/net36 n4770 U5346/net34 VDD pmos W=0.205u L=0.04u
M16280 U5346/net34 g132 VDD VDD pmos W=0.205u L=0.04u
M16281 U5346/net36 g134 U5346/net37 VDD pmos W=0.205u L=0.04u
M16282 U5346/net37 n4771 VDD VDD pmos W=0.205u L=0.04u
M16283 U5347/net4 n4929 U5347/net14 VSS nmos W=0.155u L=0.04u
M16284 U5347/net6 U5347/net10 U5347/net14 VSS nmos W=0.17u L=0.04u
M16285 U5347/net4 g109 VSS VSS nmos W=0.155u L=0.04u
M16286 U5347/net6 U5347/net4 VSS VSS nmos W=0.17u L=0.04u
M16287 n4926 U5347/net14 VSS VSS nmos W=0.155u L=0.04u
M16288 U5347/net10 n4929 VSS VSS nmos W=0.155u L=0.04u
M16289 U5347/net4 U5347/net10 U5347/net14 VDD pmos W=0.255u L=0.04u
M16290 U5347/net6 n4929 U5347/net14 VDD pmos W=0.28u L=0.04u
M16291 U5347/net4 g109 VDD VDD pmos W=0.205u L=0.04u
M16292 U5347/net6 U5347/net4 VDD VDD pmos W=0.24u L=0.04u
M16293 n4926 U5347/net14 VDD VDD pmos W=0.205u L=0.04u
M16294 U5347/net10 n4929 VDD VDD pmos W=0.205u L=0.04u
M16295 U5348/net36 g144 U5348/net27 VSS nmos W=0.155u L=0.04u
M16296 U5348/net39 g145 VSS VSS nmos W=0.155u L=0.04u
M16297 U5348/net27 n4771 U5348/net39 VSS nmos W=0.155u L=0.04u
M16298 U5348/net27 g146 U5348/net39 VSS nmos W=0.155u L=0.04u
M16299 U5348/net36 n4770 U5348/net27 VSS nmos W=0.155u L=0.04u
M16300 U5348/net39 n4769 VSS VSS nmos W=0.155u L=0.04u
M16301 n4929 U5348/net36 VSS VSS nmos W=0.155u L=0.04u
M16302 n4929 U5348/net36 VDD VDD pmos W=0.205u L=0.04u
M16303 U5348/net36 g145 U5348/net46 VDD pmos W=0.205u L=0.04u
M16304 U5348/net46 n4769 VDD VDD pmos W=0.205u L=0.04u
M16305 U5348/net36 n4770 U5348/net34 VDD pmos W=0.205u L=0.04u
M16306 U5348/net34 g144 VDD VDD pmos W=0.205u L=0.04u
M16307 U5348/net36 g146 U5348/net37 VDD pmos W=0.205u L=0.04u
M16308 U5348/net37 n4771 VDD VDD pmos W=0.205u L=0.04u
M16309 U5349/net4 n4930 U5349/net14 VSS nmos W=0.155u L=0.04u
M16310 U5349/net6 U5349/net10 U5349/net14 VSS nmos W=0.17u L=0.04u
M16311 U5349/net4 g121 VSS VSS nmos W=0.155u L=0.04u
M16312 U5349/net6 U5349/net4 VSS VSS nmos W=0.17u L=0.04u
M16313 n4925 U5349/net14 VSS VSS nmos W=0.155u L=0.04u
M16314 U5349/net10 n4930 VSS VSS nmos W=0.155u L=0.04u
M16315 U5349/net4 U5349/net10 U5349/net14 VDD pmos W=0.255u L=0.04u
M16316 U5349/net6 n4930 U5349/net14 VDD pmos W=0.28u L=0.04u
M16317 U5349/net4 g121 VDD VDD pmos W=0.205u L=0.04u
M16318 U5349/net6 U5349/net4 VDD VDD pmos W=0.24u L=0.04u
M16319 n4925 U5349/net14 VDD VDD pmos W=0.205u L=0.04u
M16320 U5349/net10 n4930 VDD VDD pmos W=0.205u L=0.04u
M16321 U5350/net36 g153 U5350/net27 VSS nmos W=0.155u L=0.04u
M16322 U5350/net39 g154 VSS VSS nmos W=0.155u L=0.04u
M16323 U5350/net27 n4771 U5350/net39 VSS nmos W=0.155u L=0.04u
M16324 U5350/net27 g155 U5350/net39 VSS nmos W=0.155u L=0.04u
M16325 U5350/net36 n4770 U5350/net27 VSS nmos W=0.155u L=0.04u
M16326 U5350/net39 n4769 VSS VSS nmos W=0.155u L=0.04u
M16327 n4930 U5350/net36 VSS VSS nmos W=0.155u L=0.04u
M16328 n4930 U5350/net36 VDD VDD pmos W=0.205u L=0.04u
M16329 U5350/net36 g154 U5350/net46 VDD pmos W=0.205u L=0.04u
M16330 U5350/net46 n4769 VDD VDD pmos W=0.205u L=0.04u
M16331 U5350/net36 n4770 U5350/net34 VDD pmos W=0.205u L=0.04u
M16332 U5350/net34 g153 VDD VDD pmos W=0.205u L=0.04u
M16333 U5350/net36 g155 U5350/net37 VDD pmos W=0.205u L=0.04u
M16334 U5350/net37 n4771 VDD VDD pmos W=0.205u L=0.04u
M16335 n4924 n4931 U5351/XI0-net10 VSS nmos W=0.155u L=0.04u
M16336 U5351/XI0-net10 n4932 U5351/XI0-net13 VSS nmos W=0.155u L=0.04u
M16337 U5351/XI0-net13 n4933 VSS VSS nmos W=0.155u L=0.04u
M16338 n4924 n4933 VDD VDD pmos W=0.205u L=0.04u
M16339 n4924 n4931 VDD VDD pmos W=0.205u L=0.04u
M16340 n4924 n4932 VDD VDD pmos W=0.205u L=0.04u
M16341 U5352/net4 n4741 U5352/net14 VSS nmos W=0.155u L=0.04u
M16342 U5352/net6 U5352/net10 U5352/net14 VSS nmos W=0.17u L=0.04u
M16343 U5352/net4 n4934 VSS VSS nmos W=0.155u L=0.04u
M16344 U5352/net6 U5352/net4 VSS VSS nmos W=0.17u L=0.04u
M16345 n4933 U5352/net14 VSS VSS nmos W=0.155u L=0.04u
M16346 U5352/net10 n4741 VSS VSS nmos W=0.155u L=0.04u
M16347 U5352/net4 U5352/net10 U5352/net14 VDD pmos W=0.255u L=0.04u
M16348 U5352/net6 n4741 U5352/net14 VDD pmos W=0.28u L=0.04u
M16349 U5352/net4 n4934 VDD VDD pmos W=0.205u L=0.04u
M16350 U5352/net6 U5352/net4 VDD VDD pmos W=0.24u L=0.04u
M16351 n4933 U5352/net14 VDD VDD pmos W=0.205u L=0.04u
M16352 U5352/net10 n4741 VDD VDD pmos W=0.205u L=0.04u
M16353 U5353/net36 g129 U5353/net27 VSS nmos W=0.155u L=0.04u
M16354 U5353/net39 g130 VSS VSS nmos W=0.155u L=0.04u
M16355 U5353/net27 n4771 U5353/net39 VSS nmos W=0.155u L=0.04u
M16356 U5353/net27 g131 U5353/net39 VSS nmos W=0.155u L=0.04u
M16357 U5353/net36 n4770 U5353/net27 VSS nmos W=0.155u L=0.04u
M16358 U5353/net39 n4769 VSS VSS nmos W=0.155u L=0.04u
M16359 n4934 U5353/net36 VSS VSS nmos W=0.155u L=0.04u
M16360 n4934 U5353/net36 VDD VDD pmos W=0.205u L=0.04u
M16361 U5353/net36 g130 U5353/net46 VDD pmos W=0.205u L=0.04u
M16362 U5353/net46 n4769 VDD VDD pmos W=0.205u L=0.04u
M16363 U5353/net36 n4770 U5353/net34 VDD pmos W=0.205u L=0.04u
M16364 U5353/net34 g129 VDD VDD pmos W=0.205u L=0.04u
M16365 U5353/net36 g131 U5353/net37 VDD pmos W=0.205u L=0.04u
M16366 U5353/net37 n4771 VDD VDD pmos W=0.205u L=0.04u
M16367 U5354/net4 n4796 U5354/net14 VSS nmos W=0.155u L=0.04u
M16368 U5354/net6 U5354/net10 U5354/net14 VSS nmos W=0.17u L=0.04u
M16369 U5354/net4 n4935 VSS VSS nmos W=0.155u L=0.04u
M16370 U5354/net6 U5354/net4 VSS VSS nmos W=0.17u L=0.04u
M16371 n4932 U5354/net14 VSS VSS nmos W=0.155u L=0.04u
M16372 U5354/net10 n4796 VSS VSS nmos W=0.155u L=0.04u
M16373 U5354/net4 U5354/net10 U5354/net14 VDD pmos W=0.255u L=0.04u
M16374 U5354/net6 n4796 U5354/net14 VDD pmos W=0.28u L=0.04u
M16375 U5354/net4 n4935 VDD VDD pmos W=0.205u L=0.04u
M16376 U5354/net6 U5354/net4 VDD VDD pmos W=0.24u L=0.04u
M16377 n4932 U5354/net14 VDD VDD pmos W=0.205u L=0.04u
M16378 U5354/net10 n4796 VDD VDD pmos W=0.205u L=0.04u
M16379 U5355/net36 g156 U5355/net27 VSS nmos W=0.155u L=0.04u
M16380 U5355/net39 g157 VSS VSS nmos W=0.155u L=0.04u
M16381 U5355/net27 n4771 U5355/net39 VSS nmos W=0.155u L=0.04u
M16382 U5355/net27 g158 U5355/net39 VSS nmos W=0.155u L=0.04u
M16383 U5355/net36 n4770 U5355/net27 VSS nmos W=0.155u L=0.04u
M16384 U5355/net39 n4769 VSS VSS nmos W=0.155u L=0.04u
M16385 n4935 U5355/net36 VSS VSS nmos W=0.155u L=0.04u
M16386 n4935 U5355/net36 VDD VDD pmos W=0.205u L=0.04u
M16387 U5355/net36 g157 U5355/net46 VDD pmos W=0.205u L=0.04u
M16388 U5355/net46 n4769 VDD VDD pmos W=0.205u L=0.04u
M16389 U5355/net36 n4770 U5355/net34 VDD pmos W=0.205u L=0.04u
M16390 U5355/net34 g156 VDD VDD pmos W=0.205u L=0.04u
M16391 U5355/net36 g158 U5355/net37 VDD pmos W=0.205u L=0.04u
M16392 U5355/net37 n4771 VDD VDD pmos W=0.205u L=0.04u
M16393 U5356/net4 n4745 U5356/net14 VSS nmos W=0.155u L=0.04u
M16394 U5356/net6 U5356/net10 U5356/net14 VSS nmos W=0.17u L=0.04u
M16395 U5356/net4 n4936 VSS VSS nmos W=0.155u L=0.04u
M16396 U5356/net6 U5356/net4 VSS VSS nmos W=0.17u L=0.04u
M16397 n4931 U5356/net14 VSS VSS nmos W=0.155u L=0.04u
M16398 U5356/net10 n4745 VSS VSS nmos W=0.155u L=0.04u
M16399 U5356/net4 U5356/net10 U5356/net14 VDD pmos W=0.255u L=0.04u
M16400 U5356/net6 n4745 U5356/net14 VDD pmos W=0.28u L=0.04u
M16401 U5356/net4 n4936 VDD VDD pmos W=0.205u L=0.04u
M16402 U5356/net6 U5356/net4 VDD VDD pmos W=0.24u L=0.04u
M16403 n4931 U5356/net14 VDD VDD pmos W=0.205u L=0.04u
M16404 U5356/net10 n4745 VDD VDD pmos W=0.205u L=0.04u
M16405 U5357/net36 g147 U5357/net27 VSS nmos W=0.155u L=0.04u
M16406 U5357/net39 g148 VSS VSS nmos W=0.155u L=0.04u
M16407 U5357/net27 n4771 U5357/net39 VSS nmos W=0.155u L=0.04u
M16408 U5357/net27 g149 U5357/net39 VSS nmos W=0.155u L=0.04u
M16409 U5357/net36 n4770 U5357/net27 VSS nmos W=0.155u L=0.04u
M16410 U5357/net39 n4769 VSS VSS nmos W=0.155u L=0.04u
M16411 n4936 U5357/net36 VSS VSS nmos W=0.155u L=0.04u
M16412 n4936 U5357/net36 VDD VDD pmos W=0.205u L=0.04u
M16413 U5357/net36 g148 U5357/net46 VDD pmos W=0.205u L=0.04u
M16414 U5357/net46 n4769 VDD VDD pmos W=0.205u L=0.04u
M16415 U5357/net36 n4770 U5357/net34 VDD pmos W=0.205u L=0.04u
M16416 U5357/net34 g147 VDD VDD pmos W=0.205u L=0.04u
M16417 U5357/net36 g149 U5357/net37 VDD pmos W=0.205u L=0.04u
M16418 U5357/net37 n4771 VDD VDD pmos W=0.205u L=0.04u
M16419 n4922 n4938 VSS VSS nmos W=0.155u L=0.04u
M16420 n4922 n4937 VSS VSS nmos W=0.155u L=0.04u
M16421 n4922 n4891 VSS VSS nmos W=0.155u L=0.04u
M16422 U5358/net25 n4938 VDD VDD pmos W=0.41u L=0.04u
M16423 U5358/net28 n4937 U5358/net25 VDD pmos W=0.41u L=0.04u
M16424 n4922 n4891 U5358/net28 VDD pmos W=0.41u L=0.04u
M16425 U5359/net4 n4939 U5359/net14 VSS nmos W=0.155u L=0.04u
M16426 U5359/net6 U5359/net10 U5359/net14 VSS nmos W=0.17u L=0.04u
M16427 U5359/net4 g117 VSS VSS nmos W=0.155u L=0.04u
M16428 U5359/net6 U5359/net4 VSS VSS nmos W=0.17u L=0.04u
M16429 n4938 U5359/net14 VSS VSS nmos W=0.155u L=0.04u
M16430 U5359/net10 n4939 VSS VSS nmos W=0.155u L=0.04u
M16431 U5359/net4 U5359/net10 U5359/net14 VDD pmos W=0.255u L=0.04u
M16432 U5359/net6 n4939 U5359/net14 VDD pmos W=0.28u L=0.04u
M16433 U5359/net4 g117 VDD VDD pmos W=0.205u L=0.04u
M16434 U5359/net6 U5359/net4 VDD VDD pmos W=0.24u L=0.04u
M16435 n4938 U5359/net14 VDD VDD pmos W=0.205u L=0.04u
M16436 U5359/net10 n4939 VDD VDD pmos W=0.205u L=0.04u
M16437 U5360/net36 g150 U5360/net27 VSS nmos W=0.155u L=0.04u
M16438 U5360/net39 g151 VSS VSS nmos W=0.155u L=0.04u
M16439 U5360/net27 n4771 U5360/net39 VSS nmos W=0.155u L=0.04u
M16440 U5360/net27 g152 U5360/net39 VSS nmos W=0.155u L=0.04u
M16441 U5360/net36 n4770 U5360/net27 VSS nmos W=0.155u L=0.04u
M16442 U5360/net39 n4769 VSS VSS nmos W=0.155u L=0.04u
M16443 n4939 U5360/net36 VSS VSS nmos W=0.155u L=0.04u
M16444 n4939 U5360/net36 VDD VDD pmos W=0.205u L=0.04u
M16445 U5360/net36 g151 U5360/net46 VDD pmos W=0.205u L=0.04u
M16446 U5360/net46 n4769 VDD VDD pmos W=0.205u L=0.04u
M16447 U5360/net36 n4770 U5360/net34 VDD pmos W=0.205u L=0.04u
M16448 U5360/net34 g150 VDD VDD pmos W=0.205u L=0.04u
M16449 U5360/net36 g152 U5360/net37 VDD pmos W=0.205u L=0.04u
M16450 U5360/net37 n4771 VDD VDD pmos W=0.205u L=0.04u
M16451 U5361/net4 n4940 U5361/net14 VSS nmos W=0.155u L=0.04u
M16452 U5361/net6 U5361/net10 U5361/net14 VSS nmos W=0.17u L=0.04u
M16453 U5361/net4 g105 VSS VSS nmos W=0.155u L=0.04u
M16454 U5361/net6 U5361/net4 VSS VSS nmos W=0.17u L=0.04u
M16455 n4937 U5361/net14 VSS VSS nmos W=0.155u L=0.04u
M16456 U5361/net10 n4940 VSS VSS nmos W=0.155u L=0.04u
M16457 U5361/net4 U5361/net10 U5361/net14 VDD pmos W=0.255u L=0.04u
M16458 U5361/net6 n4940 U5361/net14 VDD pmos W=0.28u L=0.04u
M16459 U5361/net4 g105 VDD VDD pmos W=0.205u L=0.04u
M16460 U5361/net6 U5361/net4 VDD VDD pmos W=0.24u L=0.04u
M16461 n4937 U5361/net14 VDD VDD pmos W=0.205u L=0.04u
M16462 U5361/net10 n4940 VDD VDD pmos W=0.205u L=0.04u
M16463 U5362/net36 g141 U5362/net27 VSS nmos W=0.155u L=0.04u
M16464 U5362/net39 g142 VSS VSS nmos W=0.155u L=0.04u
M16465 U5362/net27 n4771 U5362/net39 VSS nmos W=0.155u L=0.04u
M16466 U5362/net27 g143 U5362/net39 VSS nmos W=0.155u L=0.04u
M16467 U5362/net36 n4770 U5362/net27 VSS nmos W=0.155u L=0.04u
M16468 U5362/net39 n4769 VSS VSS nmos W=0.155u L=0.04u
M16469 n4940 U5362/net36 VSS VSS nmos W=0.155u L=0.04u
M16470 n4940 U5362/net36 VDD VDD pmos W=0.205u L=0.04u
M16471 U5362/net36 g142 U5362/net46 VDD pmos W=0.205u L=0.04u
M16472 U5362/net46 n4769 VDD VDD pmos W=0.205u L=0.04u
M16473 U5362/net36 n4770 U5362/net34 VDD pmos W=0.205u L=0.04u
M16474 U5362/net34 g141 VDD VDD pmos W=0.205u L=0.04u
M16475 U5362/net36 g143 U5362/net37 VDD pmos W=0.205u L=0.04u
M16476 U5362/net37 n4771 VDD VDD pmos W=0.205u L=0.04u
M16477 U5363/net4 n4795 U5363/net14 VSS nmos W=0.155u L=0.04u
M16478 U5363/net6 U5363/net10 U5363/net14 VSS nmos W=0.17u L=0.04u
M16479 U5363/net4 n4941 VSS VSS nmos W=0.155u L=0.04u
M16480 U5363/net6 U5363/net4 VSS VSS nmos W=0.17u L=0.04u
M16481 n4921 U5363/net14 VSS VSS nmos W=0.155u L=0.04u
M16482 U5363/net10 n4795 VSS VSS nmos W=0.155u L=0.04u
M16483 U5363/net4 U5363/net10 U5363/net14 VDD pmos W=0.255u L=0.04u
M16484 U5363/net6 n4795 U5363/net14 VDD pmos W=0.28u L=0.04u
M16485 U5363/net4 n4941 VDD VDD pmos W=0.205u L=0.04u
M16486 U5363/net6 U5363/net4 VDD VDD pmos W=0.24u L=0.04u
M16487 n4921 U5363/net14 VDD VDD pmos W=0.205u L=0.04u
M16488 U5363/net10 n4795 VDD VDD pmos W=0.205u L=0.04u
M16489 n4941 n4769 U5364/net27 VSS nmos W=0.155u L=0.04u
M16490 U5364/net39 n4771 VSS VSS nmos W=0.155u L=0.04u
M16491 U5364/net27 g162 U5364/net39 VSS nmos W=0.155u L=0.04u
M16492 U5364/net27 n4770 U5364/net39 VSS nmos W=0.155u L=0.04u
M16493 n4941 g163 U5364/net27 VSS nmos W=0.155u L=0.04u
M16494 U5364/net39 g164 VSS VSS nmos W=0.155u L=0.04u
M16495 n4941 n4771 U5364/net46 VDD pmos W=0.205u L=0.04u
M16496 U5364/net46 g164 VDD VDD pmos W=0.205u L=0.04u
M16497 n4941 g163 U5364/net34 VDD pmos W=0.205u L=0.04u
M16498 U5364/net34 n4769 VDD VDD pmos W=0.205u L=0.04u
M16499 n4941 n4770 U5364/net37 VDD pmos W=0.205u L=0.04u
M16500 U5364/net37 g162 VDD VDD pmos W=0.205u L=0.04u
M16501 U5365/net4 n4942 U5365/net14 VSS nmos W=0.155u L=0.04u
M16502 U5365/net6 U5365/net10 U5365/net14 VSS nmos W=0.17u L=0.04u
M16503 U5365/net4 n4943 VSS VSS nmos W=0.155u L=0.04u
M16504 U5365/net6 U5365/net4 VSS VSS nmos W=0.17u L=0.04u
M16505 n4920 U5365/net14 VSS VSS nmos W=0.155u L=0.04u
M16506 U5365/net10 n4942 VSS VSS nmos W=0.155u L=0.04u
M16507 U5365/net4 U5365/net10 U5365/net14 VDD pmos W=0.255u L=0.04u
M16508 U5365/net6 n4942 U5365/net14 VDD pmos W=0.28u L=0.04u
M16509 U5365/net4 n4943 VDD VDD pmos W=0.205u L=0.04u
M16510 U5365/net6 U5365/net4 VDD VDD pmos W=0.24u L=0.04u
M16511 n4920 U5365/net14 VDD VDD pmos W=0.205u L=0.04u
M16512 U5365/net10 n4942 VDD VDD pmos W=0.205u L=0.04u
M16513 n4943 n4769 U5366/net27 VSS nmos W=0.155u L=0.04u
M16514 U5366/net39 n4771 VSS VSS nmos W=0.155u L=0.04u
M16515 U5366/net27 g159 U5366/net39 VSS nmos W=0.155u L=0.04u
M16516 U5366/net27 n4770 U5366/net39 VSS nmos W=0.155u L=0.04u
M16517 n4943 g160 U5366/net27 VSS nmos W=0.155u L=0.04u
M16518 U5366/net39 g161 VSS VSS nmos W=0.155u L=0.04u
M16519 n4943 n4771 U5366/net46 VDD pmos W=0.205u L=0.04u
M16520 U5366/net46 g161 VDD VDD pmos W=0.205u L=0.04u
M16521 n4943 g160 U5366/net34 VDD pmos W=0.205u L=0.04u
M16522 U5366/net34 n4769 VDD VDD pmos W=0.205u L=0.04u
M16523 n4943 n4770 U5366/net37 VDD pmos W=0.205u L=0.04u
M16524 U5366/net37 g159 VDD VDD pmos W=0.205u L=0.04u
M16525 U5367/XU1-net6 n4900 VSS VSS nmos W=0.155u L=0.04u
M16526 n4806 n4885 U5367/XU1-net6 VSS nmos W=0.155u L=0.04u
M16527 n4806 n4900 VDD VDD pmos W=0.155u L=0.04u
M16528 n4806 n4885 VDD VDD pmos W=0.155u L=0.04u
M16529 n4900 n4944 U5368/net15 VSS nmos W=0.155u L=0.04u
M16530 n4900 n4945 U5368/net15 VSS nmos W=0.155u L=0.04u
M16531 U5368/net15 n4886 VSS VSS nmos W=0.155u L=0.04u
M16532 n4900 n4886 VDD VDD pmos W=0.205u L=0.04u
M16533 n4900 n4944 U5368/XI16-net11 VDD pmos W=0.205u L=0.04u
M16534 U5368/XI16-net11 n4945 VDD VDD pmos W=0.205u L=0.04u
M16535 n4945 n4897 U5369/net14 VSS nmos W=0.155u L=0.04u
M16536 U5369/net14 n4947 VSS VSS nmos W=0.155u L=0.04u
M16537 U5369/net14 n4946 VSS VSS nmos W=0.155u L=0.04u
M16538 n4945 n4896 U5369/net14 VSS nmos W=0.155u L=0.04u
M16539 n4945 n4892 U5369/net14 VSS nmos W=0.155u L=0.04u
M16540 n4945 n4947 U5369/XI16-net11 VDD pmos W=0.205u L=0.04u
M16541 U5369/XI16-net11 n4946 VDD VDD pmos W=0.205u L=0.04u
M16542 n4945 n4896 U5369/XI15-net11 VDD pmos W=0.205u L=0.04u
M16543 U5369/XI15-net11 n4892 U5369/XI15-net18 VDD pmos W=0.205u L=0.04u
M16544 U5369/XI15-net18 n4897 VDD VDD pmos W=0.205u L=0.04u
M16545 U5370/net29 n4897 VSS VSS nmos W=0.155u L=0.04u
M16546 U5370/net26 n4949 U5370/net20 VSS nmos W=0.155u L=0.04u
M16547 U5370/net20 n4950 VSS VSS nmos W=0.155u L=0.04u
M16548 U5370/net26 n4948 U5370/net29 VSS nmos W=0.155u L=0.04u
M16549 n4947 U5370/net26 VSS VSS nmos W=0.155u L=0.04u
M16550 n4947 U5370/net26 VDD VDD pmos W=0.205u L=0.04u
M16551 U5370/net26 n4948 U5370/net40 VDD pmos W=0.205u L=0.04u
M16552 U5370/net26 n4897 U5370/net40 VDD pmos W=0.205u L=0.04u
M16553 U5370/net40 n4950 VDD VDD pmos W=0.205u L=0.04u
M16554 U5370/net40 n4949 VDD VDD pmos W=0.205u L=0.04u
M16555 n4896 U5371/net6 VSS VSS nmos W=0.155u L=0.04u
M16556 U5371/X_u2-net6 n4949 VSS VSS nmos W=0.155u L=0.04u
M16557 U5371/net6 n4948 U5371/X_u2-net6 VSS nmos W=0.155u L=0.04u
M16558 n4896 U5371/net6 VDD VDD pmos W=0.205u L=0.04u
M16559 U5371/net6 n4949 VDD VDD pmos W=0.205u L=0.04u
M16560 U5371/net6 n4948 VDD VDD pmos W=0.205u L=0.04u
M16561 n4892 U5372/net6 VSS VSS nmos W=0.155u L=0.04u
M16562 U5372/X_u2-net6 n4950 VSS VSS nmos W=0.155u L=0.04u
M16563 U5372/net6 n4946 U5372/X_u2-net6 VSS nmos W=0.155u L=0.04u
M16564 n4892 U5372/net6 VDD VDD pmos W=0.205u L=0.04u
M16565 U5372/net6 n4950 VDD VDD pmos W=0.205u L=0.04u
M16566 U5372/net6 n4946 VDD VDD pmos W=0.205u L=0.04u
M16567 n4944 n4949 VSS VSS nmos W=0.155u L=0.04u
M16568 n4944 n4950 U5373/XI17-net17 VSS nmos W=0.155u L=0.04u
M16569 U5373/XI17-net17 n4897 VSS VSS nmos W=0.155u L=0.04u
M16570 n4944 n4946 U5373/XI10-net17 VSS nmos W=0.155u L=0.04u
M16571 U5373/XI10-net17 n4948 VSS VSS nmos W=0.155u L=0.04u
M16572 U5373/net30 n4946 n4944 VDD pmos W=0.205u L=0.04u
M16573 U5373/net30 n4948 n4944 VDD pmos W=0.205u L=0.04u
M16574 VDD n4949 U5373/net36 VDD pmos W=0.205u L=0.04u
M16575 U5373/net36 n4897 U5373/net30 VDD pmos W=0.205u L=0.04u
M16576 U5373/net36 n4950 U5373/net30 VDD pmos W=0.205u L=0.04u
M16577 U5374/net4 U5374/net10 U5374/net14 VSS nmos W=0.155u L=0.04u
M16578 U5374/net6 n4910 U5374/net14 VSS nmos W=0.155u L=0.04u
M16579 U5374/net4 n4742 VSS VSS nmos W=0.155u L=0.04u
M16580 U5374/net6 U5374/net4 VSS VSS nmos W=0.155u L=0.04u
M16581 n4949 U5374/net14 VSS VSS nmos W=0.155u L=0.04u
M16582 U5374/net10 n4910 VSS VSS nmos W=0.155u L=0.04u
M16583 U5374/net4 n4910 U5374/net14 VDD pmos W=0.205u L=0.04u
M16584 U5374/net6 U5374/net10 U5374/net14 VDD pmos W=0.205u L=0.04u
M16585 U5374/net4 n4742 VDD VDD pmos W=0.205u L=0.04u
M16586 U5374/net6 U5374/net4 VDD VDD pmos W=0.205u L=0.04u
M16587 n4949 U5374/net14 VDD VDD pmos W=0.205u L=0.04u
M16588 U5374/net10 n4910 VDD VDD pmos W=0.205u L=0.04u
M16589 U5375/net4 U5375/net10 U5375/net14 VSS nmos W=0.155u L=0.04u
M16590 U5375/net6 n4912 U5375/net14 VSS nmos W=0.155u L=0.04u
M16591 U5375/net4 n4746 VSS VSS nmos W=0.155u L=0.04u
M16592 U5375/net6 U5375/net4 VSS VSS nmos W=0.155u L=0.04u
M16593 n4897 U5375/net14 VSS VSS nmos W=0.155u L=0.04u
M16594 U5375/net10 n4912 VSS VSS nmos W=0.155u L=0.04u
M16595 U5375/net4 n4912 U5375/net14 VDD pmos W=0.205u L=0.04u
M16596 U5375/net6 U5375/net10 U5375/net14 VDD pmos W=0.205u L=0.04u
M16597 U5375/net4 n4746 VDD VDD pmos W=0.205u L=0.04u
M16598 U5375/net6 U5375/net4 VDD VDD pmos W=0.205u L=0.04u
M16599 n4897 U5375/net14 VDD VDD pmos W=0.205u L=0.04u
M16600 U5375/net10 n4912 VDD VDD pmos W=0.205u L=0.04u
M16601 U5376/net4 n4911 U5376/net14 VSS nmos W=0.155u L=0.04u
M16602 U5376/net6 U5376/net10 U5376/net14 VSS nmos W=0.17u L=0.04u
M16603 U5376/net4 g109 VSS VSS nmos W=0.155u L=0.04u
M16604 U5376/net6 U5376/net4 VSS VSS nmos W=0.17u L=0.04u
M16605 n4950 U5376/net14 VSS VSS nmos W=0.155u L=0.04u
M16606 U5376/net10 n4911 VSS VSS nmos W=0.155u L=0.04u
M16607 U5376/net4 U5376/net10 U5376/net14 VDD pmos W=0.255u L=0.04u
M16608 U5376/net6 n4911 U5376/net14 VDD pmos W=0.28u L=0.04u
M16609 U5376/net4 g109 VDD VDD pmos W=0.205u L=0.04u
M16610 U5376/net6 U5376/net4 VDD VDD pmos W=0.24u L=0.04u
M16611 n4950 U5376/net14 VDD VDD pmos W=0.205u L=0.04u
M16612 U5376/net10 n4911 VDD VDD pmos W=0.205u L=0.04u
M16613 U5377/net4 U5377/net10 U5377/net14 VSS nmos W=0.155u L=0.04u
M16614 U5377/net6 n4842 U5377/net14 VSS nmos W=0.155u L=0.04u
M16615 U5377/net4 n4796 VSS VSS nmos W=0.155u L=0.04u
M16616 U5377/net6 U5377/net4 VSS VSS nmos W=0.155u L=0.04u
M16617 n4948 U5377/net14 VSS VSS nmos W=0.155u L=0.04u
M16618 U5377/net10 n4842 VSS VSS nmos W=0.155u L=0.04u
M16619 U5377/net4 n4842 U5377/net14 VDD pmos W=0.205u L=0.04u
M16620 U5377/net6 U5377/net10 U5377/net14 VDD pmos W=0.205u L=0.04u
M16621 U5377/net4 n4796 VDD VDD pmos W=0.205u L=0.04u
M16622 U5377/net6 U5377/net4 VDD VDD pmos W=0.205u L=0.04u
M16623 n4948 U5377/net14 VDD VDD pmos W=0.205u L=0.04u
M16624 U5377/net10 n4842 VDD VDD pmos W=0.205u L=0.04u
M16625 U5378/net4 n4795 U5378/net14 VSS nmos W=0.155u L=0.04u
M16626 U5378/net6 U5378/net10 U5378/net14 VSS nmos W=0.17u L=0.04u
M16627 U5378/net4 n4951 VSS VSS nmos W=0.155u L=0.04u
M16628 U5378/net6 U5378/net4 VSS VSS nmos W=0.17u L=0.04u
M16629 n4946 U5378/net14 VSS VSS nmos W=0.155u L=0.04u
M16630 U5378/net10 n4795 VSS VSS nmos W=0.155u L=0.04u
M16631 U5378/net4 U5378/net10 U5378/net14 VDD pmos W=0.255u L=0.04u
M16632 U5378/net6 n4795 U5378/net14 VDD pmos W=0.28u L=0.04u
M16633 U5378/net4 n4951 VDD VDD pmos W=0.205u L=0.04u
M16634 U5378/net6 U5378/net4 VDD VDD pmos W=0.24u L=0.04u
M16635 n4946 U5378/net14 VDD VDD pmos W=0.205u L=0.04u
M16636 U5378/net10 n4795 VDD VDD pmos W=0.205u L=0.04u
M16637 n4795 n4769 U5379/net27 VSS nmos W=0.155u L=0.04u
M16638 U5379/net39 n4771 VSS VSS nmos W=0.155u L=0.04u
M16639 U5379/net27 g171 U5379/net39 VSS nmos W=0.155u L=0.04u
M16640 U5379/net27 n4770 U5379/net39 VSS nmos W=0.155u L=0.04u
M16641 n4795 g172 U5379/net27 VSS nmos W=0.155u L=0.04u
M16642 U5379/net39 g173 VSS VSS nmos W=0.155u L=0.04u
M16643 n4795 n4771 U5379/net46 VDD pmos W=0.205u L=0.04u
M16644 U5379/net46 g173 VDD VDD pmos W=0.205u L=0.04u
M16645 n4795 g172 U5379/net34 VDD pmos W=0.205u L=0.04u
M16646 U5379/net34 n4769 VDD VDD pmos W=0.205u L=0.04u
M16647 n4795 n4770 U5379/net37 VDD pmos W=0.205u L=0.04u
M16648 U5379/net37 g171 VDD VDD pmos W=0.205u L=0.04u
M16649 n4885 n4952 U5380/net15 VSS nmos W=0.155u L=0.04u
M16650 n4885 n4953 U5380/net15 VSS nmos W=0.155u L=0.04u
M16651 U5380/net15 n4886 VSS VSS nmos W=0.155u L=0.04u
M16652 n4885 n4886 VDD VDD pmos W=0.205u L=0.04u
M16653 n4885 n4952 U5380/XI16-net11 VDD pmos W=0.205u L=0.04u
M16654 U5380/XI16-net11 n4953 VDD VDD pmos W=0.205u L=0.04u
M16655 n4886 n4891 VSS VSS nmos W=0.135u L=0.04u
M16656 n4886 n4891 VDD VDD pmos W=0.205u L=0.04u
M16657 U5382/XU1-net6 n4919 VSS VSS nmos W=0.155u L=0.04u
M16658 n4891 g181 U5382/XU1-net6 VSS nmos W=0.155u L=0.04u
M16659 n4891 n4919 VDD VDD pmos W=0.155u L=0.04u
M16660 n4891 g181 VDD VDD pmos W=0.155u L=0.04u
M16661 n4919 n4769 U5383/net27 VSS nmos W=0.155u L=0.04u
M16662 U5383/net39 n4771 VSS VSS nmos W=0.155u L=0.04u
M16663 U5383/net27 g168 U5383/net39 VSS nmos W=0.155u L=0.04u
M16664 U5383/net27 n4770 U5383/net39 VSS nmos W=0.155u L=0.04u
M16665 n4919 g169 U5383/net27 VSS nmos W=0.155u L=0.04u
M16666 U5383/net39 g170 VSS VSS nmos W=0.155u L=0.04u
M16667 n4919 n4771 U5383/net46 VDD pmos W=0.205u L=0.04u
M16668 U5383/net46 g170 VDD VDD pmos W=0.205u L=0.04u
M16669 n4919 g169 U5383/net34 VDD pmos W=0.205u L=0.04u
M16670 U5383/net34 n4769 VDD VDD pmos W=0.205u L=0.04u
M16671 n4919 n4770 U5383/net37 VDD pmos W=0.205u L=0.04u
M16672 U5383/net37 g168 VDD VDD pmos W=0.205u L=0.04u
M16673 n4953 n4898 U5384/net14 VSS nmos W=0.155u L=0.04u
M16674 U5384/net14 n4955 VSS VSS nmos W=0.155u L=0.04u
M16675 U5384/net14 n4954 VSS VSS nmos W=0.155u L=0.04u
M16676 n4953 n4893 U5384/net14 VSS nmos W=0.155u L=0.04u
M16677 n4953 n4894 U5384/net14 VSS nmos W=0.155u L=0.04u
M16678 n4953 n4955 U5384/XI16-net11 VDD pmos W=0.205u L=0.04u
M16679 U5384/XI16-net11 n4954 VDD VDD pmos W=0.205u L=0.04u
M16680 n4953 n4893 U5384/XI15-net11 VDD pmos W=0.205u L=0.04u
M16681 U5384/XI15-net11 n4894 U5384/XI15-net18 VDD pmos W=0.205u L=0.04u
M16682 U5384/XI15-net18 n4898 VDD VDD pmos W=0.205u L=0.04u
M16683 U5385/net29 n4898 VSS VSS nmos W=0.155u L=0.04u
M16684 U5385/net26 n4957 U5385/net20 VSS nmos W=0.155u L=0.04u
M16685 U5385/net20 n4958 VSS VSS nmos W=0.155u L=0.04u
M16686 U5385/net26 n4956 U5385/net29 VSS nmos W=0.155u L=0.04u
M16687 n4955 U5385/net26 VSS VSS nmos W=0.155u L=0.04u
M16688 n4955 U5385/net26 VDD VDD pmos W=0.205u L=0.04u
M16689 U5385/net26 n4956 U5385/net40 VDD pmos W=0.205u L=0.04u
M16690 U5385/net26 n4898 U5385/net40 VDD pmos W=0.205u L=0.04u
M16691 U5385/net40 n4958 VDD VDD pmos W=0.205u L=0.04u
M16692 U5385/net40 n4957 VDD VDD pmos W=0.205u L=0.04u
M16693 n4893 U5386/net6 VSS VSS nmos W=0.155u L=0.04u
M16694 U5386/X_u2-net6 n4957 VSS VSS nmos W=0.155u L=0.04u
M16695 U5386/net6 n4956 U5386/X_u2-net6 VSS nmos W=0.155u L=0.04u
M16696 n4893 U5386/net6 VDD VDD pmos W=0.205u L=0.04u
M16697 U5386/net6 n4957 VDD VDD pmos W=0.205u L=0.04u
M16698 U5386/net6 n4956 VDD VDD pmos W=0.205u L=0.04u
M16699 n4894 U5387/net6 VSS VSS nmos W=0.155u L=0.04u
M16700 U5387/X_u2-net6 n4958 VSS VSS nmos W=0.155u L=0.04u
M16701 U5387/net6 n4954 U5387/X_u2-net6 VSS nmos W=0.155u L=0.04u
M16702 n4894 U5387/net6 VDD VDD pmos W=0.205u L=0.04u
M16703 U5387/net6 n4958 VDD VDD pmos W=0.205u L=0.04u
M16704 U5387/net6 n4954 VDD VDD pmos W=0.205u L=0.04u
M16705 n4952 n4957 VSS VSS nmos W=0.155u L=0.04u
M16706 n4952 n4958 U5388/XI17-net17 VSS nmos W=0.155u L=0.04u
M16707 U5388/XI17-net17 n4898 VSS VSS nmos W=0.155u L=0.04u
M16708 n4952 n4954 U5388/XI10-net17 VSS nmos W=0.155u L=0.04u
M16709 U5388/XI10-net17 n4956 VSS VSS nmos W=0.155u L=0.04u
M16710 U5388/net30 n4954 n4952 VDD pmos W=0.205u L=0.04u
M16711 U5388/net30 n4956 n4952 VDD pmos W=0.205u L=0.04u
M16712 VDD n4957 U5388/net36 VDD pmos W=0.205u L=0.04u
M16713 U5388/net36 n4898 U5388/net30 VDD pmos W=0.205u L=0.04u
M16714 U5388/net36 n4958 U5388/net30 VDD pmos W=0.205u L=0.04u
M16715 U5389/net4 U5389/net10 U5389/net14 VSS nmos W=0.155u L=0.04u
M16716 U5389/net6 n4828 U5389/net14 VSS nmos W=0.155u L=0.04u
M16717 U5389/net4 g97 VSS VSS nmos W=0.155u L=0.04u
M16718 U5389/net6 U5389/net4 VSS VSS nmos W=0.155u L=0.04u
M16719 n4957 U5389/net14 VSS VSS nmos W=0.155u L=0.04u
M16720 U5389/net10 n4828 VSS VSS nmos W=0.155u L=0.04u
M16721 U5389/net4 n4828 U5389/net14 VDD pmos W=0.205u L=0.04u
M16722 U5389/net6 U5389/net10 U5389/net14 VDD pmos W=0.205u L=0.04u
M16723 U5389/net4 g97 VDD VDD pmos W=0.205u L=0.04u
M16724 U5389/net6 U5389/net4 VDD VDD pmos W=0.205u L=0.04u
M16725 n4957 U5389/net14 VDD VDD pmos W=0.205u L=0.04u
M16726 U5389/net10 n4828 VDD VDD pmos W=0.205u L=0.04u
M16727 U5390/net4 U5390/net10 U5390/net14 VSS nmos W=0.155u L=0.04u
M16728 U5390/net6 n4824 U5390/net14 VSS nmos W=0.155u L=0.04u
M16729 U5390/net4 n4745 VSS VSS nmos W=0.155u L=0.04u
M16730 U5390/net6 U5390/net4 VSS VSS nmos W=0.155u L=0.04u
M16731 n4898 U5390/net14 VSS VSS nmos W=0.155u L=0.04u
M16732 U5390/net10 n4824 VSS VSS nmos W=0.155u L=0.04u
M16733 U5390/net4 n4824 U5390/net14 VDD pmos W=0.205u L=0.04u
M16734 U5390/net6 U5390/net10 U5390/net14 VDD pmos W=0.205u L=0.04u
M16735 U5390/net4 n4745 VDD VDD pmos W=0.205u L=0.04u
M16736 U5390/net6 U5390/net4 VDD VDD pmos W=0.205u L=0.04u
M16737 n4898 U5390/net14 VDD VDD pmos W=0.205u L=0.04u
M16738 U5390/net10 n4824 VDD VDD pmos W=0.205u L=0.04u
M16739 n4824 n4959 VSS VSS nmos W=0.135u L=0.04u
M16740 n4824 n4959 VDD VDD pmos W=0.205u L=0.04u
M16741 U5392/net4 U5392/net10 U5392/net14 VSS nmos W=0.155u L=0.04u
M16742 U5392/net6 n4847 U5392/net14 VSS nmos W=0.155u L=0.04u
M16743 U5392/net4 g105 VSS VSS nmos W=0.155u L=0.04u
M16744 U5392/net6 U5392/net4 VSS VSS nmos W=0.155u L=0.04u
M16745 n4958 U5392/net14 VSS VSS nmos W=0.155u L=0.04u
M16746 U5392/net10 n4847 VSS VSS nmos W=0.155u L=0.04u
M16747 U5392/net4 n4847 U5392/net14 VDD pmos W=0.205u L=0.04u
M16748 U5392/net6 U5392/net10 U5392/net14 VDD pmos W=0.205u L=0.04u
M16749 U5392/net4 g105 VDD VDD pmos W=0.205u L=0.04u
M16750 U5392/net6 U5392/net4 VDD VDD pmos W=0.205u L=0.04u
M16751 n4958 U5392/net14 VDD VDD pmos W=0.205u L=0.04u
M16752 U5392/net10 n4847 VDD VDD pmos W=0.205u L=0.04u
M16753 U5393/net4 U5393/net10 U5393/net14 VSS nmos W=0.155u L=0.04u
M16754 U5393/net6 n4905 U5393/net14 VSS nmos W=0.155u L=0.04u
M16755 U5393/net4 n4747 VSS VSS nmos W=0.155u L=0.04u
M16756 U5393/net6 U5393/net4 VSS VSS nmos W=0.155u L=0.04u
M16757 n4956 U5393/net14 VSS VSS nmos W=0.155u L=0.04u
M16758 U5393/net10 n4905 VSS VSS nmos W=0.155u L=0.04u
M16759 U5393/net4 n4905 U5393/net14 VDD pmos W=0.205u L=0.04u
M16760 U5393/net6 U5393/net10 U5393/net14 VDD pmos W=0.205u L=0.04u
M16761 U5393/net4 n4747 VDD VDD pmos W=0.205u L=0.04u
M16762 U5393/net6 U5393/net4 VDD VDD pmos W=0.205u L=0.04u
M16763 n4956 U5393/net14 VDD VDD pmos W=0.205u L=0.04u
M16764 U5393/net10 n4905 VDD VDD pmos W=0.205u L=0.04u
M16765 U5394/net4 n4836 U5394/net14 VSS nmos W=0.155u L=0.04u
M16766 U5394/net6 U5394/net10 U5394/net14 VSS nmos W=0.17u L=0.04u
M16767 U5394/net4 n4343 VSS VSS nmos W=0.155u L=0.04u
M16768 U5394/net6 U5394/net4 VSS VSS nmos W=0.17u L=0.04u
M16769 n4954 U5394/net14 VSS VSS nmos W=0.155u L=0.04u
M16770 U5394/net10 n4836 VSS VSS nmos W=0.155u L=0.04u
M16771 U5394/net4 U5394/net10 U5394/net14 VDD pmos W=0.255u L=0.04u
M16772 U5394/net6 n4836 U5394/net14 VDD pmos W=0.28u L=0.04u
M16773 U5394/net4 n4343 VDD VDD pmos W=0.205u L=0.04u
M16774 U5394/net6 U5394/net4 VDD VDD pmos W=0.24u L=0.04u
M16775 n4954 U5394/net14 VDD VDD pmos W=0.205u L=0.04u
M16776 U5394/net10 n4836 VDD VDD pmos W=0.205u L=0.04u
M16777 n4343 n4942 VSS VSS nmos W=0.135u L=0.04u
M16778 n4343 n4942 VDD VDD pmos W=0.205u L=0.04u
M16779 n4942 n4769 U5396/net27 VSS nmos W=0.155u L=0.04u
M16780 U5396/net39 n4771 VSS VSS nmos W=0.155u L=0.04u
M16781 U5396/net27 g174 U5396/net39 VSS nmos W=0.155u L=0.04u
M16782 U5396/net27 n4770 U5396/net39 VSS nmos W=0.155u L=0.04u
M16783 n4942 g175 U5396/net27 VSS nmos W=0.155u L=0.04u
M16784 U5396/net39 g176 VSS VSS nmos W=0.155u L=0.04u
M16785 n4942 n4771 U5396/net46 VDD pmos W=0.205u L=0.04u
M16786 U5396/net46 g176 VDD VDD pmos W=0.205u L=0.04u
M16787 n4942 g175 U5396/net34 VDD pmos W=0.205u L=0.04u
M16788 U5396/net34 n4769 VDD VDD pmos W=0.205u L=0.04u
M16789 n4942 n4770 U5396/net37 VDD pmos W=0.205u L=0.04u
M16790 U5396/net37 g174 VDD VDD pmos W=0.205u L=0.04u
M16791 n4899 n4749 U5397/net27 VSS nmos W=0.155u L=0.04u
M16792 U5397/net39 n4750 VSS VSS nmos W=0.155u L=0.04u
M16793 U5397/net27 g321 U5397/net39 VSS nmos W=0.155u L=0.04u
M16794 U5397/net27 n4751 U5397/net39 VSS nmos W=0.155u L=0.04u
M16795 n4899 g322 U5397/net27 VSS nmos W=0.155u L=0.04u
M16796 U5397/net39 g323 VSS VSS nmos W=0.155u L=0.04u
M16797 n4899 n4750 U5397/net46 VDD pmos W=0.205u L=0.04u
M16798 U5397/net46 g323 VDD VDD pmos W=0.205u L=0.04u
M16799 n4899 g322 U5397/net34 VDD pmos W=0.205u L=0.04u
M16800 U5397/net34 n4749 VDD VDD pmos W=0.205u L=0.04u
M16801 n4899 n4751 U5397/net37 VDD pmos W=0.205u L=0.04u
M16802 U5397/net37 g321 VDD VDD pmos W=0.205u L=0.04u
M16803 n4883 n4808 VSS VSS nmos W=0.135u L=0.04u
M16804 n4883 n4808 VDD VDD pmos W=0.205u L=0.04u
M16805 n4916 n4914 U5399/net27 VSS nmos W=0.155u L=0.04u
M16806 U5399/net27 n4906 VSS VSS nmos W=0.155u L=0.04u
M16807 n4916 n4913 VSS VSS nmos W=0.155u L=0.04u
M16808 n4916 n4906 U5399/net13 VDD pmos W=0.205u L=0.04u
M16809 U5399/net13 n4913 VDD VDD pmos W=0.205u L=0.04u
M16810 n4916 n4914 U5399/net13 VDD pmos W=0.205u L=0.04u
M16811 n4913 U5400/net6 VSS VSS nmos W=0.155u L=0.04u
M16812 U5400/net6 n4960 U5400/XU30-net23 VSS nmos W=0.155u L=0.04u
M16813 U5400/XU30-net23 n4911 U5400/XU30-net26 VSS nmos W=0.155u L=0.04u
M16814 U5400/XU30-net26 n4809 U5400/XU30-net29 VSS nmos W=0.155u L=0.04u
M16815 U5400/XU30-net29 n4961 VSS VSS nmos W=0.155u L=0.04u
M16816 n4913 U5400/net6 VDD VDD pmos W=0.205u L=0.04u
M16817 U5400/net6 n4961 VDD VDD pmos W=0.205u L=0.04u
M16818 U5400/net6 n4809 VDD VDD pmos W=0.205u L=0.04u
M16819 U5400/net6 n4911 VDD VDD pmos W=0.205u L=0.04u
M16820 U5400/net6 n4960 VDD VDD pmos W=0.205u L=0.04u
M16821 n4961 n4855 VSS VSS nmos W=0.155u L=0.04u
M16822 n4961 n4833 VSS VSS nmos W=0.155u L=0.04u
M16823 n4961 n4847 VSS VSS nmos W=0.155u L=0.04u
M16824 n4961 n4836 VSS VSS nmos W=0.155u L=0.04u
M16825 U5401/net49 n4833 U5401/net52 VDD pmos W=0.41u L=0.04u
M16826 U5401/net52 n4855 VDD VDD pmos W=0.41u L=0.04u
M16827 U5401/net46 n4847 U5401/net49 VDD pmos W=0.41u L=0.04u
M16828 n4961 n4836 U5401/net46 VDD pmos W=0.41u L=0.04u
M16829 n4827 n4809 VSS VSS nmos W=0.155u L=0.04u
M16830 n4827 n4335 VSS VSS nmos W=0.155u L=0.04u
M16831 U5402/XI1-net8 n4335 VDD VDD pmos W=0.205u L=0.04u
M16832 n4827 n4809 U5402/XI1-net8 VDD pmos W=0.205u L=0.04u
M16833 n4809 n4906 VSS VSS nmos W=0.135u L=0.04u
M16834 n4809 n4906 VDD VDD pmos W=0.205u L=0.04u
M16835 U5404/XU1-net6 n4866 VSS VSS nmos W=0.155u L=0.04u
M16836 n4906 n4879 U5404/XU1-net6 VSS nmos W=0.155u L=0.04u
M16837 n4906 n4866 VDD VDD pmos W=0.155u L=0.04u
M16838 n4906 n4879 VDD VDD pmos W=0.155u L=0.04u
M16839 n4866 n4874 VSS VSS nmos W=0.135u L=0.04u
M16840 n4866 n4874 VDD VDD pmos W=0.205u L=0.04u
M16841 U5406/net19 n4179 VSS VSS nmos W=0.155u L=0.04u
M16842 n3094 n4179 U5406/net40 VSS nmos W=0.155u L=0.04u
M16843 n3094 U5406/net19 U5406/net36 VSS nmos W=0.155u L=0.04u
M16844 U5406/net40 n4962 VSS VSS nmos W=0.31u L=0.04u
M16845 U5406/net36 g818 VSS VSS nmos W=0.155u L=0.04u
M16846 U5406/net19 n4179 VDD VDD pmos W=0.205u L=0.04u
M16847 n3094 U5406/net19 U5406/net26 VDD pmos W=0.325u L=0.04u
M16848 U5406/net26 n4962 VDD VDD pmos W=0.41u L=0.04u
M16849 n3094 n4179 U5406/net30 VDD pmos W=0.325u L=0.04u
M16850 U5406/net30 g818 VDD VDD pmos W=0.205u L=0.04u
M16851 U5407/net19 n4176 VSS VSS nmos W=0.155u L=0.04u
M16852 n3093 n4176 U5407/net40 VSS nmos W=0.155u L=0.04u
M16853 n3093 U5407/net19 U5407/net36 VSS nmos W=0.155u L=0.04u
M16854 U5407/net40 n4962 VSS VSS nmos W=0.31u L=0.04u
M16855 U5407/net36 g819 VSS VSS nmos W=0.155u L=0.04u
M16856 U5407/net19 n4176 VDD VDD pmos W=0.205u L=0.04u
M16857 n3093 U5407/net19 U5407/net26 VDD pmos W=0.325u L=0.04u
M16858 U5407/net26 n4962 VDD VDD pmos W=0.41u L=0.04u
M16859 n3093 n4176 U5407/net30 VDD pmos W=0.325u L=0.04u
M16860 U5407/net30 g819 VDD VDD pmos W=0.205u L=0.04u
M16861 U5408/net19 n4177 VSS VSS nmos W=0.155u L=0.04u
M16862 n3092 n4177 U5408/net40 VSS nmos W=0.155u L=0.04u
M16863 n3092 U5408/net19 U5408/net36 VSS nmos W=0.155u L=0.04u
M16864 U5408/net40 n4962 VSS VSS nmos W=0.31u L=0.04u
M16865 U5408/net36 g817 VSS VSS nmos W=0.155u L=0.04u
M16866 U5408/net19 n4177 VDD VDD pmos W=0.205u L=0.04u
M16867 n3092 U5408/net19 U5408/net26 VDD pmos W=0.325u L=0.04u
M16868 U5408/net26 n4962 VDD VDD pmos W=0.41u L=0.04u
M16869 n3092 n4177 U5408/net30 VDD pmos W=0.325u L=0.04u
M16870 U5408/net30 g817 VDD VDD pmos W=0.205u L=0.04u
M16871 U5409/net19 n4179 VSS VSS nmos W=0.155u L=0.04u
M16872 n3091 n4179 U5409/net40 VSS nmos W=0.155u L=0.04u
M16873 n3091 U5409/net19 U5409/net36 VSS nmos W=0.155u L=0.04u
M16874 U5409/net40 n4963 VSS VSS nmos W=0.31u L=0.04u
M16875 U5409/net36 g821 VSS VSS nmos W=0.155u L=0.04u
M16876 U5409/net19 n4179 VDD VDD pmos W=0.205u L=0.04u
M16877 n3091 U5409/net19 U5409/net26 VDD pmos W=0.325u L=0.04u
M16878 U5409/net26 n4963 VDD VDD pmos W=0.41u L=0.04u
M16879 n3091 n4179 U5409/net30 VDD pmos W=0.325u L=0.04u
M16880 U5409/net30 g821 VDD VDD pmos W=0.205u L=0.04u
M16881 U5410/net19 n4176 VSS VSS nmos W=0.155u L=0.04u
M16882 n3090 n4176 U5410/net40 VSS nmos W=0.155u L=0.04u
M16883 n3090 U5410/net19 U5410/net36 VSS nmos W=0.155u L=0.04u
M16884 U5410/net40 n4963 VSS VSS nmos W=0.31u L=0.04u
M16885 U5410/net36 g822 VSS VSS nmos W=0.155u L=0.04u
M16886 U5410/net19 n4176 VDD VDD pmos W=0.205u L=0.04u
M16887 n3090 U5410/net19 U5410/net26 VDD pmos W=0.325u L=0.04u
M16888 U5410/net26 n4963 VDD VDD pmos W=0.41u L=0.04u
M16889 n3090 n4176 U5410/net30 VDD pmos W=0.325u L=0.04u
M16890 U5410/net30 g822 VDD VDD pmos W=0.205u L=0.04u
M16891 U5411/net19 n4177 VSS VSS nmos W=0.155u L=0.04u
M16892 n3089 n4177 U5411/net40 VSS nmos W=0.155u L=0.04u
M16893 n3089 U5411/net19 U5411/net36 VSS nmos W=0.155u L=0.04u
M16894 U5411/net40 n4963 VSS VSS nmos W=0.31u L=0.04u
M16895 U5411/net36 g820 VSS VSS nmos W=0.155u L=0.04u
M16896 U5411/net19 n4177 VDD VDD pmos W=0.205u L=0.04u
M16897 n3089 U5411/net19 U5411/net26 VDD pmos W=0.325u L=0.04u
M16898 U5411/net26 n4963 VDD VDD pmos W=0.41u L=0.04u
M16899 n3089 n4177 U5411/net30 VDD pmos W=0.325u L=0.04u
M16900 U5411/net30 g820 VDD VDD pmos W=0.205u L=0.04u
M16901 U5412/net19 n4179 VSS VSS nmos W=0.155u L=0.04u
M16902 n3088 n4179 U5412/net40 VSS nmos W=0.155u L=0.04u
M16903 n3088 U5412/net19 U5412/net36 VSS nmos W=0.155u L=0.04u
M16904 U5412/net40 n4964 VSS VSS nmos W=0.31u L=0.04u
M16905 U5412/net36 g830 VSS VSS nmos W=0.155u L=0.04u
M16906 U5412/net19 n4179 VDD VDD pmos W=0.205u L=0.04u
M16907 n3088 U5412/net19 U5412/net26 VDD pmos W=0.325u L=0.04u
M16908 U5412/net26 n4964 VDD VDD pmos W=0.41u L=0.04u
M16909 n3088 n4179 U5412/net30 VDD pmos W=0.325u L=0.04u
M16910 U5412/net30 g830 VDD VDD pmos W=0.205u L=0.04u
M16911 U5413/net19 n4176 VSS VSS nmos W=0.155u L=0.04u
M16912 n3087 n4176 U5413/net40 VSS nmos W=0.155u L=0.04u
M16913 n3087 U5413/net19 U5413/net36 VSS nmos W=0.155u L=0.04u
M16914 U5413/net40 n4964 VSS VSS nmos W=0.31u L=0.04u
M16915 U5413/net36 g831 VSS VSS nmos W=0.155u L=0.04u
M16916 U5413/net19 n4176 VDD VDD pmos W=0.205u L=0.04u
M16917 n3087 U5413/net19 U5413/net26 VDD pmos W=0.325u L=0.04u
M16918 U5413/net26 n4964 VDD VDD pmos W=0.41u L=0.04u
M16919 n3087 n4176 U5413/net30 VDD pmos W=0.325u L=0.04u
M16920 U5413/net30 g831 VDD VDD pmos W=0.205u L=0.04u
M16921 U5414/net19 n4177 VSS VSS nmos W=0.155u L=0.04u
M16922 n3086 n4177 U5414/net40 VSS nmos W=0.155u L=0.04u
M16923 n3086 U5414/net19 U5414/net36 VSS nmos W=0.155u L=0.04u
M16924 U5414/net40 n4964 VSS VSS nmos W=0.31u L=0.04u
M16925 U5414/net36 g829 VSS VSS nmos W=0.155u L=0.04u
M16926 U5414/net19 n4177 VDD VDD pmos W=0.205u L=0.04u
M16927 n3086 U5414/net19 U5414/net26 VDD pmos W=0.325u L=0.04u
M16928 U5414/net26 n4964 VDD VDD pmos W=0.41u L=0.04u
M16929 n3086 n4177 U5414/net30 VDD pmos W=0.325u L=0.04u
M16930 U5414/net30 g829 VDD VDD pmos W=0.205u L=0.04u
M16931 U5415/net19 n4179 VSS VSS nmos W=0.155u L=0.04u
M16932 n3085 n4179 U5415/net40 VSS nmos W=0.155u L=0.04u
M16933 n3085 U5415/net19 U5415/net36 VSS nmos W=0.155u L=0.04u
M16934 U5415/net40 n4965 VSS VSS nmos W=0.31u L=0.04u
M16935 U5415/net36 g833 VSS VSS nmos W=0.155u L=0.04u
M16936 U5415/net19 n4179 VDD VDD pmos W=0.205u L=0.04u
M16937 n3085 U5415/net19 U5415/net26 VDD pmos W=0.325u L=0.04u
M16938 U5415/net26 n4965 VDD VDD pmos W=0.41u L=0.04u
M16939 n3085 n4179 U5415/net30 VDD pmos W=0.325u L=0.04u
M16940 U5415/net30 g833 VDD VDD pmos W=0.205u L=0.04u
M16941 U5416/net19 n4176 VSS VSS nmos W=0.155u L=0.04u
M16942 n3084 n4176 U5416/net40 VSS nmos W=0.155u L=0.04u
M16943 n3084 U5416/net19 U5416/net36 VSS nmos W=0.155u L=0.04u
M16944 U5416/net40 n4965 VSS VSS nmos W=0.31u L=0.04u
M16945 U5416/net36 g834 VSS VSS nmos W=0.155u L=0.04u
M16946 U5416/net19 n4176 VDD VDD pmos W=0.205u L=0.04u
M16947 n3084 U5416/net19 U5416/net26 VDD pmos W=0.325u L=0.04u
M16948 U5416/net26 n4965 VDD VDD pmos W=0.41u L=0.04u
M16949 n3084 n4176 U5416/net30 VDD pmos W=0.325u L=0.04u
M16950 U5416/net30 g834 VDD VDD pmos W=0.205u L=0.04u
M16951 U5417/net19 n4177 VSS VSS nmos W=0.155u L=0.04u
M16952 n3083 n4177 U5417/net40 VSS nmos W=0.155u L=0.04u
M16953 n3083 U5417/net19 U5417/net36 VSS nmos W=0.155u L=0.04u
M16954 U5417/net40 n4965 VSS VSS nmos W=0.31u L=0.04u
M16955 U5417/net36 g832 VSS VSS nmos W=0.155u L=0.04u
M16956 U5417/net19 n4177 VDD VDD pmos W=0.205u L=0.04u
M16957 n3083 U5417/net19 U5417/net26 VDD pmos W=0.325u L=0.04u
M16958 U5417/net26 n4965 VDD VDD pmos W=0.41u L=0.04u
M16959 n3083 n4177 U5417/net30 VDD pmos W=0.325u L=0.04u
M16960 U5417/net30 g832 VDD VDD pmos W=0.205u L=0.04u
M16961 U5418/net19 n4179 VSS VSS nmos W=0.155u L=0.04u
M16962 n3082 n4179 U5418/net40 VSS nmos W=0.155u L=0.04u
M16963 n3082 U5418/net19 U5418/net36 VSS nmos W=0.155u L=0.04u
M16964 U5418/net40 n4966 VSS VSS nmos W=0.31u L=0.04u
M16965 U5418/net36 g836 VSS VSS nmos W=0.155u L=0.04u
M16966 U5418/net19 n4179 VDD VDD pmos W=0.205u L=0.04u
M16967 n3082 U5418/net19 U5418/net26 VDD pmos W=0.325u L=0.04u
M16968 U5418/net26 n4966 VDD VDD pmos W=0.41u L=0.04u
M16969 n3082 n4179 U5418/net30 VDD pmos W=0.325u L=0.04u
M16970 U5418/net30 g836 VDD VDD pmos W=0.205u L=0.04u
M16971 U5419/net19 n4176 VSS VSS nmos W=0.155u L=0.04u
M16972 n3081 n4176 U5419/net40 VSS nmos W=0.155u L=0.04u
M16973 n3081 U5419/net19 U5419/net36 VSS nmos W=0.155u L=0.04u
M16974 U5419/net40 n4966 VSS VSS nmos W=0.31u L=0.04u
M16975 U5419/net36 g837 VSS VSS nmos W=0.155u L=0.04u
M16976 U5419/net19 n4176 VDD VDD pmos W=0.205u L=0.04u
M16977 n3081 U5419/net19 U5419/net26 VDD pmos W=0.325u L=0.04u
M16978 U5419/net26 n4966 VDD VDD pmos W=0.41u L=0.04u
M16979 n3081 n4176 U5419/net30 VDD pmos W=0.325u L=0.04u
M16980 U5419/net30 g837 VDD VDD pmos W=0.205u L=0.04u
M16981 U5420/net19 n4177 VSS VSS nmos W=0.155u L=0.04u
M16982 n3080 n4177 U5420/net40 VSS nmos W=0.155u L=0.04u
M16983 n3080 U5420/net19 U5420/net36 VSS nmos W=0.155u L=0.04u
M16984 U5420/net40 n4966 VSS VSS nmos W=0.31u L=0.04u
M16985 U5420/net36 g835 VSS VSS nmos W=0.155u L=0.04u
M16986 U5420/net19 n4177 VDD VDD pmos W=0.205u L=0.04u
M16987 n3080 U5420/net19 U5420/net26 VDD pmos W=0.325u L=0.04u
M16988 U5420/net26 n4966 VDD VDD pmos W=0.41u L=0.04u
M16989 n3080 n4177 U5420/net30 VDD pmos W=0.325u L=0.04u
M16990 U5420/net30 g835 VDD VDD pmos W=0.205u L=0.04u
M16991 U5421/net19 n4179 VSS VSS nmos W=0.155u L=0.04u
M16992 n3079 n4179 U5421/net40 VSS nmos W=0.155u L=0.04u
M16993 n3079 U5421/net19 U5421/net36 VSS nmos W=0.155u L=0.04u
M16994 U5421/net40 n4967 VSS VSS nmos W=0.31u L=0.04u
M16995 U5421/net36 g839 VSS VSS nmos W=0.155u L=0.04u
M16996 U5421/net19 n4179 VDD VDD pmos W=0.205u L=0.04u
M16997 n3079 U5421/net19 U5421/net26 VDD pmos W=0.325u L=0.04u
M16998 U5421/net26 n4967 VDD VDD pmos W=0.41u L=0.04u
M16999 n3079 n4179 U5421/net30 VDD pmos W=0.325u L=0.04u
M17000 U5421/net30 g839 VDD VDD pmos W=0.205u L=0.04u
M17001 U5422/net19 n4176 VSS VSS nmos W=0.155u L=0.04u
M17002 n3078 n4176 U5422/net40 VSS nmos W=0.155u L=0.04u
M17003 n3078 U5422/net19 U5422/net36 VSS nmos W=0.155u L=0.04u
M17004 U5422/net40 n4967 VSS VSS nmos W=0.31u L=0.04u
M17005 U5422/net36 g840 VSS VSS nmos W=0.155u L=0.04u
M17006 U5422/net19 n4176 VDD VDD pmos W=0.205u L=0.04u
M17007 n3078 U5422/net19 U5422/net26 VDD pmos W=0.325u L=0.04u
M17008 U5422/net26 n4967 VDD VDD pmos W=0.41u L=0.04u
M17009 n3078 n4176 U5422/net30 VDD pmos W=0.325u L=0.04u
M17010 U5422/net30 g840 VDD VDD pmos W=0.205u L=0.04u
M17011 U5423/net19 n4177 VSS VSS nmos W=0.155u L=0.04u
M17012 n3077 n4177 U5423/net40 VSS nmos W=0.155u L=0.04u
M17013 n3077 U5423/net19 U5423/net36 VSS nmos W=0.155u L=0.04u
M17014 U5423/net40 n4967 VSS VSS nmos W=0.31u L=0.04u
M17015 U5423/net36 g838 VSS VSS nmos W=0.155u L=0.04u
M17016 U5423/net19 n4177 VDD VDD pmos W=0.205u L=0.04u
M17017 n3077 U5423/net19 U5423/net26 VDD pmos W=0.325u L=0.04u
M17018 U5423/net26 n4967 VDD VDD pmos W=0.41u L=0.04u
M17019 n3077 n4177 U5423/net30 VDD pmos W=0.325u L=0.04u
M17020 U5423/net30 g838 VDD VDD pmos W=0.205u L=0.04u
M17021 U5424/net19 n4179 VSS VSS nmos W=0.155u L=0.04u
M17022 n3076 n4179 U5424/net40 VSS nmos W=0.155u L=0.04u
M17023 n3076 U5424/net19 U5424/net36 VSS nmos W=0.155u L=0.04u
M17024 U5424/net40 n4968 VSS VSS nmos W=0.31u L=0.04u
M17025 U5424/net36 g842 VSS VSS nmos W=0.155u L=0.04u
M17026 U5424/net19 n4179 VDD VDD pmos W=0.205u L=0.04u
M17027 n3076 U5424/net19 U5424/net26 VDD pmos W=0.325u L=0.04u
M17028 U5424/net26 n4968 VDD VDD pmos W=0.41u L=0.04u
M17029 n3076 n4179 U5424/net30 VDD pmos W=0.325u L=0.04u
M17030 U5424/net30 g842 VDD VDD pmos W=0.205u L=0.04u
M17031 U5425/net19 n4176 VSS VSS nmos W=0.155u L=0.04u
M17032 n3075 n4176 U5425/net40 VSS nmos W=0.155u L=0.04u
M17033 n3075 U5425/net19 U5425/net36 VSS nmos W=0.155u L=0.04u
M17034 U5425/net40 n4968 VSS VSS nmos W=0.31u L=0.04u
M17035 U5425/net36 g843 VSS VSS nmos W=0.155u L=0.04u
M17036 U5425/net19 n4176 VDD VDD pmos W=0.205u L=0.04u
M17037 n3075 U5425/net19 U5425/net26 VDD pmos W=0.325u L=0.04u
M17038 U5425/net26 n4968 VDD VDD pmos W=0.41u L=0.04u
M17039 n3075 n4176 U5425/net30 VDD pmos W=0.325u L=0.04u
M17040 U5425/net30 g843 VDD VDD pmos W=0.205u L=0.04u
M17041 U5426/net19 n4177 VSS VSS nmos W=0.155u L=0.04u
M17042 n3074 n4177 U5426/net40 VSS nmos W=0.155u L=0.04u
M17043 n3074 U5426/net19 U5426/net36 VSS nmos W=0.155u L=0.04u
M17044 U5426/net40 n4968 VSS VSS nmos W=0.31u L=0.04u
M17045 U5426/net36 g841 VSS VSS nmos W=0.155u L=0.04u
M17046 U5426/net19 n4177 VDD VDD pmos W=0.205u L=0.04u
M17047 n3074 U5426/net19 U5426/net26 VDD pmos W=0.325u L=0.04u
M17048 U5426/net26 n4968 VDD VDD pmos W=0.41u L=0.04u
M17049 n3074 n4177 U5426/net30 VDD pmos W=0.325u L=0.04u
M17050 U5426/net30 g841 VDD VDD pmos W=0.205u L=0.04u
M17051 U5427/net19 n4970 VSS VSS nmos W=0.155u L=0.04u
M17052 n3073 n4970 U5427/net40 VSS nmos W=0.155u L=0.04u
M17053 n3073 U5427/net19 U5427/net36 VSS nmos W=0.155u L=0.04u
M17054 U5427/net40 g1116 VSS VSS nmos W=0.31u L=0.04u
M17055 U5427/net36 n4969 VSS VSS nmos W=0.155u L=0.04u
M17056 U5427/net19 n4970 VDD VDD pmos W=0.205u L=0.04u
M17057 n3073 U5427/net19 U5427/net26 VDD pmos W=0.325u L=0.04u
M17058 U5427/net26 g1116 VDD VDD pmos W=0.41u L=0.04u
M17059 n3073 n4970 U5427/net30 VDD pmos W=0.325u L=0.04u
M17060 U5427/net30 n4969 VDD VDD pmos W=0.205u L=0.04u
M17061 U5428/net19 n4333 VSS VSS nmos W=0.155u L=0.04u
M17062 n3072 n4333 U5428/net40 VSS nmos W=0.155u L=0.04u
M17063 n3072 U5428/net19 U5428/net36 VSS nmos W=0.155u L=0.04u
M17064 U5428/net40 g1119 VSS VSS nmos W=0.31u L=0.04u
M17065 U5428/net36 n4969 VSS VSS nmos W=0.155u L=0.04u
M17066 U5428/net19 n4333 VDD VDD pmos W=0.205u L=0.04u
M17067 n3072 U5428/net19 U5428/net26 VDD pmos W=0.325u L=0.04u
M17068 U5428/net26 g1119 VDD VDD pmos W=0.41u L=0.04u
M17069 n3072 n4333 U5428/net30 VDD pmos W=0.325u L=0.04u
M17070 U5428/net30 n4969 VDD VDD pmos W=0.205u L=0.04u
M17071 U5429/net19 n4971 VSS VSS nmos W=0.155u L=0.04u
M17072 n3071 n4971 U5429/net40 VSS nmos W=0.155u L=0.04u
M17073 n3071 U5429/net19 U5429/net36 VSS nmos W=0.155u L=0.04u
M17074 U5429/net40 g1122 VSS VSS nmos W=0.31u L=0.04u
M17075 U5429/net36 n4969 VSS VSS nmos W=0.155u L=0.04u
M17076 U5429/net19 n4971 VDD VDD pmos W=0.205u L=0.04u
M17077 n3071 U5429/net19 U5429/net26 VDD pmos W=0.325u L=0.04u
M17078 U5429/net26 g1122 VDD VDD pmos W=0.41u L=0.04u
M17079 n3071 n4971 U5429/net30 VDD pmos W=0.325u L=0.04u
M17080 U5429/net30 n4969 VDD VDD pmos W=0.205u L=0.04u
M17081 U5430/net19 g996 VSS VSS nmos W=0.155u L=0.04u
M17082 n4969 g996 U5430/net40 VSS nmos W=0.155u L=0.04u
M17083 n4969 U5430/net19 U5430/net36 VSS nmos W=0.155u L=0.04u
M17084 U5430/net40 n4973 VSS VSS nmos W=0.31u L=0.04u
M17085 U5430/net36 n4972 VSS VSS nmos W=0.155u L=0.04u
M17086 U5430/net19 g996 VDD VDD pmos W=0.205u L=0.04u
M17087 n4969 U5430/net19 U5430/net26 VDD pmos W=0.325u L=0.04u
M17088 U5430/net26 n4973 VDD VDD pmos W=0.41u L=0.04u
M17089 n4969 g996 U5430/net30 VDD pmos W=0.325u L=0.04u
M17090 U5430/net30 n4972 VDD VDD pmos W=0.205u L=0.04u
M17091 U5431/net19 n4970 VSS VSS nmos W=0.155u L=0.04u
M17092 n3070 n4970 U5431/net40 VSS nmos W=0.155u L=0.04u
M17093 n3070 U5431/net19 U5431/net36 VSS nmos W=0.155u L=0.04u
M17094 U5431/net40 g1125 VSS VSS nmos W=0.31u L=0.04u
M17095 U5431/net36 n4974 VSS VSS nmos W=0.155u L=0.04u
M17096 U5431/net19 n4970 VDD VDD pmos W=0.205u L=0.04u
M17097 n3070 U5431/net19 U5431/net26 VDD pmos W=0.325u L=0.04u
M17098 U5431/net26 g1125 VDD VDD pmos W=0.41u L=0.04u
M17099 n3070 n4970 U5431/net30 VDD pmos W=0.325u L=0.04u
M17100 U5431/net30 n4974 VDD VDD pmos W=0.205u L=0.04u
M17101 U5432/net19 n4333 VSS VSS nmos W=0.155u L=0.04u
M17102 n3069 n4333 U5432/net40 VSS nmos W=0.155u L=0.04u
M17103 n3069 U5432/net19 U5432/net36 VSS nmos W=0.155u L=0.04u
M17104 U5432/net40 g1128 VSS VSS nmos W=0.31u L=0.04u
M17105 U5432/net36 n4974 VSS VSS nmos W=0.155u L=0.04u
M17106 U5432/net19 n4333 VDD VDD pmos W=0.205u L=0.04u
M17107 n3069 U5432/net19 U5432/net26 VDD pmos W=0.325u L=0.04u
M17108 U5432/net26 g1128 VDD VDD pmos W=0.41u L=0.04u
M17109 n3069 n4333 U5432/net30 VDD pmos W=0.325u L=0.04u
M17110 U5432/net30 n4974 VDD VDD pmos W=0.205u L=0.04u
M17111 U5433/net19 n4971 VSS VSS nmos W=0.155u L=0.04u
M17112 n3068 n4971 U5433/net40 VSS nmos W=0.155u L=0.04u
M17113 n3068 U5433/net19 U5433/net36 VSS nmos W=0.155u L=0.04u
M17114 U5433/net40 g1131 VSS VSS nmos W=0.31u L=0.04u
M17115 U5433/net36 n4974 VSS VSS nmos W=0.155u L=0.04u
M17116 U5433/net19 n4971 VDD VDD pmos W=0.205u L=0.04u
M17117 n3068 U5433/net19 U5433/net26 VDD pmos W=0.325u L=0.04u
M17118 U5433/net26 g1131 VDD VDD pmos W=0.41u L=0.04u
M17119 n3068 n4971 U5433/net30 VDD pmos W=0.325u L=0.04u
M17120 U5433/net30 n4974 VDD VDD pmos W=0.205u L=0.04u
M17121 U5434/net4 n4975 U5434/net14 VSS nmos W=0.155u L=0.04u
M17122 U5434/net6 U5434/net10 U5434/net14 VSS nmos W=0.17u L=0.04u
M17123 U5434/net4 n4976 VSS VSS nmos W=0.155u L=0.04u
M17124 U5434/net6 U5434/net4 VSS VSS nmos W=0.17u L=0.04u
M17125 n4974 U5434/net14 VSS VSS nmos W=0.155u L=0.04u
M17126 U5434/net10 n4975 VSS VSS nmos W=0.155u L=0.04u
M17127 U5434/net4 U5434/net10 U5434/net14 VDD pmos W=0.255u L=0.04u
M17128 U5434/net6 n4975 U5434/net14 VDD pmos W=0.28u L=0.04u
M17129 U5434/net4 n4976 VDD VDD pmos W=0.205u L=0.04u
M17130 U5434/net6 U5434/net4 VDD VDD pmos W=0.24u L=0.04u
M17131 n4974 U5434/net14 VDD VDD pmos W=0.205u L=0.04u
M17132 U5434/net10 n4975 VDD VDD pmos W=0.205u L=0.04u
M17133 n4975 n4979 VSS VSS nmos W=0.155u L=0.04u
M17134 n4975 n4978 VSS VSS nmos W=0.155u L=0.04u
M17135 n4975 n4977 VSS VSS nmos W=0.155u L=0.04u
M17136 U5435/net25 n4979 VDD VDD pmos W=0.41u L=0.04u
M17137 U5435/net28 n4978 U5435/net25 VDD pmos W=0.41u L=0.04u
M17138 n4975 n4977 U5435/net28 VDD pmos W=0.41u L=0.04u
M17139 n3067 n4971 U5436/net10 VSS nmos W=0.155u L=0.04u
M17140 U5436/net10 n4981 VSS VSS nmos W=0.155u L=0.04u
M17141 n3067 n4980 U5436/net10 VSS nmos W=0.155u L=0.04u
M17142 U5436/net10 g1134 VSS VSS nmos W=0.155u L=0.04u
M17143 U5436/net30 n4981 VDD VDD pmos W=0.205u L=0.04u
M17144 n3067 n4971 U5436/net24 VDD pmos W=0.205u L=0.04u
M17145 U5436/net24 n4980 VDD VDD pmos W=0.205u L=0.04u
M17146 n3067 g1134 U5436/net30 VDD pmos W=0.205u L=0.04u
M17147 n4981 n4971 VSS VSS nmos W=0.155u L=0.04u
M17148 n4981 n4982 VSS VSS nmos W=0.155u L=0.04u
M17149 U5437/XI1-net8 n4982 VDD VDD pmos W=0.205u L=0.04u
M17150 n4981 n4971 U5437/XI1-net8 VDD pmos W=0.205u L=0.04u
M17151 n3066 n4333 U5438/net10 VSS nmos W=0.155u L=0.04u
M17152 U5438/net10 n4983 VSS VSS nmos W=0.155u L=0.04u
M17153 n3066 n4980 U5438/net10 VSS nmos W=0.155u L=0.04u
M17154 U5438/net10 g1136 VSS VSS nmos W=0.155u L=0.04u
M17155 U5438/net30 n4983 VDD VDD pmos W=0.205u L=0.04u
M17156 n3066 n4333 U5438/net24 VDD pmos W=0.205u L=0.04u
M17157 U5438/net24 n4980 VDD VDD pmos W=0.205u L=0.04u
M17158 n3066 g1136 U5438/net30 VDD pmos W=0.205u L=0.04u
M17159 n4983 n4333 VSS VSS nmos W=0.155u L=0.04u
M17160 n4983 n4982 VSS VSS nmos W=0.155u L=0.04u
M17161 U5439/XI1-net8 n4982 VDD VDD pmos W=0.205u L=0.04u
M17162 n4983 n4333 U5439/XI1-net8 VDD pmos W=0.205u L=0.04u
M17163 n3065 n4970 U5440/net10 VSS nmos W=0.155u L=0.04u
M17164 U5440/net10 n4984 VSS VSS nmos W=0.155u L=0.04u
M17165 n3065 n4980 U5440/net10 VSS nmos W=0.155u L=0.04u
M17166 U5440/net10 g1135 VSS VSS nmos W=0.155u L=0.04u
M17167 U5440/net30 n4984 VDD VDD pmos W=0.205u L=0.04u
M17168 n3065 n4970 U5440/net24 VDD pmos W=0.205u L=0.04u
M17169 U5440/net24 n4980 VDD VDD pmos W=0.205u L=0.04u
M17170 n3065 g1135 U5440/net30 VDD pmos W=0.205u L=0.04u
M17171 n4984 n4970 VSS VSS nmos W=0.155u L=0.04u
M17172 n4984 n4982 VSS VSS nmos W=0.155u L=0.04u
M17173 U5441/XI1-net8 n4982 VDD VDD pmos W=0.205u L=0.04u
M17174 n4984 n4970 U5441/XI1-net8 VDD pmos W=0.205u L=0.04u
M17175 U5442/net36 g996 U5442/net24 VSS nmos W=0.155u L=0.04u
M17176 U5442/net24 n4985 VSS VSS nmos W=0.155u L=0.04u
M17177 n4982 n4972 U5442/net36 VSS nmos W=0.155u L=0.04u
M17178 n4982 n4973 U5442/net36 VSS nmos W=0.155u L=0.04u
M17179 n4982 n4973 U5442/net35 VDD pmos W=0.205u L=0.04u
M17180 U5442/net35 n4972 VDD VDD pmos W=0.205u L=0.04u
M17181 n4982 n4985 VDD VDD pmos W=0.205u L=0.04u
M17182 n4982 g996 VDD VDD pmos W=0.205u L=0.04u
M17183 U5443/net19 n4174 VSS VSS nmos W=0.155u L=0.04u
M17184 n4985 n4174 U5443/net40 VSS nmos W=0.155u L=0.04u
M17185 n4985 U5443/net19 U5443/net36 VSS nmos W=0.155u L=0.04u
M17186 U5443/net40 n4972 VSS VSS nmos W=0.31u L=0.04u
M17187 U5443/net36 n4973 VSS VSS nmos W=0.155u L=0.04u
M17188 U5443/net19 n4174 VDD VDD pmos W=0.205u L=0.04u
M17189 n4985 U5443/net19 U5443/net26 VDD pmos W=0.325u L=0.04u
M17190 U5443/net26 n4972 VDD VDD pmos W=0.41u L=0.04u
M17191 n4985 n4174 U5443/net30 VDD pmos W=0.325u L=0.04u
M17192 U5443/net30 n4973 VDD VDD pmos W=0.205u L=0.04u
M17193 n4174 n4976 VSS VSS nmos W=0.135u L=0.04u
M17194 n4174 n4976 VDD VDD pmos W=0.205u L=0.04u
M17195 U5445/net30 n4977 VSS VSS nmos W=0.155u L=0.04u
M17196 n4980 n4978 U5445/net23 VSS nmos W=0.155u L=0.04u
M17197 U5445/net20 U5445/net30 VSS VSS nmos W=0.155u L=0.04u
M17198 U5445/net23 g996 U5445/net20 VSS nmos W=0.155u L=0.04u
M17199 U5445/net30 n4977 VDD VDD pmos W=0.205u L=0.04u
M17200 VDD n4978 n4980 VDD pmos W=0.205u L=0.04u
M17201 VDD g996 n4980 VDD pmos W=0.205u L=0.04u
M17202 VDD U5445/net30 n4980 VDD pmos W=0.205u L=0.04u
M17203 U5446/net36 n4970 U5446/net27 VSS nmos W=0.155u L=0.04u
M17204 U5446/net39 n4333 VSS VSS nmos W=0.155u L=0.04u
M17205 U5446/net27 g1134 U5446/net39 VSS nmos W=0.155u L=0.04u
M17206 U5446/net27 n4971 U5446/net39 VSS nmos W=0.155u L=0.04u
M17207 U5446/net36 g1135 U5446/net27 VSS nmos W=0.155u L=0.04u
M17208 U5446/net39 g1136 VSS VSS nmos W=0.155u L=0.04u
M17209 n4978 U5446/net36 VSS VSS nmos W=0.155u L=0.04u
M17210 n4978 U5446/net36 VDD VDD pmos W=0.205u L=0.04u
M17211 U5446/net36 n4333 U5446/net46 VDD pmos W=0.205u L=0.04u
M17212 U5446/net46 g1136 VDD VDD pmos W=0.205u L=0.04u
M17213 U5446/net36 g1135 U5446/net34 VDD pmos W=0.205u L=0.04u
M17214 U5446/net34 n4970 VDD VDD pmos W=0.205u L=0.04u
M17215 U5446/net36 n4971 U5446/net37 VDD pmos W=0.205u L=0.04u
M17216 U5446/net37 g1134 VDD VDD pmos W=0.205u L=0.04u
M17217 n4977 n4976 U5447/net15 VSS nmos W=0.155u L=0.04u
M17218 n4977 n4972 U5447/net15 VSS nmos W=0.155u L=0.04u
M17219 U5447/net15 n4986 VSS VSS nmos W=0.155u L=0.04u
M17220 n4977 n4986 VDD VDD pmos W=0.205u L=0.04u
M17221 n4977 n4976 U5447/XI16-net11 VDD pmos W=0.205u L=0.04u
M17222 U5447/XI16-net11 n4972 VDD VDD pmos W=0.205u L=0.04u
M17223 U5448/net19 n4973 VSS VSS nmos W=0.155u L=0.04u
M17224 n4986 n4973 U5448/net40 VSS nmos W=0.155u L=0.04u
M17225 n4986 U5448/net19 U5448/net36 VSS nmos W=0.155u L=0.04u
M17226 U5448/net40 n4976 VSS VSS nmos W=0.31u L=0.04u
M17227 U5448/net36 n4972 VSS VSS nmos W=0.155u L=0.04u
M17228 U5448/net19 n4973 VDD VDD pmos W=0.205u L=0.04u
M17229 n4986 U5448/net19 U5448/net26 VDD pmos W=0.325u L=0.04u
M17230 U5448/net26 n4976 VDD VDD pmos W=0.41u L=0.04u
M17231 n4986 n4973 U5448/net30 VDD pmos W=0.325u L=0.04u
M17232 U5448/net30 n4972 VDD VDD pmos W=0.205u L=0.04u
M17233 U5449/net13 n4987 VSS VSS nmos W=0.155u L=0.04u
M17234 U5449/net16 U5449/net13 VSS VSS nmos W=0.155u L=0.04u
M17235 n4973 n4988 U5449/net16 VSS nmos W=0.155u L=0.04u
M17236 U5449/net13 n4987 VDD VDD pmos W=0.205u L=0.04u
M17237 VDD U5449/net13 n4973 VDD pmos W=0.205u L=0.04u
M17238 VDD n4988 n4973 VDD pmos W=0.205u L=0.04u
M17239 n4988 n4989 U5450/net27 VSS nmos W=0.155u L=0.04u
M17240 U5450/net39 n4991 VSS VSS nmos W=0.155u L=0.04u
M17241 U5450/net27 g866 U5450/net39 VSS nmos W=0.155u L=0.04u
M17242 U5450/net27 n4990 U5450/net39 VSS nmos W=0.155u L=0.04u
M17243 n4988 g867 U5450/net27 VSS nmos W=0.155u L=0.04u
M17244 U5450/net39 g865 VSS VSS nmos W=0.155u L=0.04u
M17245 n4988 n4991 U5450/net46 VDD pmos W=0.205u L=0.04u
M17246 U5450/net46 g865 VDD VDD pmos W=0.205u L=0.04u
M17247 n4988 g867 U5450/net34 VDD pmos W=0.205u L=0.04u
M17248 U5450/net34 n4989 VDD VDD pmos W=0.205u L=0.04u
M17249 n4988 n4990 U5450/net37 VDD pmos W=0.205u L=0.04u
M17250 U5450/net37 g866 VDD VDD pmos W=0.205u L=0.04u
M17251 n4972 g1088 U5451/XI21-net17 VSS nmos W=0.155u L=0.04u
M17252 U5451/XI21-net17 g1122 VSS VSS nmos W=0.155u L=0.04u
M17253 n4972 g5472 U5451/XI6-net17 VSS nmos W=0.155u L=0.04u
M17254 U5451/XI6-net17 g1116 VSS VSS nmos W=0.155u L=0.04u
M17255 n4972 g6712 U5451/XI20-net17 VSS nmos W=0.155u L=0.04u
M17256 U5451/XI20-net17 g1119 VSS VSS nmos W=0.155u L=0.04u
M17257 VDD g1088 U5451/net22 VDD pmos W=0.205u L=0.04u
M17258 VDD g1122 U5451/net22 VDD pmos W=0.205u L=0.04u
M17259 U5451/net16 g5472 n4972 VDD pmos W=0.205u L=0.04u
M17260 U5451/net16 g1116 n4972 VDD pmos W=0.205u L=0.04u
M17261 U5451/net22 g6712 U5451/net16 VDD pmos W=0.205u L=0.04u
M17262 U5451/net22 g1119 U5451/net16 VDD pmos W=0.205u L=0.04u
M17263 n4976 g1088 U5452/XI21-net17 VSS nmos W=0.155u L=0.04u
M17264 U5452/XI21-net17 g1131 VSS VSS nmos W=0.155u L=0.04u
M17265 n4976 g5472 U5452/XI6-net17 VSS nmos W=0.155u L=0.04u
M17266 U5452/XI6-net17 g1125 VSS VSS nmos W=0.155u L=0.04u
M17267 n4976 g6712 U5452/XI20-net17 VSS nmos W=0.155u L=0.04u
M17268 U5452/XI20-net17 g1128 VSS VSS nmos W=0.155u L=0.04u
M17269 VDD g1088 U5452/net22 VDD pmos W=0.205u L=0.04u
M17270 VDD g1131 U5452/net22 VDD pmos W=0.205u L=0.04u
M17271 U5452/net16 g5472 n4976 VDD pmos W=0.205u L=0.04u
M17272 U5452/net16 g1125 n4976 VDD pmos W=0.205u L=0.04u
M17273 U5452/net22 g6712 U5452/net16 VDD pmos W=0.205u L=0.04u
M17274 U5452/net22 g1128 U5452/net16 VDD pmos W=0.205u L=0.04u
M17275 U5453/net19 n4970 VSS VSS nmos W=0.155u L=0.04u
M17276 n3064 n4970 U5453/net40 VSS nmos W=0.155u L=0.04u
M17277 n3064 U5453/net19 U5453/net36 VSS nmos W=0.155u L=0.04u
M17278 U5453/net40 g1104 VSS VSS nmos W=0.31u L=0.04u
M17279 U5453/net36 n4992 VSS VSS nmos W=0.155u L=0.04u
M17280 U5453/net19 n4970 VDD VDD pmos W=0.205u L=0.04u
M17281 n3064 U5453/net19 U5453/net26 VDD pmos W=0.325u L=0.04u
M17282 U5453/net26 g1104 VDD VDD pmos W=0.41u L=0.04u
M17283 n3064 n4970 U5453/net30 VDD pmos W=0.325u L=0.04u
M17284 U5453/net30 n4992 VDD VDD pmos W=0.205u L=0.04u
M17285 U5454/net19 n4333 VSS VSS nmos W=0.155u L=0.04u
M17286 n3063 n4333 U5454/net40 VSS nmos W=0.155u L=0.04u
M17287 n3063 U5454/net19 U5454/net36 VSS nmos W=0.155u L=0.04u
M17288 U5454/net40 g1107 VSS VSS nmos W=0.31u L=0.04u
M17289 U5454/net36 n4992 VSS VSS nmos W=0.155u L=0.04u
M17290 U5454/net19 n4333 VDD VDD pmos W=0.205u L=0.04u
M17291 n3063 U5454/net19 U5454/net26 VDD pmos W=0.325u L=0.04u
M17292 U5454/net26 g1107 VDD VDD pmos W=0.41u L=0.04u
M17293 n3063 n4333 U5454/net30 VDD pmos W=0.325u L=0.04u
M17294 U5454/net30 n4992 VDD VDD pmos W=0.205u L=0.04u
M17295 U5455/net19 n4971 VSS VSS nmos W=0.155u L=0.04u
M17296 n3062 n4971 U5455/net40 VSS nmos W=0.155u L=0.04u
M17297 n3062 U5455/net19 U5455/net36 VSS nmos W=0.155u L=0.04u
M17298 U5455/net40 g1110 VSS VSS nmos W=0.31u L=0.04u
M17299 U5455/net36 n4992 VSS VSS nmos W=0.155u L=0.04u
M17300 U5455/net19 n4971 VDD VDD pmos W=0.205u L=0.04u
M17301 n3062 U5455/net19 U5455/net26 VDD pmos W=0.325u L=0.04u
M17302 U5455/net26 g1110 VDD VDD pmos W=0.41u L=0.04u
M17303 n3062 n4971 U5455/net30 VDD pmos W=0.325u L=0.04u
M17304 U5455/net30 n4992 VDD VDD pmos W=0.205u L=0.04u
M17305 U5456/net4 g11902 U5456/net14 VSS nmos W=0.155u L=0.04u
M17306 U5456/net6 U5456/net10 U5456/net14 VSS nmos W=0.17u L=0.04u
M17307 U5456/net4 n4993 VSS VSS nmos W=0.155u L=0.04u
M17308 U5456/net6 U5456/net4 VSS VSS nmos W=0.17u L=0.04u
M17309 n4992 U5456/net14 VSS VSS nmos W=0.155u L=0.04u
M17310 U5456/net10 g11902 VSS VSS nmos W=0.155u L=0.04u
M17311 U5456/net4 U5456/net10 U5456/net14 VDD pmos W=0.255u L=0.04u
M17312 U5456/net6 g11902 U5456/net14 VDD pmos W=0.28u L=0.04u
M17313 U5456/net4 n4993 VDD VDD pmos W=0.205u L=0.04u
M17314 U5456/net6 U5456/net4 VDD VDD pmos W=0.24u L=0.04u
M17315 n4992 U5456/net14 VDD VDD pmos W=0.205u L=0.04u
M17316 U5456/net10 g11902 VDD VDD pmos W=0.205u L=0.04u
M17317 n4993 n4994 U5457/net14 VSS nmos W=0.155u L=0.04u
M17318 U5457/net14 n4998 VSS VSS nmos W=0.155u L=0.04u
M17319 U5457/net14 n4997 VSS VSS nmos W=0.155u L=0.04u
M17320 n4993 n4996 U5457/net14 VSS nmos W=0.155u L=0.04u
M17321 n4993 n4995 U5457/net14 VSS nmos W=0.155u L=0.04u
M17322 n4993 n4998 U5457/XI16-net11 VDD pmos W=0.205u L=0.04u
M17323 U5457/XI16-net11 n4997 VDD VDD pmos W=0.205u L=0.04u
M17324 n4993 n4996 U5457/XI15-net11 VDD pmos W=0.205u L=0.04u
M17325 U5457/XI15-net11 n4995 U5457/XI15-net18 VDD pmos W=0.205u L=0.04u
M17326 U5457/XI15-net18 n4994 VDD VDD pmos W=0.205u L=0.04u
M17327 n4997 n4999 U5458/net23 VDD pmos W=0.205u L=0.04u
M17328 n4997 g11902 U5458/net23 VDD pmos W=0.205u L=0.04u
M17329 n4997 n5000 U5458/net23 VDD pmos W=0.205u L=0.04u
M17330 U5458/net23 n5001 VDD VDD pmos W=0.205u L=0.04u
M17331 U5458/net23 n5002 VDD VDD pmos W=0.205u L=0.04u
M17332 U5458/XI20-net13 g11902 VSS VSS nmos W=0.155u L=0.04u
M17333 n4997 n4999 U5458/XI20-net17 VSS nmos W=0.155u L=0.04u
M17334 U5458/XI20-net17 n5000 U5458/XI20-net13 VSS nmos W=0.155u L=0.04u
M17335 n4997 n5001 U5458/XI17-net17 VSS nmos W=0.155u L=0.04u
M17336 U5458/XI17-net17 n5002 VSS VSS nmos W=0.155u L=0.04u
M17337 n5000 U5459/net7 VSS VSS nmos W=0.155u L=0.04u
M17338 U5459/net7 n5002 VSS VSS nmos W=0.155u L=0.04u
M17339 U5459/net7 n5003 VSS VSS nmos W=0.155u L=0.04u
M17340 n5000 U5459/net7 VDD VDD pmos W=0.205u L=0.04u
M17341 U5459/X_u7-net8 n5003 VDD VDD pmos W=0.205u L=0.04u
M17342 U5459/net7 n5002 U5459/X_u7-net8 VDD pmos W=0.205u L=0.04u
M17343 n4996 g11902 VSS VSS nmos W=0.135u L=0.04u
M17344 n4996 g11902 VDD VDD pmos W=0.205u L=0.04u
M17345 U5461/XU1-net6 n5004 VSS VSS nmos W=0.155u L=0.04u
M17346 n4994 n4999 U5461/XU1-net6 VSS nmos W=0.155u L=0.04u
M17347 n4994 n5004 VDD VDD pmos W=0.155u L=0.04u
M17348 n4994 n4999 VDD VDD pmos W=0.155u L=0.04u
M17349 n3061 n4970 U5462/net10 VSS nmos W=0.155u L=0.04u
M17350 U5462/net10 n5006 VSS VSS nmos W=0.155u L=0.04u
M17351 n3061 n5005 U5462/net10 VSS nmos W=0.155u L=0.04u
M17352 U5462/net10 g1114 VSS VSS nmos W=0.155u L=0.04u
M17353 U5462/net30 n5006 VDD VDD pmos W=0.205u L=0.04u
M17354 n3061 n4970 U5462/net24 VDD pmos W=0.205u L=0.04u
M17355 U5462/net24 n5005 VDD VDD pmos W=0.205u L=0.04u
M17356 n3061 g1114 U5462/net30 VDD pmos W=0.205u L=0.04u
M17357 n5006 n4970 VSS VSS nmos W=0.155u L=0.04u
M17358 n5006 n5007 VSS VSS nmos W=0.155u L=0.04u
M17359 U5463/XI1-net8 n5007 VDD VDD pmos W=0.205u L=0.04u
M17360 n5006 n4970 U5463/XI1-net8 VDD pmos W=0.205u L=0.04u
M17361 n3060 n4333 U5464/net10 VSS nmos W=0.155u L=0.04u
M17362 U5464/net10 n5008 VSS VSS nmos W=0.155u L=0.04u
M17363 n3060 n5005 U5464/net10 VSS nmos W=0.155u L=0.04u
M17364 U5464/net10 g1115 VSS VSS nmos W=0.155u L=0.04u
M17365 U5464/net30 n5008 VDD VDD pmos W=0.205u L=0.04u
M17366 n3060 n4333 U5464/net24 VDD pmos W=0.205u L=0.04u
M17367 U5464/net24 n5005 VDD VDD pmos W=0.205u L=0.04u
M17368 n3060 g1115 U5464/net30 VDD pmos W=0.205u L=0.04u
M17369 n5008 n4333 VSS VSS nmos W=0.155u L=0.04u
M17370 n5008 n5007 VSS VSS nmos W=0.155u L=0.04u
M17371 U5465/XI1-net8 n5007 VDD VDD pmos W=0.205u L=0.04u
M17372 n5008 n4333 U5465/XI1-net8 VDD pmos W=0.205u L=0.04u
M17373 n3059 n4971 U5466/net10 VSS nmos W=0.155u L=0.04u
M17374 U5466/net10 n5009 VSS VSS nmos W=0.155u L=0.04u
M17375 n3059 n5005 U5466/net10 VSS nmos W=0.155u L=0.04u
M17376 U5466/net10 g1113 VSS VSS nmos W=0.155u L=0.04u
M17377 U5466/net30 n5009 VDD VDD pmos W=0.205u L=0.04u
M17378 n3059 n4971 U5466/net24 VDD pmos W=0.205u L=0.04u
M17379 U5466/net24 n5005 VDD VDD pmos W=0.205u L=0.04u
M17380 n3059 g1113 U5466/net30 VDD pmos W=0.205u L=0.04u
M17381 n5009 n4971 VSS VSS nmos W=0.155u L=0.04u
M17382 n5009 n5007 VSS VSS nmos W=0.155u L=0.04u
M17383 U5467/XI1-net8 n5007 VDD VDD pmos W=0.205u L=0.04u
M17384 n5009 n4971 U5467/XI1-net8 VDD pmos W=0.205u L=0.04u
M17385 U5468/net13 n4998 VSS VSS nmos W=0.155u L=0.04u
M17386 U5468/net16 U5468/net13 VSS VSS nmos W=0.155u L=0.04u
M17387 n5005 n5010 U5468/net16 VSS nmos W=0.155u L=0.04u
M17388 U5468/net13 n4998 VDD VDD pmos W=0.205u L=0.04u
M17389 VDD U5468/net13 n5005 VDD pmos W=0.205u L=0.04u
M17390 VDD n5010 n5005 VDD pmos W=0.205u L=0.04u
M17391 U5469/net19 n4970 VSS VSS nmos W=0.155u L=0.04u
M17392 n3058 n4970 U5469/net40 VSS nmos W=0.155u L=0.04u
M17393 n3058 U5469/net19 U5469/net36 VSS nmos W=0.155u L=0.04u
M17394 U5469/net40 g1095 VSS VSS nmos W=0.31u L=0.04u
M17395 U5469/net36 n5011 VSS VSS nmos W=0.155u L=0.04u
M17396 U5469/net19 n4970 VDD VDD pmos W=0.205u L=0.04u
M17397 n3058 U5469/net19 U5469/net26 VDD pmos W=0.325u L=0.04u
M17398 U5469/net26 g1095 VDD VDD pmos W=0.41u L=0.04u
M17399 n3058 n4970 U5469/net30 VDD pmos W=0.325u L=0.04u
M17400 U5469/net30 n5011 VDD VDD pmos W=0.205u L=0.04u
M17401 U5470/net19 n4333 VSS VSS nmos W=0.155u L=0.04u
M17402 n3057 n4333 U5470/net40 VSS nmos W=0.155u L=0.04u
M17403 n3057 U5470/net19 U5470/net36 VSS nmos W=0.155u L=0.04u
M17404 U5470/net40 g1098 VSS VSS nmos W=0.31u L=0.04u
M17405 U5470/net36 n5011 VSS VSS nmos W=0.155u L=0.04u
M17406 U5470/net19 n4333 VDD VDD pmos W=0.205u L=0.04u
M17407 n3057 U5470/net19 U5470/net26 VDD pmos W=0.325u L=0.04u
M17408 U5470/net26 g1098 VDD VDD pmos W=0.41u L=0.04u
M17409 n3057 n4333 U5470/net30 VDD pmos W=0.325u L=0.04u
M17410 U5470/net30 n5011 VDD VDD pmos W=0.205u L=0.04u
M17411 U5471/net19 n4971 VSS VSS nmos W=0.155u L=0.04u
M17412 n3056 n4971 U5471/net40 VSS nmos W=0.155u L=0.04u
M17413 n3056 U5471/net19 U5471/net36 VSS nmos W=0.155u L=0.04u
M17414 U5471/net40 g1101 VSS VSS nmos W=0.31u L=0.04u
M17415 U5471/net36 n5011 VSS VSS nmos W=0.155u L=0.04u
M17416 U5471/net19 n4971 VDD VDD pmos W=0.205u L=0.04u
M17417 n3056 U5471/net19 U5471/net26 VDD pmos W=0.325u L=0.04u
M17418 U5471/net26 g1101 VDD VDD pmos W=0.41u L=0.04u
M17419 n3056 n4971 U5471/net30 VDD pmos W=0.325u L=0.04u
M17420 U5471/net30 n5011 VDD VDD pmos W=0.205u L=0.04u
M17421 U5472/net4 n5012 U5472/net14 VSS nmos W=0.155u L=0.04u
M17422 U5472/net6 U5472/net10 U5472/net14 VSS nmos W=0.17u L=0.04u
M17423 U5472/net4 n5013 VSS VSS nmos W=0.155u L=0.04u
M17424 U5472/net6 U5472/net4 VSS VSS nmos W=0.17u L=0.04u
M17425 n5011 U5472/net14 VSS VSS nmos W=0.155u L=0.04u
M17426 U5472/net10 n5012 VSS VSS nmos W=0.155u L=0.04u
M17427 U5472/net4 U5472/net10 U5472/net14 VDD pmos W=0.255u L=0.04u
M17428 U5472/net6 n5012 U5472/net14 VDD pmos W=0.28u L=0.04u
M17429 U5472/net4 n5013 VDD VDD pmos W=0.205u L=0.04u
M17430 U5472/net6 U5472/net4 VDD VDD pmos W=0.24u L=0.04u
M17431 n5011 U5472/net14 VDD VDD pmos W=0.205u L=0.04u
M17432 U5472/net10 n5012 VDD VDD pmos W=0.205u L=0.04u
M17433 U5473/net14 n5010 U5473/net20 VSS nmos W=0.155u L=0.04u
M17434 U5473/net14 n4998 U5473/net20 VSS nmos W=0.155u L=0.04u
M17435 U5473/net20 n5007 VSS VSS nmos W=0.155u L=0.04u
M17436 n5012 U5473/net14 VSS VSS nmos W=0.155u L=0.04u
M17437 n5012 U5473/net14 VDD VDD pmos W=0.205u L=0.04u
M17438 U5473/net14 n5007 VDD VDD pmos W=0.205u L=0.04u
M17439 U5473/net24 n5010 VDD VDD pmos W=0.205u L=0.04u
M17440 U5473/net14 n4998 U5473/net24 VDD pmos W=0.205u L=0.04u
M17441 U5474/XU1-net6 n5014 VSS VSS nmos W=0.155u L=0.04u
M17442 n5007 n5004 U5474/XU1-net6 VSS nmos W=0.155u L=0.04u
M17443 n5007 n5014 VDD VDD pmos W=0.155u L=0.04u
M17444 n5007 n5004 VDD VDD pmos W=0.155u L=0.04u
M17445 n5004 n5013 VSS VSS nmos W=0.155u L=0.04u
M17446 n5004 n4979 VSS VSS nmos W=0.155u L=0.04u
M17447 U5475/XI1-net8 n4979 VDD VDD pmos W=0.205u L=0.04u
M17448 n5004 n5013 U5475/XI1-net8 VDD pmos W=0.205u L=0.04u
M17449 n5010 n5002 VSS VSS nmos W=0.155u L=0.04u
M17450 n5010 U5476/net4 VSS VSS nmos W=0.155u L=0.04u
M17451 U5476/net4 n5014 VSS VSS nmos W=0.155u L=0.04u
M17452 U5476/XU1-net8 U5476/net4 VDD VDD pmos W=0.205u L=0.04u
M17453 n5010 n5002 U5476/XU1-net8 VDD pmos W=0.205u L=0.04u
M17454 U5476/net4 n5014 VDD VDD pmos W=0.205u L=0.04u
M17455 n5002 n4970 U5477/net27 VSS nmos W=0.155u L=0.04u
M17456 U5477/net39 n4333 VSS VSS nmos W=0.155u L=0.04u
M17457 U5477/net27 g1113 U5477/net39 VSS nmos W=0.155u L=0.04u
M17458 U5477/net27 n4971 U5477/net39 VSS nmos W=0.155u L=0.04u
M17459 n5002 g1114 U5477/net27 VSS nmos W=0.155u L=0.04u
M17460 U5477/net39 g1115 VSS VSS nmos W=0.155u L=0.04u
M17461 n5002 n4333 U5477/net46 VDD pmos W=0.205u L=0.04u
M17462 U5477/net46 g1115 VDD VDD pmos W=0.205u L=0.04u
M17463 n5002 g1114 U5477/net34 VDD pmos W=0.205u L=0.04u
M17464 U5477/net34 n4970 VDD VDD pmos W=0.205u L=0.04u
M17465 n5002 n4971 U5477/net37 VDD pmos W=0.205u L=0.04u
M17466 U5477/net37 g1113 VDD VDD pmos W=0.205u L=0.04u
M17467 n5014 U5478/net26 VDD VDD pmos W=0.205u L=0.04u
M17468 U5478/net26 g11902 U5478/net19 VDD pmos W=0.205u L=0.04u
M17469 U5478/net26 n4995 U5478/net19 VDD pmos W=0.205u L=0.04u
M17470 U5478/net26 n4999 U5478/net19 VDD pmos W=0.205u L=0.04u
M17471 U5478/net19 n5001 VDD VDD pmos W=0.205u L=0.04u
M17472 U5478/net26 n5001 VSS VSS nmos W=0.155u L=0.04u
M17473 n5014 U5478/net26 VSS VSS nmos W=0.155u L=0.04u
M17474 U5478/XI20-net13 n4999 VSS VSS nmos W=0.155u L=0.04u
M17475 U5478/net26 g11902 U5478/XI20-net17 VSS nmos W=0.155u L=0.04u
M17476 U5478/XI20-net17 n4995 U5478/XI20-net13 VSS nmos W=0.155u L=0.04u
M17477 n5001 n4999 VSS VSS nmos W=0.155u L=0.04u
M17478 n5001 g11902 VSS VSS nmos W=0.155u L=0.04u
M17479 U5479/XI1-net8 g11902 VDD VDD pmos W=0.205u L=0.04u
M17480 n5001 n4999 U5479/XI1-net8 VDD pmos W=0.205u L=0.04u
M17481 n4999 n4987 VSS VSS nmos W=0.155u L=0.04u
M17482 n4999 n4175 VSS VSS nmos W=0.155u L=0.04u
M17483 n4999 n4178 VSS VSS nmos W=0.155u L=0.04u
M17484 U5480/net25 n4987 VDD VDD pmos W=0.41u L=0.04u
M17485 U5480/net28 n4175 U5480/net25 VDD pmos W=0.41u L=0.04u
M17486 n4999 n4178 U5480/net28 VDD pmos W=0.41u L=0.04u
M17487 n4175 n5015 VSS VSS nmos W=0.135u L=0.04u
M17488 n4175 n5015 VDD VDD pmos W=0.205u L=0.04u
M17489 U5482/XU1-net6 n5013 VSS VSS nmos W=0.155u L=0.04u
M17490 n4998 g996 U5482/XU1-net6 VSS nmos W=0.155u L=0.04u
M17491 n4998 n5013 VDD VDD pmos W=0.155u L=0.04u
M17492 n4998 g996 VDD VDD pmos W=0.155u L=0.04u
M17493 n5013 U5483/net39 VDD VDD pmos W=0.205u L=0.04u
M17494 VDD g1088 U5483/net22 VDD pmos W=0.205u L=0.04u
M17495 VDD g1101 U5483/net22 VDD pmos W=0.205u L=0.04u
M17496 U5483/net16 g5472 U5483/net39 VDD pmos W=0.205u L=0.04u
M17497 U5483/net16 g1095 U5483/net39 VDD pmos W=0.205u L=0.04u
M17498 U5483/net22 g6712 U5483/net16 VDD pmos W=0.205u L=0.04u
M17499 U5483/net22 g1098 U5483/net16 VDD pmos W=0.205u L=0.04u
M17500 n5013 U5483/net39 VSS VSS nmos W=0.155u L=0.04u
M17501 U5483/net39 g1088 U5483/XI22-net17 VSS nmos W=0.155u L=0.04u
M17502 U5483/XI22-net17 g1101 VSS VSS nmos W=0.155u L=0.04u
M17503 U5483/net39 g5472 U5483/XI6-net17 VSS nmos W=0.155u L=0.04u
M17504 U5483/XI6-net17 g1095 VSS VSS nmos W=0.155u L=0.04u
M17505 U5483/net39 g6712 U5483/XI21-net17 VSS nmos W=0.155u L=0.04u
M17506 U5483/XI21-net17 g1098 VSS VSS nmos W=0.155u L=0.04u
M17507 U5484/net19 n4179 VSS VSS nmos W=0.155u L=0.04u
M17508 n3055 n4179 U5484/net40 VSS nmos W=0.155u L=0.04u
M17509 n3055 U5484/net19 U5484/net36 VSS nmos W=0.155u L=0.04u
M17510 U5484/net40 n5016 VSS VSS nmos W=0.31u L=0.04u
M17511 U5484/net36 g845 VSS VSS nmos W=0.155u L=0.04u
M17512 U5484/net19 n4179 VDD VDD pmos W=0.205u L=0.04u
M17513 n3055 U5484/net19 U5484/net26 VDD pmos W=0.325u L=0.04u
M17514 U5484/net26 n5016 VDD VDD pmos W=0.41u L=0.04u
M17515 n3055 n4179 U5484/net30 VDD pmos W=0.325u L=0.04u
M17516 U5484/net30 g845 VDD VDD pmos W=0.205u L=0.04u
M17517 n4179 U5485/net6 VSS VSS nmos W=0.155u L=0.04u
M17518 U5485/X_u2-net6 g6368 VSS VSS nmos W=0.155u L=0.04u
M17519 U5485/net6 g869 U5485/X_u2-net6 VSS nmos W=0.155u L=0.04u
M17520 n4179 U5485/net6 VDD VDD pmos W=0.205u L=0.04u
M17521 U5485/net6 g6368 VDD VDD pmos W=0.205u L=0.04u
M17522 U5485/net6 g869 VDD VDD pmos W=0.205u L=0.04u
M17523 U5486/net19 n4176 VSS VSS nmos W=0.155u L=0.04u
M17524 n3054 n4176 U5486/net40 VSS nmos W=0.155u L=0.04u
M17525 n3054 U5486/net19 U5486/net36 VSS nmos W=0.155u L=0.04u
M17526 U5486/net40 n5016 VSS VSS nmos W=0.31u L=0.04u
M17527 U5486/net36 g846 VSS VSS nmos W=0.155u L=0.04u
M17528 U5486/net19 n4176 VDD VDD pmos W=0.205u L=0.04u
M17529 n3054 U5486/net19 U5486/net26 VDD pmos W=0.325u L=0.04u
M17530 U5486/net26 n5016 VDD VDD pmos W=0.41u L=0.04u
M17531 n3054 n4176 U5486/net30 VDD pmos W=0.325u L=0.04u
M17532 U5486/net30 g846 VDD VDD pmos W=0.205u L=0.04u
M17533 n4176 U5487/net6 VSS VSS nmos W=0.155u L=0.04u
M17534 U5487/X_u2-net6 g6518 VSS VSS nmos W=0.155u L=0.04u
M17535 U5487/net6 g869 U5487/X_u2-net6 VSS nmos W=0.155u L=0.04u
M17536 n4176 U5487/net6 VDD VDD pmos W=0.205u L=0.04u
M17537 U5487/net6 g6518 VDD VDD pmos W=0.205u L=0.04u
M17538 U5487/net6 g869 VDD VDD pmos W=0.205u L=0.04u
M17539 U5488/net19 n4177 VSS VSS nmos W=0.155u L=0.04u
M17540 n3053 n4177 U5488/net40 VSS nmos W=0.155u L=0.04u
M17541 n3053 U5488/net19 U5488/net36 VSS nmos W=0.155u L=0.04u
M17542 U5488/net40 n5016 VSS VSS nmos W=0.31u L=0.04u
M17543 U5488/net36 g844 VSS VSS nmos W=0.155u L=0.04u
M17544 U5488/net19 n4177 VDD VDD pmos W=0.205u L=0.04u
M17545 n3053 U5488/net19 U5488/net26 VDD pmos W=0.325u L=0.04u
M17546 U5488/net26 n5016 VDD VDD pmos W=0.41u L=0.04u
M17547 n3053 n4177 U5488/net30 VDD pmos W=0.325u L=0.04u
M17548 U5488/net30 g844 VDD VDD pmos W=0.205u L=0.04u
M17549 n3052 n4970 U5489/net10 VSS nmos W=0.155u L=0.04u
M17550 U5489/net10 n5018 VSS VSS nmos W=0.155u L=0.04u
M17551 n3052 n5017 U5489/net10 VSS nmos W=0.155u L=0.04u
M17552 U5489/net10 g1090 VSS VSS nmos W=0.155u L=0.04u
M17553 U5489/net30 n5018 VDD VDD pmos W=0.205u L=0.04u
M17554 n3052 n4970 U5489/net24 VDD pmos W=0.205u L=0.04u
M17555 U5489/net24 n5017 VDD VDD pmos W=0.205u L=0.04u
M17556 n3052 g1090 U5489/net30 VDD pmos W=0.205u L=0.04u
M17557 n5018 n4970 VSS VSS nmos W=0.155u L=0.04u
M17558 n5018 n4979 VSS VSS nmos W=0.155u L=0.04u
M17559 U5490/XI1-net8 n4979 VDD VDD pmos W=0.205u L=0.04u
M17560 n5018 n4970 U5490/XI1-net8 VDD pmos W=0.205u L=0.04u
M17561 n3051 n4333 U5491/net10 VSS nmos W=0.155u L=0.04u
M17562 U5491/net10 n5019 VSS VSS nmos W=0.155u L=0.04u
M17563 n3051 n5017 U5491/net10 VSS nmos W=0.155u L=0.04u
M17564 U5491/net10 g1091 VSS VSS nmos W=0.155u L=0.04u
M17565 U5491/net30 n5019 VDD VDD pmos W=0.205u L=0.04u
M17566 n3051 n4333 U5491/net24 VDD pmos W=0.205u L=0.04u
M17567 U5491/net24 n5017 VDD VDD pmos W=0.205u L=0.04u
M17568 n3051 g1091 U5491/net30 VDD pmos W=0.205u L=0.04u
M17569 n5019 n4333 VSS VSS nmos W=0.155u L=0.04u
M17570 n5019 n4979 VSS VSS nmos W=0.155u L=0.04u
M17571 U5492/XI1-net8 n4979 VDD VDD pmos W=0.205u L=0.04u
M17572 n5019 n4333 U5492/XI1-net8 VDD pmos W=0.205u L=0.04u
M17573 n3050 n4971 U5493/net10 VSS nmos W=0.155u L=0.04u
M17574 U5493/net10 n5020 VSS VSS nmos W=0.155u L=0.04u
M17575 n3050 n5017 U5493/net10 VSS nmos W=0.155u L=0.04u
M17576 U5493/net10 g1089 VSS VSS nmos W=0.155u L=0.04u
M17577 U5493/net30 n5020 VDD VDD pmos W=0.205u L=0.04u
M17578 n3050 n4971 U5493/net24 VDD pmos W=0.205u L=0.04u
M17579 U5493/net24 n5017 VDD VDD pmos W=0.205u L=0.04u
M17580 n3050 g1089 U5493/net30 VDD pmos W=0.205u L=0.04u
M17581 n5020 n4971 VSS VSS nmos W=0.155u L=0.04u
M17582 n5020 n4979 VSS VSS nmos W=0.155u L=0.04u
M17583 U5494/XI1-net8 n4979 VDD VDD pmos W=0.205u L=0.04u
M17584 n5020 n4971 U5494/XI1-net8 VDD pmos W=0.205u L=0.04u
M17585 U5495/net30 n5021 VSS VSS nmos W=0.155u L=0.04u
M17586 n5017 n5022 U5495/net23 VSS nmos W=0.155u L=0.04u
M17587 U5495/net20 U5495/net30 VSS VSS nmos W=0.155u L=0.04u
M17588 U5495/net23 g996 U5495/net20 VSS nmos W=0.155u L=0.04u
M17589 U5495/net30 n5021 VDD VDD pmos W=0.205u L=0.04u
M17590 VDD n5022 n5017 VDD pmos W=0.205u L=0.04u
M17591 VDD g996 n5017 VDD pmos W=0.205u L=0.04u
M17592 VDD U5495/net30 n5017 VDD pmos W=0.205u L=0.04u
M17593 U5496/net19 n4970 VSS VSS nmos W=0.155u L=0.04u
M17594 n3049 n4970 U5496/net40 VSS nmos W=0.155u L=0.04u
M17595 n3049 U5496/net19 U5496/net36 VSS nmos W=0.155u L=0.04u
M17596 U5496/net40 g999 VSS VSS nmos W=0.31u L=0.04u
M17597 U5496/net36 n5023 VSS VSS nmos W=0.155u L=0.04u
M17598 U5496/net19 n4970 VDD VDD pmos W=0.205u L=0.04u
M17599 n3049 U5496/net19 U5496/net26 VDD pmos W=0.325u L=0.04u
M17600 U5496/net26 g999 VDD VDD pmos W=0.41u L=0.04u
M17601 n3049 n4970 U5496/net30 VDD pmos W=0.325u L=0.04u
M17602 U5496/net30 n5023 VDD VDD pmos W=0.205u L=0.04u
M17603 U5497/net19 n4333 VSS VSS nmos W=0.155u L=0.04u
M17604 n3048 n4333 U5497/net40 VSS nmos W=0.155u L=0.04u
M17605 n3048 U5497/net19 U5497/net36 VSS nmos W=0.155u L=0.04u
M17606 U5497/net40 g1000 VSS VSS nmos W=0.31u L=0.04u
M17607 U5497/net36 n5023 VSS VSS nmos W=0.155u L=0.04u
M17608 U5497/net19 n4333 VDD VDD pmos W=0.205u L=0.04u
M17609 n3048 U5497/net19 U5497/net26 VDD pmos W=0.325u L=0.04u
M17610 U5497/net26 g1000 VDD VDD pmos W=0.41u L=0.04u
M17611 n3048 n4333 U5497/net30 VDD pmos W=0.325u L=0.04u
M17612 U5497/net30 n5023 VDD VDD pmos W=0.205u L=0.04u
M17613 U5498/net19 n4971 VSS VSS nmos W=0.155u L=0.04u
M17614 n3047 n4971 U5498/net40 VSS nmos W=0.155u L=0.04u
M17615 n3047 U5498/net19 U5498/net36 VSS nmos W=0.155u L=0.04u
M17616 U5498/net40 g1001 VSS VSS nmos W=0.31u L=0.04u
M17617 U5498/net36 n5023 VSS VSS nmos W=0.155u L=0.04u
M17618 U5498/net19 n4971 VDD VDD pmos W=0.205u L=0.04u
M17619 n3047 U5498/net19 U5498/net26 VDD pmos W=0.325u L=0.04u
M17620 U5498/net26 g1001 VDD VDD pmos W=0.41u L=0.04u
M17621 n3047 n4971 U5498/net30 VDD pmos W=0.325u L=0.04u
M17622 U5498/net30 n5023 VDD VDD pmos W=0.205u L=0.04u
M17623 n5023 U5499/net6 VSS VSS nmos W=0.155u L=0.04u
M17624 U5499/X_u2-net6 n5025 VSS VSS nmos W=0.155u L=0.04u
M17625 U5499/net6 n5024 U5499/X_u2-net6 VSS nmos W=0.155u L=0.04u
M17626 n5023 U5499/net6 VDD VDD pmos W=0.205u L=0.04u
M17627 U5499/net6 n5025 VDD VDD pmos W=0.205u L=0.04u
M17628 U5499/net6 n5024 VDD VDD pmos W=0.205u L=0.04u
M17629 n5024 U5500/net26 VDD VDD pmos W=0.205u L=0.04u
M17630 U5500/net26 n5026 U5500/net19 VDD pmos W=0.205u L=0.04u
M17631 U5500/net26 n5027 U5500/net19 VDD pmos W=0.205u L=0.04u
M17632 U5500/net26 n5028 U5500/net19 VDD pmos W=0.205u L=0.04u
M17633 U5500/net19 n5029 VDD VDD pmos W=0.205u L=0.04u
M17634 U5500/net26 n5029 VSS VSS nmos W=0.155u L=0.04u
M17635 n5024 U5500/net26 VSS VSS nmos W=0.155u L=0.04u
M17636 U5500/XI20-net13 n5028 VSS VSS nmos W=0.155u L=0.04u
M17637 U5500/net26 n5026 U5500/XI20-net17 VSS nmos W=0.155u L=0.04u
M17638 U5500/XI20-net17 n5027 U5500/XI20-net13 VSS nmos W=0.155u L=0.04u
M17639 U5501/net19 n4990 VSS VSS nmos W=0.155u L=0.04u
M17640 n3046 n4990 U5501/net40 VSS nmos W=0.155u L=0.04u
M17641 n3046 U5501/net19 U5501/net36 VSS nmos W=0.155u L=0.04u
M17642 U5501/net40 g900 VSS VSS nmos W=0.31u L=0.04u
M17643 U5501/net36 n5030 VSS VSS nmos W=0.155u L=0.04u
M17644 U5501/net19 n4990 VDD VDD pmos W=0.205u L=0.04u
M17645 n3046 U5501/net19 U5501/net26 VDD pmos W=0.325u L=0.04u
M17646 U5501/net26 g900 VDD VDD pmos W=0.41u L=0.04u
M17647 n3046 n4990 U5501/net30 VDD pmos W=0.325u L=0.04u
M17648 U5501/net30 n5030 VDD VDD pmos W=0.205u L=0.04u
M17649 U5502/net19 n4989 VSS VSS nmos W=0.155u L=0.04u
M17650 n3045 n4989 U5502/net40 VSS nmos W=0.155u L=0.04u
M17651 n3045 U5502/net19 U5502/net36 VSS nmos W=0.155u L=0.04u
M17652 U5502/net40 g903 VSS VSS nmos W=0.31u L=0.04u
M17653 U5502/net36 n5030 VSS VSS nmos W=0.155u L=0.04u
M17654 U5502/net19 n4989 VDD VDD pmos W=0.205u L=0.04u
M17655 n3045 U5502/net19 U5502/net26 VDD pmos W=0.325u L=0.04u
M17656 U5502/net26 g903 VDD VDD pmos W=0.41u L=0.04u
M17657 n3045 n4989 U5502/net30 VDD pmos W=0.325u L=0.04u
M17658 U5502/net30 n5030 VDD VDD pmos W=0.205u L=0.04u
M17659 U5503/net19 n4991 VSS VSS nmos W=0.155u L=0.04u
M17660 n3044 n4991 U5503/net40 VSS nmos W=0.155u L=0.04u
M17661 n3044 U5503/net19 U5503/net36 VSS nmos W=0.155u L=0.04u
M17662 U5503/net40 g906 VSS VSS nmos W=0.31u L=0.04u
M17663 U5503/net36 n5030 VSS VSS nmos W=0.155u L=0.04u
M17664 U5503/net19 n4991 VDD VDD pmos W=0.205u L=0.04u
M17665 n3044 U5503/net19 U5503/net26 VDD pmos W=0.325u L=0.04u
M17666 U5503/net26 g906 VDD VDD pmos W=0.41u L=0.04u
M17667 n3044 n4991 U5503/net30 VDD pmos W=0.325u L=0.04u
M17668 U5503/net30 n5030 VDD VDD pmos W=0.205u L=0.04u
M17669 n5030 n4968 U5504/net10 VSS nmos W=0.155u L=0.04u
M17670 U5504/net10 n5033 VSS VSS nmos W=0.155u L=0.04u
M17671 n5030 n5031 U5504/net10 VSS nmos W=0.155u L=0.04u
M17672 U5504/net10 n5032 VSS VSS nmos W=0.155u L=0.04u
M17673 U5504/net30 n5033 VDD VDD pmos W=0.205u L=0.04u
M17674 n5030 n4968 U5504/net24 VDD pmos W=0.205u L=0.04u
M17675 U5504/net24 n5031 VDD VDD pmos W=0.205u L=0.04u
M17676 n5030 n5032 U5504/net30 VDD pmos W=0.205u L=0.04u
M17677 U5505/net4 n5034 U5505/net14 VSS nmos W=0.155u L=0.04u
M17678 U5505/net6 U5505/net10 U5505/net14 VSS nmos W=0.17u L=0.04u
M17679 U5505/net4 n5035 VSS VSS nmos W=0.155u L=0.04u
M17680 U5505/net6 U5505/net4 VSS VSS nmos W=0.17u L=0.04u
M17681 n5033 U5505/net14 VSS VSS nmos W=0.155u L=0.04u
M17682 U5505/net10 n5034 VSS VSS nmos W=0.155u L=0.04u
M17683 U5505/net4 U5505/net10 U5505/net14 VDD pmos W=0.255u L=0.04u
M17684 U5505/net6 n5034 U5505/net14 VDD pmos W=0.28u L=0.04u
M17685 U5505/net4 n5035 VDD VDD pmos W=0.205u L=0.04u
M17686 U5505/net6 U5505/net4 VDD VDD pmos W=0.24u L=0.04u
M17687 n5033 U5505/net14 VDD VDD pmos W=0.205u L=0.04u
M17688 U5505/net10 n5034 VDD VDD pmos W=0.205u L=0.04u
M17689 U5506/net19 n4990 VSS VSS nmos W=0.155u L=0.04u
M17690 n3043 n4990 U5506/net40 VSS nmos W=0.155u L=0.04u
M17691 n3043 U5506/net19 U5506/net36 VSS nmos W=0.155u L=0.04u
M17692 U5506/net40 g936 VSS VSS nmos W=0.31u L=0.04u
M17693 U5506/net36 n5036 VSS VSS nmos W=0.155u L=0.04u
M17694 U5506/net19 n4990 VDD VDD pmos W=0.205u L=0.04u
M17695 n3043 U5506/net19 U5506/net26 VDD pmos W=0.325u L=0.04u
M17696 U5506/net26 g936 VDD VDD pmos W=0.41u L=0.04u
M17697 n3043 n4990 U5506/net30 VDD pmos W=0.325u L=0.04u
M17698 U5506/net30 n5036 VDD VDD pmos W=0.205u L=0.04u
M17699 U5507/net19 n4989 VSS VSS nmos W=0.155u L=0.04u
M17700 n3042 n4989 U5507/net40 VSS nmos W=0.155u L=0.04u
M17701 n3042 U5507/net19 U5507/net36 VSS nmos W=0.155u L=0.04u
M17702 U5507/net40 g939 VSS VSS nmos W=0.31u L=0.04u
M17703 U5507/net36 n5036 VSS VSS nmos W=0.155u L=0.04u
M17704 U5507/net19 n4989 VDD VDD pmos W=0.205u L=0.04u
M17705 n3042 U5507/net19 U5507/net26 VDD pmos W=0.325u L=0.04u
M17706 U5507/net26 g939 VDD VDD pmos W=0.41u L=0.04u
M17707 n3042 n4989 U5507/net30 VDD pmos W=0.325u L=0.04u
M17708 U5507/net30 n5036 VDD VDD pmos W=0.205u L=0.04u
M17709 U5508/net19 n4991 VSS VSS nmos W=0.155u L=0.04u
M17710 n3041 n4991 U5508/net40 VSS nmos W=0.155u L=0.04u
M17711 n3041 U5508/net19 U5508/net36 VSS nmos W=0.155u L=0.04u
M17712 U5508/net40 g942 VSS VSS nmos W=0.31u L=0.04u
M17713 U5508/net36 n5036 VSS VSS nmos W=0.155u L=0.04u
M17714 U5508/net19 n4991 VDD VDD pmos W=0.205u L=0.04u
M17715 n3041 U5508/net19 U5508/net26 VDD pmos W=0.325u L=0.04u
M17716 U5508/net26 g942 VDD VDD pmos W=0.41u L=0.04u
M17717 n3041 n4991 U5508/net30 VDD pmos W=0.325u L=0.04u
M17718 U5508/net30 n5036 VDD VDD pmos W=0.205u L=0.04u
M17719 n5036 n4967 U5509/net10 VSS nmos W=0.155u L=0.04u
M17720 U5509/net10 n5037 VSS VSS nmos W=0.155u L=0.04u
M17721 n5036 n5031 U5509/net10 VSS nmos W=0.155u L=0.04u
M17722 U5509/net10 n5032 VSS VSS nmos W=0.155u L=0.04u
M17723 U5509/net30 n5037 VDD VDD pmos W=0.205u L=0.04u
M17724 n5036 n4967 U5509/net24 VDD pmos W=0.205u L=0.04u
M17725 U5509/net24 n5031 VDD VDD pmos W=0.205u L=0.04u
M17726 n5036 n5032 U5509/net30 VDD pmos W=0.205u L=0.04u
M17727 U5510/net4 n5038 U5510/net14 VSS nmos W=0.155u L=0.04u
M17728 U5510/net6 U5510/net10 U5510/net14 VSS nmos W=0.17u L=0.04u
M17729 U5510/net4 n5039 VSS VSS nmos W=0.155u L=0.04u
M17730 U5510/net6 U5510/net4 VSS VSS nmos W=0.17u L=0.04u
M17731 n5037 U5510/net14 VSS VSS nmos W=0.155u L=0.04u
M17732 U5510/net10 n5038 VSS VSS nmos W=0.155u L=0.04u
M17733 U5510/net4 U5510/net10 U5510/net14 VDD pmos W=0.255u L=0.04u
M17734 U5510/net6 n5038 U5510/net14 VDD pmos W=0.28u L=0.04u
M17735 U5510/net4 n5039 VDD VDD pmos W=0.205u L=0.04u
M17736 U5510/net6 U5510/net4 VDD VDD pmos W=0.24u L=0.04u
M17737 n5037 U5510/net14 VDD VDD pmos W=0.205u L=0.04u
M17738 U5510/net10 n5038 VDD VDD pmos W=0.205u L=0.04u
M17739 U5511/XU1-net6 n5041 VSS VSS nmos W=0.155u L=0.04u
M17740 n5038 n5040 U5511/XU1-net6 VSS nmos W=0.155u L=0.04u
M17741 n5038 n5041 VDD VDD pmos W=0.155u L=0.04u
M17742 n5038 n5040 VDD VDD pmos W=0.155u L=0.04u
M17743 U5512/net19 n4990 VSS VSS nmos W=0.155u L=0.04u
M17744 n3040 n4990 U5512/net40 VSS nmos W=0.155u L=0.04u
M17745 n3040 U5512/net19 U5512/net36 VSS nmos W=0.155u L=0.04u
M17746 U5512/net40 g891 VSS VSS nmos W=0.31u L=0.04u
M17747 U5512/net36 n5042 VSS VSS nmos W=0.155u L=0.04u
M17748 U5512/net19 n4990 VDD VDD pmos W=0.205u L=0.04u
M17749 n3040 U5512/net19 U5512/net26 VDD pmos W=0.325u L=0.04u
M17750 U5512/net26 g891 VDD VDD pmos W=0.41u L=0.04u
M17751 n3040 n4990 U5512/net30 VDD pmos W=0.325u L=0.04u
M17752 U5512/net30 n5042 VDD VDD pmos W=0.205u L=0.04u
M17753 U5513/net19 n4989 VSS VSS nmos W=0.155u L=0.04u
M17754 n3039 n4989 U5513/net40 VSS nmos W=0.155u L=0.04u
M17755 n3039 U5513/net19 U5513/net36 VSS nmos W=0.155u L=0.04u
M17756 U5513/net40 g894 VSS VSS nmos W=0.31u L=0.04u
M17757 U5513/net36 n5042 VSS VSS nmos W=0.155u L=0.04u
M17758 U5513/net19 n4989 VDD VDD pmos W=0.205u L=0.04u
M17759 n3039 U5513/net19 U5513/net26 VDD pmos W=0.325u L=0.04u
M17760 U5513/net26 g894 VDD VDD pmos W=0.41u L=0.04u
M17761 n3039 n4989 U5513/net30 VDD pmos W=0.325u L=0.04u
M17762 U5513/net30 n5042 VDD VDD pmos W=0.205u L=0.04u
M17763 U5514/net19 n4991 VSS VSS nmos W=0.155u L=0.04u
M17764 n3038 n4991 U5514/net40 VSS nmos W=0.155u L=0.04u
M17765 n3038 U5514/net19 U5514/net36 VSS nmos W=0.155u L=0.04u
M17766 U5514/net40 g897 VSS VSS nmos W=0.31u L=0.04u
M17767 U5514/net36 n5042 VSS VSS nmos W=0.155u L=0.04u
M17768 U5514/net19 n4991 VDD VDD pmos W=0.205u L=0.04u
M17769 n3038 U5514/net19 U5514/net26 VDD pmos W=0.325u L=0.04u
M17770 U5514/net26 g897 VDD VDD pmos W=0.41u L=0.04u
M17771 n3038 n4991 U5514/net30 VDD pmos W=0.325u L=0.04u
M17772 U5514/net30 n5042 VDD VDD pmos W=0.205u L=0.04u
M17773 n5042 n4966 U5515/net10 VSS nmos W=0.155u L=0.04u
M17774 U5515/net10 n5043 VSS VSS nmos W=0.155u L=0.04u
M17775 n5042 n5031 U5515/net10 VSS nmos W=0.155u L=0.04u
M17776 U5515/net10 n5032 VSS VSS nmos W=0.155u L=0.04u
M17777 U5515/net30 n5043 VDD VDD pmos W=0.205u L=0.04u
M17778 n5042 n4966 U5515/net24 VDD pmos W=0.205u L=0.04u
M17779 U5515/net24 n5031 VDD VDD pmos W=0.205u L=0.04u
M17780 n5042 n5032 U5515/net30 VDD pmos W=0.205u L=0.04u
M17781 U5516/net4 n5040 U5516/net14 VSS nmos W=0.155u L=0.04u
M17782 U5516/net6 U5516/net10 U5516/net14 VSS nmos W=0.17u L=0.04u
M17783 U5516/net4 n5044 VSS VSS nmos W=0.155u L=0.04u
M17784 U5516/net6 U5516/net4 VSS VSS nmos W=0.17u L=0.04u
M17785 n5043 U5516/net14 VSS VSS nmos W=0.155u L=0.04u
M17786 U5516/net10 n5040 VSS VSS nmos W=0.155u L=0.04u
M17787 U5516/net4 U5516/net10 U5516/net14 VDD pmos W=0.255u L=0.04u
M17788 U5516/net6 n5040 U5516/net14 VDD pmos W=0.28u L=0.04u
M17789 U5516/net4 n5044 VDD VDD pmos W=0.205u L=0.04u
M17790 U5516/net6 U5516/net4 VDD VDD pmos W=0.24u L=0.04u
M17791 n5043 U5516/net14 VDD VDD pmos W=0.205u L=0.04u
M17792 U5516/net10 n5040 VDD VDD pmos W=0.205u L=0.04u
M17793 U5517/net19 n4991 VSS VSS nmos W=0.155u L=0.04u
M17794 n3037 n4991 U5517/net40 VSS nmos W=0.155u L=0.04u
M17795 n3037 U5517/net19 U5517/net36 VSS nmos W=0.155u L=0.04u
M17796 U5517/net40 g879 VSS VSS nmos W=0.31u L=0.04u
M17797 U5517/net36 n5045 VSS VSS nmos W=0.155u L=0.04u
M17798 U5517/net19 n4991 VDD VDD pmos W=0.205u L=0.04u
M17799 n3037 U5517/net19 U5517/net26 VDD pmos W=0.325u L=0.04u
M17800 U5517/net26 g879 VDD VDD pmos W=0.41u L=0.04u
M17801 n3037 n4991 U5517/net30 VDD pmos W=0.325u L=0.04u
M17802 U5517/net30 n5045 VDD VDD pmos W=0.205u L=0.04u
M17803 U5518/net19 n4990 VSS VSS nmos W=0.155u L=0.04u
M17804 n3036 n4990 U5518/net40 VSS nmos W=0.155u L=0.04u
M17805 n3036 U5518/net19 U5518/net36 VSS nmos W=0.155u L=0.04u
M17806 U5518/net40 g873 VSS VSS nmos W=0.31u L=0.04u
M17807 U5518/net36 n5045 VSS VSS nmos W=0.155u L=0.04u
M17808 U5518/net19 n4990 VDD VDD pmos W=0.205u L=0.04u
M17809 n3036 U5518/net19 U5518/net26 VDD pmos W=0.325u L=0.04u
M17810 U5518/net26 g873 VDD VDD pmos W=0.41u L=0.04u
M17811 n3036 n4990 U5518/net30 VDD pmos W=0.325u L=0.04u
M17812 U5518/net30 n5045 VDD VDD pmos W=0.205u L=0.04u
M17813 U5519/net19 n4989 VSS VSS nmos W=0.155u L=0.04u
M17814 n3035 n4989 U5519/net40 VSS nmos W=0.155u L=0.04u
M17815 n3035 U5519/net19 U5519/net36 VSS nmos W=0.155u L=0.04u
M17816 U5519/net40 g876 VSS VSS nmos W=0.31u L=0.04u
M17817 U5519/net36 n5045 VSS VSS nmos W=0.155u L=0.04u
M17818 U5519/net19 n4989 VDD VDD pmos W=0.205u L=0.04u
M17819 n3035 U5519/net19 U5519/net26 VDD pmos W=0.325u L=0.04u
M17820 U5519/net26 g876 VDD VDD pmos W=0.41u L=0.04u
M17821 n3035 n4989 U5519/net30 VDD pmos W=0.325u L=0.04u
M17822 U5519/net30 n5045 VDD VDD pmos W=0.205u L=0.04u
M17823 n5045 n4962 U5520/net10 VSS nmos W=0.155u L=0.04u
M17824 U5520/net10 n5032 VSS VSS nmos W=0.155u L=0.04u
M17825 n5045 n5031 U5520/net10 VSS nmos W=0.155u L=0.04u
M17826 U5520/net10 n5046 VSS VSS nmos W=0.155u L=0.04u
M17827 U5520/net30 n5032 VDD VDD pmos W=0.205u L=0.04u
M17828 n5045 n4962 U5520/net24 VDD pmos W=0.205u L=0.04u
M17829 U5520/net24 n5031 VDD VDD pmos W=0.205u L=0.04u
M17830 n5045 n5046 U5520/net30 VDD pmos W=0.205u L=0.04u
M17831 U5521/net4 n5047 U5521/net14 VSS nmos W=0.155u L=0.04u
M17832 U5521/net6 U5521/net10 U5521/net14 VSS nmos W=0.17u L=0.04u
M17833 U5521/net4 n5048 VSS VSS nmos W=0.155u L=0.04u
M17834 U5521/net6 U5521/net4 VSS VSS nmos W=0.17u L=0.04u
M17835 n5046 U5521/net14 VSS VSS nmos W=0.155u L=0.04u
M17836 U5521/net10 n5047 VSS VSS nmos W=0.155u L=0.04u
M17837 U5521/net4 U5521/net10 U5521/net14 VDD pmos W=0.255u L=0.04u
M17838 U5521/net6 n5047 U5521/net14 VDD pmos W=0.28u L=0.04u
M17839 U5521/net4 n5048 VDD VDD pmos W=0.205u L=0.04u
M17840 U5521/net6 U5521/net4 VDD VDD pmos W=0.24u L=0.04u
M17841 n5046 U5521/net14 VDD VDD pmos W=0.205u L=0.04u
M17842 U5521/net10 n5047 VDD VDD pmos W=0.205u L=0.04u
M17843 U5522/net19 n4991 VSS VSS nmos W=0.155u L=0.04u
M17844 n3034 n4991 U5522/net40 VSS nmos W=0.155u L=0.04u
M17845 n3034 U5522/net19 U5522/net36 VSS nmos W=0.155u L=0.04u
M17846 U5522/net40 g960 VSS VSS nmos W=0.31u L=0.04u
M17847 U5522/net36 n5049 VSS VSS nmos W=0.155u L=0.04u
M17848 U5522/net19 n4991 VDD VDD pmos W=0.205u L=0.04u
M17849 n3034 U5522/net19 U5522/net26 VDD pmos W=0.325u L=0.04u
M17850 U5522/net26 g960 VDD VDD pmos W=0.41u L=0.04u
M17851 n3034 n4991 U5522/net30 VDD pmos W=0.325u L=0.04u
M17852 U5522/net30 n5049 VDD VDD pmos W=0.205u L=0.04u
M17853 U5523/net19 n4990 VSS VSS nmos W=0.155u L=0.04u
M17854 n3033 n4990 U5523/net40 VSS nmos W=0.155u L=0.04u
M17855 n3033 U5523/net19 U5523/net36 VSS nmos W=0.155u L=0.04u
M17856 U5523/net40 g954 VSS VSS nmos W=0.31u L=0.04u
M17857 U5523/net36 n5049 VSS VSS nmos W=0.155u L=0.04u
M17858 U5523/net19 n4990 VDD VDD pmos W=0.205u L=0.04u
M17859 n3033 U5523/net19 U5523/net26 VDD pmos W=0.325u L=0.04u
M17860 U5523/net26 g954 VDD VDD pmos W=0.41u L=0.04u
M17861 n3033 n4990 U5523/net30 VDD pmos W=0.325u L=0.04u
M17862 U5523/net30 n5049 VDD VDD pmos W=0.205u L=0.04u
M17863 U5524/net19 n4989 VSS VSS nmos W=0.155u L=0.04u
M17864 n3032 n4989 U5524/net40 VSS nmos W=0.155u L=0.04u
M17865 n3032 U5524/net19 U5524/net36 VSS nmos W=0.155u L=0.04u
M17866 U5524/net40 g957 VSS VSS nmos W=0.31u L=0.04u
M17867 U5524/net36 n5049 VSS VSS nmos W=0.155u L=0.04u
M17868 U5524/net19 n4989 VDD VDD pmos W=0.205u L=0.04u
M17869 n3032 U5524/net19 U5524/net26 VDD pmos W=0.325u L=0.04u
M17870 U5524/net26 g957 VDD VDD pmos W=0.41u L=0.04u
M17871 n3032 n4989 U5524/net30 VDD pmos W=0.325u L=0.04u
M17872 U5524/net30 n5049 VDD VDD pmos W=0.205u L=0.04u
M17873 U5525/net32 n5031 U5525/net26 VSS nmos W=0.155u L=0.04u
M17874 U5525/net32 n5015 U5525/net26 VSS nmos W=0.155u L=0.04u
M17875 U5525/net29 n5051 VSS VSS nmos W=0.155u L=0.04u
M17876 U5525/net26 n5050 U5525/net29 VSS nmos W=0.155u L=0.04u
M17877 U5525/net26 n5032 U5525/net29 VSS nmos W=0.155u L=0.04u
M17878 n5049 U5525/net32 VSS VSS nmos W=0.155u L=0.04u
M17879 n5049 U5525/net32 VDD VDD pmos W=0.205u L=0.04u
M17880 U5525/net32 n5015 U5525/net43 VDD pmos W=0.205u L=0.04u
M17881 U5525/net32 n5032 U5525/net49 VDD pmos W=0.205u L=0.04u
M17882 U5525/net49 n5050 VDD VDD pmos W=0.205u L=0.04u
M17883 U5525/net43 n5031 VDD VDD pmos W=0.205u L=0.04u
M17884 U5525/net32 n5051 VDD VDD pmos W=0.205u L=0.04u
M17885 U5526/net4 n5052 U5526/net14 VSS nmos W=0.155u L=0.04u
M17886 U5526/net6 U5526/net10 U5526/net14 VSS nmos W=0.17u L=0.04u
M17887 U5526/net4 n5053 VSS VSS nmos W=0.155u L=0.04u
M17888 U5526/net6 U5526/net4 VSS VSS nmos W=0.17u L=0.04u
M17889 n5050 U5526/net14 VSS VSS nmos W=0.155u L=0.04u
M17890 U5526/net10 n5052 VSS VSS nmos W=0.155u L=0.04u
M17891 U5526/net4 U5526/net10 U5526/net14 VDD pmos W=0.255u L=0.04u
M17892 U5526/net6 n5052 U5526/net14 VDD pmos W=0.28u L=0.04u
M17893 U5526/net4 n5053 VDD VDD pmos W=0.205u L=0.04u
M17894 U5526/net6 U5526/net4 VDD VDD pmos W=0.24u L=0.04u
M17895 n5050 U5526/net14 VDD VDD pmos W=0.205u L=0.04u
M17896 U5526/net10 n5052 VDD VDD pmos W=0.205u L=0.04u
M17897 U5527/net13 n5054 VSS VSS nmos W=0.155u L=0.04u
M17898 U5527/net16 U5527/net13 VSS VSS nmos W=0.155u L=0.04u
M17899 n5053 n5055 U5527/net16 VSS nmos W=0.155u L=0.04u
M17900 U5527/net13 n5054 VDD VDD pmos W=0.205u L=0.04u
M17901 VDD U5527/net13 n5053 VDD pmos W=0.205u L=0.04u
M17902 VDD n5055 n5053 VDD pmos W=0.205u L=0.04u
M17903 U5528/net4 n5056 U5528/net14 VSS nmos W=0.155u L=0.04u
M17904 U5528/net6 U5528/net10 U5528/net14 VSS nmos W=0.17u L=0.04u
M17905 U5528/net4 n5057 VSS VSS nmos W=0.155u L=0.04u
M17906 U5528/net6 U5528/net4 VSS VSS nmos W=0.17u L=0.04u
M17907 n5055 U5528/net14 VSS VSS nmos W=0.155u L=0.04u
M17908 U5528/net10 n5056 VSS VSS nmos W=0.155u L=0.04u
M17909 U5528/net4 U5528/net10 U5528/net14 VDD pmos W=0.255u L=0.04u
M17910 U5528/net6 n5056 U5528/net14 VDD pmos W=0.28u L=0.04u
M17911 U5528/net4 n5057 VDD VDD pmos W=0.205u L=0.04u
M17912 U5528/net6 U5528/net4 VDD VDD pmos W=0.24u L=0.04u
M17913 n5055 U5528/net14 VDD VDD pmos W=0.205u L=0.04u
M17914 U5528/net10 n5056 VDD VDD pmos W=0.205u L=0.04u
M17915 U5529/net19 n4990 VSS VSS nmos W=0.155u L=0.04u
M17916 n3031 n4990 U5529/net40 VSS nmos W=0.155u L=0.04u
M17917 n3031 U5529/net19 U5529/net36 VSS nmos W=0.155u L=0.04u
M17918 U5529/net40 g909 VSS VSS nmos W=0.31u L=0.04u
M17919 U5529/net36 n5058 VSS VSS nmos W=0.155u L=0.04u
M17920 U5529/net19 n4990 VDD VDD pmos W=0.205u L=0.04u
M17921 n3031 U5529/net19 U5529/net26 VDD pmos W=0.325u L=0.04u
M17922 U5529/net26 g909 VDD VDD pmos W=0.41u L=0.04u
M17923 n3031 n4990 U5529/net30 VDD pmos W=0.325u L=0.04u
M17924 U5529/net30 n5058 VDD VDD pmos W=0.205u L=0.04u
M17925 U5530/net19 n4989 VSS VSS nmos W=0.155u L=0.04u
M17926 n3030 n4989 U5530/net40 VSS nmos W=0.155u L=0.04u
M17927 n3030 U5530/net19 U5530/net36 VSS nmos W=0.155u L=0.04u
M17928 U5530/net40 g912 VSS VSS nmos W=0.31u L=0.04u
M17929 U5530/net36 n5058 VSS VSS nmos W=0.155u L=0.04u
M17930 U5530/net19 n4989 VDD VDD pmos W=0.205u L=0.04u
M17931 n3030 U5530/net19 U5530/net26 VDD pmos W=0.325u L=0.04u
M17932 U5530/net26 g912 VDD VDD pmos W=0.41u L=0.04u
M17933 n3030 n4989 U5530/net30 VDD pmos W=0.325u L=0.04u
M17934 U5530/net30 n5058 VDD VDD pmos W=0.205u L=0.04u
M17935 U5531/net19 n4991 VSS VSS nmos W=0.155u L=0.04u
M17936 n3029 n4991 U5531/net40 VSS nmos W=0.155u L=0.04u
M17937 n3029 U5531/net19 U5531/net36 VSS nmos W=0.155u L=0.04u
M17938 U5531/net40 g915 VSS VSS nmos W=0.31u L=0.04u
M17939 U5531/net36 n5058 VSS VSS nmos W=0.155u L=0.04u
M17940 U5531/net19 n4991 VDD VDD pmos W=0.205u L=0.04u
M17941 n3029 U5531/net19 U5531/net26 VDD pmos W=0.325u L=0.04u
M17942 U5531/net26 g915 VDD VDD pmos W=0.41u L=0.04u
M17943 n3029 n4991 U5531/net30 VDD pmos W=0.325u L=0.04u
M17944 U5531/net30 n5058 VDD VDD pmos W=0.205u L=0.04u
M17945 n5058 n5031 U5532/net27 VSS nmos W=0.155u L=0.04u
M17946 U5532/net39 n5060 VSS VSS nmos W=0.155u L=0.04u
M17947 U5532/net27 n5032 U5532/net39 VSS nmos W=0.155u L=0.04u
M17948 U5532/net27 n5059 U5532/net39 VSS nmos W=0.155u L=0.04u
M17949 n5058 n4178 U5532/net27 VSS nmos W=0.155u L=0.04u
M17950 U5532/net39 n5029 VSS VSS nmos W=0.155u L=0.04u
M17951 n5058 n5060 U5532/net46 VDD pmos W=0.205u L=0.04u
M17952 U5532/net46 n5029 VDD VDD pmos W=0.205u L=0.04u
M17953 n5058 n4178 U5532/net34 VDD pmos W=0.205u L=0.04u
M17954 U5532/net34 n5031 VDD VDD pmos W=0.205u L=0.04u
M17955 n5058 n5059 U5532/net37 VDD pmos W=0.205u L=0.04u
M17956 U5532/net37 n5032 VDD VDD pmos W=0.205u L=0.04u
M17957 U5533/net4 n5054 U5533/net14 VSS nmos W=0.155u L=0.04u
M17958 U5533/net6 U5533/net10 U5533/net14 VSS nmos W=0.17u L=0.04u
M17959 U5533/net4 n5057 VSS VSS nmos W=0.155u L=0.04u
M17960 U5533/net6 U5533/net4 VSS VSS nmos W=0.17u L=0.04u
M17961 n5059 U5533/net14 VSS VSS nmos W=0.155u L=0.04u
M17962 U5533/net10 n5054 VSS VSS nmos W=0.155u L=0.04u
M17963 U5533/net4 U5533/net10 U5533/net14 VDD pmos W=0.255u L=0.04u
M17964 U5533/net6 n5054 U5533/net14 VDD pmos W=0.28u L=0.04u
M17965 U5533/net4 n5057 VDD VDD pmos W=0.205u L=0.04u
M17966 U5533/net6 U5533/net4 VDD VDD pmos W=0.24u L=0.04u
M17967 n5059 U5533/net14 VDD VDD pmos W=0.205u L=0.04u
M17968 U5533/net10 n5054 VDD VDD pmos W=0.205u L=0.04u
M17969 U5534/XU1-net6 n5062 VSS VSS nmos W=0.155u L=0.04u
M17970 n5054 n5061 U5534/XU1-net6 VSS nmos W=0.155u L=0.04u
M17971 n5054 n5062 VDD VDD pmos W=0.155u L=0.04u
M17972 n5054 n5061 VDD VDD pmos W=0.155u L=0.04u
M17973 U5535/net19 n5064 VSS VSS nmos W=0.155u L=0.04u
M17974 n5061 n5064 U5535/net40 VSS nmos W=0.155u L=0.04u
M17975 n5061 U5535/net19 U5535/net36 VSS nmos W=0.155u L=0.04u
M17976 U5535/net40 n5063 VSS VSS nmos W=0.31u L=0.04u
M17977 U5535/net36 n5029 VSS VSS nmos W=0.155u L=0.04u
M17978 U5535/net19 n5064 VDD VDD pmos W=0.205u L=0.04u
M17979 n5061 U5535/net19 U5535/net26 VDD pmos W=0.325u L=0.04u
M17980 U5535/net26 n5063 VDD VDD pmos W=0.41u L=0.04u
M17981 n5061 n5064 U5535/net30 VDD pmos W=0.325u L=0.04u
M17982 U5535/net30 n5029 VDD VDD pmos W=0.205u L=0.04u
M17983 U5536/net19 n4990 VSS VSS nmos W=0.155u L=0.04u
M17984 n3028 n4990 U5536/net40 VSS nmos W=0.155u L=0.04u
M17985 n3028 U5536/net19 U5536/net36 VSS nmos W=0.155u L=0.04u
M17986 U5536/net40 g927 VSS VSS nmos W=0.31u L=0.04u
M17987 U5536/net36 n5065 VSS VSS nmos W=0.155u L=0.04u
M17988 U5536/net19 n4990 VDD VDD pmos W=0.205u L=0.04u
M17989 n3028 U5536/net19 U5536/net26 VDD pmos W=0.325u L=0.04u
M17990 U5536/net26 g927 VDD VDD pmos W=0.41u L=0.04u
M17991 n3028 n4990 U5536/net30 VDD pmos W=0.325u L=0.04u
M17992 U5536/net30 n5065 VDD VDD pmos W=0.205u L=0.04u
M17993 U5537/net19 n4989 VSS VSS nmos W=0.155u L=0.04u
M17994 n3027 n4989 U5537/net40 VSS nmos W=0.155u L=0.04u
M17995 n3027 U5537/net19 U5537/net36 VSS nmos W=0.155u L=0.04u
M17996 U5537/net40 g930 VSS VSS nmos W=0.31u L=0.04u
M17997 U5537/net36 n5065 VSS VSS nmos W=0.155u L=0.04u
M17998 U5537/net19 n4989 VDD VDD pmos W=0.205u L=0.04u
M17999 n3027 U5537/net19 U5537/net26 VDD pmos W=0.325u L=0.04u
M18000 U5537/net26 g930 VDD VDD pmos W=0.41u L=0.04u
M18001 n3027 n4989 U5537/net30 VDD pmos W=0.325u L=0.04u
M18002 U5537/net30 n5065 VDD VDD pmos W=0.205u L=0.04u
M18003 U5538/net19 n4991 VSS VSS nmos W=0.155u L=0.04u
M18004 n3026 n4991 U5538/net40 VSS nmos W=0.155u L=0.04u
M18005 n3026 U5538/net19 U5538/net36 VSS nmos W=0.155u L=0.04u
M18006 U5538/net40 g933 VSS VSS nmos W=0.31u L=0.04u
M18007 U5538/net36 n5065 VSS VSS nmos W=0.155u L=0.04u
M18008 U5538/net19 n4991 VDD VDD pmos W=0.205u L=0.04u
M18009 n3026 U5538/net19 U5538/net26 VDD pmos W=0.325u L=0.04u
M18010 U5538/net26 g933 VDD VDD pmos W=0.41u L=0.04u
M18011 n3026 n4991 U5538/net30 VDD pmos W=0.325u L=0.04u
M18012 U5538/net30 n5065 VDD VDD pmos W=0.205u L=0.04u
M18013 U5539/net32 n5031 U5539/net26 VSS nmos W=0.155u L=0.04u
M18014 U5539/net32 g797 U5539/net26 VSS nmos W=0.155u L=0.04u
M18015 U5539/net29 n5051 VSS VSS nmos W=0.155u L=0.04u
M18016 U5539/net26 n5066 U5539/net29 VSS nmos W=0.155u L=0.04u
M18017 U5539/net26 n5032 U5539/net29 VSS nmos W=0.155u L=0.04u
M18018 n5065 U5539/net32 VSS VSS nmos W=0.155u L=0.04u
M18019 n5065 U5539/net32 VDD VDD pmos W=0.205u L=0.04u
M18020 U5539/net32 g797 U5539/net43 VDD pmos W=0.205u L=0.04u
M18021 U5539/net32 n5032 U5539/net49 VDD pmos W=0.205u L=0.04u
M18022 U5539/net49 n5066 VDD VDD pmos W=0.205u L=0.04u
M18023 U5539/net43 n5031 VDD VDD pmos W=0.205u L=0.04u
M18024 U5539/net32 n5051 VDD VDD pmos W=0.205u L=0.04u
M18025 U5540/net4 n5067 U5540/net14 VSS nmos W=0.155u L=0.04u
M18026 U5540/net6 U5540/net10 U5540/net14 VSS nmos W=0.17u L=0.04u
M18027 U5540/net4 n5068 VSS VSS nmos W=0.155u L=0.04u
M18028 U5540/net6 U5540/net4 VSS VSS nmos W=0.17u L=0.04u
M18029 n5066 U5540/net14 VSS VSS nmos W=0.155u L=0.04u
M18030 U5540/net10 n5067 VSS VSS nmos W=0.155u L=0.04u
M18031 U5540/net4 U5540/net10 U5540/net14 VDD pmos W=0.255u L=0.04u
M18032 U5540/net6 n5067 U5540/net14 VDD pmos W=0.28u L=0.04u
M18033 U5540/net4 n5068 VDD VDD pmos W=0.205u L=0.04u
M18034 U5540/net6 U5540/net4 VDD VDD pmos W=0.24u L=0.04u
M18035 n5066 U5540/net14 VDD VDD pmos W=0.205u L=0.04u
M18036 U5540/net10 n5067 VDD VDD pmos W=0.205u L=0.04u
M18037 n5067 n5029 U5541/net27 VSS nmos W=0.155u L=0.04u
M18038 U5541/net27 n5069 VSS VSS nmos W=0.155u L=0.04u
M18039 n5067 n5070 VSS VSS nmos W=0.155u L=0.04u
M18040 n5067 n5069 U5541/net13 VDD pmos W=0.205u L=0.04u
M18041 U5541/net13 n5070 VDD VDD pmos W=0.205u L=0.04u
M18042 n5067 n5029 U5541/net13 VDD pmos W=0.205u L=0.04u
M18043 U5542/net19 n4989 VSS VSS nmos W=0.155u L=0.04u
M18044 n3025 n4989 U5542/net40 VSS nmos W=0.155u L=0.04u
M18045 n3025 U5542/net19 U5542/net36 VSS nmos W=0.155u L=0.04u
M18046 U5542/net40 g885 VSS VSS nmos W=0.31u L=0.04u
M18047 U5542/net36 n5071 VSS VSS nmos W=0.155u L=0.04u
M18048 U5542/net19 n4989 VDD VDD pmos W=0.205u L=0.04u
M18049 n3025 U5542/net19 U5542/net26 VDD pmos W=0.325u L=0.04u
M18050 U5542/net26 g885 VDD VDD pmos W=0.41u L=0.04u
M18051 n3025 n4989 U5542/net30 VDD pmos W=0.325u L=0.04u
M18052 U5542/net30 n5071 VDD VDD pmos W=0.205u L=0.04u
M18053 U5543/net19 n4991 VSS VSS nmos W=0.155u L=0.04u
M18054 n3024 n4991 U5543/net40 VSS nmos W=0.155u L=0.04u
M18055 n3024 U5543/net19 U5543/net36 VSS nmos W=0.155u L=0.04u
M18056 U5543/net40 g888 VSS VSS nmos W=0.31u L=0.04u
M18057 U5543/net36 n5071 VSS VSS nmos W=0.155u L=0.04u
M18058 U5543/net19 n4991 VDD VDD pmos W=0.205u L=0.04u
M18059 n3024 U5543/net19 U5543/net26 VDD pmos W=0.325u L=0.04u
M18060 U5543/net26 g888 VDD VDD pmos W=0.41u L=0.04u
M18061 n3024 n4991 U5543/net30 VDD pmos W=0.325u L=0.04u
M18062 U5543/net30 n5071 VDD VDD pmos W=0.205u L=0.04u
M18063 U5544/net19 n4990 VSS VSS nmos W=0.155u L=0.04u
M18064 n3023 n4990 U5544/net40 VSS nmos W=0.155u L=0.04u
M18065 n3023 U5544/net19 U5544/net36 VSS nmos W=0.155u L=0.04u
M18066 U5544/net40 g882 VSS VSS nmos W=0.31u L=0.04u
M18067 U5544/net36 n5071 VSS VSS nmos W=0.155u L=0.04u
M18068 U5544/net19 n4990 VDD VDD pmos W=0.205u L=0.04u
M18069 n3023 U5544/net19 U5544/net26 VDD pmos W=0.325u L=0.04u
M18070 U5544/net26 g882 VDD VDD pmos W=0.41u L=0.04u
M18071 n3023 n4990 U5544/net30 VDD pmos W=0.325u L=0.04u
M18072 U5544/net30 n5071 VDD VDD pmos W=0.205u L=0.04u
M18073 n5071 n5031 U5545/net27 VSS nmos W=0.155u L=0.04u
M18074 U5545/net39 n5060 VSS VSS nmos W=0.155u L=0.04u
M18075 U5545/net27 n5032 U5545/net39 VSS nmos W=0.155u L=0.04u
M18076 U5545/net27 n5072 U5545/net39 VSS nmos W=0.155u L=0.04u
M18077 n5071 n4964 U5545/net27 VSS nmos W=0.155u L=0.04u
M18078 U5545/net39 n5029 VSS VSS nmos W=0.155u L=0.04u
M18079 n5071 n5060 U5545/net46 VDD pmos W=0.205u L=0.04u
M18080 U5545/net46 n5029 VDD VDD pmos W=0.205u L=0.04u
M18081 n5071 n4964 U5545/net34 VDD pmos W=0.205u L=0.04u
M18082 U5545/net34 n5031 VDD VDD pmos W=0.205u L=0.04u
M18083 n5071 n5072 U5545/net37 VDD pmos W=0.205u L=0.04u
M18084 U5545/net37 n5032 VDD VDD pmos W=0.205u L=0.04u
M18085 U5546/net4 U5546/net10 U5546/net14 VSS nmos W=0.155u L=0.04u
M18086 U5546/net6 n5069 U5546/net14 VSS nmos W=0.155u L=0.04u
M18087 U5546/net4 n5073 VSS VSS nmos W=0.155u L=0.04u
M18088 U5546/net6 U5546/net4 VSS VSS nmos W=0.155u L=0.04u
M18089 n5072 U5546/net14 VSS VSS nmos W=0.155u L=0.04u
M18090 U5546/net10 n5069 VSS VSS nmos W=0.155u L=0.04u
M18091 U5546/net4 n5069 U5546/net14 VDD pmos W=0.205u L=0.04u
M18092 U5546/net6 U5546/net10 U5546/net14 VDD pmos W=0.205u L=0.04u
M18093 U5546/net4 n5073 VDD VDD pmos W=0.205u L=0.04u
M18094 U5546/net6 U5546/net4 VDD VDD pmos W=0.205u L=0.04u
M18095 n5072 U5546/net14 VDD VDD pmos W=0.205u L=0.04u
M18096 U5546/net10 n5069 VDD VDD pmos W=0.205u L=0.04u
M18097 U5547/net19 n4990 VSS VSS nmos W=0.155u L=0.04u
M18098 n3022 n4990 U5547/net40 VSS nmos W=0.155u L=0.04u
M18099 n3022 U5547/net19 U5547/net36 VSS nmos W=0.155u L=0.04u
M18100 U5547/net40 g918 VSS VSS nmos W=0.31u L=0.04u
M18101 U5547/net36 n5074 VSS VSS nmos W=0.155u L=0.04u
M18102 U5547/net19 n4990 VDD VDD pmos W=0.205u L=0.04u
M18103 n3022 U5547/net19 U5547/net26 VDD pmos W=0.325u L=0.04u
M18104 U5547/net26 g918 VDD VDD pmos W=0.41u L=0.04u
M18105 n3022 n4990 U5547/net30 VDD pmos W=0.325u L=0.04u
M18106 U5547/net30 n5074 VDD VDD pmos W=0.205u L=0.04u
M18107 U5548/net19 n4989 VSS VSS nmos W=0.155u L=0.04u
M18108 n3021 n4989 U5548/net40 VSS nmos W=0.155u L=0.04u
M18109 n3021 U5548/net19 U5548/net36 VSS nmos W=0.155u L=0.04u
M18110 U5548/net40 g921 VSS VSS nmos W=0.31u L=0.04u
M18111 U5548/net36 n5074 VSS VSS nmos W=0.155u L=0.04u
M18112 U5548/net19 n4989 VDD VDD pmos W=0.205u L=0.04u
M18113 n3021 U5548/net19 U5548/net26 VDD pmos W=0.325u L=0.04u
M18114 U5548/net26 g921 VDD VDD pmos W=0.41u L=0.04u
M18115 n3021 n4989 U5548/net30 VDD pmos W=0.325u L=0.04u
M18116 U5548/net30 n5074 VDD VDD pmos W=0.205u L=0.04u
M18117 U5549/net19 n4991 VSS VSS nmos W=0.155u L=0.04u
M18118 n3020 n4991 U5549/net40 VSS nmos W=0.155u L=0.04u
M18119 n3020 U5549/net19 U5549/net36 VSS nmos W=0.155u L=0.04u
M18120 U5549/net40 g924 VSS VSS nmos W=0.31u L=0.04u
M18121 U5549/net36 n5074 VSS VSS nmos W=0.155u L=0.04u
M18122 U5549/net19 n4991 VDD VDD pmos W=0.205u L=0.04u
M18123 n3020 U5549/net19 U5549/net26 VDD pmos W=0.325u L=0.04u
M18124 U5549/net26 g924 VDD VDD pmos W=0.41u L=0.04u
M18125 n3020 n4991 U5549/net30 VDD pmos W=0.325u L=0.04u
M18126 U5549/net30 n5074 VDD VDD pmos W=0.205u L=0.04u
M18127 U5550/net32 n5031 U5550/net26 VSS nmos W=0.155u L=0.04u
M18128 U5550/net32 g789 U5550/net26 VSS nmos W=0.155u L=0.04u
M18129 U5550/net29 n5051 VSS VSS nmos W=0.155u L=0.04u
M18130 U5550/net26 n5075 U5550/net29 VSS nmos W=0.155u L=0.04u
M18131 U5550/net26 n5032 U5550/net29 VSS nmos W=0.155u L=0.04u
M18132 n5074 U5550/net32 VSS VSS nmos W=0.155u L=0.04u
M18133 n5074 U5550/net32 VDD VDD pmos W=0.205u L=0.04u
M18134 U5550/net32 g789 U5550/net43 VDD pmos W=0.205u L=0.04u
M18135 U5550/net32 n5032 U5550/net49 VDD pmos W=0.205u L=0.04u
M18136 U5550/net49 n5075 VDD VDD pmos W=0.205u L=0.04u
M18137 U5550/net43 n5031 VDD VDD pmos W=0.205u L=0.04u
M18138 U5550/net32 n5051 VDD VDD pmos W=0.205u L=0.04u
M18139 U5551/net13 n5060 VSS VSS nmos W=0.155u L=0.04u
M18140 U5551/net16 U5551/net13 VSS VSS nmos W=0.155u L=0.04u
M18141 n5051 n5029 U5551/net16 VSS nmos W=0.155u L=0.04u
M18142 U5551/net13 n5060 VDD VDD pmos W=0.205u L=0.04u
M18143 VDD U5551/net13 n5051 VDD pmos W=0.205u L=0.04u
M18144 VDD n5029 n5051 VDD pmos W=0.205u L=0.04u
M18145 U5552/net4 n5076 U5552/net14 VSS nmos W=0.155u L=0.04u
M18146 U5552/net6 U5552/net10 U5552/net14 VSS nmos W=0.17u L=0.04u
M18147 U5552/net4 n5077 VSS VSS nmos W=0.155u L=0.04u
M18148 U5552/net6 U5552/net4 VSS VSS nmos W=0.17u L=0.04u
M18149 n5075 U5552/net14 VSS VSS nmos W=0.155u L=0.04u
M18150 U5552/net10 n5076 VSS VSS nmos W=0.155u L=0.04u
M18151 U5552/net4 U5552/net10 U5552/net14 VDD pmos W=0.255u L=0.04u
M18152 U5552/net6 n5076 U5552/net14 VDD pmos W=0.28u L=0.04u
M18153 U5552/net4 n5077 VDD VDD pmos W=0.205u L=0.04u
M18154 U5552/net6 U5552/net4 VDD VDD pmos W=0.24u L=0.04u
M18155 n5075 U5552/net14 VDD VDD pmos W=0.205u L=0.04u
M18156 U5552/net10 n5076 VDD VDD pmos W=0.205u L=0.04u
M18157 n5076 U5553/net6 VSS VSS nmos W=0.155u L=0.04u
M18158 U5553/X_u2-net6 n5047 VSS VSS nmos W=0.155u L=0.04u
M18159 U5553/net6 n5078 U5553/X_u2-net6 VSS nmos W=0.155u L=0.04u
M18160 n5076 U5553/net6 VDD VDD pmos W=0.205u L=0.04u
M18161 U5553/net6 n5047 VDD VDD pmos W=0.205u L=0.04u
M18162 U5553/net6 n5078 VDD VDD pmos W=0.205u L=0.04u
M18163 n3019 n4333 U5554/net10 VSS nmos W=0.155u L=0.04u
M18164 U5554/net10 n5080 VSS VSS nmos W=0.155u L=0.04u
M18165 n3019 n5079 U5554/net10 VSS nmos W=0.155u L=0.04u
M18166 U5554/net10 g1010 VSS VSS nmos W=0.155u L=0.04u
M18167 U5554/net30 n5080 VDD VDD pmos W=0.205u L=0.04u
M18168 n3019 n4333 U5554/net24 VDD pmos W=0.205u L=0.04u
M18169 U5554/net24 n5079 VDD VDD pmos W=0.205u L=0.04u
M18170 n3019 g1010 U5554/net30 VDD pmos W=0.205u L=0.04u
M18171 n5080 n4333 VSS VSS nmos W=0.155u L=0.04u
M18172 n5080 n5081 VSS VSS nmos W=0.155u L=0.04u
M18173 U5555/XI1-net8 n5081 VDD VDD pmos W=0.205u L=0.04u
M18174 n5080 n4333 U5555/XI1-net8 VDD pmos W=0.205u L=0.04u
M18175 n3018 n4970 U5556/net10 VSS nmos W=0.155u L=0.04u
M18176 U5556/net10 n5082 VSS VSS nmos W=0.155u L=0.04u
M18177 n3018 n5079 U5556/net10 VSS nmos W=0.155u L=0.04u
M18178 U5556/net10 g1009 VSS VSS nmos W=0.155u L=0.04u
M18179 U5556/net30 n5082 VDD VDD pmos W=0.205u L=0.04u
M18180 n3018 n4970 U5556/net24 VDD pmos W=0.205u L=0.04u
M18181 U5556/net24 n5079 VDD VDD pmos W=0.205u L=0.04u
M18182 n3018 g1009 U5556/net30 VDD pmos W=0.205u L=0.04u
M18183 n5082 n4970 VSS VSS nmos W=0.155u L=0.04u
M18184 n5082 n5081 VSS VSS nmos W=0.155u L=0.04u
M18185 U5557/XI1-net8 n5081 VDD VDD pmos W=0.205u L=0.04u
M18186 n5082 n4970 U5557/XI1-net8 VDD pmos W=0.205u L=0.04u
M18187 n3017 n4971 U5558/net10 VSS nmos W=0.155u L=0.04u
M18188 U5558/net10 n5083 VSS VSS nmos W=0.155u L=0.04u
M18189 n3017 n5079 U5558/net10 VSS nmos W=0.155u L=0.04u
M18190 U5558/net10 g1008 VSS VSS nmos W=0.155u L=0.04u
M18191 U5558/net30 n5083 VDD VDD pmos W=0.205u L=0.04u
M18192 n3017 n4971 U5558/net24 VDD pmos W=0.205u L=0.04u
M18193 U5558/net24 n5079 VDD VDD pmos W=0.205u L=0.04u
M18194 n3017 g1008 U5558/net30 VDD pmos W=0.205u L=0.04u
M18195 n5083 n4971 VSS VSS nmos W=0.155u L=0.04u
M18196 n5083 n5081 VSS VSS nmos W=0.155u L=0.04u
M18197 U5559/XI1-net8 n5081 VDD VDD pmos W=0.205u L=0.04u
M18198 n5083 n4971 U5559/XI1-net8 VDD pmos W=0.205u L=0.04u
M18199 n5079 U5560/net7 VSS VSS nmos W=0.155u L=0.04u
M18200 U5560/net7 n5084 VSS VSS nmos W=0.155u L=0.04u
M18201 U5560/net7 n5081 VSS VSS nmos W=0.155u L=0.04u
M18202 n5079 U5560/net7 VDD VDD pmos W=0.205u L=0.04u
M18203 U5560/X_u7-net8 n5081 VDD VDD pmos W=0.205u L=0.04u
M18204 U5560/net7 n5084 U5560/X_u7-net8 VDD pmos W=0.205u L=0.04u
M18205 n5081 U5561/net28 VSS VSS nmos W=0.155u L=0.04u
M18206 U5561/net47 n5085 VSS VSS nmos W=0.155u L=0.04u
M18207 U5561/net28 U5561/net6 U5561/net47 VSS nmos W=0.155u L=0.04u
M18208 U5561/net44 n4979 VSS VSS nmos W=0.155u L=0.04u
M18209 U5561/net28 n4173 U5561/net44 VSS nmos W=0.155u L=0.04u
M18210 U5561/net6 n4173 VSS VSS nmos W=0.155u L=0.04u
M18211 n5081 U5561/net28 VDD VDD pmos W=0.205u L=0.04u
M18212 VDD n5085 U5561/net47 VDD pmos W=0.205u L=0.04u
M18213 U5561/net47 n4173 U5561/net28 VDD pmos W=0.205u L=0.04u
M18214 U5561/net44 U5561/net6 U5561/net28 VDD pmos W=0.205u L=0.04u
M18215 VDD n4979 U5561/net44 VDD pmos W=0.205u L=0.04u
M18216 VDD n4173 U5561/net6 VDD pmos W=0.205u L=0.04u
M18217 n5084 n5086 U5562/net23 VDD pmos W=0.205u L=0.04u
M18218 n5084 n5087 U5562/net23 VDD pmos W=0.205u L=0.04u
M18219 n5084 n5028 U5562/net23 VDD pmos W=0.205u L=0.04u
M18220 U5562/net23 n5022 VDD VDD pmos W=0.205u L=0.04u
M18221 U5562/net23 n4173 VDD VDD pmos W=0.205u L=0.04u
M18222 U5562/XI20-net13 n5087 VSS VSS nmos W=0.155u L=0.04u
M18223 n5084 n5086 U5562/XI20-net17 VSS nmos W=0.155u L=0.04u
M18224 U5562/XI20-net17 n5028 U5562/XI20-net13 VSS nmos W=0.155u L=0.04u
M18225 n5084 n5022 U5562/XI17-net17 VSS nmos W=0.155u L=0.04u
M18226 U5562/XI17-net17 n4173 VSS VSS nmos W=0.155u L=0.04u
M18227 U5563/net19 n4970 VSS VSS nmos W=0.155u L=0.04u
M18228 n3016 n4970 U5563/net40 VSS nmos W=0.155u L=0.04u
M18229 n3016 U5563/net19 U5563/net36 VSS nmos W=0.155u L=0.04u
M18230 U5563/net40 g1005 VSS VSS nmos W=0.31u L=0.04u
M18231 U5563/net36 n5088 VSS VSS nmos W=0.155u L=0.04u
M18232 U5563/net19 n4970 VDD VDD pmos W=0.205u L=0.04u
M18233 n3016 U5563/net19 U5563/net26 VDD pmos W=0.325u L=0.04u
M18234 U5563/net26 g1005 VDD VDD pmos W=0.41u L=0.04u
M18235 n3016 n4970 U5563/net30 VDD pmos W=0.325u L=0.04u
M18236 U5563/net30 n5088 VDD VDD pmos W=0.205u L=0.04u
M18237 U5564/net19 n4333 VSS VSS nmos W=0.155u L=0.04u
M18238 n3015 n4333 U5564/net40 VSS nmos W=0.155u L=0.04u
M18239 n3015 U5564/net19 U5564/net36 VSS nmos W=0.155u L=0.04u
M18240 U5564/net40 g1006 VSS VSS nmos W=0.31u L=0.04u
M18241 U5564/net36 n5088 VSS VSS nmos W=0.155u L=0.04u
M18242 U5564/net19 n4333 VDD VDD pmos W=0.205u L=0.04u
M18243 n3015 U5564/net19 U5564/net26 VDD pmos W=0.325u L=0.04u
M18244 U5564/net26 g1006 VDD VDD pmos W=0.41u L=0.04u
M18245 n3015 n4333 U5564/net30 VDD pmos W=0.325u L=0.04u
M18246 U5564/net30 n5088 VDD VDD pmos W=0.205u L=0.04u
M18247 U5565/net19 n4971 VSS VSS nmos W=0.155u L=0.04u
M18248 n3014 n4971 U5565/net40 VSS nmos W=0.155u L=0.04u
M18249 n3014 U5565/net19 U5565/net36 VSS nmos W=0.155u L=0.04u
M18250 U5565/net40 g1007 VSS VSS nmos W=0.31u L=0.04u
M18251 U5565/net36 n5088 VSS VSS nmos W=0.155u L=0.04u
M18252 U5565/net19 n4971 VDD VDD pmos W=0.205u L=0.04u
M18253 n3014 U5565/net19 U5565/net26 VDD pmos W=0.325u L=0.04u
M18254 U5565/net26 g1007 VDD VDD pmos W=0.41u L=0.04u
M18255 n3014 n4971 U5565/net30 VDD pmos W=0.325u L=0.04u
M18256 U5565/net30 n5088 VDD VDD pmos W=0.205u L=0.04u
M18257 n5088 U5566/net6 VSS VSS nmos W=0.155u L=0.04u
M18258 U5566/X_u2-net6 n5025 VSS VSS nmos W=0.155u L=0.04u
M18259 U5566/net6 n5089 U5566/X_u2-net6 VSS nmos W=0.155u L=0.04u
M18260 n5088 U5566/net6 VDD VDD pmos W=0.205u L=0.04u
M18261 U5566/net6 n5025 VDD VDD pmos W=0.205u L=0.04u
M18262 U5566/net6 n5089 VDD VDD pmos W=0.205u L=0.04u
M18263 U5567/net4 n5090 U5567/net14 VSS nmos W=0.155u L=0.04u
M18264 U5567/net6 U5567/net10 U5567/net14 VSS nmos W=0.17u L=0.04u
M18265 U5567/net4 n5087 VSS VSS nmos W=0.155u L=0.04u
M18266 U5567/net6 U5567/net4 VSS VSS nmos W=0.17u L=0.04u
M18267 n5089 U5567/net14 VSS VSS nmos W=0.155u L=0.04u
M18268 U5567/net10 n5090 VSS VSS nmos W=0.155u L=0.04u
M18269 U5567/net4 U5567/net10 U5567/net14 VDD pmos W=0.255u L=0.04u
M18270 U5567/net6 n5090 U5567/net14 VDD pmos W=0.28u L=0.04u
M18271 U5567/net4 n5087 VDD VDD pmos W=0.205u L=0.04u
M18272 U5567/net6 U5567/net4 VDD VDD pmos W=0.24u L=0.04u
M18273 n5089 U5567/net14 VDD VDD pmos W=0.205u L=0.04u
M18274 U5567/net10 n5090 VDD VDD pmos W=0.205u L=0.04u
M18275 n5090 n5091 U5568/net23 VDD pmos W=0.205u L=0.04u
M18276 n5090 n5092 U5568/net23 VDD pmos W=0.205u L=0.04u
M18277 n5090 n5028 U5568/net23 VDD pmos W=0.205u L=0.04u
M18278 U5568/net23 n5087 VDD VDD pmos W=0.205u L=0.04u
M18279 U5568/net23 n5093 VDD VDD pmos W=0.205u L=0.04u
M18280 U5568/XI20-net13 n5092 VSS VSS nmos W=0.155u L=0.04u
M18281 n5090 n5091 U5568/XI20-net17 VSS nmos W=0.155u L=0.04u
M18282 U5568/XI20-net17 n5028 U5568/XI20-net13 VSS nmos W=0.155u L=0.04u
M18283 n5090 n5087 U5568/XI17-net17 VSS nmos W=0.155u L=0.04u
M18284 U5568/XI17-net17 n5093 VSS VSS nmos W=0.155u L=0.04u
M18285 VSS n5028 U5569/net22 VSS nmos W=0.155u L=0.04u
M18286 U5569/net22 n4979 n5093 VSS nmos W=0.155u L=0.04u
M18287 U5569/net22 n5094 n5093 VSS nmos W=0.155u L=0.04u
M18288 U5569/net22 n5026 n5093 VSS nmos W=0.155u L=0.04u
M18289 U5569/net38 n5026 VDD VDD pmos W=0.205u L=0.04u
M18290 U5569/net35 n5094 U5569/net38 VDD pmos W=0.205u L=0.04u
M18291 n5093 n4979 U5569/net35 VDD pmos W=0.205u L=0.04u
M18292 n5093 n5028 VDD VDD pmos W=0.205u L=0.04u
M18293 n4979 g996 VSS VSS nmos W=0.135u L=0.04u
M18294 n4979 g996 VDD VDD pmos W=0.205u L=0.04u
M18295 n5092 n5085 U5571/net27 VSS nmos W=0.155u L=0.04u
M18296 U5571/net27 n5095 VSS VSS nmos W=0.155u L=0.04u
M18297 n5092 n5096 VSS VSS nmos W=0.155u L=0.04u
M18298 n5092 n5095 U5571/net13 VDD pmos W=0.205u L=0.04u
M18299 U5571/net13 n5096 VDD VDD pmos W=0.205u L=0.04u
M18300 n5092 n5085 U5571/net13 VDD pmos W=0.205u L=0.04u
M18301 U5572/net19 n4970 VSS VSS nmos W=0.155u L=0.04u
M18302 n3013 n4970 U5572/net40 VSS nmos W=0.155u L=0.04u
M18303 n3013 U5572/net19 U5572/net36 VSS nmos W=0.155u L=0.04u
M18304 U5572/net40 g1002 VSS VSS nmos W=0.31u L=0.04u
M18305 U5572/net36 n5097 VSS VSS nmos W=0.155u L=0.04u
M18306 U5572/net19 n4970 VDD VDD pmos W=0.205u L=0.04u
M18307 n3013 U5572/net19 U5572/net26 VDD pmos W=0.325u L=0.04u
M18308 U5572/net26 g1002 VDD VDD pmos W=0.41u L=0.04u
M18309 n3013 n4970 U5572/net30 VDD pmos W=0.325u L=0.04u
M18310 U5572/net30 n5097 VDD VDD pmos W=0.205u L=0.04u
M18311 U5573/net19 n4333 VSS VSS nmos W=0.155u L=0.04u
M18312 n3012 n4333 U5573/net40 VSS nmos W=0.155u L=0.04u
M18313 n3012 U5573/net19 U5573/net36 VSS nmos W=0.155u L=0.04u
M18314 U5573/net40 g1003 VSS VSS nmos W=0.31u L=0.04u
M18315 U5573/net36 n5097 VSS VSS nmos W=0.155u L=0.04u
M18316 U5573/net19 n4333 VDD VDD pmos W=0.205u L=0.04u
M18317 n3012 U5573/net19 U5573/net26 VDD pmos W=0.325u L=0.04u
M18318 U5573/net26 g1003 VDD VDD pmos W=0.41u L=0.04u
M18319 n3012 n4333 U5573/net30 VDD pmos W=0.325u L=0.04u
M18320 U5573/net30 n5097 VDD VDD pmos W=0.205u L=0.04u
M18321 U5574/net19 n4971 VSS VSS nmos W=0.155u L=0.04u
M18322 n3011 n4971 U5574/net40 VSS nmos W=0.155u L=0.04u
M18323 n3011 U5574/net19 U5574/net36 VSS nmos W=0.155u L=0.04u
M18324 U5574/net40 g1004 VSS VSS nmos W=0.31u L=0.04u
M18325 U5574/net36 n5097 VSS VSS nmos W=0.155u L=0.04u
M18326 U5574/net19 n4971 VDD VDD pmos W=0.205u L=0.04u
M18327 n3011 U5574/net19 U5574/net26 VDD pmos W=0.325u L=0.04u
M18328 U5574/net26 g1004 VDD VDD pmos W=0.41u L=0.04u
M18329 n3011 n4971 U5574/net30 VDD pmos W=0.325u L=0.04u
M18330 U5574/net30 n5097 VDD VDD pmos W=0.205u L=0.04u
M18331 n5097 U5575/net6 VSS VSS nmos W=0.155u L=0.04u
M18332 U5575/X_u2-net6 n5025 VSS VSS nmos W=0.155u L=0.04u
M18333 U5575/net6 n5098 U5575/X_u2-net6 VSS nmos W=0.155u L=0.04u
M18334 n5097 U5575/net6 VDD VDD pmos W=0.205u L=0.04u
M18335 U5575/net6 n5025 VDD VDD pmos W=0.205u L=0.04u
M18336 U5575/net6 n5098 VDD VDD pmos W=0.205u L=0.04u
M18337 U5576/net4 n5099 U5576/net14 VSS nmos W=0.155u L=0.04u
M18338 U5576/net6 U5576/net10 U5576/net14 VSS nmos W=0.17u L=0.04u
M18339 U5576/net4 n5094 VSS VSS nmos W=0.155u L=0.04u
M18340 U5576/net6 U5576/net4 VSS VSS nmos W=0.17u L=0.04u
M18341 n5098 U5576/net14 VSS VSS nmos W=0.155u L=0.04u
M18342 U5576/net10 n5099 VSS VSS nmos W=0.155u L=0.04u
M18343 U5576/net4 U5576/net10 U5576/net14 VDD pmos W=0.255u L=0.04u
M18344 U5576/net6 n5099 U5576/net14 VDD pmos W=0.28u L=0.04u
M18345 U5576/net4 n5094 VDD VDD pmos W=0.205u L=0.04u
M18346 U5576/net6 U5576/net4 VDD VDD pmos W=0.24u L=0.04u
M18347 n5098 U5576/net14 VDD VDD pmos W=0.205u L=0.04u
M18348 U5576/net10 n5099 VDD VDD pmos W=0.205u L=0.04u
M18349 n5099 n5100 VSS VSS nmos W=0.155u L=0.04u
M18350 n5099 n5101 VSS VSS nmos W=0.155u L=0.04u
M18351 U5577/XI1-net8 n5101 VDD VDD pmos W=0.205u L=0.04u
M18352 n5099 n5100 U5577/XI1-net8 VDD pmos W=0.205u L=0.04u
M18353 U5578/PG2 n5087 VSS VSS nmos W=0.31u L=0.04u
M18354 U5578/net55 n5103 VSS VSS nmos W=0.31u L=0.04u
M18355 U5578/net51 n5094 VSS VSS nmos W=0.155u L=0.04u
M18356 U5578/net53 n5102 VSS VSS nmos W=0.155u L=0.04u
M18357 U5578/net29 n5104 VSS VSS nmos W=0.155u L=0.04u
M18358 U5578/net53 U5578/net51 U5578/PG1 VSS nmos W=0.155u L=0.04u
M18359 U5578/net55 n5094 U5578/PG1 VSS nmos W=0.21u L=0.04u
M18360 U5578/PG2 n5104 n5101 VSS nmos W=0.22u L=0.04u
M18361 U5578/PG1 U5578/net29 n5101 VSS nmos W=0.155u L=0.04u
M18362 U5578/PG2 n5087 VDD VDD pmos W=0.41u L=0.04u
M18363 U5578/net55 n5103 VDD VDD pmos W=0.41u L=0.04u
M18364 U5578/net51 n5094 VDD VDD pmos W=0.205u L=0.04u
M18365 U5578/net53 n5102 VDD VDD pmos W=0.28u L=0.04u
M18366 U5578/net29 n5104 VDD VDD pmos W=0.205u L=0.04u
M18367 U5578/net53 n5094 U5578/PG1 VDD pmos W=0.27u L=0.04u
M18368 U5578/net55 U5578/net51 U5578/PG1 VDD pmos W=0.285u L=0.04u
M18369 U5578/PG2 U5578/net29 n5101 VDD pmos W=0.205u L=0.04u
M18370 U5578/PG1 n5104 n5101 VDD pmos W=0.28u L=0.04u
M18371 VSS n5106 U5579/net22 VSS nmos W=0.155u L=0.04u
M18372 U5579/net22 n5095 n5103 VSS nmos W=0.155u L=0.04u
M18373 U5579/net22 n5105 n5103 VSS nmos W=0.155u L=0.04u
M18374 U5579/net22 n5085 n5103 VSS nmos W=0.155u L=0.04u
M18375 U5579/net38 n5085 VDD VDD pmos W=0.205u L=0.04u
M18376 U5579/net35 n5105 U5579/net38 VDD pmos W=0.205u L=0.04u
M18377 n5103 n5095 U5579/net35 VDD pmos W=0.205u L=0.04u
M18378 n5103 n5106 VDD VDD pmos W=0.205u L=0.04u
M18379 U5580/XU1-net6 n5108 VSS VSS nmos W=0.155u L=0.04u
M18380 n5085 n5107 U5580/XU1-net6 VSS nmos W=0.155u L=0.04u
M18381 n5085 n5108 VDD VDD pmos W=0.155u L=0.04u
M18382 n5085 n5107 VDD VDD pmos W=0.155u L=0.04u
M18383 n5102 n5095 U5581/net23 VDD pmos W=0.205u L=0.04u
M18384 n5102 n5109 U5581/net23 VDD pmos W=0.205u L=0.04u
M18385 n5102 n4995 U5581/net23 VDD pmos W=0.205u L=0.04u
M18386 U5581/net23 n5110 VDD VDD pmos W=0.205u L=0.04u
M18387 U5581/net23 n5111 VDD VDD pmos W=0.205u L=0.04u
M18388 U5581/XI20-net13 n5109 VSS VSS nmos W=0.155u L=0.04u
M18389 n5102 n5095 U5581/XI20-net17 VSS nmos W=0.155u L=0.04u
M18390 U5581/XI20-net17 n4995 U5581/XI20-net13 VSS nmos W=0.155u L=0.04u
M18391 n5102 n5110 U5581/XI17-net17 VSS nmos W=0.155u L=0.04u
M18392 U5581/XI17-net17 n5111 VSS VSS nmos W=0.155u L=0.04u
M18393 n5111 n5091 VSS VSS nmos W=0.135u L=0.04u
M18394 n5111 n5091 VDD VDD pmos W=0.205u L=0.04u
M18395 U5583/net36 n4995 U5583/net24 VSS nmos W=0.155u L=0.04u
M18396 U5583/net24 n5087 VSS VSS nmos W=0.155u L=0.04u
M18397 n5091 n5112 U5583/net36 VSS nmos W=0.155u L=0.04u
M18398 n5091 n5108 U5583/net36 VSS nmos W=0.155u L=0.04u
M18399 n5091 n5108 U5583/net35 VDD pmos W=0.205u L=0.04u
M18400 U5583/net35 n5112 VDD VDD pmos W=0.205u L=0.04u
M18401 n5091 n5087 VDD VDD pmos W=0.205u L=0.04u
M18402 n5091 n4995 VDD VDD pmos W=0.205u L=0.04u
M18403 U5584/p2 n5116 VSS VSS nmos W=0.155u L=0.04u
M18404 U5584/p0 n5114 U5584/p1 VSS nmos W=0.155u L=0.04u
M18405 U5584/p1 n5115 U5584/p2 VSS nmos W=0.155u L=0.04u
M18406 n5108 n5113 U5584/p0 VSS nmos W=0.155u L=0.04u
M18407 n5108 n5115 VDD VDD pmos W=0.205u L=0.04u
M18408 n5108 n5114 VDD VDD pmos W=0.205u L=0.04u
M18409 n5108 n5113 VDD VDD pmos W=0.205u L=0.04u
M18410 n5108 n5116 VDD VDD pmos W=0.205u L=0.04u
M18411 U5585/net7 n5117 U5585/X_u4-net10 VSS nmos W=0.155u L=0.04u
M18412 U5585/X_u4-net10 n5118 U5585/X_u4-net13 VSS nmos W=0.155u L=0.04u
M18413 U5585/X_u4-net13 n5119 VSS VSS nmos W=0.155u L=0.04u
M18414 n5116 U5585/net7 VSS VSS nmos W=0.155u L=0.04u
M18415 U5585/net7 n5119 VDD VDD pmos W=0.205u L=0.04u
M18416 U5585/net7 n5117 VDD VDD pmos W=0.205u L=0.04u
M18417 U5585/net7 n5118 VDD VDD pmos W=0.205u L=0.04u
M18418 n5116 U5585/net7 VDD VDD pmos W=0.205u L=0.04u
M18419 n5110 n5086 U5586/net27 VSS nmos W=0.155u L=0.04u
M18420 U5586/net27 n5120 VSS VSS nmos W=0.155u L=0.04u
M18421 n5110 n5105 VSS VSS nmos W=0.155u L=0.04u
M18422 n5110 n5120 U5586/net13 VDD pmos W=0.205u L=0.04u
M18423 U5586/net13 n5105 VDD VDD pmos W=0.205u L=0.04u
M18424 n5110 n5086 U5586/net13 VDD pmos W=0.205u L=0.04u
M18425 n5105 n5121 VSS VSS nmos W=0.135u L=0.04u
M18426 n5105 n5121 VDD VDD pmos W=0.205u L=0.04u
M18427 n4995 n5003 VSS VSS nmos W=0.135u L=0.04u
M18428 n4995 n5003 VDD VDD pmos W=0.205u L=0.04u
M18429 U5589/net19 n4990 VSS VSS nmos W=0.155u L=0.04u
M18430 n3010 n4990 U5589/net40 VSS nmos W=0.155u L=0.04u
M18431 n3010 U5589/net19 U5589/net36 VSS nmos W=0.155u L=0.04u
M18432 U5589/net40 g945 VSS VSS nmos W=0.31u L=0.04u
M18433 U5589/net36 n5122 VSS VSS nmos W=0.155u L=0.04u
M18434 U5589/net19 n4990 VDD VDD pmos W=0.205u L=0.04u
M18435 n3010 U5589/net19 U5589/net26 VDD pmos W=0.325u L=0.04u
M18436 U5589/net26 g945 VDD VDD pmos W=0.41u L=0.04u
M18437 n3010 n4990 U5589/net30 VDD pmos W=0.325u L=0.04u
M18438 U5589/net30 n5122 VDD VDD pmos W=0.205u L=0.04u
M18439 U5590/net19 n4989 VSS VSS nmos W=0.155u L=0.04u
M18440 n3009 n4989 U5590/net40 VSS nmos W=0.155u L=0.04u
M18441 n3009 U5590/net19 U5590/net36 VSS nmos W=0.155u L=0.04u
M18442 U5590/net40 g948 VSS VSS nmos W=0.31u L=0.04u
M18443 U5590/net36 n5122 VSS VSS nmos W=0.155u L=0.04u
M18444 U5590/net19 n4989 VDD VDD pmos W=0.205u L=0.04u
M18445 n3009 U5590/net19 U5590/net26 VDD pmos W=0.325u L=0.04u
M18446 U5590/net26 g948 VDD VDD pmos W=0.41u L=0.04u
M18447 n3009 n4989 U5590/net30 VDD pmos W=0.325u L=0.04u
M18448 U5590/net30 n5122 VDD VDD pmos W=0.205u L=0.04u
M18449 U5591/net19 n4991 VSS VSS nmos W=0.155u L=0.04u
M18450 n3008 n4991 U5591/net40 VSS nmos W=0.155u L=0.04u
M18451 n3008 U5591/net19 U5591/net36 VSS nmos W=0.155u L=0.04u
M18452 U5591/net40 g951 VSS VSS nmos W=0.31u L=0.04u
M18453 U5591/net36 n5122 VSS VSS nmos W=0.155u L=0.04u
M18454 U5591/net19 n4991 VDD VDD pmos W=0.205u L=0.04u
M18455 n3008 U5591/net19 U5591/net26 VDD pmos W=0.325u L=0.04u
M18456 U5591/net26 g951 VDD VDD pmos W=0.41u L=0.04u
M18457 n3008 n4991 U5591/net30 VDD pmos W=0.325u L=0.04u
M18458 U5591/net30 n5122 VDD VDD pmos W=0.205u L=0.04u
M18459 n5122 n5016 U5592/net10 VSS nmos W=0.155u L=0.04u
M18460 U5592/net10 n5123 VSS VSS nmos W=0.155u L=0.04u
M18461 n5122 n5031 U5592/net10 VSS nmos W=0.155u L=0.04u
M18462 U5592/net10 n5032 VSS VSS nmos W=0.155u L=0.04u
M18463 U5592/net30 n5123 VDD VDD pmos W=0.205u L=0.04u
M18464 n5122 n5016 U5592/net24 VDD pmos W=0.205u L=0.04u
M18465 U5592/net24 n5031 VDD VDD pmos W=0.205u L=0.04u
M18466 n5122 n5032 U5592/net30 VDD pmos W=0.205u L=0.04u
M18467 U5593/net4 n5124 U5593/net14 VSS nmos W=0.155u L=0.04u
M18468 U5593/net6 U5593/net10 U5593/net14 VSS nmos W=0.17u L=0.04u
M18469 U5593/net4 n5125 VSS VSS nmos W=0.155u L=0.04u
M18470 U5593/net6 U5593/net4 VSS VSS nmos W=0.17u L=0.04u
M18471 n5123 U5593/net14 VSS VSS nmos W=0.155u L=0.04u
M18472 U5593/net10 n5124 VSS VSS nmos W=0.155u L=0.04u
M18473 U5593/net4 U5593/net10 U5593/net14 VDD pmos W=0.255u L=0.04u
M18474 U5593/net6 n5124 U5593/net14 VDD pmos W=0.28u L=0.04u
M18475 U5593/net4 n5125 VDD VDD pmos W=0.205u L=0.04u
M18476 U5593/net6 U5593/net4 VDD VDD pmos W=0.24u L=0.04u
M18477 n5123 U5593/net14 VDD VDD pmos W=0.205u L=0.04u
M18478 U5593/net10 n5124 VDD VDD pmos W=0.205u L=0.04u
M18479 n5124 n5034 U5594/net15 VSS nmos W=0.155u L=0.04u
M18480 n5124 n5056 U5594/net15 VSS nmos W=0.155u L=0.04u
M18481 U5594/net15 n5062 VSS VSS nmos W=0.155u L=0.04u
M18482 n5124 n5062 VDD VDD pmos W=0.205u L=0.04u
M18483 n5124 n5034 U5594/XI16-net11 VDD pmos W=0.205u L=0.04u
M18484 U5594/XI16-net11 n5056 VDD VDD pmos W=0.205u L=0.04u
M18485 U5595/net14 n5029 U5595/net20 VSS nmos W=0.155u L=0.04u
M18486 U5595/net14 n5063 U5595/net20 VSS nmos W=0.155u L=0.04u
M18487 U5595/net20 n5035 VSS VSS nmos W=0.155u L=0.04u
M18488 n5062 U5595/net14 VSS VSS nmos W=0.155u L=0.04u
M18489 n5062 U5595/net14 VDD VDD pmos W=0.205u L=0.04u
M18490 U5595/net14 n5035 VDD VDD pmos W=0.205u L=0.04u
M18491 U5595/net24 n5029 VDD VDD pmos W=0.205u L=0.04u
M18492 U5595/net14 n5063 U5595/net24 VDD pmos W=0.205u L=0.04u
M18493 U5596/net7 n5041 U5596/X_u4-net10 VSS nmos W=0.155u L=0.04u
M18494 U5596/X_u4-net10 n5126 U5596/X_u4-net13 VSS nmos W=0.155u L=0.04u
M18495 U5596/X_u4-net13 n5040 VSS VSS nmos W=0.155u L=0.04u
M18496 n5035 U5596/net7 VSS VSS nmos W=0.155u L=0.04u
M18497 U5596/net7 n5040 VDD VDD pmos W=0.205u L=0.04u
M18498 U5596/net7 n5041 VDD VDD pmos W=0.205u L=0.04u
M18499 U5596/net7 n5126 VDD VDD pmos W=0.205u L=0.04u
M18500 n5035 U5596/net7 VDD VDD pmos W=0.205u L=0.04u
M18501 n5040 n5070 VSS VSS nmos W=0.155u L=0.04u
M18502 n5040 U5597/net4 VSS VSS nmos W=0.155u L=0.04u
M18503 U5597/net4 n5127 VSS VSS nmos W=0.155u L=0.04u
M18504 U5597/XU1-net8 U5597/net4 VDD VDD pmos W=0.205u L=0.04u
M18505 n5040 n5070 U5597/XU1-net8 VDD pmos W=0.205u L=0.04u
M18506 U5597/net4 n5127 VDD VDD pmos W=0.205u L=0.04u
M18507 n5070 n5069 U5598/net15 VSS nmos W=0.155u L=0.04u
M18508 n5070 n5029 U5598/net15 VSS nmos W=0.155u L=0.04u
M18509 U5598/net15 n5073 VSS VSS nmos W=0.155u L=0.04u
M18510 n5070 n5073 VDD VDD pmos W=0.205u L=0.04u
M18511 n5070 n5069 U5598/XI16-net11 VDD pmos W=0.205u L=0.04u
M18512 U5598/XI16-net11 n5029 VDD VDD pmos W=0.205u L=0.04u
M18513 U5599/net7 n5128 U5599/X_u4-net10 VSS nmos W=0.155u L=0.04u
M18514 U5599/X_u4-net10 n5047 U5599/X_u4-net13 VSS nmos W=0.155u L=0.04u
M18515 U5599/X_u4-net13 n5078 VSS VSS nmos W=0.155u L=0.04u
M18516 n5073 U5599/net7 VSS VSS nmos W=0.155u L=0.04u
M18517 U5599/net7 n5078 VDD VDD pmos W=0.205u L=0.04u
M18518 U5599/net7 n5128 VDD VDD pmos W=0.205u L=0.04u
M18519 U5599/net7 n5047 VDD VDD pmos W=0.205u L=0.04u
M18520 n5073 U5599/net7 VDD VDD pmos W=0.205u L=0.04u
M18521 U5600/net4 n5056 U5600/net14 VSS nmos W=0.155u L=0.04u
M18522 U5600/net6 U5600/net10 U5600/net14 VSS nmos W=0.17u L=0.04u
M18523 U5600/net4 n5129 VSS VSS nmos W=0.155u L=0.04u
M18524 U5600/net6 U5600/net4 VSS VSS nmos W=0.17u L=0.04u
M18525 n5078 U5600/net14 VSS VSS nmos W=0.155u L=0.04u
M18526 U5600/net10 n5056 VSS VSS nmos W=0.155u L=0.04u
M18527 U5600/net4 U5600/net10 U5600/net14 VDD pmos W=0.255u L=0.04u
M18528 U5600/net6 n5056 U5600/net14 VDD pmos W=0.28u L=0.04u
M18529 U5600/net4 n5129 VDD VDD pmos W=0.205u L=0.04u
M18530 U5600/net6 U5600/net4 VDD VDD pmos W=0.24u L=0.04u
M18531 n5078 U5600/net14 VDD VDD pmos W=0.205u L=0.04u
M18532 U5600/net10 n5056 VDD VDD pmos W=0.205u L=0.04u
M18533 U5601/net4 n5029 U5601/net14 VSS nmos W=0.155u L=0.04u
M18534 U5601/net6 U5601/net10 U5601/net14 VSS nmos W=0.17u L=0.04u
M18535 U5601/net4 n5130 VSS VSS nmos W=0.155u L=0.04u
M18536 U5601/net6 U5601/net4 VSS VSS nmos W=0.17u L=0.04u
M18537 n5128 U5601/net14 VSS VSS nmos W=0.155u L=0.04u
M18538 U5601/net10 n5029 VSS VSS nmos W=0.155u L=0.04u
M18539 U5601/net4 U5601/net10 U5601/net14 VDD pmos W=0.255u L=0.04u
M18540 U5601/net6 n5029 U5601/net14 VDD pmos W=0.28u L=0.04u
M18541 U5601/net4 n5130 VDD VDD pmos W=0.205u L=0.04u
M18542 U5601/net6 U5601/net4 VDD VDD pmos W=0.24u L=0.04u
M18543 n5128 U5601/net14 VDD VDD pmos W=0.205u L=0.04u
M18544 U5601/net10 n5029 VDD VDD pmos W=0.205u L=0.04u
M18545 U5602/net19 n5131 VSS VSS nmos W=0.155u L=0.04u
M18546 n5127 n5131 U5602/net40 VSS nmos W=0.155u L=0.04u
M18547 n5127 U5602/net19 U5602/net36 VSS nmos W=0.155u L=0.04u
M18548 U5602/net40 n5069 VSS VSS nmos W=0.31u L=0.04u
M18549 U5602/net36 n5029 VSS VSS nmos W=0.155u L=0.04u
M18550 U5602/net19 n5131 VDD VDD pmos W=0.205u L=0.04u
M18551 n5127 U5602/net19 U5602/net26 VDD pmos W=0.325u L=0.04u
M18552 U5602/net26 n5069 VDD VDD pmos W=0.41u L=0.04u
M18553 n5127 n5131 U5602/net30 VDD pmos W=0.325u L=0.04u
M18554 U5602/net30 n5029 VDD VDD pmos W=0.205u L=0.04u
M18555 U5603/net4 n5029 U5603/net14 VSS nmos W=0.155u L=0.04u
M18556 U5603/net6 U5603/net10 U5603/net14 VSS nmos W=0.17u L=0.04u
M18557 U5603/net4 n5132 VSS VSS nmos W=0.155u L=0.04u
M18558 U5603/net6 U5603/net4 VSS VSS nmos W=0.17u L=0.04u
M18559 n5126 U5603/net14 VSS VSS nmos W=0.155u L=0.04u
M18560 U5603/net10 n5029 VSS VSS nmos W=0.155u L=0.04u
M18561 U5603/net4 U5603/net10 U5603/net14 VDD pmos W=0.255u L=0.04u
M18562 U5603/net6 n5029 U5603/net14 VDD pmos W=0.28u L=0.04u
M18563 U5603/net4 n5132 VDD VDD pmos W=0.205u L=0.04u
M18564 U5603/net6 U5603/net4 VDD VDD pmos W=0.24u L=0.04u
M18565 n5126 U5603/net14 VDD VDD pmos W=0.205u L=0.04u
M18566 U5603/net10 n5029 VDD VDD pmos W=0.205u L=0.04u
M18567 U5604/net4 n5029 U5604/net14 VSS nmos W=0.155u L=0.04u
M18568 U5604/net6 U5604/net10 U5604/net14 VSS nmos W=0.17u L=0.04u
M18569 U5604/net4 n5044 VSS VSS nmos W=0.155u L=0.04u
M18570 U5604/net6 U5604/net4 VSS VSS nmos W=0.17u L=0.04u
M18571 n5041 U5604/net14 VSS VSS nmos W=0.155u L=0.04u
M18572 U5604/net10 n5029 VSS VSS nmos W=0.155u L=0.04u
M18573 U5604/net4 U5604/net10 U5604/net14 VDD pmos W=0.255u L=0.04u
M18574 U5604/net6 n5029 U5604/net14 VDD pmos W=0.28u L=0.04u
M18575 U5604/net4 n5044 VDD VDD pmos W=0.205u L=0.04u
M18576 U5604/net6 U5604/net4 VDD VDD pmos W=0.24u L=0.04u
M18577 n5041 U5604/net14 VDD VDD pmos W=0.205u L=0.04u
M18578 U5604/net10 n5029 VDD VDD pmos W=0.205u L=0.04u
M18579 U5605/XU1-net6 n5060 VSS VSS nmos W=0.155u L=0.04u
M18580 n5031 n5032 U5605/XU1-net6 VSS nmos W=0.155u L=0.04u
M18581 n5031 n5060 VDD VDD pmos W=0.155u L=0.04u
M18582 n5031 n5032 VDD VDD pmos W=0.155u L=0.04u
M18583 U5606/net36 n5047 U5606/net24 VSS nmos W=0.155u L=0.04u
M18584 U5606/net24 n5135 VSS VSS nmos W=0.155u L=0.04u
M18585 n5060 n5133 U5606/net36 VSS nmos W=0.155u L=0.04u
M18586 n5060 n5134 U5606/net36 VSS nmos W=0.155u L=0.04u
M18587 n5060 n5134 U5606/net35 VDD pmos W=0.205u L=0.04u
M18588 U5606/net35 n5133 VDD VDD pmos W=0.205u L=0.04u
M18589 n5060 n5135 VDD VDD pmos W=0.205u L=0.04u
M18590 n5060 n5047 VDD VDD pmos W=0.205u L=0.04u
M18591 n5047 n5136 VSS VSS nmos W=0.135u L=0.04u
M18592 n5047 n5136 VDD VDD pmos W=0.205u L=0.04u
M18593 n5032 n5136 U5608/net15 VSS nmos W=0.155u L=0.04u
M18594 n5032 n5137 U5608/net15 VSS nmos W=0.155u L=0.04u
M18595 U5608/net15 n5135 VSS VSS nmos W=0.155u L=0.04u
M18596 n5032 n5135 VDD VDD pmos W=0.205u L=0.04u
M18597 n5032 n5136 U5608/XI16-net11 VDD pmos W=0.205u L=0.04u
M18598 U5608/XI16-net11 n5137 VDD VDD pmos W=0.205u L=0.04u
M18599 U5609/net32 n5138 U5609/net26 VSS nmos W=0.155u L=0.04u
M18600 U5609/net32 n5104 U5609/net26 VSS nmos W=0.155u L=0.04u
M18601 U5609/net29 n5025 VSS VSS nmos W=0.155u L=0.04u
M18602 U5609/net26 n5109 U5609/net29 VSS nmos W=0.155u L=0.04u
M18603 U5609/net26 n5027 U5609/net29 VSS nmos W=0.155u L=0.04u
M18604 n5135 U5609/net32 VSS VSS nmos W=0.155u L=0.04u
M18605 n5135 U5609/net32 VDD VDD pmos W=0.205u L=0.04u
M18606 U5609/net32 n5104 U5609/net43 VDD pmos W=0.205u L=0.04u
M18607 U5609/net32 n5027 U5609/net49 VDD pmos W=0.205u L=0.04u
M18608 U5609/net49 n5109 VDD VDD pmos W=0.205u L=0.04u
M18609 U5609/net43 n5138 VDD VDD pmos W=0.205u L=0.04u
M18610 U5609/net32 n5025 VDD VDD pmos W=0.205u L=0.04u
M18611 U5610/XU1-net6 n5021 VSS VSS nmos W=0.155u L=0.04u
M18612 n5025 n5022 U5610/XU1-net6 VSS nmos W=0.155u L=0.04u
M18613 n5025 n5021 VDD VDD pmos W=0.155u L=0.04u
M18614 n5025 n5022 VDD VDD pmos W=0.155u L=0.04u
M18615 n5021 n4970 U5611/net27 VSS nmos W=0.155u L=0.04u
M18616 U5611/net39 n4333 VSS VSS nmos W=0.155u L=0.04u
M18617 U5611/net27 g1089 U5611/net39 VSS nmos W=0.155u L=0.04u
M18618 U5611/net27 n4971 U5611/net39 VSS nmos W=0.155u L=0.04u
M18619 n5021 g1090 U5611/net27 VSS nmos W=0.155u L=0.04u
M18620 U5611/net39 g1091 VSS VSS nmos W=0.155u L=0.04u
M18621 n5021 n4333 U5611/net46 VDD pmos W=0.205u L=0.04u
M18622 U5611/net46 g1091 VDD VDD pmos W=0.205u L=0.04u
M18623 n5021 g1090 U5611/net34 VDD pmos W=0.205u L=0.04u
M18624 U5611/net34 n4970 VDD VDD pmos W=0.205u L=0.04u
M18625 n5021 n4971 U5611/net37 VDD pmos W=0.205u L=0.04u
M18626 U5611/net37 g1089 VDD VDD pmos W=0.205u L=0.04u
M18627 n5027 n4173 VSS VSS nmos W=0.135u L=0.04u
M18628 n5027 n4173 VDD VDD pmos W=0.205u L=0.04u
M18629 n4173 n5094 VSS VSS nmos W=0.155u L=0.04u
M18630 n4173 n5087 VSS VSS nmos W=0.155u L=0.04u
M18631 n4173 n5104 VSS VSS nmos W=0.155u L=0.04u
M18632 U5613/net25 n5094 VDD VDD pmos W=0.41u L=0.04u
M18633 U5613/net28 n5087 U5613/net25 VDD pmos W=0.41u L=0.04u
M18634 n4173 n5104 U5613/net28 VDD pmos W=0.41u L=0.04u
M18635 U5614/XU1-net6 n5120 VSS VSS nmos W=0.155u L=0.04u
M18636 n5109 n5022 U5614/XU1-net6 VSS nmos W=0.155u L=0.04u
M18637 n5109 n5120 VDD VDD pmos W=0.155u L=0.04u
M18638 n5109 n5022 VDD VDD pmos W=0.155u L=0.04u
M18639 n5022 n5139 VSS VSS nmos W=0.135u L=0.04u
M18640 n5022 n5139 VDD VDD pmos W=0.205u L=0.04u
M18641 n5138 n5096 U5616/net19 VDD pmos W=0.205u L=0.04u
M18642 n5138 n5086 U5616/net19 VDD pmos W=0.205u L=0.04u
M18643 n5138 n5120 U5616/net19 VDD pmos W=0.205u L=0.04u
M18644 U5616/net19 n5003 VDD VDD pmos W=0.205u L=0.04u
M18645 n5138 n5003 VSS VSS nmos W=0.155u L=0.04u
M18646 U5616/XI20-net13 n5086 VSS VSS nmos W=0.155u L=0.04u
M18647 n5138 n5096 U5616/XI20-net17 VSS nmos W=0.155u L=0.04u
M18648 U5616/XI20-net17 n5120 U5616/XI20-net13 VSS nmos W=0.155u L=0.04u
M18649 n5003 n5140 VSS VSS nmos W=0.155u L=0.04u
M18650 n5003 U5617/net4 VSS VSS nmos W=0.155u L=0.04u
M18651 U5617/net4 g869 VSS VSS nmos W=0.155u L=0.04u
M18652 U5617/XU1-net8 U5617/net4 VDD VDD pmos W=0.205u L=0.04u
M18653 n5003 n5140 U5617/XU1-net8 VDD pmos W=0.205u L=0.04u
M18654 U5617/net4 g869 VDD VDD pmos W=0.205u L=0.04u
M18655 n5086 n5026 VSS VSS nmos W=0.155u L=0.04u
M18656 n5086 n5139 VSS VSS nmos W=0.155u L=0.04u
M18657 U5618/XI1-net8 n5139 VDD VDD pmos W=0.205u L=0.04u
M18658 n5086 n5026 U5618/XI1-net8 VDD pmos W=0.205u L=0.04u
M18659 U5619/p2 n5144 VSS VSS nmos W=0.155u L=0.04u
M18660 U5619/p0 n5142 U5619/p1 VSS nmos W=0.155u L=0.04u
M18661 U5619/p1 n5143 U5619/p2 VSS nmos W=0.155u L=0.04u
M18662 n5139 n5141 U5619/p0 VSS nmos W=0.155u L=0.04u
M18663 n5139 n5143 VDD VDD pmos W=0.205u L=0.04u
M18664 n5139 n5142 VDD VDD pmos W=0.205u L=0.04u
M18665 n5139 n5141 VDD VDD pmos W=0.205u L=0.04u
M18666 n5139 n5144 VDD VDD pmos W=0.205u L=0.04u
M18667 n5144 n5148 VSS VSS nmos W=0.155u L=0.04u
M18668 n5144 n5147 VSS VSS nmos W=0.155u L=0.04u
M18669 n5144 n5146 VSS VSS nmos W=0.155u L=0.04u
M18670 n5144 n5145 VSS VSS nmos W=0.155u L=0.04u
M18671 U5620/net49 n5147 U5620/net52 VDD pmos W=0.41u L=0.04u
M18672 U5620/net52 n5148 VDD VDD pmos W=0.41u L=0.04u
M18673 U5620/net46 n5146 U5620/net49 VDD pmos W=0.41u L=0.04u
M18674 n5144 n5145 U5620/net46 VDD pmos W=0.41u L=0.04u
M18675 U5621/net4 n5149 U5621/net14 VSS nmos W=0.155u L=0.04u
M18676 U5621/net6 U5621/net10 U5621/net14 VSS nmos W=0.17u L=0.04u
M18677 U5621/net4 g789 VSS VSS nmos W=0.155u L=0.04u
M18678 U5621/net6 U5621/net4 VSS VSS nmos W=0.17u L=0.04u
M18679 n5148 U5621/net14 VSS VSS nmos W=0.155u L=0.04u
M18680 U5621/net10 n5149 VSS VSS nmos W=0.155u L=0.04u
M18681 U5621/net4 U5621/net10 U5621/net14 VDD pmos W=0.255u L=0.04u
M18682 U5621/net6 n5149 U5621/net14 VDD pmos W=0.28u L=0.04u
M18683 U5621/net4 g789 VDD VDD pmos W=0.205u L=0.04u
M18684 U5621/net6 U5621/net4 VDD VDD pmos W=0.24u L=0.04u
M18685 n5148 U5621/net14 VDD VDD pmos W=0.205u L=0.04u
M18686 U5621/net10 n5149 VDD VDD pmos W=0.205u L=0.04u
M18687 U5622/net36 g821 U5622/net27 VSS nmos W=0.155u L=0.04u
M18688 U5622/net39 g822 VSS VSS nmos W=0.155u L=0.04u
M18689 U5622/net27 n4991 U5622/net39 VSS nmos W=0.155u L=0.04u
M18690 U5622/net27 g820 U5622/net39 VSS nmos W=0.155u L=0.04u
M18691 U5622/net36 n4990 U5622/net27 VSS nmos W=0.155u L=0.04u
M18692 U5622/net39 n4989 VSS VSS nmos W=0.155u L=0.04u
M18693 n5149 U5622/net36 VSS VSS nmos W=0.155u L=0.04u
M18694 n5149 U5622/net36 VDD VDD pmos W=0.205u L=0.04u
M18695 U5622/net36 g822 U5622/net46 VDD pmos W=0.205u L=0.04u
M18696 U5622/net46 n4989 VDD VDD pmos W=0.205u L=0.04u
M18697 U5622/net36 n4990 U5622/net34 VDD pmos W=0.205u L=0.04u
M18698 U5622/net34 g821 VDD VDD pmos W=0.205u L=0.04u
M18699 U5622/net36 g820 U5622/net37 VDD pmos W=0.205u L=0.04u
M18700 U5622/net37 n4991 VDD VDD pmos W=0.205u L=0.04u
M18701 U5623/net4 n5150 U5623/net14 VSS nmos W=0.155u L=0.04u
M18702 U5623/net6 U5623/net10 U5623/net14 VSS nmos W=0.17u L=0.04u
M18703 U5623/net4 g797 VSS VSS nmos W=0.155u L=0.04u
M18704 U5623/net6 U5623/net4 VSS VSS nmos W=0.17u L=0.04u
M18705 n5147 U5623/net14 VSS VSS nmos W=0.155u L=0.04u
M18706 U5623/net10 n5150 VSS VSS nmos W=0.155u L=0.04u
M18707 U5623/net4 U5623/net10 U5623/net14 VDD pmos W=0.255u L=0.04u
M18708 U5623/net6 n5150 U5623/net14 VDD pmos W=0.28u L=0.04u
M18709 U5623/net4 g797 VDD VDD pmos W=0.205u L=0.04u
M18710 U5623/net6 U5623/net4 VDD VDD pmos W=0.24u L=0.04u
M18711 n5147 U5623/net14 VDD VDD pmos W=0.205u L=0.04u
M18712 U5623/net10 n5150 VDD VDD pmos W=0.205u L=0.04u
M18713 U5624/net36 g833 U5624/net27 VSS nmos W=0.155u L=0.04u
M18714 U5624/net39 g834 VSS VSS nmos W=0.155u L=0.04u
M18715 U5624/net27 n4991 U5624/net39 VSS nmos W=0.155u L=0.04u
M18716 U5624/net27 g832 U5624/net39 VSS nmos W=0.155u L=0.04u
M18717 U5624/net36 n4990 U5624/net27 VSS nmos W=0.155u L=0.04u
M18718 U5624/net39 n4989 VSS VSS nmos W=0.155u L=0.04u
M18719 n5150 U5624/net36 VSS VSS nmos W=0.155u L=0.04u
M18720 n5150 U5624/net36 VDD VDD pmos W=0.205u L=0.04u
M18721 U5624/net36 g834 U5624/net46 VDD pmos W=0.205u L=0.04u
M18722 U5624/net46 n4989 VDD VDD pmos W=0.205u L=0.04u
M18723 U5624/net36 n4990 U5624/net34 VDD pmos W=0.205u L=0.04u
M18724 U5624/net34 g833 VDD VDD pmos W=0.205u L=0.04u
M18725 U5624/net36 g832 U5624/net37 VDD pmos W=0.205u L=0.04u
M18726 U5624/net37 n4991 VDD VDD pmos W=0.205u L=0.04u
M18727 U5625/net4 n5151 U5625/net14 VSS nmos W=0.155u L=0.04u
M18728 U5625/net6 U5625/net10 U5625/net14 VSS nmos W=0.17u L=0.04u
M18729 U5625/net4 g809 VSS VSS nmos W=0.155u L=0.04u
M18730 U5625/net6 U5625/net4 VSS VSS nmos W=0.17u L=0.04u
M18731 n5146 U5625/net14 VSS VSS nmos W=0.155u L=0.04u
M18732 U5625/net10 n5151 VSS VSS nmos W=0.155u L=0.04u
M18733 U5625/net4 U5625/net10 U5625/net14 VDD pmos W=0.255u L=0.04u
M18734 U5625/net6 n5151 U5625/net14 VDD pmos W=0.28u L=0.04u
M18735 U5625/net4 g809 VDD VDD pmos W=0.205u L=0.04u
M18736 U5625/net6 U5625/net4 VDD VDD pmos W=0.24u L=0.04u
M18737 n5146 U5625/net14 VDD VDD pmos W=0.205u L=0.04u
M18738 U5625/net10 n5151 VDD VDD pmos W=0.205u L=0.04u
M18739 U5626/net36 g842 U5626/net27 VSS nmos W=0.155u L=0.04u
M18740 U5626/net39 g843 VSS VSS nmos W=0.155u L=0.04u
M18741 U5626/net27 n4991 U5626/net39 VSS nmos W=0.155u L=0.04u
M18742 U5626/net27 g841 U5626/net39 VSS nmos W=0.155u L=0.04u
M18743 U5626/net36 n4990 U5626/net27 VSS nmos W=0.155u L=0.04u
M18744 U5626/net39 n4989 VSS VSS nmos W=0.155u L=0.04u
M18745 n5151 U5626/net36 VSS VSS nmos W=0.155u L=0.04u
M18746 n5151 U5626/net36 VDD VDD pmos W=0.205u L=0.04u
M18747 U5626/net36 g843 U5626/net46 VDD pmos W=0.205u L=0.04u
M18748 U5626/net46 n4989 VDD VDD pmos W=0.205u L=0.04u
M18749 U5626/net36 n4990 U5626/net34 VDD pmos W=0.205u L=0.04u
M18750 U5626/net34 g842 VDD VDD pmos W=0.205u L=0.04u
M18751 U5626/net36 g841 U5626/net37 VDD pmos W=0.205u L=0.04u
M18752 U5626/net37 n4991 VDD VDD pmos W=0.205u L=0.04u
M18753 n5145 n5152 U5627/XI0-net10 VSS nmos W=0.155u L=0.04u
M18754 U5627/XI0-net10 n5153 U5627/XI0-net13 VSS nmos W=0.155u L=0.04u
M18755 U5627/XI0-net13 n5154 VSS VSS nmos W=0.155u L=0.04u
M18756 n5145 n5154 VDD VDD pmos W=0.205u L=0.04u
M18757 n5145 n5152 VDD VDD pmos W=0.205u L=0.04u
M18758 n5145 n5153 VDD VDD pmos W=0.205u L=0.04u
M18759 U5628/net4 n4962 U5628/net14 VSS nmos W=0.155u L=0.04u
M18760 U5628/net6 U5628/net10 U5628/net14 VSS nmos W=0.17u L=0.04u
M18761 U5628/net4 n5155 VSS VSS nmos W=0.155u L=0.04u
M18762 U5628/net6 U5628/net4 VSS VSS nmos W=0.17u L=0.04u
M18763 n5154 U5628/net14 VSS VSS nmos W=0.155u L=0.04u
M18764 U5628/net10 n4962 VSS VSS nmos W=0.155u L=0.04u
M18765 U5628/net4 U5628/net10 U5628/net14 VDD pmos W=0.255u L=0.04u
M18766 U5628/net6 n4962 U5628/net14 VDD pmos W=0.28u L=0.04u
M18767 U5628/net4 n5155 VDD VDD pmos W=0.205u L=0.04u
M18768 U5628/net6 U5628/net4 VDD VDD pmos W=0.24u L=0.04u
M18769 n5154 U5628/net14 VDD VDD pmos W=0.205u L=0.04u
M18770 U5628/net10 n4962 VDD VDD pmos W=0.205u L=0.04u
M18771 U5629/net36 g818 U5629/net27 VSS nmos W=0.155u L=0.04u
M18772 U5629/net39 g819 VSS VSS nmos W=0.155u L=0.04u
M18773 U5629/net27 n4991 U5629/net39 VSS nmos W=0.155u L=0.04u
M18774 U5629/net27 g817 U5629/net39 VSS nmos W=0.155u L=0.04u
M18775 U5629/net36 n4990 U5629/net27 VSS nmos W=0.155u L=0.04u
M18776 U5629/net39 n4989 VSS VSS nmos W=0.155u L=0.04u
M18777 n5155 U5629/net36 VSS VSS nmos W=0.155u L=0.04u
M18778 n5155 U5629/net36 VDD VDD pmos W=0.205u L=0.04u
M18779 U5629/net36 g819 U5629/net46 VDD pmos W=0.205u L=0.04u
M18780 U5629/net46 n4989 VDD VDD pmos W=0.205u L=0.04u
M18781 U5629/net36 n4990 U5629/net34 VDD pmos W=0.205u L=0.04u
M18782 U5629/net34 g818 VDD VDD pmos W=0.205u L=0.04u
M18783 U5629/net36 g817 U5629/net37 VDD pmos W=0.205u L=0.04u
M18784 U5629/net37 n4991 VDD VDD pmos W=0.205u L=0.04u
M18785 U5630/net4 n5016 U5630/net14 VSS nmos W=0.155u L=0.04u
M18786 U5630/net6 U5630/net10 U5630/net14 VSS nmos W=0.17u L=0.04u
M18787 U5630/net4 n5156 VSS VSS nmos W=0.155u L=0.04u
M18788 U5630/net6 U5630/net4 VSS VSS nmos W=0.17u L=0.04u
M18789 n5153 U5630/net14 VSS VSS nmos W=0.155u L=0.04u
M18790 U5630/net10 n5016 VSS VSS nmos W=0.155u L=0.04u
M18791 U5630/net4 U5630/net10 U5630/net14 VDD pmos W=0.255u L=0.04u
M18792 U5630/net6 n5016 U5630/net14 VDD pmos W=0.28u L=0.04u
M18793 U5630/net4 n5156 VDD VDD pmos W=0.205u L=0.04u
M18794 U5630/net6 U5630/net4 VDD VDD pmos W=0.24u L=0.04u
M18795 n5153 U5630/net14 VDD VDD pmos W=0.205u L=0.04u
M18796 U5630/net10 n5016 VDD VDD pmos W=0.205u L=0.04u
M18797 U5631/net36 g845 U5631/net27 VSS nmos W=0.155u L=0.04u
M18798 U5631/net39 g846 VSS VSS nmos W=0.155u L=0.04u
M18799 U5631/net27 n4991 U5631/net39 VSS nmos W=0.155u L=0.04u
M18800 U5631/net27 g844 U5631/net39 VSS nmos W=0.155u L=0.04u
M18801 U5631/net36 n4990 U5631/net27 VSS nmos W=0.155u L=0.04u
M18802 U5631/net39 n4989 VSS VSS nmos W=0.155u L=0.04u
M18803 n5156 U5631/net36 VSS VSS nmos W=0.155u L=0.04u
M18804 n5156 U5631/net36 VDD VDD pmos W=0.205u L=0.04u
M18805 U5631/net36 g846 U5631/net46 VDD pmos W=0.205u L=0.04u
M18806 U5631/net46 n4989 VDD VDD pmos W=0.205u L=0.04u
M18807 U5631/net36 n4990 U5631/net34 VDD pmos W=0.205u L=0.04u
M18808 U5631/net34 g845 VDD VDD pmos W=0.205u L=0.04u
M18809 U5631/net36 g844 U5631/net37 VDD pmos W=0.205u L=0.04u
M18810 U5631/net37 n4991 VDD VDD pmos W=0.205u L=0.04u
M18811 U5632/net4 n4966 U5632/net14 VSS nmos W=0.155u L=0.04u
M18812 U5632/net6 U5632/net10 U5632/net14 VSS nmos W=0.17u L=0.04u
M18813 U5632/net4 n5157 VSS VSS nmos W=0.155u L=0.04u
M18814 U5632/net6 U5632/net4 VSS VSS nmos W=0.17u L=0.04u
M18815 n5152 U5632/net14 VSS VSS nmos W=0.155u L=0.04u
M18816 U5632/net10 n4966 VSS VSS nmos W=0.155u L=0.04u
M18817 U5632/net4 U5632/net10 U5632/net14 VDD pmos W=0.255u L=0.04u
M18818 U5632/net6 n4966 U5632/net14 VDD pmos W=0.28u L=0.04u
M18819 U5632/net4 n5157 VDD VDD pmos W=0.205u L=0.04u
M18820 U5632/net6 U5632/net4 VDD VDD pmos W=0.24u L=0.04u
M18821 n5152 U5632/net14 VDD VDD pmos W=0.205u L=0.04u
M18822 U5632/net10 n4966 VDD VDD pmos W=0.205u L=0.04u
M18823 U5633/net36 g836 U5633/net27 VSS nmos W=0.155u L=0.04u
M18824 U5633/net39 g837 VSS VSS nmos W=0.155u L=0.04u
M18825 U5633/net27 n4991 U5633/net39 VSS nmos W=0.155u L=0.04u
M18826 U5633/net27 g835 U5633/net39 VSS nmos W=0.155u L=0.04u
M18827 U5633/net36 n4990 U5633/net27 VSS nmos W=0.155u L=0.04u
M18828 U5633/net39 n4989 VSS VSS nmos W=0.155u L=0.04u
M18829 n5157 U5633/net36 VSS VSS nmos W=0.155u L=0.04u
M18830 n5157 U5633/net36 VDD VDD pmos W=0.205u L=0.04u
M18831 U5633/net36 g837 U5633/net46 VDD pmos W=0.205u L=0.04u
M18832 U5633/net46 n4989 VDD VDD pmos W=0.205u L=0.04u
M18833 U5633/net36 n4990 U5633/net34 VDD pmos W=0.205u L=0.04u
M18834 U5633/net34 g836 VDD VDD pmos W=0.205u L=0.04u
M18835 U5633/net36 g835 U5633/net37 VDD pmos W=0.205u L=0.04u
M18836 U5633/net37 n4991 VDD VDD pmos W=0.205u L=0.04u
M18837 n5143 n5159 VSS VSS nmos W=0.155u L=0.04u
M18838 n5143 n5158 VSS VSS nmos W=0.155u L=0.04u
M18839 n5143 n5112 VSS VSS nmos W=0.155u L=0.04u
M18840 U5634/net25 n5159 VDD VDD pmos W=0.41u L=0.04u
M18841 U5634/net28 n5158 U5634/net25 VDD pmos W=0.41u L=0.04u
M18842 n5143 n5112 U5634/net28 VDD pmos W=0.41u L=0.04u
M18843 U5635/net4 n5160 U5635/net14 VSS nmos W=0.155u L=0.04u
M18844 U5635/net6 U5635/net10 U5635/net14 VSS nmos W=0.17u L=0.04u
M18845 U5635/net4 g805 VSS VSS nmos W=0.155u L=0.04u
M18846 U5635/net6 U5635/net4 VSS VSS nmos W=0.17u L=0.04u
M18847 n5159 U5635/net14 VSS VSS nmos W=0.155u L=0.04u
M18848 U5635/net10 n5160 VSS VSS nmos W=0.155u L=0.04u
M18849 U5635/net4 U5635/net10 U5635/net14 VDD pmos W=0.255u L=0.04u
M18850 U5635/net6 n5160 U5635/net14 VDD pmos W=0.28u L=0.04u
M18851 U5635/net4 g805 VDD VDD pmos W=0.205u L=0.04u
M18852 U5635/net6 U5635/net4 VDD VDD pmos W=0.24u L=0.04u
M18853 n5159 U5635/net14 VDD VDD pmos W=0.205u L=0.04u
M18854 U5635/net10 n5160 VDD VDD pmos W=0.205u L=0.04u
M18855 U5636/net36 g839 U5636/net27 VSS nmos W=0.155u L=0.04u
M18856 U5636/net39 g840 VSS VSS nmos W=0.155u L=0.04u
M18857 U5636/net27 n4991 U5636/net39 VSS nmos W=0.155u L=0.04u
M18858 U5636/net27 g838 U5636/net39 VSS nmos W=0.155u L=0.04u
M18859 U5636/net36 n4990 U5636/net27 VSS nmos W=0.155u L=0.04u
M18860 U5636/net39 n4989 VSS VSS nmos W=0.155u L=0.04u
M18861 n5160 U5636/net36 VSS VSS nmos W=0.155u L=0.04u
M18862 n5160 U5636/net36 VDD VDD pmos W=0.205u L=0.04u
M18863 U5636/net36 g840 U5636/net46 VDD pmos W=0.205u L=0.04u
M18864 U5636/net46 n4989 VDD VDD pmos W=0.205u L=0.04u
M18865 U5636/net36 n4990 U5636/net34 VDD pmos W=0.205u L=0.04u
M18866 U5636/net34 g839 VDD VDD pmos W=0.205u L=0.04u
M18867 U5636/net36 g838 U5636/net37 VDD pmos W=0.205u L=0.04u
M18868 U5636/net37 n4991 VDD VDD pmos W=0.205u L=0.04u
M18869 U5637/net4 n5161 U5637/net14 VSS nmos W=0.155u L=0.04u
M18870 U5637/net6 U5637/net10 U5637/net14 VSS nmos W=0.17u L=0.04u
M18871 U5637/net4 g793 VSS VSS nmos W=0.155u L=0.04u
M18872 U5637/net6 U5637/net4 VSS VSS nmos W=0.17u L=0.04u
M18873 n5158 U5637/net14 VSS VSS nmos W=0.155u L=0.04u
M18874 U5637/net10 n5161 VSS VSS nmos W=0.155u L=0.04u
M18875 U5637/net4 U5637/net10 U5637/net14 VDD pmos W=0.255u L=0.04u
M18876 U5637/net6 n5161 U5637/net14 VDD pmos W=0.28u L=0.04u
M18877 U5637/net4 g793 VDD VDD pmos W=0.205u L=0.04u
M18878 U5637/net6 U5637/net4 VDD VDD pmos W=0.24u L=0.04u
M18879 n5158 U5637/net14 VDD VDD pmos W=0.205u L=0.04u
M18880 U5637/net10 n5161 VDD VDD pmos W=0.205u L=0.04u
M18881 U5638/net36 g830 U5638/net27 VSS nmos W=0.155u L=0.04u
M18882 U5638/net39 g831 VSS VSS nmos W=0.155u L=0.04u
M18883 U5638/net27 n4991 U5638/net39 VSS nmos W=0.155u L=0.04u
M18884 U5638/net27 g829 U5638/net39 VSS nmos W=0.155u L=0.04u
M18885 U5638/net36 n4990 U5638/net27 VSS nmos W=0.155u L=0.04u
M18886 U5638/net39 n4989 VSS VSS nmos W=0.155u L=0.04u
M18887 n5161 U5638/net36 VSS VSS nmos W=0.155u L=0.04u
M18888 n5161 U5638/net36 VDD VDD pmos W=0.205u L=0.04u
M18889 U5638/net36 g831 U5638/net46 VDD pmos W=0.205u L=0.04u
M18890 U5638/net46 n4989 VDD VDD pmos W=0.205u L=0.04u
M18891 U5638/net36 n4990 U5638/net34 VDD pmos W=0.205u L=0.04u
M18892 U5638/net34 g830 VDD VDD pmos W=0.205u L=0.04u
M18893 U5638/net36 g829 U5638/net37 VDD pmos W=0.205u L=0.04u
M18894 U5638/net37 n4991 VDD VDD pmos W=0.205u L=0.04u
M18895 U5639/net4 n5015 U5639/net14 VSS nmos W=0.155u L=0.04u
M18896 U5639/net6 U5639/net10 U5639/net14 VSS nmos W=0.17u L=0.04u
M18897 U5639/net4 n5162 VSS VSS nmos W=0.155u L=0.04u
M18898 U5639/net6 U5639/net4 VSS VSS nmos W=0.17u L=0.04u
M18899 n5142 U5639/net14 VSS VSS nmos W=0.155u L=0.04u
M18900 U5639/net10 n5015 VSS VSS nmos W=0.155u L=0.04u
M18901 U5639/net4 U5639/net10 U5639/net14 VDD pmos W=0.255u L=0.04u
M18902 U5639/net6 n5015 U5639/net14 VDD pmos W=0.28u L=0.04u
M18903 U5639/net4 n5162 VDD VDD pmos W=0.205u L=0.04u
M18904 U5639/net6 U5639/net4 VDD VDD pmos W=0.24u L=0.04u
M18905 n5142 U5639/net14 VDD VDD pmos W=0.205u L=0.04u
M18906 U5639/net10 n5015 VDD VDD pmos W=0.205u L=0.04u
M18907 n5162 n4989 U5640/net27 VSS nmos W=0.155u L=0.04u
M18908 U5640/net39 n4991 VSS VSS nmos W=0.155u L=0.04u
M18909 U5640/net27 g851 U5640/net39 VSS nmos W=0.155u L=0.04u
M18910 U5640/net27 n4990 U5640/net39 VSS nmos W=0.155u L=0.04u
M18911 n5162 g852 U5640/net27 VSS nmos W=0.155u L=0.04u
M18912 U5640/net39 g850 VSS VSS nmos W=0.155u L=0.04u
M18913 n5162 n4991 U5640/net46 VDD pmos W=0.205u L=0.04u
M18914 U5640/net46 g850 VDD VDD pmos W=0.205u L=0.04u
M18915 n5162 g852 U5640/net34 VDD pmos W=0.205u L=0.04u
M18916 U5640/net34 n4989 VDD VDD pmos W=0.205u L=0.04u
M18917 n5162 n4990 U5640/net37 VDD pmos W=0.205u L=0.04u
M18918 U5640/net37 g851 VDD VDD pmos W=0.205u L=0.04u
M18919 U5641/net4 n5163 U5641/net14 VSS nmos W=0.155u L=0.04u
M18920 U5641/net6 U5641/net10 U5641/net14 VSS nmos W=0.17u L=0.04u
M18921 U5641/net4 n5164 VSS VSS nmos W=0.155u L=0.04u
M18922 U5641/net6 U5641/net4 VSS VSS nmos W=0.17u L=0.04u
M18923 n5141 U5641/net14 VSS VSS nmos W=0.155u L=0.04u
M18924 U5641/net10 n5163 VSS VSS nmos W=0.155u L=0.04u
M18925 U5641/net4 U5641/net10 U5641/net14 VDD pmos W=0.255u L=0.04u
M18926 U5641/net6 n5163 U5641/net14 VDD pmos W=0.28u L=0.04u
M18927 U5641/net4 n5164 VDD VDD pmos W=0.205u L=0.04u
M18928 U5641/net6 U5641/net4 VDD VDD pmos W=0.24u L=0.04u
M18929 n5141 U5641/net14 VDD VDD pmos W=0.205u L=0.04u
M18930 U5641/net10 n5163 VDD VDD pmos W=0.205u L=0.04u
M18931 n5164 n4989 U5642/net27 VSS nmos W=0.155u L=0.04u
M18932 U5642/net39 n4991 VSS VSS nmos W=0.155u L=0.04u
M18933 U5642/net27 g848 U5642/net39 VSS nmos W=0.155u L=0.04u
M18934 U5642/net27 n4990 U5642/net39 VSS nmos W=0.155u L=0.04u
M18935 n5164 g849 U5642/net27 VSS nmos W=0.155u L=0.04u
M18936 U5642/net39 g847 VSS VSS nmos W=0.155u L=0.04u
M18937 n5164 n4991 U5642/net46 VDD pmos W=0.205u L=0.04u
M18938 U5642/net46 g847 VDD VDD pmos W=0.205u L=0.04u
M18939 n5164 g849 U5642/net34 VDD pmos W=0.205u L=0.04u
M18940 U5642/net34 n4989 VDD VDD pmos W=0.205u L=0.04u
M18941 n5164 n4990 U5642/net37 VDD pmos W=0.205u L=0.04u
M18942 U5642/net37 g848 VDD VDD pmos W=0.205u L=0.04u
M18943 U5643/XU1-net6 n5121 VSS VSS nmos W=0.155u L=0.04u
M18944 n5026 n5106 U5643/XU1-net6 VSS nmos W=0.155u L=0.04u
M18945 n5026 n5121 VDD VDD pmos W=0.155u L=0.04u
M18946 n5026 n5106 VDD VDD pmos W=0.155u L=0.04u
M18947 n5121 n5165 U5644/net15 VSS nmos W=0.155u L=0.04u
M18948 n5121 n5166 U5644/net15 VSS nmos W=0.155u L=0.04u
M18949 U5644/net15 n5107 VSS VSS nmos W=0.155u L=0.04u
M18950 n5121 n5107 VDD VDD pmos W=0.205u L=0.04u
M18951 n5121 n5165 U5644/XI16-net11 VDD pmos W=0.205u L=0.04u
M18952 U5644/XI16-net11 n5166 VDD VDD pmos W=0.205u L=0.04u
M18953 n5166 n5118 U5645/net14 VSS nmos W=0.155u L=0.04u
M18954 U5645/net14 n5168 VSS VSS nmos W=0.155u L=0.04u
M18955 U5645/net14 n5167 VSS VSS nmos W=0.155u L=0.04u
M18956 n5166 n5117 U5645/net14 VSS nmos W=0.155u L=0.04u
M18957 n5166 n5113 U5645/net14 VSS nmos W=0.155u L=0.04u
M18958 n5166 n5168 U5645/XI16-net11 VDD pmos W=0.205u L=0.04u
M18959 U5645/XI16-net11 n5167 VDD VDD pmos W=0.205u L=0.04u
M18960 n5166 n5117 U5645/XI15-net11 VDD pmos W=0.205u L=0.04u
M18961 U5645/XI15-net11 n5113 U5645/XI15-net18 VDD pmos W=0.205u L=0.04u
M18962 U5645/XI15-net18 n5118 VDD VDD pmos W=0.205u L=0.04u
M18963 U5646/net29 n5118 VSS VSS nmos W=0.155u L=0.04u
M18964 U5646/net26 n5170 U5646/net20 VSS nmos W=0.155u L=0.04u
M18965 U5646/net20 n5171 VSS VSS nmos W=0.155u L=0.04u
M18966 U5646/net26 n5169 U5646/net29 VSS nmos W=0.155u L=0.04u
M18967 n5168 U5646/net26 VSS VSS nmos W=0.155u L=0.04u
M18968 n5168 U5646/net26 VDD VDD pmos W=0.205u L=0.04u
M18969 U5646/net26 n5169 U5646/net40 VDD pmos W=0.205u L=0.04u
M18970 U5646/net26 n5118 U5646/net40 VDD pmos W=0.205u L=0.04u
M18971 U5646/net40 n5171 VDD VDD pmos W=0.205u L=0.04u
M18972 U5646/net40 n5170 VDD VDD pmos W=0.205u L=0.04u
M18973 n5117 U5647/net6 VSS VSS nmos W=0.155u L=0.04u
M18974 U5647/X_u2-net6 n5170 VSS VSS nmos W=0.155u L=0.04u
M18975 U5647/net6 n5169 U5647/X_u2-net6 VSS nmos W=0.155u L=0.04u
M18976 n5117 U5647/net6 VDD VDD pmos W=0.205u L=0.04u
M18977 U5647/net6 n5170 VDD VDD pmos W=0.205u L=0.04u
M18978 U5647/net6 n5169 VDD VDD pmos W=0.205u L=0.04u
M18979 n5113 U5648/net6 VSS VSS nmos W=0.155u L=0.04u
M18980 U5648/X_u2-net6 n5171 VSS VSS nmos W=0.155u L=0.04u
M18981 U5648/net6 n5167 U5648/X_u2-net6 VSS nmos W=0.155u L=0.04u
M18982 n5113 U5648/net6 VDD VDD pmos W=0.205u L=0.04u
M18983 U5648/net6 n5171 VDD VDD pmos W=0.205u L=0.04u
M18984 U5648/net6 n5167 VDD VDD pmos W=0.205u L=0.04u
M18985 n5165 n5170 VSS VSS nmos W=0.155u L=0.04u
M18986 n5165 n5171 U5649/XI17-net17 VSS nmos W=0.155u L=0.04u
M18987 U5649/XI17-net17 n5118 VSS VSS nmos W=0.155u L=0.04u
M18988 n5165 n5167 U5649/XI10-net17 VSS nmos W=0.155u L=0.04u
M18989 U5649/XI10-net17 n5169 VSS VSS nmos W=0.155u L=0.04u
M18990 U5649/net30 n5167 n5165 VDD pmos W=0.205u L=0.04u
M18991 U5649/net30 n5169 n5165 VDD pmos W=0.205u L=0.04u
M18992 VDD n5170 U5649/net36 VDD pmos W=0.205u L=0.04u
M18993 U5649/net36 n5118 U5649/net30 VDD pmos W=0.205u L=0.04u
M18994 U5649/net36 n5171 U5649/net30 VDD pmos W=0.205u L=0.04u
M18995 U5650/net4 U5650/net10 U5650/net14 VSS nmos W=0.155u L=0.04u
M18996 U5650/net6 n5130 U5650/net14 VSS nmos W=0.155u L=0.04u
M18997 U5650/net4 n4963 VSS VSS nmos W=0.155u L=0.04u
M18998 U5650/net6 U5650/net4 VSS VSS nmos W=0.155u L=0.04u
M18999 n5170 U5650/net14 VSS VSS nmos W=0.155u L=0.04u
M19000 U5650/net10 n5130 VSS VSS nmos W=0.155u L=0.04u
M19001 U5650/net4 n5130 U5650/net14 VDD pmos W=0.205u L=0.04u
M19002 U5650/net6 U5650/net10 U5650/net14 VDD pmos W=0.205u L=0.04u
M19003 U5650/net4 n4963 VDD VDD pmos W=0.205u L=0.04u
M19004 U5650/net6 U5650/net4 VDD VDD pmos W=0.205u L=0.04u
M19005 n5170 U5650/net14 VDD VDD pmos W=0.205u L=0.04u
M19006 U5650/net10 n5130 VDD VDD pmos W=0.205u L=0.04u
M19007 U5651/net4 U5651/net10 U5651/net14 VSS nmos W=0.155u L=0.04u
M19008 U5651/net6 n5132 U5651/net14 VSS nmos W=0.155u L=0.04u
M19009 U5651/net4 n4967 VSS VSS nmos W=0.155u L=0.04u
M19010 U5651/net6 U5651/net4 VSS VSS nmos W=0.155u L=0.04u
M19011 n5118 U5651/net14 VSS VSS nmos W=0.155u L=0.04u
M19012 U5651/net10 n5132 VSS VSS nmos W=0.155u L=0.04u
M19013 U5651/net4 n5132 U5651/net14 VDD pmos W=0.205u L=0.04u
M19014 U5651/net6 U5651/net10 U5651/net14 VDD pmos W=0.205u L=0.04u
M19015 U5651/net4 n4967 VDD VDD pmos W=0.205u L=0.04u
M19016 U5651/net6 U5651/net4 VDD VDD pmos W=0.205u L=0.04u
M19017 n5118 U5651/net14 VDD VDD pmos W=0.205u L=0.04u
M19018 U5651/net10 n5132 VDD VDD pmos W=0.205u L=0.04u
M19019 U5652/net4 n5131 U5652/net14 VSS nmos W=0.155u L=0.04u
M19020 U5652/net6 U5652/net10 U5652/net14 VSS nmos W=0.17u L=0.04u
M19021 U5652/net4 g797 VSS VSS nmos W=0.155u L=0.04u
M19022 U5652/net6 U5652/net4 VSS VSS nmos W=0.17u L=0.04u
M19023 n5171 U5652/net14 VSS VSS nmos W=0.155u L=0.04u
M19024 U5652/net10 n5131 VSS VSS nmos W=0.155u L=0.04u
M19025 U5652/net4 U5652/net10 U5652/net14 VDD pmos W=0.255u L=0.04u
M19026 U5652/net6 n5131 U5652/net14 VDD pmos W=0.28u L=0.04u
M19027 U5652/net4 g797 VDD VDD pmos W=0.205u L=0.04u
M19028 U5652/net6 U5652/net4 VDD VDD pmos W=0.24u L=0.04u
M19029 n5171 U5652/net14 VDD VDD pmos W=0.205u L=0.04u
M19030 U5652/net10 n5131 VDD VDD pmos W=0.205u L=0.04u
M19031 U5653/net4 U5653/net10 U5653/net14 VSS nmos W=0.155u L=0.04u
M19032 U5653/net6 n5064 U5653/net14 VSS nmos W=0.155u L=0.04u
M19033 U5653/net4 n5016 VSS VSS nmos W=0.155u L=0.04u
M19034 U5653/net6 U5653/net4 VSS VSS nmos W=0.155u L=0.04u
M19035 n5169 U5653/net14 VSS VSS nmos W=0.155u L=0.04u
M19036 U5653/net10 n5064 VSS VSS nmos W=0.155u L=0.04u
M19037 U5653/net4 n5064 U5653/net14 VDD pmos W=0.205u L=0.04u
M19038 U5653/net6 U5653/net10 U5653/net14 VDD pmos W=0.205u L=0.04u
M19039 U5653/net4 n5016 VDD VDD pmos W=0.205u L=0.04u
M19040 U5653/net6 U5653/net4 VDD VDD pmos W=0.205u L=0.04u
M19041 n5169 U5653/net14 VDD VDD pmos W=0.205u L=0.04u
M19042 U5653/net10 n5064 VDD VDD pmos W=0.205u L=0.04u
M19043 U5654/net4 n5015 U5654/net14 VSS nmos W=0.155u L=0.04u
M19044 U5654/net6 U5654/net10 U5654/net14 VSS nmos W=0.17u L=0.04u
M19045 U5654/net4 n5052 VSS VSS nmos W=0.155u L=0.04u
M19046 U5654/net6 U5654/net4 VSS VSS nmos W=0.17u L=0.04u
M19047 n5167 U5654/net14 VSS VSS nmos W=0.155u L=0.04u
M19048 U5654/net10 n5015 VSS VSS nmos W=0.155u L=0.04u
M19049 U5654/net4 U5654/net10 U5654/net14 VDD pmos W=0.255u L=0.04u
M19050 U5654/net6 n5015 U5654/net14 VDD pmos W=0.28u L=0.04u
M19051 U5654/net4 n5052 VDD VDD pmos W=0.205u L=0.04u
M19052 U5654/net6 U5654/net4 VDD VDD pmos W=0.24u L=0.04u
M19053 n5167 U5654/net14 VDD VDD pmos W=0.205u L=0.04u
M19054 U5654/net10 n5015 VDD VDD pmos W=0.205u L=0.04u
M19055 n5015 n4989 U5655/net27 VSS nmos W=0.155u L=0.04u
M19056 U5655/net39 n4991 VSS VSS nmos W=0.155u L=0.04u
M19057 U5655/net27 g860 U5655/net39 VSS nmos W=0.155u L=0.04u
M19058 U5655/net27 n4990 U5655/net39 VSS nmos W=0.155u L=0.04u
M19059 n5015 g861 U5655/net27 VSS nmos W=0.155u L=0.04u
M19060 U5655/net39 g859 VSS VSS nmos W=0.155u L=0.04u
M19061 n5015 n4991 U5655/net46 VDD pmos W=0.205u L=0.04u
M19062 U5655/net46 g859 VDD VDD pmos W=0.205u L=0.04u
M19063 n5015 g861 U5655/net34 VDD pmos W=0.205u L=0.04u
M19064 U5655/net34 n4989 VDD VDD pmos W=0.205u L=0.04u
M19065 n5015 n4990 U5655/net37 VDD pmos W=0.205u L=0.04u
M19066 U5655/net37 g860 VDD VDD pmos W=0.205u L=0.04u
M19067 n5106 n5172 U5656/net15 VSS nmos W=0.155u L=0.04u
M19068 n5106 n5173 U5656/net15 VSS nmos W=0.155u L=0.04u
M19069 U5656/net15 n5107 VSS VSS nmos W=0.155u L=0.04u
M19070 n5106 n5107 VDD VDD pmos W=0.205u L=0.04u
M19071 n5106 n5172 U5656/XI16-net11 VDD pmos W=0.205u L=0.04u
M19072 U5656/XI16-net11 n5173 VDD VDD pmos W=0.205u L=0.04u
M19073 n5107 n5112 VSS VSS nmos W=0.135u L=0.04u
M19074 n5107 n5112 VDD VDD pmos W=0.205u L=0.04u
M19075 U5658/XU1-net6 n5140 VSS VSS nmos W=0.155u L=0.04u
M19076 n5112 g869 U5658/XU1-net6 VSS nmos W=0.155u L=0.04u
M19077 n5112 n5140 VDD VDD pmos W=0.155u L=0.04u
M19078 n5112 g869 VDD VDD pmos W=0.155u L=0.04u
M19079 n5140 n4989 U5659/net27 VSS nmos W=0.155u L=0.04u
M19080 U5659/net39 n4991 VSS VSS nmos W=0.155u L=0.04u
M19081 U5659/net27 g857 U5659/net39 VSS nmos W=0.155u L=0.04u
M19082 U5659/net27 n4990 U5659/net39 VSS nmos W=0.155u L=0.04u
M19083 n5140 g858 U5659/net27 VSS nmos W=0.155u L=0.04u
M19084 U5659/net39 g856 VSS VSS nmos W=0.155u L=0.04u
M19085 n5140 n4991 U5659/net46 VDD pmos W=0.205u L=0.04u
M19086 U5659/net46 g856 VDD VDD pmos W=0.205u L=0.04u
M19087 n5140 g858 U5659/net34 VDD pmos W=0.205u L=0.04u
M19088 U5659/net34 n4989 VDD VDD pmos W=0.205u L=0.04u
M19089 n5140 n4990 U5659/net37 VDD pmos W=0.205u L=0.04u
M19090 U5659/net37 g857 VDD VDD pmos W=0.205u L=0.04u
M19091 n5173 n5119 U5660/net14 VSS nmos W=0.155u L=0.04u
M19092 U5660/net14 n5175 VSS VSS nmos W=0.155u L=0.04u
M19093 U5660/net14 n5174 VSS VSS nmos W=0.155u L=0.04u
M19094 n5173 n5114 U5660/net14 VSS nmos W=0.155u L=0.04u
M19095 n5173 n5115 U5660/net14 VSS nmos W=0.155u L=0.04u
M19096 n5173 n5175 U5660/XI16-net11 VDD pmos W=0.205u L=0.04u
M19097 U5660/XI16-net11 n5174 VDD VDD pmos W=0.205u L=0.04u
M19098 n5173 n5114 U5660/XI15-net11 VDD pmos W=0.205u L=0.04u
M19099 U5660/XI15-net11 n5115 U5660/XI15-net18 VDD pmos W=0.205u L=0.04u
M19100 U5660/XI15-net18 n5119 VDD VDD pmos W=0.205u L=0.04u
M19101 U5661/net29 n5119 VSS VSS nmos W=0.155u L=0.04u
M19102 U5661/net26 n5177 U5661/net20 VSS nmos W=0.155u L=0.04u
M19103 U5661/net20 n5178 VSS VSS nmos W=0.155u L=0.04u
M19104 U5661/net26 n5176 U5661/net29 VSS nmos W=0.155u L=0.04u
M19105 n5175 U5661/net26 VSS VSS nmos W=0.155u L=0.04u
M19106 n5175 U5661/net26 VDD VDD pmos W=0.205u L=0.04u
M19107 U5661/net26 n5176 U5661/net40 VDD pmos W=0.205u L=0.04u
M19108 U5661/net26 n5119 U5661/net40 VDD pmos W=0.205u L=0.04u
M19109 U5661/net40 n5178 VDD VDD pmos W=0.205u L=0.04u
M19110 U5661/net40 n5177 VDD VDD pmos W=0.205u L=0.04u
M19111 n5114 U5662/net6 VSS VSS nmos W=0.155u L=0.04u
M19112 U5662/X_u2-net6 n5177 VSS VSS nmos W=0.155u L=0.04u
M19113 U5662/net6 n5176 U5662/X_u2-net6 VSS nmos W=0.155u L=0.04u
M19114 n5114 U5662/net6 VDD VDD pmos W=0.205u L=0.04u
M19115 U5662/net6 n5177 VDD VDD pmos W=0.205u L=0.04u
M19116 U5662/net6 n5176 VDD VDD pmos W=0.205u L=0.04u
M19117 n5115 U5663/net6 VSS VSS nmos W=0.155u L=0.04u
M19118 U5663/X_u2-net6 n5178 VSS VSS nmos W=0.155u L=0.04u
M19119 U5663/net6 n5174 U5663/X_u2-net6 VSS nmos W=0.155u L=0.04u
M19120 n5115 U5663/net6 VDD VDD pmos W=0.205u L=0.04u
M19121 U5663/net6 n5178 VDD VDD pmos W=0.205u L=0.04u
M19122 U5663/net6 n5174 VDD VDD pmos W=0.205u L=0.04u
M19123 n5172 n5177 VSS VSS nmos W=0.155u L=0.04u
M19124 n5172 n5178 U5664/XI17-net17 VSS nmos W=0.155u L=0.04u
M19125 U5664/XI17-net17 n5119 VSS VSS nmos W=0.155u L=0.04u
M19126 n5172 n5174 U5664/XI10-net17 VSS nmos W=0.155u L=0.04u
M19127 U5664/XI10-net17 n5176 VSS VSS nmos W=0.155u L=0.04u
M19128 U5664/net30 n5174 n5172 VDD pmos W=0.205u L=0.04u
M19129 U5664/net30 n5176 n5172 VDD pmos W=0.205u L=0.04u
M19130 VDD n5177 U5664/net36 VDD pmos W=0.205u L=0.04u
M19131 U5664/net36 n5119 U5664/net30 VDD pmos W=0.205u L=0.04u
M19132 U5664/net36 n5178 U5664/net30 VDD pmos W=0.205u L=0.04u
M19133 U5665/net4 U5665/net10 U5665/net14 VSS nmos W=0.155u L=0.04u
M19134 U5665/net6 n5048 U5665/net14 VSS nmos W=0.155u L=0.04u
M19135 U5665/net4 n4962 VSS VSS nmos W=0.155u L=0.04u
M19136 U5665/net6 U5665/net4 VSS VSS nmos W=0.155u L=0.04u
M19137 n5177 U5665/net14 VSS VSS nmos W=0.155u L=0.04u
M19138 U5665/net10 n5048 VSS VSS nmos W=0.155u L=0.04u
M19139 U5665/net4 n5048 U5665/net14 VDD pmos W=0.205u L=0.04u
M19140 U5665/net6 U5665/net10 U5665/net14 VDD pmos W=0.205u L=0.04u
M19141 U5665/net4 n4962 VDD VDD pmos W=0.205u L=0.04u
M19142 U5665/net6 U5665/net4 VDD VDD pmos W=0.205u L=0.04u
M19143 n5177 U5665/net14 VDD VDD pmos W=0.205u L=0.04u
M19144 U5665/net10 n5048 VDD VDD pmos W=0.205u L=0.04u
M19145 U5666/net4 U5666/net10 U5666/net14 VSS nmos W=0.155u L=0.04u
M19146 U5666/net6 n5044 U5666/net14 VSS nmos W=0.155u L=0.04u
M19147 U5666/net4 n4966 VSS VSS nmos W=0.155u L=0.04u
M19148 U5666/net6 U5666/net4 VSS VSS nmos W=0.155u L=0.04u
M19149 n5119 U5666/net14 VSS VSS nmos W=0.155u L=0.04u
M19150 U5666/net10 n5044 VSS VSS nmos W=0.155u L=0.04u
M19151 U5666/net4 n5044 U5666/net14 VDD pmos W=0.205u L=0.04u
M19152 U5666/net6 U5666/net10 U5666/net14 VDD pmos W=0.205u L=0.04u
M19153 U5666/net4 n4966 VDD VDD pmos W=0.205u L=0.04u
M19154 U5666/net6 U5666/net4 VDD VDD pmos W=0.205u L=0.04u
M19155 n5119 U5666/net14 VDD VDD pmos W=0.205u L=0.04u
M19156 U5666/net10 n5044 VDD VDD pmos W=0.205u L=0.04u
M19157 U5667/net4 U5667/net10 U5667/net14 VSS nmos W=0.155u L=0.04u
M19158 U5667/net6 n5069 U5667/net14 VSS nmos W=0.155u L=0.04u
M19159 U5667/net4 g793 VSS VSS nmos W=0.155u L=0.04u
M19160 U5667/net6 U5667/net4 VSS VSS nmos W=0.155u L=0.04u
M19161 n5178 U5667/net14 VSS VSS nmos W=0.155u L=0.04u
M19162 U5667/net10 n5069 VSS VSS nmos W=0.155u L=0.04u
M19163 U5667/net4 n5069 U5667/net14 VDD pmos W=0.205u L=0.04u
M19164 U5667/net6 U5667/net10 U5667/net14 VDD pmos W=0.205u L=0.04u
M19165 U5667/net4 g793 VDD VDD pmos W=0.205u L=0.04u
M19166 U5667/net6 U5667/net4 VDD VDD pmos W=0.205u L=0.04u
M19167 n5178 U5667/net14 VDD VDD pmos W=0.205u L=0.04u
M19168 U5667/net10 n5069 VDD VDD pmos W=0.205u L=0.04u
M19169 U5668/net4 U5668/net10 U5668/net14 VSS nmos W=0.155u L=0.04u
M19170 U5668/net6 n5034 U5668/net14 VSS nmos W=0.155u L=0.04u
M19171 U5668/net4 n4968 VSS VSS nmos W=0.155u L=0.04u
M19172 U5668/net6 U5668/net4 VSS VSS nmos W=0.155u L=0.04u
M19173 n5176 U5668/net14 VSS VSS nmos W=0.155u L=0.04u
M19174 U5668/net10 n5034 VSS VSS nmos W=0.155u L=0.04u
M19175 U5668/net4 n5034 U5668/net14 VDD pmos W=0.205u L=0.04u
M19176 U5668/net6 U5668/net10 U5668/net14 VDD pmos W=0.205u L=0.04u
M19177 U5668/net4 n4968 VDD VDD pmos W=0.205u L=0.04u
M19178 U5668/net6 U5668/net4 VDD VDD pmos W=0.205u L=0.04u
M19179 n5176 U5668/net14 VDD VDD pmos W=0.205u L=0.04u
M19180 U5668/net10 n5034 VDD VDD pmos W=0.205u L=0.04u
M19181 U5669/net4 n5057 U5669/net14 VSS nmos W=0.155u L=0.04u
M19182 U5669/net6 U5669/net10 U5669/net14 VSS nmos W=0.17u L=0.04u
M19183 U5669/net4 n4178 VSS VSS nmos W=0.155u L=0.04u
M19184 U5669/net6 U5669/net4 VSS VSS nmos W=0.17u L=0.04u
M19185 n5174 U5669/net14 VSS VSS nmos W=0.155u L=0.04u
M19186 U5669/net10 n5057 VSS VSS nmos W=0.155u L=0.04u
M19187 U5669/net4 U5669/net10 U5669/net14 VDD pmos W=0.255u L=0.04u
M19188 U5669/net6 n5057 U5669/net14 VDD pmos W=0.28u L=0.04u
M19189 U5669/net4 n4178 VDD VDD pmos W=0.205u L=0.04u
M19190 U5669/net6 U5669/net4 VDD VDD pmos W=0.24u L=0.04u
M19191 n5174 U5669/net14 VDD VDD pmos W=0.205u L=0.04u
M19192 U5669/net10 n5057 VDD VDD pmos W=0.205u L=0.04u
M19193 n4178 n5163 VSS VSS nmos W=0.135u L=0.04u
M19194 n4178 n5163 VDD VDD pmos W=0.205u L=0.04u
M19195 n5163 n4989 U5671/net27 VSS nmos W=0.155u L=0.04u
M19196 U5671/net39 n4991 VSS VSS nmos W=0.155u L=0.04u
M19197 U5671/net27 g863 U5671/net39 VSS nmos W=0.155u L=0.04u
M19198 U5671/net27 n4990 U5671/net39 VSS nmos W=0.155u L=0.04u
M19199 n5163 g864 U5671/net27 VSS nmos W=0.155u L=0.04u
M19200 U5671/net39 g862 VSS VSS nmos W=0.155u L=0.04u
M19201 n5163 n4991 U5671/net46 VDD pmos W=0.205u L=0.04u
M19202 U5671/net46 g862 VDD VDD pmos W=0.205u L=0.04u
M19203 n5163 g864 U5671/net34 VDD pmos W=0.205u L=0.04u
M19204 U5671/net34 n4989 VDD VDD pmos W=0.205u L=0.04u
M19205 n5163 n4990 U5671/net37 VDD pmos W=0.205u L=0.04u
M19206 U5671/net37 g863 VDD VDD pmos W=0.205u L=0.04u
M19207 n5120 n4970 U5672/net27 VSS nmos W=0.155u L=0.04u
M19208 U5672/net39 n4333 VSS VSS nmos W=0.155u L=0.04u
M19209 U5672/net27 g1008 U5672/net39 VSS nmos W=0.155u L=0.04u
M19210 U5672/net27 n4971 U5672/net39 VSS nmos W=0.155u L=0.04u
M19211 n5120 g1009 U5672/net27 VSS nmos W=0.155u L=0.04u
M19212 U5672/net39 g1010 VSS VSS nmos W=0.155u L=0.04u
M19213 n5120 n4333 U5672/net46 VDD pmos W=0.205u L=0.04u
M19214 U5672/net46 g1010 VDD VDD pmos W=0.205u L=0.04u
M19215 n5120 g1009 U5672/net34 VDD pmos W=0.205u L=0.04u
M19216 U5672/net34 n4970 VDD VDD pmos W=0.205u L=0.04u
M19217 n5120 n4971 U5672/net37 VDD pmos W=0.205u L=0.04u
M19218 U5672/net37 g1008 VDD VDD pmos W=0.205u L=0.04u
M19219 n5104 n5028 VSS VSS nmos W=0.135u L=0.04u
M19220 n5104 n5028 VDD VDD pmos W=0.205u L=0.04u
M19221 n5137 n5134 U5674/net27 VSS nmos W=0.155u L=0.04u
M19222 U5674/net27 n5056 VSS VSS nmos W=0.155u L=0.04u
M19223 n5137 n5133 VSS VSS nmos W=0.155u L=0.04u
M19224 n5137 n5056 U5674/net13 VDD pmos W=0.205u L=0.04u
M19225 U5674/net13 n5133 VDD VDD pmos W=0.205u L=0.04u
M19226 n5137 n5134 U5674/net13 VDD pmos W=0.205u L=0.04u
M19227 n5133 U5675/net6 VSS VSS nmos W=0.155u L=0.04u
M19228 U5675/net6 n5179 U5675/XU30-net23 VSS nmos W=0.155u L=0.04u
M19229 U5675/XU30-net23 n5131 U5675/XU30-net26 VSS nmos W=0.155u L=0.04u
M19230 U5675/XU30-net26 n5029 U5675/XU30-net29 VSS nmos W=0.155u L=0.04u
M19231 U5675/XU30-net29 n5180 VSS VSS nmos W=0.155u L=0.04u
M19232 n5133 U5675/net6 VDD VDD pmos W=0.205u L=0.04u
M19233 U5675/net6 n5180 VDD VDD pmos W=0.205u L=0.04u
M19234 U5675/net6 n5029 VDD VDD pmos W=0.205u L=0.04u
M19235 U5675/net6 n5131 VDD VDD pmos W=0.205u L=0.04u
M19236 U5675/net6 n5179 VDD VDD pmos W=0.205u L=0.04u
M19237 n5180 n5077 VSS VSS nmos W=0.155u L=0.04u
M19238 n5180 n5181 VSS VSS nmos W=0.155u L=0.04u
M19239 n5180 n5069 VSS VSS nmos W=0.155u L=0.04u
M19240 n5180 n5057 VSS VSS nmos W=0.155u L=0.04u
M19241 U5676/net49 n5181 U5676/net52 VDD pmos W=0.41u L=0.04u
M19242 U5676/net52 n5077 VDD VDD pmos W=0.41u L=0.04u
M19243 U5676/net46 n5069 U5676/net49 VDD pmos W=0.41u L=0.04u
M19244 n5180 n5057 U5676/net46 VDD pmos W=0.41u L=0.04u
M19245 n5134 n5182 VSS VSS nmos W=0.135u L=0.04u
M19246 n5134 n5182 VDD VDD pmos W=0.205u L=0.04u
M19247 n5136 n5029 VSS VSS nmos W=0.155u L=0.04u
M19248 n5136 n4170 VSS VSS nmos W=0.155u L=0.04u
M19249 U5678/XI1-net8 n4170 VDD VDD pmos W=0.205u L=0.04u
M19250 n5136 n5029 U5678/XI1-net8 VDD pmos W=0.205u L=0.04u
M19251 n5029 n5056 VSS VSS nmos W=0.135u L=0.04u
M19252 n5029 n5056 VDD VDD pmos W=0.205u L=0.04u
M19253 U5680/XU1-net6 n5087 VSS VSS nmos W=0.155u L=0.04u
M19254 n5056 n5100 U5680/XU1-net6 VSS nmos W=0.155u L=0.04u
M19255 n5056 n5087 VDD VDD pmos W=0.155u L=0.04u
M19256 n5056 n5100 VDD VDD pmos W=0.155u L=0.04u
M19257 n5087 n5095 VSS VSS nmos W=0.135u L=0.04u
M19258 n5087 n5095 VDD VDD pmos W=0.205u L=0.04u
M19259 U5682/net19 n4071 VSS VSS nmos W=0.155u L=0.04u
M19260 n3007 n4071 U5682/net40 VSS nmos W=0.155u L=0.04u
M19261 n3007 U5682/net19 U5682/net36 VSS nmos W=0.155u L=0.04u
M19262 U5682/net40 n5183 VSS VSS nmos W=0.31u L=0.04u
M19263 U5682/net36 g1512 VSS VSS nmos W=0.155u L=0.04u
M19264 U5682/net19 n4071 VDD VDD pmos W=0.205u L=0.04u
M19265 n3007 U5682/net19 U5682/net26 VDD pmos W=0.325u L=0.04u
M19266 U5682/net26 n5183 VDD VDD pmos W=0.41u L=0.04u
M19267 n3007 n4071 U5682/net30 VDD pmos W=0.325u L=0.04u
M19268 U5682/net30 g1512 VDD VDD pmos W=0.205u L=0.04u
M19269 U5683/net19 n4068 VSS VSS nmos W=0.155u L=0.04u
M19270 n3006 n4068 U5683/net40 VSS nmos W=0.155u L=0.04u
M19271 n3006 U5683/net19 U5683/net36 VSS nmos W=0.155u L=0.04u
M19272 U5683/net40 n5183 VSS VSS nmos W=0.31u L=0.04u
M19273 U5683/net36 g1513 VSS VSS nmos W=0.155u L=0.04u
M19274 U5683/net19 n4068 VDD VDD pmos W=0.205u L=0.04u
M19275 n3006 U5683/net19 U5683/net26 VDD pmos W=0.325u L=0.04u
M19276 U5683/net26 n5183 VDD VDD pmos W=0.41u L=0.04u
M19277 n3006 n4068 U5683/net30 VDD pmos W=0.325u L=0.04u
M19278 U5683/net30 g1513 VDD VDD pmos W=0.205u L=0.04u
M19279 U5684/net19 n4069 VSS VSS nmos W=0.155u L=0.04u
M19280 n3005 n4069 U5684/net40 VSS nmos W=0.155u L=0.04u
M19281 n3005 U5684/net19 U5684/net36 VSS nmos W=0.155u L=0.04u
M19282 U5684/net40 n5183 VSS VSS nmos W=0.31u L=0.04u
M19283 U5684/net36 g1511 VSS VSS nmos W=0.155u L=0.04u
M19284 U5684/net19 n4069 VDD VDD pmos W=0.205u L=0.04u
M19285 n3005 U5684/net19 U5684/net26 VDD pmos W=0.325u L=0.04u
M19286 U5684/net26 n5183 VDD VDD pmos W=0.41u L=0.04u
M19287 n3005 n4069 U5684/net30 VDD pmos W=0.325u L=0.04u
M19288 U5684/net30 g1511 VDD VDD pmos W=0.205u L=0.04u
M19289 U5685/net19 n4071 VSS VSS nmos W=0.155u L=0.04u
M19290 n3004 n4071 U5685/net40 VSS nmos W=0.155u L=0.04u
M19291 n3004 U5685/net19 U5685/net36 VSS nmos W=0.155u L=0.04u
M19292 U5685/net40 n5184 VSS VSS nmos W=0.31u L=0.04u
M19293 U5685/net36 g1515 VSS VSS nmos W=0.155u L=0.04u
M19294 U5685/net19 n4071 VDD VDD pmos W=0.205u L=0.04u
M19295 n3004 U5685/net19 U5685/net26 VDD pmos W=0.325u L=0.04u
M19296 U5685/net26 n5184 VDD VDD pmos W=0.41u L=0.04u
M19297 n3004 n4071 U5685/net30 VDD pmos W=0.325u L=0.04u
M19298 U5685/net30 g1515 VDD VDD pmos W=0.205u L=0.04u
M19299 U5686/net19 n4068 VSS VSS nmos W=0.155u L=0.04u
M19300 n3003 n4068 U5686/net40 VSS nmos W=0.155u L=0.04u
M19301 n3003 U5686/net19 U5686/net36 VSS nmos W=0.155u L=0.04u
M19302 U5686/net40 n5184 VSS VSS nmos W=0.31u L=0.04u
M19303 U5686/net36 g1516 VSS VSS nmos W=0.155u L=0.04u
M19304 U5686/net19 n4068 VDD VDD pmos W=0.205u L=0.04u
M19305 n3003 U5686/net19 U5686/net26 VDD pmos W=0.325u L=0.04u
M19306 U5686/net26 n5184 VDD VDD pmos W=0.41u L=0.04u
M19307 n3003 n4068 U5686/net30 VDD pmos W=0.325u L=0.04u
M19308 U5686/net30 g1516 VDD VDD pmos W=0.205u L=0.04u
M19309 U5687/net19 n4069 VSS VSS nmos W=0.155u L=0.04u
M19310 n3002 n4069 U5687/net40 VSS nmos W=0.155u L=0.04u
M19311 n3002 U5687/net19 U5687/net36 VSS nmos W=0.155u L=0.04u
M19312 U5687/net40 n5184 VSS VSS nmos W=0.31u L=0.04u
M19313 U5687/net36 g1514 VSS VSS nmos W=0.155u L=0.04u
M19314 U5687/net19 n4069 VDD VDD pmos W=0.205u L=0.04u
M19315 n3002 U5687/net19 U5687/net26 VDD pmos W=0.325u L=0.04u
M19316 U5687/net26 n5184 VDD VDD pmos W=0.41u L=0.04u
M19317 n3002 n4069 U5687/net30 VDD pmos W=0.325u L=0.04u
M19318 U5687/net30 g1514 VDD VDD pmos W=0.205u L=0.04u
M19319 U5688/net19 n4071 VSS VSS nmos W=0.155u L=0.04u
M19320 n3001 n4071 U5688/net40 VSS nmos W=0.155u L=0.04u
M19321 n3001 U5688/net19 U5688/net36 VSS nmos W=0.155u L=0.04u
M19322 U5688/net40 n5185 VSS VSS nmos W=0.31u L=0.04u
M19323 U5688/net36 g1524 VSS VSS nmos W=0.155u L=0.04u
M19324 U5688/net19 n4071 VDD VDD pmos W=0.205u L=0.04u
M19325 n3001 U5688/net19 U5688/net26 VDD pmos W=0.325u L=0.04u
M19326 U5688/net26 n5185 VDD VDD pmos W=0.41u L=0.04u
M19327 n3001 n4071 U5688/net30 VDD pmos W=0.325u L=0.04u
M19328 U5688/net30 g1524 VDD VDD pmos W=0.205u L=0.04u
M19329 U5689/net19 n4068 VSS VSS nmos W=0.155u L=0.04u
M19330 n3000 n4068 U5689/net40 VSS nmos W=0.155u L=0.04u
M19331 n3000 U5689/net19 U5689/net36 VSS nmos W=0.155u L=0.04u
M19332 U5689/net40 n5185 VSS VSS nmos W=0.31u L=0.04u
M19333 U5689/net36 g1525 VSS VSS nmos W=0.155u L=0.04u
M19334 U5689/net19 n4068 VDD VDD pmos W=0.205u L=0.04u
M19335 n3000 U5689/net19 U5689/net26 VDD pmos W=0.325u L=0.04u
M19336 U5689/net26 n5185 VDD VDD pmos W=0.41u L=0.04u
M19337 n3000 n4068 U5689/net30 VDD pmos W=0.325u L=0.04u
M19338 U5689/net30 g1525 VDD VDD pmos W=0.205u L=0.04u
M19339 U5690/net19 n4069 VSS VSS nmos W=0.155u L=0.04u
M19340 n2999 n4069 U5690/net40 VSS nmos W=0.155u L=0.04u
M19341 n2999 U5690/net19 U5690/net36 VSS nmos W=0.155u L=0.04u
M19342 U5690/net40 n5185 VSS VSS nmos W=0.31u L=0.04u
M19343 U5690/net36 g1523 VSS VSS nmos W=0.155u L=0.04u
M19344 U5690/net19 n4069 VDD VDD pmos W=0.205u L=0.04u
M19345 n2999 U5690/net19 U5690/net26 VDD pmos W=0.325u L=0.04u
M19346 U5690/net26 n5185 VDD VDD pmos W=0.41u L=0.04u
M19347 n2999 n4069 U5690/net30 VDD pmos W=0.325u L=0.04u
M19348 U5690/net30 g1523 VDD VDD pmos W=0.205u L=0.04u
M19349 U5691/net19 n4071 VSS VSS nmos W=0.155u L=0.04u
M19350 n2998 n4071 U5691/net40 VSS nmos W=0.155u L=0.04u
M19351 n2998 U5691/net19 U5691/net36 VSS nmos W=0.155u L=0.04u
M19352 U5691/net40 n5186 VSS VSS nmos W=0.31u L=0.04u
M19353 U5691/net36 g1527 VSS VSS nmos W=0.155u L=0.04u
M19354 U5691/net19 n4071 VDD VDD pmos W=0.205u L=0.04u
M19355 n2998 U5691/net19 U5691/net26 VDD pmos W=0.325u L=0.04u
M19356 U5691/net26 n5186 VDD VDD pmos W=0.41u L=0.04u
M19357 n2998 n4071 U5691/net30 VDD pmos W=0.325u L=0.04u
M19358 U5691/net30 g1527 VDD VDD pmos W=0.205u L=0.04u
M19359 U5692/net19 n4068 VSS VSS nmos W=0.155u L=0.04u
M19360 n2997 n4068 U5692/net40 VSS nmos W=0.155u L=0.04u
M19361 n2997 U5692/net19 U5692/net36 VSS nmos W=0.155u L=0.04u
M19362 U5692/net40 n5186 VSS VSS nmos W=0.31u L=0.04u
M19363 U5692/net36 g1528 VSS VSS nmos W=0.155u L=0.04u
M19364 U5692/net19 n4068 VDD VDD pmos W=0.205u L=0.04u
M19365 n2997 U5692/net19 U5692/net26 VDD pmos W=0.325u L=0.04u
M19366 U5692/net26 n5186 VDD VDD pmos W=0.41u L=0.04u
M19367 n2997 n4068 U5692/net30 VDD pmos W=0.325u L=0.04u
M19368 U5692/net30 g1528 VDD VDD pmos W=0.205u L=0.04u
M19369 U5693/net19 n4069 VSS VSS nmos W=0.155u L=0.04u
M19370 n2996 n4069 U5693/net40 VSS nmos W=0.155u L=0.04u
M19371 n2996 U5693/net19 U5693/net36 VSS nmos W=0.155u L=0.04u
M19372 U5693/net40 n5186 VSS VSS nmos W=0.31u L=0.04u
M19373 U5693/net36 g1526 VSS VSS nmos W=0.155u L=0.04u
M19374 U5693/net19 n4069 VDD VDD pmos W=0.205u L=0.04u
M19375 n2996 U5693/net19 U5693/net26 VDD pmos W=0.325u L=0.04u
M19376 U5693/net26 n5186 VDD VDD pmos W=0.41u L=0.04u
M19377 n2996 n4069 U5693/net30 VDD pmos W=0.325u L=0.04u
M19378 U5693/net30 g1526 VDD VDD pmos W=0.205u L=0.04u
M19379 U5694/net19 n4071 VSS VSS nmos W=0.155u L=0.04u
M19380 n2995 n4071 U5694/net40 VSS nmos W=0.155u L=0.04u
M19381 n2995 U5694/net19 U5694/net36 VSS nmos W=0.155u L=0.04u
M19382 U5694/net40 n5187 VSS VSS nmos W=0.31u L=0.04u
M19383 U5694/net36 g1530 VSS VSS nmos W=0.155u L=0.04u
M19384 U5694/net19 n4071 VDD VDD pmos W=0.205u L=0.04u
M19385 n2995 U5694/net19 U5694/net26 VDD pmos W=0.325u L=0.04u
M19386 U5694/net26 n5187 VDD VDD pmos W=0.41u L=0.04u
M19387 n2995 n4071 U5694/net30 VDD pmos W=0.325u L=0.04u
M19388 U5694/net30 g1530 VDD VDD pmos W=0.205u L=0.04u
M19389 U5695/net19 n4068 VSS VSS nmos W=0.155u L=0.04u
M19390 n2994 n4068 U5695/net40 VSS nmos W=0.155u L=0.04u
M19391 n2994 U5695/net19 U5695/net36 VSS nmos W=0.155u L=0.04u
M19392 U5695/net40 n5187 VSS VSS nmos W=0.31u L=0.04u
M19393 U5695/net36 g1531 VSS VSS nmos W=0.155u L=0.04u
M19394 U5695/net19 n4068 VDD VDD pmos W=0.205u L=0.04u
M19395 n2994 U5695/net19 U5695/net26 VDD pmos W=0.325u L=0.04u
M19396 U5695/net26 n5187 VDD VDD pmos W=0.41u L=0.04u
M19397 n2994 n4068 U5695/net30 VDD pmos W=0.325u L=0.04u
M19398 U5695/net30 g1531 VDD VDD pmos W=0.205u L=0.04u
M19399 U5696/net19 n4069 VSS VSS nmos W=0.155u L=0.04u
M19400 n2993 n4069 U5696/net40 VSS nmos W=0.155u L=0.04u
M19401 n2993 U5696/net19 U5696/net36 VSS nmos W=0.155u L=0.04u
M19402 U5696/net40 n5187 VSS VSS nmos W=0.31u L=0.04u
M19403 U5696/net36 g1529 VSS VSS nmos W=0.155u L=0.04u
M19404 U5696/net19 n4069 VDD VDD pmos W=0.205u L=0.04u
M19405 n2993 U5696/net19 U5696/net26 VDD pmos W=0.325u L=0.04u
M19406 U5696/net26 n5187 VDD VDD pmos W=0.41u L=0.04u
M19407 n2993 n4069 U5696/net30 VDD pmos W=0.325u L=0.04u
M19408 U5696/net30 g1529 VDD VDD pmos W=0.205u L=0.04u
M19409 U5697/net19 n4071 VSS VSS nmos W=0.155u L=0.04u
M19410 n2992 n4071 U5697/net40 VSS nmos W=0.155u L=0.04u
M19411 n2992 U5697/net19 U5697/net36 VSS nmos W=0.155u L=0.04u
M19412 U5697/net40 n5188 VSS VSS nmos W=0.31u L=0.04u
M19413 U5697/net36 g1533 VSS VSS nmos W=0.155u L=0.04u
M19414 U5697/net19 n4071 VDD VDD pmos W=0.205u L=0.04u
M19415 n2992 U5697/net19 U5697/net26 VDD pmos W=0.325u L=0.04u
M19416 U5697/net26 n5188 VDD VDD pmos W=0.41u L=0.04u
M19417 n2992 n4071 U5697/net30 VDD pmos W=0.325u L=0.04u
M19418 U5697/net30 g1533 VDD VDD pmos W=0.205u L=0.04u
M19419 U5698/net19 n4068 VSS VSS nmos W=0.155u L=0.04u
M19420 n2991 n4068 U5698/net40 VSS nmos W=0.155u L=0.04u
M19421 n2991 U5698/net19 U5698/net36 VSS nmos W=0.155u L=0.04u
M19422 U5698/net40 n5188 VSS VSS nmos W=0.31u L=0.04u
M19423 U5698/net36 g1534 VSS VSS nmos W=0.155u L=0.04u
M19424 U5698/net19 n4068 VDD VDD pmos W=0.205u L=0.04u
M19425 n2991 U5698/net19 U5698/net26 VDD pmos W=0.325u L=0.04u
M19426 U5698/net26 n5188 VDD VDD pmos W=0.41u L=0.04u
M19427 n2991 n4068 U5698/net30 VDD pmos W=0.325u L=0.04u
M19428 U5698/net30 g1534 VDD VDD pmos W=0.205u L=0.04u
M19429 U5699/net19 n4069 VSS VSS nmos W=0.155u L=0.04u
M19430 n2990 n4069 U5699/net40 VSS nmos W=0.155u L=0.04u
M19431 n2990 U5699/net19 U5699/net36 VSS nmos W=0.155u L=0.04u
M19432 U5699/net40 n5188 VSS VSS nmos W=0.31u L=0.04u
M19433 U5699/net36 g1532 VSS VSS nmos W=0.155u L=0.04u
M19434 U5699/net19 n4069 VDD VDD pmos W=0.205u L=0.04u
M19435 n2990 U5699/net19 U5699/net26 VDD pmos W=0.325u L=0.04u
M19436 U5699/net26 n5188 VDD VDD pmos W=0.41u L=0.04u
M19437 n2990 n4069 U5699/net30 VDD pmos W=0.325u L=0.04u
M19438 U5699/net30 g1532 VDD VDD pmos W=0.205u L=0.04u
M19439 U5700/net19 n4071 VSS VSS nmos W=0.155u L=0.04u
M19440 n2989 n4071 U5700/net40 VSS nmos W=0.155u L=0.04u
M19441 n2989 U5700/net19 U5700/net36 VSS nmos W=0.155u L=0.04u
M19442 U5700/net40 n5189 VSS VSS nmos W=0.31u L=0.04u
M19443 U5700/net36 g1536 VSS VSS nmos W=0.155u L=0.04u
M19444 U5700/net19 n4071 VDD VDD pmos W=0.205u L=0.04u
M19445 n2989 U5700/net19 U5700/net26 VDD pmos W=0.325u L=0.04u
M19446 U5700/net26 n5189 VDD VDD pmos W=0.41u L=0.04u
M19447 n2989 n4071 U5700/net30 VDD pmos W=0.325u L=0.04u
M19448 U5700/net30 g1536 VDD VDD pmos W=0.205u L=0.04u
M19449 U5701/net19 n4068 VSS VSS nmos W=0.155u L=0.04u
M19450 n2988 n4068 U5701/net40 VSS nmos W=0.155u L=0.04u
M19451 n2988 U5701/net19 U5701/net36 VSS nmos W=0.155u L=0.04u
M19452 U5701/net40 n5189 VSS VSS nmos W=0.31u L=0.04u
M19453 U5701/net36 g1537 VSS VSS nmos W=0.155u L=0.04u
M19454 U5701/net19 n4068 VDD VDD pmos W=0.205u L=0.04u
M19455 n2988 U5701/net19 U5701/net26 VDD pmos W=0.325u L=0.04u
M19456 U5701/net26 n5189 VDD VDD pmos W=0.41u L=0.04u
M19457 n2988 n4068 U5701/net30 VDD pmos W=0.325u L=0.04u
M19458 U5701/net30 g1537 VDD VDD pmos W=0.205u L=0.04u
M19459 U5702/net19 n4069 VSS VSS nmos W=0.155u L=0.04u
M19460 n2987 n4069 U5702/net40 VSS nmos W=0.155u L=0.04u
M19461 n2987 U5702/net19 U5702/net36 VSS nmos W=0.155u L=0.04u
M19462 U5702/net40 n5189 VSS VSS nmos W=0.31u L=0.04u
M19463 U5702/net36 g1535 VSS VSS nmos W=0.155u L=0.04u
M19464 U5702/net19 n4069 VDD VDD pmos W=0.205u L=0.04u
M19465 n2987 U5702/net19 U5702/net26 VDD pmos W=0.325u L=0.04u
M19466 U5702/net26 n5189 VDD VDD pmos W=0.41u L=0.04u
M19467 n2987 n4069 U5702/net30 VDD pmos W=0.325u L=0.04u
M19468 U5702/net30 g1535 VDD VDD pmos W=0.205u L=0.04u
M19469 U5703/net19 n5191 VSS VSS nmos W=0.155u L=0.04u
M19470 n2986 n5191 U5703/net40 VSS nmos W=0.155u L=0.04u
M19471 n2986 U5703/net19 U5703/net36 VSS nmos W=0.155u L=0.04u
M19472 U5703/net40 g1810 VSS VSS nmos W=0.31u L=0.04u
M19473 U5703/net36 n5190 VSS VSS nmos W=0.155u L=0.04u
M19474 U5703/net19 n5191 VDD VDD pmos W=0.205u L=0.04u
M19475 n2986 U5703/net19 U5703/net26 VDD pmos W=0.325u L=0.04u
M19476 U5703/net26 g1810 VDD VDD pmos W=0.41u L=0.04u
M19477 n2986 n5191 U5703/net30 VDD pmos W=0.325u L=0.04u
M19478 U5703/net30 n5190 VDD VDD pmos W=0.205u L=0.04u
M19479 U5704/net19 n4334 VSS VSS nmos W=0.155u L=0.04u
M19480 n2985 n4334 U5704/net40 VSS nmos W=0.155u L=0.04u
M19481 n2985 U5704/net19 U5704/net36 VSS nmos W=0.155u L=0.04u
M19482 U5704/net40 g1813 VSS VSS nmos W=0.31u L=0.04u
M19483 U5704/net36 n5190 VSS VSS nmos W=0.155u L=0.04u
M19484 U5704/net19 n4334 VDD VDD pmos W=0.205u L=0.04u
M19485 n2985 U5704/net19 U5704/net26 VDD pmos W=0.325u L=0.04u
M19486 U5704/net26 g1813 VDD VDD pmos W=0.41u L=0.04u
M19487 n2985 n4334 U5704/net30 VDD pmos W=0.325u L=0.04u
M19488 U5704/net30 n5190 VDD VDD pmos W=0.205u L=0.04u
M19489 U5705/net19 n5192 VSS VSS nmos W=0.155u L=0.04u
M19490 n2984 n5192 U5705/net40 VSS nmos W=0.155u L=0.04u
M19491 n2984 U5705/net19 U5705/net36 VSS nmos W=0.155u L=0.04u
M19492 U5705/net40 g1816 VSS VSS nmos W=0.31u L=0.04u
M19493 U5705/net36 n5190 VSS VSS nmos W=0.155u L=0.04u
M19494 U5705/net19 n5192 VDD VDD pmos W=0.205u L=0.04u
M19495 n2984 U5705/net19 U5705/net26 VDD pmos W=0.325u L=0.04u
M19496 U5705/net26 g1816 VDD VDD pmos W=0.41u L=0.04u
M19497 n2984 n5192 U5705/net30 VDD pmos W=0.325u L=0.04u
M19498 U5705/net30 n5190 VDD VDD pmos W=0.205u L=0.04u
M19499 U5706/net19 g1690 VSS VSS nmos W=0.155u L=0.04u
M19500 n5190 g1690 U5706/net40 VSS nmos W=0.155u L=0.04u
M19501 n5190 U5706/net19 U5706/net36 VSS nmos W=0.155u L=0.04u
M19502 U5706/net40 n5194 VSS VSS nmos W=0.31u L=0.04u
M19503 U5706/net36 n5193 VSS VSS nmos W=0.155u L=0.04u
M19504 U5706/net19 g1690 VDD VDD pmos W=0.205u L=0.04u
M19505 n5190 U5706/net19 U5706/net26 VDD pmos W=0.325u L=0.04u
M19506 U5706/net26 n5194 VDD VDD pmos W=0.41u L=0.04u
M19507 n5190 g1690 U5706/net30 VDD pmos W=0.325u L=0.04u
M19508 U5706/net30 n5193 VDD VDD pmos W=0.205u L=0.04u
M19509 U5707/net19 n5191 VSS VSS nmos W=0.155u L=0.04u
M19510 n2983 n5191 U5707/net40 VSS nmos W=0.155u L=0.04u
M19511 n2983 U5707/net19 U5707/net36 VSS nmos W=0.155u L=0.04u
M19512 U5707/net40 g1819 VSS VSS nmos W=0.31u L=0.04u
M19513 U5707/net36 n5195 VSS VSS nmos W=0.155u L=0.04u
M19514 U5707/net19 n5191 VDD VDD pmos W=0.205u L=0.04u
M19515 n2983 U5707/net19 U5707/net26 VDD pmos W=0.325u L=0.04u
M19516 U5707/net26 g1819 VDD VDD pmos W=0.41u L=0.04u
M19517 n2983 n5191 U5707/net30 VDD pmos W=0.325u L=0.04u
M19518 U5707/net30 n5195 VDD VDD pmos W=0.205u L=0.04u
M19519 U5708/net19 n4334 VSS VSS nmos W=0.155u L=0.04u
M19520 n2982 n4334 U5708/net40 VSS nmos W=0.155u L=0.04u
M19521 n2982 U5708/net19 U5708/net36 VSS nmos W=0.155u L=0.04u
M19522 U5708/net40 g1822 VSS VSS nmos W=0.31u L=0.04u
M19523 U5708/net36 n5195 VSS VSS nmos W=0.155u L=0.04u
M19524 U5708/net19 n4334 VDD VDD pmos W=0.205u L=0.04u
M19525 n2982 U5708/net19 U5708/net26 VDD pmos W=0.325u L=0.04u
M19526 U5708/net26 g1822 VDD VDD pmos W=0.41u L=0.04u
M19527 n2982 n4334 U5708/net30 VDD pmos W=0.325u L=0.04u
M19528 U5708/net30 n5195 VDD VDD pmos W=0.205u L=0.04u
M19529 U5709/net19 n5192 VSS VSS nmos W=0.155u L=0.04u
M19530 n2981 n5192 U5709/net40 VSS nmos W=0.155u L=0.04u
M19531 n2981 U5709/net19 U5709/net36 VSS nmos W=0.155u L=0.04u
M19532 U5709/net40 g1825 VSS VSS nmos W=0.31u L=0.04u
M19533 U5709/net36 n5195 VSS VSS nmos W=0.155u L=0.04u
M19534 U5709/net19 n5192 VDD VDD pmos W=0.205u L=0.04u
M19535 n2981 U5709/net19 U5709/net26 VDD pmos W=0.325u L=0.04u
M19536 U5709/net26 g1825 VDD VDD pmos W=0.41u L=0.04u
M19537 n2981 n5192 U5709/net30 VDD pmos W=0.325u L=0.04u
M19538 U5709/net30 n5195 VDD VDD pmos W=0.205u L=0.04u
M19539 U5710/net4 n5196 U5710/net14 VSS nmos W=0.155u L=0.04u
M19540 U5710/net6 U5710/net10 U5710/net14 VSS nmos W=0.17u L=0.04u
M19541 U5710/net4 n5197 VSS VSS nmos W=0.155u L=0.04u
M19542 U5710/net6 U5710/net4 VSS VSS nmos W=0.17u L=0.04u
M19543 n5195 U5710/net14 VSS VSS nmos W=0.155u L=0.04u
M19544 U5710/net10 n5196 VSS VSS nmos W=0.155u L=0.04u
M19545 U5710/net4 U5710/net10 U5710/net14 VDD pmos W=0.255u L=0.04u
M19546 U5710/net6 n5196 U5710/net14 VDD pmos W=0.28u L=0.04u
M19547 U5710/net4 n5197 VDD VDD pmos W=0.205u L=0.04u
M19548 U5710/net6 U5710/net4 VDD VDD pmos W=0.24u L=0.04u
M19549 n5195 U5710/net14 VDD VDD pmos W=0.205u L=0.04u
M19550 U5710/net10 n5196 VDD VDD pmos W=0.205u L=0.04u
M19551 n5196 n5200 VSS VSS nmos W=0.155u L=0.04u
M19552 n5196 n5199 VSS VSS nmos W=0.155u L=0.04u
M19553 n5196 n5198 VSS VSS nmos W=0.155u L=0.04u
M19554 U5711/net25 n5200 VDD VDD pmos W=0.41u L=0.04u
M19555 U5711/net28 n5199 U5711/net25 VDD pmos W=0.41u L=0.04u
M19556 n5196 n5198 U5711/net28 VDD pmos W=0.41u L=0.04u
M19557 n2980 n5192 U5712/net10 VSS nmos W=0.155u L=0.04u
M19558 U5712/net10 n5202 VSS VSS nmos W=0.155u L=0.04u
M19559 n2980 n5201 U5712/net10 VSS nmos W=0.155u L=0.04u
M19560 U5712/net10 g1828 VSS VSS nmos W=0.155u L=0.04u
M19561 U5712/net30 n5202 VDD VDD pmos W=0.205u L=0.04u
M19562 n2980 n5192 U5712/net24 VDD pmos W=0.205u L=0.04u
M19563 U5712/net24 n5201 VDD VDD pmos W=0.205u L=0.04u
M19564 n2980 g1828 U5712/net30 VDD pmos W=0.205u L=0.04u
M19565 n5202 n5192 VSS VSS nmos W=0.155u L=0.04u
M19566 n5202 n5203 VSS VSS nmos W=0.155u L=0.04u
M19567 U5713/XI1-net8 n5203 VDD VDD pmos W=0.205u L=0.04u
M19568 n5202 n5192 U5713/XI1-net8 VDD pmos W=0.205u L=0.04u
M19569 n2979 n4334 U5714/net10 VSS nmos W=0.155u L=0.04u
M19570 U5714/net10 n5204 VSS VSS nmos W=0.155u L=0.04u
M19571 n2979 n5201 U5714/net10 VSS nmos W=0.155u L=0.04u
M19572 U5714/net10 g1830 VSS VSS nmos W=0.155u L=0.04u
M19573 U5714/net30 n5204 VDD VDD pmos W=0.205u L=0.04u
M19574 n2979 n4334 U5714/net24 VDD pmos W=0.205u L=0.04u
M19575 U5714/net24 n5201 VDD VDD pmos W=0.205u L=0.04u
M19576 n2979 g1830 U5714/net30 VDD pmos W=0.205u L=0.04u
M19577 n5204 n4334 VSS VSS nmos W=0.155u L=0.04u
M19578 n5204 n5203 VSS VSS nmos W=0.155u L=0.04u
M19579 U5715/XI1-net8 n5203 VDD VDD pmos W=0.205u L=0.04u
M19580 n5204 n4334 U5715/XI1-net8 VDD pmos W=0.205u L=0.04u
M19581 n2978 n5191 U5716/net10 VSS nmos W=0.155u L=0.04u
M19582 U5716/net10 n5205 VSS VSS nmos W=0.155u L=0.04u
M19583 n2978 n5201 U5716/net10 VSS nmos W=0.155u L=0.04u
M19584 U5716/net10 g1829 VSS VSS nmos W=0.155u L=0.04u
M19585 U5716/net30 n5205 VDD VDD pmos W=0.205u L=0.04u
M19586 n2978 n5191 U5716/net24 VDD pmos W=0.205u L=0.04u
M19587 U5716/net24 n5201 VDD VDD pmos W=0.205u L=0.04u
M19588 n2978 g1829 U5716/net30 VDD pmos W=0.205u L=0.04u
M19589 n5205 n5191 VSS VSS nmos W=0.155u L=0.04u
M19590 n5205 n5203 VSS VSS nmos W=0.155u L=0.04u
M19591 U5717/XI1-net8 n5203 VDD VDD pmos W=0.205u L=0.04u
M19592 n5205 n5191 U5717/XI1-net8 VDD pmos W=0.205u L=0.04u
M19593 U5718/net36 g1690 U5718/net24 VSS nmos W=0.155u L=0.04u
M19594 U5718/net24 n5206 VSS VSS nmos W=0.155u L=0.04u
M19595 n5203 n5193 U5718/net36 VSS nmos W=0.155u L=0.04u
M19596 n5203 n5194 U5718/net36 VSS nmos W=0.155u L=0.04u
M19597 n5203 n5194 U5718/net35 VDD pmos W=0.205u L=0.04u
M19598 U5718/net35 n5193 VDD VDD pmos W=0.205u L=0.04u
M19599 n5203 n5206 VDD VDD pmos W=0.205u L=0.04u
M19600 n5203 g1690 VDD VDD pmos W=0.205u L=0.04u
M19601 U5719/net19 n4066 VSS VSS nmos W=0.155u L=0.04u
M19602 n5206 n4066 U5719/net40 VSS nmos W=0.155u L=0.04u
M19603 n5206 U5719/net19 U5719/net36 VSS nmos W=0.155u L=0.04u
M19604 U5719/net40 n5193 VSS VSS nmos W=0.31u L=0.04u
M19605 U5719/net36 n5194 VSS VSS nmos W=0.155u L=0.04u
M19606 U5719/net19 n4066 VDD VDD pmos W=0.205u L=0.04u
M19607 n5206 U5719/net19 U5719/net26 VDD pmos W=0.325u L=0.04u
M19608 U5719/net26 n5193 VDD VDD pmos W=0.41u L=0.04u
M19609 n5206 n4066 U5719/net30 VDD pmos W=0.325u L=0.04u
M19610 U5719/net30 n5194 VDD VDD pmos W=0.205u L=0.04u
M19611 n4066 n5197 VSS VSS nmos W=0.135u L=0.04u
M19612 n4066 n5197 VDD VDD pmos W=0.205u L=0.04u
M19613 U5721/net30 n5198 VSS VSS nmos W=0.155u L=0.04u
M19614 n5201 n5199 U5721/net23 VSS nmos W=0.155u L=0.04u
M19615 U5721/net20 U5721/net30 VSS VSS nmos W=0.155u L=0.04u
M19616 U5721/net23 g1690 U5721/net20 VSS nmos W=0.155u L=0.04u
M19617 U5721/net30 n5198 VDD VDD pmos W=0.205u L=0.04u
M19618 VDD n5199 n5201 VDD pmos W=0.205u L=0.04u
M19619 VDD g1690 n5201 VDD pmos W=0.205u L=0.04u
M19620 VDD U5721/net30 n5201 VDD pmos W=0.205u L=0.04u
M19621 U5722/net36 n5191 U5722/net27 VSS nmos W=0.155u L=0.04u
M19622 U5722/net39 n4334 VSS VSS nmos W=0.155u L=0.04u
M19623 U5722/net27 g1828 U5722/net39 VSS nmos W=0.155u L=0.04u
M19624 U5722/net27 n5192 U5722/net39 VSS nmos W=0.155u L=0.04u
M19625 U5722/net36 g1829 U5722/net27 VSS nmos W=0.155u L=0.04u
M19626 U5722/net39 g1830 VSS VSS nmos W=0.155u L=0.04u
M19627 n5199 U5722/net36 VSS VSS nmos W=0.155u L=0.04u
M19628 n5199 U5722/net36 VDD VDD pmos W=0.205u L=0.04u
M19629 U5722/net36 n4334 U5722/net46 VDD pmos W=0.205u L=0.04u
M19630 U5722/net46 g1830 VDD VDD pmos W=0.205u L=0.04u
M19631 U5722/net36 g1829 U5722/net34 VDD pmos W=0.205u L=0.04u
M19632 U5722/net34 n5191 VDD VDD pmos W=0.205u L=0.04u
M19633 U5722/net36 n5192 U5722/net37 VDD pmos W=0.205u L=0.04u
M19634 U5722/net37 g1828 VDD VDD pmos W=0.205u L=0.04u
M19635 n5198 n5197 U5723/net15 VSS nmos W=0.155u L=0.04u
M19636 n5198 n5193 U5723/net15 VSS nmos W=0.155u L=0.04u
M19637 U5723/net15 n5207 VSS VSS nmos W=0.155u L=0.04u
M19638 n5198 n5207 VDD VDD pmos W=0.205u L=0.04u
M19639 n5198 n5197 U5723/XI16-net11 VDD pmos W=0.205u L=0.04u
M19640 U5723/XI16-net11 n5193 VDD VDD pmos W=0.205u L=0.04u
M19641 U5724/net19 n5194 VSS VSS nmos W=0.155u L=0.04u
M19642 n5207 n5194 U5724/net40 VSS nmos W=0.155u L=0.04u
M19643 n5207 U5724/net19 U5724/net36 VSS nmos W=0.155u L=0.04u
M19644 U5724/net40 n5197 VSS VSS nmos W=0.31u L=0.04u
M19645 U5724/net36 n5193 VSS VSS nmos W=0.155u L=0.04u
M19646 U5724/net19 n5194 VDD VDD pmos W=0.205u L=0.04u
M19647 n5207 U5724/net19 U5724/net26 VDD pmos W=0.325u L=0.04u
M19648 U5724/net26 n5197 VDD VDD pmos W=0.41u L=0.04u
M19649 n5207 n5194 U5724/net30 VDD pmos W=0.325u L=0.04u
M19650 U5724/net30 n5193 VDD VDD pmos W=0.205u L=0.04u
M19651 U5725/net13 n5208 VSS VSS nmos W=0.155u L=0.04u
M19652 U5725/net16 U5725/net13 VSS VSS nmos W=0.155u L=0.04u
M19653 n5194 n5209 U5725/net16 VSS nmos W=0.155u L=0.04u
M19654 U5725/net13 n5208 VDD VDD pmos W=0.205u L=0.04u
M19655 VDD U5725/net13 n5194 VDD pmos W=0.205u L=0.04u
M19656 VDD n5209 n5194 VDD pmos W=0.205u L=0.04u
M19657 n5209 n5210 U5726/net27 VSS nmos W=0.155u L=0.04u
M19658 U5726/net39 n5212 VSS VSS nmos W=0.155u L=0.04u
M19659 U5726/net27 g1559 U5726/net39 VSS nmos W=0.155u L=0.04u
M19660 U5726/net27 n5211 U5726/net39 VSS nmos W=0.155u L=0.04u
M19661 n5209 g1560 U5726/net27 VSS nmos W=0.155u L=0.04u
M19662 U5726/net39 g1561 VSS VSS nmos W=0.155u L=0.04u
M19663 n5209 n5212 U5726/net46 VDD pmos W=0.205u L=0.04u
M19664 U5726/net46 g1561 VDD VDD pmos W=0.205u L=0.04u
M19665 n5209 g1560 U5726/net34 VDD pmos W=0.205u L=0.04u
M19666 U5726/net34 n5210 VDD VDD pmos W=0.205u L=0.04u
M19667 n5209 n5211 U5726/net37 VDD pmos W=0.205u L=0.04u
M19668 U5726/net37 g1559 VDD VDD pmos W=0.205u L=0.04u
M19669 n5193 g1782 U5727/XI21-net17 VSS nmos W=0.155u L=0.04u
M19670 U5727/XI21-net17 g1816 VSS VSS nmos W=0.155u L=0.04u
M19671 n5193 g5511 U5727/XI6-net17 VSS nmos W=0.155u L=0.04u
M19672 U5727/XI6-net17 g1810 VSS VSS nmos W=0.155u L=0.04u
M19673 n5193 g7014 U5727/XI20-net17 VSS nmos W=0.155u L=0.04u
M19674 U5727/XI20-net17 g1813 VSS VSS nmos W=0.155u L=0.04u
M19675 VDD g1782 U5727/net22 VDD pmos W=0.205u L=0.04u
M19676 VDD g1816 U5727/net22 VDD pmos W=0.205u L=0.04u
M19677 U5727/net16 g5511 n5193 VDD pmos W=0.205u L=0.04u
M19678 U5727/net16 g1810 n5193 VDD pmos W=0.205u L=0.04u
M19679 U5727/net22 g7014 U5727/net16 VDD pmos W=0.205u L=0.04u
M19680 U5727/net22 g1813 U5727/net16 VDD pmos W=0.205u L=0.04u
M19681 n5197 g1782 U5728/XI21-net17 VSS nmos W=0.155u L=0.04u
M19682 U5728/XI21-net17 g1825 VSS VSS nmos W=0.155u L=0.04u
M19683 n5197 g5511 U5728/XI6-net17 VSS nmos W=0.155u L=0.04u
M19684 U5728/XI6-net17 g1819 VSS VSS nmos W=0.155u L=0.04u
M19685 n5197 g7014 U5728/XI20-net17 VSS nmos W=0.155u L=0.04u
M19686 U5728/XI20-net17 g1822 VSS VSS nmos W=0.155u L=0.04u
M19687 VDD g1782 U5728/net22 VDD pmos W=0.205u L=0.04u
M19688 VDD g1825 U5728/net22 VDD pmos W=0.205u L=0.04u
M19689 U5728/net16 g5511 n5197 VDD pmos W=0.205u L=0.04u
M19690 U5728/net16 g1819 n5197 VDD pmos W=0.205u L=0.04u
M19691 U5728/net22 g7014 U5728/net16 VDD pmos W=0.205u L=0.04u
M19692 U5728/net22 g1822 U5728/net16 VDD pmos W=0.205u L=0.04u
M19693 U5729/net19 n5191 VSS VSS nmos W=0.155u L=0.04u
M19694 n2977 n5191 U5729/net40 VSS nmos W=0.155u L=0.04u
M19695 n2977 U5729/net19 U5729/net36 VSS nmos W=0.155u L=0.04u
M19696 U5729/net40 g1798 VSS VSS nmos W=0.31u L=0.04u
M19697 U5729/net36 n5213 VSS VSS nmos W=0.155u L=0.04u
M19698 U5729/net19 n5191 VDD VDD pmos W=0.205u L=0.04u
M19699 n2977 U5729/net19 U5729/net26 VDD pmos W=0.325u L=0.04u
M19700 U5729/net26 g1798 VDD VDD pmos W=0.41u L=0.04u
M19701 n2977 n5191 U5729/net30 VDD pmos W=0.325u L=0.04u
M19702 U5729/net30 n5213 VDD VDD pmos W=0.205u L=0.04u
M19703 U5730/net19 n4334 VSS VSS nmos W=0.155u L=0.04u
M19704 n2976 n4334 U5730/net40 VSS nmos W=0.155u L=0.04u
M19705 n2976 U5730/net19 U5730/net36 VSS nmos W=0.155u L=0.04u
M19706 U5730/net40 g1801 VSS VSS nmos W=0.31u L=0.04u
M19707 U5730/net36 n5213 VSS VSS nmos W=0.155u L=0.04u
M19708 U5730/net19 n4334 VDD VDD pmos W=0.205u L=0.04u
M19709 n2976 U5730/net19 U5730/net26 VDD pmos W=0.325u L=0.04u
M19710 U5730/net26 g1801 VDD VDD pmos W=0.41u L=0.04u
M19711 n2976 n4334 U5730/net30 VDD pmos W=0.325u L=0.04u
M19712 U5730/net30 n5213 VDD VDD pmos W=0.205u L=0.04u
M19713 U5731/net19 n5192 VSS VSS nmos W=0.155u L=0.04u
M19714 n2975 n5192 U5731/net40 VSS nmos W=0.155u L=0.04u
M19715 n2975 U5731/net19 U5731/net36 VSS nmos W=0.155u L=0.04u
M19716 U5731/net40 g1804 VSS VSS nmos W=0.31u L=0.04u
M19717 U5731/net36 n5213 VSS VSS nmos W=0.155u L=0.04u
M19718 U5731/net19 n5192 VDD VDD pmos W=0.205u L=0.04u
M19719 n2975 U5731/net19 U5731/net26 VDD pmos W=0.325u L=0.04u
M19720 U5731/net26 g1804 VDD VDD pmos W=0.41u L=0.04u
M19721 n2975 n5192 U5731/net30 VDD pmos W=0.325u L=0.04u
M19722 U5731/net30 n5213 VDD VDD pmos W=0.205u L=0.04u
M19723 U5732/net4 g11952 U5732/net14 VSS nmos W=0.155u L=0.04u
M19724 U5732/net6 U5732/net10 U5732/net14 VSS nmos W=0.17u L=0.04u
M19725 U5732/net4 n5214 VSS VSS nmos W=0.155u L=0.04u
M19726 U5732/net6 U5732/net4 VSS VSS nmos W=0.17u L=0.04u
M19727 n5213 U5732/net14 VSS VSS nmos W=0.155u L=0.04u
M19728 U5732/net10 g11952 VSS VSS nmos W=0.155u L=0.04u
M19729 U5732/net4 U5732/net10 U5732/net14 VDD pmos W=0.255u L=0.04u
M19730 U5732/net6 g11952 U5732/net14 VDD pmos W=0.28u L=0.04u
M19731 U5732/net4 n5214 VDD VDD pmos W=0.205u L=0.04u
M19732 U5732/net6 U5732/net4 VDD VDD pmos W=0.24u L=0.04u
M19733 n5213 U5732/net14 VDD VDD pmos W=0.205u L=0.04u
M19734 U5732/net10 g11952 VDD VDD pmos W=0.205u L=0.04u
M19735 n5214 n5215 U5733/net14 VSS nmos W=0.155u L=0.04u
M19736 U5733/net14 n5219 VSS VSS nmos W=0.155u L=0.04u
M19737 U5733/net14 n5218 VSS VSS nmos W=0.155u L=0.04u
M19738 n5214 n5217 U5733/net14 VSS nmos W=0.155u L=0.04u
M19739 n5214 n5216 U5733/net14 VSS nmos W=0.155u L=0.04u
M19740 n5214 n5219 U5733/XI16-net11 VDD pmos W=0.205u L=0.04u
M19741 U5733/XI16-net11 n5218 VDD VDD pmos W=0.205u L=0.04u
M19742 n5214 n5217 U5733/XI15-net11 VDD pmos W=0.205u L=0.04u
M19743 U5733/XI15-net11 n5216 U5733/XI15-net18 VDD pmos W=0.205u L=0.04u
M19744 U5733/XI15-net18 n5215 VDD VDD pmos W=0.205u L=0.04u
M19745 n5218 n5220 U5734/net23 VDD pmos W=0.205u L=0.04u
M19746 n5218 g11952 U5734/net23 VDD pmos W=0.205u L=0.04u
M19747 n5218 n5221 U5734/net23 VDD pmos W=0.205u L=0.04u
M19748 U5734/net23 n5222 VDD VDD pmos W=0.205u L=0.04u
M19749 U5734/net23 n5223 VDD VDD pmos W=0.205u L=0.04u
M19750 U5734/XI20-net13 g11952 VSS VSS nmos W=0.155u L=0.04u
M19751 n5218 n5220 U5734/XI20-net17 VSS nmos W=0.155u L=0.04u
M19752 U5734/XI20-net17 n5221 U5734/XI20-net13 VSS nmos W=0.155u L=0.04u
M19753 n5218 n5222 U5734/XI17-net17 VSS nmos W=0.155u L=0.04u
M19754 U5734/XI17-net17 n5223 VSS VSS nmos W=0.155u L=0.04u
M19755 n5221 U5735/net7 VSS VSS nmos W=0.155u L=0.04u
M19756 U5735/net7 n5223 VSS VSS nmos W=0.155u L=0.04u
M19757 U5735/net7 n5224 VSS VSS nmos W=0.155u L=0.04u
M19758 n5221 U5735/net7 VDD VDD pmos W=0.205u L=0.04u
M19759 U5735/X_u7-net8 n5224 VDD VDD pmos W=0.205u L=0.04u
M19760 U5735/net7 n5223 U5735/X_u7-net8 VDD pmos W=0.205u L=0.04u
M19761 n5217 g11952 VSS VSS nmos W=0.135u L=0.04u
M19762 n5217 g11952 VDD VDD pmos W=0.205u L=0.04u
M19763 U5737/XU1-net6 n5225 VSS VSS nmos W=0.155u L=0.04u
M19764 n5215 n5220 U5737/XU1-net6 VSS nmos W=0.155u L=0.04u
M19765 n5215 n5225 VDD VDD pmos W=0.155u L=0.04u
M19766 n5215 n5220 VDD VDD pmos W=0.155u L=0.04u
M19767 n2974 n5191 U5738/net10 VSS nmos W=0.155u L=0.04u
M19768 U5738/net10 n5227 VSS VSS nmos W=0.155u L=0.04u
M19769 n2974 n5226 U5738/net10 VSS nmos W=0.155u L=0.04u
M19770 U5738/net10 g1808 VSS VSS nmos W=0.155u L=0.04u
M19771 U5738/net30 n5227 VDD VDD pmos W=0.205u L=0.04u
M19772 n2974 n5191 U5738/net24 VDD pmos W=0.205u L=0.04u
M19773 U5738/net24 n5226 VDD VDD pmos W=0.205u L=0.04u
M19774 n2974 g1808 U5738/net30 VDD pmos W=0.205u L=0.04u
M19775 n5227 n5191 VSS VSS nmos W=0.155u L=0.04u
M19776 n5227 n5228 VSS VSS nmos W=0.155u L=0.04u
M19777 U5739/XI1-net8 n5228 VDD VDD pmos W=0.205u L=0.04u
M19778 n5227 n5191 U5739/XI1-net8 VDD pmos W=0.205u L=0.04u
M19779 n2973 n4334 U5740/net10 VSS nmos W=0.155u L=0.04u
M19780 U5740/net10 n5229 VSS VSS nmos W=0.155u L=0.04u
M19781 n2973 n5226 U5740/net10 VSS nmos W=0.155u L=0.04u
M19782 U5740/net10 g1809 VSS VSS nmos W=0.155u L=0.04u
M19783 U5740/net30 n5229 VDD VDD pmos W=0.205u L=0.04u
M19784 n2973 n4334 U5740/net24 VDD pmos W=0.205u L=0.04u
M19785 U5740/net24 n5226 VDD VDD pmos W=0.205u L=0.04u
M19786 n2973 g1809 U5740/net30 VDD pmos W=0.205u L=0.04u
M19787 n5229 n4334 VSS VSS nmos W=0.155u L=0.04u
M19788 n5229 n5228 VSS VSS nmos W=0.155u L=0.04u
M19789 U5741/XI1-net8 n5228 VDD VDD pmos W=0.205u L=0.04u
M19790 n5229 n4334 U5741/XI1-net8 VDD pmos W=0.205u L=0.04u
M19791 n2972 n5192 U5742/net10 VSS nmos W=0.155u L=0.04u
M19792 U5742/net10 n5230 VSS VSS nmos W=0.155u L=0.04u
M19793 n2972 n5226 U5742/net10 VSS nmos W=0.155u L=0.04u
M19794 U5742/net10 g1807 VSS VSS nmos W=0.155u L=0.04u
M19795 U5742/net30 n5230 VDD VDD pmos W=0.205u L=0.04u
M19796 n2972 n5192 U5742/net24 VDD pmos W=0.205u L=0.04u
M19797 U5742/net24 n5226 VDD VDD pmos W=0.205u L=0.04u
M19798 n2972 g1807 U5742/net30 VDD pmos W=0.205u L=0.04u
M19799 n5230 n5192 VSS VSS nmos W=0.155u L=0.04u
M19800 n5230 n5228 VSS VSS nmos W=0.155u L=0.04u
M19801 U5743/XI1-net8 n5228 VDD VDD pmos W=0.205u L=0.04u
M19802 n5230 n5192 U5743/XI1-net8 VDD pmos W=0.205u L=0.04u
M19803 U5744/net13 n5219 VSS VSS nmos W=0.155u L=0.04u
M19804 U5744/net16 U5744/net13 VSS VSS nmos W=0.155u L=0.04u
M19805 n5226 n5231 U5744/net16 VSS nmos W=0.155u L=0.04u
M19806 U5744/net13 n5219 VDD VDD pmos W=0.205u L=0.04u
M19807 VDD U5744/net13 n5226 VDD pmos W=0.205u L=0.04u
M19808 VDD n5231 n5226 VDD pmos W=0.205u L=0.04u
M19809 U5745/net19 n5191 VSS VSS nmos W=0.155u L=0.04u
M19810 n2971 n5191 U5745/net40 VSS nmos W=0.155u L=0.04u
M19811 n2971 U5745/net19 U5745/net36 VSS nmos W=0.155u L=0.04u
M19812 U5745/net40 g1789 VSS VSS nmos W=0.31u L=0.04u
M19813 U5745/net36 n5232 VSS VSS nmos W=0.155u L=0.04u
M19814 U5745/net19 n5191 VDD VDD pmos W=0.205u L=0.04u
M19815 n2971 U5745/net19 U5745/net26 VDD pmos W=0.325u L=0.04u
M19816 U5745/net26 g1789 VDD VDD pmos W=0.41u L=0.04u
M19817 n2971 n5191 U5745/net30 VDD pmos W=0.325u L=0.04u
M19818 U5745/net30 n5232 VDD VDD pmos W=0.205u L=0.04u
M19819 U5746/net19 n4334 VSS VSS nmos W=0.155u L=0.04u
M19820 n2970 n4334 U5746/net40 VSS nmos W=0.155u L=0.04u
M19821 n2970 U5746/net19 U5746/net36 VSS nmos W=0.155u L=0.04u
M19822 U5746/net40 g1792 VSS VSS nmos W=0.31u L=0.04u
M19823 U5746/net36 n5232 VSS VSS nmos W=0.155u L=0.04u
M19824 U5746/net19 n4334 VDD VDD pmos W=0.205u L=0.04u
M19825 n2970 U5746/net19 U5746/net26 VDD pmos W=0.325u L=0.04u
M19826 U5746/net26 g1792 VDD VDD pmos W=0.41u L=0.04u
M19827 n2970 n4334 U5746/net30 VDD pmos W=0.325u L=0.04u
M19828 U5746/net30 n5232 VDD VDD pmos W=0.205u L=0.04u
M19829 U5747/net19 n5192 VSS VSS nmos W=0.155u L=0.04u
M19830 n2969 n5192 U5747/net40 VSS nmos W=0.155u L=0.04u
M19831 n2969 U5747/net19 U5747/net36 VSS nmos W=0.155u L=0.04u
M19832 U5747/net40 g1795 VSS VSS nmos W=0.31u L=0.04u
M19833 U5747/net36 n5232 VSS VSS nmos W=0.155u L=0.04u
M19834 U5747/net19 n5192 VDD VDD pmos W=0.205u L=0.04u
M19835 n2969 U5747/net19 U5747/net26 VDD pmos W=0.325u L=0.04u
M19836 U5747/net26 g1795 VDD VDD pmos W=0.41u L=0.04u
M19837 n2969 n5192 U5747/net30 VDD pmos W=0.325u L=0.04u
M19838 U5747/net30 n5232 VDD VDD pmos W=0.205u L=0.04u
M19839 U5748/net4 n5233 U5748/net14 VSS nmos W=0.155u L=0.04u
M19840 U5748/net6 U5748/net10 U5748/net14 VSS nmos W=0.17u L=0.04u
M19841 U5748/net4 n5234 VSS VSS nmos W=0.155u L=0.04u
M19842 U5748/net6 U5748/net4 VSS VSS nmos W=0.17u L=0.04u
M19843 n5232 U5748/net14 VSS VSS nmos W=0.155u L=0.04u
M19844 U5748/net10 n5233 VSS VSS nmos W=0.155u L=0.04u
M19845 U5748/net4 U5748/net10 U5748/net14 VDD pmos W=0.255u L=0.04u
M19846 U5748/net6 n5233 U5748/net14 VDD pmos W=0.28u L=0.04u
M19847 U5748/net4 n5234 VDD VDD pmos W=0.205u L=0.04u
M19848 U5748/net6 U5748/net4 VDD VDD pmos W=0.24u L=0.04u
M19849 n5232 U5748/net14 VDD VDD pmos W=0.205u L=0.04u
M19850 U5748/net10 n5233 VDD VDD pmos W=0.205u L=0.04u
M19851 U5749/net14 n5231 U5749/net20 VSS nmos W=0.155u L=0.04u
M19852 U5749/net14 n5219 U5749/net20 VSS nmos W=0.155u L=0.04u
M19853 U5749/net20 n5228 VSS VSS nmos W=0.155u L=0.04u
M19854 n5233 U5749/net14 VSS VSS nmos W=0.155u L=0.04u
M19855 n5233 U5749/net14 VDD VDD pmos W=0.205u L=0.04u
M19856 U5749/net14 n5228 VDD VDD pmos W=0.205u L=0.04u
M19857 U5749/net24 n5231 VDD VDD pmos W=0.205u L=0.04u
M19858 U5749/net14 n5219 U5749/net24 VDD pmos W=0.205u L=0.04u
M19859 U5750/XU1-net6 n5235 VSS VSS nmos W=0.155u L=0.04u
M19860 n5228 n5225 U5750/XU1-net6 VSS nmos W=0.155u L=0.04u
M19861 n5228 n5235 VDD VDD pmos W=0.155u L=0.04u
M19862 n5228 n5225 VDD VDD pmos W=0.155u L=0.04u
M19863 n5225 n5234 VSS VSS nmos W=0.155u L=0.04u
M19864 n5225 n5200 VSS VSS nmos W=0.155u L=0.04u
M19865 U5751/XI1-net8 n5200 VDD VDD pmos W=0.205u L=0.04u
M19866 n5225 n5234 U5751/XI1-net8 VDD pmos W=0.205u L=0.04u
M19867 n5231 n5223 VSS VSS nmos W=0.155u L=0.04u
M19868 n5231 U5752/net4 VSS VSS nmos W=0.155u L=0.04u
M19869 U5752/net4 n5235 VSS VSS nmos W=0.155u L=0.04u
M19870 U5752/XU1-net8 U5752/net4 VDD VDD pmos W=0.205u L=0.04u
M19871 n5231 n5223 U5752/XU1-net8 VDD pmos W=0.205u L=0.04u
M19872 U5752/net4 n5235 VDD VDD pmos W=0.205u L=0.04u
M19873 n5223 n5191 U5753/net27 VSS nmos W=0.155u L=0.04u
M19874 U5753/net39 n4334 VSS VSS nmos W=0.155u L=0.04u
M19875 U5753/net27 g1807 U5753/net39 VSS nmos W=0.155u L=0.04u
M19876 U5753/net27 n5192 U5753/net39 VSS nmos W=0.155u L=0.04u
M19877 n5223 g1808 U5753/net27 VSS nmos W=0.155u L=0.04u
M19878 U5753/net39 g1809 VSS VSS nmos W=0.155u L=0.04u
M19879 n5223 n4334 U5753/net46 VDD pmos W=0.205u L=0.04u
M19880 U5753/net46 g1809 VDD VDD pmos W=0.205u L=0.04u
M19881 n5223 g1808 U5753/net34 VDD pmos W=0.205u L=0.04u
M19882 U5753/net34 n5191 VDD VDD pmos W=0.205u L=0.04u
M19883 n5223 n5192 U5753/net37 VDD pmos W=0.205u L=0.04u
M19884 U5753/net37 g1807 VDD VDD pmos W=0.205u L=0.04u
M19885 n5235 U5754/net26 VDD VDD pmos W=0.205u L=0.04u
M19886 U5754/net26 g11952 U5754/net19 VDD pmos W=0.205u L=0.04u
M19887 U5754/net26 n5216 U5754/net19 VDD pmos W=0.205u L=0.04u
M19888 U5754/net26 n5220 U5754/net19 VDD pmos W=0.205u L=0.04u
M19889 U5754/net19 n5222 VDD VDD pmos W=0.205u L=0.04u
M19890 U5754/net26 n5222 VSS VSS nmos W=0.155u L=0.04u
M19891 n5235 U5754/net26 VSS VSS nmos W=0.155u L=0.04u
M19892 U5754/XI20-net13 n5220 VSS VSS nmos W=0.155u L=0.04u
M19893 U5754/net26 g11952 U5754/XI20-net17 VSS nmos W=0.155u L=0.04u
M19894 U5754/XI20-net17 n5216 U5754/XI20-net13 VSS nmos W=0.155u L=0.04u
M19895 n5222 n5220 VSS VSS nmos W=0.155u L=0.04u
M19896 n5222 g11952 VSS VSS nmos W=0.155u L=0.04u
M19897 U5755/XI1-net8 g11952 VDD VDD pmos W=0.205u L=0.04u
M19898 n5222 n5220 U5755/XI1-net8 VDD pmos W=0.205u L=0.04u
M19899 n5220 n5208 VSS VSS nmos W=0.155u L=0.04u
M19900 n5220 n4067 VSS VSS nmos W=0.155u L=0.04u
M19901 n5220 n4070 VSS VSS nmos W=0.155u L=0.04u
M19902 U5756/net25 n5208 VDD VDD pmos W=0.41u L=0.04u
M19903 U5756/net28 n4067 U5756/net25 VDD pmos W=0.41u L=0.04u
M19904 n5220 n4070 U5756/net28 VDD pmos W=0.41u L=0.04u
M19905 n4067 n5236 VSS VSS nmos W=0.135u L=0.04u
M19906 n4067 n5236 VDD VDD pmos W=0.205u L=0.04u
M19907 U5758/XU1-net6 n5234 VSS VSS nmos W=0.155u L=0.04u
M19908 n5219 g1690 U5758/XU1-net6 VSS nmos W=0.155u L=0.04u
M19909 n5219 n5234 VDD VDD pmos W=0.155u L=0.04u
M19910 n5219 g1690 VDD VDD pmos W=0.155u L=0.04u
M19911 n5234 U5759/net39 VDD VDD pmos W=0.205u L=0.04u
M19912 VDD g1782 U5759/net22 VDD pmos W=0.205u L=0.04u
M19913 VDD g1795 U5759/net22 VDD pmos W=0.205u L=0.04u
M19914 U5759/net16 g5511 U5759/net39 VDD pmos W=0.205u L=0.04u
M19915 U5759/net16 g1789 U5759/net39 VDD pmos W=0.205u L=0.04u
M19916 U5759/net22 g7014 U5759/net16 VDD pmos W=0.205u L=0.04u
M19917 U5759/net22 g1792 U5759/net16 VDD pmos W=0.205u L=0.04u
M19918 n5234 U5759/net39 VSS VSS nmos W=0.155u L=0.04u
M19919 U5759/net39 g1782 U5759/XI22-net17 VSS nmos W=0.155u L=0.04u
M19920 U5759/XI22-net17 g1795 VSS VSS nmos W=0.155u L=0.04u
M19921 U5759/net39 g5511 U5759/XI6-net17 VSS nmos W=0.155u L=0.04u
M19922 U5759/XI6-net17 g1789 VSS VSS nmos W=0.155u L=0.04u
M19923 U5759/net39 g7014 U5759/XI21-net17 VSS nmos W=0.155u L=0.04u
M19924 U5759/XI21-net17 g1792 VSS VSS nmos W=0.155u L=0.04u
M19925 U5760/net19 n4071 VSS VSS nmos W=0.155u L=0.04u
M19926 n2968 n4071 U5760/net40 VSS nmos W=0.155u L=0.04u
M19927 n2968 U5760/net19 U5760/net36 VSS nmos W=0.155u L=0.04u
M19928 U5760/net40 n5237 VSS VSS nmos W=0.31u L=0.04u
M19929 U5760/net36 g1539 VSS VSS nmos W=0.155u L=0.04u
M19930 U5760/net19 n4071 VDD VDD pmos W=0.205u L=0.04u
M19931 n2968 U5760/net19 U5760/net26 VDD pmos W=0.325u L=0.04u
M19932 U5760/net26 n5237 VDD VDD pmos W=0.41u L=0.04u
M19933 n2968 n4071 U5760/net30 VDD pmos W=0.325u L=0.04u
M19934 U5760/net30 g1539 VDD VDD pmos W=0.205u L=0.04u
M19935 n4071 U5761/net6 VSS VSS nmos W=0.155u L=0.04u
M19936 U5761/X_u2-net6 g6573 VSS VSS nmos W=0.155u L=0.04u
M19937 U5761/net6 g1563 U5761/X_u2-net6 VSS nmos W=0.155u L=0.04u
M19938 n4071 U5761/net6 VDD VDD pmos W=0.205u L=0.04u
M19939 U5761/net6 g6573 VDD VDD pmos W=0.205u L=0.04u
M19940 U5761/net6 g1563 VDD VDD pmos W=0.205u L=0.04u
M19941 U5762/net19 n4068 VSS VSS nmos W=0.155u L=0.04u
M19942 n2967 n4068 U5762/net40 VSS nmos W=0.155u L=0.04u
M19943 n2967 U5762/net19 U5762/net36 VSS nmos W=0.155u L=0.04u
M19944 U5762/net40 n5237 VSS VSS nmos W=0.31u L=0.04u
M19945 U5762/net36 g1540 VSS VSS nmos W=0.155u L=0.04u
M19946 U5762/net19 n4068 VDD VDD pmos W=0.205u L=0.04u
M19947 n2967 U5762/net19 U5762/net26 VDD pmos W=0.325u L=0.04u
M19948 U5762/net26 n5237 VDD VDD pmos W=0.41u L=0.04u
M19949 n2967 n4068 U5762/net30 VDD pmos W=0.325u L=0.04u
M19950 U5762/net30 g1540 VDD VDD pmos W=0.205u L=0.04u
M19951 n4068 U5763/net6 VSS VSS nmos W=0.155u L=0.04u
M19952 U5763/X_u2-net6 g6782 VSS VSS nmos W=0.155u L=0.04u
M19953 U5763/net6 g1563 U5763/X_u2-net6 VSS nmos W=0.155u L=0.04u
M19954 n4068 U5763/net6 VDD VDD pmos W=0.205u L=0.04u
M19955 U5763/net6 g6782 VDD VDD pmos W=0.205u L=0.04u
M19956 U5763/net6 g1563 VDD VDD pmos W=0.205u L=0.04u
M19957 U5764/net19 n4069 VSS VSS nmos W=0.155u L=0.04u
M19958 n2966 n4069 U5764/net40 VSS nmos W=0.155u L=0.04u
M19959 n2966 U5764/net19 U5764/net36 VSS nmos W=0.155u L=0.04u
M19960 U5764/net40 n5237 VSS VSS nmos W=0.31u L=0.04u
M19961 U5764/net36 g1538 VSS VSS nmos W=0.155u L=0.04u
M19962 U5764/net19 n4069 VDD VDD pmos W=0.205u L=0.04u
M19963 n2966 U5764/net19 U5764/net26 VDD pmos W=0.325u L=0.04u
M19964 U5764/net26 n5237 VDD VDD pmos W=0.41u L=0.04u
M19965 n2966 n4069 U5764/net30 VDD pmos W=0.325u L=0.04u
M19966 U5764/net30 g1538 VDD VDD pmos W=0.205u L=0.04u
M19967 n2965 n5191 U5765/net10 VSS nmos W=0.155u L=0.04u
M19968 U5765/net10 n5239 VSS VSS nmos W=0.155u L=0.04u
M19969 n2965 n5238 U5765/net10 VSS nmos W=0.155u L=0.04u
M19970 U5765/net10 g1784 VSS VSS nmos W=0.155u L=0.04u
M19971 U5765/net30 n5239 VDD VDD pmos W=0.205u L=0.04u
M19972 n2965 n5191 U5765/net24 VDD pmos W=0.205u L=0.04u
M19973 U5765/net24 n5238 VDD VDD pmos W=0.205u L=0.04u
M19974 n2965 g1784 U5765/net30 VDD pmos W=0.205u L=0.04u
M19975 n5239 n5191 VSS VSS nmos W=0.155u L=0.04u
M19976 n5239 n5200 VSS VSS nmos W=0.155u L=0.04u
M19977 U5766/XI1-net8 n5200 VDD VDD pmos W=0.205u L=0.04u
M19978 n5239 n5191 U5766/XI1-net8 VDD pmos W=0.205u L=0.04u
M19979 n2964 n4334 U5767/net10 VSS nmos W=0.155u L=0.04u
M19980 U5767/net10 n5240 VSS VSS nmos W=0.155u L=0.04u
M19981 n2964 n5238 U5767/net10 VSS nmos W=0.155u L=0.04u
M19982 U5767/net10 g1785 VSS VSS nmos W=0.155u L=0.04u
M19983 U5767/net30 n5240 VDD VDD pmos W=0.205u L=0.04u
M19984 n2964 n4334 U5767/net24 VDD pmos W=0.205u L=0.04u
M19985 U5767/net24 n5238 VDD VDD pmos W=0.205u L=0.04u
M19986 n2964 g1785 U5767/net30 VDD pmos W=0.205u L=0.04u
M19987 n5240 n4334 VSS VSS nmos W=0.155u L=0.04u
M19988 n5240 n5200 VSS VSS nmos W=0.155u L=0.04u
M19989 U5768/XI1-net8 n5200 VDD VDD pmos W=0.205u L=0.04u
M19990 n5240 n4334 U5768/XI1-net8 VDD pmos W=0.205u L=0.04u
M19991 n2963 n5192 U5769/net10 VSS nmos W=0.155u L=0.04u
M19992 U5769/net10 n5241 VSS VSS nmos W=0.155u L=0.04u
M19993 n2963 n5238 U5769/net10 VSS nmos W=0.155u L=0.04u
M19994 U5769/net10 g1783 VSS VSS nmos W=0.155u L=0.04u
M19995 U5769/net30 n5241 VDD VDD pmos W=0.205u L=0.04u
M19996 n2963 n5192 U5769/net24 VDD pmos W=0.205u L=0.04u
M19997 U5769/net24 n5238 VDD VDD pmos W=0.205u L=0.04u
M19998 n2963 g1783 U5769/net30 VDD pmos W=0.205u L=0.04u
M19999 n5241 n5192 VSS VSS nmos W=0.155u L=0.04u
M20000 n5241 n5200 VSS VSS nmos W=0.155u L=0.04u
M20001 U5770/XI1-net8 n5200 VDD VDD pmos W=0.205u L=0.04u
M20002 n5241 n5192 U5770/XI1-net8 VDD pmos W=0.205u L=0.04u
M20003 U5771/net30 n5242 VSS VSS nmos W=0.155u L=0.04u
M20004 n5238 n5243 U5771/net23 VSS nmos W=0.155u L=0.04u
M20005 U5771/net20 U5771/net30 VSS VSS nmos W=0.155u L=0.04u
M20006 U5771/net23 g1690 U5771/net20 VSS nmos W=0.155u L=0.04u
M20007 U5771/net30 n5242 VDD VDD pmos W=0.205u L=0.04u
M20008 VDD n5243 n5238 VDD pmos W=0.205u L=0.04u
M20009 VDD g1690 n5238 VDD pmos W=0.205u L=0.04u
M20010 VDD U5771/net30 n5238 VDD pmos W=0.205u L=0.04u
M20011 U5772/net19 n5191 VSS VSS nmos W=0.155u L=0.04u
M20012 n2962 n5191 U5772/net40 VSS nmos W=0.155u L=0.04u
M20013 n2962 U5772/net19 U5772/net36 VSS nmos W=0.155u L=0.04u
M20014 U5772/net40 g1693 VSS VSS nmos W=0.31u L=0.04u
M20015 U5772/net36 n5244 VSS VSS nmos W=0.155u L=0.04u
M20016 U5772/net19 n5191 VDD VDD pmos W=0.205u L=0.04u
M20017 n2962 U5772/net19 U5772/net26 VDD pmos W=0.325u L=0.04u
M20018 U5772/net26 g1693 VDD VDD pmos W=0.41u L=0.04u
M20019 n2962 n5191 U5772/net30 VDD pmos W=0.325u L=0.04u
M20020 U5772/net30 n5244 VDD VDD pmos W=0.205u L=0.04u
M20021 U5773/net19 n4334 VSS VSS nmos W=0.155u L=0.04u
M20022 n2961 n4334 U5773/net40 VSS nmos W=0.155u L=0.04u
M20023 n2961 U5773/net19 U5773/net36 VSS nmos W=0.155u L=0.04u
M20024 U5773/net40 g1694 VSS VSS nmos W=0.31u L=0.04u
M20025 U5773/net36 n5244 VSS VSS nmos W=0.155u L=0.04u
M20026 U5773/net19 n4334 VDD VDD pmos W=0.205u L=0.04u
M20027 n2961 U5773/net19 U5773/net26 VDD pmos W=0.325u L=0.04u
M20028 U5773/net26 g1694 VDD VDD pmos W=0.41u L=0.04u
M20029 n2961 n4334 U5773/net30 VDD pmos W=0.325u L=0.04u
M20030 U5773/net30 n5244 VDD VDD pmos W=0.205u L=0.04u
M20031 U5774/net19 n5192 VSS VSS nmos W=0.155u L=0.04u
M20032 n2960 n5192 U5774/net40 VSS nmos W=0.155u L=0.04u
M20033 n2960 U5774/net19 U5774/net36 VSS nmos W=0.155u L=0.04u
M20034 U5774/net40 g1695 VSS VSS nmos W=0.31u L=0.04u
M20035 U5774/net36 n5244 VSS VSS nmos W=0.155u L=0.04u
M20036 U5774/net19 n5192 VDD VDD pmos W=0.205u L=0.04u
M20037 n2960 U5774/net19 U5774/net26 VDD pmos W=0.325u L=0.04u
M20038 U5774/net26 g1695 VDD VDD pmos W=0.41u L=0.04u
M20039 n2960 n5192 U5774/net30 VDD pmos W=0.325u L=0.04u
M20040 U5774/net30 n5244 VDD VDD pmos W=0.205u L=0.04u
M20041 n5244 U5775/net6 VSS VSS nmos W=0.155u L=0.04u
M20042 U5775/X_u2-net6 n5246 VSS VSS nmos W=0.155u L=0.04u
M20043 U5775/net6 n5245 U5775/X_u2-net6 VSS nmos W=0.155u L=0.04u
M20044 n5244 U5775/net6 VDD VDD pmos W=0.205u L=0.04u
M20045 U5775/net6 n5246 VDD VDD pmos W=0.205u L=0.04u
M20046 U5775/net6 n5245 VDD VDD pmos W=0.205u L=0.04u
M20047 n5245 U5776/net26 VDD VDD pmos W=0.205u L=0.04u
M20048 U5776/net26 n5247 U5776/net19 VDD pmos W=0.205u L=0.04u
M20049 U5776/net26 n5248 U5776/net19 VDD pmos W=0.205u L=0.04u
M20050 U5776/net26 n5249 U5776/net19 VDD pmos W=0.205u L=0.04u
M20051 U5776/net19 n5250 VDD VDD pmos W=0.205u L=0.04u
M20052 U5776/net26 n5250 VSS VSS nmos W=0.155u L=0.04u
M20053 n5245 U5776/net26 VSS VSS nmos W=0.155u L=0.04u
M20054 U5776/XI20-net13 n5249 VSS VSS nmos W=0.155u L=0.04u
M20055 U5776/net26 n5247 U5776/XI20-net17 VSS nmos W=0.155u L=0.04u
M20056 U5776/XI20-net17 n5248 U5776/XI20-net13 VSS nmos W=0.155u L=0.04u
M20057 U5777/net19 n5210 VSS VSS nmos W=0.155u L=0.04u
M20058 n2959 n5210 U5777/net40 VSS nmos W=0.155u L=0.04u
M20059 n2959 U5777/net19 U5777/net36 VSS nmos W=0.155u L=0.04u
M20060 U5777/net40 g1594 VSS VSS nmos W=0.31u L=0.04u
M20061 U5777/net36 n5251 VSS VSS nmos W=0.155u L=0.04u
M20062 U5777/net19 n5210 VDD VDD pmos W=0.205u L=0.04u
M20063 n2959 U5777/net19 U5777/net26 VDD pmos W=0.325u L=0.04u
M20064 U5777/net26 g1594 VDD VDD pmos W=0.41u L=0.04u
M20065 n2959 n5210 U5777/net30 VDD pmos W=0.325u L=0.04u
M20066 U5777/net30 n5251 VDD VDD pmos W=0.205u L=0.04u
M20067 U5778/net19 n5212 VSS VSS nmos W=0.155u L=0.04u
M20068 n2958 n5212 U5778/net40 VSS nmos W=0.155u L=0.04u
M20069 n2958 U5778/net19 U5778/net36 VSS nmos W=0.155u L=0.04u
M20070 U5778/net40 g1597 VSS VSS nmos W=0.31u L=0.04u
M20071 U5778/net36 n5251 VSS VSS nmos W=0.155u L=0.04u
M20072 U5778/net19 n5212 VDD VDD pmos W=0.205u L=0.04u
M20073 n2958 U5778/net19 U5778/net26 VDD pmos W=0.325u L=0.04u
M20074 U5778/net26 g1597 VDD VDD pmos W=0.41u L=0.04u
M20075 n2958 n5212 U5778/net30 VDD pmos W=0.325u L=0.04u
M20076 U5778/net30 n5251 VDD VDD pmos W=0.205u L=0.04u
M20077 U5779/net19 n5211 VSS VSS nmos W=0.155u L=0.04u
M20078 n2957 n5211 U5779/net40 VSS nmos W=0.155u L=0.04u
M20079 n2957 U5779/net19 U5779/net36 VSS nmos W=0.155u L=0.04u
M20080 U5779/net40 g1600 VSS VSS nmos W=0.31u L=0.04u
M20081 U5779/net36 n5251 VSS VSS nmos W=0.155u L=0.04u
M20082 U5779/net19 n5211 VDD VDD pmos W=0.205u L=0.04u
M20083 n2957 U5779/net19 U5779/net26 VDD pmos W=0.325u L=0.04u
M20084 U5779/net26 g1600 VDD VDD pmos W=0.41u L=0.04u
M20085 n2957 n5211 U5779/net30 VDD pmos W=0.325u L=0.04u
M20086 U5779/net30 n5251 VDD VDD pmos W=0.205u L=0.04u
M20087 n5251 n5189 U5780/net10 VSS nmos W=0.155u L=0.04u
M20088 U5780/net10 n5254 VSS VSS nmos W=0.155u L=0.04u
M20089 n5251 n5252 U5780/net10 VSS nmos W=0.155u L=0.04u
M20090 U5780/net10 n5253 VSS VSS nmos W=0.155u L=0.04u
M20091 U5780/net30 n5254 VDD VDD pmos W=0.205u L=0.04u
M20092 n5251 n5189 U5780/net24 VDD pmos W=0.205u L=0.04u
M20093 U5780/net24 n5252 VDD VDD pmos W=0.205u L=0.04u
M20094 n5251 n5253 U5780/net30 VDD pmos W=0.205u L=0.04u
M20095 U5781/net4 n5255 U5781/net14 VSS nmos W=0.155u L=0.04u
M20096 U5781/net6 U5781/net10 U5781/net14 VSS nmos W=0.17u L=0.04u
M20097 U5781/net4 n5256 VSS VSS nmos W=0.155u L=0.04u
M20098 U5781/net6 U5781/net4 VSS VSS nmos W=0.17u L=0.04u
M20099 n5254 U5781/net14 VSS VSS nmos W=0.155u L=0.04u
M20100 U5781/net10 n5255 VSS VSS nmos W=0.155u L=0.04u
M20101 U5781/net4 U5781/net10 U5781/net14 VDD pmos W=0.255u L=0.04u
M20102 U5781/net6 n5255 U5781/net14 VDD pmos W=0.28u L=0.04u
M20103 U5781/net4 n5256 VDD VDD pmos W=0.205u L=0.04u
M20104 U5781/net6 U5781/net4 VDD VDD pmos W=0.24u L=0.04u
M20105 n5254 U5781/net14 VDD VDD pmos W=0.205u L=0.04u
M20106 U5781/net10 n5255 VDD VDD pmos W=0.205u L=0.04u
M20107 U5782/net19 n5210 VSS VSS nmos W=0.155u L=0.04u
M20108 n2956 n5210 U5782/net40 VSS nmos W=0.155u L=0.04u
M20109 n2956 U5782/net19 U5782/net36 VSS nmos W=0.155u L=0.04u
M20110 U5782/net40 g1630 VSS VSS nmos W=0.31u L=0.04u
M20111 U5782/net36 n5257 VSS VSS nmos W=0.155u L=0.04u
M20112 U5782/net19 n5210 VDD VDD pmos W=0.205u L=0.04u
M20113 n2956 U5782/net19 U5782/net26 VDD pmos W=0.325u L=0.04u
M20114 U5782/net26 g1630 VDD VDD pmos W=0.41u L=0.04u
M20115 n2956 n5210 U5782/net30 VDD pmos W=0.325u L=0.04u
M20116 U5782/net30 n5257 VDD VDD pmos W=0.205u L=0.04u
M20117 U5783/net19 n5212 VSS VSS nmos W=0.155u L=0.04u
M20118 n2955 n5212 U5783/net40 VSS nmos W=0.155u L=0.04u
M20119 n2955 U5783/net19 U5783/net36 VSS nmos W=0.155u L=0.04u
M20120 U5783/net40 g1633 VSS VSS nmos W=0.31u L=0.04u
M20121 U5783/net36 n5257 VSS VSS nmos W=0.155u L=0.04u
M20122 U5783/net19 n5212 VDD VDD pmos W=0.205u L=0.04u
M20123 n2955 U5783/net19 U5783/net26 VDD pmos W=0.325u L=0.04u
M20124 U5783/net26 g1633 VDD VDD pmos W=0.41u L=0.04u
M20125 n2955 n5212 U5783/net30 VDD pmos W=0.325u L=0.04u
M20126 U5783/net30 n5257 VDD VDD pmos W=0.205u L=0.04u
M20127 U5784/net19 n5211 VSS VSS nmos W=0.155u L=0.04u
M20128 n2954 n5211 U5784/net40 VSS nmos W=0.155u L=0.04u
M20129 n2954 U5784/net19 U5784/net36 VSS nmos W=0.155u L=0.04u
M20130 U5784/net40 g1636 VSS VSS nmos W=0.31u L=0.04u
M20131 U5784/net36 n5257 VSS VSS nmos W=0.155u L=0.04u
M20132 U5784/net19 n5211 VDD VDD pmos W=0.205u L=0.04u
M20133 n2954 U5784/net19 U5784/net26 VDD pmos W=0.325u L=0.04u
M20134 U5784/net26 g1636 VDD VDD pmos W=0.41u L=0.04u
M20135 n2954 n5211 U5784/net30 VDD pmos W=0.325u L=0.04u
M20136 U5784/net30 n5257 VDD VDD pmos W=0.205u L=0.04u
M20137 n5257 n5188 U5785/net10 VSS nmos W=0.155u L=0.04u
M20138 U5785/net10 n5258 VSS VSS nmos W=0.155u L=0.04u
M20139 n5257 n5252 U5785/net10 VSS nmos W=0.155u L=0.04u
M20140 U5785/net10 n5253 VSS VSS nmos W=0.155u L=0.04u
M20141 U5785/net30 n5258 VDD VDD pmos W=0.205u L=0.04u
M20142 n5257 n5188 U5785/net24 VDD pmos W=0.205u L=0.04u
M20143 U5785/net24 n5252 VDD VDD pmos W=0.205u L=0.04u
M20144 n5257 n5253 U5785/net30 VDD pmos W=0.205u L=0.04u
M20145 U5786/net4 n5259 U5786/net14 VSS nmos W=0.155u L=0.04u
M20146 U5786/net6 U5786/net10 U5786/net14 VSS nmos W=0.17u L=0.04u
M20147 U5786/net4 n5260 VSS VSS nmos W=0.155u L=0.04u
M20148 U5786/net6 U5786/net4 VSS VSS nmos W=0.17u L=0.04u
M20149 n5258 U5786/net14 VSS VSS nmos W=0.155u L=0.04u
M20150 U5786/net10 n5259 VSS VSS nmos W=0.155u L=0.04u
M20151 U5786/net4 U5786/net10 U5786/net14 VDD pmos W=0.255u L=0.04u
M20152 U5786/net6 n5259 U5786/net14 VDD pmos W=0.28u L=0.04u
M20153 U5786/net4 n5260 VDD VDD pmos W=0.205u L=0.04u
M20154 U5786/net6 U5786/net4 VDD VDD pmos W=0.24u L=0.04u
M20155 n5258 U5786/net14 VDD VDD pmos W=0.205u L=0.04u
M20156 U5786/net10 n5259 VDD VDD pmos W=0.205u L=0.04u
M20157 U5787/XU1-net6 n5262 VSS VSS nmos W=0.155u L=0.04u
M20158 n5259 n5261 U5787/XU1-net6 VSS nmos W=0.155u L=0.04u
M20159 n5259 n5262 VDD VDD pmos W=0.155u L=0.04u
M20160 n5259 n5261 VDD VDD pmos W=0.155u L=0.04u
M20161 U5788/net19 n5210 VSS VSS nmos W=0.155u L=0.04u
M20162 n2953 n5210 U5788/net40 VSS nmos W=0.155u L=0.04u
M20163 n2953 U5788/net19 U5788/net36 VSS nmos W=0.155u L=0.04u
M20164 U5788/net40 g1585 VSS VSS nmos W=0.31u L=0.04u
M20165 U5788/net36 n5263 VSS VSS nmos W=0.155u L=0.04u
M20166 U5788/net19 n5210 VDD VDD pmos W=0.205u L=0.04u
M20167 n2953 U5788/net19 U5788/net26 VDD pmos W=0.325u L=0.04u
M20168 U5788/net26 g1585 VDD VDD pmos W=0.41u L=0.04u
M20169 n2953 n5210 U5788/net30 VDD pmos W=0.325u L=0.04u
M20170 U5788/net30 n5263 VDD VDD pmos W=0.205u L=0.04u
M20171 U5789/net19 n5212 VSS VSS nmos W=0.155u L=0.04u
M20172 n2952 n5212 U5789/net40 VSS nmos W=0.155u L=0.04u
M20173 n2952 U5789/net19 U5789/net36 VSS nmos W=0.155u L=0.04u
M20174 U5789/net40 g1588 VSS VSS nmos W=0.31u L=0.04u
M20175 U5789/net36 n5263 VSS VSS nmos W=0.155u L=0.04u
M20176 U5789/net19 n5212 VDD VDD pmos W=0.205u L=0.04u
M20177 n2952 U5789/net19 U5789/net26 VDD pmos W=0.325u L=0.04u
M20178 U5789/net26 g1588 VDD VDD pmos W=0.41u L=0.04u
M20179 n2952 n5212 U5789/net30 VDD pmos W=0.325u L=0.04u
M20180 U5789/net30 n5263 VDD VDD pmos W=0.205u L=0.04u
M20181 U5790/net19 n5211 VSS VSS nmos W=0.155u L=0.04u
M20182 n2951 n5211 U5790/net40 VSS nmos W=0.155u L=0.04u
M20183 n2951 U5790/net19 U5790/net36 VSS nmos W=0.155u L=0.04u
M20184 U5790/net40 g1591 VSS VSS nmos W=0.31u L=0.04u
M20185 U5790/net36 n5263 VSS VSS nmos W=0.155u L=0.04u
M20186 U5790/net19 n5211 VDD VDD pmos W=0.205u L=0.04u
M20187 n2951 U5790/net19 U5790/net26 VDD pmos W=0.325u L=0.04u
M20188 U5790/net26 g1591 VDD VDD pmos W=0.41u L=0.04u
M20189 n2951 n5211 U5790/net30 VDD pmos W=0.325u L=0.04u
M20190 U5790/net30 n5263 VDD VDD pmos W=0.205u L=0.04u
M20191 n5263 n5187 U5791/net10 VSS nmos W=0.155u L=0.04u
M20192 U5791/net10 n5264 VSS VSS nmos W=0.155u L=0.04u
M20193 n5263 n5252 U5791/net10 VSS nmos W=0.155u L=0.04u
M20194 U5791/net10 n5253 VSS VSS nmos W=0.155u L=0.04u
M20195 U5791/net30 n5264 VDD VDD pmos W=0.205u L=0.04u
M20196 n5263 n5187 U5791/net24 VDD pmos W=0.205u L=0.04u
M20197 U5791/net24 n5252 VDD VDD pmos W=0.205u L=0.04u
M20198 n5263 n5253 U5791/net30 VDD pmos W=0.205u L=0.04u
M20199 U5792/net4 n5265 U5792/net14 VSS nmos W=0.155u L=0.04u
M20200 U5792/net6 U5792/net10 U5792/net14 VSS nmos W=0.17u L=0.04u
M20201 U5792/net4 n5261 VSS VSS nmos W=0.155u L=0.04u
M20202 U5792/net6 U5792/net4 VSS VSS nmos W=0.17u L=0.04u
M20203 n5264 U5792/net14 VSS VSS nmos W=0.155u L=0.04u
M20204 U5792/net10 n5265 VSS VSS nmos W=0.155u L=0.04u
M20205 U5792/net4 U5792/net10 U5792/net14 VDD pmos W=0.255u L=0.04u
M20206 U5792/net6 n5265 U5792/net14 VDD pmos W=0.28u L=0.04u
M20207 U5792/net4 n5261 VDD VDD pmos W=0.205u L=0.04u
M20208 U5792/net6 U5792/net4 VDD VDD pmos W=0.24u L=0.04u
M20209 n5264 U5792/net14 VDD VDD pmos W=0.205u L=0.04u
M20210 U5792/net10 n5265 VDD VDD pmos W=0.205u L=0.04u
M20211 U5793/net19 n5212 VSS VSS nmos W=0.155u L=0.04u
M20212 n2950 n5212 U5793/net40 VSS nmos W=0.155u L=0.04u
M20213 n2950 U5793/net19 U5793/net36 VSS nmos W=0.155u L=0.04u
M20214 U5793/net40 g1570 VSS VSS nmos W=0.31u L=0.04u
M20215 U5793/net36 n5266 VSS VSS nmos W=0.155u L=0.04u
M20216 U5793/net19 n5212 VDD VDD pmos W=0.205u L=0.04u
M20217 n2950 U5793/net19 U5793/net26 VDD pmos W=0.325u L=0.04u
M20218 U5793/net26 g1570 VDD VDD pmos W=0.41u L=0.04u
M20219 n2950 n5212 U5793/net30 VDD pmos W=0.325u L=0.04u
M20220 U5793/net30 n5266 VDD VDD pmos W=0.205u L=0.04u
M20221 U5794/net19 n5211 VSS VSS nmos W=0.155u L=0.04u
M20222 n2949 n5211 U5794/net40 VSS nmos W=0.155u L=0.04u
M20223 n2949 U5794/net19 U5794/net36 VSS nmos W=0.155u L=0.04u
M20224 U5794/net40 g1573 VSS VSS nmos W=0.31u L=0.04u
M20225 U5794/net36 n5266 VSS VSS nmos W=0.155u L=0.04u
M20226 U5794/net19 n5211 VDD VDD pmos W=0.205u L=0.04u
M20227 n2949 U5794/net19 U5794/net26 VDD pmos W=0.325u L=0.04u
M20228 U5794/net26 g1573 VDD VDD pmos W=0.41u L=0.04u
M20229 n2949 n5211 U5794/net30 VDD pmos W=0.325u L=0.04u
M20230 U5794/net30 n5266 VDD VDD pmos W=0.205u L=0.04u
M20231 U5795/net19 n5210 VSS VSS nmos W=0.155u L=0.04u
M20232 n2948 n5210 U5795/net40 VSS nmos W=0.155u L=0.04u
M20233 n2948 U5795/net19 U5795/net36 VSS nmos W=0.155u L=0.04u
M20234 U5795/net40 g1567 VSS VSS nmos W=0.31u L=0.04u
M20235 U5795/net36 n5266 VSS VSS nmos W=0.155u L=0.04u
M20236 U5795/net19 n5210 VDD VDD pmos W=0.205u L=0.04u
M20237 n2948 U5795/net19 U5795/net26 VDD pmos W=0.325u L=0.04u
M20238 U5795/net26 g1567 VDD VDD pmos W=0.41u L=0.04u
M20239 n2948 n5210 U5795/net30 VDD pmos W=0.325u L=0.04u
M20240 U5795/net30 n5266 VDD VDD pmos W=0.205u L=0.04u
M20241 n5266 n5183 U5796/net10 VSS nmos W=0.155u L=0.04u
M20242 U5796/net10 n5253 VSS VSS nmos W=0.155u L=0.04u
M20243 n5266 n5252 U5796/net10 VSS nmos W=0.155u L=0.04u
M20244 U5796/net10 n5267 VSS VSS nmos W=0.155u L=0.04u
M20245 U5796/net30 n5253 VDD VDD pmos W=0.205u L=0.04u
M20246 n5266 n5183 U5796/net24 VDD pmos W=0.205u L=0.04u
M20247 U5796/net24 n5252 VDD VDD pmos W=0.205u L=0.04u
M20248 n5266 n5267 U5796/net30 VDD pmos W=0.205u L=0.04u
M20249 U5797/net4 n5268 U5797/net14 VSS nmos W=0.155u L=0.04u
M20250 U5797/net6 U5797/net10 U5797/net14 VSS nmos W=0.17u L=0.04u
M20251 U5797/net4 n5269 VSS VSS nmos W=0.155u L=0.04u
M20252 U5797/net6 U5797/net4 VSS VSS nmos W=0.17u L=0.04u
M20253 n5267 U5797/net14 VSS VSS nmos W=0.155u L=0.04u
M20254 U5797/net10 n5268 VSS VSS nmos W=0.155u L=0.04u
M20255 U5797/net4 U5797/net10 U5797/net14 VDD pmos W=0.255u L=0.04u
M20256 U5797/net6 n5268 U5797/net14 VDD pmos W=0.28u L=0.04u
M20257 U5797/net4 n5269 VDD VDD pmos W=0.205u L=0.04u
M20258 U5797/net6 U5797/net4 VDD VDD pmos W=0.24u L=0.04u
M20259 n5267 U5797/net14 VDD VDD pmos W=0.205u L=0.04u
M20260 U5797/net10 n5268 VDD VDD pmos W=0.205u L=0.04u
M20261 U5798/net19 n5212 VSS VSS nmos W=0.155u L=0.04u
M20262 n2947 n5212 U5798/net40 VSS nmos W=0.155u L=0.04u
M20263 n2947 U5798/net19 U5798/net36 VSS nmos W=0.155u L=0.04u
M20264 U5798/net40 g1651 VSS VSS nmos W=0.31u L=0.04u
M20265 U5798/net36 n5270 VSS VSS nmos W=0.155u L=0.04u
M20266 U5798/net19 n5212 VDD VDD pmos W=0.205u L=0.04u
M20267 n2947 U5798/net19 U5798/net26 VDD pmos W=0.325u L=0.04u
M20268 U5798/net26 g1651 VDD VDD pmos W=0.41u L=0.04u
M20269 n2947 n5212 U5798/net30 VDD pmos W=0.325u L=0.04u
M20270 U5798/net30 n5270 VDD VDD pmos W=0.205u L=0.04u
M20271 U5799/net19 n5211 VSS VSS nmos W=0.155u L=0.04u
M20272 n2946 n5211 U5799/net40 VSS nmos W=0.155u L=0.04u
M20273 n2946 U5799/net19 U5799/net36 VSS nmos W=0.155u L=0.04u
M20274 U5799/net40 g1654 VSS VSS nmos W=0.31u L=0.04u
M20275 U5799/net36 n5270 VSS VSS nmos W=0.155u L=0.04u
M20276 U5799/net19 n5211 VDD VDD pmos W=0.205u L=0.04u
M20277 n2946 U5799/net19 U5799/net26 VDD pmos W=0.325u L=0.04u
M20278 U5799/net26 g1654 VDD VDD pmos W=0.41u L=0.04u
M20279 n2946 n5211 U5799/net30 VDD pmos W=0.325u L=0.04u
M20280 U5799/net30 n5270 VDD VDD pmos W=0.205u L=0.04u
M20281 U5800/net19 n5210 VSS VSS nmos W=0.155u L=0.04u
M20282 n2945 n5210 U5800/net40 VSS nmos W=0.155u L=0.04u
M20283 n2945 U5800/net19 U5800/net36 VSS nmos W=0.155u L=0.04u
M20284 U5800/net40 g1648 VSS VSS nmos W=0.31u L=0.04u
M20285 U5800/net36 n5270 VSS VSS nmos W=0.155u L=0.04u
M20286 U5800/net19 n5210 VDD VDD pmos W=0.205u L=0.04u
M20287 n2945 U5800/net19 U5800/net26 VDD pmos W=0.325u L=0.04u
M20288 U5800/net26 g1648 VDD VDD pmos W=0.41u L=0.04u
M20289 n2945 n5210 U5800/net30 VDD pmos W=0.325u L=0.04u
M20290 U5800/net30 n5270 VDD VDD pmos W=0.205u L=0.04u
M20291 U5801/net32 n5252 U5801/net26 VSS nmos W=0.155u L=0.04u
M20292 U5801/net32 n5236 U5801/net26 VSS nmos W=0.155u L=0.04u
M20293 U5801/net29 n5272 VSS VSS nmos W=0.155u L=0.04u
M20294 U5801/net26 n5271 U5801/net29 VSS nmos W=0.155u L=0.04u
M20295 U5801/net26 n5253 U5801/net29 VSS nmos W=0.155u L=0.04u
M20296 n5270 U5801/net32 VSS VSS nmos W=0.155u L=0.04u
M20297 n5270 U5801/net32 VDD VDD pmos W=0.205u L=0.04u
M20298 U5801/net32 n5236 U5801/net43 VDD pmos W=0.205u L=0.04u
M20299 U5801/net32 n5253 U5801/net49 VDD pmos W=0.205u L=0.04u
M20300 U5801/net49 n5271 VDD VDD pmos W=0.205u L=0.04u
M20301 U5801/net43 n5252 VDD VDD pmos W=0.205u L=0.04u
M20302 U5801/net32 n5272 VDD VDD pmos W=0.205u L=0.04u
M20303 U5802/net4 n5273 U5802/net14 VSS nmos W=0.155u L=0.04u
M20304 U5802/net6 U5802/net10 U5802/net14 VSS nmos W=0.17u L=0.04u
M20305 U5802/net4 n5274 VSS VSS nmos W=0.155u L=0.04u
M20306 U5802/net6 U5802/net4 VSS VSS nmos W=0.17u L=0.04u
M20307 n5271 U5802/net14 VSS VSS nmos W=0.155u L=0.04u
M20308 U5802/net10 n5273 VSS VSS nmos W=0.155u L=0.04u
M20309 U5802/net4 U5802/net10 U5802/net14 VDD pmos W=0.255u L=0.04u
M20310 U5802/net6 n5273 U5802/net14 VDD pmos W=0.28u L=0.04u
M20311 U5802/net4 n5274 VDD VDD pmos W=0.205u L=0.04u
M20312 U5802/net6 U5802/net4 VDD VDD pmos W=0.24u L=0.04u
M20313 n5271 U5802/net14 VDD VDD pmos W=0.205u L=0.04u
M20314 U5802/net10 n5273 VDD VDD pmos W=0.205u L=0.04u
M20315 n5273 n5275 VSS VSS nmos W=0.155u L=0.04u
M20316 n5273 n5276 VSS VSS nmos W=0.155u L=0.04u
M20317 U5803/XI1-net8 n5276 VDD VDD pmos W=0.205u L=0.04u
M20318 n5273 n5275 U5803/XI1-net8 VDD pmos W=0.205u L=0.04u
M20319 U5804/net4 n5250 U5804/net14 VSS nmos W=0.155u L=0.04u
M20320 U5804/net6 U5804/net10 U5804/net14 VSS nmos W=0.17u L=0.04u
M20321 U5804/net4 n5277 VSS VSS nmos W=0.155u L=0.04u
M20322 U5804/net6 U5804/net4 VSS VSS nmos W=0.17u L=0.04u
M20323 n5275 U5804/net14 VSS VSS nmos W=0.155u L=0.04u
M20324 U5804/net10 n5250 VSS VSS nmos W=0.155u L=0.04u
M20325 U5804/net4 U5804/net10 U5804/net14 VDD pmos W=0.255u L=0.04u
M20326 U5804/net6 n5250 U5804/net14 VDD pmos W=0.28u L=0.04u
M20327 U5804/net4 n5277 VDD VDD pmos W=0.205u L=0.04u
M20328 U5804/net6 U5804/net4 VDD VDD pmos W=0.24u L=0.04u
M20329 n5275 U5804/net14 VDD VDD pmos W=0.205u L=0.04u
M20330 U5804/net10 n5250 VDD VDD pmos W=0.205u L=0.04u
M20331 U5805/net19 n5210 VSS VSS nmos W=0.155u L=0.04u
M20332 n2944 n5210 U5805/net40 VSS nmos W=0.155u L=0.04u
M20333 n2944 U5805/net19 U5805/net36 VSS nmos W=0.155u L=0.04u
M20334 U5805/net40 g1603 VSS VSS nmos W=0.31u L=0.04u
M20335 U5805/net36 n5278 VSS VSS nmos W=0.155u L=0.04u
M20336 U5805/net19 n5210 VDD VDD pmos W=0.205u L=0.04u
M20337 n2944 U5805/net19 U5805/net26 VDD pmos W=0.325u L=0.04u
M20338 U5805/net26 g1603 VDD VDD pmos W=0.41u L=0.04u
M20339 n2944 n5210 U5805/net30 VDD pmos W=0.325u L=0.04u
M20340 U5805/net30 n5278 VDD VDD pmos W=0.205u L=0.04u
M20341 U5806/net19 n5212 VSS VSS nmos W=0.155u L=0.04u
M20342 n2943 n5212 U5806/net40 VSS nmos W=0.155u L=0.04u
M20343 n2943 U5806/net19 U5806/net36 VSS nmos W=0.155u L=0.04u
M20344 U5806/net40 g1606 VSS VSS nmos W=0.31u L=0.04u
M20345 U5806/net36 n5278 VSS VSS nmos W=0.155u L=0.04u
M20346 U5806/net19 n5212 VDD VDD pmos W=0.205u L=0.04u
M20347 n2943 U5806/net19 U5806/net26 VDD pmos W=0.325u L=0.04u
M20348 U5806/net26 g1606 VDD VDD pmos W=0.41u L=0.04u
M20349 n2943 n5212 U5806/net30 VDD pmos W=0.325u L=0.04u
M20350 U5806/net30 n5278 VDD VDD pmos W=0.205u L=0.04u
M20351 U5807/net19 n5211 VSS VSS nmos W=0.155u L=0.04u
M20352 n2942 n5211 U5807/net40 VSS nmos W=0.155u L=0.04u
M20353 n2942 U5807/net19 U5807/net36 VSS nmos W=0.155u L=0.04u
M20354 U5807/net40 g1609 VSS VSS nmos W=0.31u L=0.04u
M20355 U5807/net36 n5278 VSS VSS nmos W=0.155u L=0.04u
M20356 U5807/net19 n5211 VDD VDD pmos W=0.205u L=0.04u
M20357 n2942 U5807/net19 U5807/net26 VDD pmos W=0.325u L=0.04u
M20358 U5807/net26 g1609 VDD VDD pmos W=0.41u L=0.04u
M20359 n2942 n5211 U5807/net30 VDD pmos W=0.325u L=0.04u
M20360 U5807/net30 n5278 VDD VDD pmos W=0.205u L=0.04u
M20361 n5278 n5252 U5808/net27 VSS nmos W=0.155u L=0.04u
M20362 U5808/net39 n5280 VSS VSS nmos W=0.155u L=0.04u
M20363 U5808/net27 n5253 U5808/net39 VSS nmos W=0.155u L=0.04u
M20364 U5808/net27 n5279 U5808/net39 VSS nmos W=0.155u L=0.04u
M20365 n5278 n4070 U5808/net27 VSS nmos W=0.155u L=0.04u
M20366 U5808/net39 n5250 VSS VSS nmos W=0.155u L=0.04u
M20367 n5278 n5280 U5808/net46 VDD pmos W=0.205u L=0.04u
M20368 U5808/net46 n5250 VDD VDD pmos W=0.205u L=0.04u
M20369 n5278 n4070 U5808/net34 VDD pmos W=0.205u L=0.04u
M20370 U5808/net34 n5252 VDD VDD pmos W=0.205u L=0.04u
M20371 n5278 n5279 U5808/net37 VDD pmos W=0.205u L=0.04u
M20372 U5808/net37 n5253 VDD VDD pmos W=0.205u L=0.04u
M20373 U5809/net4 n5276 U5809/net14 VSS nmos W=0.155u L=0.04u
M20374 U5809/net6 U5809/net10 U5809/net14 VSS nmos W=0.17u L=0.04u
M20375 U5809/net4 n5277 VSS VSS nmos W=0.155u L=0.04u
M20376 U5809/net6 U5809/net4 VSS VSS nmos W=0.17u L=0.04u
M20377 n5279 U5809/net14 VSS VSS nmos W=0.155u L=0.04u
M20378 U5809/net10 n5276 VSS VSS nmos W=0.155u L=0.04u
M20379 U5809/net4 U5809/net10 U5809/net14 VDD pmos W=0.255u L=0.04u
M20380 U5809/net6 n5276 U5809/net14 VDD pmos W=0.28u L=0.04u
M20381 U5809/net4 n5277 VDD VDD pmos W=0.205u L=0.04u
M20382 U5809/net6 U5809/net4 VDD VDD pmos W=0.24u L=0.04u
M20383 n5279 U5809/net14 VDD VDD pmos W=0.205u L=0.04u
M20384 U5809/net10 n5276 VDD VDD pmos W=0.205u L=0.04u
M20385 U5810/XU1-net6 n5282 VSS VSS nmos W=0.155u L=0.04u
M20386 n5276 n5281 U5810/XU1-net6 VSS nmos W=0.155u L=0.04u
M20387 n5276 n5282 VDD VDD pmos W=0.155u L=0.04u
M20388 n5276 n5281 VDD VDD pmos W=0.155u L=0.04u
M20389 U5811/net19 n5283 VSS VSS nmos W=0.155u L=0.04u
M20390 n5281 n5283 U5811/net40 VSS nmos W=0.155u L=0.04u
M20391 n5281 U5811/net19 U5811/net36 VSS nmos W=0.155u L=0.04u
M20392 U5811/net40 n5256 VSS VSS nmos W=0.31u L=0.04u
M20393 U5811/net36 n5250 VSS VSS nmos W=0.155u L=0.04u
M20394 U5811/net19 n5283 VDD VDD pmos W=0.205u L=0.04u
M20395 n5281 U5811/net19 U5811/net26 VDD pmos W=0.325u L=0.04u
M20396 U5811/net26 n5256 VDD VDD pmos W=0.41u L=0.04u
M20397 n5281 n5283 U5811/net30 VDD pmos W=0.325u L=0.04u
M20398 U5811/net30 n5250 VDD VDD pmos W=0.205u L=0.04u
M20399 U5812/net19 n5210 VSS VSS nmos W=0.155u L=0.04u
M20400 n2941 n5210 U5812/net40 VSS nmos W=0.155u L=0.04u
M20401 n2941 U5812/net19 U5812/net36 VSS nmos W=0.155u L=0.04u
M20402 U5812/net40 g1621 VSS VSS nmos W=0.31u L=0.04u
M20403 U5812/net36 n5284 VSS VSS nmos W=0.155u L=0.04u
M20404 U5812/net19 n5210 VDD VDD pmos W=0.205u L=0.04u
M20405 n2941 U5812/net19 U5812/net26 VDD pmos W=0.325u L=0.04u
M20406 U5812/net26 g1621 VDD VDD pmos W=0.41u L=0.04u
M20407 n2941 n5210 U5812/net30 VDD pmos W=0.325u L=0.04u
M20408 U5812/net30 n5284 VDD VDD pmos W=0.205u L=0.04u
M20409 U5813/net19 n5212 VSS VSS nmos W=0.155u L=0.04u
M20410 n2940 n5212 U5813/net40 VSS nmos W=0.155u L=0.04u
M20411 n2940 U5813/net19 U5813/net36 VSS nmos W=0.155u L=0.04u
M20412 U5813/net40 g1624 VSS VSS nmos W=0.31u L=0.04u
M20413 U5813/net36 n5284 VSS VSS nmos W=0.155u L=0.04u
M20414 U5813/net19 n5212 VDD VDD pmos W=0.205u L=0.04u
M20415 n2940 U5813/net19 U5813/net26 VDD pmos W=0.325u L=0.04u
M20416 U5813/net26 g1624 VDD VDD pmos W=0.41u L=0.04u
M20417 n2940 n5212 U5813/net30 VDD pmos W=0.325u L=0.04u
M20418 U5813/net30 n5284 VDD VDD pmos W=0.205u L=0.04u
M20419 U5814/net19 n5211 VSS VSS nmos W=0.155u L=0.04u
M20420 n2939 n5211 U5814/net40 VSS nmos W=0.155u L=0.04u
M20421 n2939 U5814/net19 U5814/net36 VSS nmos W=0.155u L=0.04u
M20422 U5814/net40 g1627 VSS VSS nmos W=0.31u L=0.04u
M20423 U5814/net36 n5284 VSS VSS nmos W=0.155u L=0.04u
M20424 U5814/net19 n5211 VDD VDD pmos W=0.205u L=0.04u
M20425 n2939 U5814/net19 U5814/net26 VDD pmos W=0.325u L=0.04u
M20426 U5814/net26 g1627 VDD VDD pmos W=0.41u L=0.04u
M20427 n2939 n5211 U5814/net30 VDD pmos W=0.325u L=0.04u
M20428 U5814/net30 n5284 VDD VDD pmos W=0.205u L=0.04u
M20429 U5815/net32 n5252 U5815/net26 VSS nmos W=0.155u L=0.04u
M20430 U5815/net32 g1486 U5815/net26 VSS nmos W=0.155u L=0.04u
M20431 U5815/net29 n5272 VSS VSS nmos W=0.155u L=0.04u
M20432 U5815/net26 n5285 U5815/net29 VSS nmos W=0.155u L=0.04u
M20433 U5815/net26 n5253 U5815/net29 VSS nmos W=0.155u L=0.04u
M20434 n5284 U5815/net32 VSS VSS nmos W=0.155u L=0.04u
M20435 n5284 U5815/net32 VDD VDD pmos W=0.205u L=0.04u
M20436 U5815/net32 g1486 U5815/net43 VDD pmos W=0.205u L=0.04u
M20437 U5815/net32 n5253 U5815/net49 VDD pmos W=0.205u L=0.04u
M20438 U5815/net49 n5285 VDD VDD pmos W=0.205u L=0.04u
M20439 U5815/net43 n5252 VDD VDD pmos W=0.205u L=0.04u
M20440 U5815/net32 n5272 VDD VDD pmos W=0.205u L=0.04u
M20441 U5816/net4 n5286 U5816/net14 VSS nmos W=0.155u L=0.04u
M20442 U5816/net6 U5816/net10 U5816/net14 VSS nmos W=0.17u L=0.04u
M20443 U5816/net4 n5287 VSS VSS nmos W=0.155u L=0.04u
M20444 U5816/net6 U5816/net4 VSS VSS nmos W=0.17u L=0.04u
M20445 n5285 U5816/net14 VSS VSS nmos W=0.155u L=0.04u
M20446 U5816/net10 n5286 VSS VSS nmos W=0.155u L=0.04u
M20447 U5816/net4 U5816/net10 U5816/net14 VDD pmos W=0.255u L=0.04u
M20448 U5816/net6 n5286 U5816/net14 VDD pmos W=0.28u L=0.04u
M20449 U5816/net4 n5287 VDD VDD pmos W=0.205u L=0.04u
M20450 U5816/net6 U5816/net4 VDD VDD pmos W=0.24u L=0.04u
M20451 n5285 U5816/net14 VDD VDD pmos W=0.205u L=0.04u
M20452 U5816/net10 n5286 VDD VDD pmos W=0.205u L=0.04u
M20453 n5286 n5250 U5817/net27 VSS nmos W=0.155u L=0.04u
M20454 U5817/net27 n5288 VSS VSS nmos W=0.155u L=0.04u
M20455 n5286 n5289 VSS VSS nmos W=0.155u L=0.04u
M20456 n5286 n5288 U5817/net13 VDD pmos W=0.205u L=0.04u
M20457 U5817/net13 n5289 VDD VDD pmos W=0.205u L=0.04u
M20458 n5286 n5250 U5817/net13 VDD pmos W=0.205u L=0.04u
M20459 U5818/net19 n5210 VSS VSS nmos W=0.155u L=0.04u
M20460 n2938 n5210 U5818/net40 VSS nmos W=0.155u L=0.04u
M20461 n2938 U5818/net19 U5818/net36 VSS nmos W=0.155u L=0.04u
M20462 U5818/net40 g1576 VSS VSS nmos W=0.31u L=0.04u
M20463 U5818/net36 n5290 VSS VSS nmos W=0.155u L=0.04u
M20464 U5818/net19 n5210 VDD VDD pmos W=0.205u L=0.04u
M20465 n2938 U5818/net19 U5818/net26 VDD pmos W=0.325u L=0.04u
M20466 U5818/net26 g1576 VDD VDD pmos W=0.41u L=0.04u
M20467 n2938 n5210 U5818/net30 VDD pmos W=0.325u L=0.04u
M20468 U5818/net30 n5290 VDD VDD pmos W=0.205u L=0.04u
M20469 U5819/net19 n5212 VSS VSS nmos W=0.155u L=0.04u
M20470 n2937 n5212 U5819/net40 VSS nmos W=0.155u L=0.04u
M20471 n2937 U5819/net19 U5819/net36 VSS nmos W=0.155u L=0.04u
M20472 U5819/net40 g1579 VSS VSS nmos W=0.31u L=0.04u
M20473 U5819/net36 n5290 VSS VSS nmos W=0.155u L=0.04u
M20474 U5819/net19 n5212 VDD VDD pmos W=0.205u L=0.04u
M20475 n2937 U5819/net19 U5819/net26 VDD pmos W=0.325u L=0.04u
M20476 U5819/net26 g1579 VDD VDD pmos W=0.41u L=0.04u
M20477 n2937 n5212 U5819/net30 VDD pmos W=0.325u L=0.04u
M20478 U5819/net30 n5290 VDD VDD pmos W=0.205u L=0.04u
M20479 U5820/net19 n5211 VSS VSS nmos W=0.155u L=0.04u
M20480 n2936 n5211 U5820/net40 VSS nmos W=0.155u L=0.04u
M20481 n2936 U5820/net19 U5820/net36 VSS nmos W=0.155u L=0.04u
M20482 U5820/net40 g1582 VSS VSS nmos W=0.31u L=0.04u
M20483 U5820/net36 n5290 VSS VSS nmos W=0.155u L=0.04u
M20484 U5820/net19 n5211 VDD VDD pmos W=0.205u L=0.04u
M20485 n2936 U5820/net19 U5820/net26 VDD pmos W=0.325u L=0.04u
M20486 U5820/net26 g1582 VDD VDD pmos W=0.41u L=0.04u
M20487 n2936 n5211 U5820/net30 VDD pmos W=0.325u L=0.04u
M20488 U5820/net30 n5290 VDD VDD pmos W=0.205u L=0.04u
M20489 n5290 n5252 U5821/net27 VSS nmos W=0.155u L=0.04u
M20490 U5821/net39 n5280 VSS VSS nmos W=0.155u L=0.04u
M20491 U5821/net27 n5253 U5821/net39 VSS nmos W=0.155u L=0.04u
M20492 U5821/net27 n5291 U5821/net39 VSS nmos W=0.155u L=0.04u
M20493 n5290 n5185 U5821/net27 VSS nmos W=0.155u L=0.04u
M20494 U5821/net39 n5250 VSS VSS nmos W=0.155u L=0.04u
M20495 n5290 n5280 U5821/net46 VDD pmos W=0.205u L=0.04u
M20496 U5821/net46 n5250 VDD VDD pmos W=0.205u L=0.04u
M20497 n5290 n5185 U5821/net34 VDD pmos W=0.205u L=0.04u
M20498 U5821/net34 n5252 VDD VDD pmos W=0.205u L=0.04u
M20499 n5290 n5291 U5821/net37 VDD pmos W=0.205u L=0.04u
M20500 U5821/net37 n5253 VDD VDD pmos W=0.205u L=0.04u
M20501 U5822/net4 U5822/net10 U5822/net14 VSS nmos W=0.155u L=0.04u
M20502 U5822/net6 n5288 U5822/net14 VSS nmos W=0.155u L=0.04u
M20503 U5822/net4 n5292 VSS VSS nmos W=0.155u L=0.04u
M20504 U5822/net6 U5822/net4 VSS VSS nmos W=0.155u L=0.04u
M20505 n5291 U5822/net14 VSS VSS nmos W=0.155u L=0.04u
M20506 U5822/net10 n5288 VSS VSS nmos W=0.155u L=0.04u
M20507 U5822/net4 n5288 U5822/net14 VDD pmos W=0.205u L=0.04u
M20508 U5822/net6 U5822/net10 U5822/net14 VDD pmos W=0.205u L=0.04u
M20509 U5822/net4 n5292 VDD VDD pmos W=0.205u L=0.04u
M20510 U5822/net6 U5822/net4 VDD VDD pmos W=0.205u L=0.04u
M20511 n5291 U5822/net14 VDD VDD pmos W=0.205u L=0.04u
M20512 U5822/net10 n5288 VDD VDD pmos W=0.205u L=0.04u
M20513 U5823/net19 n5210 VSS VSS nmos W=0.155u L=0.04u
M20514 n2935 n5210 U5823/net40 VSS nmos W=0.155u L=0.04u
M20515 n2935 U5823/net19 U5823/net36 VSS nmos W=0.155u L=0.04u
M20516 U5823/net40 g1612 VSS VSS nmos W=0.31u L=0.04u
M20517 U5823/net36 n5293 VSS VSS nmos W=0.155u L=0.04u
M20518 U5823/net19 n5210 VDD VDD pmos W=0.205u L=0.04u
M20519 n2935 U5823/net19 U5823/net26 VDD pmos W=0.325u L=0.04u
M20520 U5823/net26 g1612 VDD VDD pmos W=0.41u L=0.04u
M20521 n2935 n5210 U5823/net30 VDD pmos W=0.325u L=0.04u
M20522 U5823/net30 n5293 VDD VDD pmos W=0.205u L=0.04u
M20523 U5824/net19 n5212 VSS VSS nmos W=0.155u L=0.04u
M20524 n2934 n5212 U5824/net40 VSS nmos W=0.155u L=0.04u
M20525 n2934 U5824/net19 U5824/net36 VSS nmos W=0.155u L=0.04u
M20526 U5824/net40 g1615 VSS VSS nmos W=0.31u L=0.04u
M20527 U5824/net36 n5293 VSS VSS nmos W=0.155u L=0.04u
M20528 U5824/net19 n5212 VDD VDD pmos W=0.205u L=0.04u
M20529 n2934 U5824/net19 U5824/net26 VDD pmos W=0.325u L=0.04u
M20530 U5824/net26 g1615 VDD VDD pmos W=0.41u L=0.04u
M20531 n2934 n5212 U5824/net30 VDD pmos W=0.325u L=0.04u
M20532 U5824/net30 n5293 VDD VDD pmos W=0.205u L=0.04u
M20533 U5825/net19 n5211 VSS VSS nmos W=0.155u L=0.04u
M20534 n2933 n5211 U5825/net40 VSS nmos W=0.155u L=0.04u
M20535 n2933 U5825/net19 U5825/net36 VSS nmos W=0.155u L=0.04u
M20536 U5825/net40 g1618 VSS VSS nmos W=0.31u L=0.04u
M20537 U5825/net36 n5293 VSS VSS nmos W=0.155u L=0.04u
M20538 U5825/net19 n5211 VDD VDD pmos W=0.205u L=0.04u
M20539 n2933 U5825/net19 U5825/net26 VDD pmos W=0.325u L=0.04u
M20540 U5825/net26 g1618 VDD VDD pmos W=0.41u L=0.04u
M20541 n2933 n5211 U5825/net30 VDD pmos W=0.325u L=0.04u
M20542 U5825/net30 n5293 VDD VDD pmos W=0.205u L=0.04u
M20543 U5826/net32 n5252 U5826/net26 VSS nmos W=0.155u L=0.04u
M20544 U5826/net32 g1476 U5826/net26 VSS nmos W=0.155u L=0.04u
M20545 U5826/net29 n5272 VSS VSS nmos W=0.155u L=0.04u
M20546 U5826/net26 n5294 U5826/net29 VSS nmos W=0.155u L=0.04u
M20547 U5826/net26 n5253 U5826/net29 VSS nmos W=0.155u L=0.04u
M20548 n5293 U5826/net32 VSS VSS nmos W=0.155u L=0.04u
M20549 n5293 U5826/net32 VDD VDD pmos W=0.205u L=0.04u
M20550 U5826/net32 g1476 U5826/net43 VDD pmos W=0.205u L=0.04u
M20551 U5826/net32 n5253 U5826/net49 VDD pmos W=0.205u L=0.04u
M20552 U5826/net49 n5294 VDD VDD pmos W=0.205u L=0.04u
M20553 U5826/net43 n5252 VDD VDD pmos W=0.205u L=0.04u
M20554 U5826/net32 n5272 VDD VDD pmos W=0.205u L=0.04u
M20555 U5827/net13 n5280 VSS VSS nmos W=0.155u L=0.04u
M20556 U5827/net16 U5827/net13 VSS VSS nmos W=0.155u L=0.04u
M20557 n5272 n5250 U5827/net16 VSS nmos W=0.155u L=0.04u
M20558 U5827/net13 n5280 VDD VDD pmos W=0.205u L=0.04u
M20559 VDD U5827/net13 n5272 VDD pmos W=0.205u L=0.04u
M20560 VDD n5250 n5272 VDD pmos W=0.205u L=0.04u
M20561 U5828/net4 n5295 U5828/net14 VSS nmos W=0.155u L=0.04u
M20562 U5828/net6 U5828/net10 U5828/net14 VSS nmos W=0.17u L=0.04u
M20563 U5828/net4 n5296 VSS VSS nmos W=0.155u L=0.04u
M20564 U5828/net6 U5828/net4 VSS VSS nmos W=0.17u L=0.04u
M20565 n5294 U5828/net14 VSS VSS nmos W=0.155u L=0.04u
M20566 U5828/net10 n5295 VSS VSS nmos W=0.155u L=0.04u
M20567 U5828/net4 U5828/net10 U5828/net14 VDD pmos W=0.255u L=0.04u
M20568 U5828/net6 n5295 U5828/net14 VDD pmos W=0.28u L=0.04u
M20569 U5828/net4 n5296 VDD VDD pmos W=0.205u L=0.04u
M20570 U5828/net6 U5828/net4 VDD VDD pmos W=0.24u L=0.04u
M20571 n5294 U5828/net14 VDD VDD pmos W=0.205u L=0.04u
M20572 U5828/net10 n5295 VDD VDD pmos W=0.205u L=0.04u
M20573 n5295 U5829/net6 VSS VSS nmos W=0.155u L=0.04u
M20574 U5829/X_u2-net6 n5298 VSS VSS nmos W=0.155u L=0.04u
M20575 U5829/net6 n5297 U5829/X_u2-net6 VSS nmos W=0.155u L=0.04u
M20576 n5295 U5829/net6 VDD VDD pmos W=0.205u L=0.04u
M20577 U5829/net6 n5298 VDD VDD pmos W=0.205u L=0.04u
M20578 U5829/net6 n5297 VDD VDD pmos W=0.205u L=0.04u
M20579 n2932 n4334 U5830/net10 VSS nmos W=0.155u L=0.04u
M20580 U5830/net10 n5300 VSS VSS nmos W=0.155u L=0.04u
M20581 n2932 n5299 U5830/net10 VSS nmos W=0.155u L=0.04u
M20582 U5830/net10 g1704 VSS VSS nmos W=0.155u L=0.04u
M20583 U5830/net30 n5300 VDD VDD pmos W=0.205u L=0.04u
M20584 n2932 n4334 U5830/net24 VDD pmos W=0.205u L=0.04u
M20585 U5830/net24 n5299 VDD VDD pmos W=0.205u L=0.04u
M20586 n2932 g1704 U5830/net30 VDD pmos W=0.205u L=0.04u
M20587 n5300 n4334 VSS VSS nmos W=0.155u L=0.04u
M20588 n5300 n5301 VSS VSS nmos W=0.155u L=0.04u
M20589 U5831/XI1-net8 n5301 VDD VDD pmos W=0.205u L=0.04u
M20590 n5300 n4334 U5831/XI1-net8 VDD pmos W=0.205u L=0.04u
M20591 n2931 n5191 U5832/net10 VSS nmos W=0.155u L=0.04u
M20592 U5832/net10 n5302 VSS VSS nmos W=0.155u L=0.04u
M20593 n2931 n5299 U5832/net10 VSS nmos W=0.155u L=0.04u
M20594 U5832/net10 g1703 VSS VSS nmos W=0.155u L=0.04u
M20595 U5832/net30 n5302 VDD VDD pmos W=0.205u L=0.04u
M20596 n2931 n5191 U5832/net24 VDD pmos W=0.205u L=0.04u
M20597 U5832/net24 n5299 VDD VDD pmos W=0.205u L=0.04u
M20598 n2931 g1703 U5832/net30 VDD pmos W=0.205u L=0.04u
M20599 n5302 n5191 VSS VSS nmos W=0.155u L=0.04u
M20600 n5302 n5301 VSS VSS nmos W=0.155u L=0.04u
M20601 U5833/XI1-net8 n5301 VDD VDD pmos W=0.205u L=0.04u
M20602 n5302 n5191 U5833/XI1-net8 VDD pmos W=0.205u L=0.04u
M20603 n2930 n5192 U5834/net10 VSS nmos W=0.155u L=0.04u
M20604 U5834/net10 n5303 VSS VSS nmos W=0.155u L=0.04u
M20605 n2930 n5299 U5834/net10 VSS nmos W=0.155u L=0.04u
M20606 U5834/net10 g1702 VSS VSS nmos W=0.155u L=0.04u
M20607 U5834/net30 n5303 VDD VDD pmos W=0.205u L=0.04u
M20608 n2930 n5192 U5834/net24 VDD pmos W=0.205u L=0.04u
M20609 U5834/net24 n5299 VDD VDD pmos W=0.205u L=0.04u
M20610 n2930 g1702 U5834/net30 VDD pmos W=0.205u L=0.04u
M20611 n5303 n5192 VSS VSS nmos W=0.155u L=0.04u
M20612 n5303 n5301 VSS VSS nmos W=0.155u L=0.04u
M20613 U5835/XI1-net8 n5301 VDD VDD pmos W=0.205u L=0.04u
M20614 n5303 n5192 U5835/XI1-net8 VDD pmos W=0.205u L=0.04u
M20615 n5299 U5836/net7 VSS VSS nmos W=0.155u L=0.04u
M20616 U5836/net7 n5304 VSS VSS nmos W=0.155u L=0.04u
M20617 U5836/net7 n5301 VSS VSS nmos W=0.155u L=0.04u
M20618 n5299 U5836/net7 VDD VDD pmos W=0.205u L=0.04u
M20619 U5836/X_u7-net8 n5301 VDD VDD pmos W=0.205u L=0.04u
M20620 U5836/net7 n5304 U5836/X_u7-net8 VDD pmos W=0.205u L=0.04u
M20621 n5301 U5837/net28 VSS VSS nmos W=0.155u L=0.04u
M20622 U5837/net47 n5305 VSS VSS nmos W=0.155u L=0.04u
M20623 U5837/net28 U5837/net6 U5837/net47 VSS nmos W=0.155u L=0.04u
M20624 U5837/net44 n5200 VSS VSS nmos W=0.155u L=0.04u
M20625 U5837/net28 n4065 U5837/net44 VSS nmos W=0.155u L=0.04u
M20626 U5837/net6 n4065 VSS VSS nmos W=0.155u L=0.04u
M20627 n5301 U5837/net28 VDD VDD pmos W=0.205u L=0.04u
M20628 VDD n5305 U5837/net47 VDD pmos W=0.205u L=0.04u
M20629 U5837/net47 n4065 U5837/net28 VDD pmos W=0.205u L=0.04u
M20630 U5837/net44 U5837/net6 U5837/net28 VDD pmos W=0.205u L=0.04u
M20631 VDD n5200 U5837/net44 VDD pmos W=0.205u L=0.04u
M20632 VDD n4065 U5837/net6 VDD pmos W=0.205u L=0.04u
M20633 n5304 n5306 U5838/net23 VDD pmos W=0.205u L=0.04u
M20634 n5304 n5307 U5838/net23 VDD pmos W=0.205u L=0.04u
M20635 n5304 n5249 U5838/net23 VDD pmos W=0.205u L=0.04u
M20636 U5838/net23 n5243 VDD VDD pmos W=0.205u L=0.04u
M20637 U5838/net23 n4065 VDD VDD pmos W=0.205u L=0.04u
M20638 U5838/XI20-net13 n5307 VSS VSS nmos W=0.155u L=0.04u
M20639 n5304 n5306 U5838/XI20-net17 VSS nmos W=0.155u L=0.04u
M20640 U5838/XI20-net17 n5249 U5838/XI20-net13 VSS nmos W=0.155u L=0.04u
M20641 n5304 n5243 U5838/XI17-net17 VSS nmos W=0.155u L=0.04u
M20642 U5838/XI17-net17 n4065 VSS VSS nmos W=0.155u L=0.04u
M20643 U5839/net19 n5191 VSS VSS nmos W=0.155u L=0.04u
M20644 n2929 n5191 U5839/net40 VSS nmos W=0.155u L=0.04u
M20645 n2929 U5839/net19 U5839/net36 VSS nmos W=0.155u L=0.04u
M20646 U5839/net40 g1699 VSS VSS nmos W=0.31u L=0.04u
M20647 U5839/net36 n5308 VSS VSS nmos W=0.155u L=0.04u
M20648 U5839/net19 n5191 VDD VDD pmos W=0.205u L=0.04u
M20649 n2929 U5839/net19 U5839/net26 VDD pmos W=0.325u L=0.04u
M20650 U5839/net26 g1699 VDD VDD pmos W=0.41u L=0.04u
M20651 n2929 n5191 U5839/net30 VDD pmos W=0.325u L=0.04u
M20652 U5839/net30 n5308 VDD VDD pmos W=0.205u L=0.04u
M20653 U5840/net19 n4334 VSS VSS nmos W=0.155u L=0.04u
M20654 n2928 n4334 U5840/net40 VSS nmos W=0.155u L=0.04u
M20655 n2928 U5840/net19 U5840/net36 VSS nmos W=0.155u L=0.04u
M20656 U5840/net40 g1700 VSS VSS nmos W=0.31u L=0.04u
M20657 U5840/net36 n5308 VSS VSS nmos W=0.155u L=0.04u
M20658 U5840/net19 n4334 VDD VDD pmos W=0.205u L=0.04u
M20659 n2928 U5840/net19 U5840/net26 VDD pmos W=0.325u L=0.04u
M20660 U5840/net26 g1700 VDD VDD pmos W=0.41u L=0.04u
M20661 n2928 n4334 U5840/net30 VDD pmos W=0.325u L=0.04u
M20662 U5840/net30 n5308 VDD VDD pmos W=0.205u L=0.04u
M20663 U5841/net19 n5192 VSS VSS nmos W=0.155u L=0.04u
M20664 n2927 n5192 U5841/net40 VSS nmos W=0.155u L=0.04u
M20665 n2927 U5841/net19 U5841/net36 VSS nmos W=0.155u L=0.04u
M20666 U5841/net40 g1701 VSS VSS nmos W=0.31u L=0.04u
M20667 U5841/net36 n5308 VSS VSS nmos W=0.155u L=0.04u
M20668 U5841/net19 n5192 VDD VDD pmos W=0.205u L=0.04u
M20669 n2927 U5841/net19 U5841/net26 VDD pmos W=0.325u L=0.04u
M20670 U5841/net26 g1701 VDD VDD pmos W=0.41u L=0.04u
M20671 n2927 n5192 U5841/net30 VDD pmos W=0.325u L=0.04u
M20672 U5841/net30 n5308 VDD VDD pmos W=0.205u L=0.04u
M20673 n5308 U5842/net6 VSS VSS nmos W=0.155u L=0.04u
M20674 U5842/X_u2-net6 n5246 VSS VSS nmos W=0.155u L=0.04u
M20675 U5842/net6 n5309 U5842/X_u2-net6 VSS nmos W=0.155u L=0.04u
M20676 n5308 U5842/net6 VDD VDD pmos W=0.205u L=0.04u
M20677 U5842/net6 n5246 VDD VDD pmos W=0.205u L=0.04u
M20678 U5842/net6 n5309 VDD VDD pmos W=0.205u L=0.04u
M20679 U5843/net4 n5310 U5843/net14 VSS nmos W=0.155u L=0.04u
M20680 U5843/net6 U5843/net10 U5843/net14 VSS nmos W=0.17u L=0.04u
M20681 U5843/net4 n5307 VSS VSS nmos W=0.155u L=0.04u
M20682 U5843/net6 U5843/net4 VSS VSS nmos W=0.17u L=0.04u
M20683 n5309 U5843/net14 VSS VSS nmos W=0.155u L=0.04u
M20684 U5843/net10 n5310 VSS VSS nmos W=0.155u L=0.04u
M20685 U5843/net4 U5843/net10 U5843/net14 VDD pmos W=0.255u L=0.04u
M20686 U5843/net6 n5310 U5843/net14 VDD pmos W=0.28u L=0.04u
M20687 U5843/net4 n5307 VDD VDD pmos W=0.205u L=0.04u
M20688 U5843/net6 U5843/net4 VDD VDD pmos W=0.24u L=0.04u
M20689 n5309 U5843/net14 VDD VDD pmos W=0.205u L=0.04u
M20690 U5843/net10 n5310 VDD VDD pmos W=0.205u L=0.04u
M20691 n5310 n5311 U5844/net23 VDD pmos W=0.205u L=0.04u
M20692 n5310 n5312 U5844/net23 VDD pmos W=0.205u L=0.04u
M20693 n5310 n5249 U5844/net23 VDD pmos W=0.205u L=0.04u
M20694 U5844/net23 n5307 VDD VDD pmos W=0.205u L=0.04u
M20695 U5844/net23 n5313 VDD VDD pmos W=0.205u L=0.04u
M20696 U5844/XI20-net13 n5312 VSS VSS nmos W=0.155u L=0.04u
M20697 n5310 n5311 U5844/XI20-net17 VSS nmos W=0.155u L=0.04u
M20698 U5844/XI20-net17 n5249 U5844/XI20-net13 VSS nmos W=0.155u L=0.04u
M20699 n5310 n5307 U5844/XI17-net17 VSS nmos W=0.155u L=0.04u
M20700 U5844/XI17-net17 n5313 VSS VSS nmos W=0.155u L=0.04u
M20701 VSS n5249 U5845/net22 VSS nmos W=0.155u L=0.04u
M20702 U5845/net22 n5200 n5313 VSS nmos W=0.155u L=0.04u
M20703 U5845/net22 n5314 n5313 VSS nmos W=0.155u L=0.04u
M20704 U5845/net22 n5247 n5313 VSS nmos W=0.155u L=0.04u
M20705 U5845/net38 n5247 VDD VDD pmos W=0.205u L=0.04u
M20706 U5845/net35 n5314 U5845/net38 VDD pmos W=0.205u L=0.04u
M20707 n5313 n5200 U5845/net35 VDD pmos W=0.205u L=0.04u
M20708 n5313 n5249 VDD VDD pmos W=0.205u L=0.04u
M20709 n5200 g1690 VSS VSS nmos W=0.135u L=0.04u
M20710 n5200 g1690 VDD VDD pmos W=0.205u L=0.04u
M20711 n5312 n5305 U5847/net27 VSS nmos W=0.155u L=0.04u
M20712 U5847/net27 n5315 VSS VSS nmos W=0.155u L=0.04u
M20713 n5312 n5316 VSS VSS nmos W=0.155u L=0.04u
M20714 n5312 n5315 U5847/net13 VDD pmos W=0.205u L=0.04u
M20715 U5847/net13 n5316 VDD VDD pmos W=0.205u L=0.04u
M20716 n5312 n5305 U5847/net13 VDD pmos W=0.205u L=0.04u
M20717 U5848/net19 n5191 VSS VSS nmos W=0.155u L=0.04u
M20718 n2926 n5191 U5848/net40 VSS nmos W=0.155u L=0.04u
M20719 n2926 U5848/net19 U5848/net36 VSS nmos W=0.155u L=0.04u
M20720 U5848/net40 g1696 VSS VSS nmos W=0.31u L=0.04u
M20721 U5848/net36 n5317 VSS VSS nmos W=0.155u L=0.04u
M20722 U5848/net19 n5191 VDD VDD pmos W=0.205u L=0.04u
M20723 n2926 U5848/net19 U5848/net26 VDD pmos W=0.325u L=0.04u
M20724 U5848/net26 g1696 VDD VDD pmos W=0.41u L=0.04u
M20725 n2926 n5191 U5848/net30 VDD pmos W=0.325u L=0.04u
M20726 U5848/net30 n5317 VDD VDD pmos W=0.205u L=0.04u
M20727 U5849/net19 n4334 VSS VSS nmos W=0.155u L=0.04u
M20728 n2925 n4334 U5849/net40 VSS nmos W=0.155u L=0.04u
M20729 n2925 U5849/net19 U5849/net36 VSS nmos W=0.155u L=0.04u
M20730 U5849/net40 g1697 VSS VSS nmos W=0.31u L=0.04u
M20731 U5849/net36 n5317 VSS VSS nmos W=0.155u L=0.04u
M20732 U5849/net19 n4334 VDD VDD pmos W=0.205u L=0.04u
M20733 n2925 U5849/net19 U5849/net26 VDD pmos W=0.325u L=0.04u
M20734 U5849/net26 g1697 VDD VDD pmos W=0.41u L=0.04u
M20735 n2925 n4334 U5849/net30 VDD pmos W=0.325u L=0.04u
M20736 U5849/net30 n5317 VDD VDD pmos W=0.205u L=0.04u
M20737 U5850/net19 n5192 VSS VSS nmos W=0.155u L=0.04u
M20738 n2924 n5192 U5850/net40 VSS nmos W=0.155u L=0.04u
M20739 n2924 U5850/net19 U5850/net36 VSS nmos W=0.155u L=0.04u
M20740 U5850/net40 g1698 VSS VSS nmos W=0.31u L=0.04u
M20741 U5850/net36 n5317 VSS VSS nmos W=0.155u L=0.04u
M20742 U5850/net19 n5192 VDD VDD pmos W=0.205u L=0.04u
M20743 n2924 U5850/net19 U5850/net26 VDD pmos W=0.325u L=0.04u
M20744 U5850/net26 g1698 VDD VDD pmos W=0.41u L=0.04u
M20745 n2924 n5192 U5850/net30 VDD pmos W=0.325u L=0.04u
M20746 U5850/net30 n5317 VDD VDD pmos W=0.205u L=0.04u
M20747 n5317 U5851/net6 VSS VSS nmos W=0.155u L=0.04u
M20748 U5851/X_u2-net6 n5246 VSS VSS nmos W=0.155u L=0.04u
M20749 U5851/net6 n5318 U5851/X_u2-net6 VSS nmos W=0.155u L=0.04u
M20750 n5317 U5851/net6 VDD VDD pmos W=0.205u L=0.04u
M20751 U5851/net6 n5246 VDD VDD pmos W=0.205u L=0.04u
M20752 U5851/net6 n5318 VDD VDD pmos W=0.205u L=0.04u
M20753 U5852/net4 n5319 U5852/net14 VSS nmos W=0.155u L=0.04u
M20754 U5852/net6 U5852/net10 U5852/net14 VSS nmos W=0.17u L=0.04u
M20755 U5852/net4 n5314 VSS VSS nmos W=0.155u L=0.04u
M20756 U5852/net6 U5852/net4 VSS VSS nmos W=0.17u L=0.04u
M20757 n5318 U5852/net14 VSS VSS nmos W=0.155u L=0.04u
M20758 U5852/net10 n5319 VSS VSS nmos W=0.155u L=0.04u
M20759 U5852/net4 U5852/net10 U5852/net14 VDD pmos W=0.255u L=0.04u
M20760 U5852/net6 n5319 U5852/net14 VDD pmos W=0.28u L=0.04u
M20761 U5852/net4 n5314 VDD VDD pmos W=0.205u L=0.04u
M20762 U5852/net6 U5852/net4 VDD VDD pmos W=0.24u L=0.04u
M20763 n5318 U5852/net14 VDD VDD pmos W=0.205u L=0.04u
M20764 U5852/net10 n5319 VDD VDD pmos W=0.205u L=0.04u
M20765 n5319 n5320 VSS VSS nmos W=0.155u L=0.04u
M20766 n5319 n5321 VSS VSS nmos W=0.155u L=0.04u
M20767 U5853/XI1-net8 n5321 VDD VDD pmos W=0.205u L=0.04u
M20768 n5319 n5320 U5853/XI1-net8 VDD pmos W=0.205u L=0.04u
M20769 U5854/PG2 n5307 VSS VSS nmos W=0.31u L=0.04u
M20770 U5854/net55 n5323 VSS VSS nmos W=0.31u L=0.04u
M20771 U5854/net51 n5314 VSS VSS nmos W=0.155u L=0.04u
M20772 U5854/net53 n5322 VSS VSS nmos W=0.155u L=0.04u
M20773 U5854/net29 n5324 VSS VSS nmos W=0.155u L=0.04u
M20774 U5854/net53 U5854/net51 U5854/PG1 VSS nmos W=0.155u L=0.04u
M20775 U5854/net55 n5314 U5854/PG1 VSS nmos W=0.21u L=0.04u
M20776 U5854/PG2 n5324 n5321 VSS nmos W=0.22u L=0.04u
M20777 U5854/PG1 U5854/net29 n5321 VSS nmos W=0.155u L=0.04u
M20778 U5854/PG2 n5307 VDD VDD pmos W=0.41u L=0.04u
M20779 U5854/net55 n5323 VDD VDD pmos W=0.41u L=0.04u
M20780 U5854/net51 n5314 VDD VDD pmos W=0.205u L=0.04u
M20781 U5854/net53 n5322 VDD VDD pmos W=0.28u L=0.04u
M20782 U5854/net29 n5324 VDD VDD pmos W=0.205u L=0.04u
M20783 U5854/net53 n5314 U5854/PG1 VDD pmos W=0.27u L=0.04u
M20784 U5854/net55 U5854/net51 U5854/PG1 VDD pmos W=0.285u L=0.04u
M20785 U5854/PG2 U5854/net29 n5321 VDD pmos W=0.205u L=0.04u
M20786 U5854/PG1 n5324 n5321 VDD pmos W=0.28u L=0.04u
M20787 VSS n5326 U5855/net22 VSS nmos W=0.155u L=0.04u
M20788 U5855/net22 n5315 n5323 VSS nmos W=0.155u L=0.04u
M20789 U5855/net22 n5325 n5323 VSS nmos W=0.155u L=0.04u
M20790 U5855/net22 n5305 n5323 VSS nmos W=0.155u L=0.04u
M20791 U5855/net38 n5305 VDD VDD pmos W=0.205u L=0.04u
M20792 U5855/net35 n5325 U5855/net38 VDD pmos W=0.205u L=0.04u
M20793 n5323 n5315 U5855/net35 VDD pmos W=0.205u L=0.04u
M20794 n5323 n5326 VDD VDD pmos W=0.205u L=0.04u
M20795 U5856/XU1-net6 n5328 VSS VSS nmos W=0.155u L=0.04u
M20796 n5305 n5327 U5856/XU1-net6 VSS nmos W=0.155u L=0.04u
M20797 n5305 n5328 VDD VDD pmos W=0.155u L=0.04u
M20798 n5305 n5327 VDD VDD pmos W=0.155u L=0.04u
M20799 n5322 n5315 U5857/net23 VDD pmos W=0.205u L=0.04u
M20800 n5322 n5329 U5857/net23 VDD pmos W=0.205u L=0.04u
M20801 n5322 n5216 U5857/net23 VDD pmos W=0.205u L=0.04u
M20802 U5857/net23 n5330 VDD VDD pmos W=0.205u L=0.04u
M20803 U5857/net23 n5331 VDD VDD pmos W=0.205u L=0.04u
M20804 U5857/XI20-net13 n5329 VSS VSS nmos W=0.155u L=0.04u
M20805 n5322 n5315 U5857/XI20-net17 VSS nmos W=0.155u L=0.04u
M20806 U5857/XI20-net17 n5216 U5857/XI20-net13 VSS nmos W=0.155u L=0.04u
M20807 n5322 n5330 U5857/XI17-net17 VSS nmos W=0.155u L=0.04u
M20808 U5857/XI17-net17 n5331 VSS VSS nmos W=0.155u L=0.04u
M20809 n5331 n5311 VSS VSS nmos W=0.135u L=0.04u
M20810 n5331 n5311 VDD VDD pmos W=0.205u L=0.04u
M20811 U5859/net36 n5216 U5859/net24 VSS nmos W=0.155u L=0.04u
M20812 U5859/net24 n5307 VSS VSS nmos W=0.155u L=0.04u
M20813 n5311 n5332 U5859/net36 VSS nmos W=0.155u L=0.04u
M20814 n5311 n5328 U5859/net36 VSS nmos W=0.155u L=0.04u
M20815 n5311 n5328 U5859/net35 VDD pmos W=0.205u L=0.04u
M20816 U5859/net35 n5332 VDD VDD pmos W=0.205u L=0.04u
M20817 n5311 n5307 VDD VDD pmos W=0.205u L=0.04u
M20818 n5311 n5216 VDD VDD pmos W=0.205u L=0.04u
M20819 U5860/p2 n5336 VSS VSS nmos W=0.155u L=0.04u
M20820 U5860/p0 n5334 U5860/p1 VSS nmos W=0.155u L=0.04u
M20821 U5860/p1 n5335 U5860/p2 VSS nmos W=0.155u L=0.04u
M20822 n5328 n5333 U5860/p0 VSS nmos W=0.155u L=0.04u
M20823 n5328 n5335 VDD VDD pmos W=0.205u L=0.04u
M20824 n5328 n5334 VDD VDD pmos W=0.205u L=0.04u
M20825 n5328 n5333 VDD VDD pmos W=0.205u L=0.04u
M20826 n5328 n5336 VDD VDD pmos W=0.205u L=0.04u
M20827 U5861/net7 n5337 U5861/X_u4-net10 VSS nmos W=0.155u L=0.04u
M20828 U5861/X_u4-net10 n5338 U5861/X_u4-net13 VSS nmos W=0.155u L=0.04u
M20829 U5861/X_u4-net13 n5339 VSS VSS nmos W=0.155u L=0.04u
M20830 n5336 U5861/net7 VSS VSS nmos W=0.155u L=0.04u
M20831 U5861/net7 n5339 VDD VDD pmos W=0.205u L=0.04u
M20832 U5861/net7 n5337 VDD VDD pmos W=0.205u L=0.04u
M20833 U5861/net7 n5338 VDD VDD pmos W=0.205u L=0.04u
M20834 n5336 U5861/net7 VDD VDD pmos W=0.205u L=0.04u
M20835 n5330 n5306 U5862/net27 VSS nmos W=0.155u L=0.04u
M20836 U5862/net27 n5340 VSS VSS nmos W=0.155u L=0.04u
M20837 n5330 n5325 VSS VSS nmos W=0.155u L=0.04u
M20838 n5330 n5340 U5862/net13 VDD pmos W=0.205u L=0.04u
M20839 U5862/net13 n5325 VDD VDD pmos W=0.205u L=0.04u
M20840 n5330 n5306 U5862/net13 VDD pmos W=0.205u L=0.04u
M20841 n5325 n5341 VSS VSS nmos W=0.135u L=0.04u
M20842 n5325 n5341 VDD VDD pmos W=0.205u L=0.04u
M20843 n5216 n5224 VSS VSS nmos W=0.135u L=0.04u
M20844 n5216 n5224 VDD VDD pmos W=0.205u L=0.04u
M20845 U5865/net19 n5211 VSS VSS nmos W=0.155u L=0.04u
M20846 n2923 n5211 U5865/net40 VSS nmos W=0.155u L=0.04u
M20847 n2923 U5865/net19 U5865/net36 VSS nmos W=0.155u L=0.04u
M20848 U5865/net40 g1645 VSS VSS nmos W=0.31u L=0.04u
M20849 U5865/net36 n5342 VSS VSS nmos W=0.155u L=0.04u
M20850 U5865/net19 n5211 VDD VDD pmos W=0.205u L=0.04u
M20851 n2923 U5865/net19 U5865/net26 VDD pmos W=0.325u L=0.04u
M20852 U5865/net26 g1645 VDD VDD pmos W=0.41u L=0.04u
M20853 n2923 n5211 U5865/net30 VDD pmos W=0.325u L=0.04u
M20854 U5865/net30 n5342 VDD VDD pmos W=0.205u L=0.04u
M20855 U5866/net19 n5210 VSS VSS nmos W=0.155u L=0.04u
M20856 n2922 n5210 U5866/net40 VSS nmos W=0.155u L=0.04u
M20857 n2922 U5866/net19 U5866/net36 VSS nmos W=0.155u L=0.04u
M20858 U5866/net40 g1639 VSS VSS nmos W=0.31u L=0.04u
M20859 U5866/net36 n5342 VSS VSS nmos W=0.155u L=0.04u
M20860 U5866/net19 n5210 VDD VDD pmos W=0.205u L=0.04u
M20861 n2922 U5866/net19 U5866/net26 VDD pmos W=0.325u L=0.04u
M20862 U5866/net26 g1639 VDD VDD pmos W=0.41u L=0.04u
M20863 n2922 n5210 U5866/net30 VDD pmos W=0.325u L=0.04u
M20864 U5866/net30 n5342 VDD VDD pmos W=0.205u L=0.04u
M20865 U5867/net19 n5212 VSS VSS nmos W=0.155u L=0.04u
M20866 n2921 n5212 U5867/net40 VSS nmos W=0.155u L=0.04u
M20867 n2921 U5867/net19 U5867/net36 VSS nmos W=0.155u L=0.04u
M20868 U5867/net40 g1642 VSS VSS nmos W=0.31u L=0.04u
M20869 U5867/net36 n5342 VSS VSS nmos W=0.155u L=0.04u
M20870 U5867/net19 n5212 VDD VDD pmos W=0.205u L=0.04u
M20871 n2921 U5867/net19 U5867/net26 VDD pmos W=0.325u L=0.04u
M20872 U5867/net26 g1642 VDD VDD pmos W=0.41u L=0.04u
M20873 n2921 n5212 U5867/net30 VDD pmos W=0.325u L=0.04u
M20874 U5867/net30 n5342 VDD VDD pmos W=0.205u L=0.04u
M20875 n5342 n5237 U5868/net10 VSS nmos W=0.155u L=0.04u
M20876 U5868/net10 n5343 VSS VSS nmos W=0.155u L=0.04u
M20877 n5342 n5252 U5868/net10 VSS nmos W=0.155u L=0.04u
M20878 U5868/net10 n5253 VSS VSS nmos W=0.155u L=0.04u
M20879 U5868/net30 n5343 VDD VDD pmos W=0.205u L=0.04u
M20880 n5342 n5237 U5868/net24 VDD pmos W=0.205u L=0.04u
M20881 U5868/net24 n5252 VDD VDD pmos W=0.205u L=0.04u
M20882 n5342 n5253 U5868/net30 VDD pmos W=0.205u L=0.04u
M20883 U5869/net4 n5344 U5869/net14 VSS nmos W=0.155u L=0.04u
M20884 U5869/net6 U5869/net10 U5869/net14 VSS nmos W=0.17u L=0.04u
M20885 U5869/net4 n5345 VSS VSS nmos W=0.155u L=0.04u
M20886 U5869/net6 U5869/net4 VSS VSS nmos W=0.17u L=0.04u
M20887 n5343 U5869/net14 VSS VSS nmos W=0.155u L=0.04u
M20888 U5869/net10 n5344 VSS VSS nmos W=0.155u L=0.04u
M20889 U5869/net4 U5869/net10 U5869/net14 VDD pmos W=0.255u L=0.04u
M20890 U5869/net6 n5344 U5869/net14 VDD pmos W=0.28u L=0.04u
M20891 U5869/net4 n5345 VDD VDD pmos W=0.205u L=0.04u
M20892 U5869/net6 U5869/net4 VDD VDD pmos W=0.24u L=0.04u
M20893 n5343 U5869/net14 VDD VDD pmos W=0.205u L=0.04u
M20894 U5869/net10 n5344 VDD VDD pmos W=0.205u L=0.04u
M20895 n5344 n5346 U5870/net15 VSS nmos W=0.155u L=0.04u
M20896 n5344 n5347 U5870/net15 VSS nmos W=0.155u L=0.04u
M20897 U5870/net15 n5282 VSS VSS nmos W=0.155u L=0.04u
M20898 n5344 n5282 VDD VDD pmos W=0.205u L=0.04u
M20899 n5344 n5346 U5870/XI16-net11 VDD pmos W=0.205u L=0.04u
M20900 U5870/XI16-net11 n5347 VDD VDD pmos W=0.205u L=0.04u
M20901 n5282 n5346 U5871/net27 VSS nmos W=0.155u L=0.04u
M20902 U5871/net27 n5347 VSS VSS nmos W=0.155u L=0.04u
M20903 n5282 n5255 VSS VSS nmos W=0.155u L=0.04u
M20904 n5282 n5347 U5871/net13 VDD pmos W=0.205u L=0.04u
M20905 U5871/net13 n5255 VDD VDD pmos W=0.205u L=0.04u
M20906 n5282 n5346 U5871/net13 VDD pmos W=0.205u L=0.04u
M20907 n5255 n5262 U5872/XI0-net10 VSS nmos W=0.155u L=0.04u
M20908 U5872/XI0-net10 n5348 U5872/XI0-net13 VSS nmos W=0.155u L=0.04u
M20909 U5872/XI0-net13 n5261 VSS VSS nmos W=0.155u L=0.04u
M20910 n5255 n5261 VDD VDD pmos W=0.205u L=0.04u
M20911 n5255 n5262 VDD VDD pmos W=0.205u L=0.04u
M20912 n5255 n5348 VDD VDD pmos W=0.205u L=0.04u
M20913 n5261 n5289 VSS VSS nmos W=0.155u L=0.04u
M20914 n5261 U5873/net4 VSS VSS nmos W=0.155u L=0.04u
M20915 U5873/net4 n5349 VSS VSS nmos W=0.155u L=0.04u
M20916 U5873/XU1-net8 U5873/net4 VDD VDD pmos W=0.205u L=0.04u
M20917 n5261 n5289 U5873/XU1-net8 VDD pmos W=0.205u L=0.04u
M20918 U5873/net4 n5349 VDD VDD pmos W=0.205u L=0.04u
M20919 n5289 n5288 U5874/net15 VSS nmos W=0.155u L=0.04u
M20920 n5289 n5250 U5874/net15 VSS nmos W=0.155u L=0.04u
M20921 U5874/net15 n5292 VSS VSS nmos W=0.155u L=0.04u
M20922 n5289 n5292 VDD VDD pmos W=0.205u L=0.04u
M20923 n5289 n5288 U5874/XI16-net11 VDD pmos W=0.205u L=0.04u
M20924 U5874/XI16-net11 n5250 VDD VDD pmos W=0.205u L=0.04u
M20925 U5875/net7 n5350 U5875/X_u4-net10 VSS nmos W=0.155u L=0.04u
M20926 U5875/X_u4-net10 n5298 U5875/X_u4-net13 VSS nmos W=0.155u L=0.04u
M20927 U5875/X_u4-net13 n5297 VSS VSS nmos W=0.155u L=0.04u
M20928 n5292 U5875/net7 VSS VSS nmos W=0.155u L=0.04u
M20929 U5875/net7 n5297 VDD VDD pmos W=0.205u L=0.04u
M20930 U5875/net7 n5350 VDD VDD pmos W=0.205u L=0.04u
M20931 U5875/net7 n5298 VDD VDD pmos W=0.205u L=0.04u
M20932 n5292 U5875/net7 VDD VDD pmos W=0.205u L=0.04u
M20933 U5876/net4 n5347 U5876/net14 VSS nmos W=0.155u L=0.04u
M20934 U5876/net6 U5876/net10 U5876/net14 VSS nmos W=0.17u L=0.04u
M20935 U5876/net4 n5269 VSS VSS nmos W=0.155u L=0.04u
M20936 U5876/net6 U5876/net4 VSS VSS nmos W=0.17u L=0.04u
M20937 n5297 U5876/net14 VSS VSS nmos W=0.155u L=0.04u
M20938 U5876/net10 n5347 VSS VSS nmos W=0.155u L=0.04u
M20939 U5876/net4 U5876/net10 U5876/net14 VDD pmos W=0.255u L=0.04u
M20940 U5876/net6 n5347 U5876/net14 VDD pmos W=0.28u L=0.04u
M20941 U5876/net4 n5269 VDD VDD pmos W=0.205u L=0.04u
M20942 U5876/net6 U5876/net4 VDD VDD pmos W=0.24u L=0.04u
M20943 n5297 U5876/net14 VDD VDD pmos W=0.205u L=0.04u
M20944 U5876/net10 n5347 VDD VDD pmos W=0.205u L=0.04u
M20945 U5877/net4 n5250 U5877/net14 VSS nmos W=0.155u L=0.04u
M20946 U5877/net6 U5877/net10 U5877/net14 VSS nmos W=0.17u L=0.04u
M20947 U5877/net4 n5351 VSS VSS nmos W=0.155u L=0.04u
M20948 U5877/net6 U5877/net4 VSS VSS nmos W=0.17u L=0.04u
M20949 n5350 U5877/net14 VSS VSS nmos W=0.155u L=0.04u
M20950 U5877/net10 n5250 VSS VSS nmos W=0.155u L=0.04u
M20951 U5877/net4 U5877/net10 U5877/net14 VDD pmos W=0.255u L=0.04u
M20952 U5877/net6 n5250 U5877/net14 VDD pmos W=0.28u L=0.04u
M20953 U5877/net4 n5351 VDD VDD pmos W=0.205u L=0.04u
M20954 U5877/net6 U5877/net4 VDD VDD pmos W=0.24u L=0.04u
M20955 n5350 U5877/net14 VDD VDD pmos W=0.205u L=0.04u
M20956 U5877/net10 n5250 VDD VDD pmos W=0.205u L=0.04u
M20957 U5878/net19 n5352 VSS VSS nmos W=0.155u L=0.04u
M20958 n5349 n5352 U5878/net40 VSS nmos W=0.155u L=0.04u
M20959 n5349 U5878/net19 U5878/net36 VSS nmos W=0.155u L=0.04u
M20960 U5878/net40 n5288 VSS VSS nmos W=0.31u L=0.04u
M20961 U5878/net36 n5250 VSS VSS nmos W=0.155u L=0.04u
M20962 U5878/net19 n5352 VDD VDD pmos W=0.205u L=0.04u
M20963 n5349 U5878/net19 U5878/net26 VDD pmos W=0.325u L=0.04u
M20964 U5878/net26 n5288 VDD VDD pmos W=0.41u L=0.04u
M20965 n5349 n5352 U5878/net30 VDD pmos W=0.325u L=0.04u
M20966 U5878/net30 n5250 VDD VDD pmos W=0.205u L=0.04u
M20967 U5879/net4 n5250 U5879/net14 VSS nmos W=0.155u L=0.04u
M20968 U5879/net6 U5879/net10 U5879/net14 VSS nmos W=0.17u L=0.04u
M20969 U5879/net4 n5353 VSS VSS nmos W=0.155u L=0.04u
M20970 U5879/net6 U5879/net4 VSS VSS nmos W=0.17u L=0.04u
M20971 n5348 U5879/net14 VSS VSS nmos W=0.155u L=0.04u
M20972 U5879/net10 n5250 VSS VSS nmos W=0.155u L=0.04u
M20973 U5879/net4 U5879/net10 U5879/net14 VDD pmos W=0.255u L=0.04u
M20974 U5879/net6 n5250 U5879/net14 VDD pmos W=0.28u L=0.04u
M20975 U5879/net4 n5353 VDD VDD pmos W=0.205u L=0.04u
M20976 U5879/net6 U5879/net4 VDD VDD pmos W=0.24u L=0.04u
M20977 n5348 U5879/net14 VDD VDD pmos W=0.205u L=0.04u
M20978 U5879/net10 n5250 VDD VDD pmos W=0.205u L=0.04u
M20979 U5880/net4 n5250 U5880/net14 VSS nmos W=0.155u L=0.04u
M20980 U5880/net6 U5880/net10 U5880/net14 VSS nmos W=0.17u L=0.04u
M20981 U5880/net4 n5265 VSS VSS nmos W=0.155u L=0.04u
M20982 U5880/net6 U5880/net4 VSS VSS nmos W=0.17u L=0.04u
M20983 n5262 U5880/net14 VSS VSS nmos W=0.155u L=0.04u
M20984 U5880/net10 n5250 VSS VSS nmos W=0.155u L=0.04u
M20985 U5880/net4 U5880/net10 U5880/net14 VDD pmos W=0.255u L=0.04u
M20986 U5880/net6 n5250 U5880/net14 VDD pmos W=0.28u L=0.04u
M20987 U5880/net4 n5265 VDD VDD pmos W=0.205u L=0.04u
M20988 U5880/net6 U5880/net4 VDD VDD pmos W=0.24u L=0.04u
M20989 n5262 U5880/net14 VDD VDD pmos W=0.205u L=0.04u
M20990 U5880/net10 n5250 VDD VDD pmos W=0.205u L=0.04u
M20991 U5881/XU1-net6 n5280 VSS VSS nmos W=0.155u L=0.04u
M20992 n5252 n5253 U5881/XU1-net6 VSS nmos W=0.155u L=0.04u
M20993 n5252 n5280 VDD VDD pmos W=0.155u L=0.04u
M20994 n5252 n5253 VDD VDD pmos W=0.155u L=0.04u
M20995 U5882/net36 n5298 U5882/net24 VSS nmos W=0.155u L=0.04u
M20996 U5882/net24 n5356 VSS VSS nmos W=0.155u L=0.04u
M20997 n5280 n5354 U5882/net36 VSS nmos W=0.155u L=0.04u
M20998 n5280 n5355 U5882/net36 VSS nmos W=0.155u L=0.04u
M20999 n5280 n5355 U5882/net35 VDD pmos W=0.205u L=0.04u
M21000 U5882/net35 n5354 VDD VDD pmos W=0.205u L=0.04u
M21001 n5280 n5356 VDD VDD pmos W=0.205u L=0.04u
M21002 n5280 n5298 VDD VDD pmos W=0.205u L=0.04u
M21003 n5298 n5268 VSS VSS nmos W=0.135u L=0.04u
M21004 n5298 n5268 VDD VDD pmos W=0.205u L=0.04u
M21005 n5253 n5268 U5884/net15 VSS nmos W=0.155u L=0.04u
M21006 n5253 n5357 U5884/net15 VSS nmos W=0.155u L=0.04u
M21007 U5884/net15 n5356 VSS VSS nmos W=0.155u L=0.04u
M21008 n5253 n5356 VDD VDD pmos W=0.205u L=0.04u
M21009 n5253 n5268 U5884/XI16-net11 VDD pmos W=0.205u L=0.04u
M21010 U5884/XI16-net11 n5357 VDD VDD pmos W=0.205u L=0.04u
M21011 U5885/net32 n5358 U5885/net26 VSS nmos W=0.155u L=0.04u
M21012 U5885/net32 n5324 U5885/net26 VSS nmos W=0.155u L=0.04u
M21013 U5885/net29 n5246 VSS VSS nmos W=0.155u L=0.04u
M21014 U5885/net26 n5329 U5885/net29 VSS nmos W=0.155u L=0.04u
M21015 U5885/net26 n5248 U5885/net29 VSS nmos W=0.155u L=0.04u
M21016 n5356 U5885/net32 VSS VSS nmos W=0.155u L=0.04u
M21017 n5356 U5885/net32 VDD VDD pmos W=0.205u L=0.04u
M21018 U5885/net32 n5324 U5885/net43 VDD pmos W=0.205u L=0.04u
M21019 U5885/net32 n5248 U5885/net49 VDD pmos W=0.205u L=0.04u
M21020 U5885/net49 n5329 VDD VDD pmos W=0.205u L=0.04u
M21021 U5885/net43 n5358 VDD VDD pmos W=0.205u L=0.04u
M21022 U5885/net32 n5246 VDD VDD pmos W=0.205u L=0.04u
M21023 U5886/XU1-net6 n5242 VSS VSS nmos W=0.155u L=0.04u
M21024 n5246 n5243 U5886/XU1-net6 VSS nmos W=0.155u L=0.04u
M21025 n5246 n5242 VDD VDD pmos W=0.155u L=0.04u
M21026 n5246 n5243 VDD VDD pmos W=0.155u L=0.04u
M21027 n5242 n5191 U5887/net27 VSS nmos W=0.155u L=0.04u
M21028 U5887/net39 n4334 VSS VSS nmos W=0.155u L=0.04u
M21029 U5887/net27 g1783 U5887/net39 VSS nmos W=0.155u L=0.04u
M21030 U5887/net27 n5192 U5887/net39 VSS nmos W=0.155u L=0.04u
M21031 n5242 g1784 U5887/net27 VSS nmos W=0.155u L=0.04u
M21032 U5887/net39 g1785 VSS VSS nmos W=0.155u L=0.04u
M21033 n5242 n4334 U5887/net46 VDD pmos W=0.205u L=0.04u
M21034 U5887/net46 g1785 VDD VDD pmos W=0.205u L=0.04u
M21035 n5242 g1784 U5887/net34 VDD pmos W=0.205u L=0.04u
M21036 U5887/net34 n5191 VDD VDD pmos W=0.205u L=0.04u
M21037 n5242 n5192 U5887/net37 VDD pmos W=0.205u L=0.04u
M21038 U5887/net37 g1783 VDD VDD pmos W=0.205u L=0.04u
M21039 n5248 n4065 VSS VSS nmos W=0.135u L=0.04u
M21040 n5248 n4065 VDD VDD pmos W=0.205u L=0.04u
M21041 n4065 n5314 VSS VSS nmos W=0.155u L=0.04u
M21042 n4065 n5307 VSS VSS nmos W=0.155u L=0.04u
M21043 n4065 n5324 VSS VSS nmos W=0.155u L=0.04u
M21044 U5889/net25 n5314 VDD VDD pmos W=0.41u L=0.04u
M21045 U5889/net28 n5307 U5889/net25 VDD pmos W=0.41u L=0.04u
M21046 n4065 n5324 U5889/net28 VDD pmos W=0.41u L=0.04u
M21047 U5890/XU1-net6 n5340 VSS VSS nmos W=0.155u L=0.04u
M21048 n5329 n5243 U5890/XU1-net6 VSS nmos W=0.155u L=0.04u
M21049 n5329 n5340 VDD VDD pmos W=0.155u L=0.04u
M21050 n5329 n5243 VDD VDD pmos W=0.155u L=0.04u
M21051 n5243 n5359 VSS VSS nmos W=0.135u L=0.04u
M21052 n5243 n5359 VDD VDD pmos W=0.205u L=0.04u
M21053 n5358 n5316 U5892/net19 VDD pmos W=0.205u L=0.04u
M21054 n5358 n5306 U5892/net19 VDD pmos W=0.205u L=0.04u
M21055 n5358 n5340 U5892/net19 VDD pmos W=0.205u L=0.04u
M21056 U5892/net19 n5224 VDD VDD pmos W=0.205u L=0.04u
M21057 n5358 n5224 VSS VSS nmos W=0.155u L=0.04u
M21058 U5892/XI20-net13 n5306 VSS VSS nmos W=0.155u L=0.04u
M21059 n5358 n5316 U5892/XI20-net17 VSS nmos W=0.155u L=0.04u
M21060 U5892/XI20-net17 n5340 U5892/XI20-net13 VSS nmos W=0.155u L=0.04u
M21061 n5224 n5360 VSS VSS nmos W=0.155u L=0.04u
M21062 n5224 U5893/net4 VSS VSS nmos W=0.155u L=0.04u
M21063 U5893/net4 g1563 VSS VSS nmos W=0.155u L=0.04u
M21064 U5893/XU1-net8 U5893/net4 VDD VDD pmos W=0.205u L=0.04u
M21065 n5224 n5360 U5893/XU1-net8 VDD pmos W=0.205u L=0.04u
M21066 U5893/net4 g1563 VDD VDD pmos W=0.205u L=0.04u
M21067 n5306 n5247 VSS VSS nmos W=0.155u L=0.04u
M21068 n5306 n5359 VSS VSS nmos W=0.155u L=0.04u
M21069 U5894/XI1-net8 n5359 VDD VDD pmos W=0.205u L=0.04u
M21070 n5306 n5247 U5894/XI1-net8 VDD pmos W=0.205u L=0.04u
M21071 U5895/p2 n5364 VSS VSS nmos W=0.155u L=0.04u
M21072 U5895/p0 n5362 U5895/p1 VSS nmos W=0.155u L=0.04u
M21073 U5895/p1 n5363 U5895/p2 VSS nmos W=0.155u L=0.04u
M21074 n5359 n5361 U5895/p0 VSS nmos W=0.155u L=0.04u
M21075 n5359 n5363 VDD VDD pmos W=0.205u L=0.04u
M21076 n5359 n5362 VDD VDD pmos W=0.205u L=0.04u
M21077 n5359 n5361 VDD VDD pmos W=0.205u L=0.04u
M21078 n5359 n5364 VDD VDD pmos W=0.205u L=0.04u
M21079 n5364 n5368 VSS VSS nmos W=0.155u L=0.04u
M21080 n5364 n5367 VSS VSS nmos W=0.155u L=0.04u
M21081 n5364 n5366 VSS VSS nmos W=0.155u L=0.04u
M21082 n5364 n5365 VSS VSS nmos W=0.155u L=0.04u
M21083 U5896/net49 n5367 U5896/net52 VDD pmos W=0.41u L=0.04u
M21084 U5896/net52 n5368 VDD VDD pmos W=0.41u L=0.04u
M21085 U5896/net46 n5366 U5896/net49 VDD pmos W=0.41u L=0.04u
M21086 n5364 n5365 U5896/net46 VDD pmos W=0.41u L=0.04u
M21087 U5897/net4 n5369 U5897/net14 VSS nmos W=0.155u L=0.04u
M21088 U5897/net6 U5897/net10 U5897/net14 VSS nmos W=0.17u L=0.04u
M21089 U5897/net4 g1476 VSS VSS nmos W=0.155u L=0.04u
M21090 U5897/net6 U5897/net4 VSS VSS nmos W=0.17u L=0.04u
M21091 n5368 U5897/net14 VSS VSS nmos W=0.155u L=0.04u
M21092 U5897/net10 n5369 VSS VSS nmos W=0.155u L=0.04u
M21093 U5897/net4 U5897/net10 U5897/net14 VDD pmos W=0.255u L=0.04u
M21094 U5897/net6 n5369 U5897/net14 VDD pmos W=0.28u L=0.04u
M21095 U5897/net4 g1476 VDD VDD pmos W=0.205u L=0.04u
M21096 U5897/net6 U5897/net4 VDD VDD pmos W=0.24u L=0.04u
M21097 n5368 U5897/net14 VDD VDD pmos W=0.205u L=0.04u
M21098 U5897/net10 n5369 VDD VDD pmos W=0.205u L=0.04u
M21099 U5898/net36 g1514 U5898/net27 VSS nmos W=0.155u L=0.04u
M21100 U5898/net39 g1515 VSS VSS nmos W=0.155u L=0.04u
M21101 U5898/net27 n5212 U5898/net39 VSS nmos W=0.155u L=0.04u
M21102 U5898/net27 g1516 U5898/net39 VSS nmos W=0.155u L=0.04u
M21103 U5898/net36 n5211 U5898/net27 VSS nmos W=0.155u L=0.04u
M21104 U5898/net39 n5210 VSS VSS nmos W=0.155u L=0.04u
M21105 n5369 U5898/net36 VSS VSS nmos W=0.155u L=0.04u
M21106 n5369 U5898/net36 VDD VDD pmos W=0.205u L=0.04u
M21107 U5898/net36 g1515 U5898/net46 VDD pmos W=0.205u L=0.04u
M21108 U5898/net46 n5210 VDD VDD pmos W=0.205u L=0.04u
M21109 U5898/net36 n5211 U5898/net34 VDD pmos W=0.205u L=0.04u
M21110 U5898/net34 g1514 VDD VDD pmos W=0.205u L=0.04u
M21111 U5898/net36 g1516 U5898/net37 VDD pmos W=0.205u L=0.04u
M21112 U5898/net37 n5212 VDD VDD pmos W=0.205u L=0.04u
M21113 U5899/net4 n5370 U5899/net14 VSS nmos W=0.155u L=0.04u
M21114 U5899/net6 U5899/net10 U5899/net14 VSS nmos W=0.17u L=0.04u
M21115 U5899/net4 g1486 VSS VSS nmos W=0.155u L=0.04u
M21116 U5899/net6 U5899/net4 VSS VSS nmos W=0.17u L=0.04u
M21117 n5367 U5899/net14 VSS VSS nmos W=0.155u L=0.04u
M21118 U5899/net10 n5370 VSS VSS nmos W=0.155u L=0.04u
M21119 U5899/net4 U5899/net10 U5899/net14 VDD pmos W=0.255u L=0.04u
M21120 U5899/net6 n5370 U5899/net14 VDD pmos W=0.28u L=0.04u
M21121 U5899/net4 g1486 VDD VDD pmos W=0.205u L=0.04u
M21122 U5899/net6 U5899/net4 VDD VDD pmos W=0.24u L=0.04u
M21123 n5367 U5899/net14 VDD VDD pmos W=0.205u L=0.04u
M21124 U5899/net10 n5370 VDD VDD pmos W=0.205u L=0.04u
M21125 U5900/net36 g1526 U5900/net27 VSS nmos W=0.155u L=0.04u
M21126 U5900/net39 g1527 VSS VSS nmos W=0.155u L=0.04u
M21127 U5900/net27 n5212 U5900/net39 VSS nmos W=0.155u L=0.04u
M21128 U5900/net27 g1528 U5900/net39 VSS nmos W=0.155u L=0.04u
M21129 U5900/net36 n5211 U5900/net27 VSS nmos W=0.155u L=0.04u
M21130 U5900/net39 n5210 VSS VSS nmos W=0.155u L=0.04u
M21131 n5370 U5900/net36 VSS VSS nmos W=0.155u L=0.04u
M21132 n5370 U5900/net36 VDD VDD pmos W=0.205u L=0.04u
M21133 U5900/net36 g1527 U5900/net46 VDD pmos W=0.205u L=0.04u
M21134 U5900/net46 n5210 VDD VDD pmos W=0.205u L=0.04u
M21135 U5900/net36 n5211 U5900/net34 VDD pmos W=0.205u L=0.04u
M21136 U5900/net34 g1526 VDD VDD pmos W=0.205u L=0.04u
M21137 U5900/net36 g1528 U5900/net37 VDD pmos W=0.205u L=0.04u
M21138 U5900/net37 n5212 VDD VDD pmos W=0.205u L=0.04u
M21139 U5901/net4 n5371 U5901/net14 VSS nmos W=0.155u L=0.04u
M21140 U5901/net6 U5901/net10 U5901/net14 VSS nmos W=0.17u L=0.04u
M21141 U5901/net4 g1501 VSS VSS nmos W=0.155u L=0.04u
M21142 U5901/net6 U5901/net4 VSS VSS nmos W=0.17u L=0.04u
M21143 n5366 U5901/net14 VSS VSS nmos W=0.155u L=0.04u
M21144 U5901/net10 n5371 VSS VSS nmos W=0.155u L=0.04u
M21145 U5901/net4 U5901/net10 U5901/net14 VDD pmos W=0.255u L=0.04u
M21146 U5901/net6 n5371 U5901/net14 VDD pmos W=0.28u L=0.04u
M21147 U5901/net4 g1501 VDD VDD pmos W=0.205u L=0.04u
M21148 U5901/net6 U5901/net4 VDD VDD pmos W=0.24u L=0.04u
M21149 n5366 U5901/net14 VDD VDD pmos W=0.205u L=0.04u
M21150 U5901/net10 n5371 VDD VDD pmos W=0.205u L=0.04u
M21151 U5902/net36 g1535 U5902/net27 VSS nmos W=0.155u L=0.04u
M21152 U5902/net39 g1536 VSS VSS nmos W=0.155u L=0.04u
M21153 U5902/net27 n5212 U5902/net39 VSS nmos W=0.155u L=0.04u
M21154 U5902/net27 g1537 U5902/net39 VSS nmos W=0.155u L=0.04u
M21155 U5902/net36 n5211 U5902/net27 VSS nmos W=0.155u L=0.04u
M21156 U5902/net39 n5210 VSS VSS nmos W=0.155u L=0.04u
M21157 n5371 U5902/net36 VSS VSS nmos W=0.155u L=0.04u
M21158 n5371 U5902/net36 VDD VDD pmos W=0.205u L=0.04u
M21159 U5902/net36 g1536 U5902/net46 VDD pmos W=0.205u L=0.04u
M21160 U5902/net46 n5210 VDD VDD pmos W=0.205u L=0.04u
M21161 U5902/net36 n5211 U5902/net34 VDD pmos W=0.205u L=0.04u
M21162 U5902/net34 g1535 VDD VDD pmos W=0.205u L=0.04u
M21163 U5902/net36 g1537 U5902/net37 VDD pmos W=0.205u L=0.04u
M21164 U5902/net37 n5212 VDD VDD pmos W=0.205u L=0.04u
M21165 n5365 n5372 U5903/XI0-net10 VSS nmos W=0.155u L=0.04u
M21166 U5903/XI0-net10 n5373 U5903/XI0-net13 VSS nmos W=0.155u L=0.04u
M21167 U5903/XI0-net13 n5374 VSS VSS nmos W=0.155u L=0.04u
M21168 n5365 n5374 VDD VDD pmos W=0.205u L=0.04u
M21169 n5365 n5372 VDD VDD pmos W=0.205u L=0.04u
M21170 n5365 n5373 VDD VDD pmos W=0.205u L=0.04u
M21171 U5904/net4 n5183 U5904/net14 VSS nmos W=0.155u L=0.04u
M21172 U5904/net6 U5904/net10 U5904/net14 VSS nmos W=0.17u L=0.04u
M21173 U5904/net4 n5375 VSS VSS nmos W=0.155u L=0.04u
M21174 U5904/net6 U5904/net4 VSS VSS nmos W=0.17u L=0.04u
M21175 n5374 U5904/net14 VSS VSS nmos W=0.155u L=0.04u
M21176 U5904/net10 n5183 VSS VSS nmos W=0.155u L=0.04u
M21177 U5904/net4 U5904/net10 U5904/net14 VDD pmos W=0.255u L=0.04u
M21178 U5904/net6 n5183 U5904/net14 VDD pmos W=0.28u L=0.04u
M21179 U5904/net4 n5375 VDD VDD pmos W=0.205u L=0.04u
M21180 U5904/net6 U5904/net4 VDD VDD pmos W=0.24u L=0.04u
M21181 n5374 U5904/net14 VDD VDD pmos W=0.205u L=0.04u
M21182 U5904/net10 n5183 VDD VDD pmos W=0.205u L=0.04u
M21183 U5905/net36 g1511 U5905/net27 VSS nmos W=0.155u L=0.04u
M21184 U5905/net39 g1512 VSS VSS nmos W=0.155u L=0.04u
M21185 U5905/net27 n5212 U5905/net39 VSS nmos W=0.155u L=0.04u
M21186 U5905/net27 g1513 U5905/net39 VSS nmos W=0.155u L=0.04u
M21187 U5905/net36 n5211 U5905/net27 VSS nmos W=0.155u L=0.04u
M21188 U5905/net39 n5210 VSS VSS nmos W=0.155u L=0.04u
M21189 n5375 U5905/net36 VSS VSS nmos W=0.155u L=0.04u
M21190 n5375 U5905/net36 VDD VDD pmos W=0.205u L=0.04u
M21191 U5905/net36 g1512 U5905/net46 VDD pmos W=0.205u L=0.04u
M21192 U5905/net46 n5210 VDD VDD pmos W=0.205u L=0.04u
M21193 U5905/net36 n5211 U5905/net34 VDD pmos W=0.205u L=0.04u
M21194 U5905/net34 g1511 VDD VDD pmos W=0.205u L=0.04u
M21195 U5905/net36 g1513 U5905/net37 VDD pmos W=0.205u L=0.04u
M21196 U5905/net37 n5212 VDD VDD pmos W=0.205u L=0.04u
M21197 U5906/net4 n5237 U5906/net14 VSS nmos W=0.155u L=0.04u
M21198 U5906/net6 U5906/net10 U5906/net14 VSS nmos W=0.17u L=0.04u
M21199 U5906/net4 n5376 VSS VSS nmos W=0.155u L=0.04u
M21200 U5906/net6 U5906/net4 VSS VSS nmos W=0.17u L=0.04u
M21201 n5373 U5906/net14 VSS VSS nmos W=0.155u L=0.04u
M21202 U5906/net10 n5237 VSS VSS nmos W=0.155u L=0.04u
M21203 U5906/net4 U5906/net10 U5906/net14 VDD pmos W=0.255u L=0.04u
M21204 U5906/net6 n5237 U5906/net14 VDD pmos W=0.28u L=0.04u
M21205 U5906/net4 n5376 VDD VDD pmos W=0.205u L=0.04u
M21206 U5906/net6 U5906/net4 VDD VDD pmos W=0.24u L=0.04u
M21207 n5373 U5906/net14 VDD VDD pmos W=0.205u L=0.04u
M21208 U5906/net10 n5237 VDD VDD pmos W=0.205u L=0.04u
M21209 U5907/net36 g1538 U5907/net27 VSS nmos W=0.155u L=0.04u
M21210 U5907/net39 g1539 VSS VSS nmos W=0.155u L=0.04u
M21211 U5907/net27 n5212 U5907/net39 VSS nmos W=0.155u L=0.04u
M21212 U5907/net27 g1540 U5907/net39 VSS nmos W=0.155u L=0.04u
M21213 U5907/net36 n5211 U5907/net27 VSS nmos W=0.155u L=0.04u
M21214 U5907/net39 n5210 VSS VSS nmos W=0.155u L=0.04u
M21215 n5376 U5907/net36 VSS VSS nmos W=0.155u L=0.04u
M21216 n5376 U5907/net36 VDD VDD pmos W=0.205u L=0.04u
M21217 U5907/net36 g1539 U5907/net46 VDD pmos W=0.205u L=0.04u
M21218 U5907/net46 n5210 VDD VDD pmos W=0.205u L=0.04u
M21219 U5907/net36 n5211 U5907/net34 VDD pmos W=0.205u L=0.04u
M21220 U5907/net34 g1538 VDD VDD pmos W=0.205u L=0.04u
M21221 U5907/net36 g1540 U5907/net37 VDD pmos W=0.205u L=0.04u
M21222 U5907/net37 n5212 VDD VDD pmos W=0.205u L=0.04u
M21223 U5908/net4 n5187 U5908/net14 VSS nmos W=0.155u L=0.04u
M21224 U5908/net6 U5908/net10 U5908/net14 VSS nmos W=0.17u L=0.04u
M21225 U5908/net4 n5377 VSS VSS nmos W=0.155u L=0.04u
M21226 U5908/net6 U5908/net4 VSS VSS nmos W=0.17u L=0.04u
M21227 n5372 U5908/net14 VSS VSS nmos W=0.155u L=0.04u
M21228 U5908/net10 n5187 VSS VSS nmos W=0.155u L=0.04u
M21229 U5908/net4 U5908/net10 U5908/net14 VDD pmos W=0.255u L=0.04u
M21230 U5908/net6 n5187 U5908/net14 VDD pmos W=0.28u L=0.04u
M21231 U5908/net4 n5377 VDD VDD pmos W=0.205u L=0.04u
M21232 U5908/net6 U5908/net4 VDD VDD pmos W=0.24u L=0.04u
M21233 n5372 U5908/net14 VDD VDD pmos W=0.205u L=0.04u
M21234 U5908/net10 n5187 VDD VDD pmos W=0.205u L=0.04u
M21235 U5909/net36 g1529 U5909/net27 VSS nmos W=0.155u L=0.04u
M21236 U5909/net39 g1530 VSS VSS nmos W=0.155u L=0.04u
M21237 U5909/net27 n5212 U5909/net39 VSS nmos W=0.155u L=0.04u
M21238 U5909/net27 g1531 U5909/net39 VSS nmos W=0.155u L=0.04u
M21239 U5909/net36 n5211 U5909/net27 VSS nmos W=0.155u L=0.04u
M21240 U5909/net39 n5210 VSS VSS nmos W=0.155u L=0.04u
M21241 n5377 U5909/net36 VSS VSS nmos W=0.155u L=0.04u
M21242 n5377 U5909/net36 VDD VDD pmos W=0.205u L=0.04u
M21243 U5909/net36 g1530 U5909/net46 VDD pmos W=0.205u L=0.04u
M21244 U5909/net46 n5210 VDD VDD pmos W=0.205u L=0.04u
M21245 U5909/net36 n5211 U5909/net34 VDD pmos W=0.205u L=0.04u
M21246 U5909/net34 g1529 VDD VDD pmos W=0.205u L=0.04u
M21247 U5909/net36 g1531 U5909/net37 VDD pmos W=0.205u L=0.04u
M21248 U5909/net37 n5212 VDD VDD pmos W=0.205u L=0.04u
M21249 n5363 n5379 VSS VSS nmos W=0.155u L=0.04u
M21250 n5363 n5378 VSS VSS nmos W=0.155u L=0.04u
M21251 n5363 n5332 VSS VSS nmos W=0.155u L=0.04u
M21252 U5910/net25 n5379 VDD VDD pmos W=0.41u L=0.04u
M21253 U5910/net28 n5378 U5910/net25 VDD pmos W=0.41u L=0.04u
M21254 n5363 n5332 U5910/net28 VDD pmos W=0.41u L=0.04u
M21255 U5911/net4 n5380 U5911/net14 VSS nmos W=0.155u L=0.04u
M21256 U5911/net6 U5911/net10 U5911/net14 VSS nmos W=0.17u L=0.04u
M21257 U5911/net4 g1496 VSS VSS nmos W=0.155u L=0.04u
M21258 U5911/net6 U5911/net4 VSS VSS nmos W=0.17u L=0.04u
M21259 n5379 U5911/net14 VSS VSS nmos W=0.155u L=0.04u
M21260 U5911/net10 n5380 VSS VSS nmos W=0.155u L=0.04u
M21261 U5911/net4 U5911/net10 U5911/net14 VDD pmos W=0.255u L=0.04u
M21262 U5911/net6 n5380 U5911/net14 VDD pmos W=0.28u L=0.04u
M21263 U5911/net4 g1496 VDD VDD pmos W=0.205u L=0.04u
M21264 U5911/net6 U5911/net4 VDD VDD pmos W=0.24u L=0.04u
M21265 n5379 U5911/net14 VDD VDD pmos W=0.205u L=0.04u
M21266 U5911/net10 n5380 VDD VDD pmos W=0.205u L=0.04u
M21267 U5912/net36 g1532 U5912/net27 VSS nmos W=0.155u L=0.04u
M21268 U5912/net39 g1533 VSS VSS nmos W=0.155u L=0.04u
M21269 U5912/net27 n5212 U5912/net39 VSS nmos W=0.155u L=0.04u
M21270 U5912/net27 g1534 U5912/net39 VSS nmos W=0.155u L=0.04u
M21271 U5912/net36 n5211 U5912/net27 VSS nmos W=0.155u L=0.04u
M21272 U5912/net39 n5210 VSS VSS nmos W=0.155u L=0.04u
M21273 n5380 U5912/net36 VSS VSS nmos W=0.155u L=0.04u
M21274 n5380 U5912/net36 VDD VDD pmos W=0.205u L=0.04u
M21275 U5912/net36 g1533 U5912/net46 VDD pmos W=0.205u L=0.04u
M21276 U5912/net46 n5210 VDD VDD pmos W=0.205u L=0.04u
M21277 U5912/net36 n5211 U5912/net34 VDD pmos W=0.205u L=0.04u
M21278 U5912/net34 g1532 VDD VDD pmos W=0.205u L=0.04u
M21279 U5912/net36 g1534 U5912/net37 VDD pmos W=0.205u L=0.04u
M21280 U5912/net37 n5212 VDD VDD pmos W=0.205u L=0.04u
M21281 U5913/net4 n5381 U5913/net14 VSS nmos W=0.155u L=0.04u
M21282 U5913/net6 U5913/net10 U5913/net14 VSS nmos W=0.17u L=0.04u
M21283 U5913/net4 g1481 VSS VSS nmos W=0.155u L=0.04u
M21284 U5913/net6 U5913/net4 VSS VSS nmos W=0.17u L=0.04u
M21285 n5378 U5913/net14 VSS VSS nmos W=0.155u L=0.04u
M21286 U5913/net10 n5381 VSS VSS nmos W=0.155u L=0.04u
M21287 U5913/net4 U5913/net10 U5913/net14 VDD pmos W=0.255u L=0.04u
M21288 U5913/net6 n5381 U5913/net14 VDD pmos W=0.28u L=0.04u
M21289 U5913/net4 g1481 VDD VDD pmos W=0.205u L=0.04u
M21290 U5913/net6 U5913/net4 VDD VDD pmos W=0.24u L=0.04u
M21291 n5378 U5913/net14 VDD VDD pmos W=0.205u L=0.04u
M21292 U5913/net10 n5381 VDD VDD pmos W=0.205u L=0.04u
M21293 U5914/net36 g1523 U5914/net27 VSS nmos W=0.155u L=0.04u
M21294 U5914/net39 g1524 VSS VSS nmos W=0.155u L=0.04u
M21295 U5914/net27 n5212 U5914/net39 VSS nmos W=0.155u L=0.04u
M21296 U5914/net27 g1525 U5914/net39 VSS nmos W=0.155u L=0.04u
M21297 U5914/net36 n5211 U5914/net27 VSS nmos W=0.155u L=0.04u
M21298 U5914/net39 n5210 VSS VSS nmos W=0.155u L=0.04u
M21299 n5381 U5914/net36 VSS VSS nmos W=0.155u L=0.04u
M21300 n5381 U5914/net36 VDD VDD pmos W=0.205u L=0.04u
M21301 U5914/net36 g1524 U5914/net46 VDD pmos W=0.205u L=0.04u
M21302 U5914/net46 n5210 VDD VDD pmos W=0.205u L=0.04u
M21303 U5914/net36 n5211 U5914/net34 VDD pmos W=0.205u L=0.04u
M21304 U5914/net34 g1523 VDD VDD pmos W=0.205u L=0.04u
M21305 U5914/net36 g1525 U5914/net37 VDD pmos W=0.205u L=0.04u
M21306 U5914/net37 n5212 VDD VDD pmos W=0.205u L=0.04u
M21307 U5915/net4 n5236 U5915/net14 VSS nmos W=0.155u L=0.04u
M21308 U5915/net6 U5915/net10 U5915/net14 VSS nmos W=0.17u L=0.04u
M21309 U5915/net4 n5382 VSS VSS nmos W=0.155u L=0.04u
M21310 U5915/net6 U5915/net4 VSS VSS nmos W=0.17u L=0.04u
M21311 n5362 U5915/net14 VSS VSS nmos W=0.155u L=0.04u
M21312 U5915/net10 n5236 VSS VSS nmos W=0.155u L=0.04u
M21313 U5915/net4 U5915/net10 U5915/net14 VDD pmos W=0.255u L=0.04u
M21314 U5915/net6 n5236 U5915/net14 VDD pmos W=0.28u L=0.04u
M21315 U5915/net4 n5382 VDD VDD pmos W=0.205u L=0.04u
M21316 U5915/net6 U5915/net4 VDD VDD pmos W=0.24u L=0.04u
M21317 n5362 U5915/net14 VDD VDD pmos W=0.205u L=0.04u
M21318 U5915/net10 n5236 VDD VDD pmos W=0.205u L=0.04u
M21319 n5382 n5210 U5916/net27 VSS nmos W=0.155u L=0.04u
M21320 U5916/net39 n5212 VSS VSS nmos W=0.155u L=0.04u
M21321 U5916/net27 g1544 U5916/net39 VSS nmos W=0.155u L=0.04u
M21322 U5916/net27 n5211 U5916/net39 VSS nmos W=0.155u L=0.04u
M21323 n5382 g1545 U5916/net27 VSS nmos W=0.155u L=0.04u
M21324 U5916/net39 g1546 VSS VSS nmos W=0.155u L=0.04u
M21325 n5382 n5212 U5916/net46 VDD pmos W=0.205u L=0.04u
M21326 U5916/net46 g1546 VDD VDD pmos W=0.205u L=0.04u
M21327 n5382 g1545 U5916/net34 VDD pmos W=0.205u L=0.04u
M21328 U5916/net34 n5210 VDD VDD pmos W=0.205u L=0.04u
M21329 n5382 n5211 U5916/net37 VDD pmos W=0.205u L=0.04u
M21330 U5916/net37 g1544 VDD VDD pmos W=0.205u L=0.04u
M21331 U5917/net4 n5383 U5917/net14 VSS nmos W=0.155u L=0.04u
M21332 U5917/net6 U5917/net10 U5917/net14 VSS nmos W=0.17u L=0.04u
M21333 U5917/net4 n5384 VSS VSS nmos W=0.155u L=0.04u
M21334 U5917/net6 U5917/net4 VSS VSS nmos W=0.17u L=0.04u
M21335 n5361 U5917/net14 VSS VSS nmos W=0.155u L=0.04u
M21336 U5917/net10 n5383 VSS VSS nmos W=0.155u L=0.04u
M21337 U5917/net4 U5917/net10 U5917/net14 VDD pmos W=0.255u L=0.04u
M21338 U5917/net6 n5383 U5917/net14 VDD pmos W=0.28u L=0.04u
M21339 U5917/net4 n5384 VDD VDD pmos W=0.205u L=0.04u
M21340 U5917/net6 U5917/net4 VDD VDD pmos W=0.24u L=0.04u
M21341 n5361 U5917/net14 VDD VDD pmos W=0.205u L=0.04u
M21342 U5917/net10 n5383 VDD VDD pmos W=0.205u L=0.04u
M21343 n5384 n5210 U5918/net27 VSS nmos W=0.155u L=0.04u
M21344 U5918/net39 n5212 VSS VSS nmos W=0.155u L=0.04u
M21345 U5918/net27 g1541 U5918/net39 VSS nmos W=0.155u L=0.04u
M21346 U5918/net27 n5211 U5918/net39 VSS nmos W=0.155u L=0.04u
M21347 n5384 g1542 U5918/net27 VSS nmos W=0.155u L=0.04u
M21348 U5918/net39 g1543 VSS VSS nmos W=0.155u L=0.04u
M21349 n5384 n5212 U5918/net46 VDD pmos W=0.205u L=0.04u
M21350 U5918/net46 g1543 VDD VDD pmos W=0.205u L=0.04u
M21351 n5384 g1542 U5918/net34 VDD pmos W=0.205u L=0.04u
M21352 U5918/net34 n5210 VDD VDD pmos W=0.205u L=0.04u
M21353 n5384 n5211 U5918/net37 VDD pmos W=0.205u L=0.04u
M21354 U5918/net37 g1541 VDD VDD pmos W=0.205u L=0.04u
M21355 U5919/XU1-net6 n5341 VSS VSS nmos W=0.155u L=0.04u
M21356 n5247 n5326 U5919/XU1-net6 VSS nmos W=0.155u L=0.04u
M21357 n5247 n5341 VDD VDD pmos W=0.155u L=0.04u
M21358 n5247 n5326 VDD VDD pmos W=0.155u L=0.04u
M21359 n5341 n5385 U5920/net15 VSS nmos W=0.155u L=0.04u
M21360 n5341 n5386 U5920/net15 VSS nmos W=0.155u L=0.04u
M21361 U5920/net15 n5327 VSS VSS nmos W=0.155u L=0.04u
M21362 n5341 n5327 VDD VDD pmos W=0.205u L=0.04u
M21363 n5341 n5385 U5920/XI16-net11 VDD pmos W=0.205u L=0.04u
M21364 U5920/XI16-net11 n5386 VDD VDD pmos W=0.205u L=0.04u
M21365 n5386 n5338 U5921/net14 VSS nmos W=0.155u L=0.04u
M21366 U5921/net14 n5388 VSS VSS nmos W=0.155u L=0.04u
M21367 U5921/net14 n5387 VSS VSS nmos W=0.155u L=0.04u
M21368 n5386 n5337 U5921/net14 VSS nmos W=0.155u L=0.04u
M21369 n5386 n5333 U5921/net14 VSS nmos W=0.155u L=0.04u
M21370 n5386 n5388 U5921/XI16-net11 VDD pmos W=0.205u L=0.04u
M21371 U5921/XI16-net11 n5387 VDD VDD pmos W=0.205u L=0.04u
M21372 n5386 n5337 U5921/XI15-net11 VDD pmos W=0.205u L=0.04u
M21373 U5921/XI15-net11 n5333 U5921/XI15-net18 VDD pmos W=0.205u L=0.04u
M21374 U5921/XI15-net18 n5338 VDD VDD pmos W=0.205u L=0.04u
M21375 U5922/net29 n5338 VSS VSS nmos W=0.155u L=0.04u
M21376 U5922/net26 n5390 U5922/net20 VSS nmos W=0.155u L=0.04u
M21377 U5922/net20 n5391 VSS VSS nmos W=0.155u L=0.04u
M21378 U5922/net26 n5389 U5922/net29 VSS nmos W=0.155u L=0.04u
M21379 n5388 U5922/net26 VSS VSS nmos W=0.155u L=0.04u
M21380 n5388 U5922/net26 VDD VDD pmos W=0.205u L=0.04u
M21381 U5922/net26 n5389 U5922/net40 VDD pmos W=0.205u L=0.04u
M21382 U5922/net26 n5338 U5922/net40 VDD pmos W=0.205u L=0.04u
M21383 U5922/net40 n5391 VDD VDD pmos W=0.205u L=0.04u
M21384 U5922/net40 n5390 VDD VDD pmos W=0.205u L=0.04u
M21385 n5337 U5923/net6 VSS VSS nmos W=0.155u L=0.04u
M21386 U5923/X_u2-net6 n5390 VSS VSS nmos W=0.155u L=0.04u
M21387 U5923/net6 n5389 U5923/X_u2-net6 VSS nmos W=0.155u L=0.04u
M21388 n5337 U5923/net6 VDD VDD pmos W=0.205u L=0.04u
M21389 U5923/net6 n5390 VDD VDD pmos W=0.205u L=0.04u
M21390 U5923/net6 n5389 VDD VDD pmos W=0.205u L=0.04u
M21391 n5333 U5924/net6 VSS VSS nmos W=0.155u L=0.04u
M21392 U5924/X_u2-net6 n5391 VSS VSS nmos W=0.155u L=0.04u
M21393 U5924/net6 n5387 U5924/X_u2-net6 VSS nmos W=0.155u L=0.04u
M21394 n5333 U5924/net6 VDD VDD pmos W=0.205u L=0.04u
M21395 U5924/net6 n5391 VDD VDD pmos W=0.205u L=0.04u
M21396 U5924/net6 n5387 VDD VDD pmos W=0.205u L=0.04u
M21397 n5385 n5390 VSS VSS nmos W=0.155u L=0.04u
M21398 n5385 n5391 U5925/XI17-net17 VSS nmos W=0.155u L=0.04u
M21399 U5925/XI17-net17 n5338 VSS VSS nmos W=0.155u L=0.04u
M21400 n5385 n5387 U5925/XI10-net17 VSS nmos W=0.155u L=0.04u
M21401 U5925/XI10-net17 n5389 VSS VSS nmos W=0.155u L=0.04u
M21402 U5925/net30 n5387 n5385 VDD pmos W=0.205u L=0.04u
M21403 U5925/net30 n5389 n5385 VDD pmos W=0.205u L=0.04u
M21404 VDD n5390 U5925/net36 VDD pmos W=0.205u L=0.04u
M21405 U5925/net36 n5338 U5925/net30 VDD pmos W=0.205u L=0.04u
M21406 U5925/net36 n5391 U5925/net30 VDD pmos W=0.205u L=0.04u
M21407 U5926/net4 U5926/net10 U5926/net14 VSS nmos W=0.155u L=0.04u
M21408 U5926/net6 n5351 U5926/net14 VSS nmos W=0.155u L=0.04u
M21409 U5926/net4 n5184 VSS VSS nmos W=0.155u L=0.04u
M21410 U5926/net6 U5926/net4 VSS VSS nmos W=0.155u L=0.04u
M21411 n5390 U5926/net14 VSS VSS nmos W=0.155u L=0.04u
M21412 U5926/net10 n5351 VSS VSS nmos W=0.155u L=0.04u
M21413 U5926/net4 n5351 U5926/net14 VDD pmos W=0.205u L=0.04u
M21414 U5926/net6 U5926/net10 U5926/net14 VDD pmos W=0.205u L=0.04u
M21415 U5926/net4 n5184 VDD VDD pmos W=0.205u L=0.04u
M21416 U5926/net6 U5926/net4 VDD VDD pmos W=0.205u L=0.04u
M21417 n5390 U5926/net14 VDD VDD pmos W=0.205u L=0.04u
M21418 U5926/net10 n5351 VDD VDD pmos W=0.205u L=0.04u
M21419 U5927/net4 U5927/net10 U5927/net14 VSS nmos W=0.155u L=0.04u
M21420 U5927/net6 n5353 U5927/net14 VSS nmos W=0.155u L=0.04u
M21421 U5927/net4 n5188 VSS VSS nmos W=0.155u L=0.04u
M21422 U5927/net6 U5927/net4 VSS VSS nmos W=0.155u L=0.04u
M21423 n5338 U5927/net14 VSS VSS nmos W=0.155u L=0.04u
M21424 U5927/net10 n5353 VSS VSS nmos W=0.155u L=0.04u
M21425 U5927/net4 n5353 U5927/net14 VDD pmos W=0.205u L=0.04u
M21426 U5927/net6 U5927/net10 U5927/net14 VDD pmos W=0.205u L=0.04u
M21427 U5927/net4 n5188 VDD VDD pmos W=0.205u L=0.04u
M21428 U5927/net6 U5927/net4 VDD VDD pmos W=0.205u L=0.04u
M21429 n5338 U5927/net14 VDD VDD pmos W=0.205u L=0.04u
M21430 U5927/net10 n5353 VDD VDD pmos W=0.205u L=0.04u
M21431 U5928/net4 n5352 U5928/net14 VSS nmos W=0.155u L=0.04u
M21432 U5928/net6 U5928/net10 U5928/net14 VSS nmos W=0.17u L=0.04u
M21433 U5928/net4 g1486 VSS VSS nmos W=0.155u L=0.04u
M21434 U5928/net6 U5928/net4 VSS VSS nmos W=0.17u L=0.04u
M21435 n5391 U5928/net14 VSS VSS nmos W=0.155u L=0.04u
M21436 U5928/net10 n5352 VSS VSS nmos W=0.155u L=0.04u
M21437 U5928/net4 U5928/net10 U5928/net14 VDD pmos W=0.255u L=0.04u
M21438 U5928/net6 n5352 U5928/net14 VDD pmos W=0.28u L=0.04u
M21439 U5928/net4 g1486 VDD VDD pmos W=0.205u L=0.04u
M21440 U5928/net6 U5928/net4 VDD VDD pmos W=0.24u L=0.04u
M21441 n5391 U5928/net14 VDD VDD pmos W=0.205u L=0.04u
M21442 U5928/net10 n5352 VDD VDD pmos W=0.205u L=0.04u
M21443 U5929/net4 U5929/net10 U5929/net14 VSS nmos W=0.155u L=0.04u
M21444 U5929/net6 n5283 U5929/net14 VSS nmos W=0.155u L=0.04u
M21445 U5929/net4 n5237 VSS VSS nmos W=0.155u L=0.04u
M21446 U5929/net6 U5929/net4 VSS VSS nmos W=0.155u L=0.04u
M21447 n5389 U5929/net14 VSS VSS nmos W=0.155u L=0.04u
M21448 U5929/net10 n5283 VSS VSS nmos W=0.155u L=0.04u
M21449 U5929/net4 n5283 U5929/net14 VDD pmos W=0.205u L=0.04u
M21450 U5929/net6 U5929/net10 U5929/net14 VDD pmos W=0.205u L=0.04u
M21451 U5929/net4 n5237 VDD VDD pmos W=0.205u L=0.04u
M21452 U5929/net6 U5929/net4 VDD VDD pmos W=0.205u L=0.04u
M21453 n5389 U5929/net14 VDD VDD pmos W=0.205u L=0.04u
M21454 U5929/net10 n5283 VDD VDD pmos W=0.205u L=0.04u
M21455 U5930/net4 n5236 U5930/net14 VSS nmos W=0.155u L=0.04u
M21456 U5930/net6 U5930/net10 U5930/net14 VSS nmos W=0.17u L=0.04u
M21457 U5930/net4 n5392 VSS VSS nmos W=0.155u L=0.04u
M21458 U5930/net6 U5930/net4 VSS VSS nmos W=0.17u L=0.04u
M21459 n5387 U5930/net14 VSS VSS nmos W=0.155u L=0.04u
M21460 U5930/net10 n5236 VSS VSS nmos W=0.155u L=0.04u
M21461 U5930/net4 U5930/net10 U5930/net14 VDD pmos W=0.255u L=0.04u
M21462 U5930/net6 n5236 U5930/net14 VDD pmos W=0.28u L=0.04u
M21463 U5930/net4 n5392 VDD VDD pmos W=0.205u L=0.04u
M21464 U5930/net6 U5930/net4 VDD VDD pmos W=0.24u L=0.04u
M21465 n5387 U5930/net14 VDD VDD pmos W=0.205u L=0.04u
M21466 U5930/net10 n5236 VDD VDD pmos W=0.205u L=0.04u
M21467 n5236 n5210 U5931/net27 VSS nmos W=0.155u L=0.04u
M21468 U5931/net39 n5212 VSS VSS nmos W=0.155u L=0.04u
M21469 U5931/net27 g1553 U5931/net39 VSS nmos W=0.155u L=0.04u
M21470 U5931/net27 n5211 U5931/net39 VSS nmos W=0.155u L=0.04u
M21471 n5236 g1554 U5931/net27 VSS nmos W=0.155u L=0.04u
M21472 U5931/net39 g1555 VSS VSS nmos W=0.155u L=0.04u
M21473 n5236 n5212 U5931/net46 VDD pmos W=0.205u L=0.04u
M21474 U5931/net46 g1555 VDD VDD pmos W=0.205u L=0.04u
M21475 n5236 g1554 U5931/net34 VDD pmos W=0.205u L=0.04u
M21476 U5931/net34 n5210 VDD VDD pmos W=0.205u L=0.04u
M21477 n5236 n5211 U5931/net37 VDD pmos W=0.205u L=0.04u
M21478 U5931/net37 g1553 VDD VDD pmos W=0.205u L=0.04u
M21479 n5326 n5393 U5932/net15 VSS nmos W=0.155u L=0.04u
M21480 n5326 n5394 U5932/net15 VSS nmos W=0.155u L=0.04u
M21481 U5932/net15 n5327 VSS VSS nmos W=0.155u L=0.04u
M21482 n5326 n5327 VDD VDD pmos W=0.205u L=0.04u
M21483 n5326 n5393 U5932/XI16-net11 VDD pmos W=0.205u L=0.04u
M21484 U5932/XI16-net11 n5394 VDD VDD pmos W=0.205u L=0.04u
M21485 n5327 n5332 VSS VSS nmos W=0.135u L=0.04u
M21486 n5327 n5332 VDD VDD pmos W=0.205u L=0.04u
M21487 U5934/XU1-net6 n5360 VSS VSS nmos W=0.155u L=0.04u
M21488 n5332 g1563 U5934/XU1-net6 VSS nmos W=0.155u L=0.04u
M21489 n5332 n5360 VDD VDD pmos W=0.155u L=0.04u
M21490 n5332 g1563 VDD VDD pmos W=0.155u L=0.04u
M21491 n5360 n5210 U5935/net27 VSS nmos W=0.155u L=0.04u
M21492 U5935/net39 n5212 VSS VSS nmos W=0.155u L=0.04u
M21493 U5935/net27 g1550 U5935/net39 VSS nmos W=0.155u L=0.04u
M21494 U5935/net27 n5211 U5935/net39 VSS nmos W=0.155u L=0.04u
M21495 n5360 g1551 U5935/net27 VSS nmos W=0.155u L=0.04u
M21496 U5935/net39 g1552 VSS VSS nmos W=0.155u L=0.04u
M21497 n5360 n5212 U5935/net46 VDD pmos W=0.205u L=0.04u
M21498 U5935/net46 g1552 VDD VDD pmos W=0.205u L=0.04u
M21499 n5360 g1551 U5935/net34 VDD pmos W=0.205u L=0.04u
M21500 U5935/net34 n5210 VDD VDD pmos W=0.205u L=0.04u
M21501 n5360 n5211 U5935/net37 VDD pmos W=0.205u L=0.04u
M21502 U5935/net37 g1550 VDD VDD pmos W=0.205u L=0.04u
M21503 n5394 n5339 U5936/net14 VSS nmos W=0.155u L=0.04u
M21504 U5936/net14 n5396 VSS VSS nmos W=0.155u L=0.04u
M21505 U5936/net14 n5395 VSS VSS nmos W=0.155u L=0.04u
M21506 n5394 n5334 U5936/net14 VSS nmos W=0.155u L=0.04u
M21507 n5394 n5335 U5936/net14 VSS nmos W=0.155u L=0.04u
M21508 n5394 n5396 U5936/XI16-net11 VDD pmos W=0.205u L=0.04u
M21509 U5936/XI16-net11 n5395 VDD VDD pmos W=0.205u L=0.04u
M21510 n5394 n5334 U5936/XI15-net11 VDD pmos W=0.205u L=0.04u
M21511 U5936/XI15-net11 n5335 U5936/XI15-net18 VDD pmos W=0.205u L=0.04u
M21512 U5936/XI15-net18 n5339 VDD VDD pmos W=0.205u L=0.04u
M21513 U5937/net29 n5339 VSS VSS nmos W=0.155u L=0.04u
M21514 U5937/net26 n5398 U5937/net20 VSS nmos W=0.155u L=0.04u
M21515 U5937/net20 n5399 VSS VSS nmos W=0.155u L=0.04u
M21516 U5937/net26 n5397 U5937/net29 VSS nmos W=0.155u L=0.04u
M21517 n5396 U5937/net26 VSS VSS nmos W=0.155u L=0.04u
M21518 n5396 U5937/net26 VDD VDD pmos W=0.205u L=0.04u
M21519 U5937/net26 n5397 U5937/net40 VDD pmos W=0.205u L=0.04u
M21520 U5937/net26 n5339 U5937/net40 VDD pmos W=0.205u L=0.04u
M21521 U5937/net40 n5399 VDD VDD pmos W=0.205u L=0.04u
M21522 U5937/net40 n5398 VDD VDD pmos W=0.205u L=0.04u
M21523 n5334 U5938/net6 VSS VSS nmos W=0.155u L=0.04u
M21524 U5938/X_u2-net6 n5398 VSS VSS nmos W=0.155u L=0.04u
M21525 U5938/net6 n5397 U5938/X_u2-net6 VSS nmos W=0.155u L=0.04u
M21526 n5334 U5938/net6 VDD VDD pmos W=0.205u L=0.04u
M21527 U5938/net6 n5398 VDD VDD pmos W=0.205u L=0.04u
M21528 U5938/net6 n5397 VDD VDD pmos W=0.205u L=0.04u
M21529 n5335 U5939/net6 VSS VSS nmos W=0.155u L=0.04u
M21530 U5939/X_u2-net6 n5399 VSS VSS nmos W=0.155u L=0.04u
M21531 U5939/net6 n5395 U5939/X_u2-net6 VSS nmos W=0.155u L=0.04u
M21532 n5335 U5939/net6 VDD VDD pmos W=0.205u L=0.04u
M21533 U5939/net6 n5399 VDD VDD pmos W=0.205u L=0.04u
M21534 U5939/net6 n5395 VDD VDD pmos W=0.205u L=0.04u
M21535 n5393 n5398 VSS VSS nmos W=0.155u L=0.04u
M21536 n5393 n5399 U5940/XI17-net17 VSS nmos W=0.155u L=0.04u
M21537 U5940/XI17-net17 n5339 VSS VSS nmos W=0.155u L=0.04u
M21538 n5393 n5395 U5940/XI10-net17 VSS nmos W=0.155u L=0.04u
M21539 U5940/XI10-net17 n5397 VSS VSS nmos W=0.155u L=0.04u
M21540 U5940/net30 n5395 n5393 VDD pmos W=0.205u L=0.04u
M21541 U5940/net30 n5397 n5393 VDD pmos W=0.205u L=0.04u
M21542 VDD n5398 U5940/net36 VDD pmos W=0.205u L=0.04u
M21543 U5940/net36 n5339 U5940/net30 VDD pmos W=0.205u L=0.04u
M21544 U5940/net36 n5399 U5940/net30 VDD pmos W=0.205u L=0.04u
M21545 U5941/net4 U5941/net10 U5941/net14 VSS nmos W=0.155u L=0.04u
M21546 U5941/net6 n5269 U5941/net14 VSS nmos W=0.155u L=0.04u
M21547 U5941/net4 g1471 VSS VSS nmos W=0.155u L=0.04u
M21548 U5941/net6 U5941/net4 VSS VSS nmos W=0.155u L=0.04u
M21549 n5398 U5941/net14 VSS VSS nmos W=0.155u L=0.04u
M21550 U5941/net10 n5269 VSS VSS nmos W=0.155u L=0.04u
M21551 U5941/net4 n5269 U5941/net14 VDD pmos W=0.205u L=0.04u
M21552 U5941/net6 U5941/net10 U5941/net14 VDD pmos W=0.205u L=0.04u
M21553 U5941/net4 g1471 VDD VDD pmos W=0.205u L=0.04u
M21554 U5941/net6 U5941/net4 VDD VDD pmos W=0.205u L=0.04u
M21555 n5398 U5941/net14 VDD VDD pmos W=0.205u L=0.04u
M21556 U5941/net10 n5269 VDD VDD pmos W=0.205u L=0.04u
M21557 U5942/net4 U5942/net10 U5942/net14 VSS nmos W=0.155u L=0.04u
M21558 U5942/net6 n5265 U5942/net14 VSS nmos W=0.155u L=0.04u
M21559 U5942/net4 n5187 VSS VSS nmos W=0.155u L=0.04u
M21560 U5942/net6 U5942/net4 VSS VSS nmos W=0.155u L=0.04u
M21561 n5339 U5942/net14 VSS VSS nmos W=0.155u L=0.04u
M21562 U5942/net10 n5265 VSS VSS nmos W=0.155u L=0.04u
M21563 U5942/net4 n5265 U5942/net14 VDD pmos W=0.205u L=0.04u
M21564 U5942/net6 U5942/net10 U5942/net14 VDD pmos W=0.205u L=0.04u
M21565 U5942/net4 n5187 VDD VDD pmos W=0.205u L=0.04u
M21566 U5942/net6 U5942/net4 VDD VDD pmos W=0.205u L=0.04u
M21567 n5339 U5942/net14 VDD VDD pmos W=0.205u L=0.04u
M21568 U5942/net10 n5265 VDD VDD pmos W=0.205u L=0.04u
M21569 n5265 n5400 VSS VSS nmos W=0.135u L=0.04u
M21570 n5265 n5400 VDD VDD pmos W=0.205u L=0.04u
M21571 U5944/net4 U5944/net10 U5944/net14 VSS nmos W=0.155u L=0.04u
M21572 U5944/net6 n5288 U5944/net14 VSS nmos W=0.155u L=0.04u
M21573 U5944/net4 g1481 VSS VSS nmos W=0.155u L=0.04u
M21574 U5944/net6 U5944/net4 VSS VSS nmos W=0.155u L=0.04u
M21575 n5399 U5944/net14 VSS VSS nmos W=0.155u L=0.04u
M21576 U5944/net10 n5288 VSS VSS nmos W=0.155u L=0.04u
M21577 U5944/net4 n5288 U5944/net14 VDD pmos W=0.205u L=0.04u
M21578 U5944/net6 U5944/net10 U5944/net14 VDD pmos W=0.205u L=0.04u
M21579 U5944/net4 g1481 VDD VDD pmos W=0.205u L=0.04u
M21580 U5944/net6 U5944/net4 VDD VDD pmos W=0.205u L=0.04u
M21581 n5399 U5944/net14 VDD VDD pmos W=0.205u L=0.04u
M21582 U5944/net10 n5288 VDD VDD pmos W=0.205u L=0.04u
M21583 U5945/net4 U5945/net10 U5945/net14 VSS nmos W=0.155u L=0.04u
M21584 U5945/net6 n5346 U5945/net14 VSS nmos W=0.155u L=0.04u
M21585 U5945/net4 n5189 VSS VSS nmos W=0.155u L=0.04u
M21586 U5945/net6 U5945/net4 VSS VSS nmos W=0.155u L=0.04u
M21587 n5397 U5945/net14 VSS VSS nmos W=0.155u L=0.04u
M21588 U5945/net10 n5346 VSS VSS nmos W=0.155u L=0.04u
M21589 U5945/net4 n5346 U5945/net14 VDD pmos W=0.205u L=0.04u
M21590 U5945/net6 U5945/net10 U5945/net14 VDD pmos W=0.205u L=0.04u
M21591 U5945/net4 n5189 VDD VDD pmos W=0.205u L=0.04u
M21592 U5945/net6 U5945/net4 VDD VDD pmos W=0.205u L=0.04u
M21593 n5397 U5945/net14 VDD VDD pmos W=0.205u L=0.04u
M21594 U5945/net10 n5346 VDD VDD pmos W=0.205u L=0.04u
M21595 U5946/net4 n5277 U5946/net14 VSS nmos W=0.155u L=0.04u
M21596 U5946/net6 U5946/net10 U5946/net14 VSS nmos W=0.17u L=0.04u
M21597 U5946/net4 n4070 VSS VSS nmos W=0.155u L=0.04u
M21598 U5946/net6 U5946/net4 VSS VSS nmos W=0.17u L=0.04u
M21599 n5395 U5946/net14 VSS VSS nmos W=0.155u L=0.04u
M21600 U5946/net10 n5277 VSS VSS nmos W=0.155u L=0.04u
M21601 U5946/net4 U5946/net10 U5946/net14 VDD pmos W=0.255u L=0.04u
M21602 U5946/net6 n5277 U5946/net14 VDD pmos W=0.28u L=0.04u
M21603 U5946/net4 n4070 VDD VDD pmos W=0.205u L=0.04u
M21604 U5946/net6 U5946/net4 VDD VDD pmos W=0.24u L=0.04u
M21605 n5395 U5946/net14 VDD VDD pmos W=0.205u L=0.04u
M21606 U5946/net10 n5277 VDD VDD pmos W=0.205u L=0.04u
M21607 n4070 n5383 VSS VSS nmos W=0.135u L=0.04u
M21608 n4070 n5383 VDD VDD pmos W=0.205u L=0.04u
M21609 n5383 n5210 U5948/net27 VSS nmos W=0.155u L=0.04u
M21610 U5948/net39 n5212 VSS VSS nmos W=0.155u L=0.04u
M21611 U5948/net27 g1556 U5948/net39 VSS nmos W=0.155u L=0.04u
M21612 U5948/net27 n5211 U5948/net39 VSS nmos W=0.155u L=0.04u
M21613 n5383 g1557 U5948/net27 VSS nmos W=0.155u L=0.04u
M21614 U5948/net39 g1558 VSS VSS nmos W=0.155u L=0.04u
M21615 n5383 n5212 U5948/net46 VDD pmos W=0.205u L=0.04u
M21616 U5948/net46 g1558 VDD VDD pmos W=0.205u L=0.04u
M21617 n5383 g1557 U5948/net34 VDD pmos W=0.205u L=0.04u
M21618 U5948/net34 n5210 VDD VDD pmos W=0.205u L=0.04u
M21619 n5383 n5211 U5948/net37 VDD pmos W=0.205u L=0.04u
M21620 U5948/net37 g1556 VDD VDD pmos W=0.205u L=0.04u
M21621 n5340 n5191 U5949/net27 VSS nmos W=0.155u L=0.04u
M21622 U5949/net39 n4334 VSS VSS nmos W=0.155u L=0.04u
M21623 U5949/net27 g1702 U5949/net39 VSS nmos W=0.155u L=0.04u
M21624 U5949/net27 n5192 U5949/net39 VSS nmos W=0.155u L=0.04u
M21625 n5340 g1703 U5949/net27 VSS nmos W=0.155u L=0.04u
M21626 U5949/net39 g1704 VSS VSS nmos W=0.155u L=0.04u
M21627 n5340 n4334 U5949/net46 VDD pmos W=0.205u L=0.04u
M21628 U5949/net46 g1704 VDD VDD pmos W=0.205u L=0.04u
M21629 n5340 g1703 U5949/net34 VDD pmos W=0.205u L=0.04u
M21630 U5949/net34 n5191 VDD VDD pmos W=0.205u L=0.04u
M21631 n5340 n5192 U5949/net37 VDD pmos W=0.205u L=0.04u
M21632 U5949/net37 g1702 VDD VDD pmos W=0.205u L=0.04u
M21633 n5324 n5249 VSS VSS nmos W=0.135u L=0.04u
M21634 n5324 n5249 VDD VDD pmos W=0.205u L=0.04u
M21635 n5357 n5355 U5951/net27 VSS nmos W=0.155u L=0.04u
M21636 U5951/net27 n5347 VSS VSS nmos W=0.155u L=0.04u
M21637 n5357 n5354 VSS VSS nmos W=0.155u L=0.04u
M21638 n5357 n5347 U5951/net13 VDD pmos W=0.205u L=0.04u
M21639 U5951/net13 n5354 VDD VDD pmos W=0.205u L=0.04u
M21640 n5357 n5355 U5951/net13 VDD pmos W=0.205u L=0.04u
M21641 n5354 U5952/net6 VSS VSS nmos W=0.155u L=0.04u
M21642 U5952/net6 n5401 U5952/XU30-net23 VSS nmos W=0.155u L=0.04u
M21643 U5952/XU30-net23 n5352 U5952/XU30-net26 VSS nmos W=0.155u L=0.04u
M21644 U5952/XU30-net26 n5250 U5952/XU30-net29 VSS nmos W=0.155u L=0.04u
M21645 U5952/XU30-net29 n5402 VSS VSS nmos W=0.155u L=0.04u
M21646 n5354 U5952/net6 VDD VDD pmos W=0.205u L=0.04u
M21647 U5952/net6 n5402 VDD VDD pmos W=0.205u L=0.04u
M21648 U5952/net6 n5250 VDD VDD pmos W=0.205u L=0.04u
M21649 U5952/net6 n5352 VDD VDD pmos W=0.205u L=0.04u
M21650 U5952/net6 n5401 VDD VDD pmos W=0.205u L=0.04u
M21651 n5402 n5296 VSS VSS nmos W=0.155u L=0.04u
M21652 n5402 n5274 VSS VSS nmos W=0.155u L=0.04u
M21653 n5402 n5288 VSS VSS nmos W=0.155u L=0.04u
M21654 n5402 n5277 VSS VSS nmos W=0.155u L=0.04u
M21655 U5953/net49 n5274 U5953/net52 VDD pmos W=0.41u L=0.04u
M21656 U5953/net52 n5296 VDD VDD pmos W=0.41u L=0.04u
M21657 U5953/net46 n5288 U5953/net49 VDD pmos W=0.41u L=0.04u
M21658 n5402 n5277 U5953/net46 VDD pmos W=0.41u L=0.04u
M21659 n5268 n5250 VSS VSS nmos W=0.155u L=0.04u
M21660 n5268 n4062 VSS VSS nmos W=0.155u L=0.04u
M21661 U5954/XI1-net8 n4062 VDD VDD pmos W=0.205u L=0.04u
M21662 n5268 n5250 U5954/XI1-net8 VDD pmos W=0.205u L=0.04u
M21663 n5250 n5347 VSS VSS nmos W=0.135u L=0.04u
M21664 n5250 n5347 VDD VDD pmos W=0.205u L=0.04u
M21665 U5956/XU1-net6 n5307 VSS VSS nmos W=0.155u L=0.04u
M21666 n5347 n5320 U5956/XU1-net6 VSS nmos W=0.155u L=0.04u
M21667 n5347 n5307 VDD VDD pmos W=0.155u L=0.04u
M21668 n5347 n5320 VDD VDD pmos W=0.155u L=0.04u
M21669 n5307 n5315 VSS VSS nmos W=0.135u L=0.04u
M21670 n5307 n5315 VDD VDD pmos W=0.205u L=0.04u
M21671 U5958/net19 g2879 VSS VSS nmos W=0.155u L=0.04u
M21672 n2920 g2879 U5958/net40 VSS nmos W=0.155u L=0.04u
M21673 n2920 U5958/net19 U5958/net36 VSS nmos W=0.155u L=0.04u
M21674 U5958/net40 g2959 VSS VSS nmos W=0.31u L=0.04u
M21675 U5958/net36 g1506 VSS VSS nmos W=0.155u L=0.04u
M21676 U5958/net19 g2879 VDD VDD pmos W=0.205u L=0.04u
M21677 n2920 U5958/net19 U5958/net26 VDD pmos W=0.325u L=0.04u
M21678 U5958/net26 g2959 VDD VDD pmos W=0.41u L=0.04u
M21679 n2920 g2879 U5958/net30 VDD pmos W=0.325u L=0.04u
M21680 U5958/net30 g1506 VDD VDD pmos W=0.205u L=0.04u
M21681 U5959/net19 g2879 VSS VSS nmos W=0.155u L=0.04u
M21682 n2919 g2879 U5959/net40 VSS nmos W=0.155u L=0.04u
M21683 n2919 U5959/net19 U5959/net36 VSS nmos W=0.155u L=0.04u
M21684 U5959/net40 g2956 VSS VSS nmos W=0.31u L=0.04u
M21685 U5959/net36 g1501 VSS VSS nmos W=0.155u L=0.04u
M21686 U5959/net19 g2879 VDD VDD pmos W=0.205u L=0.04u
M21687 n2919 U5959/net19 U5959/net26 VDD pmos W=0.325u L=0.04u
M21688 U5959/net26 g2956 VDD VDD pmos W=0.41u L=0.04u
M21689 n2919 g2879 U5959/net30 VDD pmos W=0.325u L=0.04u
M21690 U5959/net30 g1501 VDD VDD pmos W=0.205u L=0.04u
M21691 U5960/net19 g2879 VSS VSS nmos W=0.155u L=0.04u
M21692 n2918 g2879 U5960/net40 VSS nmos W=0.155u L=0.04u
M21693 n2918 U5960/net19 U5960/net36 VSS nmos W=0.155u L=0.04u
M21694 U5960/net40 g2953 VSS VSS nmos W=0.31u L=0.04u
M21695 U5960/net36 g1496 VSS VSS nmos W=0.155u L=0.04u
M21696 U5960/net19 g2879 VDD VDD pmos W=0.205u L=0.04u
M21697 n2918 U5960/net19 U5960/net26 VDD pmos W=0.325u L=0.04u
M21698 U5960/net26 g2953 VDD VDD pmos W=0.41u L=0.04u
M21699 n2918 g2879 U5960/net30 VDD pmos W=0.325u L=0.04u
M21700 U5960/net30 g1496 VDD VDD pmos W=0.205u L=0.04u
M21701 U5961/net19 g2879 VSS VSS nmos W=0.155u L=0.04u
M21702 n2917 g2879 U5961/net40 VSS nmos W=0.155u L=0.04u
M21703 n2917 U5961/net19 U5961/net36 VSS nmos W=0.155u L=0.04u
M21704 U5961/net40 g2947 VSS VSS nmos W=0.31u L=0.04u
M21705 U5961/net36 g1491 VSS VSS nmos W=0.155u L=0.04u
M21706 U5961/net19 g2879 VDD VDD pmos W=0.205u L=0.04u
M21707 n2917 U5961/net19 U5961/net26 VDD pmos W=0.325u L=0.04u
M21708 U5961/net26 g2947 VDD VDD pmos W=0.41u L=0.04u
M21709 n2917 g2879 U5961/net30 VDD pmos W=0.325u L=0.04u
M21710 U5961/net30 g1491 VDD VDD pmos W=0.205u L=0.04u
M21711 U5962/net19 g2879 VSS VSS nmos W=0.155u L=0.04u
M21712 n2916 g2879 U5962/net40 VSS nmos W=0.155u L=0.04u
M21713 n2916 U5962/net19 U5962/net36 VSS nmos W=0.155u L=0.04u
M21714 U5962/net40 g2944 VSS VSS nmos W=0.31u L=0.04u
M21715 U5962/net36 g1486 VSS VSS nmos W=0.155u L=0.04u
M21716 U5962/net19 g2879 VDD VDD pmos W=0.205u L=0.04u
M21717 n2916 U5962/net19 U5962/net26 VDD pmos W=0.325u L=0.04u
M21718 U5962/net26 g2944 VDD VDD pmos W=0.41u L=0.04u
M21719 n2916 g2879 U5962/net30 VDD pmos W=0.325u L=0.04u
M21720 U5962/net30 g1486 VDD VDD pmos W=0.205u L=0.04u
M21721 U5963/net19 g2879 VSS VSS nmos W=0.155u L=0.04u
M21722 n2915 g2879 U5963/net40 VSS nmos W=0.155u L=0.04u
M21723 n2915 U5963/net19 U5963/net36 VSS nmos W=0.155u L=0.04u
M21724 U5963/net40 g2966 VSS VSS nmos W=0.31u L=0.04u
M21725 U5963/net36 g2170 VSS VSS nmos W=0.155u L=0.04u
M21726 U5963/net19 g2879 VDD VDD pmos W=0.205u L=0.04u
M21727 n2915 U5963/net19 U5963/net26 VDD pmos W=0.325u L=0.04u
M21728 U5963/net26 g2966 VDD VDD pmos W=0.41u L=0.04u
M21729 n2915 g2879 U5963/net30 VDD pmos W=0.325u L=0.04u
M21730 U5963/net30 g2170 VDD VDD pmos W=0.205u L=0.04u
M21731 U5964/net19 g2879 VSS VSS nmos W=0.155u L=0.04u
M21732 n2914 g2879 U5964/net40 VSS nmos W=0.155u L=0.04u
M21733 n2914 U5964/net19 U5964/net36 VSS nmos W=0.155u L=0.04u
M21734 U5964/net40 g2941 VSS VSS nmos W=0.31u L=0.04u
M21735 U5964/net36 g1481 VSS VSS nmos W=0.155u L=0.04u
M21736 U5964/net19 g2879 VDD VDD pmos W=0.205u L=0.04u
M21737 n2914 U5964/net19 U5964/net26 VDD pmos W=0.325u L=0.04u
M21738 U5964/net26 g2941 VDD VDD pmos W=0.41u L=0.04u
M21739 n2914 g2879 U5964/net30 VDD pmos W=0.325u L=0.04u
M21740 U5964/net30 g1481 VDD VDD pmos W=0.205u L=0.04u
M21741 U5965/net19 g2879 VSS VSS nmos W=0.155u L=0.04u
M21742 n2913 g2879 U5965/net40 VSS nmos W=0.155u L=0.04u
M21743 n2913 U5965/net19 U5965/net36 VSS nmos W=0.155u L=0.04u
M21744 U5965/net40 g2938 VSS VSS nmos W=0.31u L=0.04u
M21745 U5965/net36 g1476 VSS VSS nmos W=0.155u L=0.04u
M21746 U5965/net19 g2879 VDD VDD pmos W=0.205u L=0.04u
M21747 n2913 U5965/net19 U5965/net26 VDD pmos W=0.325u L=0.04u
M21748 U5965/net26 g2938 VDD VDD pmos W=0.41u L=0.04u
M21749 n2913 g2879 U5965/net30 VDD pmos W=0.325u L=0.04u
M21750 U5965/net30 g1476 VDD VDD pmos W=0.205u L=0.04u
M21751 U5966/net19 g2879 VSS VSS nmos W=0.155u L=0.04u
M21752 n2912 g2879 U5966/net40 VSS nmos W=0.155u L=0.04u
M21753 n2912 U5966/net19 U5966/net36 VSS nmos W=0.155u L=0.04u
M21754 U5966/net40 g2969 VSS VSS nmos W=0.31u L=0.04u
M21755 U5966/net36 g2175 VSS VSS nmos W=0.155u L=0.04u
M21756 U5966/net19 g2879 VDD VDD pmos W=0.205u L=0.04u
M21757 n2912 U5966/net19 U5966/net26 VDD pmos W=0.325u L=0.04u
M21758 U5966/net26 g2969 VDD VDD pmos W=0.41u L=0.04u
M21759 n2912 g2879 U5966/net30 VDD pmos W=0.325u L=0.04u
M21760 U5966/net30 g2175 VDD VDD pmos W=0.205u L=0.04u
M21761 U5967/net19 g2879 VSS VSS nmos W=0.155u L=0.04u
M21762 n2911 g2879 U5967/net40 VSS nmos W=0.155u L=0.04u
M21763 n2911 U5967/net19 U5967/net36 VSS nmos W=0.155u L=0.04u
M21764 U5967/net40 g2935 VSS VSS nmos W=0.31u L=0.04u
M21765 U5967/net36 g1471 VSS VSS nmos W=0.155u L=0.04u
M21766 U5967/net19 g2879 VDD VDD pmos W=0.205u L=0.04u
M21767 n2911 U5967/net19 U5967/net26 VDD pmos W=0.325u L=0.04u
M21768 U5967/net26 g2935 VDD VDD pmos W=0.41u L=0.04u
M21769 n2911 g2879 U5967/net30 VDD pmos W=0.325u L=0.04u
M21770 U5967/net30 g1471 VDD VDD pmos W=0.205u L=0.04u
M21771 U5968/net19 g2879 VSS VSS nmos W=0.155u L=0.04u
M21772 n2910 g2879 U5968/net40 VSS nmos W=0.155u L=0.04u
M21773 n2910 U5968/net19 U5968/net36 VSS nmos W=0.155u L=0.04u
M21774 U5968/net40 g2874 VSS VSS nmos W=0.31u L=0.04u
M21775 U5968/net36 g2200 VSS VSS nmos W=0.155u L=0.04u
M21776 U5968/net19 g2879 VDD VDD pmos W=0.205u L=0.04u
M21777 n2910 U5968/net19 U5968/net26 VDD pmos W=0.325u L=0.04u
M21778 U5968/net26 g2874 VDD VDD pmos W=0.41u L=0.04u
M21779 n2910 g2879 U5968/net30 VDD pmos W=0.325u L=0.04u
M21780 U5968/net30 g2200 VDD VDD pmos W=0.205u L=0.04u
M21781 U5969/net19 g2879 VSS VSS nmos W=0.155u L=0.04u
M21782 n2909 g2879 U5969/net40 VSS nmos W=0.155u L=0.04u
M21783 n2909 U5969/net19 U5969/net36 VSS nmos W=0.155u L=0.04u
M21784 U5969/net40 n5403 VSS VSS nmos W=0.31u L=0.04u
M21785 U5969/net36 g2877 VSS VSS nmos W=0.155u L=0.04u
M21786 U5969/net19 g2879 VDD VDD pmos W=0.205u L=0.04u
M21787 n2909 U5969/net19 U5969/net26 VDD pmos W=0.325u L=0.04u
M21788 U5969/net26 n5403 VDD VDD pmos W=0.41u L=0.04u
M21789 n2909 g2879 U5969/net30 VDD pmos W=0.325u L=0.04u
M21790 U5969/net30 g2877 VDD VDD pmos W=0.205u L=0.04u
M21791 U5970/net19 g2879 VSS VSS nmos W=0.155u L=0.04u
M21792 n2908 g2879 U5970/net40 VSS nmos W=0.155u L=0.04u
M21793 n2908 U5970/net19 U5970/net36 VSS nmos W=0.155u L=0.04u
M21794 U5970/net40 g2972 VSS VSS nmos W=0.31u L=0.04u
M21795 U5970/net36 g2180 VSS VSS nmos W=0.155u L=0.04u
M21796 U5970/net19 g2879 VDD VDD pmos W=0.205u L=0.04u
M21797 n2908 U5970/net19 U5970/net26 VDD pmos W=0.325u L=0.04u
M21798 U5970/net26 g2972 VDD VDD pmos W=0.41u L=0.04u
M21799 n2908 g2879 U5970/net30 VDD pmos W=0.325u L=0.04u
M21800 U5970/net30 g2180 VDD VDD pmos W=0.205u L=0.04u
M21801 U5971/net19 g2879 VSS VSS nmos W=0.155u L=0.04u
M21802 n2907 g2879 U5971/net40 VSS nmos W=0.155u L=0.04u
M21803 n2907 U5971/net19 U5971/net36 VSS nmos W=0.155u L=0.04u
M21804 U5971/net40 n5404 VSS VSS nmos W=0.31u L=0.04u
M21805 U5971/net36 g2878 VSS VSS nmos W=0.155u L=0.04u
M21806 U5971/net19 g2879 VDD VDD pmos W=0.205u L=0.04u
M21807 n2907 U5971/net19 U5971/net26 VDD pmos W=0.325u L=0.04u
M21808 U5971/net26 n5404 VDD VDD pmos W=0.41u L=0.04u
M21809 n2907 g2879 U5971/net30 VDD pmos W=0.325u L=0.04u
M21810 U5971/net30 g2878 VDD VDD pmos W=0.205u L=0.04u
M21811 U5972/net19 g2879 VSS VSS nmos W=0.155u L=0.04u
M21812 n2906 g2879 U5972/net40 VSS nmos W=0.155u L=0.04u
M21813 n2906 U5972/net19 U5972/net36 VSS nmos W=0.155u L=0.04u
M21814 U5972/net40 g2975 VSS VSS nmos W=0.31u L=0.04u
M21815 U5972/net36 g2185 VSS VSS nmos W=0.155u L=0.04u
M21816 U5972/net19 g2879 VDD VDD pmos W=0.205u L=0.04u
M21817 n2906 U5972/net19 U5972/net26 VDD pmos W=0.325u L=0.04u
M21818 U5972/net26 g2975 VDD VDD pmos W=0.41u L=0.04u
M21819 n2906 g2879 U5972/net30 VDD pmos W=0.325u L=0.04u
M21820 U5972/net30 g2185 VDD VDD pmos W=0.205u L=0.04u
M21821 U5973/net19 g2879 VSS VSS nmos W=0.155u L=0.04u
M21822 n2905 g2879 U5973/net40 VSS nmos W=0.155u L=0.04u
M21823 n2905 U5973/net19 U5973/net36 VSS nmos W=0.155u L=0.04u
M21824 U5973/net40 g2963 VSS VSS nmos W=0.31u L=0.04u
M21825 U5973/net36 g2165 VSS VSS nmos W=0.155u L=0.04u
M21826 U5973/net19 g2879 VDD VDD pmos W=0.205u L=0.04u
M21827 n2905 U5973/net19 U5973/net26 VDD pmos W=0.325u L=0.04u
M21828 U5973/net26 g2963 VDD VDD pmos W=0.41u L=0.04u
M21829 n2905 g2879 U5973/net30 VDD pmos W=0.325u L=0.04u
M21830 U5973/net30 g2165 VDD VDD pmos W=0.205u L=0.04u
M21831 U5974/net19 g2879 VSS VSS nmos W=0.155u L=0.04u
M21832 n2904 g2879 U5974/net40 VSS nmos W=0.155u L=0.04u
M21833 n2904 U5974/net19 U5974/net36 VSS nmos W=0.155u L=0.04u
M21834 U5974/net40 g2978 VSS VSS nmos W=0.31u L=0.04u
M21835 U5974/net36 g2190 VSS VSS nmos W=0.155u L=0.04u
M21836 U5974/net19 g2879 VDD VDD pmos W=0.205u L=0.04u
M21837 n2904 U5974/net19 U5974/net26 VDD pmos W=0.325u L=0.04u
M21838 U5974/net26 g2978 VDD VDD pmos W=0.41u L=0.04u
M21839 n2904 g2879 U5974/net30 VDD pmos W=0.325u L=0.04u
M21840 U5974/net30 g2190 VDD VDD pmos W=0.205u L=0.04u
M21841 U5975/net19 g2879 VSS VSS nmos W=0.155u L=0.04u
M21842 n2903 g2879 U5975/net40 VSS nmos W=0.155u L=0.04u
M21843 n2903 U5975/net19 U5975/net36 VSS nmos W=0.155u L=0.04u
M21844 U5975/net40 g2981 VSS VSS nmos W=0.31u L=0.04u
M21845 U5975/net36 g2195 VSS VSS nmos W=0.155u L=0.04u
M21846 U5975/net19 g2879 VDD VDD pmos W=0.205u L=0.04u
M21847 n2903 U5975/net19 U5975/net26 VDD pmos W=0.325u L=0.04u
M21848 U5975/net26 g2981 VDD VDD pmos W=0.41u L=0.04u
M21849 n2903 g2879 U5975/net30 VDD pmos W=0.325u L=0.04u
M21850 U5975/net30 g2195 VDD VDD pmos W=0.205u L=0.04u
M21851 U5976/net19 g2879 VSS VSS nmos W=0.155u L=0.04u
M21852 n2902 g2879 U5976/net40 VSS nmos W=0.155u L=0.04u
M21853 n2902 U5976/net19 U5976/net36 VSS nmos W=0.155u L=0.04u
M21854 U5976/net40 g6225 VSS VSS nmos W=0.31u L=0.04u
M21855 U5976/net36 g2972 VSS VSS nmos W=0.155u L=0.04u
M21856 U5976/net19 g2879 VDD VDD pmos W=0.205u L=0.04u
M21857 n2902 U5976/net19 U5976/net26 VDD pmos W=0.325u L=0.04u
M21858 U5976/net26 g6225 VDD VDD pmos W=0.41u L=0.04u
M21859 n2902 g2879 U5976/net30 VDD pmos W=0.325u L=0.04u
M21860 U5976/net30 g2972 VDD VDD pmos W=0.205u L=0.04u
M21861 U5977/net19 g2879 VSS VSS nmos W=0.155u L=0.04u
M21862 n2901 g2879 U5977/net40 VSS nmos W=0.155u L=0.04u
M21863 n2901 U5977/net19 U5977/net36 VSS nmos W=0.155u L=0.04u
M21864 U5977/net40 g6442 VSS VSS nmos W=0.31u L=0.04u
M21865 U5977/net36 g2969 VSS VSS nmos W=0.155u L=0.04u
M21866 U5977/net19 g2879 VDD VDD pmos W=0.205u L=0.04u
M21867 n2901 U5977/net19 U5977/net26 VDD pmos W=0.325u L=0.04u
M21868 U5977/net26 g6442 VDD VDD pmos W=0.41u L=0.04u
M21869 n2901 g2879 U5977/net30 VDD pmos W=0.325u L=0.04u
M21870 U5977/net30 g2969 VDD VDD pmos W=0.205u L=0.04u
M21871 U5978/net19 g2879 VSS VSS nmos W=0.155u L=0.04u
M21872 n2900 g2879 U5978/net40 VSS nmos W=0.155u L=0.04u
M21873 n2900 U5978/net19 U5978/net36 VSS nmos W=0.155u L=0.04u
M21874 U5978/net40 g6895 VSS VSS nmos W=0.31u L=0.04u
M21875 U5978/net36 g2966 VSS VSS nmos W=0.155u L=0.04u
M21876 U5978/net19 g2879 VDD VDD pmos W=0.205u L=0.04u
M21877 n2900 U5978/net19 U5978/net26 VDD pmos W=0.325u L=0.04u
M21878 U5978/net26 g6895 VDD VDD pmos W=0.41u L=0.04u
M21879 n2900 g2879 U5978/net30 VDD pmos W=0.325u L=0.04u
M21880 U5978/net30 g2966 VDD VDD pmos W=0.205u L=0.04u
M21881 U5979/net19 g2879 VSS VSS nmos W=0.155u L=0.04u
M21882 n2899 g2879 U5979/net40 VSS nmos W=0.155u L=0.04u
M21883 n2899 U5979/net19 U5979/net36 VSS nmos W=0.155u L=0.04u
M21884 U5979/net40 g7334 VSS VSS nmos W=0.31u L=0.04u
M21885 U5979/net36 g2963 VSS VSS nmos W=0.155u L=0.04u
M21886 U5979/net19 g2879 VDD VDD pmos W=0.205u L=0.04u
M21887 n2899 U5979/net19 U5979/net26 VDD pmos W=0.325u L=0.04u
M21888 U5979/net26 g7334 VDD VDD pmos W=0.41u L=0.04u
M21889 n2899 g2879 U5979/net30 VDD pmos W=0.325u L=0.04u
M21890 U5979/net30 g2963 VDD VDD pmos W=0.205u L=0.04u
M21891 U5980/net19 g2879 VSS VSS nmos W=0.155u L=0.04u
M21892 n2898 g2879 U5980/net40 VSS nmos W=0.155u L=0.04u
M21893 n2898 U5980/net19 U5980/net36 VSS nmos W=0.155u L=0.04u
M21894 U5980/net40 g7519 VSS VSS nmos W=0.31u L=0.04u
M21895 U5980/net36 n5404 VSS VSS nmos W=0.155u L=0.04u
M21896 U5980/net19 g2879 VDD VDD pmos W=0.205u L=0.04u
M21897 n2898 U5980/net19 U5980/net26 VDD pmos W=0.325u L=0.04u
M21898 U5980/net26 g7519 VDD VDD pmos W=0.41u L=0.04u
M21899 n2898 g2879 U5980/net30 VDD pmos W=0.325u L=0.04u
M21900 U5980/net30 n5404 VDD VDD pmos W=0.205u L=0.04u
M21901 U5981/XU1-net6 n5406 VSS VSS nmos W=0.155u L=0.04u
M21902 n5404 n5405 U5981/XU1-net6 VSS nmos W=0.155u L=0.04u
M21903 n5404 n5406 VDD VDD pmos W=0.155u L=0.04u
M21904 n5404 n5405 VDD VDD pmos W=0.155u L=0.04u
M21905 U5982/XU1-net6 n5408 VSS VSS nmos W=0.155u L=0.04u
M21906 n5406 n5407 U5982/XU1-net6 VSS nmos W=0.155u L=0.04u
M21907 n5406 n5408 VDD VDD pmos W=0.155u L=0.04u
M21908 n5406 n5407 VDD VDD pmos W=0.155u L=0.04u
M21909 U5983/XU1-net6 n5410 VSS VSS nmos W=0.155u L=0.04u
M21910 n5405 n5409 U5983/XU1-net6 VSS nmos W=0.155u L=0.04u
M21911 n5405 n5410 VDD VDD pmos W=0.155u L=0.04u
M21912 n5405 n5409 VDD VDD pmos W=0.155u L=0.04u
M21913 n5409 n5408 VSS VSS nmos W=0.135u L=0.04u
M21914 n5409 n5408 VDD VDD pmos W=0.205u L=0.04u
M21915 U5985/net19 g2879 VSS VSS nmos W=0.155u L=0.04u
M21916 n2897 g2879 U5985/net40 VSS nmos W=0.155u L=0.04u
M21917 n2897 U5985/net19 U5985/net36 VSS nmos W=0.155u L=0.04u
M21918 U5985/net40 g8023 VSS VSS nmos W=0.31u L=0.04u
M21919 U5985/net36 g2947 VSS VSS nmos W=0.155u L=0.04u
M21920 U5985/net19 g2879 VDD VDD pmos W=0.205u L=0.04u
M21921 n2897 U5985/net19 U5985/net26 VDD pmos W=0.325u L=0.04u
M21922 U5985/net26 g8023 VDD VDD pmos W=0.41u L=0.04u
M21923 n2897 g2879 U5985/net30 VDD pmos W=0.325u L=0.04u
M21924 U5985/net30 g2947 VDD VDD pmos W=0.205u L=0.04u
M21925 U5986/net19 g2879 VSS VSS nmos W=0.155u L=0.04u
M21926 n2896 g2879 U5986/net40 VSS nmos W=0.155u L=0.04u
M21927 n2896 U5986/net19 U5986/net36 VSS nmos W=0.155u L=0.04u
M21928 U5986/net40 g8096 VSS VSS nmos W=0.31u L=0.04u
M21929 U5986/net36 n5403 VSS VSS nmos W=0.155u L=0.04u
M21930 U5986/net19 g2879 VDD VDD pmos W=0.205u L=0.04u
M21931 n2896 U5986/net19 U5986/net26 VDD pmos W=0.325u L=0.04u
M21932 U5986/net26 g8096 VDD VDD pmos W=0.41u L=0.04u
M21933 n2896 g2879 U5986/net30 VDD pmos W=0.325u L=0.04u
M21934 U5986/net30 n5403 VDD VDD pmos W=0.205u L=0.04u
M21935 U5987/XU1-net6 n5412 VSS VSS nmos W=0.155u L=0.04u
M21936 n5403 n5411 U5987/XU1-net6 VSS nmos W=0.155u L=0.04u
M21937 n5403 n5412 VDD VDD pmos W=0.155u L=0.04u
M21938 n5403 n5411 VDD VDD pmos W=0.155u L=0.04u
M21939 U5988/XU1-net6 n5413 VSS VSS nmos W=0.155u L=0.04u
M21940 n5412 n5407 U5988/XU1-net6 VSS nmos W=0.155u L=0.04u
M21941 n5412 n5413 VDD VDD pmos W=0.155u L=0.04u
M21942 n5412 n5407 VDD VDD pmos W=0.155u L=0.04u
M21943 U5989/XU1-net6 n5410 VSS VSS nmos W=0.155u L=0.04u
M21944 n5411 n5414 U5989/XU1-net6 VSS nmos W=0.155u L=0.04u
M21945 n5411 n5410 VDD VDD pmos W=0.155u L=0.04u
M21946 n5411 n5414 VDD VDD pmos W=0.155u L=0.04u
M21947 n5410 n5407 VSS VSS nmos W=0.135u L=0.04u
M21948 n5410 n5407 VDD VDD pmos W=0.205u L=0.04u
M21949 n5407 n5415 VSS VSS nmos W=0.155u L=0.04u
M21950 n5407 g3231 VSS VSS nmos W=0.155u L=0.04u
M21951 U5991/XI1-net8 g3231 VDD VDD pmos W=0.205u L=0.04u
M21952 n5407 n5415 U5991/XI1-net8 VDD pmos W=0.205u L=0.04u
M21953 n5414 n5413 VSS VSS nmos W=0.135u L=0.04u
M21954 n5414 n5413 VDD VDD pmos W=0.205u L=0.04u
M21955 U5993/net19 g2879 VSS VSS nmos W=0.155u L=0.04u
M21956 n2895 g2879 U5993/net40 VSS nmos W=0.155u L=0.04u
M21957 n2895 U5993/net19 U5993/net36 VSS nmos W=0.155u L=0.04u
M21958 U5993/net40 g8175 VSS VSS nmos W=0.31u L=0.04u
M21959 U5993/net36 g2944 VSS VSS nmos W=0.155u L=0.04u
M21960 U5993/net19 g2879 VDD VDD pmos W=0.205u L=0.04u
M21961 n2895 U5993/net19 U5993/net26 VDD pmos W=0.325u L=0.04u
M21962 U5993/net26 g8175 VDD VDD pmos W=0.41u L=0.04u
M21963 n2895 g2879 U5993/net30 VDD pmos W=0.325u L=0.04u
M21964 U5993/net30 g2944 VDD VDD pmos W=0.205u L=0.04u
M21965 U5994/net19 g2879 VSS VSS nmos W=0.155u L=0.04u
M21966 n2894 g2879 U5994/net40 VSS nmos W=0.155u L=0.04u
M21967 n2894 U5994/net19 U5994/net36 VSS nmos W=0.155u L=0.04u
M21968 U5994/net40 g8249 VSS VSS nmos W=0.31u L=0.04u
M21969 U5994/net36 g2959 VSS VSS nmos W=0.155u L=0.04u
M21970 U5994/net19 g2879 VDD VDD pmos W=0.205u L=0.04u
M21971 n2894 U5994/net19 U5994/net26 VDD pmos W=0.325u L=0.04u
M21972 U5994/net26 g8249 VDD VDD pmos W=0.41u L=0.04u
M21973 n2894 g2879 U5994/net30 VDD pmos W=0.325u L=0.04u
M21974 U5994/net30 g2959 VDD VDD pmos W=0.205u L=0.04u
M21975 U5995/net19 g2879 VSS VSS nmos W=0.155u L=0.04u
M21976 n2893 g2879 U5995/net40 VSS nmos W=0.155u L=0.04u
M21977 n2893 U5995/net19 U5995/net36 VSS nmos W=0.155u L=0.04u
M21978 U5995/net40 g8251 VSS VSS nmos W=0.31u L=0.04u
M21979 U5995/net36 g2874 VSS VSS nmos W=0.155u L=0.04u
M21980 U5995/net19 g2879 VDD VDD pmos W=0.205u L=0.04u
M21981 n2893 U5995/net19 U5995/net26 VDD pmos W=0.325u L=0.04u
M21982 U5995/net26 g8251 VDD VDD pmos W=0.41u L=0.04u
M21983 n2893 g2879 U5995/net30 VDD pmos W=0.325u L=0.04u
M21984 U5995/net30 g2874 VDD VDD pmos W=0.205u L=0.04u
M21985 U5996/net19 g2879 VSS VSS nmos W=0.155u L=0.04u
M21986 n2892 g2879 U5996/net40 VSS nmos W=0.155u L=0.04u
M21987 n2892 U5996/net19 U5996/net36 VSS nmos W=0.155u L=0.04u
M21988 U5996/net40 g3993 VSS VSS nmos W=0.31u L=0.04u
M21989 U5996/net36 g2941 VSS VSS nmos W=0.155u L=0.04u
M21990 U5996/net19 g2879 VDD VDD pmos W=0.205u L=0.04u
M21991 n2892 U5996/net19 U5996/net26 VDD pmos W=0.325u L=0.04u
M21992 U5996/net26 g3993 VDD VDD pmos W=0.41u L=0.04u
M21993 n2892 g2879 U5996/net30 VDD pmos W=0.325u L=0.04u
M21994 U5996/net30 g2941 VDD VDD pmos W=0.205u L=0.04u
M21995 U5997/net19 g2879 VSS VSS nmos W=0.155u L=0.04u
M21996 n2891 g2879 U5997/net40 VSS nmos W=0.155u L=0.04u
M21997 n2891 U5997/net19 U5997/net36 VSS nmos W=0.155u L=0.04u
M21998 U5997/net40 g4088 VSS VSS nmos W=0.31u L=0.04u
M21999 U5997/net36 g2956 VSS VSS nmos W=0.155u L=0.04u
M22000 U5997/net19 g2879 VDD VDD pmos W=0.205u L=0.04u
M22001 n2891 U5997/net19 U5997/net26 VDD pmos W=0.325u L=0.04u
M22002 U5997/net26 g4088 VDD VDD pmos W=0.41u L=0.04u
M22003 n2891 g2879 U5997/net30 VDD pmos W=0.325u L=0.04u
M22004 U5997/net30 g2956 VDD VDD pmos W=0.205u L=0.04u
M22005 U5998/net19 g2879 VSS VSS nmos W=0.155u L=0.04u
M22006 n2890 g2879 U5998/net40 VSS nmos W=0.155u L=0.04u
M22007 n2890 U5998/net19 U5998/net36 VSS nmos W=0.155u L=0.04u
M22008 U5998/net40 g4090 VSS VSS nmos W=0.31u L=0.04u
M22009 U5998/net36 g2981 VSS VSS nmos W=0.155u L=0.04u
M22010 U5998/net19 g2879 VDD VDD pmos W=0.205u L=0.04u
M22011 n2890 U5998/net19 U5998/net26 VDD pmos W=0.325u L=0.04u
M22012 U5998/net26 g4090 VDD VDD pmos W=0.41u L=0.04u
M22013 n2890 g2879 U5998/net30 VDD pmos W=0.325u L=0.04u
M22014 U5998/net30 g2981 VDD VDD pmos W=0.205u L=0.04u
M22015 U5999/net19 g2879 VSS VSS nmos W=0.155u L=0.04u
M22016 n2889 g2879 U5999/net40 VSS nmos W=0.155u L=0.04u
M22017 n2889 U5999/net19 U5999/net36 VSS nmos W=0.155u L=0.04u
M22018 U5999/net40 g4200 VSS VSS nmos W=0.31u L=0.04u
M22019 U5999/net36 g2938 VSS VSS nmos W=0.155u L=0.04u
M22020 U5999/net19 g2879 VDD VDD pmos W=0.205u L=0.04u
M22021 n2889 U5999/net19 U5999/net26 VDD pmos W=0.325u L=0.04u
M22022 U5999/net26 g4200 VDD VDD pmos W=0.41u L=0.04u
M22023 n2889 g2879 U5999/net30 VDD pmos W=0.325u L=0.04u
M22024 U5999/net30 g2938 VDD VDD pmos W=0.205u L=0.04u
M22025 U6000/net19 g2879 VSS VSS nmos W=0.155u L=0.04u
M22026 n2888 g2879 U6000/net40 VSS nmos W=0.155u L=0.04u
M22027 n2888 U6000/net19 U6000/net36 VSS nmos W=0.155u L=0.04u
M22028 U6000/net40 g4321 VSS VSS nmos W=0.31u L=0.04u
M22029 U6000/net36 g2953 VSS VSS nmos W=0.155u L=0.04u
M22030 U6000/net19 g2879 VDD VDD pmos W=0.205u L=0.04u
M22031 n2888 U6000/net19 U6000/net26 VDD pmos W=0.325u L=0.04u
M22032 U6000/net26 g4321 VDD VDD pmos W=0.41u L=0.04u
M22033 n2888 g2879 U6000/net30 VDD pmos W=0.325u L=0.04u
M22034 U6000/net30 g2953 VDD VDD pmos W=0.205u L=0.04u
M22035 U6001/net19 g2879 VSS VSS nmos W=0.155u L=0.04u
M22036 n2887 g2879 U6001/net40 VSS nmos W=0.155u L=0.04u
M22037 n2887 U6001/net19 U6001/net36 VSS nmos W=0.155u L=0.04u
M22038 U6001/net40 g4323 VSS VSS nmos W=0.31u L=0.04u
M22039 U6001/net36 g2978 VSS VSS nmos W=0.155u L=0.04u
M22040 U6001/net19 g2879 VDD VDD pmos W=0.205u L=0.04u
M22041 n2887 U6001/net19 U6001/net26 VDD pmos W=0.325u L=0.04u
M22042 U6001/net26 g4323 VDD VDD pmos W=0.41u L=0.04u
M22043 n2887 g2879 U6001/net30 VDD pmos W=0.325u L=0.04u
M22044 U6001/net30 g2978 VDD VDD pmos W=0.205u L=0.04u
M22045 U6002/net19 g2879 VSS VSS nmos W=0.155u L=0.04u
M22046 n2886 g2879 U6002/net40 VSS nmos W=0.155u L=0.04u
M22047 n2886 U6002/net19 U6002/net36 VSS nmos W=0.155u L=0.04u
M22048 U6002/net40 g4450 VSS VSS nmos W=0.31u L=0.04u
M22049 U6002/net36 g2935 VSS VSS nmos W=0.155u L=0.04u
M22050 U6002/net19 g2879 VDD VDD pmos W=0.205u L=0.04u
M22051 n2886 U6002/net19 U6002/net26 VDD pmos W=0.325u L=0.04u
M22052 U6002/net26 g4450 VDD VDD pmos W=0.41u L=0.04u
M22053 n2886 g2879 U6002/net30 VDD pmos W=0.325u L=0.04u
M22054 U6002/net30 g2935 VDD VDD pmos W=0.205u L=0.04u
M22055 U6003/net19 g2879 VSS VSS nmos W=0.155u L=0.04u
M22056 n2885 g2879 U6003/net40 VSS nmos W=0.155u L=0.04u
M22057 n2885 U6003/net19 U6003/net36 VSS nmos W=0.155u L=0.04u
M22058 U6003/net40 g4590 VSS VSS nmos W=0.31u L=0.04u
M22059 U6003/net36 g2975 VSS VSS nmos W=0.155u L=0.04u
M22060 U6003/net19 g2879 VDD VDD pmos W=0.205u L=0.04u
M22061 n2885 U6003/net19 U6003/net26 VDD pmos W=0.325u L=0.04u
M22062 U6003/net26 g4590 VDD VDD pmos W=0.41u L=0.04u
M22063 n2885 g2879 U6003/net30 VDD pmos W=0.325u L=0.04u
M22064 U6003/net30 g2975 VDD VDD pmos W=0.205u L=0.04u
M22065 U6004/net19 n5417 VSS VSS nmos W=0.155u L=0.04u
M22066 n2884 n5417 U6004/net40 VSS nmos W=0.155u L=0.04u
M22067 n2884 U6004/net19 U6004/net36 VSS nmos W=0.155u L=0.04u
M22068 U6004/net40 n5416 VSS VSS nmos W=0.31u L=0.04u
M22069 U6004/net36 g346 VSS VSS nmos W=0.155u L=0.04u
M22070 U6004/net19 n5417 VDD VDD pmos W=0.205u L=0.04u
M22071 n2884 U6004/net19 U6004/net26 VDD pmos W=0.325u L=0.04u
M22072 U6004/net26 n5416 VDD VDD pmos W=0.41u L=0.04u
M22073 n2884 n5417 U6004/net30 VDD pmos W=0.325u L=0.04u
M22074 U6004/net30 g346 VDD VDD pmos W=0.205u L=0.04u
M22075 U6005/net19 n5417 VSS VSS nmos W=0.155u L=0.04u
M22076 n2883 n5417 U6005/net40 VSS nmos W=0.155u L=0.04u
M22077 n2883 U6005/net19 U6005/net36 VSS nmos W=0.155u L=0.04u
M22078 U6005/net40 n5418 VSS VSS nmos W=0.31u L=0.04u
M22079 U6005/net36 g361 VSS VSS nmos W=0.155u L=0.04u
M22080 U6005/net19 n5417 VDD VDD pmos W=0.205u L=0.04u
M22081 n2883 U6005/net19 U6005/net26 VDD pmos W=0.325u L=0.04u
M22082 U6005/net26 n5418 VDD VDD pmos W=0.41u L=0.04u
M22083 n2883 n5417 U6005/net30 VDD pmos W=0.325u L=0.04u
M22084 U6005/net30 g361 VDD VDD pmos W=0.205u L=0.04u
M22085 U6006/net19 n5417 VSS VSS nmos W=0.155u L=0.04u
M22086 n2882 n5417 U6006/net40 VSS nmos W=0.155u L=0.04u
M22087 n2882 U6006/net19 U6006/net36 VSS nmos W=0.155u L=0.04u
M22088 U6006/net40 n5419 VSS VSS nmos W=0.31u L=0.04u
M22089 U6006/net36 g376 VSS VSS nmos W=0.155u L=0.04u
M22090 U6006/net19 n5417 VDD VDD pmos W=0.205u L=0.04u
M22091 n2882 U6006/net19 U6006/net26 VDD pmos W=0.325u L=0.04u
M22092 U6006/net26 n5419 VDD VDD pmos W=0.41u L=0.04u
M22093 n2882 n5417 U6006/net30 VDD pmos W=0.325u L=0.04u
M22094 U6006/net30 g376 VDD VDD pmos W=0.205u L=0.04u
M22095 U6007/net19 n5417 VSS VSS nmos W=0.155u L=0.04u
M22096 n2881 n5417 U6007/net40 VSS nmos W=0.155u L=0.04u
M22097 n2881 U6007/net19 U6007/net36 VSS nmos W=0.155u L=0.04u
M22098 U6007/net40 n5420 VSS VSS nmos W=0.31u L=0.04u
M22099 U6007/net36 g391 VSS VSS nmos W=0.155u L=0.04u
M22100 U6007/net19 n5417 VDD VDD pmos W=0.205u L=0.04u
M22101 n2881 U6007/net19 U6007/net26 VDD pmos W=0.325u L=0.04u
M22102 U6007/net26 n5420 VDD VDD pmos W=0.41u L=0.04u
M22103 n2881 n5417 U6007/net30 VDD pmos W=0.325u L=0.04u
M22104 U6007/net30 g391 VDD VDD pmos W=0.205u L=0.04u
M22105 n5417 n4751 VSS VSS nmos W=0.155u L=0.04u
M22106 n5417 n2872 VSS VSS nmos W=0.155u L=0.04u
M22107 U6008/XI1-net8 n2872 VDD VDD pmos W=0.205u L=0.04u
M22108 n5417 n4751 U6008/XI1-net8 VDD pmos W=0.205u L=0.04u
M22109 U6009/net19 n5421 VSS VSS nmos W=0.155u L=0.04u
M22110 n2880 n5421 U6009/net40 VSS nmos W=0.155u L=0.04u
M22111 n2880 U6009/net19 U6009/net36 VSS nmos W=0.155u L=0.04u
M22112 U6009/net40 n5416 VSS VSS nmos W=0.31u L=0.04u
M22113 U6009/net36 g343 VSS VSS nmos W=0.155u L=0.04u
M22114 U6009/net19 n5421 VDD VDD pmos W=0.205u L=0.04u
M22115 n2880 U6009/net19 U6009/net26 VDD pmos W=0.325u L=0.04u
M22116 U6009/net26 n5416 VDD VDD pmos W=0.41u L=0.04u
M22117 n2880 n5421 U6009/net30 VDD pmos W=0.325u L=0.04u
M22118 U6009/net30 g343 VDD VDD pmos W=0.205u L=0.04u
M22119 U6010/net19 n5422 VSS VSS nmos W=0.155u L=0.04u
M22120 n2879 n5422 U6010/net40 VSS nmos W=0.155u L=0.04u
M22121 n2879 U6010/net19 U6010/net36 VSS nmos W=0.155u L=0.04u
M22122 U6010/net40 n5416 VSS VSS nmos W=0.31u L=0.04u
M22123 U6010/net36 g354 VSS VSS nmos W=0.155u L=0.04u
M22124 U6010/net19 n5422 VDD VDD pmos W=0.205u L=0.04u
M22125 n2879 U6010/net19 U6010/net26 VDD pmos W=0.325u L=0.04u
M22126 U6010/net26 n5416 VDD VDD pmos W=0.41u L=0.04u
M22127 n2879 n5422 U6010/net30 VDD pmos W=0.325u L=0.04u
M22128 U6010/net30 g354 VDD VDD pmos W=0.205u L=0.04u
M22129 U6011/net7 n5423 U6011/X_u4-net10 VSS nmos W=0.155u L=0.04u
M22130 U6011/X_u4-net10 n5424 U6011/X_u4-net13 VSS nmos W=0.155u L=0.04u
M22131 U6011/X_u4-net13 n5425 VSS VSS nmos W=0.155u L=0.04u
M22132 n5416 U6011/net7 VSS VSS nmos W=0.155u L=0.04u
M22133 U6011/net7 n5425 VDD VDD pmos W=0.205u L=0.04u
M22134 U6011/net7 n5423 VDD VDD pmos W=0.205u L=0.04u
M22135 U6011/net7 n5424 VDD VDD pmos W=0.205u L=0.04u
M22136 n5416 U6011/net7 VDD VDD pmos W=0.205u L=0.04u
M22137 U6012/net19 n3937 VSS VSS nmos W=0.155u L=0.04u
M22138 n5425 n3937 U6012/net40 VSS nmos W=0.155u L=0.04u
M22139 n5425 U6012/net19 U6012/net36 VSS nmos W=0.155u L=0.04u
M22140 U6012/net40 n5427 VSS VSS nmos W=0.31u L=0.04u
M22141 U6012/net36 n5426 VSS VSS nmos W=0.155u L=0.04u
M22142 U6012/net19 n3937 VDD VDD pmos W=0.205u L=0.04u
M22143 n5425 U6012/net19 U6012/net26 VDD pmos W=0.325u L=0.04u
M22144 U6012/net26 n5427 VDD VDD pmos W=0.41u L=0.04u
M22145 n5425 n3937 U6012/net30 VDD pmos W=0.325u L=0.04u
M22146 U6012/net30 n5426 VDD VDD pmos W=0.205u L=0.04u
M22147 n5427 g11934 U6013/net15 VSS nmos W=0.155u L=0.04u
M22148 n5427 n5426 U6013/net15 VSS nmos W=0.155u L=0.04u
M22149 U6013/net15 n5428 VSS VSS nmos W=0.155u L=0.04u
M22150 n5427 n5428 VDD VDD pmos W=0.205u L=0.04u
M22151 n5427 g11934 U6013/XI16-net11 VDD pmos W=0.205u L=0.04u
M22152 U6013/XI16-net11 n5426 VDD VDD pmos W=0.205u L=0.04u
M22153 U6014/net19 n5421 VSS VSS nmos W=0.155u L=0.04u
M22154 n2878 n5421 U6014/net40 VSS nmos W=0.155u L=0.04u
M22155 n2878 U6014/net19 U6014/net36 VSS nmos W=0.155u L=0.04u
M22156 U6014/net40 n5418 VSS VSS nmos W=0.31u L=0.04u
M22157 U6014/net36 g358 VSS VSS nmos W=0.155u L=0.04u
M22158 U6014/net19 n5421 VDD VDD pmos W=0.205u L=0.04u
M22159 n2878 U6014/net19 U6014/net26 VDD pmos W=0.325u L=0.04u
M22160 U6014/net26 n5418 VDD VDD pmos W=0.41u L=0.04u
M22161 n2878 n5421 U6014/net30 VDD pmos W=0.325u L=0.04u
M22162 U6014/net30 g358 VDD VDD pmos W=0.205u L=0.04u
M22163 U6015/net19 n5422 VSS VSS nmos W=0.155u L=0.04u
M22164 n2877 n5422 U6015/net40 VSS nmos W=0.155u L=0.04u
M22165 n2877 U6015/net19 U6015/net36 VSS nmos W=0.155u L=0.04u
M22166 U6015/net40 n5418 VSS VSS nmos W=0.31u L=0.04u
M22167 U6015/net36 g369 VSS VSS nmos W=0.155u L=0.04u
M22168 U6015/net19 n5422 VDD VDD pmos W=0.205u L=0.04u
M22169 n2877 U6015/net19 U6015/net26 VDD pmos W=0.325u L=0.04u
M22170 U6015/net26 n5418 VDD VDD pmos W=0.41u L=0.04u
M22171 n2877 n5422 U6015/net30 VDD pmos W=0.325u L=0.04u
M22172 U6015/net30 g369 VDD VDD pmos W=0.205u L=0.04u
M22173 U6016/net36 n5428 U6016/net24 VSS nmos W=0.155u L=0.04u
M22174 U6016/net24 n5423 VSS VSS nmos W=0.155u L=0.04u
M22175 U6016/net33 n5429 U6016/net36 VSS nmos W=0.155u L=0.04u
M22176 U6016/net33 n5430 U6016/net36 VSS nmos W=0.155u L=0.04u
M22177 n5418 U6016/net33 VSS VSS nmos W=0.155u L=0.04u
M22178 n5418 U6016/net33 VDD VDD pmos W=0.205u L=0.04u
M22179 U6016/net33 n5430 U6016/net35 VDD pmos W=0.205u L=0.04u
M22180 U6016/net35 n5429 VDD VDD pmos W=0.205u L=0.04u
M22181 U6016/net33 n5423 VDD VDD pmos W=0.205u L=0.04u
M22182 U6016/net33 n5428 VDD VDD pmos W=0.205u L=0.04u
M22183 n5423 n5429 U6017/XI0-net10 VSS nmos W=0.155u L=0.04u
M22184 U6017/XI0-net10 n5431 U6017/XI0-net13 VSS nmos W=0.155u L=0.04u
M22185 U6017/XI0-net13 g3229 VSS VSS nmos W=0.155u L=0.04u
M22186 n5423 g3229 VDD VDD pmos W=0.205u L=0.04u
M22187 n5423 n5429 VDD VDD pmos W=0.205u L=0.04u
M22188 n5423 n5431 VDD VDD pmos W=0.205u L=0.04u
M22189 U6018/net13 g11974 VSS VSS nmos W=0.155u L=0.04u
M22190 U6018/net16 U6018/net13 VSS VSS nmos W=0.155u L=0.04u
M22191 n5428 g12026 U6018/net16 VSS nmos W=0.155u L=0.04u
M22192 U6018/net13 g11974 VDD VDD pmos W=0.205u L=0.04u
M22193 VDD U6018/net13 n5428 VDD pmos W=0.205u L=0.04u
M22194 VDD g12026 n5428 VDD pmos W=0.205u L=0.04u
M22195 U6019/XU1-net6 n3937 VSS VSS nmos W=0.155u L=0.04u
M22196 n5430 n5431 U6019/XU1-net6 VSS nmos W=0.155u L=0.04u
M22197 n5430 n3937 VDD VDD pmos W=0.155u L=0.04u
M22198 n5430 n5431 VDD VDD pmos W=0.155u L=0.04u
M22199 n5431 g12026 VSS VSS nmos W=0.135u L=0.04u
M22200 n5431 g12026 VDD VDD pmos W=0.205u L=0.04u
M22201 U6021/net19 n5421 VSS VSS nmos W=0.155u L=0.04u
M22202 n2876 n5421 U6021/net40 VSS nmos W=0.155u L=0.04u
M22203 n2876 U6021/net19 U6021/net36 VSS nmos W=0.155u L=0.04u
M22204 U6021/net40 n5419 VSS VSS nmos W=0.31u L=0.04u
M22205 U6021/net36 g373 VSS VSS nmos W=0.155u L=0.04u
M22206 U6021/net19 n5421 VDD VDD pmos W=0.205u L=0.04u
M22207 n2876 U6021/net19 U6021/net26 VDD pmos W=0.325u L=0.04u
M22208 U6021/net26 n5419 VDD VDD pmos W=0.41u L=0.04u
M22209 n2876 n5421 U6021/net30 VDD pmos W=0.325u L=0.04u
M22210 U6021/net30 g373 VDD VDD pmos W=0.205u L=0.04u
M22211 U6022/net19 n5422 VSS VSS nmos W=0.155u L=0.04u
M22212 n2875 n5422 U6022/net40 VSS nmos W=0.155u L=0.04u
M22213 n2875 U6022/net19 U6022/net36 VSS nmos W=0.155u L=0.04u
M22214 U6022/net40 n5419 VSS VSS nmos W=0.31u L=0.04u
M22215 U6022/net36 g384 VSS VSS nmos W=0.155u L=0.04u
M22216 U6022/net19 n5422 VDD VDD pmos W=0.205u L=0.04u
M22217 n2875 U6022/net19 U6022/net26 VDD pmos W=0.325u L=0.04u
M22218 U6022/net26 n5419 VDD VDD pmos W=0.41u L=0.04u
M22219 n2875 n5422 U6022/net30 VDD pmos W=0.325u L=0.04u
M22220 U6022/net30 g384 VDD VDD pmos W=0.205u L=0.04u
M22221 U6023/net36 n5424 U6023/net24 VSS nmos W=0.155u L=0.04u
M22222 U6023/net24 n5433 VSS VSS nmos W=0.155u L=0.04u
M22223 U6023/net33 g11974 U6023/net36 VSS nmos W=0.155u L=0.04u
M22224 U6023/net33 n5432 U6023/net36 VSS nmos W=0.155u L=0.04u
M22225 n5419 U6023/net33 VSS VSS nmos W=0.155u L=0.04u
M22226 n5419 U6023/net33 VDD VDD pmos W=0.205u L=0.04u
M22227 U6023/net33 n5432 U6023/net35 VDD pmos W=0.205u L=0.04u
M22228 U6023/net35 g11974 VDD VDD pmos W=0.205u L=0.04u
M22229 U6023/net33 n5433 VDD VDD pmos W=0.205u L=0.04u
M22230 U6023/net33 n5424 VDD VDD pmos W=0.205u L=0.04u
M22231 U6024/net19 g11974 VSS VSS nmos W=0.155u L=0.04u
M22232 n5433 g11974 U6024/net40 VSS nmos W=0.155u L=0.04u
M22233 n5433 U6024/net19 U6024/net36 VSS nmos W=0.155u L=0.04u
M22234 U6024/net40 n5435 VSS VSS nmos W=0.31u L=0.04u
M22235 U6024/net36 n5434 VSS VSS nmos W=0.155u L=0.04u
M22236 U6024/net19 g11974 VDD VDD pmos W=0.205u L=0.04u
M22237 n5433 U6024/net19 U6024/net26 VDD pmos W=0.325u L=0.04u
M22238 U6024/net26 n5435 VDD VDD pmos W=0.41u L=0.04u
M22239 n5433 g11974 U6024/net30 VDD pmos W=0.325u L=0.04u
M22240 U6024/net30 n5434 VDD VDD pmos W=0.205u L=0.04u
M22241 n5435 n5426 VSS VSS nmos W=0.155u L=0.04u
M22242 n5435 g3229 VSS VSS nmos W=0.155u L=0.04u
M22243 n5435 n5429 VSS VSS nmos W=0.155u L=0.04u
M22244 U6025/net25 n5426 VDD VDD pmos W=0.41u L=0.04u
M22245 U6025/net28 g3229 U6025/net25 VDD pmos W=0.41u L=0.04u
M22246 n5435 n5429 U6025/net28 VDD pmos W=0.41u L=0.04u
M22247 n5426 g12079 VSS VSS nmos W=0.135u L=0.04u
M22248 n5426 g12079 VDD VDD pmos W=0.205u L=0.04u
M22249 U6027/p2 n5429 VSS VSS nmos W=0.155u L=0.04u
M22250 U6027/p0 g11974 U6027/p1 VSS nmos W=0.155u L=0.04u
M22251 U6027/p1 g3229 U6027/p2 VSS nmos W=0.155u L=0.04u
M22252 n5424 g12079 U6027/p0 VSS nmos W=0.155u L=0.04u
M22253 n5424 g3229 VDD VDD pmos W=0.205u L=0.04u
M22254 n5424 g11974 VDD VDD pmos W=0.205u L=0.04u
M22255 n5424 g12079 VDD VDD pmos W=0.205u L=0.04u
M22256 n5424 n5429 VDD VDD pmos W=0.205u L=0.04u
M22257 n5432 n5436 VSS VSS nmos W=0.135u L=0.04u
M22258 n5432 n5436 VDD VDD pmos W=0.205u L=0.04u
M22259 U6029/net19 n5421 VSS VSS nmos W=0.155u L=0.04u
M22260 n2874 n5421 U6029/net40 VSS nmos W=0.155u L=0.04u
M22261 n2874 U6029/net19 U6029/net36 VSS nmos W=0.155u L=0.04u
M22262 U6029/net40 n5420 VSS VSS nmos W=0.31u L=0.04u
M22263 U6029/net36 g388 VSS VSS nmos W=0.155u L=0.04u
M22264 U6029/net19 n5421 VDD VDD pmos W=0.205u L=0.04u
M22265 n2874 U6029/net19 U6029/net26 VDD pmos W=0.325u L=0.04u
M22266 U6029/net26 n5420 VDD VDD pmos W=0.41u L=0.04u
M22267 n2874 n5421 U6029/net30 VDD pmos W=0.325u L=0.04u
M22268 U6029/net30 g388 VDD VDD pmos W=0.205u L=0.04u
M22269 n5421 n4750 VSS VSS nmos W=0.155u L=0.04u
M22270 n5421 n2872 VSS VSS nmos W=0.155u L=0.04u
M22271 U6030/XI1-net8 n2872 VDD VDD pmos W=0.205u L=0.04u
M22272 n5421 n4750 U6030/XI1-net8 VDD pmos W=0.205u L=0.04u
M22273 U6031/net19 n5422 VSS VSS nmos W=0.155u L=0.04u
M22274 n2873 n5422 U6031/net40 VSS nmos W=0.155u L=0.04u
M22275 n2873 U6031/net19 U6031/net36 VSS nmos W=0.155u L=0.04u
M22276 U6031/net40 n5420 VSS VSS nmos W=0.31u L=0.04u
M22277 U6031/net36 g398 VSS VSS nmos W=0.155u L=0.04u
M22278 U6031/net19 n5422 VDD VDD pmos W=0.205u L=0.04u
M22279 n2873 U6031/net19 U6031/net26 VDD pmos W=0.325u L=0.04u
M22280 U6031/net26 n5420 VDD VDD pmos W=0.41u L=0.04u
M22281 n2873 n5422 U6031/net30 VDD pmos W=0.325u L=0.04u
M22282 U6031/net30 g398 VDD VDD pmos W=0.205u L=0.04u
M22283 n5422 n4749 VSS VSS nmos W=0.155u L=0.04u
M22284 n5422 n2872 VSS VSS nmos W=0.155u L=0.04u
M22285 U6032/XI1-net8 n2872 VDD VDD pmos W=0.205u L=0.04u
M22286 n5422 n4749 U6032/XI1-net8 VDD pmos W=0.205u L=0.04u
M22287 U6033/net36 g11974 U6033/net24 VSS nmos W=0.155u L=0.04u
M22288 U6033/net24 g12026 VSS VSS nmos W=0.155u L=0.04u
M22289 n5420 n5434 U6033/net36 VSS nmos W=0.155u L=0.04u
M22290 n5420 n5436 U6033/net36 VSS nmos W=0.155u L=0.04u
M22291 n5420 n5436 U6033/net35 VDD pmos W=0.205u L=0.04u
M22292 U6033/net35 n5434 VDD VDD pmos W=0.205u L=0.04u
M22293 n5420 g12026 VDD VDD pmos W=0.205u L=0.04u
M22294 n5420 g11974 VDD VDD pmos W=0.205u L=0.04u
M22295 n5436 g3229 VSS VSS nmos W=0.155u L=0.04u
M22296 n5436 g11934 VSS VSS nmos W=0.155u L=0.04u
M22297 U6034/XI1-net8 g11934 VDD VDD pmos W=0.205u L=0.04u
M22298 n5436 g3229 U6034/XI1-net8 VDD pmos W=0.205u L=0.04u
M22299 n5434 n5429 VSS VSS nmos W=0.155u L=0.04u
M22300 n5434 n3937 VSS VSS nmos W=0.155u L=0.04u
M22301 U6035/XI1-net8 n3937 VDD VDD pmos W=0.205u L=0.04u
M22302 n5434 n5429 U6035/XI1-net8 VDD pmos W=0.205u L=0.04u
M22303 n5429 g11934 VSS VSS nmos W=0.135u L=0.04u
M22304 n5429 g11934 VDD VDD pmos W=0.205u L=0.04u
M22305 n2872 n4335 U6037/net15 VSS nmos W=0.155u L=0.04u
M22306 n2872 n5437 U6037/net15 VSS nmos W=0.155u L=0.04u
M22307 U6037/net15 n4337 VSS VSS nmos W=0.155u L=0.04u
M22308 n2872 n4337 VDD VDD pmos W=0.205u L=0.04u
M22309 n2872 n4335 U6037/XI16-net11 VDD pmos W=0.205u L=0.04u
M22310 U6037/XI16-net11 n5437 VDD VDD pmos W=0.205u L=0.04u
M22311 U6038/net19 n5439 VSS VSS nmos W=0.155u L=0.04u
M22312 n2871 n5439 U6038/net40 VSS nmos W=0.155u L=0.04u
M22313 n2871 U6038/net19 U6038/net36 VSS nmos W=0.155u L=0.04u
M22314 U6038/net40 n5438 VSS VSS nmos W=0.31u L=0.04u
M22315 U6038/net36 g1033 VSS VSS nmos W=0.155u L=0.04u
M22316 U6038/net19 n5439 VDD VDD pmos W=0.205u L=0.04u
M22317 n2871 U6038/net19 U6038/net26 VDD pmos W=0.325u L=0.04u
M22318 U6038/net26 n5438 VDD VDD pmos W=0.41u L=0.04u
M22319 n2871 n5439 U6038/net30 VDD pmos W=0.325u L=0.04u
M22320 U6038/net30 g1033 VDD VDD pmos W=0.205u L=0.04u
M22321 U6039/net19 n5439 VSS VSS nmos W=0.155u L=0.04u
M22322 n2870 n5439 U6039/net40 VSS nmos W=0.155u L=0.04u
M22323 n2870 U6039/net19 U6039/net36 VSS nmos W=0.155u L=0.04u
M22324 U6039/net40 n5440 VSS VSS nmos W=0.31u L=0.04u
M22325 U6039/net36 g1048 VSS VSS nmos W=0.155u L=0.04u
M22326 U6039/net19 n5439 VDD VDD pmos W=0.205u L=0.04u
M22327 n2870 U6039/net19 U6039/net26 VDD pmos W=0.325u L=0.04u
M22328 U6039/net26 n5440 VDD VDD pmos W=0.41u L=0.04u
M22329 n2870 n5439 U6039/net30 VDD pmos W=0.325u L=0.04u
M22330 U6039/net30 g1048 VDD VDD pmos W=0.205u L=0.04u
M22331 U6040/net19 n5439 VSS VSS nmos W=0.155u L=0.04u
M22332 n2869 n5439 U6040/net40 VSS nmos W=0.155u L=0.04u
M22333 n2869 U6040/net19 U6040/net36 VSS nmos W=0.155u L=0.04u
M22334 U6040/net40 n5441 VSS VSS nmos W=0.31u L=0.04u
M22335 U6040/net36 g1063 VSS VSS nmos W=0.155u L=0.04u
M22336 U6040/net19 n5439 VDD VDD pmos W=0.205u L=0.04u
M22337 n2869 U6040/net19 U6040/net26 VDD pmos W=0.325u L=0.04u
M22338 U6040/net26 n5441 VDD VDD pmos W=0.41u L=0.04u
M22339 n2869 n5439 U6040/net30 VDD pmos W=0.325u L=0.04u
M22340 U6040/net30 g1063 VDD VDD pmos W=0.205u L=0.04u
M22341 U6041/net19 n5439 VSS VSS nmos W=0.155u L=0.04u
M22342 n2868 n5439 U6041/net40 VSS nmos W=0.155u L=0.04u
M22343 n2868 U6041/net19 U6041/net36 VSS nmos W=0.155u L=0.04u
M22344 U6041/net40 n5442 VSS VSS nmos W=0.31u L=0.04u
M22345 U6041/net36 g1078 VSS VSS nmos W=0.155u L=0.04u
M22346 U6041/net19 n5439 VDD VDD pmos W=0.205u L=0.04u
M22347 n2868 U6041/net19 U6041/net26 VDD pmos W=0.325u L=0.04u
M22348 U6041/net26 n5442 VDD VDD pmos W=0.41u L=0.04u
M22349 n2868 n5439 U6041/net30 VDD pmos W=0.325u L=0.04u
M22350 U6041/net30 g1078 VDD VDD pmos W=0.205u L=0.04u
M22351 n5439 n4971 VSS VSS nmos W=0.155u L=0.04u
M22352 n5439 n2859 VSS VSS nmos W=0.155u L=0.04u
M22353 U6042/XI1-net8 n2859 VDD VDD pmos W=0.205u L=0.04u
M22354 n5439 n4971 U6042/XI1-net8 VDD pmos W=0.205u L=0.04u
M22355 U6043/net19 n5443 VSS VSS nmos W=0.155u L=0.04u
M22356 n2867 n5443 U6043/net40 VSS nmos W=0.155u L=0.04u
M22357 n2867 U6043/net19 U6043/net36 VSS nmos W=0.155u L=0.04u
M22358 U6043/net40 n5438 VSS VSS nmos W=0.31u L=0.04u
M22359 U6043/net36 g1030 VSS VSS nmos W=0.155u L=0.04u
M22360 U6043/net19 n5443 VDD VDD pmos W=0.205u L=0.04u
M22361 n2867 U6043/net19 U6043/net26 VDD pmos W=0.325u L=0.04u
M22362 U6043/net26 n5438 VDD VDD pmos W=0.41u L=0.04u
M22363 n2867 n5443 U6043/net30 VDD pmos W=0.325u L=0.04u
M22364 U6043/net30 g1030 VDD VDD pmos W=0.205u L=0.04u
M22365 U6044/net19 n5444 VSS VSS nmos W=0.155u L=0.04u
M22366 n2866 n5444 U6044/net40 VSS nmos W=0.155u L=0.04u
M22367 n2866 U6044/net19 U6044/net36 VSS nmos W=0.155u L=0.04u
M22368 U6044/net40 n5438 VSS VSS nmos W=0.31u L=0.04u
M22369 U6044/net36 g1041 VSS VSS nmos W=0.155u L=0.04u
M22370 U6044/net19 n5444 VDD VDD pmos W=0.205u L=0.04u
M22371 n2866 U6044/net19 U6044/net26 VDD pmos W=0.325u L=0.04u
M22372 U6044/net26 n5438 VDD VDD pmos W=0.41u L=0.04u
M22373 n2866 n5444 U6044/net30 VDD pmos W=0.325u L=0.04u
M22374 U6044/net30 g1041 VDD VDD pmos W=0.205u L=0.04u
M22375 U6045/net7 n5445 U6045/X_u4-net10 VSS nmos W=0.155u L=0.04u
M22376 U6045/X_u4-net10 n5446 U6045/X_u4-net13 VSS nmos W=0.155u L=0.04u
M22377 U6045/X_u4-net13 n5447 VSS VSS nmos W=0.155u L=0.04u
M22378 n5438 U6045/net7 VSS VSS nmos W=0.155u L=0.04u
M22379 U6045/net7 n5447 VDD VDD pmos W=0.205u L=0.04u
M22380 U6045/net7 n5445 VDD VDD pmos W=0.205u L=0.04u
M22381 U6045/net7 n5446 VDD VDD pmos W=0.205u L=0.04u
M22382 n5438 U6045/net7 VDD VDD pmos W=0.205u L=0.04u
M22383 U6046/net19 n3937 VSS VSS nmos W=0.155u L=0.04u
M22384 n5447 n3937 U6046/net40 VSS nmos W=0.155u L=0.04u
M22385 n5447 U6046/net19 U6046/net36 VSS nmos W=0.155u L=0.04u
M22386 U6046/net40 n5449 VSS VSS nmos W=0.31u L=0.04u
M22387 U6046/net36 n5448 VSS VSS nmos W=0.155u L=0.04u
M22388 U6046/net19 n3937 VDD VDD pmos W=0.205u L=0.04u
M22389 n5447 U6046/net19 U6046/net26 VDD pmos W=0.325u L=0.04u
M22390 U6046/net26 n5449 VDD VDD pmos W=0.41u L=0.04u
M22391 n5447 n3937 U6046/net30 VDD pmos W=0.325u L=0.04u
M22392 U6046/net30 n5448 VDD VDD pmos W=0.205u L=0.04u
M22393 n5449 g11987 U6047/net15 VSS nmos W=0.155u L=0.04u
M22394 n5449 n5448 U6047/net15 VSS nmos W=0.155u L=0.04u
M22395 U6047/net15 n5450 VSS VSS nmos W=0.155u L=0.04u
M22396 n5449 n5450 VDD VDD pmos W=0.205u L=0.04u
M22397 n5449 g11987 U6047/XI16-net11 VDD pmos W=0.205u L=0.04u
M22398 U6047/XI16-net11 n5448 VDD VDD pmos W=0.205u L=0.04u
M22399 U6048/net19 n5443 VSS VSS nmos W=0.155u L=0.04u
M22400 n2865 n5443 U6048/net40 VSS nmos W=0.155u L=0.04u
M22401 n2865 U6048/net19 U6048/net36 VSS nmos W=0.155u L=0.04u
M22402 U6048/net40 n5440 VSS VSS nmos W=0.31u L=0.04u
M22403 U6048/net36 g1045 VSS VSS nmos W=0.155u L=0.04u
M22404 U6048/net19 n5443 VDD VDD pmos W=0.205u L=0.04u
M22405 n2865 U6048/net19 U6048/net26 VDD pmos W=0.325u L=0.04u
M22406 U6048/net26 n5440 VDD VDD pmos W=0.41u L=0.04u
M22407 n2865 n5443 U6048/net30 VDD pmos W=0.325u L=0.04u
M22408 U6048/net30 g1045 VDD VDD pmos W=0.205u L=0.04u
M22409 U6049/net19 n5444 VSS VSS nmos W=0.155u L=0.04u
M22410 n2864 n5444 U6049/net40 VSS nmos W=0.155u L=0.04u
M22411 n2864 U6049/net19 U6049/net36 VSS nmos W=0.155u L=0.04u
M22412 U6049/net40 n5440 VSS VSS nmos W=0.31u L=0.04u
M22413 U6049/net36 g1056 VSS VSS nmos W=0.155u L=0.04u
M22414 U6049/net19 n5444 VDD VDD pmos W=0.205u L=0.04u
M22415 n2864 U6049/net19 U6049/net26 VDD pmos W=0.325u L=0.04u
M22416 U6049/net26 n5440 VDD VDD pmos W=0.41u L=0.04u
M22417 n2864 n5444 U6049/net30 VDD pmos W=0.325u L=0.04u
M22418 U6049/net30 g1056 VDD VDD pmos W=0.205u L=0.04u
M22419 U6050/net36 n5450 U6050/net24 VSS nmos W=0.155u L=0.04u
M22420 U6050/net24 n5445 VSS VSS nmos W=0.155u L=0.04u
M22421 U6050/net33 n5451 U6050/net36 VSS nmos W=0.155u L=0.04u
M22422 U6050/net33 n5452 U6050/net36 VSS nmos W=0.155u L=0.04u
M22423 n5440 U6050/net33 VSS VSS nmos W=0.155u L=0.04u
M22424 n5440 U6050/net33 VDD VDD pmos W=0.205u L=0.04u
M22425 U6050/net33 n5452 U6050/net35 VDD pmos W=0.205u L=0.04u
M22426 U6050/net35 n5451 VDD VDD pmos W=0.205u L=0.04u
M22427 U6050/net33 n5445 VDD VDD pmos W=0.205u L=0.04u
M22428 U6050/net33 n5450 VDD VDD pmos W=0.205u L=0.04u
M22429 n5445 n5451 U6051/XI0-net10 VSS nmos W=0.155u L=0.04u
M22430 U6051/XI0-net10 n5453 U6051/XI0-net13 VSS nmos W=0.155u L=0.04u
M22431 U6051/XI0-net13 g3229 VSS VSS nmos W=0.155u L=0.04u
M22432 n5445 g3229 VDD VDD pmos W=0.205u L=0.04u
M22433 n5445 n5451 VDD VDD pmos W=0.205u L=0.04u
M22434 n5445 n5453 VDD VDD pmos W=0.205u L=0.04u
M22435 U6052/net13 g12043 VSS VSS nmos W=0.155u L=0.04u
M22436 U6052/net16 U6052/net13 VSS VSS nmos W=0.155u L=0.04u
M22437 n5450 g12090 U6052/net16 VSS nmos W=0.155u L=0.04u
M22438 U6052/net13 g12043 VDD VDD pmos W=0.205u L=0.04u
M22439 VDD U6052/net13 n5450 VDD pmos W=0.205u L=0.04u
M22440 VDD g12090 n5450 VDD pmos W=0.205u L=0.04u
M22441 U6053/XU1-net6 n3937 VSS VSS nmos W=0.155u L=0.04u
M22442 n5452 n5453 U6053/XU1-net6 VSS nmos W=0.155u L=0.04u
M22443 n5452 n3937 VDD VDD pmos W=0.155u L=0.04u
M22444 n5452 n5453 VDD VDD pmos W=0.155u L=0.04u
M22445 n5453 g12090 VSS VSS nmos W=0.135u L=0.04u
M22446 n5453 g12090 VDD VDD pmos W=0.205u L=0.04u
M22447 U6055/net19 n5443 VSS VSS nmos W=0.155u L=0.04u
M22448 n2863 n5443 U6055/net40 VSS nmos W=0.155u L=0.04u
M22449 n2863 U6055/net19 U6055/net36 VSS nmos W=0.155u L=0.04u
M22450 U6055/net40 n5441 VSS VSS nmos W=0.31u L=0.04u
M22451 U6055/net36 g1060 VSS VSS nmos W=0.155u L=0.04u
M22452 U6055/net19 n5443 VDD VDD pmos W=0.205u L=0.04u
M22453 n2863 U6055/net19 U6055/net26 VDD pmos W=0.325u L=0.04u
M22454 U6055/net26 n5441 VDD VDD pmos W=0.41u L=0.04u
M22455 n2863 n5443 U6055/net30 VDD pmos W=0.325u L=0.04u
M22456 U6055/net30 g1060 VDD VDD pmos W=0.205u L=0.04u
M22457 U6056/net19 n5444 VSS VSS nmos W=0.155u L=0.04u
M22458 n2862 n5444 U6056/net40 VSS nmos W=0.155u L=0.04u
M22459 n2862 U6056/net19 U6056/net36 VSS nmos W=0.155u L=0.04u
M22460 U6056/net40 n5441 VSS VSS nmos W=0.31u L=0.04u
M22461 U6056/net36 g1071 VSS VSS nmos W=0.155u L=0.04u
M22462 U6056/net19 n5444 VDD VDD pmos W=0.205u L=0.04u
M22463 n2862 U6056/net19 U6056/net26 VDD pmos W=0.325u L=0.04u
M22464 U6056/net26 n5441 VDD VDD pmos W=0.41u L=0.04u
M22465 n2862 n5444 U6056/net30 VDD pmos W=0.325u L=0.04u
M22466 U6056/net30 g1071 VDD VDD pmos W=0.205u L=0.04u
M22467 U6057/net36 n5446 U6057/net24 VSS nmos W=0.155u L=0.04u
M22468 U6057/net24 n5455 VSS VSS nmos W=0.155u L=0.04u
M22469 U6057/net33 g12043 U6057/net36 VSS nmos W=0.155u L=0.04u
M22470 U6057/net33 n5454 U6057/net36 VSS nmos W=0.155u L=0.04u
M22471 n5441 U6057/net33 VSS VSS nmos W=0.155u L=0.04u
M22472 n5441 U6057/net33 VDD VDD pmos W=0.205u L=0.04u
M22473 U6057/net33 n5454 U6057/net35 VDD pmos W=0.205u L=0.04u
M22474 U6057/net35 g12043 VDD VDD pmos W=0.205u L=0.04u
M22475 U6057/net33 n5455 VDD VDD pmos W=0.205u L=0.04u
M22476 U6057/net33 n5446 VDD VDD pmos W=0.205u L=0.04u
M22477 U6058/net19 g12043 VSS VSS nmos W=0.155u L=0.04u
M22478 n5455 g12043 U6058/net40 VSS nmos W=0.155u L=0.04u
M22479 n5455 U6058/net19 U6058/net36 VSS nmos W=0.155u L=0.04u
M22480 U6058/net40 n5457 VSS VSS nmos W=0.31u L=0.04u
M22481 U6058/net36 n5456 VSS VSS nmos W=0.155u L=0.04u
M22482 U6058/net19 g12043 VDD VDD pmos W=0.205u L=0.04u
M22483 n5455 U6058/net19 U6058/net26 VDD pmos W=0.325u L=0.04u
M22484 U6058/net26 n5457 VDD VDD pmos W=0.41u L=0.04u
M22485 n5455 g12043 U6058/net30 VDD pmos W=0.325u L=0.04u
M22486 U6058/net30 n5456 VDD VDD pmos W=0.205u L=0.04u
M22487 n5457 n5448 VSS VSS nmos W=0.155u L=0.04u
M22488 n5457 g3229 VSS VSS nmos W=0.155u L=0.04u
M22489 n5457 n5451 VSS VSS nmos W=0.155u L=0.04u
M22490 U6059/net25 n5448 VDD VDD pmos W=0.41u L=0.04u
M22491 U6059/net28 g3229 U6059/net25 VDD pmos W=0.41u L=0.04u
M22492 n5457 n5451 U6059/net28 VDD pmos W=0.41u L=0.04u
M22493 n5448 g12151 VSS VSS nmos W=0.135u L=0.04u
M22494 n5448 g12151 VDD VDD pmos W=0.205u L=0.04u
M22495 U6061/p2 n5451 VSS VSS nmos W=0.155u L=0.04u
M22496 U6061/p0 g12043 U6061/p1 VSS nmos W=0.155u L=0.04u
M22497 U6061/p1 g3229 U6061/p2 VSS nmos W=0.155u L=0.04u
M22498 n5446 g12151 U6061/p0 VSS nmos W=0.155u L=0.04u
M22499 n5446 g3229 VDD VDD pmos W=0.205u L=0.04u
M22500 n5446 g12043 VDD VDD pmos W=0.205u L=0.04u
M22501 n5446 g12151 VDD VDD pmos W=0.205u L=0.04u
M22502 n5446 n5451 VDD VDD pmos W=0.205u L=0.04u
M22503 n5454 n5458 VSS VSS nmos W=0.135u L=0.04u
M22504 n5454 n5458 VDD VDD pmos W=0.205u L=0.04u
M22505 U6063/net19 n5443 VSS VSS nmos W=0.155u L=0.04u
M22506 n2861 n5443 U6063/net40 VSS nmos W=0.155u L=0.04u
M22507 n2861 U6063/net19 U6063/net36 VSS nmos W=0.155u L=0.04u
M22508 U6063/net40 n5442 VSS VSS nmos W=0.31u L=0.04u
M22509 U6063/net36 g1075 VSS VSS nmos W=0.155u L=0.04u
M22510 U6063/net19 n5443 VDD VDD pmos W=0.205u L=0.04u
M22511 n2861 U6063/net19 U6063/net26 VDD pmos W=0.325u L=0.04u
M22512 U6063/net26 n5442 VDD VDD pmos W=0.41u L=0.04u
M22513 n2861 n5443 U6063/net30 VDD pmos W=0.325u L=0.04u
M22514 U6063/net30 g1075 VDD VDD pmos W=0.205u L=0.04u
M22515 n5443 n4333 VSS VSS nmos W=0.155u L=0.04u
M22516 n5443 n2859 VSS VSS nmos W=0.155u L=0.04u
M22517 U6064/XI1-net8 n2859 VDD VDD pmos W=0.205u L=0.04u
M22518 n5443 n4333 U6064/XI1-net8 VDD pmos W=0.205u L=0.04u
M22519 U6065/net19 n5444 VSS VSS nmos W=0.155u L=0.04u
M22520 n2860 n5444 U6065/net40 VSS nmos W=0.155u L=0.04u
M22521 n2860 U6065/net19 U6065/net36 VSS nmos W=0.155u L=0.04u
M22522 U6065/net40 n5442 VSS VSS nmos W=0.31u L=0.04u
M22523 U6065/net36 g1085 VSS VSS nmos W=0.155u L=0.04u
M22524 U6065/net19 n5444 VDD VDD pmos W=0.205u L=0.04u
M22525 n2860 U6065/net19 U6065/net26 VDD pmos W=0.325u L=0.04u
M22526 U6065/net26 n5442 VDD VDD pmos W=0.41u L=0.04u
M22527 n2860 n5444 U6065/net30 VDD pmos W=0.325u L=0.04u
M22528 U6065/net30 g1085 VDD VDD pmos W=0.205u L=0.04u
M22529 n5444 n4970 VSS VSS nmos W=0.155u L=0.04u
M22530 n5444 n2859 VSS VSS nmos W=0.155u L=0.04u
M22531 U6066/XI1-net8 n2859 VDD VDD pmos W=0.205u L=0.04u
M22532 n5444 n4970 U6066/XI1-net8 VDD pmos W=0.205u L=0.04u
M22533 U6067/net36 g12043 U6067/net24 VSS nmos W=0.155u L=0.04u
M22534 U6067/net24 g12090 VSS VSS nmos W=0.155u L=0.04u
M22535 n5442 n5456 U6067/net36 VSS nmos W=0.155u L=0.04u
M22536 n5442 n5458 U6067/net36 VSS nmos W=0.155u L=0.04u
M22537 n5442 n5458 U6067/net35 VDD pmos W=0.205u L=0.04u
M22538 U6067/net35 n5456 VDD VDD pmos W=0.205u L=0.04u
M22539 n5442 g12090 VDD VDD pmos W=0.205u L=0.04u
M22540 n5442 g12043 VDD VDD pmos W=0.205u L=0.04u
M22541 n5458 g3229 VSS VSS nmos W=0.155u L=0.04u
M22542 n5458 g11987 VSS VSS nmos W=0.155u L=0.04u
M22543 U6068/XI1-net8 g11987 VDD VDD pmos W=0.205u L=0.04u
M22544 n5458 g3229 U6068/XI1-net8 VDD pmos W=0.205u L=0.04u
M22545 n5456 n5451 VSS VSS nmos W=0.155u L=0.04u
M22546 n5456 n3937 VSS VSS nmos W=0.155u L=0.04u
M22547 U6069/XI1-net8 n3937 VDD VDD pmos W=0.205u L=0.04u
M22548 n5456 n5451 U6069/XI1-net8 VDD pmos W=0.205u L=0.04u
M22549 n5451 g11987 VSS VSS nmos W=0.135u L=0.04u
M22550 n5451 g11987 VDD VDD pmos W=0.205u L=0.04u
M22551 n2859 n4170 U6071/net15 VSS nmos W=0.155u L=0.04u
M22552 n2859 n5437 U6071/net15 VSS nmos W=0.155u L=0.04u
M22553 U6071/net15 n4172 VSS VSS nmos W=0.155u L=0.04u
M22554 n2859 n4172 VDD VDD pmos W=0.205u L=0.04u
M22555 n2859 n4170 U6071/XI16-net11 VDD pmos W=0.205u L=0.04u
M22556 U6071/XI16-net11 n5437 VDD VDD pmos W=0.205u L=0.04u
M22557 U6072/net19 n5460 VSS VSS nmos W=0.155u L=0.04u
M22558 n2858 n5460 U6072/net40 VSS nmos W=0.155u L=0.04u
M22559 n2858 U6072/net19 U6072/net36 VSS nmos W=0.155u L=0.04u
M22560 U6072/net40 n5459 VSS VSS nmos W=0.31u L=0.04u
M22561 U6072/net36 g1727 VSS VSS nmos W=0.155u L=0.04u
M22562 U6072/net19 n5460 VDD VDD pmos W=0.205u L=0.04u
M22563 n2858 U6072/net19 U6072/net26 VDD pmos W=0.325u L=0.04u
M22564 U6072/net26 n5459 VDD VDD pmos W=0.41u L=0.04u
M22565 n2858 n5460 U6072/net30 VDD pmos W=0.325u L=0.04u
M22566 U6072/net30 g1727 VDD VDD pmos W=0.205u L=0.04u
M22567 U6073/net19 n5460 VSS VSS nmos W=0.155u L=0.04u
M22568 n2857 n5460 U6073/net40 VSS nmos W=0.155u L=0.04u
M22569 n2857 U6073/net19 U6073/net36 VSS nmos W=0.155u L=0.04u
M22570 U6073/net40 n5461 VSS VSS nmos W=0.31u L=0.04u
M22571 U6073/net36 g1742 VSS VSS nmos W=0.155u L=0.04u
M22572 U6073/net19 n5460 VDD VDD pmos W=0.205u L=0.04u
M22573 n2857 U6073/net19 U6073/net26 VDD pmos W=0.325u L=0.04u
M22574 U6073/net26 n5461 VDD VDD pmos W=0.41u L=0.04u
M22575 n2857 n5460 U6073/net30 VDD pmos W=0.325u L=0.04u
M22576 U6073/net30 g1742 VDD VDD pmos W=0.205u L=0.04u
M22577 U6074/net19 n5460 VSS VSS nmos W=0.155u L=0.04u
M22578 n2856 n5460 U6074/net40 VSS nmos W=0.155u L=0.04u
M22579 n2856 U6074/net19 U6074/net36 VSS nmos W=0.155u L=0.04u
M22580 U6074/net40 n5462 VSS VSS nmos W=0.31u L=0.04u
M22581 U6074/net36 g1757 VSS VSS nmos W=0.155u L=0.04u
M22582 U6074/net19 n5460 VDD VDD pmos W=0.205u L=0.04u
M22583 n2856 U6074/net19 U6074/net26 VDD pmos W=0.325u L=0.04u
M22584 U6074/net26 n5462 VDD VDD pmos W=0.41u L=0.04u
M22585 n2856 n5460 U6074/net30 VDD pmos W=0.325u L=0.04u
M22586 U6074/net30 g1757 VDD VDD pmos W=0.205u L=0.04u
M22587 U6075/net19 n5460 VSS VSS nmos W=0.155u L=0.04u
M22588 n2855 n5460 U6075/net40 VSS nmos W=0.155u L=0.04u
M22589 n2855 U6075/net19 U6075/net36 VSS nmos W=0.155u L=0.04u
M22590 U6075/net40 n5463 VSS VSS nmos W=0.31u L=0.04u
M22591 U6075/net36 g1772 VSS VSS nmos W=0.155u L=0.04u
M22592 U6075/net19 n5460 VDD VDD pmos W=0.205u L=0.04u
M22593 n2855 U6075/net19 U6075/net26 VDD pmos W=0.325u L=0.04u
M22594 U6075/net26 n5463 VDD VDD pmos W=0.41u L=0.04u
M22595 n2855 n5460 U6075/net30 VDD pmos W=0.325u L=0.04u
M22596 U6075/net30 g1772 VDD VDD pmos W=0.205u L=0.04u
M22597 n5460 n5192 VSS VSS nmos W=0.155u L=0.04u
M22598 n5460 n2846 VSS VSS nmos W=0.155u L=0.04u
M22599 U6076/XI1-net8 n2846 VDD VDD pmos W=0.205u L=0.04u
M22600 n5460 n5192 U6076/XI1-net8 VDD pmos W=0.205u L=0.04u
M22601 U6077/net19 n5464 VSS VSS nmos W=0.155u L=0.04u
M22602 n2854 n5464 U6077/net40 VSS nmos W=0.155u L=0.04u
M22603 n2854 U6077/net19 U6077/net36 VSS nmos W=0.155u L=0.04u
M22604 U6077/net40 n5459 VSS VSS nmos W=0.31u L=0.04u
M22605 U6077/net36 g1724 VSS VSS nmos W=0.155u L=0.04u
M22606 U6077/net19 n5464 VDD VDD pmos W=0.205u L=0.04u
M22607 n2854 U6077/net19 U6077/net26 VDD pmos W=0.325u L=0.04u
M22608 U6077/net26 n5459 VDD VDD pmos W=0.41u L=0.04u
M22609 n2854 n5464 U6077/net30 VDD pmos W=0.325u L=0.04u
M22610 U6077/net30 g1724 VDD VDD pmos W=0.205u L=0.04u
M22611 U6078/net19 n5465 VSS VSS nmos W=0.155u L=0.04u
M22612 n2853 n5465 U6078/net40 VSS nmos W=0.155u L=0.04u
M22613 n2853 U6078/net19 U6078/net36 VSS nmos W=0.155u L=0.04u
M22614 U6078/net40 n5459 VSS VSS nmos W=0.31u L=0.04u
M22615 U6078/net36 g1735 VSS VSS nmos W=0.155u L=0.04u
M22616 U6078/net19 n5465 VDD VDD pmos W=0.205u L=0.04u
M22617 n2853 U6078/net19 U6078/net26 VDD pmos W=0.325u L=0.04u
M22618 U6078/net26 n5459 VDD VDD pmos W=0.41u L=0.04u
M22619 n2853 n5465 U6078/net30 VDD pmos W=0.325u L=0.04u
M22620 U6078/net30 g1735 VDD VDD pmos W=0.205u L=0.04u
M22621 U6079/net7 n5466 U6079/X_u4-net10 VSS nmos W=0.155u L=0.04u
M22622 U6079/X_u4-net10 n5467 U6079/X_u4-net13 VSS nmos W=0.155u L=0.04u
M22623 U6079/X_u4-net13 n5468 VSS VSS nmos W=0.155u L=0.04u
M22624 n5459 U6079/net7 VSS VSS nmos W=0.155u L=0.04u
M22625 U6079/net7 n5468 VDD VDD pmos W=0.205u L=0.04u
M22626 U6079/net7 n5466 VDD VDD pmos W=0.205u L=0.04u
M22627 U6079/net7 n5467 VDD VDD pmos W=0.205u L=0.04u
M22628 n5459 U6079/net7 VDD VDD pmos W=0.205u L=0.04u
M22629 U6080/net19 n3937 VSS VSS nmos W=0.155u L=0.04u
M22630 n5468 n3937 U6080/net40 VSS nmos W=0.155u L=0.04u
M22631 n5468 U6080/net19 U6080/net36 VSS nmos W=0.155u L=0.04u
M22632 U6080/net40 n5470 VSS VSS nmos W=0.31u L=0.04u
M22633 U6080/net36 n5469 VSS VSS nmos W=0.155u L=0.04u
M22634 U6080/net19 n3937 VDD VDD pmos W=0.205u L=0.04u
M22635 n5468 U6080/net19 U6080/net26 VDD pmos W=0.325u L=0.04u
M22636 U6080/net26 n5470 VDD VDD pmos W=0.41u L=0.04u
M22637 n5468 n3937 U6080/net30 VDD pmos W=0.325u L=0.04u
M22638 U6080/net30 n5469 VDD VDD pmos W=0.205u L=0.04u
M22639 n5470 g12056 U6081/net15 VSS nmos W=0.155u L=0.04u
M22640 n5470 n5469 U6081/net15 VSS nmos W=0.155u L=0.04u
M22641 U6081/net15 n5471 VSS VSS nmos W=0.155u L=0.04u
M22642 n5470 n5471 VDD VDD pmos W=0.205u L=0.04u
M22643 n5470 g12056 U6081/XI16-net11 VDD pmos W=0.205u L=0.04u
M22644 U6081/XI16-net11 n5469 VDD VDD pmos W=0.205u L=0.04u
M22645 U6082/net19 n5464 VSS VSS nmos W=0.155u L=0.04u
M22646 n2852 n5464 U6082/net40 VSS nmos W=0.155u L=0.04u
M22647 n2852 U6082/net19 U6082/net36 VSS nmos W=0.155u L=0.04u
M22648 U6082/net40 n5461 VSS VSS nmos W=0.31u L=0.04u
M22649 U6082/net36 g1739 VSS VSS nmos W=0.155u L=0.04u
M22650 U6082/net19 n5464 VDD VDD pmos W=0.205u L=0.04u
M22651 n2852 U6082/net19 U6082/net26 VDD pmos W=0.325u L=0.04u
M22652 U6082/net26 n5461 VDD VDD pmos W=0.41u L=0.04u
M22653 n2852 n5464 U6082/net30 VDD pmos W=0.325u L=0.04u
M22654 U6082/net30 g1739 VDD VDD pmos W=0.205u L=0.04u
M22655 U6083/net19 n5465 VSS VSS nmos W=0.155u L=0.04u
M22656 n2851 n5465 U6083/net40 VSS nmos W=0.155u L=0.04u
M22657 n2851 U6083/net19 U6083/net36 VSS nmos W=0.155u L=0.04u
M22658 U6083/net40 n5461 VSS VSS nmos W=0.31u L=0.04u
M22659 U6083/net36 g1750 VSS VSS nmos W=0.155u L=0.04u
M22660 U6083/net19 n5465 VDD VDD pmos W=0.205u L=0.04u
M22661 n2851 U6083/net19 U6083/net26 VDD pmos W=0.325u L=0.04u
M22662 U6083/net26 n5461 VDD VDD pmos W=0.41u L=0.04u
M22663 n2851 n5465 U6083/net30 VDD pmos W=0.325u L=0.04u
M22664 U6083/net30 g1750 VDD VDD pmos W=0.205u L=0.04u
M22665 U6084/net36 n5471 U6084/net24 VSS nmos W=0.155u L=0.04u
M22666 U6084/net24 n5466 VSS VSS nmos W=0.155u L=0.04u
M22667 U6084/net33 n5472 U6084/net36 VSS nmos W=0.155u L=0.04u
M22668 U6084/net33 n5473 U6084/net36 VSS nmos W=0.155u L=0.04u
M22669 n5461 U6084/net33 VSS VSS nmos W=0.155u L=0.04u
M22670 n5461 U6084/net33 VDD VDD pmos W=0.205u L=0.04u
M22671 U6084/net33 n5473 U6084/net35 VDD pmos W=0.205u L=0.04u
M22672 U6084/net35 n5472 VDD VDD pmos W=0.205u L=0.04u
M22673 U6084/net33 n5466 VDD VDD pmos W=0.205u L=0.04u
M22674 U6084/net33 n5471 VDD VDD pmos W=0.205u L=0.04u
M22675 n5466 n5472 U6085/XI0-net10 VSS nmos W=0.155u L=0.04u
M22676 U6085/XI0-net10 n5474 U6085/XI0-net13 VSS nmos W=0.155u L=0.04u
M22677 U6085/XI0-net13 g3229 VSS VSS nmos W=0.155u L=0.04u
M22678 n5466 g3229 VDD VDD pmos W=0.205u L=0.04u
M22679 n5466 n5472 VDD VDD pmos W=0.205u L=0.04u
M22680 n5466 n5474 VDD VDD pmos W=0.205u L=0.04u
M22681 U6086/net13 g12107 VSS VSS nmos W=0.155u L=0.04u
M22682 U6086/net16 U6086/net13 VSS VSS nmos W=0.155u L=0.04u
M22683 n5471 g12162 U6086/net16 VSS nmos W=0.155u L=0.04u
M22684 U6086/net13 g12107 VDD VDD pmos W=0.205u L=0.04u
M22685 VDD U6086/net13 n5471 VDD pmos W=0.205u L=0.04u
M22686 VDD g12162 n5471 VDD pmos W=0.205u L=0.04u
M22687 U6087/XU1-net6 n3937 VSS VSS nmos W=0.155u L=0.04u
M22688 n5473 n5474 U6087/XU1-net6 VSS nmos W=0.155u L=0.04u
M22689 n5473 n3937 VDD VDD pmos W=0.155u L=0.04u
M22690 n5473 n5474 VDD VDD pmos W=0.155u L=0.04u
M22691 n5474 g12162 VSS VSS nmos W=0.135u L=0.04u
M22692 n5474 g12162 VDD VDD pmos W=0.205u L=0.04u
M22693 U6089/net19 n5464 VSS VSS nmos W=0.155u L=0.04u
M22694 n2850 n5464 U6089/net40 VSS nmos W=0.155u L=0.04u
M22695 n2850 U6089/net19 U6089/net36 VSS nmos W=0.155u L=0.04u
M22696 U6089/net40 n5462 VSS VSS nmos W=0.31u L=0.04u
M22697 U6089/net36 g1754 VSS VSS nmos W=0.155u L=0.04u
M22698 U6089/net19 n5464 VDD VDD pmos W=0.205u L=0.04u
M22699 n2850 U6089/net19 U6089/net26 VDD pmos W=0.325u L=0.04u
M22700 U6089/net26 n5462 VDD VDD pmos W=0.41u L=0.04u
M22701 n2850 n5464 U6089/net30 VDD pmos W=0.325u L=0.04u
M22702 U6089/net30 g1754 VDD VDD pmos W=0.205u L=0.04u
M22703 U6090/net19 n5465 VSS VSS nmos W=0.155u L=0.04u
M22704 n2849 n5465 U6090/net40 VSS nmos W=0.155u L=0.04u
M22705 n2849 U6090/net19 U6090/net36 VSS nmos W=0.155u L=0.04u
M22706 U6090/net40 n5462 VSS VSS nmos W=0.31u L=0.04u
M22707 U6090/net36 g1765 VSS VSS nmos W=0.155u L=0.04u
M22708 U6090/net19 n5465 VDD VDD pmos W=0.205u L=0.04u
M22709 n2849 U6090/net19 U6090/net26 VDD pmos W=0.325u L=0.04u
M22710 U6090/net26 n5462 VDD VDD pmos W=0.41u L=0.04u
M22711 n2849 n5465 U6090/net30 VDD pmos W=0.325u L=0.04u
M22712 U6090/net30 g1765 VDD VDD pmos W=0.205u L=0.04u
M22713 U6091/net36 n5467 U6091/net24 VSS nmos W=0.155u L=0.04u
M22714 U6091/net24 n5476 VSS VSS nmos W=0.155u L=0.04u
M22715 U6091/net33 g12107 U6091/net36 VSS nmos W=0.155u L=0.04u
M22716 U6091/net33 n5475 U6091/net36 VSS nmos W=0.155u L=0.04u
M22717 n5462 U6091/net33 VSS VSS nmos W=0.155u L=0.04u
M22718 n5462 U6091/net33 VDD VDD pmos W=0.205u L=0.04u
M22719 U6091/net33 n5475 U6091/net35 VDD pmos W=0.205u L=0.04u
M22720 U6091/net35 g12107 VDD VDD pmos W=0.205u L=0.04u
M22721 U6091/net33 n5476 VDD VDD pmos W=0.205u L=0.04u
M22722 U6091/net33 n5467 VDD VDD pmos W=0.205u L=0.04u
M22723 U6092/net19 g12107 VSS VSS nmos W=0.155u L=0.04u
M22724 n5476 g12107 U6092/net40 VSS nmos W=0.155u L=0.04u
M22725 n5476 U6092/net19 U6092/net36 VSS nmos W=0.155u L=0.04u
M22726 U6092/net40 n5478 VSS VSS nmos W=0.31u L=0.04u
M22727 U6092/net36 n5477 VSS VSS nmos W=0.155u L=0.04u
M22728 U6092/net19 g12107 VDD VDD pmos W=0.205u L=0.04u
M22729 n5476 U6092/net19 U6092/net26 VDD pmos W=0.325u L=0.04u
M22730 U6092/net26 n5478 VDD VDD pmos W=0.41u L=0.04u
M22731 n5476 g12107 U6092/net30 VDD pmos W=0.325u L=0.04u
M22732 U6092/net30 n5477 VDD VDD pmos W=0.205u L=0.04u
M22733 n5478 n5469 VSS VSS nmos W=0.155u L=0.04u
M22734 n5478 g3229 VSS VSS nmos W=0.155u L=0.04u
M22735 n5478 n5472 VSS VSS nmos W=0.155u L=0.04u
M22736 U6093/net25 n5469 VDD VDD pmos W=0.41u L=0.04u
M22737 U6093/net28 g3229 U6093/net25 VDD pmos W=0.41u L=0.04u
M22738 n5478 n5472 U6093/net28 VDD pmos W=0.41u L=0.04u
M22739 n5469 g12213 VSS VSS nmos W=0.135u L=0.04u
M22740 n5469 g12213 VDD VDD pmos W=0.205u L=0.04u
M22741 U6095/p2 n5472 VSS VSS nmos W=0.155u L=0.04u
M22742 U6095/p0 g12107 U6095/p1 VSS nmos W=0.155u L=0.04u
M22743 U6095/p1 g3229 U6095/p2 VSS nmos W=0.155u L=0.04u
M22744 n5467 g12213 U6095/p0 VSS nmos W=0.155u L=0.04u
M22745 n5467 g3229 VDD VDD pmos W=0.205u L=0.04u
M22746 n5467 g12107 VDD VDD pmos W=0.205u L=0.04u
M22747 n5467 g12213 VDD VDD pmos W=0.205u L=0.04u
M22748 n5467 n5472 VDD VDD pmos W=0.205u L=0.04u
M22749 n5475 n5479 VSS VSS nmos W=0.135u L=0.04u
M22750 n5475 n5479 VDD VDD pmos W=0.205u L=0.04u
M22751 U6097/net19 n5464 VSS VSS nmos W=0.155u L=0.04u
M22752 n2848 n5464 U6097/net40 VSS nmos W=0.155u L=0.04u
M22753 n2848 U6097/net19 U6097/net36 VSS nmos W=0.155u L=0.04u
M22754 U6097/net40 n5463 VSS VSS nmos W=0.31u L=0.04u
M22755 U6097/net36 g1769 VSS VSS nmos W=0.155u L=0.04u
M22756 U6097/net19 n5464 VDD VDD pmos W=0.205u L=0.04u
M22757 n2848 U6097/net19 U6097/net26 VDD pmos W=0.325u L=0.04u
M22758 U6097/net26 n5463 VDD VDD pmos W=0.41u L=0.04u
M22759 n2848 n5464 U6097/net30 VDD pmos W=0.325u L=0.04u
M22760 U6097/net30 g1769 VDD VDD pmos W=0.205u L=0.04u
M22761 n5464 n4334 VSS VSS nmos W=0.155u L=0.04u
M22762 n5464 n2846 VSS VSS nmos W=0.155u L=0.04u
M22763 U6098/XI1-net8 n2846 VDD VDD pmos W=0.205u L=0.04u
M22764 n5464 n4334 U6098/XI1-net8 VDD pmos W=0.205u L=0.04u
M22765 U6099/net19 n5465 VSS VSS nmos W=0.155u L=0.04u
M22766 n2847 n5465 U6099/net40 VSS nmos W=0.155u L=0.04u
M22767 n2847 U6099/net19 U6099/net36 VSS nmos W=0.155u L=0.04u
M22768 U6099/net40 n5463 VSS VSS nmos W=0.31u L=0.04u
M22769 U6099/net36 g1779 VSS VSS nmos W=0.155u L=0.04u
M22770 U6099/net19 n5465 VDD VDD pmos W=0.205u L=0.04u
M22771 n2847 U6099/net19 U6099/net26 VDD pmos W=0.325u L=0.04u
M22772 U6099/net26 n5463 VDD VDD pmos W=0.41u L=0.04u
M22773 n2847 n5465 U6099/net30 VDD pmos W=0.325u L=0.04u
M22774 U6099/net30 g1779 VDD VDD pmos W=0.205u L=0.04u
M22775 n5465 n5191 VSS VSS nmos W=0.155u L=0.04u
M22776 n5465 n2846 VSS VSS nmos W=0.155u L=0.04u
M22777 U6100/XI1-net8 n2846 VDD VDD pmos W=0.205u L=0.04u
M22778 n5465 n5191 U6100/XI1-net8 VDD pmos W=0.205u L=0.04u
M22779 U6101/net36 g12107 U6101/net24 VSS nmos W=0.155u L=0.04u
M22780 U6101/net24 g12162 VSS VSS nmos W=0.155u L=0.04u
M22781 n5463 n5477 U6101/net36 VSS nmos W=0.155u L=0.04u
M22782 n5463 n5479 U6101/net36 VSS nmos W=0.155u L=0.04u
M22783 n5463 n5479 U6101/net35 VDD pmos W=0.205u L=0.04u
M22784 U6101/net35 n5477 VDD VDD pmos W=0.205u L=0.04u
M22785 n5463 g12162 VDD VDD pmos W=0.205u L=0.04u
M22786 n5463 g12107 VDD VDD pmos W=0.205u L=0.04u
M22787 n5479 g3229 VSS VSS nmos W=0.155u L=0.04u
M22788 n5479 g12056 VSS VSS nmos W=0.155u L=0.04u
M22789 U6102/XI1-net8 g12056 VDD VDD pmos W=0.205u L=0.04u
M22790 n5479 g3229 U6102/XI1-net8 VDD pmos W=0.205u L=0.04u
M22791 n5477 n5472 VSS VSS nmos W=0.155u L=0.04u
M22792 n5477 n3937 VSS VSS nmos W=0.155u L=0.04u
M22793 U6103/XI1-net8 n3937 VDD VDD pmos W=0.205u L=0.04u
M22794 n5477 n5472 U6103/XI1-net8 VDD pmos W=0.205u L=0.04u
M22795 n5472 g12056 VSS VSS nmos W=0.135u L=0.04u
M22796 n5472 g12056 VDD VDD pmos W=0.205u L=0.04u
M22797 n2846 n4062 U6105/net15 VSS nmos W=0.155u L=0.04u
M22798 n2846 n5437 U6105/net15 VSS nmos W=0.155u L=0.04u
M22799 U6105/net15 n4064 VSS VSS nmos W=0.155u L=0.04u
M22800 n2846 n4064 VDD VDD pmos W=0.205u L=0.04u
M22801 n2846 n4062 U6105/XI16-net11 VDD pmos W=0.205u L=0.04u
M22802 U6105/XI16-net11 n5437 VDD VDD pmos W=0.205u L=0.04u
M22803 U6106/net19 n5481 VSS VSS nmos W=0.155u L=0.04u
M22804 n2845 n5481 U6106/net40 VSS nmos W=0.155u L=0.04u
M22805 n2845 U6106/net19 U6106/net36 VSS nmos W=0.155u L=0.04u
M22806 U6106/net40 n5480 VSS VSS nmos W=0.31u L=0.04u
M22807 U6106/net36 g2421 VSS VSS nmos W=0.155u L=0.04u
M22808 U6106/net19 n5481 VDD VDD pmos W=0.205u L=0.04u
M22809 n2845 U6106/net19 U6106/net26 VDD pmos W=0.325u L=0.04u
M22810 U6106/net26 n5480 VDD VDD pmos W=0.41u L=0.04u
M22811 n2845 n5481 U6106/net30 VDD pmos W=0.325u L=0.04u
M22812 U6106/net30 g2421 VDD VDD pmos W=0.205u L=0.04u
M22813 U6107/net19 n5481 VSS VSS nmos W=0.155u L=0.04u
M22814 n2844 n5481 U6107/net40 VSS nmos W=0.155u L=0.04u
M22815 n2844 U6107/net19 U6107/net36 VSS nmos W=0.155u L=0.04u
M22816 U6107/net40 n5482 VSS VSS nmos W=0.31u L=0.04u
M22817 U6107/net36 g2436 VSS VSS nmos W=0.155u L=0.04u
M22818 U6107/net19 n5481 VDD VDD pmos W=0.205u L=0.04u
M22819 n2844 U6107/net19 U6107/net26 VDD pmos W=0.325u L=0.04u
M22820 U6107/net26 n5482 VDD VDD pmos W=0.41u L=0.04u
M22821 n2844 n5481 U6107/net30 VDD pmos W=0.325u L=0.04u
M22822 U6107/net30 g2436 VDD VDD pmos W=0.205u L=0.04u
M22823 U6108/net19 n5481 VSS VSS nmos W=0.155u L=0.04u
M22824 n2843 n5481 U6108/net40 VSS nmos W=0.155u L=0.04u
M22825 n2843 U6108/net19 U6108/net36 VSS nmos W=0.155u L=0.04u
M22826 U6108/net40 n5483 VSS VSS nmos W=0.31u L=0.04u
M22827 U6108/net36 g2451 VSS VSS nmos W=0.155u L=0.04u
M22828 U6108/net19 n5481 VDD VDD pmos W=0.205u L=0.04u
M22829 n2843 U6108/net19 U6108/net26 VDD pmos W=0.325u L=0.04u
M22830 U6108/net26 n5483 VDD VDD pmos W=0.41u L=0.04u
M22831 n2843 n5481 U6108/net30 VDD pmos W=0.325u L=0.04u
M22832 U6108/net30 g2451 VDD VDD pmos W=0.205u L=0.04u
M22833 U6109/net19 n5481 VSS VSS nmos W=0.155u L=0.04u
M22834 n2842 n5481 U6109/net40 VSS nmos W=0.155u L=0.04u
M22835 n2842 U6109/net19 U6109/net36 VSS nmos W=0.155u L=0.04u
M22836 U6109/net40 n5484 VSS VSS nmos W=0.31u L=0.04u
M22837 U6109/net36 g2466 VSS VSS nmos W=0.155u L=0.04u
M22838 U6109/net19 n5481 VDD VDD pmos W=0.205u L=0.04u
M22839 n2842 U6109/net19 U6109/net26 VDD pmos W=0.325u L=0.04u
M22840 U6109/net26 n5484 VDD VDD pmos W=0.41u L=0.04u
M22841 n2842 n5481 U6109/net30 VDD pmos W=0.325u L=0.04u
M22842 U6109/net30 g2466 VDD VDD pmos W=0.205u L=0.04u
M22843 n5481 n4530 VSS VSS nmos W=0.155u L=0.04u
M22844 n5481 n2833 VSS VSS nmos W=0.155u L=0.04u
M22845 U6110/XI1-net8 n2833 VDD VDD pmos W=0.205u L=0.04u
M22846 n5481 n4530 U6110/XI1-net8 VDD pmos W=0.205u L=0.04u
M22847 U6111/net19 n5485 VSS VSS nmos W=0.155u L=0.04u
M22848 n2841 n5485 U6111/net40 VSS nmos W=0.155u L=0.04u
M22849 n2841 U6111/net19 U6111/net36 VSS nmos W=0.155u L=0.04u
M22850 U6111/net40 n5480 VSS VSS nmos W=0.31u L=0.04u
M22851 U6111/net36 g2418 VSS VSS nmos W=0.155u L=0.04u
M22852 U6111/net19 n5485 VDD VDD pmos W=0.205u L=0.04u
M22853 n2841 U6111/net19 U6111/net26 VDD pmos W=0.325u L=0.04u
M22854 U6111/net26 n5480 VDD VDD pmos W=0.41u L=0.04u
M22855 n2841 n5485 U6111/net30 VDD pmos W=0.325u L=0.04u
M22856 U6111/net30 g2418 VDD VDD pmos W=0.205u L=0.04u
M22857 U6112/net19 n5486 VSS VSS nmos W=0.155u L=0.04u
M22858 n2840 n5486 U6112/net40 VSS nmos W=0.155u L=0.04u
M22859 n2840 U6112/net19 U6112/net36 VSS nmos W=0.155u L=0.04u
M22860 U6112/net40 n5480 VSS VSS nmos W=0.31u L=0.04u
M22861 U6112/net36 g2429 VSS VSS nmos W=0.155u L=0.04u
M22862 U6112/net19 n5486 VDD VDD pmos W=0.205u L=0.04u
M22863 n2840 U6112/net19 U6112/net26 VDD pmos W=0.325u L=0.04u
M22864 U6112/net26 n5480 VDD VDD pmos W=0.41u L=0.04u
M22865 n2840 n5486 U6112/net30 VDD pmos W=0.325u L=0.04u
M22866 U6112/net30 g2429 VDD VDD pmos W=0.205u L=0.04u
M22867 U6113/net7 n5487 U6113/X_u4-net10 VSS nmos W=0.155u L=0.04u
M22868 U6113/X_u4-net10 n5488 U6113/X_u4-net13 VSS nmos W=0.155u L=0.04u
M22869 U6113/X_u4-net13 n5489 VSS VSS nmos W=0.155u L=0.04u
M22870 n5480 U6113/net7 VSS VSS nmos W=0.155u L=0.04u
M22871 U6113/net7 n5489 VDD VDD pmos W=0.205u L=0.04u
M22872 U6113/net7 n5487 VDD VDD pmos W=0.205u L=0.04u
M22873 U6113/net7 n5488 VDD VDD pmos W=0.205u L=0.04u
M22874 n5480 U6113/net7 VDD VDD pmos W=0.205u L=0.04u
M22875 U6114/net19 n3937 VSS VSS nmos W=0.155u L=0.04u
M22876 n5489 n3937 U6114/net40 VSS nmos W=0.155u L=0.04u
M22877 n5489 U6114/net19 U6114/net36 VSS nmos W=0.155u L=0.04u
M22878 U6114/net40 n5491 VSS VSS nmos W=0.31u L=0.04u
M22879 U6114/net36 n5490 VSS VSS nmos W=0.155u L=0.04u
M22880 U6114/net19 n3937 VDD VDD pmos W=0.205u L=0.04u
M22881 n5489 U6114/net19 U6114/net26 VDD pmos W=0.325u L=0.04u
M22882 U6114/net26 n5491 VDD VDD pmos W=0.41u L=0.04u
M22883 n5489 n3937 U6114/net30 VDD pmos W=0.325u L=0.04u
M22884 U6114/net30 n5490 VDD VDD pmos W=0.205u L=0.04u
M22885 n5491 g12120 U6115/net15 VSS nmos W=0.155u L=0.04u
M22886 n5491 n5490 U6115/net15 VSS nmos W=0.155u L=0.04u
M22887 U6115/net15 n5492 VSS VSS nmos W=0.155u L=0.04u
M22888 n5491 n5492 VDD VDD pmos W=0.205u L=0.04u
M22889 n5491 g12120 U6115/XI16-net11 VDD pmos W=0.205u L=0.04u
M22890 U6115/XI16-net11 n5490 VDD VDD pmos W=0.205u L=0.04u
M22891 U6116/net19 n5485 VSS VSS nmos W=0.155u L=0.04u
M22892 n2839 n5485 U6116/net40 VSS nmos W=0.155u L=0.04u
M22893 n2839 U6116/net19 U6116/net36 VSS nmos W=0.155u L=0.04u
M22894 U6116/net40 n5482 VSS VSS nmos W=0.31u L=0.04u
M22895 U6116/net36 g2433 VSS VSS nmos W=0.155u L=0.04u
M22896 U6116/net19 n5485 VDD VDD pmos W=0.205u L=0.04u
M22897 n2839 U6116/net19 U6116/net26 VDD pmos W=0.325u L=0.04u
M22898 U6116/net26 n5482 VDD VDD pmos W=0.41u L=0.04u
M22899 n2839 n5485 U6116/net30 VDD pmos W=0.325u L=0.04u
M22900 U6116/net30 g2433 VDD VDD pmos W=0.205u L=0.04u
M22901 U6117/net19 n5486 VSS VSS nmos W=0.155u L=0.04u
M22902 n2838 n5486 U6117/net40 VSS nmos W=0.155u L=0.04u
M22903 n2838 U6117/net19 U6117/net36 VSS nmos W=0.155u L=0.04u
M22904 U6117/net40 n5482 VSS VSS nmos W=0.31u L=0.04u
M22905 U6117/net36 g2444 VSS VSS nmos W=0.155u L=0.04u
M22906 U6117/net19 n5486 VDD VDD pmos W=0.205u L=0.04u
M22907 n2838 U6117/net19 U6117/net26 VDD pmos W=0.325u L=0.04u
M22908 U6117/net26 n5482 VDD VDD pmos W=0.41u L=0.04u
M22909 n2838 n5486 U6117/net30 VDD pmos W=0.325u L=0.04u
M22910 U6117/net30 g2444 VDD VDD pmos W=0.205u L=0.04u
M22911 U6118/net36 n5492 U6118/net24 VSS nmos W=0.155u L=0.04u
M22912 U6118/net24 n5487 VSS VSS nmos W=0.155u L=0.04u
M22913 U6118/net33 n5493 U6118/net36 VSS nmos W=0.155u L=0.04u
M22914 U6118/net33 n5494 U6118/net36 VSS nmos W=0.155u L=0.04u
M22915 n5482 U6118/net33 VSS VSS nmos W=0.155u L=0.04u
M22916 n5482 U6118/net33 VDD VDD pmos W=0.205u L=0.04u
M22917 U6118/net33 n5494 U6118/net35 VDD pmos W=0.205u L=0.04u
M22918 U6118/net35 n5493 VDD VDD pmos W=0.205u L=0.04u
M22919 U6118/net33 n5487 VDD VDD pmos W=0.205u L=0.04u
M22920 U6118/net33 n5492 VDD VDD pmos W=0.205u L=0.04u
M22921 n5487 n5493 U6119/XI0-net10 VSS nmos W=0.155u L=0.04u
M22922 U6119/XI0-net10 n5495 U6119/XI0-net13 VSS nmos W=0.155u L=0.04u
M22923 U6119/XI0-net13 g3229 VSS VSS nmos W=0.155u L=0.04u
M22924 n5487 g3229 VDD VDD pmos W=0.205u L=0.04u
M22925 n5487 n5493 VDD VDD pmos W=0.205u L=0.04u
M22926 n5487 n5495 VDD VDD pmos W=0.205u L=0.04u
M22927 U6120/net13 g12179 VSS VSS nmos W=0.155u L=0.04u
M22928 U6120/net16 U6120/net13 VSS VSS nmos W=0.155u L=0.04u
M22929 n5492 g12224 U6120/net16 VSS nmos W=0.155u L=0.04u
M22930 U6120/net13 g12179 VDD VDD pmos W=0.205u L=0.04u
M22931 VDD U6120/net13 n5492 VDD pmos W=0.205u L=0.04u
M22932 VDD g12224 n5492 VDD pmos W=0.205u L=0.04u
M22933 U6121/XU1-net6 n3937 VSS VSS nmos W=0.155u L=0.04u
M22934 n5494 n5495 U6121/XU1-net6 VSS nmos W=0.155u L=0.04u
M22935 n5494 n3937 VDD VDD pmos W=0.155u L=0.04u
M22936 n5494 n5495 VDD VDD pmos W=0.155u L=0.04u
M22937 n5495 g12224 VSS VSS nmos W=0.135u L=0.04u
M22938 n5495 g12224 VDD VDD pmos W=0.205u L=0.04u
M22939 U6123/net19 n5485 VSS VSS nmos W=0.155u L=0.04u
M22940 n2837 n5485 U6123/net40 VSS nmos W=0.155u L=0.04u
M22941 n2837 U6123/net19 U6123/net36 VSS nmos W=0.155u L=0.04u
M22942 U6123/net40 n5483 VSS VSS nmos W=0.31u L=0.04u
M22943 U6123/net36 g2448 VSS VSS nmos W=0.155u L=0.04u
M22944 U6123/net19 n5485 VDD VDD pmos W=0.205u L=0.04u
M22945 n2837 U6123/net19 U6123/net26 VDD pmos W=0.325u L=0.04u
M22946 U6123/net26 n5483 VDD VDD pmos W=0.41u L=0.04u
M22947 n2837 n5485 U6123/net30 VDD pmos W=0.325u L=0.04u
M22948 U6123/net30 g2448 VDD VDD pmos W=0.205u L=0.04u
M22949 U6124/net19 n5486 VSS VSS nmos W=0.155u L=0.04u
M22950 n2836 n5486 U6124/net40 VSS nmos W=0.155u L=0.04u
M22951 n2836 U6124/net19 U6124/net36 VSS nmos W=0.155u L=0.04u
M22952 U6124/net40 n5483 VSS VSS nmos W=0.31u L=0.04u
M22953 U6124/net36 g2459 VSS VSS nmos W=0.155u L=0.04u
M22954 U6124/net19 n5486 VDD VDD pmos W=0.205u L=0.04u
M22955 n2836 U6124/net19 U6124/net26 VDD pmos W=0.325u L=0.04u
M22956 U6124/net26 n5483 VDD VDD pmos W=0.41u L=0.04u
M22957 n2836 n5486 U6124/net30 VDD pmos W=0.325u L=0.04u
M22958 U6124/net30 g2459 VDD VDD pmos W=0.205u L=0.04u
M22959 U6125/net36 n5488 U6125/net24 VSS nmos W=0.155u L=0.04u
M22960 U6125/net24 n5497 VSS VSS nmos W=0.155u L=0.04u
M22961 U6125/net33 g12179 U6125/net36 VSS nmos W=0.155u L=0.04u
M22962 U6125/net33 n5496 U6125/net36 VSS nmos W=0.155u L=0.04u
M22963 n5483 U6125/net33 VSS VSS nmos W=0.155u L=0.04u
M22964 n5483 U6125/net33 VDD VDD pmos W=0.205u L=0.04u
M22965 U6125/net33 n5496 U6125/net35 VDD pmos W=0.205u L=0.04u
M22966 U6125/net35 g12179 VDD VDD pmos W=0.205u L=0.04u
M22967 U6125/net33 n5497 VDD VDD pmos W=0.205u L=0.04u
M22968 U6125/net33 n5488 VDD VDD pmos W=0.205u L=0.04u
M22969 U6126/net19 g12179 VSS VSS nmos W=0.155u L=0.04u
M22970 n5497 g12179 U6126/net40 VSS nmos W=0.155u L=0.04u
M22971 n5497 U6126/net19 U6126/net36 VSS nmos W=0.155u L=0.04u
M22972 U6126/net40 n5499 VSS VSS nmos W=0.31u L=0.04u
M22973 U6126/net36 n5498 VSS VSS nmos W=0.155u L=0.04u
M22974 U6126/net19 g12179 VDD VDD pmos W=0.205u L=0.04u
M22975 n5497 U6126/net19 U6126/net26 VDD pmos W=0.325u L=0.04u
M22976 U6126/net26 n5499 VDD VDD pmos W=0.41u L=0.04u
M22977 n5497 g12179 U6126/net30 VDD pmos W=0.325u L=0.04u
M22978 U6126/net30 n5498 VDD VDD pmos W=0.205u L=0.04u
M22979 n5499 n5490 VSS VSS nmos W=0.155u L=0.04u
M22980 n5499 g3229 VSS VSS nmos W=0.155u L=0.04u
M22981 n5499 n5493 VSS VSS nmos W=0.155u L=0.04u
M22982 U6127/net25 n5490 VDD VDD pmos W=0.41u L=0.04u
M22983 U6127/net28 g3229 U6127/net25 VDD pmos W=0.41u L=0.04u
M22984 n5499 n5493 U6127/net28 VDD pmos W=0.41u L=0.04u
M22985 n5490 g12268 VSS VSS nmos W=0.135u L=0.04u
M22986 n5490 g12268 VDD VDD pmos W=0.205u L=0.04u
M22987 U6129/p2 n5493 VSS VSS nmos W=0.155u L=0.04u
M22988 U6129/p0 g12179 U6129/p1 VSS nmos W=0.155u L=0.04u
M22989 U6129/p1 g3229 U6129/p2 VSS nmos W=0.155u L=0.04u
M22990 n5488 g12268 U6129/p0 VSS nmos W=0.155u L=0.04u
M22991 n5488 g3229 VDD VDD pmos W=0.205u L=0.04u
M22992 n5488 g12179 VDD VDD pmos W=0.205u L=0.04u
M22993 n5488 g12268 VDD VDD pmos W=0.205u L=0.04u
M22994 n5488 n5493 VDD VDD pmos W=0.205u L=0.04u
M22995 n5496 n5500 VSS VSS nmos W=0.135u L=0.04u
M22996 n5496 n5500 VDD VDD pmos W=0.205u L=0.04u
M22997 U6131/net19 n5485 VSS VSS nmos W=0.155u L=0.04u
M22998 n2835 n5485 U6131/net40 VSS nmos W=0.155u L=0.04u
M22999 n2835 U6131/net19 U6131/net36 VSS nmos W=0.155u L=0.04u
M23000 U6131/net40 n5484 VSS VSS nmos W=0.31u L=0.04u
M23001 U6131/net36 g2463 VSS VSS nmos W=0.155u L=0.04u
M23002 U6131/net19 n5485 VDD VDD pmos W=0.205u L=0.04u
M23003 n2835 U6131/net19 U6131/net26 VDD pmos W=0.325u L=0.04u
M23004 U6131/net26 n5484 VDD VDD pmos W=0.41u L=0.04u
M23005 n2835 n5485 U6131/net30 VDD pmos W=0.325u L=0.04u
M23006 U6131/net30 g2463 VDD VDD pmos W=0.205u L=0.04u
M23007 n5485 n4330 VSS VSS nmos W=0.155u L=0.04u
M23008 n5485 n2833 VSS VSS nmos W=0.155u L=0.04u
M23009 U6132/XI1-net8 n2833 VDD VDD pmos W=0.205u L=0.04u
M23010 n5485 n4330 U6132/XI1-net8 VDD pmos W=0.205u L=0.04u
M23011 U6133/net19 n5486 VSS VSS nmos W=0.155u L=0.04u
M23012 n2834 n5486 U6133/net40 VSS nmos W=0.155u L=0.04u
M23013 n2834 U6133/net19 U6133/net36 VSS nmos W=0.155u L=0.04u
M23014 U6133/net40 n5484 VSS VSS nmos W=0.31u L=0.04u
M23015 U6133/net36 g2473 VSS VSS nmos W=0.155u L=0.04u
M23016 U6133/net19 n5486 VDD VDD pmos W=0.205u L=0.04u
M23017 n2834 U6133/net19 U6133/net26 VDD pmos W=0.325u L=0.04u
M23018 U6133/net26 n5484 VDD VDD pmos W=0.41u L=0.04u
M23019 n2834 n5486 U6133/net30 VDD pmos W=0.325u L=0.04u
M23020 U6133/net30 g2473 VDD VDD pmos W=0.205u L=0.04u
M23021 n5486 n4529 VSS VSS nmos W=0.155u L=0.04u
M23022 n5486 n2833 VSS VSS nmos W=0.155u L=0.04u
M23023 U6134/XI1-net8 n2833 VDD VDD pmos W=0.205u L=0.04u
M23024 n5486 n4529 U6134/XI1-net8 VDD pmos W=0.205u L=0.04u
M23025 U6135/net36 g12179 U6135/net24 VSS nmos W=0.155u L=0.04u
M23026 U6135/net24 g12224 VSS VSS nmos W=0.155u L=0.04u
M23027 n5484 n5498 U6135/net36 VSS nmos W=0.155u L=0.04u
M23028 n5484 n5500 U6135/net36 VSS nmos W=0.155u L=0.04u
M23029 n5484 n5500 U6135/net35 VDD pmos W=0.205u L=0.04u
M23030 U6135/net35 n5498 VDD VDD pmos W=0.205u L=0.04u
M23031 n5484 g12224 VDD VDD pmos W=0.205u L=0.04u
M23032 n5484 g12179 VDD VDD pmos W=0.205u L=0.04u
M23033 n5500 g3229 VSS VSS nmos W=0.155u L=0.04u
M23034 n5500 g12120 VSS VSS nmos W=0.155u L=0.04u
M23035 U6136/XI1-net8 g12120 VDD VDD pmos W=0.205u L=0.04u
M23036 n5500 g3229 U6136/XI1-net8 VDD pmos W=0.205u L=0.04u
M23037 n5498 n5493 VSS VSS nmos W=0.155u L=0.04u
M23038 n5498 n3937 VSS VSS nmos W=0.155u L=0.04u
M23039 U6137/XI1-net8 n3937 VDD VDD pmos W=0.205u L=0.04u
M23040 n5498 n5493 U6137/XI1-net8 VDD pmos W=0.205u L=0.04u
M23041 n5493 g12120 VSS VSS nmos W=0.135u L=0.04u
M23042 n5493 g12120 VDD VDD pmos W=0.205u L=0.04u
M23043 n2833 n3954 U6139/net15 VSS nmos W=0.155u L=0.04u
M23044 n2833 n5437 U6139/net15 VSS nmos W=0.155u L=0.04u
M23045 U6139/net15 n3956 VSS VSS nmos W=0.155u L=0.04u
M23046 n2833 n3956 VDD VDD pmos W=0.205u L=0.04u
M23047 n2833 n3954 U6139/XI16-net11 VDD pmos W=0.205u L=0.04u
M23048 U6139/XI16-net11 n5437 VDD VDD pmos W=0.205u L=0.04u
M23049 U6140/XU1-net6 n5502 VSS VSS nmos W=0.155u L=0.04u
M23050 n2832 n5501 U6140/XU1-net6 VSS nmos W=0.155u L=0.04u
M23051 n2832 n5502 VDD VDD pmos W=0.155u L=0.04u
M23052 n2832 n5501 VDD VDD pmos W=0.155u L=0.04u
M23053 U6141/net4 U6141/net10 U6141/net14 VSS nmos W=0.155u L=0.04u
M23054 U6141/net6 g52 U6141/net14 VSS nmos W=0.155u L=0.04u
M23055 U6141/net4 n5503 VSS VSS nmos W=0.155u L=0.04u
M23056 U6141/net6 U6141/net4 VSS VSS nmos W=0.155u L=0.04u
M23057 n5501 U6141/net14 VSS VSS nmos W=0.155u L=0.04u
M23058 U6141/net10 g52 VSS VSS nmos W=0.155u L=0.04u
M23059 U6141/net4 g52 U6141/net14 VDD pmos W=0.205u L=0.04u
M23060 U6141/net6 U6141/net10 U6141/net14 VDD pmos W=0.205u L=0.04u
M23061 U6141/net4 n5503 VDD VDD pmos W=0.205u L=0.04u
M23062 U6141/net6 U6141/net4 VDD VDD pmos W=0.205u L=0.04u
M23063 n5501 U6141/net14 VDD VDD pmos W=0.205u L=0.04u
M23064 U6141/net10 g52 VDD VDD pmos W=0.205u L=0.04u
M23065 n5503 n5504 VSS VSS nmos W=0.155u L=0.04u
M23066 n5503 n5505 VSS VSS nmos W=0.155u L=0.04u
M23067 U6142/XI1-net8 n5505 VDD VDD pmos W=0.205u L=0.04u
M23068 n5503 n5504 U6142/XI1-net8 VDD pmos W=0.205u L=0.04u
M23069 U6143/XU1-net6 n5502 VSS VSS nmos W=0.155u L=0.04u
M23070 n2831 n5506 U6143/XU1-net6 VSS nmos W=0.155u L=0.04u
M23071 n2831 n5502 VDD VDD pmos W=0.155u L=0.04u
M23072 n2831 n5506 VDD VDD pmos W=0.155u L=0.04u
M23073 U6144/net4 n5504 U6144/net14 VSS nmos W=0.155u L=0.04u
M23074 U6144/net6 U6144/net10 U6144/net14 VSS nmos W=0.17u L=0.04u
M23075 U6144/net4 g56 VSS VSS nmos W=0.155u L=0.04u
M23076 U6144/net6 U6144/net4 VSS VSS nmos W=0.17u L=0.04u
M23077 n5506 U6144/net14 VSS VSS nmos W=0.155u L=0.04u
M23078 U6144/net10 n5504 VSS VSS nmos W=0.155u L=0.04u
M23079 U6144/net4 U6144/net10 U6144/net14 VDD pmos W=0.255u L=0.04u
M23080 U6144/net6 n5504 U6144/net14 VDD pmos W=0.28u L=0.04u
M23081 U6144/net4 g56 VDD VDD pmos W=0.205u L=0.04u
M23082 U6144/net6 U6144/net4 VDD VDD pmos W=0.24u L=0.04u
M23083 n5506 U6144/net14 VDD VDD pmos W=0.205u L=0.04u
M23084 U6144/net10 n5504 VDD VDD pmos W=0.205u L=0.04u
M23085 U6145/net36 n5504 U6145/net24 VSS nmos W=0.155u L=0.04u
M23086 U6145/net24 n5502 VSS VSS nmos W=0.155u L=0.04u
M23087 n2830 g61 U6145/net36 VSS nmos W=0.155u L=0.04u
M23088 n2830 n5507 U6145/net36 VSS nmos W=0.155u L=0.04u
M23089 n2830 n5507 U6145/net35 VDD pmos W=0.205u L=0.04u
M23090 U6145/net35 g61 VDD VDD pmos W=0.205u L=0.04u
M23091 n2830 n5502 VDD VDD pmos W=0.205u L=0.04u
M23092 n2830 n5504 VDD VDD pmos W=0.205u L=0.04u
M23093 U6146/XU1-net6 n5507 VSS VSS nmos W=0.155u L=0.04u
M23094 n5504 g61 U6146/XU1-net6 VSS nmos W=0.155u L=0.04u
M23095 n5504 n5507 VDD VDD pmos W=0.155u L=0.04u
M23096 n5504 g61 VDD VDD pmos W=0.155u L=0.04u
M23097 n5507 n5508 VSS VSS nmos W=0.135u L=0.04u
M23098 n5507 n5508 VDD VDD pmos W=0.205u L=0.04u
M23099 U6148/net36 n5508 U6148/net24 VSS nmos W=0.155u L=0.04u
M23100 U6148/net24 n5502 VSS VSS nmos W=0.155u L=0.04u
M23101 n2829 g65 U6148/net36 VSS nmos W=0.155u L=0.04u
M23102 n2829 n5509 U6148/net36 VSS nmos W=0.155u L=0.04u
M23103 n2829 n5509 U6148/net35 VDD pmos W=0.205u L=0.04u
M23104 U6148/net35 g65 VDD VDD pmos W=0.205u L=0.04u
M23105 n2829 n5502 VDD VDD pmos W=0.205u L=0.04u
M23106 n2829 n5508 VDD VDD pmos W=0.205u L=0.04u
M23107 U6149/XU1-net6 n5509 VSS VSS nmos W=0.155u L=0.04u
M23108 n5508 g65 U6149/XU1-net6 VSS nmos W=0.155u L=0.04u
M23109 n5508 n5509 VDD VDD pmos W=0.155u L=0.04u
M23110 n5508 g65 VDD VDD pmos W=0.155u L=0.04u
M23111 n5509 n5510 VSS VSS nmos W=0.135u L=0.04u
M23112 n5509 n5510 VDD VDD pmos W=0.205u L=0.04u
M23113 U6151/net36 n5510 U6151/net24 VSS nmos W=0.155u L=0.04u
M23114 U6151/net24 n5502 VSS VSS nmos W=0.155u L=0.04u
M23115 n2828 g70 U6151/net36 VSS nmos W=0.155u L=0.04u
M23116 n2828 n5511 U6151/net36 VSS nmos W=0.155u L=0.04u
M23117 n2828 n5511 U6151/net35 VDD pmos W=0.205u L=0.04u
M23118 U6151/net35 g70 VDD VDD pmos W=0.205u L=0.04u
M23119 n2828 n5502 VDD VDD pmos W=0.205u L=0.04u
M23120 n2828 n5510 VDD VDD pmos W=0.205u L=0.04u
M23121 U6152/XU1-net6 n5511 VSS VSS nmos W=0.155u L=0.04u
M23122 n5510 g70 U6152/XU1-net6 VSS nmos W=0.155u L=0.04u
M23123 n5510 n5511 VDD VDD pmos W=0.155u L=0.04u
M23124 n5510 g70 VDD VDD pmos W=0.155u L=0.04u
M23125 n5511 n5512 VSS VSS nmos W=0.135u L=0.04u
M23126 n5511 n5512 VDD VDD pmos W=0.205u L=0.04u
M23127 U6154/net36 n5512 U6154/net24 VSS nmos W=0.155u L=0.04u
M23128 U6154/net24 n5502 VSS VSS nmos W=0.155u L=0.04u
M23129 n2827 g74 U6154/net36 VSS nmos W=0.155u L=0.04u
M23130 n2827 n5513 U6154/net36 VSS nmos W=0.155u L=0.04u
M23131 n2827 n5513 U6154/net35 VDD pmos W=0.205u L=0.04u
M23132 U6154/net35 g74 VDD VDD pmos W=0.205u L=0.04u
M23133 n2827 n5502 VDD VDD pmos W=0.205u L=0.04u
M23134 n2827 n5512 VDD VDD pmos W=0.205u L=0.04u
M23135 U6155/XU1-net6 n5513 VSS VSS nmos W=0.155u L=0.04u
M23136 n5512 g74 U6155/XU1-net6 VSS nmos W=0.155u L=0.04u
M23137 n5512 n5513 VDD VDD pmos W=0.155u L=0.04u
M23138 n5512 g74 VDD VDD pmos W=0.155u L=0.04u
M23139 n5513 n5514 VSS VSS nmos W=0.135u L=0.04u
M23140 n5513 n5514 VDD VDD pmos W=0.205u L=0.04u
M23141 U6157/net36 n5514 U6157/net24 VSS nmos W=0.155u L=0.04u
M23142 U6157/net24 n5502 VSS VSS nmos W=0.155u L=0.04u
M23143 n2826 g79 U6157/net36 VSS nmos W=0.155u L=0.04u
M23144 n2826 n5515 U6157/net36 VSS nmos W=0.155u L=0.04u
M23145 n2826 n5515 U6157/net35 VDD pmos W=0.205u L=0.04u
M23146 U6157/net35 g79 VDD VDD pmos W=0.205u L=0.04u
M23147 n2826 n5502 VDD VDD pmos W=0.205u L=0.04u
M23148 n2826 n5514 VDD VDD pmos W=0.205u L=0.04u
M23149 U6158/XU1-net6 n5515 VSS VSS nmos W=0.155u L=0.04u
M23150 n5514 g79 U6158/XU1-net6 VSS nmos W=0.155u L=0.04u
M23151 n5514 n5515 VDD VDD pmos W=0.155u L=0.04u
M23152 n5514 g79 VDD VDD pmos W=0.155u L=0.04u
M23153 n5515 n5516 VSS VSS nmos W=0.135u L=0.04u
M23154 n5515 n5516 VDD VDD pmos W=0.205u L=0.04u
M23155 U6160/net36 n5516 U6160/net24 VSS nmos W=0.155u L=0.04u
M23156 U6160/net24 n5502 VSS VSS nmos W=0.155u L=0.04u
M23157 n2825 g83 U6160/net36 VSS nmos W=0.155u L=0.04u
M23158 n2825 n5517 U6160/net36 VSS nmos W=0.155u L=0.04u
M23159 n2825 n5517 U6160/net35 VDD pmos W=0.205u L=0.04u
M23160 U6160/net35 g83 VDD VDD pmos W=0.205u L=0.04u
M23161 n2825 n5502 VDD VDD pmos W=0.205u L=0.04u
M23162 n2825 n5516 VDD VDD pmos W=0.205u L=0.04u
M23163 U6161/XU1-net6 n5517 VSS VSS nmos W=0.155u L=0.04u
M23164 n5516 g83 U6161/XU1-net6 VSS nmos W=0.155u L=0.04u
M23165 n5516 n5517 VDD VDD pmos W=0.155u L=0.04u
M23166 n5516 g83 VDD VDD pmos W=0.155u L=0.04u
M23167 n2824 U6162/net27 VDD VDD pmos W=0.205u L=0.04u
M23168 U6162/net11 n5518 U6162/net27 VDD pmos W=0.205u L=0.04u
M23169 U6162/net11 n5519 U6162/net27 VDD pmos W=0.205u L=0.04u
M23170 U6162/net11 n5517 U6162/XI16-net11 VDD pmos W=0.205u L=0.04u
M23171 U6162/XI16-net11 n5520 VDD VDD pmos W=0.205u L=0.04u
M23172 U6162/net27 n5520 VSS VSS nmos W=0.155u L=0.04u
M23173 U6162/net27 n5517 VSS VSS nmos W=0.155u L=0.04u
M23174 n2824 U6162/net27 VSS VSS nmos W=0.155u L=0.04u
M23175 U6162/net27 n5518 U6162/XI12-net17 VSS nmos W=0.155u L=0.04u
M23176 U6162/XI12-net17 n5519 VSS VSS nmos W=0.155u L=0.04u
M23177 n5520 n5502 VSS VSS nmos W=0.135u L=0.04u
M23178 n5520 n5502 VDD VDD pmos W=0.205u L=0.04u
M23179 n5517 n5518 VSS VSS nmos W=0.155u L=0.04u
M23180 n5517 n5519 VSS VSS nmos W=0.155u L=0.04u
M23181 U6164/XI1-net8 n5519 VDD VDD pmos W=0.205u L=0.04u
M23182 n5517 n5518 U6164/XI1-net8 VDD pmos W=0.205u L=0.04u
M23183 U6165/net36 n5519 U6165/net24 VSS nmos W=0.155u L=0.04u
M23184 U6165/net24 n5502 VSS VSS nmos W=0.155u L=0.04u
M23185 n2823 g92 U6165/net36 VSS nmos W=0.155u L=0.04u
M23186 n2823 n5521 U6165/net36 VSS nmos W=0.155u L=0.04u
M23187 n2823 n5521 U6165/net35 VDD pmos W=0.205u L=0.04u
M23188 U6165/net35 g92 VDD VDD pmos W=0.205u L=0.04u
M23189 n2823 n5502 VDD VDD pmos W=0.205u L=0.04u
M23190 n2823 n5519 VDD VDD pmos W=0.205u L=0.04u
M23191 U6166/XU1-net6 n4342 VSS VSS nmos W=0.155u L=0.04u
M23192 n5502 n5522 U6166/XU1-net6 VSS nmos W=0.155u L=0.04u
M23193 n5502 n4342 VDD VDD pmos W=0.155u L=0.04u
M23194 n5502 n5522 VDD VDD pmos W=0.155u L=0.04u
M23195 n4342 U6167/net6 VSS VSS nmos W=0.155u L=0.04u
M23196 U6167/X_u2-net6 g165 VSS VSS nmos W=0.155u L=0.04u
M23197 U6167/net6 g181 U6167/X_u2-net6 VSS nmos W=0.155u L=0.04u
M23198 n4342 U6167/net6 VDD VDD pmos W=0.205u L=0.04u
M23199 U6167/net6 g165 VDD VDD pmos W=0.205u L=0.04u
M23200 U6167/net6 g181 VDD VDD pmos W=0.205u L=0.04u
M23201 U6168/XU1-net6 n5521 VSS VSS nmos W=0.155u L=0.04u
M23202 n5519 g92 U6168/XU1-net6 VSS nmos W=0.155u L=0.04u
M23203 n5519 n5521 VDD VDD pmos W=0.155u L=0.04u
M23204 n5519 g92 VDD VDD pmos W=0.155u L=0.04u
M23205 n5521 n4770 VSS VSS nmos W=0.155u L=0.04u
M23206 n5521 n5522 VSS VSS nmos W=0.155u L=0.04u
M23207 U6169/XI1-net8 n5522 VDD VDD pmos W=0.205u L=0.04u
M23208 n5521 n4770 U6169/XI1-net8 VDD pmos W=0.205u L=0.04u
M23209 U6170/XU1-net6 n5524 VSS VSS nmos W=0.155u L=0.04u
M23210 n2822 n5523 U6170/XU1-net6 VSS nmos W=0.155u L=0.04u
M23211 n2822 n5524 VDD VDD pmos W=0.155u L=0.04u
M23212 n2822 n5523 VDD VDD pmos W=0.155u L=0.04u
M23213 U6171/net4 U6171/net10 U6171/net14 VSS nmos W=0.155u L=0.04u
M23214 U6171/net6 g740 U6171/net14 VSS nmos W=0.155u L=0.04u
M23215 U6171/net4 n5525 VSS VSS nmos W=0.155u L=0.04u
M23216 U6171/net6 U6171/net4 VSS VSS nmos W=0.155u L=0.04u
M23217 n5523 U6171/net14 VSS VSS nmos W=0.155u L=0.04u
M23218 U6171/net10 g740 VSS VSS nmos W=0.155u L=0.04u
M23219 U6171/net4 g740 U6171/net14 VDD pmos W=0.205u L=0.04u
M23220 U6171/net6 U6171/net10 U6171/net14 VDD pmos W=0.205u L=0.04u
M23221 U6171/net4 n5525 VDD VDD pmos W=0.205u L=0.04u
M23222 U6171/net6 U6171/net4 VDD VDD pmos W=0.205u L=0.04u
M23223 n5523 U6171/net14 VDD VDD pmos W=0.205u L=0.04u
M23224 U6171/net10 g740 VDD VDD pmos W=0.205u L=0.04u
M23225 n5525 n5526 VSS VSS nmos W=0.155u L=0.04u
M23226 n5525 n5527 VSS VSS nmos W=0.155u L=0.04u
M23227 U6172/XI1-net8 n5527 VDD VDD pmos W=0.205u L=0.04u
M23228 n5525 n5526 U6172/XI1-net8 VDD pmos W=0.205u L=0.04u
M23229 U6173/XU1-net6 n5524 VSS VSS nmos W=0.155u L=0.04u
M23230 n2821 n5528 U6173/XU1-net6 VSS nmos W=0.155u L=0.04u
M23231 n2821 n5524 VDD VDD pmos W=0.155u L=0.04u
M23232 n2821 n5528 VDD VDD pmos W=0.155u L=0.04u
M23233 U6174/net4 n5526 U6174/net14 VSS nmos W=0.155u L=0.04u
M23234 U6174/net6 U6174/net10 U6174/net14 VSS nmos W=0.17u L=0.04u
M23235 U6174/net4 g744 VSS VSS nmos W=0.155u L=0.04u
M23236 U6174/net6 U6174/net4 VSS VSS nmos W=0.17u L=0.04u
M23237 n5528 U6174/net14 VSS VSS nmos W=0.155u L=0.04u
M23238 U6174/net10 n5526 VSS VSS nmos W=0.155u L=0.04u
M23239 U6174/net4 U6174/net10 U6174/net14 VDD pmos W=0.255u L=0.04u
M23240 U6174/net6 n5526 U6174/net14 VDD pmos W=0.28u L=0.04u
M23241 U6174/net4 g744 VDD VDD pmos W=0.205u L=0.04u
M23242 U6174/net6 U6174/net4 VDD VDD pmos W=0.24u L=0.04u
M23243 n5528 U6174/net14 VDD VDD pmos W=0.205u L=0.04u
M23244 U6174/net10 n5526 VDD VDD pmos W=0.205u L=0.04u
M23245 U6175/net36 n5526 U6175/net24 VSS nmos W=0.155u L=0.04u
M23246 U6175/net24 n5524 VSS VSS nmos W=0.155u L=0.04u
M23247 n2820 g749 U6175/net36 VSS nmos W=0.155u L=0.04u
M23248 n2820 n5529 U6175/net36 VSS nmos W=0.155u L=0.04u
M23249 n2820 n5529 U6175/net35 VDD pmos W=0.205u L=0.04u
M23250 U6175/net35 g749 VDD VDD pmos W=0.205u L=0.04u
M23251 n2820 n5524 VDD VDD pmos W=0.205u L=0.04u
M23252 n2820 n5526 VDD VDD pmos W=0.205u L=0.04u
M23253 U6176/XU1-net6 n5529 VSS VSS nmos W=0.155u L=0.04u
M23254 n5526 g749 U6176/XU1-net6 VSS nmos W=0.155u L=0.04u
M23255 n5526 n5529 VDD VDD pmos W=0.155u L=0.04u
M23256 n5526 g749 VDD VDD pmos W=0.155u L=0.04u
M23257 n5529 n5530 VSS VSS nmos W=0.135u L=0.04u
M23258 n5529 n5530 VDD VDD pmos W=0.205u L=0.04u
M23259 U6178/net36 n5530 U6178/net24 VSS nmos W=0.155u L=0.04u
M23260 U6178/net24 n5524 VSS VSS nmos W=0.155u L=0.04u
M23261 n2819 g753 U6178/net36 VSS nmos W=0.155u L=0.04u
M23262 n2819 n5531 U6178/net36 VSS nmos W=0.155u L=0.04u
M23263 n2819 n5531 U6178/net35 VDD pmos W=0.205u L=0.04u
M23264 U6178/net35 g753 VDD VDD pmos W=0.205u L=0.04u
M23265 n2819 n5524 VDD VDD pmos W=0.205u L=0.04u
M23266 n2819 n5530 VDD VDD pmos W=0.205u L=0.04u
M23267 U6179/XU1-net6 n5531 VSS VSS nmos W=0.155u L=0.04u
M23268 n5530 g753 U6179/XU1-net6 VSS nmos W=0.155u L=0.04u
M23269 n5530 n5531 VDD VDD pmos W=0.155u L=0.04u
M23270 n5530 g753 VDD VDD pmos W=0.155u L=0.04u
M23271 n2818 U6180/net27 VDD VDD pmos W=0.205u L=0.04u
M23272 U6180/net11 n5532 U6180/net27 VDD pmos W=0.205u L=0.04u
M23273 U6180/net11 n5533 U6180/net27 VDD pmos W=0.205u L=0.04u
M23274 U6180/net11 n5531 U6180/XI16-net11 VDD pmos W=0.205u L=0.04u
M23275 U6180/XI16-net11 n5534 VDD VDD pmos W=0.205u L=0.04u
M23276 U6180/net27 n5534 VSS VSS nmos W=0.155u L=0.04u
M23277 U6180/net27 n5531 VSS VSS nmos W=0.155u L=0.04u
M23278 n2818 U6180/net27 VSS VSS nmos W=0.155u L=0.04u
M23279 U6180/net27 n5532 U6180/XI12-net17 VSS nmos W=0.155u L=0.04u
M23280 U6180/XI12-net17 n5533 VSS VSS nmos W=0.155u L=0.04u
M23281 n5534 n5524 VSS VSS nmos W=0.135u L=0.04u
M23282 n5534 n5524 VDD VDD pmos W=0.205u L=0.04u
M23283 n5531 n5532 VSS VSS nmos W=0.155u L=0.04u
M23284 n5531 n5533 VSS VSS nmos W=0.155u L=0.04u
M23285 U6182/XI1-net8 n5533 VDD VDD pmos W=0.205u L=0.04u
M23286 n5531 n5532 U6182/XI1-net8 VDD pmos W=0.205u L=0.04u
M23287 U6183/net36 n5533 U6183/net24 VSS nmos W=0.155u L=0.04u
M23288 U6183/net24 n5524 VSS VSS nmos W=0.155u L=0.04u
M23289 n2817 g762 U6183/net36 VSS nmos W=0.155u L=0.04u
M23290 n2817 n5535 U6183/net36 VSS nmos W=0.155u L=0.04u
M23291 n2817 n5535 U6183/net35 VDD pmos W=0.205u L=0.04u
M23292 U6183/net35 g762 VDD VDD pmos W=0.205u L=0.04u
M23293 n2817 n5524 VDD VDD pmos W=0.205u L=0.04u
M23294 n2817 n5533 VDD VDD pmos W=0.205u L=0.04u
M23295 U6184/XU1-net6 n5535 VSS VSS nmos W=0.155u L=0.04u
M23296 n5533 g762 U6184/XU1-net6 VSS nmos W=0.155u L=0.04u
M23297 n5533 n5535 VDD VDD pmos W=0.155u L=0.04u
M23298 n5533 g762 VDD VDD pmos W=0.155u L=0.04u
M23299 n5535 n5536 VSS VSS nmos W=0.135u L=0.04u
M23300 n5535 n5536 VDD VDD pmos W=0.205u L=0.04u
M23301 U6186/net36 n5536 U6186/net24 VSS nmos W=0.155u L=0.04u
M23302 U6186/net24 n5524 VSS VSS nmos W=0.155u L=0.04u
M23303 n2816 g767 U6186/net36 VSS nmos W=0.155u L=0.04u
M23304 n2816 n5537 U6186/net36 VSS nmos W=0.155u L=0.04u
M23305 n2816 n5537 U6186/net35 VDD pmos W=0.205u L=0.04u
M23306 U6186/net35 g767 VDD VDD pmos W=0.205u L=0.04u
M23307 n2816 n5524 VDD VDD pmos W=0.205u L=0.04u
M23308 n2816 n5536 VDD VDD pmos W=0.205u L=0.04u
M23309 U6187/XU1-net6 n5537 VSS VSS nmos W=0.155u L=0.04u
M23310 n5536 g767 U6187/XU1-net6 VSS nmos W=0.155u L=0.04u
M23311 n5536 n5537 VDD VDD pmos W=0.155u L=0.04u
M23312 n5536 g767 VDD VDD pmos W=0.155u L=0.04u
M23313 n5537 n5538 VSS VSS nmos W=0.135u L=0.04u
M23314 n5537 n5538 VDD VDD pmos W=0.205u L=0.04u
M23315 U6189/net36 n5538 U6189/net24 VSS nmos W=0.155u L=0.04u
M23316 U6189/net24 n5524 VSS VSS nmos W=0.155u L=0.04u
M23317 n2815 g771 U6189/net36 VSS nmos W=0.155u L=0.04u
M23318 n2815 n5539 U6189/net36 VSS nmos W=0.155u L=0.04u
M23319 n2815 n5539 U6189/net35 VDD pmos W=0.205u L=0.04u
M23320 U6189/net35 g771 VDD VDD pmos W=0.205u L=0.04u
M23321 n2815 n5524 VDD VDD pmos W=0.205u L=0.04u
M23322 n2815 n5538 VDD VDD pmos W=0.205u L=0.04u
M23323 U6190/XU1-net6 n5539 VSS VSS nmos W=0.155u L=0.04u
M23324 n5538 g771 U6190/XU1-net6 VSS nmos W=0.155u L=0.04u
M23325 n5538 n5539 VDD VDD pmos W=0.155u L=0.04u
M23326 n5538 g771 VDD VDD pmos W=0.155u L=0.04u
M23327 n5539 n5540 VSS VSS nmos W=0.135u L=0.04u
M23328 n5539 n5540 VDD VDD pmos W=0.205u L=0.04u
M23329 U6192/net36 n5540 U6192/net24 VSS nmos W=0.155u L=0.04u
M23330 U6192/net24 n5524 VSS VSS nmos W=0.155u L=0.04u
M23331 n2814 g776 U6192/net36 VSS nmos W=0.155u L=0.04u
M23332 n2814 n5541 U6192/net36 VSS nmos W=0.155u L=0.04u
M23333 n2814 n5541 U6192/net35 VDD pmos W=0.205u L=0.04u
M23334 U6192/net35 g776 VDD VDD pmos W=0.205u L=0.04u
M23335 n2814 n5524 VDD VDD pmos W=0.205u L=0.04u
M23336 n2814 n5540 VDD VDD pmos W=0.205u L=0.04u
M23337 U6193/XU1-net6 n5541 VSS VSS nmos W=0.155u L=0.04u
M23338 n5540 g776 U6193/XU1-net6 VSS nmos W=0.155u L=0.04u
M23339 n5540 n5541 VDD VDD pmos W=0.155u L=0.04u
M23340 n5540 g776 VDD VDD pmos W=0.155u L=0.04u
M23341 n5541 n5542 VSS VSS nmos W=0.135u L=0.04u
M23342 n5541 n5542 VDD VDD pmos W=0.205u L=0.04u
M23343 U6195/net36 n5542 U6195/net24 VSS nmos W=0.155u L=0.04u
M23344 U6195/net24 n5524 VSS VSS nmos W=0.155u L=0.04u
M23345 n2813 g780 U6195/net36 VSS nmos W=0.155u L=0.04u
M23346 n2813 n5543 U6195/net36 VSS nmos W=0.155u L=0.04u
M23347 n2813 n5543 U6195/net35 VDD pmos W=0.205u L=0.04u
M23348 U6195/net35 g780 VDD VDD pmos W=0.205u L=0.04u
M23349 n2813 n5524 VDD VDD pmos W=0.205u L=0.04u
M23350 n2813 n5542 VDD VDD pmos W=0.205u L=0.04u
M23351 U6196/XU1-net6 n4177 VSS VSS nmos W=0.155u L=0.04u
M23352 n5524 n5522 U6196/XU1-net6 VSS nmos W=0.155u L=0.04u
M23353 n5524 n4177 VDD VDD pmos W=0.155u L=0.04u
M23354 n5524 n5522 VDD VDD pmos W=0.155u L=0.04u
M23355 n4177 U6197/net6 VSS VSS nmos W=0.155u L=0.04u
M23356 U6197/X_u2-net6 g853 VSS VSS nmos W=0.155u L=0.04u
M23357 U6197/net6 g869 U6197/X_u2-net6 VSS nmos W=0.155u L=0.04u
M23358 n4177 U6197/net6 VDD VDD pmos W=0.205u L=0.04u
M23359 U6197/net6 g853 VDD VDD pmos W=0.205u L=0.04u
M23360 U6197/net6 g869 VDD VDD pmos W=0.205u L=0.04u
M23361 U6198/XU1-net6 n5543 VSS VSS nmos W=0.155u L=0.04u
M23362 n5542 g780 U6198/XU1-net6 VSS nmos W=0.155u L=0.04u
M23363 n5542 n5543 VDD VDD pmos W=0.155u L=0.04u
M23364 n5542 g780 VDD VDD pmos W=0.155u L=0.04u
M23365 n5543 n4991 VSS VSS nmos W=0.155u L=0.04u
M23366 n5543 n5522 VSS VSS nmos W=0.155u L=0.04u
M23367 U6199/XI1-net8 n5522 VDD VDD pmos W=0.205u L=0.04u
M23368 n5543 n4991 U6199/XI1-net8 VDD pmos W=0.205u L=0.04u
M23369 U6200/XU1-net6 n5545 VSS VSS nmos W=0.155u L=0.04u
M23370 n2812 n5544 U6200/XU1-net6 VSS nmos W=0.155u L=0.04u
M23371 n2812 n5545 VDD VDD pmos W=0.155u L=0.04u
M23372 n2812 n5544 VDD VDD pmos W=0.155u L=0.04u
M23373 U6201/net4 U6201/net10 U6201/net14 VSS nmos W=0.155u L=0.04u
M23374 U6201/net6 g1426 U6201/net14 VSS nmos W=0.155u L=0.04u
M23375 U6201/net4 n5546 VSS VSS nmos W=0.155u L=0.04u
M23376 U6201/net6 U6201/net4 VSS VSS nmos W=0.155u L=0.04u
M23377 n5544 U6201/net14 VSS VSS nmos W=0.155u L=0.04u
M23378 U6201/net10 g1426 VSS VSS nmos W=0.155u L=0.04u
M23379 U6201/net4 g1426 U6201/net14 VDD pmos W=0.205u L=0.04u
M23380 U6201/net6 U6201/net10 U6201/net14 VDD pmos W=0.205u L=0.04u
M23381 U6201/net4 n5546 VDD VDD pmos W=0.205u L=0.04u
M23382 U6201/net6 U6201/net4 VDD VDD pmos W=0.205u L=0.04u
M23383 n5544 U6201/net14 VDD VDD pmos W=0.205u L=0.04u
M23384 U6201/net10 g1426 VDD VDD pmos W=0.205u L=0.04u
M23385 n5546 n5547 VSS VSS nmos W=0.155u L=0.04u
M23386 n5546 n5548 VSS VSS nmos W=0.155u L=0.04u
M23387 U6202/XI1-net8 n5548 VDD VDD pmos W=0.205u L=0.04u
M23388 n5546 n5547 U6202/XI1-net8 VDD pmos W=0.205u L=0.04u
M23389 U6203/XU1-net6 n5545 VSS VSS nmos W=0.155u L=0.04u
M23390 n2811 n5549 U6203/XU1-net6 VSS nmos W=0.155u L=0.04u
M23391 n2811 n5545 VDD VDD pmos W=0.155u L=0.04u
M23392 n2811 n5549 VDD VDD pmos W=0.155u L=0.04u
M23393 U6204/net4 n5547 U6204/net14 VSS nmos W=0.155u L=0.04u
M23394 U6204/net6 U6204/net10 U6204/net14 VSS nmos W=0.17u L=0.04u
M23395 U6204/net4 g1430 VSS VSS nmos W=0.155u L=0.04u
M23396 U6204/net6 U6204/net4 VSS VSS nmos W=0.17u L=0.04u
M23397 n5549 U6204/net14 VSS VSS nmos W=0.155u L=0.04u
M23398 U6204/net10 n5547 VSS VSS nmos W=0.155u L=0.04u
M23399 U6204/net4 U6204/net10 U6204/net14 VDD pmos W=0.255u L=0.04u
M23400 U6204/net6 n5547 U6204/net14 VDD pmos W=0.28u L=0.04u
M23401 U6204/net4 g1430 VDD VDD pmos W=0.205u L=0.04u
M23402 U6204/net6 U6204/net4 VDD VDD pmos W=0.24u L=0.04u
M23403 n5549 U6204/net14 VDD VDD pmos W=0.205u L=0.04u
M23404 U6204/net10 n5547 VDD VDD pmos W=0.205u L=0.04u
M23405 U6205/net36 n5547 U6205/net24 VSS nmos W=0.155u L=0.04u
M23406 U6205/net24 n5545 VSS VSS nmos W=0.155u L=0.04u
M23407 n2810 g1435 U6205/net36 VSS nmos W=0.155u L=0.04u
M23408 n2810 n5550 U6205/net36 VSS nmos W=0.155u L=0.04u
M23409 n2810 n5550 U6205/net35 VDD pmos W=0.205u L=0.04u
M23410 U6205/net35 g1435 VDD VDD pmos W=0.205u L=0.04u
M23411 n2810 n5545 VDD VDD pmos W=0.205u L=0.04u
M23412 n2810 n5547 VDD VDD pmos W=0.205u L=0.04u
M23413 U6206/XU1-net6 n5550 VSS VSS nmos W=0.155u L=0.04u
M23414 n5547 g1435 U6206/XU1-net6 VSS nmos W=0.155u L=0.04u
M23415 n5547 n5550 VDD VDD pmos W=0.155u L=0.04u
M23416 n5547 g1435 VDD VDD pmos W=0.155u L=0.04u
M23417 n5550 n5551 VSS VSS nmos W=0.135u L=0.04u
M23418 n5550 n5551 VDD VDD pmos W=0.205u L=0.04u
M23419 U6208/net36 n5551 U6208/net24 VSS nmos W=0.155u L=0.04u
M23420 U6208/net24 n5545 VSS VSS nmos W=0.155u L=0.04u
M23421 n2809 g1439 U6208/net36 VSS nmos W=0.155u L=0.04u
M23422 n2809 n5552 U6208/net36 VSS nmos W=0.155u L=0.04u
M23423 n2809 n5552 U6208/net35 VDD pmos W=0.205u L=0.04u
M23424 U6208/net35 g1439 VDD VDD pmos W=0.205u L=0.04u
M23425 n2809 n5545 VDD VDD pmos W=0.205u L=0.04u
M23426 n2809 n5551 VDD VDD pmos W=0.205u L=0.04u
M23427 U6209/XU1-net6 n5552 VSS VSS nmos W=0.155u L=0.04u
M23428 n5551 g1439 U6209/XU1-net6 VSS nmos W=0.155u L=0.04u
M23429 n5551 n5552 VDD VDD pmos W=0.155u L=0.04u
M23430 n5551 g1439 VDD VDD pmos W=0.155u L=0.04u
M23431 n5552 n5553 VSS VSS nmos W=0.135u L=0.04u
M23432 n5552 n5553 VDD VDD pmos W=0.205u L=0.04u
M23433 U6211/net36 n5553 U6211/net24 VSS nmos W=0.155u L=0.04u
M23434 U6211/net24 n5545 VSS VSS nmos W=0.155u L=0.04u
M23435 n2808 g1444 U6211/net36 VSS nmos W=0.155u L=0.04u
M23436 n2808 n5554 U6211/net36 VSS nmos W=0.155u L=0.04u
M23437 n2808 n5554 U6211/net35 VDD pmos W=0.205u L=0.04u
M23438 U6211/net35 g1444 VDD VDD pmos W=0.205u L=0.04u
M23439 n2808 n5545 VDD VDD pmos W=0.205u L=0.04u
M23440 n2808 n5553 VDD VDD pmos W=0.205u L=0.04u
M23441 U6212/XU1-net6 n5554 VSS VSS nmos W=0.155u L=0.04u
M23442 n5553 g1444 U6212/XU1-net6 VSS nmos W=0.155u L=0.04u
M23443 n5553 n5554 VDD VDD pmos W=0.155u L=0.04u
M23444 n5553 g1444 VDD VDD pmos W=0.155u L=0.04u
M23445 n5554 n5555 VSS VSS nmos W=0.135u L=0.04u
M23446 n5554 n5555 VDD VDD pmos W=0.205u L=0.04u
M23447 U6214/net36 n5555 U6214/net24 VSS nmos W=0.155u L=0.04u
M23448 U6214/net24 n5545 VSS VSS nmos W=0.155u L=0.04u
M23449 n2807 g1448 U6214/net36 VSS nmos W=0.155u L=0.04u
M23450 n2807 n5556 U6214/net36 VSS nmos W=0.155u L=0.04u
M23451 n2807 n5556 U6214/net35 VDD pmos W=0.205u L=0.04u
M23452 U6214/net35 g1448 VDD VDD pmos W=0.205u L=0.04u
M23453 n2807 n5545 VDD VDD pmos W=0.205u L=0.04u
M23454 n2807 n5555 VDD VDD pmos W=0.205u L=0.04u
M23455 U6215/XU1-net6 n5556 VSS VSS nmos W=0.155u L=0.04u
M23456 n5555 g1448 U6215/XU1-net6 VSS nmos W=0.155u L=0.04u
M23457 n5555 n5556 VDD VDD pmos W=0.155u L=0.04u
M23458 n5555 g1448 VDD VDD pmos W=0.155u L=0.04u
M23459 n5556 n5557 VSS VSS nmos W=0.135u L=0.04u
M23460 n5556 n5557 VDD VDD pmos W=0.205u L=0.04u
M23461 U6217/net36 n5557 U6217/net24 VSS nmos W=0.155u L=0.04u
M23462 U6217/net24 n5545 VSS VSS nmos W=0.155u L=0.04u
M23463 n2806 g1453 U6217/net36 VSS nmos W=0.155u L=0.04u
M23464 n2806 n5558 U6217/net36 VSS nmos W=0.155u L=0.04u
M23465 n2806 n5558 U6217/net35 VDD pmos W=0.205u L=0.04u
M23466 U6217/net35 g1453 VDD VDD pmos W=0.205u L=0.04u
M23467 n2806 n5545 VDD VDD pmos W=0.205u L=0.04u
M23468 n2806 n5557 VDD VDD pmos W=0.205u L=0.04u
M23469 U6218/XU1-net6 n5558 VSS VSS nmos W=0.155u L=0.04u
M23470 n5557 g1453 U6218/XU1-net6 VSS nmos W=0.155u L=0.04u
M23471 n5557 n5558 VDD VDD pmos W=0.155u L=0.04u
M23472 n5557 g1453 VDD VDD pmos W=0.155u L=0.04u
M23473 n5558 n5559 VSS VSS nmos W=0.135u L=0.04u
M23474 n5558 n5559 VDD VDD pmos W=0.205u L=0.04u
M23475 U6220/net36 n5559 U6220/net24 VSS nmos W=0.155u L=0.04u
M23476 U6220/net24 n5545 VSS VSS nmos W=0.155u L=0.04u
M23477 n2805 g1457 U6220/net36 VSS nmos W=0.155u L=0.04u
M23478 n2805 n5560 U6220/net36 VSS nmos W=0.155u L=0.04u
M23479 n2805 n5560 U6220/net35 VDD pmos W=0.205u L=0.04u
M23480 U6220/net35 g1457 VDD VDD pmos W=0.205u L=0.04u
M23481 n2805 n5545 VDD VDD pmos W=0.205u L=0.04u
M23482 n2805 n5559 VDD VDD pmos W=0.205u L=0.04u
M23483 U6221/XU1-net6 n5560 VSS VSS nmos W=0.155u L=0.04u
M23484 n5559 g1457 U6221/XU1-net6 VSS nmos W=0.155u L=0.04u
M23485 n5559 n5560 VDD VDD pmos W=0.155u L=0.04u
M23486 n5559 g1457 VDD VDD pmos W=0.155u L=0.04u
M23487 n2804 U6222/net27 VDD VDD pmos W=0.205u L=0.04u
M23488 U6222/net11 n5561 U6222/net27 VDD pmos W=0.205u L=0.04u
M23489 U6222/net11 n5562 U6222/net27 VDD pmos W=0.205u L=0.04u
M23490 U6222/net11 n5560 U6222/XI16-net11 VDD pmos W=0.205u L=0.04u
M23491 U6222/XI16-net11 n5563 VDD VDD pmos W=0.205u L=0.04u
M23492 U6222/net27 n5563 VSS VSS nmos W=0.155u L=0.04u
M23493 U6222/net27 n5560 VSS VSS nmos W=0.155u L=0.04u
M23494 n2804 U6222/net27 VSS VSS nmos W=0.155u L=0.04u
M23495 U6222/net27 n5561 U6222/XI12-net17 VSS nmos W=0.155u L=0.04u
M23496 U6222/XI12-net17 n5562 VSS VSS nmos W=0.155u L=0.04u
M23497 n5563 n5545 VSS VSS nmos W=0.135u L=0.04u
M23498 n5563 n5545 VDD VDD pmos W=0.205u L=0.04u
M23499 n5560 n5561 VSS VSS nmos W=0.155u L=0.04u
M23500 n5560 n5562 VSS VSS nmos W=0.155u L=0.04u
M23501 U6224/XI1-net8 n5562 VDD VDD pmos W=0.205u L=0.04u
M23502 n5560 n5561 U6224/XI1-net8 VDD pmos W=0.205u L=0.04u
M23503 U6225/net36 n5562 U6225/net24 VSS nmos W=0.155u L=0.04u
M23504 U6225/net24 n5545 VSS VSS nmos W=0.155u L=0.04u
M23505 n2803 g1466 U6225/net36 VSS nmos W=0.155u L=0.04u
M23506 n2803 n5564 U6225/net36 VSS nmos W=0.155u L=0.04u
M23507 n2803 n5564 U6225/net35 VDD pmos W=0.205u L=0.04u
M23508 U6225/net35 g1466 VDD VDD pmos W=0.205u L=0.04u
M23509 n2803 n5545 VDD VDD pmos W=0.205u L=0.04u
M23510 n2803 n5562 VDD VDD pmos W=0.205u L=0.04u
M23511 U6226/XU1-net6 n4069 VSS VSS nmos W=0.155u L=0.04u
M23512 n5545 n5522 U6226/XU1-net6 VSS nmos W=0.155u L=0.04u
M23513 n5545 n4069 VDD VDD pmos W=0.155u L=0.04u
M23514 n5545 n5522 VDD VDD pmos W=0.155u L=0.04u
M23515 n4069 U6227/net6 VSS VSS nmos W=0.155u L=0.04u
M23516 U6227/X_u2-net6 g1547 VSS VSS nmos W=0.155u L=0.04u
M23517 U6227/net6 g1563 U6227/X_u2-net6 VSS nmos W=0.155u L=0.04u
M23518 n4069 U6227/net6 VDD VDD pmos W=0.205u L=0.04u
M23519 U6227/net6 g1547 VDD VDD pmos W=0.205u L=0.04u
M23520 U6227/net6 g1563 VDD VDD pmos W=0.205u L=0.04u
M23521 U6228/XU1-net6 n5564 VSS VSS nmos W=0.155u L=0.04u
M23522 n5562 g1466 U6228/XU1-net6 VSS nmos W=0.155u L=0.04u
M23523 n5562 n5564 VDD VDD pmos W=0.155u L=0.04u
M23524 n5562 g1466 VDD VDD pmos W=0.155u L=0.04u
M23525 n5564 n5211 VSS VSS nmos W=0.155u L=0.04u
M23526 n5564 n5522 VSS VSS nmos W=0.155u L=0.04u
M23527 U6229/XI1-net8 n5522 VDD VDD pmos W=0.205u L=0.04u
M23528 n5564 n5211 U6229/XI1-net8 VDD pmos W=0.205u L=0.04u
M23529 U6230/XU1-net6 n5566 VSS VSS nmos W=0.155u L=0.04u
M23530 n2802 n5565 U6230/XU1-net6 VSS nmos W=0.155u L=0.04u
M23531 n2802 n5566 VDD VDD pmos W=0.155u L=0.04u
M23532 n2802 n5565 VDD VDD pmos W=0.155u L=0.04u
M23533 U6231/net4 U6231/net10 U6231/net14 VSS nmos W=0.155u L=0.04u
M23534 U6231/net6 g2120 U6231/net14 VSS nmos W=0.155u L=0.04u
M23535 U6231/net4 n5567 VSS VSS nmos W=0.155u L=0.04u
M23536 U6231/net6 U6231/net4 VSS VSS nmos W=0.155u L=0.04u
M23537 n5565 U6231/net14 VSS VSS nmos W=0.155u L=0.04u
M23538 U6231/net10 g2120 VSS VSS nmos W=0.155u L=0.04u
M23539 U6231/net4 g2120 U6231/net14 VDD pmos W=0.205u L=0.04u
M23540 U6231/net6 U6231/net10 U6231/net14 VDD pmos W=0.205u L=0.04u
M23541 U6231/net4 n5567 VDD VDD pmos W=0.205u L=0.04u
M23542 U6231/net6 U6231/net4 VDD VDD pmos W=0.205u L=0.04u
M23543 n5565 U6231/net14 VDD VDD pmos W=0.205u L=0.04u
M23544 U6231/net10 g2120 VDD VDD pmos W=0.205u L=0.04u
M23545 n5567 n5568 VSS VSS nmos W=0.155u L=0.04u
M23546 n5567 n5569 VSS VSS nmos W=0.155u L=0.04u
M23547 U6232/XI1-net8 n5569 VDD VDD pmos W=0.205u L=0.04u
M23548 n5567 n5568 U6232/XI1-net8 VDD pmos W=0.205u L=0.04u
M23549 U6233/XU1-net6 n5566 VSS VSS nmos W=0.155u L=0.04u
M23550 n2801 n5570 U6233/XU1-net6 VSS nmos W=0.155u L=0.04u
M23551 n2801 n5566 VDD VDD pmos W=0.155u L=0.04u
M23552 n2801 n5570 VDD VDD pmos W=0.155u L=0.04u
M23553 U6234/net4 n5568 U6234/net14 VSS nmos W=0.155u L=0.04u
M23554 U6234/net6 U6234/net10 U6234/net14 VSS nmos W=0.17u L=0.04u
M23555 U6234/net4 g2124 VSS VSS nmos W=0.155u L=0.04u
M23556 U6234/net6 U6234/net4 VSS VSS nmos W=0.17u L=0.04u
M23557 n5570 U6234/net14 VSS VSS nmos W=0.155u L=0.04u
M23558 U6234/net10 n5568 VSS VSS nmos W=0.155u L=0.04u
M23559 U6234/net4 U6234/net10 U6234/net14 VDD pmos W=0.255u L=0.04u
M23560 U6234/net6 n5568 U6234/net14 VDD pmos W=0.28u L=0.04u
M23561 U6234/net4 g2124 VDD VDD pmos W=0.205u L=0.04u
M23562 U6234/net6 U6234/net4 VDD VDD pmos W=0.24u L=0.04u
M23563 n5570 U6234/net14 VDD VDD pmos W=0.205u L=0.04u
M23564 U6234/net10 n5568 VDD VDD pmos W=0.205u L=0.04u
M23565 U6235/net36 n5568 U6235/net24 VSS nmos W=0.155u L=0.04u
M23566 U6235/net24 n5566 VSS VSS nmos W=0.155u L=0.04u
M23567 n2800 g2129 U6235/net36 VSS nmos W=0.155u L=0.04u
M23568 n2800 n5571 U6235/net36 VSS nmos W=0.155u L=0.04u
M23569 n2800 n5571 U6235/net35 VDD pmos W=0.205u L=0.04u
M23570 U6235/net35 g2129 VDD VDD pmos W=0.205u L=0.04u
M23571 n2800 n5566 VDD VDD pmos W=0.205u L=0.04u
M23572 n2800 n5568 VDD VDD pmos W=0.205u L=0.04u
M23573 U6236/XU1-net6 n5571 VSS VSS nmos W=0.155u L=0.04u
M23574 n5568 g2129 U6236/XU1-net6 VSS nmos W=0.155u L=0.04u
M23575 n5568 n5571 VDD VDD pmos W=0.155u L=0.04u
M23576 n5568 g2129 VDD VDD pmos W=0.155u L=0.04u
M23577 n5571 n5572 VSS VSS nmos W=0.135u L=0.04u
M23578 n5571 n5572 VDD VDD pmos W=0.205u L=0.04u
M23579 U6238/net36 n5572 U6238/net24 VSS nmos W=0.155u L=0.04u
M23580 U6238/net24 n5566 VSS VSS nmos W=0.155u L=0.04u
M23581 n2799 g2133 U6238/net36 VSS nmos W=0.155u L=0.04u
M23582 n2799 n5573 U6238/net36 VSS nmos W=0.155u L=0.04u
M23583 n2799 n5573 U6238/net35 VDD pmos W=0.205u L=0.04u
M23584 U6238/net35 g2133 VDD VDD pmos W=0.205u L=0.04u
M23585 n2799 n5566 VDD VDD pmos W=0.205u L=0.04u
M23586 n2799 n5572 VDD VDD pmos W=0.205u L=0.04u
M23587 U6239/XU1-net6 n5573 VSS VSS nmos W=0.155u L=0.04u
M23588 n5572 g2133 U6239/XU1-net6 VSS nmos W=0.155u L=0.04u
M23589 n5572 n5573 VDD VDD pmos W=0.155u L=0.04u
M23590 n5572 g2133 VDD VDD pmos W=0.155u L=0.04u
M23591 n5573 n5574 VSS VSS nmos W=0.135u L=0.04u
M23592 n5573 n5574 VDD VDD pmos W=0.205u L=0.04u
M23593 U6241/net36 n5574 U6241/net24 VSS nmos W=0.155u L=0.04u
M23594 U6241/net24 n5566 VSS VSS nmos W=0.155u L=0.04u
M23595 n2798 g2138 U6241/net36 VSS nmos W=0.155u L=0.04u
M23596 n2798 n5575 U6241/net36 VSS nmos W=0.155u L=0.04u
M23597 n2798 n5575 U6241/net35 VDD pmos W=0.205u L=0.04u
M23598 U6241/net35 g2138 VDD VDD pmos W=0.205u L=0.04u
M23599 n2798 n5566 VDD VDD pmos W=0.205u L=0.04u
M23600 n2798 n5574 VDD VDD pmos W=0.205u L=0.04u
M23601 U6242/XU1-net6 n5575 VSS VSS nmos W=0.155u L=0.04u
M23602 n5574 g2138 U6242/XU1-net6 VSS nmos W=0.155u L=0.04u
M23603 n5574 n5575 VDD VDD pmos W=0.155u L=0.04u
M23604 n5574 g2138 VDD VDD pmos W=0.155u L=0.04u
M23605 n5575 n5576 VSS VSS nmos W=0.135u L=0.04u
M23606 n5575 n5576 VDD VDD pmos W=0.205u L=0.04u
M23607 U6244/net36 n5576 U6244/net24 VSS nmos W=0.155u L=0.04u
M23608 U6244/net24 n5566 VSS VSS nmos W=0.155u L=0.04u
M23609 n2797 g2142 U6244/net36 VSS nmos W=0.155u L=0.04u
M23610 n2797 n5577 U6244/net36 VSS nmos W=0.155u L=0.04u
M23611 n2797 n5577 U6244/net35 VDD pmos W=0.205u L=0.04u
M23612 U6244/net35 g2142 VDD VDD pmos W=0.205u L=0.04u
M23613 n2797 n5566 VDD VDD pmos W=0.205u L=0.04u
M23614 n2797 n5576 VDD VDD pmos W=0.205u L=0.04u
M23615 U6245/XU1-net6 n5577 VSS VSS nmos W=0.155u L=0.04u
M23616 n5576 g2142 U6245/XU1-net6 VSS nmos W=0.155u L=0.04u
M23617 n5576 n5577 VDD VDD pmos W=0.155u L=0.04u
M23618 n5576 g2142 VDD VDD pmos W=0.155u L=0.04u
M23619 n5577 n5578 VSS VSS nmos W=0.135u L=0.04u
M23620 n5577 n5578 VDD VDD pmos W=0.205u L=0.04u
M23621 U6247/net36 n5578 U6247/net24 VSS nmos W=0.155u L=0.04u
M23622 U6247/net24 n5566 VSS VSS nmos W=0.155u L=0.04u
M23623 n2796 g2147 U6247/net36 VSS nmos W=0.155u L=0.04u
M23624 n2796 n5579 U6247/net36 VSS nmos W=0.155u L=0.04u
M23625 n2796 n5579 U6247/net35 VDD pmos W=0.205u L=0.04u
M23626 U6247/net35 g2147 VDD VDD pmos W=0.205u L=0.04u
M23627 n2796 n5566 VDD VDD pmos W=0.205u L=0.04u
M23628 n2796 n5578 VDD VDD pmos W=0.205u L=0.04u
M23629 U6248/XU1-net6 n5579 VSS VSS nmos W=0.155u L=0.04u
M23630 n5578 g2147 U6248/XU1-net6 VSS nmos W=0.155u L=0.04u
M23631 n5578 n5579 VDD VDD pmos W=0.155u L=0.04u
M23632 n5578 g2147 VDD VDD pmos W=0.155u L=0.04u
M23633 n5579 n5580 VSS VSS nmos W=0.135u L=0.04u
M23634 n5579 n5580 VDD VDD pmos W=0.205u L=0.04u
M23635 U6250/net36 n5580 U6250/net24 VSS nmos W=0.155u L=0.04u
M23636 U6250/net24 n5566 VSS VSS nmos W=0.155u L=0.04u
M23637 n2795 g2151 U6250/net36 VSS nmos W=0.155u L=0.04u
M23638 n2795 n5581 U6250/net36 VSS nmos W=0.155u L=0.04u
M23639 n2795 n5581 U6250/net35 VDD pmos W=0.205u L=0.04u
M23640 U6250/net35 g2151 VDD VDD pmos W=0.205u L=0.04u
M23641 n2795 n5566 VDD VDD pmos W=0.205u L=0.04u
M23642 n2795 n5580 VDD VDD pmos W=0.205u L=0.04u
M23643 U6251/XU1-net6 n5581 VSS VSS nmos W=0.155u L=0.04u
M23644 n5580 g2151 U6251/XU1-net6 VSS nmos W=0.155u L=0.04u
M23645 n5580 n5581 VDD VDD pmos W=0.155u L=0.04u
M23646 n5580 g2151 VDD VDD pmos W=0.155u L=0.04u
M23647 n2794 U6252/net27 VDD VDD pmos W=0.205u L=0.04u
M23648 U6252/net11 n5582 U6252/net27 VDD pmos W=0.205u L=0.04u
M23649 U6252/net11 n5583 U6252/net27 VDD pmos W=0.205u L=0.04u
M23650 U6252/net11 n5581 U6252/XI16-net11 VDD pmos W=0.205u L=0.04u
M23651 U6252/XI16-net11 n5584 VDD VDD pmos W=0.205u L=0.04u
M23652 U6252/net27 n5584 VSS VSS nmos W=0.155u L=0.04u
M23653 U6252/net27 n5581 VSS VSS nmos W=0.155u L=0.04u
M23654 n2794 U6252/net27 VSS VSS nmos W=0.155u L=0.04u
M23655 U6252/net27 n5582 U6252/XI12-net17 VSS nmos W=0.155u L=0.04u
M23656 U6252/XI12-net17 n5583 VSS VSS nmos W=0.155u L=0.04u
M23657 n5584 n5566 VSS VSS nmos W=0.135u L=0.04u
M23658 n5584 n5566 VDD VDD pmos W=0.205u L=0.04u
M23659 n5581 n5582 VSS VSS nmos W=0.155u L=0.04u
M23660 n5581 n5583 VSS VSS nmos W=0.155u L=0.04u
M23661 U6254/XI1-net8 n5583 VDD VDD pmos W=0.205u L=0.04u
M23662 n5581 n5582 U6254/XI1-net8 VDD pmos W=0.205u L=0.04u
M23663 U6255/net36 n5583 U6255/net24 VSS nmos W=0.155u L=0.04u
M23664 U6255/net24 n5566 VSS VSS nmos W=0.155u L=0.04u
M23665 n2793 g2160 U6255/net36 VSS nmos W=0.155u L=0.04u
M23666 n2793 n5585 U6255/net36 VSS nmos W=0.155u L=0.04u
M23667 n2793 n5585 U6255/net35 VDD pmos W=0.205u L=0.04u
M23668 U6255/net35 g2160 VDD VDD pmos W=0.205u L=0.04u
M23669 n2793 n5566 VDD VDD pmos W=0.205u L=0.04u
M23670 n2793 n5583 VDD VDD pmos W=0.205u L=0.04u
M23671 U6256/XU1-net6 n3961 VSS VSS nmos W=0.155u L=0.04u
M23672 n5566 n5522 U6256/XU1-net6 VSS nmos W=0.155u L=0.04u
M23673 n5566 n3961 VDD VDD pmos W=0.155u L=0.04u
M23674 n5566 n5522 VDD VDD pmos W=0.155u L=0.04u
M23675 n3961 U6257/net6 VSS VSS nmos W=0.155u L=0.04u
M23676 U6257/X_u2-net6 g2241 VSS VSS nmos W=0.155u L=0.04u
M23677 U6257/net6 g2257 U6257/X_u2-net6 VSS nmos W=0.155u L=0.04u
M23678 n3961 U6257/net6 VDD VDD pmos W=0.205u L=0.04u
M23679 U6257/net6 g2241 VDD VDD pmos W=0.205u L=0.04u
M23680 U6257/net6 g2257 VDD VDD pmos W=0.205u L=0.04u
M23681 U6258/XU1-net6 n5585 VSS VSS nmos W=0.155u L=0.04u
M23682 n5583 g2160 U6258/XU1-net6 VSS nmos W=0.155u L=0.04u
M23683 n5583 n5585 VDD VDD pmos W=0.155u L=0.04u
M23684 n5583 g2160 VDD VDD pmos W=0.155u L=0.04u
M23685 n5585 n4549 VSS VSS nmos W=0.155u L=0.04u
M23686 n5585 n5522 VSS VSS nmos W=0.155u L=0.04u
M23687 U6259/XI1-net8 n5522 VDD VDD pmos W=0.205u L=0.04u
M23688 n5585 n4549 U6259/XI1-net8 VDD pmos W=0.205u L=0.04u
M23689 U6260/net19 n5587 VSS VSS nmos W=0.155u L=0.04u
M23690 n2791 n5587 U6260/net40 VSS nmos W=0.155u L=0.04u
M23691 n2791 U6260/net19 U6260/net36 VSS nmos W=0.155u L=0.04u
M23692 U6260/net40 n5586 VSS VSS nmos W=0.31u L=0.04u
M23693 U6260/net36 g168 VSS VSS nmos W=0.155u L=0.04u
M23694 U6260/net19 n5587 VDD VDD pmos W=0.205u L=0.04u
M23695 n2791 U6260/net19 U6260/net26 VDD pmos W=0.325u L=0.04u
M23696 U6260/net26 n5586 VDD VDD pmos W=0.41u L=0.04u
M23697 n2791 n5587 U6260/net30 VDD pmos W=0.325u L=0.04u
M23698 U6260/net30 g168 VDD VDD pmos W=0.205u L=0.04u
M23699 U6261/net19 n5587 VSS VSS nmos W=0.155u L=0.04u
M23700 n2790 n5587 U6261/net40 VSS nmos W=0.155u L=0.04u
M23701 n2790 U6261/net19 U6261/net36 VSS nmos W=0.155u L=0.04u
M23702 U6261/net40 n4742 VSS VSS nmos W=0.31u L=0.04u
M23703 U6261/net36 g171 VSS VSS nmos W=0.155u L=0.04u
M23704 U6261/net19 n5587 VDD VDD pmos W=0.205u L=0.04u
M23705 n2790 U6261/net19 U6261/net26 VDD pmos W=0.325u L=0.04u
M23706 U6261/net26 n4742 VDD VDD pmos W=0.41u L=0.04u
M23707 n2790 n5587 U6261/net30 VDD pmos W=0.325u L=0.04u
M23708 U6261/net30 g171 VDD VDD pmos W=0.205u L=0.04u
M23709 U6262/net19 n5587 VSS VSS nmos W=0.155u L=0.04u
M23710 n2789 n5587 U6262/net40 VSS nmos W=0.155u L=0.04u
M23711 n2789 U6262/net19 U6262/net36 VSS nmos W=0.155u L=0.04u
M23712 U6262/net40 n4741 VSS VSS nmos W=0.31u L=0.04u
M23713 U6262/net36 g174 VSS VSS nmos W=0.155u L=0.04u
M23714 U6262/net19 n5587 VDD VDD pmos W=0.205u L=0.04u
M23715 n2789 U6262/net19 U6262/net26 VDD pmos W=0.325u L=0.04u
M23716 U6262/net26 n4741 VDD VDD pmos W=0.41u L=0.04u
M23717 n2789 n5587 U6262/net30 VDD pmos W=0.325u L=0.04u
M23718 U6262/net30 g174 VDD VDD pmos W=0.205u L=0.04u
M23719 U6263/net19 n5587 VSS VSS nmos W=0.155u L=0.04u
M23720 n2788 n5587 U6263/net40 VSS nmos W=0.155u L=0.04u
M23721 n2788 U6263/net19 U6263/net36 VSS nmos W=0.155u L=0.04u
M23722 U6263/net40 n4767 VSS VSS nmos W=0.31u L=0.04u
M23723 U6263/net36 g177 VSS VSS nmos W=0.155u L=0.04u
M23724 U6263/net19 n5587 VDD VDD pmos W=0.205u L=0.04u
M23725 n2788 U6263/net19 U6263/net26 VDD pmos W=0.325u L=0.04u
M23726 U6263/net26 n4767 VDD VDD pmos W=0.41u L=0.04u
M23727 n2788 n5587 U6263/net30 VDD pmos W=0.325u L=0.04u
M23728 U6263/net30 g177 VDD VDD pmos W=0.205u L=0.04u
M23729 n5587 n4770 VSS VSS nmos W=0.155u L=0.04u
M23730 n5587 n2792 VSS VSS nmos W=0.155u L=0.04u
M23731 U6264/XI1-net8 n2792 VDD VDD pmos W=0.205u L=0.04u
M23732 n5587 n4770 U6264/XI1-net8 VDD pmos W=0.205u L=0.04u
M23733 n4770 g165 VSS VSS nmos W=0.135u L=0.04u
M23734 n4770 g165 VDD VDD pmos W=0.205u L=0.04u
M23735 U6266/net19 n5588 VSS VSS nmos W=0.155u L=0.04u
M23736 n2787 n5588 U6266/net40 VSS nmos W=0.155u L=0.04u
M23737 n2787 U6266/net19 U6266/net36 VSS nmos W=0.155u L=0.04u
M23738 U6266/net40 n5586 VSS VSS nmos W=0.31u L=0.04u
M23739 U6266/net36 g170 VSS VSS nmos W=0.155u L=0.04u
M23740 U6266/net19 n5588 VDD VDD pmos W=0.205u L=0.04u
M23741 n2787 U6266/net19 U6266/net26 VDD pmos W=0.325u L=0.04u
M23742 U6266/net26 n5586 VDD VDD pmos W=0.41u L=0.04u
M23743 n2787 n5588 U6266/net30 VDD pmos W=0.325u L=0.04u
M23744 U6266/net30 g170 VDD VDD pmos W=0.205u L=0.04u
M23745 U6267/net19 n5589 VSS VSS nmos W=0.155u L=0.04u
M23746 n2786 n5589 U6267/net40 VSS nmos W=0.155u L=0.04u
M23747 n2786 U6267/net19 U6267/net36 VSS nmos W=0.155u L=0.04u
M23748 U6267/net40 n5586 VSS VSS nmos W=0.31u L=0.04u
M23749 U6267/net36 g169 VSS VSS nmos W=0.155u L=0.04u
M23750 U6267/net19 n5589 VDD VDD pmos W=0.205u L=0.04u
M23751 n2786 U6267/net19 U6267/net26 VDD pmos W=0.325u L=0.04u
M23752 U6267/net26 n5586 VDD VDD pmos W=0.41u L=0.04u
M23753 n2786 n5589 U6267/net30 VDD pmos W=0.325u L=0.04u
M23754 U6267/net30 g169 VDD VDD pmos W=0.205u L=0.04u
M23755 n5586 g121 VSS VSS nmos W=0.155u L=0.04u
M23756 n5586 g117 VSS VSS nmos W=0.155u L=0.04u
M23757 n5586 n4745 VSS VSS nmos W=0.155u L=0.04u
M23758 n5586 n4796 VSS VSS nmos W=0.155u L=0.04u
M23759 U6268/net49 g117 U6268/net52 VDD pmos W=0.41u L=0.04u
M23760 U6268/net52 g121 VDD VDD pmos W=0.41u L=0.04u
M23761 U6268/net46 n4745 U6268/net49 VDD pmos W=0.41u L=0.04u
M23762 n5586 n4796 U6268/net46 VDD pmos W=0.41u L=0.04u
M23763 U6269/net19 n5588 VSS VSS nmos W=0.155u L=0.04u
M23764 n2785 n5588 U6269/net40 VSS nmos W=0.155u L=0.04u
M23765 n2785 U6269/net19 U6269/net36 VSS nmos W=0.155u L=0.04u
M23766 U6269/net40 n4742 VSS VSS nmos W=0.31u L=0.04u
M23767 U6269/net36 g173 VSS VSS nmos W=0.155u L=0.04u
M23768 U6269/net19 n5588 VDD VDD pmos W=0.205u L=0.04u
M23769 n2785 U6269/net19 U6269/net26 VDD pmos W=0.325u L=0.04u
M23770 U6269/net26 n4742 VDD VDD pmos W=0.41u L=0.04u
M23771 n2785 n5588 U6269/net30 VDD pmos W=0.325u L=0.04u
M23772 U6269/net30 g173 VDD VDD pmos W=0.205u L=0.04u
M23773 U6270/net19 n5589 VSS VSS nmos W=0.155u L=0.04u
M23774 n2784 n5589 U6270/net40 VSS nmos W=0.155u L=0.04u
M23775 n2784 U6270/net19 U6270/net36 VSS nmos W=0.155u L=0.04u
M23776 U6270/net40 n4742 VSS VSS nmos W=0.31u L=0.04u
M23777 U6270/net36 g172 VSS VSS nmos W=0.155u L=0.04u
M23778 U6270/net19 n5589 VDD VDD pmos W=0.205u L=0.04u
M23779 n2784 U6270/net19 U6270/net26 VDD pmos W=0.325u L=0.04u
M23780 U6270/net26 n4742 VDD VDD pmos W=0.41u L=0.04u
M23781 n2784 n5589 U6270/net30 VDD pmos W=0.325u L=0.04u
M23782 U6270/net30 g172 VDD VDD pmos W=0.205u L=0.04u
M23783 U6271/net19 n5588 VSS VSS nmos W=0.155u L=0.04u
M23784 n2783 n5588 U6271/net40 VSS nmos W=0.155u L=0.04u
M23785 n2783 U6271/net19 U6271/net36 VSS nmos W=0.155u L=0.04u
M23786 U6271/net40 n4741 VSS VSS nmos W=0.31u L=0.04u
M23787 U6271/net36 g176 VSS VSS nmos W=0.155u L=0.04u
M23788 U6271/net19 n5588 VDD VDD pmos W=0.205u L=0.04u
M23789 n2783 U6271/net19 U6271/net26 VDD pmos W=0.325u L=0.04u
M23790 U6271/net26 n4741 VDD VDD pmos W=0.41u L=0.04u
M23791 n2783 n5588 U6271/net30 VDD pmos W=0.325u L=0.04u
M23792 U6271/net30 g176 VDD VDD pmos W=0.205u L=0.04u
M23793 U6272/net19 n5589 VSS VSS nmos W=0.155u L=0.04u
M23794 n2782 n5589 U6272/net40 VSS nmos W=0.155u L=0.04u
M23795 n2782 U6272/net19 U6272/net36 VSS nmos W=0.155u L=0.04u
M23796 U6272/net40 n4741 VSS VSS nmos W=0.31u L=0.04u
M23797 U6272/net36 g175 VSS VSS nmos W=0.155u L=0.04u
M23798 U6272/net19 n5589 VDD VDD pmos W=0.205u L=0.04u
M23799 n2782 U6272/net19 U6272/net26 VDD pmos W=0.325u L=0.04u
M23800 U6272/net26 n4741 VDD VDD pmos W=0.41u L=0.04u
M23801 n2782 n5589 U6272/net30 VDD pmos W=0.325u L=0.04u
M23802 U6272/net30 g175 VDD VDD pmos W=0.205u L=0.04u
M23803 U6273/net19 n5588 VSS VSS nmos W=0.155u L=0.04u
M23804 n2781 n5588 U6273/net40 VSS nmos W=0.155u L=0.04u
M23805 n2781 U6273/net19 U6273/net36 VSS nmos W=0.155u L=0.04u
M23806 U6273/net40 n4767 VSS VSS nmos W=0.31u L=0.04u
M23807 U6273/net36 g179 VSS VSS nmos W=0.155u L=0.04u
M23808 U6273/net19 n5588 VDD VDD pmos W=0.205u L=0.04u
M23809 n2781 U6273/net19 U6273/net26 VDD pmos W=0.325u L=0.04u
M23810 U6273/net26 n4767 VDD VDD pmos W=0.41u L=0.04u
M23811 n2781 n5588 U6273/net30 VDD pmos W=0.325u L=0.04u
M23812 U6273/net30 g179 VDD VDD pmos W=0.205u L=0.04u
M23813 n5588 n4771 VSS VSS nmos W=0.155u L=0.04u
M23814 n5588 n2792 VSS VSS nmos W=0.155u L=0.04u
M23815 U6274/XI1-net8 n2792 VDD VDD pmos W=0.205u L=0.04u
M23816 n5588 n4771 U6274/XI1-net8 VDD pmos W=0.205u L=0.04u
M23817 n4771 g6313 VSS VSS nmos W=0.135u L=0.04u
M23818 n4771 g6313 VDD VDD pmos W=0.205u L=0.04u
M23819 U6276/net19 n5589 VSS VSS nmos W=0.155u L=0.04u
M23820 n2780 n5589 U6276/net40 VSS nmos W=0.155u L=0.04u
M23821 n2780 U6276/net19 U6276/net36 VSS nmos W=0.155u L=0.04u
M23822 U6276/net40 n4767 VSS VSS nmos W=0.31u L=0.04u
M23823 U6276/net36 g178 VSS VSS nmos W=0.155u L=0.04u
M23824 U6276/net19 n5589 VDD VDD pmos W=0.205u L=0.04u
M23825 n2780 U6276/net19 U6276/net26 VDD pmos W=0.325u L=0.04u
M23826 U6276/net26 n4767 VDD VDD pmos W=0.41u L=0.04u
M23827 n2780 n5589 U6276/net30 VDD pmos W=0.325u L=0.04u
M23828 U6276/net30 g178 VDD VDD pmos W=0.205u L=0.04u
M23829 n5589 n4769 VSS VSS nmos W=0.155u L=0.04u
M23830 n5589 n2792 VSS VSS nmos W=0.155u L=0.04u
M23831 U6277/XI1-net8 n2792 VDD VDD pmos W=0.205u L=0.04u
M23832 n5589 n4769 U6277/XI1-net8 VDD pmos W=0.205u L=0.04u
M23833 n4769 g6231 VSS VSS nmos W=0.135u L=0.04u
M23834 n4769 g6231 VDD VDD pmos W=0.205u L=0.04u
M23835 U6279/XU1-net6 n5591 VSS VSS nmos W=0.155u L=0.04u
M23836 n4767 n5590 U6279/XU1-net6 VSS nmos W=0.155u L=0.04u
M23837 n4767 n5591 VDD VDD pmos W=0.155u L=0.04u
M23838 n4767 n5590 VDD VDD pmos W=0.155u L=0.04u
M23839 n5591 n4744 VSS VSS nmos W=0.155u L=0.04u
M23840 n5591 n4743 VSS VSS nmos W=0.155u L=0.04u
M23841 n5591 n4742 VSS VSS nmos W=0.155u L=0.04u
M23842 n5591 n4741 VSS VSS nmos W=0.155u L=0.04u
M23843 U6280/net49 n4743 U6280/net52 VDD pmos W=0.41u L=0.04u
M23844 U6280/net52 n4744 VDD VDD pmos W=0.41u L=0.04u
M23845 U6280/net46 n4742 U6280/net49 VDD pmos W=0.41u L=0.04u
M23846 n5591 n4741 U6280/net46 VDD pmos W=0.41u L=0.04u
M23847 n4744 g109 VSS VSS nmos W=0.135u L=0.04u
M23848 n4744 g109 VDD VDD pmos W=0.205u L=0.04u
M23849 n4743 g105 VSS VSS nmos W=0.135u L=0.04u
M23850 n4743 g105 VDD VDD pmos W=0.205u L=0.04u
M23851 n4742 g101 VSS VSS nmos W=0.135u L=0.04u
M23852 n4742 g101 VDD VDD pmos W=0.205u L=0.04u
M23853 n4741 g97 VSS VSS nmos W=0.135u L=0.04u
M23854 n4741 g97 VDD VDD pmos W=0.205u L=0.04u
M23855 n5590 n4796 VSS VSS nmos W=0.155u L=0.04u
M23856 n5590 n4747 VSS VSS nmos W=0.155u L=0.04u
M23857 n5590 n4746 VSS VSS nmos W=0.155u L=0.04u
M23858 n5590 n4745 VSS VSS nmos W=0.155u L=0.04u
M23859 U6285/net49 n4747 U6285/net52 VDD pmos W=0.41u L=0.04u
M23860 U6285/net52 n4796 VDD VDD pmos W=0.41u L=0.04u
M23861 U6285/net46 n4746 U6285/net49 VDD pmos W=0.41u L=0.04u
M23862 n5590 n4745 U6285/net46 VDD pmos W=0.41u L=0.04u
M23863 n4796 g125 VSS VSS nmos W=0.135u L=0.04u
M23864 n4796 g125 VDD VDD pmos W=0.205u L=0.04u
M23865 n4747 g121 VSS VSS nmos W=0.135u L=0.04u
M23866 n4747 g121 VDD VDD pmos W=0.205u L=0.04u
M23867 n4746 g117 VSS VSS nmos W=0.135u L=0.04u
M23868 n4746 g117 VDD VDD pmos W=0.205u L=0.04u
M23869 n4745 g113 VSS VSS nmos W=0.135u L=0.04u
M23870 n4745 g113 VDD VDD pmos W=0.205u L=0.04u
M23871 U6290/net19 n5593 VSS VSS nmos W=0.155u L=0.04u
M23872 n2779 n5593 U6290/net40 VSS nmos W=0.155u L=0.04u
M23873 n2779 U6290/net19 U6290/net36 VSS nmos W=0.155u L=0.04u
M23874 U6290/net40 n5592 VSS VSS nmos W=0.31u L=0.04u
M23875 U6290/net36 g856 VSS VSS nmos W=0.155u L=0.04u
M23876 U6290/net19 n5593 VDD VDD pmos W=0.205u L=0.04u
M23877 n2779 U6290/net19 U6290/net26 VDD pmos W=0.325u L=0.04u
M23878 U6290/net26 n5592 VDD VDD pmos W=0.41u L=0.04u
M23879 n2779 n5593 U6290/net30 VDD pmos W=0.325u L=0.04u
M23880 U6290/net30 g856 VDD VDD pmos W=0.205u L=0.04u
M23881 U6291/net19 n5593 VSS VSS nmos W=0.155u L=0.04u
M23882 n2778 n5593 U6291/net40 VSS nmos W=0.155u L=0.04u
M23883 n2778 U6291/net19 U6291/net36 VSS nmos W=0.155u L=0.04u
M23884 U6291/net40 n4963 VSS VSS nmos W=0.31u L=0.04u
M23885 U6291/net36 g859 VSS VSS nmos W=0.155u L=0.04u
M23886 U6291/net19 n5593 VDD VDD pmos W=0.205u L=0.04u
M23887 n2778 U6291/net19 U6291/net26 VDD pmos W=0.325u L=0.04u
M23888 U6291/net26 n4963 VDD VDD pmos W=0.41u L=0.04u
M23889 n2778 n5593 U6291/net30 VDD pmos W=0.325u L=0.04u
M23890 U6291/net30 g859 VDD VDD pmos W=0.205u L=0.04u
M23891 U6292/net19 n5593 VSS VSS nmos W=0.155u L=0.04u
M23892 n2777 n5593 U6292/net40 VSS nmos W=0.155u L=0.04u
M23893 n2777 U6292/net19 U6292/net36 VSS nmos W=0.155u L=0.04u
M23894 U6292/net40 n4962 VSS VSS nmos W=0.31u L=0.04u
M23895 U6292/net36 g862 VSS VSS nmos W=0.155u L=0.04u
M23896 U6292/net19 n5593 VDD VDD pmos W=0.205u L=0.04u
M23897 n2777 U6292/net19 U6292/net26 VDD pmos W=0.325u L=0.04u
M23898 U6292/net26 n4962 VDD VDD pmos W=0.41u L=0.04u
M23899 n2777 n5593 U6292/net30 VDD pmos W=0.325u L=0.04u
M23900 U6292/net30 g862 VDD VDD pmos W=0.205u L=0.04u
M23901 U6293/net19 n5593 VSS VSS nmos W=0.155u L=0.04u
M23902 n2776 n5593 U6293/net40 VSS nmos W=0.155u L=0.04u
M23903 n2776 U6293/net19 U6293/net36 VSS nmos W=0.155u L=0.04u
M23904 U6293/net40 n4987 VSS VSS nmos W=0.31u L=0.04u
M23905 U6293/net36 g865 VSS VSS nmos W=0.155u L=0.04u
M23906 U6293/net19 n5593 VDD VDD pmos W=0.205u L=0.04u
M23907 n2776 U6293/net19 U6293/net26 VDD pmos W=0.325u L=0.04u
M23908 U6293/net26 n4987 VDD VDD pmos W=0.41u L=0.04u
M23909 n2776 n5593 U6293/net30 VDD pmos W=0.325u L=0.04u
M23910 U6293/net30 g865 VDD VDD pmos W=0.205u L=0.04u
M23911 n5593 n4991 VSS VSS nmos W=0.155u L=0.04u
M23912 n5593 n2792 VSS VSS nmos W=0.155u L=0.04u
M23913 U6294/XI1-net8 n2792 VDD VDD pmos W=0.205u L=0.04u
M23914 n5593 n4991 U6294/XI1-net8 VDD pmos W=0.205u L=0.04u
M23915 n4991 g853 VSS VSS nmos W=0.135u L=0.04u
M23916 n4991 g853 VDD VDD pmos W=0.205u L=0.04u
M23917 U6296/net19 n5594 VSS VSS nmos W=0.155u L=0.04u
M23918 n2775 n5594 U6296/net40 VSS nmos W=0.155u L=0.04u
M23919 n2775 U6296/net19 U6296/net36 VSS nmos W=0.155u L=0.04u
M23920 U6296/net40 n5592 VSS VSS nmos W=0.31u L=0.04u
M23921 U6296/net36 g858 VSS VSS nmos W=0.155u L=0.04u
M23922 U6296/net19 n5594 VDD VDD pmos W=0.205u L=0.04u
M23923 n2775 U6296/net19 U6296/net26 VDD pmos W=0.325u L=0.04u
M23924 U6296/net26 n5592 VDD VDD pmos W=0.41u L=0.04u
M23925 n2775 n5594 U6296/net30 VDD pmos W=0.325u L=0.04u
M23926 U6296/net30 g858 VDD VDD pmos W=0.205u L=0.04u
M23927 U6297/net19 n5595 VSS VSS nmos W=0.155u L=0.04u
M23928 n2774 n5595 U6297/net40 VSS nmos W=0.155u L=0.04u
M23929 n2774 U6297/net19 U6297/net36 VSS nmos W=0.155u L=0.04u
M23930 U6297/net40 n5592 VSS VSS nmos W=0.31u L=0.04u
M23931 U6297/net36 g857 VSS VSS nmos W=0.155u L=0.04u
M23932 U6297/net19 n5595 VDD VDD pmos W=0.205u L=0.04u
M23933 n2774 U6297/net19 U6297/net26 VDD pmos W=0.325u L=0.04u
M23934 U6297/net26 n5592 VDD VDD pmos W=0.41u L=0.04u
M23935 n2774 n5595 U6297/net30 VDD pmos W=0.325u L=0.04u
M23936 U6297/net30 g857 VDD VDD pmos W=0.205u L=0.04u
M23937 n5592 g809 VSS VSS nmos W=0.155u L=0.04u
M23938 n5592 g805 VSS VSS nmos W=0.155u L=0.04u
M23939 n5592 n4966 VSS VSS nmos W=0.155u L=0.04u
M23940 n5592 n5016 VSS VSS nmos W=0.155u L=0.04u
M23941 U6298/net49 g805 U6298/net52 VDD pmos W=0.41u L=0.04u
M23942 U6298/net52 g809 VDD VDD pmos W=0.41u L=0.04u
M23943 U6298/net46 n4966 U6298/net49 VDD pmos W=0.41u L=0.04u
M23944 n5592 n5016 U6298/net46 VDD pmos W=0.41u L=0.04u
M23945 U6299/net19 n5594 VSS VSS nmos W=0.155u L=0.04u
M23946 n2773 n5594 U6299/net40 VSS nmos W=0.155u L=0.04u
M23947 n2773 U6299/net19 U6299/net36 VSS nmos W=0.155u L=0.04u
M23948 U6299/net40 n4963 VSS VSS nmos W=0.31u L=0.04u
M23949 U6299/net36 g861 VSS VSS nmos W=0.155u L=0.04u
M23950 U6299/net19 n5594 VDD VDD pmos W=0.205u L=0.04u
M23951 n2773 U6299/net19 U6299/net26 VDD pmos W=0.325u L=0.04u
M23952 U6299/net26 n4963 VDD VDD pmos W=0.41u L=0.04u
M23953 n2773 n5594 U6299/net30 VDD pmos W=0.325u L=0.04u
M23954 U6299/net30 g861 VDD VDD pmos W=0.205u L=0.04u
M23955 U6300/net19 n5595 VSS VSS nmos W=0.155u L=0.04u
M23956 n2772 n5595 U6300/net40 VSS nmos W=0.155u L=0.04u
M23957 n2772 U6300/net19 U6300/net36 VSS nmos W=0.155u L=0.04u
M23958 U6300/net40 n4963 VSS VSS nmos W=0.31u L=0.04u
M23959 U6300/net36 g860 VSS VSS nmos W=0.155u L=0.04u
M23960 U6300/net19 n5595 VDD VDD pmos W=0.205u L=0.04u
M23961 n2772 U6300/net19 U6300/net26 VDD pmos W=0.325u L=0.04u
M23962 U6300/net26 n4963 VDD VDD pmos W=0.41u L=0.04u
M23963 n2772 n5595 U6300/net30 VDD pmos W=0.325u L=0.04u
M23964 U6300/net30 g860 VDD VDD pmos W=0.205u L=0.04u
M23965 U6301/net19 n5594 VSS VSS nmos W=0.155u L=0.04u
M23966 n2771 n5594 U6301/net40 VSS nmos W=0.155u L=0.04u
M23967 n2771 U6301/net19 U6301/net36 VSS nmos W=0.155u L=0.04u
M23968 U6301/net40 n4962 VSS VSS nmos W=0.31u L=0.04u
M23969 U6301/net36 g864 VSS VSS nmos W=0.155u L=0.04u
M23970 U6301/net19 n5594 VDD VDD pmos W=0.205u L=0.04u
M23971 n2771 U6301/net19 U6301/net26 VDD pmos W=0.325u L=0.04u
M23972 U6301/net26 n4962 VDD VDD pmos W=0.41u L=0.04u
M23973 n2771 n5594 U6301/net30 VDD pmos W=0.325u L=0.04u
M23974 U6301/net30 g864 VDD VDD pmos W=0.205u L=0.04u
M23975 U6302/net19 n5595 VSS VSS nmos W=0.155u L=0.04u
M23976 n2770 n5595 U6302/net40 VSS nmos W=0.155u L=0.04u
M23977 n2770 U6302/net19 U6302/net36 VSS nmos W=0.155u L=0.04u
M23978 U6302/net40 n4962 VSS VSS nmos W=0.31u L=0.04u
M23979 U6302/net36 g863 VSS VSS nmos W=0.155u L=0.04u
M23980 U6302/net19 n5595 VDD VDD pmos W=0.205u L=0.04u
M23981 n2770 U6302/net19 U6302/net26 VDD pmos W=0.325u L=0.04u
M23982 U6302/net26 n4962 VDD VDD pmos W=0.41u L=0.04u
M23983 n2770 n5595 U6302/net30 VDD pmos W=0.325u L=0.04u
M23984 U6302/net30 g863 VDD VDD pmos W=0.205u L=0.04u
M23985 U6303/net19 n5594 VSS VSS nmos W=0.155u L=0.04u
M23986 n2769 n5594 U6303/net40 VSS nmos W=0.155u L=0.04u
M23987 n2769 U6303/net19 U6303/net36 VSS nmos W=0.155u L=0.04u
M23988 U6303/net40 n4987 VSS VSS nmos W=0.31u L=0.04u
M23989 U6303/net36 g867 VSS VSS nmos W=0.155u L=0.04u
M23990 U6303/net19 n5594 VDD VDD pmos W=0.205u L=0.04u
M23991 n2769 U6303/net19 U6303/net26 VDD pmos W=0.325u L=0.04u
M23992 U6303/net26 n4987 VDD VDD pmos W=0.41u L=0.04u
M23993 n2769 n5594 U6303/net30 VDD pmos W=0.325u L=0.04u
M23994 U6303/net30 g867 VDD VDD pmos W=0.205u L=0.04u
M23995 n5594 n4989 VSS VSS nmos W=0.155u L=0.04u
M23996 n5594 n2792 VSS VSS nmos W=0.155u L=0.04u
M23997 U6304/XI1-net8 n2792 VDD VDD pmos W=0.205u L=0.04u
M23998 n5594 n4989 U6304/XI1-net8 VDD pmos W=0.205u L=0.04u
M23999 n4989 g6518 VSS VSS nmos W=0.135u L=0.04u
M24000 n4989 g6518 VDD VDD pmos W=0.205u L=0.04u
M24001 U6306/net19 n5595 VSS VSS nmos W=0.155u L=0.04u
M24002 n2768 n5595 U6306/net40 VSS nmos W=0.155u L=0.04u
M24003 n2768 U6306/net19 U6306/net36 VSS nmos W=0.155u L=0.04u
M24004 U6306/net40 n4987 VSS VSS nmos W=0.31u L=0.04u
M24005 U6306/net36 g866 VSS VSS nmos W=0.155u L=0.04u
M24006 U6306/net19 n5595 VDD VDD pmos W=0.205u L=0.04u
M24007 n2768 U6306/net19 U6306/net26 VDD pmos W=0.325u L=0.04u
M24008 U6306/net26 n4987 VDD VDD pmos W=0.41u L=0.04u
M24009 n2768 n5595 U6306/net30 VDD pmos W=0.325u L=0.04u
M24010 U6306/net30 g866 VDD VDD pmos W=0.205u L=0.04u
M24011 n5595 n4990 VSS VSS nmos W=0.155u L=0.04u
M24012 n5595 n2792 VSS VSS nmos W=0.155u L=0.04u
M24013 U6307/XI1-net8 n2792 VDD VDD pmos W=0.205u L=0.04u
M24014 n5595 n4990 U6307/XI1-net8 VDD pmos W=0.205u L=0.04u
M24015 n4990 g6368 VSS VSS nmos W=0.135u L=0.04u
M24016 n4990 g6368 VDD VDD pmos W=0.205u L=0.04u
M24017 U6309/XU1-net6 n5597 VSS VSS nmos W=0.155u L=0.04u
M24018 n4987 n5596 U6309/XU1-net6 VSS nmos W=0.155u L=0.04u
M24019 n4987 n5597 VDD VDD pmos W=0.155u L=0.04u
M24020 n4987 n5596 VDD VDD pmos W=0.155u L=0.04u
M24021 n5597 n4965 VSS VSS nmos W=0.155u L=0.04u
M24022 n5597 n4964 VSS VSS nmos W=0.155u L=0.04u
M24023 n5597 n4963 VSS VSS nmos W=0.155u L=0.04u
M24024 n5597 n4962 VSS VSS nmos W=0.155u L=0.04u
M24025 U6310/net49 n4964 U6310/net52 VDD pmos W=0.41u L=0.04u
M24026 U6310/net52 n4965 VDD VDD pmos W=0.41u L=0.04u
M24027 U6310/net46 n4963 U6310/net49 VDD pmos W=0.41u L=0.04u
M24028 n5597 n4962 U6310/net46 VDD pmos W=0.41u L=0.04u
M24029 n4965 g797 VSS VSS nmos W=0.135u L=0.04u
M24030 n4965 g797 VDD VDD pmos W=0.205u L=0.04u
M24031 n4964 g793 VSS VSS nmos W=0.135u L=0.04u
M24032 n4964 g793 VDD VDD pmos W=0.205u L=0.04u
M24033 n4963 g789 VSS VSS nmos W=0.135u L=0.04u
M24034 n4963 g789 VDD VDD pmos W=0.205u L=0.04u
M24035 n4962 g785 VSS VSS nmos W=0.135u L=0.04u
M24036 n4962 g785 VDD VDD pmos W=0.205u L=0.04u
M24037 n5596 n5016 VSS VSS nmos W=0.155u L=0.04u
M24038 n5596 n4968 VSS VSS nmos W=0.155u L=0.04u
M24039 n5596 n4967 VSS VSS nmos W=0.155u L=0.04u
M24040 n5596 n4966 VSS VSS nmos W=0.155u L=0.04u
M24041 U6315/net49 n4968 U6315/net52 VDD pmos W=0.41u L=0.04u
M24042 U6315/net52 n5016 VDD VDD pmos W=0.41u L=0.04u
M24043 U6315/net46 n4967 U6315/net49 VDD pmos W=0.41u L=0.04u
M24044 n5596 n4966 U6315/net46 VDD pmos W=0.41u L=0.04u
M24045 n5016 g813 VSS VSS nmos W=0.135u L=0.04u
M24046 n5016 g813 VDD VDD pmos W=0.205u L=0.04u
M24047 n4968 g809 VSS VSS nmos W=0.135u L=0.04u
M24048 n4968 g809 VDD VDD pmos W=0.205u L=0.04u
M24049 n4967 g805 VSS VSS nmos W=0.135u L=0.04u
M24050 n4967 g805 VDD VDD pmos W=0.205u L=0.04u
M24051 n4966 g801 VSS VSS nmos W=0.135u L=0.04u
M24052 n4966 g801 VDD VDD pmos W=0.205u L=0.04u
M24053 U6320/net19 n5599 VSS VSS nmos W=0.155u L=0.04u
M24054 n2767 n5599 U6320/net40 VSS nmos W=0.155u L=0.04u
M24055 n2767 U6320/net19 U6320/net36 VSS nmos W=0.155u L=0.04u
M24056 U6320/net40 n5598 VSS VSS nmos W=0.31u L=0.04u
M24057 U6320/net36 g1550 VSS VSS nmos W=0.155u L=0.04u
M24058 U6320/net19 n5599 VDD VDD pmos W=0.205u L=0.04u
M24059 n2767 U6320/net19 U6320/net26 VDD pmos W=0.325u L=0.04u
M24060 U6320/net26 n5598 VDD VDD pmos W=0.41u L=0.04u
M24061 n2767 n5599 U6320/net30 VDD pmos W=0.325u L=0.04u
M24062 U6320/net30 g1550 VDD VDD pmos W=0.205u L=0.04u
M24063 U6321/net19 n5599 VSS VSS nmos W=0.155u L=0.04u
M24064 n2766 n5599 U6321/net40 VSS nmos W=0.155u L=0.04u
M24065 n2766 U6321/net19 U6321/net36 VSS nmos W=0.155u L=0.04u
M24066 U6321/net40 n5184 VSS VSS nmos W=0.31u L=0.04u
M24067 U6321/net36 g1553 VSS VSS nmos W=0.155u L=0.04u
M24068 U6321/net19 n5599 VDD VDD pmos W=0.205u L=0.04u
M24069 n2766 U6321/net19 U6321/net26 VDD pmos W=0.325u L=0.04u
M24070 U6321/net26 n5184 VDD VDD pmos W=0.41u L=0.04u
M24071 n2766 n5599 U6321/net30 VDD pmos W=0.325u L=0.04u
M24072 U6321/net30 g1553 VDD VDD pmos W=0.205u L=0.04u
M24073 U6322/net19 n5599 VSS VSS nmos W=0.155u L=0.04u
M24074 n2765 n5599 U6322/net40 VSS nmos W=0.155u L=0.04u
M24075 n2765 U6322/net19 U6322/net36 VSS nmos W=0.155u L=0.04u
M24076 U6322/net40 n5183 VSS VSS nmos W=0.31u L=0.04u
M24077 U6322/net36 g1556 VSS VSS nmos W=0.155u L=0.04u
M24078 U6322/net19 n5599 VDD VDD pmos W=0.205u L=0.04u
M24079 n2765 U6322/net19 U6322/net26 VDD pmos W=0.325u L=0.04u
M24080 U6322/net26 n5183 VDD VDD pmos W=0.41u L=0.04u
M24081 n2765 n5599 U6322/net30 VDD pmos W=0.325u L=0.04u
M24082 U6322/net30 g1556 VDD VDD pmos W=0.205u L=0.04u
M24083 U6323/net19 n5599 VSS VSS nmos W=0.155u L=0.04u
M24084 n2764 n5599 U6323/net40 VSS nmos W=0.155u L=0.04u
M24085 n2764 U6323/net19 U6323/net36 VSS nmos W=0.155u L=0.04u
M24086 U6323/net40 n5208 VSS VSS nmos W=0.31u L=0.04u
M24087 U6323/net36 g1559 VSS VSS nmos W=0.155u L=0.04u
M24088 U6323/net19 n5599 VDD VDD pmos W=0.205u L=0.04u
M24089 n2764 U6323/net19 U6323/net26 VDD pmos W=0.325u L=0.04u
M24090 U6323/net26 n5208 VDD VDD pmos W=0.41u L=0.04u
M24091 n2764 n5599 U6323/net30 VDD pmos W=0.325u L=0.04u
M24092 U6323/net30 g1559 VDD VDD pmos W=0.205u L=0.04u
M24093 n5599 n5211 VSS VSS nmos W=0.155u L=0.04u
M24094 n5599 n2792 VSS VSS nmos W=0.155u L=0.04u
M24095 U6324/XI1-net8 n2792 VDD VDD pmos W=0.205u L=0.04u
M24096 n5599 n5211 U6324/XI1-net8 VDD pmos W=0.205u L=0.04u
M24097 n5211 g1547 VSS VSS nmos W=0.135u L=0.04u
M24098 n5211 g1547 VDD VDD pmos W=0.205u L=0.04u
M24099 U6326/net19 n5600 VSS VSS nmos W=0.155u L=0.04u
M24100 n2763 n5600 U6326/net40 VSS nmos W=0.155u L=0.04u
M24101 n2763 U6326/net19 U6326/net36 VSS nmos W=0.155u L=0.04u
M24102 U6326/net40 n5598 VSS VSS nmos W=0.31u L=0.04u
M24103 U6326/net36 g1552 VSS VSS nmos W=0.155u L=0.04u
M24104 U6326/net19 n5600 VDD VDD pmos W=0.205u L=0.04u
M24105 n2763 U6326/net19 U6326/net26 VDD pmos W=0.325u L=0.04u
M24106 U6326/net26 n5598 VDD VDD pmos W=0.41u L=0.04u
M24107 n2763 n5600 U6326/net30 VDD pmos W=0.325u L=0.04u
M24108 U6326/net30 g1552 VDD VDD pmos W=0.205u L=0.04u
M24109 U6327/net19 n5601 VSS VSS nmos W=0.155u L=0.04u
M24110 n2762 n5601 U6327/net40 VSS nmos W=0.155u L=0.04u
M24111 n2762 U6327/net19 U6327/net36 VSS nmos W=0.155u L=0.04u
M24112 U6327/net40 n5598 VSS VSS nmos W=0.31u L=0.04u
M24113 U6327/net36 g1551 VSS VSS nmos W=0.155u L=0.04u
M24114 U6327/net19 n5601 VDD VDD pmos W=0.205u L=0.04u
M24115 n2762 U6327/net19 U6327/net26 VDD pmos W=0.325u L=0.04u
M24116 U6327/net26 n5598 VDD VDD pmos W=0.41u L=0.04u
M24117 n2762 n5601 U6327/net30 VDD pmos W=0.325u L=0.04u
M24118 U6327/net30 g1551 VDD VDD pmos W=0.205u L=0.04u
M24119 n5598 g1501 VSS VSS nmos W=0.155u L=0.04u
M24120 n5598 g1496 VSS VSS nmos W=0.155u L=0.04u
M24121 n5598 n5187 VSS VSS nmos W=0.155u L=0.04u
M24122 n5598 n5237 VSS VSS nmos W=0.155u L=0.04u
M24123 U6328/net49 g1496 U6328/net52 VDD pmos W=0.41u L=0.04u
M24124 U6328/net52 g1501 VDD VDD pmos W=0.41u L=0.04u
M24125 U6328/net46 n5187 U6328/net49 VDD pmos W=0.41u L=0.04u
M24126 n5598 n5237 U6328/net46 VDD pmos W=0.41u L=0.04u
M24127 U6329/net19 n5600 VSS VSS nmos W=0.155u L=0.04u
M24128 n2761 n5600 U6329/net40 VSS nmos W=0.155u L=0.04u
M24129 n2761 U6329/net19 U6329/net36 VSS nmos W=0.155u L=0.04u
M24130 U6329/net40 n5184 VSS VSS nmos W=0.31u L=0.04u
M24131 U6329/net36 g1555 VSS VSS nmos W=0.155u L=0.04u
M24132 U6329/net19 n5600 VDD VDD pmos W=0.205u L=0.04u
M24133 n2761 U6329/net19 U6329/net26 VDD pmos W=0.325u L=0.04u
M24134 U6329/net26 n5184 VDD VDD pmos W=0.41u L=0.04u
M24135 n2761 n5600 U6329/net30 VDD pmos W=0.325u L=0.04u
M24136 U6329/net30 g1555 VDD VDD pmos W=0.205u L=0.04u
M24137 U6330/net19 n5601 VSS VSS nmos W=0.155u L=0.04u
M24138 n2760 n5601 U6330/net40 VSS nmos W=0.155u L=0.04u
M24139 n2760 U6330/net19 U6330/net36 VSS nmos W=0.155u L=0.04u
M24140 U6330/net40 n5184 VSS VSS nmos W=0.31u L=0.04u
M24141 U6330/net36 g1554 VSS VSS nmos W=0.155u L=0.04u
M24142 U6330/net19 n5601 VDD VDD pmos W=0.205u L=0.04u
M24143 n2760 U6330/net19 U6330/net26 VDD pmos W=0.325u L=0.04u
M24144 U6330/net26 n5184 VDD VDD pmos W=0.41u L=0.04u
M24145 n2760 n5601 U6330/net30 VDD pmos W=0.325u L=0.04u
M24146 U6330/net30 g1554 VDD VDD pmos W=0.205u L=0.04u
M24147 U6331/net19 n5600 VSS VSS nmos W=0.155u L=0.04u
M24148 n2759 n5600 U6331/net40 VSS nmos W=0.155u L=0.04u
M24149 n2759 U6331/net19 U6331/net36 VSS nmos W=0.155u L=0.04u
M24150 U6331/net40 n5183 VSS VSS nmos W=0.31u L=0.04u
M24151 U6331/net36 g1558 VSS VSS nmos W=0.155u L=0.04u
M24152 U6331/net19 n5600 VDD VDD pmos W=0.205u L=0.04u
M24153 n2759 U6331/net19 U6331/net26 VDD pmos W=0.325u L=0.04u
M24154 U6331/net26 n5183 VDD VDD pmos W=0.41u L=0.04u
M24155 n2759 n5600 U6331/net30 VDD pmos W=0.325u L=0.04u
M24156 U6331/net30 g1558 VDD VDD pmos W=0.205u L=0.04u
M24157 U6332/net19 n5601 VSS VSS nmos W=0.155u L=0.04u
M24158 n2758 n5601 U6332/net40 VSS nmos W=0.155u L=0.04u
M24159 n2758 U6332/net19 U6332/net36 VSS nmos W=0.155u L=0.04u
M24160 U6332/net40 n5183 VSS VSS nmos W=0.31u L=0.04u
M24161 U6332/net36 g1557 VSS VSS nmos W=0.155u L=0.04u
M24162 U6332/net19 n5601 VDD VDD pmos W=0.205u L=0.04u
M24163 n2758 U6332/net19 U6332/net26 VDD pmos W=0.325u L=0.04u
M24164 U6332/net26 n5183 VDD VDD pmos W=0.41u L=0.04u
M24165 n2758 n5601 U6332/net30 VDD pmos W=0.325u L=0.04u
M24166 U6332/net30 g1557 VDD VDD pmos W=0.205u L=0.04u
M24167 U6333/net19 n5600 VSS VSS nmos W=0.155u L=0.04u
M24168 n2757 n5600 U6333/net40 VSS nmos W=0.155u L=0.04u
M24169 n2757 U6333/net19 U6333/net36 VSS nmos W=0.155u L=0.04u
M24170 U6333/net40 n5208 VSS VSS nmos W=0.31u L=0.04u
M24171 U6333/net36 g1561 VSS VSS nmos W=0.155u L=0.04u
M24172 U6333/net19 n5600 VDD VDD pmos W=0.205u L=0.04u
M24173 n2757 U6333/net19 U6333/net26 VDD pmos W=0.325u L=0.04u
M24174 U6333/net26 n5208 VDD VDD pmos W=0.41u L=0.04u
M24175 n2757 n5600 U6333/net30 VDD pmos W=0.325u L=0.04u
M24176 U6333/net30 g1561 VDD VDD pmos W=0.205u L=0.04u
M24177 n5600 n5212 VSS VSS nmos W=0.155u L=0.04u
M24178 n5600 n2792 VSS VSS nmos W=0.155u L=0.04u
M24179 U6334/XI1-net8 n2792 VDD VDD pmos W=0.205u L=0.04u
M24180 n5600 n5212 U6334/XI1-net8 VDD pmos W=0.205u L=0.04u
M24181 n5212 g6782 VSS VSS nmos W=0.135u L=0.04u
M24182 n5212 g6782 VDD VDD pmos W=0.205u L=0.04u
M24183 U6336/net19 n5601 VSS VSS nmos W=0.155u L=0.04u
M24184 n2756 n5601 U6336/net40 VSS nmos W=0.155u L=0.04u
M24185 n2756 U6336/net19 U6336/net36 VSS nmos W=0.155u L=0.04u
M24186 U6336/net40 n5208 VSS VSS nmos W=0.31u L=0.04u
M24187 U6336/net36 g1560 VSS VSS nmos W=0.155u L=0.04u
M24188 U6336/net19 n5601 VDD VDD pmos W=0.205u L=0.04u
M24189 n2756 U6336/net19 U6336/net26 VDD pmos W=0.325u L=0.04u
M24190 U6336/net26 n5208 VDD VDD pmos W=0.41u L=0.04u
M24191 n2756 n5601 U6336/net30 VDD pmos W=0.325u L=0.04u
M24192 U6336/net30 g1560 VDD VDD pmos W=0.205u L=0.04u
M24193 n5601 n5210 VSS VSS nmos W=0.155u L=0.04u
M24194 n5601 n2792 VSS VSS nmos W=0.155u L=0.04u
M24195 U6337/XI1-net8 n2792 VDD VDD pmos W=0.205u L=0.04u
M24196 n5601 n5210 U6337/XI1-net8 VDD pmos W=0.205u L=0.04u
M24197 n5210 g6573 VSS VSS nmos W=0.135u L=0.04u
M24198 n5210 g6573 VDD VDD pmos W=0.205u L=0.04u
M24199 U6339/XU1-net6 n5603 VSS VSS nmos W=0.155u L=0.04u
M24200 n5208 n5602 U6339/XU1-net6 VSS nmos W=0.155u L=0.04u
M24201 n5208 n5603 VDD VDD pmos W=0.155u L=0.04u
M24202 n5208 n5602 VDD VDD pmos W=0.155u L=0.04u
M24203 n5603 n5186 VSS VSS nmos W=0.155u L=0.04u
M24204 n5603 n5185 VSS VSS nmos W=0.155u L=0.04u
M24205 n5603 n5184 VSS VSS nmos W=0.155u L=0.04u
M24206 n5603 n5183 VSS VSS nmos W=0.155u L=0.04u
M24207 U6340/net49 n5185 U6340/net52 VDD pmos W=0.41u L=0.04u
M24208 U6340/net52 n5186 VDD VDD pmos W=0.41u L=0.04u
M24209 U6340/net46 n5184 U6340/net49 VDD pmos W=0.41u L=0.04u
M24210 n5603 n5183 U6340/net46 VDD pmos W=0.41u L=0.04u
M24211 n5186 g1486 VSS VSS nmos W=0.135u L=0.04u
M24212 n5186 g1486 VDD VDD pmos W=0.205u L=0.04u
M24213 n5185 g1481 VSS VSS nmos W=0.135u L=0.04u
M24214 n5185 g1481 VDD VDD pmos W=0.205u L=0.04u
M24215 n5184 g1476 VSS VSS nmos W=0.135u L=0.04u
M24216 n5184 g1476 VDD VDD pmos W=0.205u L=0.04u
M24217 n5183 g1471 VSS VSS nmos W=0.135u L=0.04u
M24218 n5183 g1471 VDD VDD pmos W=0.205u L=0.04u
M24219 n5602 n5237 VSS VSS nmos W=0.155u L=0.04u
M24220 n5602 n5189 VSS VSS nmos W=0.155u L=0.04u
M24221 n5602 n5188 VSS VSS nmos W=0.155u L=0.04u
M24222 n5602 n5187 VSS VSS nmos W=0.155u L=0.04u
M24223 U6345/net49 n5189 U6345/net52 VDD pmos W=0.41u L=0.04u
M24224 U6345/net52 n5237 VDD VDD pmos W=0.41u L=0.04u
M24225 U6345/net46 n5188 U6345/net49 VDD pmos W=0.41u L=0.04u
M24226 n5602 n5187 U6345/net46 VDD pmos W=0.41u L=0.04u
M24227 n5237 g1506 VSS VSS nmos W=0.135u L=0.04u
M24228 n5237 g1506 VDD VDD pmos W=0.205u L=0.04u
M24229 n5189 g1501 VSS VSS nmos W=0.135u L=0.04u
M24230 n5189 g1501 VDD VDD pmos W=0.205u L=0.04u
M24231 n5188 g1496 VSS VSS nmos W=0.135u L=0.04u
M24232 n5188 g1496 VDD VDD pmos W=0.205u L=0.04u
M24233 n5187 g1491 VSS VSS nmos W=0.135u L=0.04u
M24234 n5187 g1491 VDD VDD pmos W=0.205u L=0.04u
M24235 U6350/net19 n5605 VSS VSS nmos W=0.155u L=0.04u
M24236 n2755 n5605 U6350/net40 VSS nmos W=0.155u L=0.04u
M24237 n2755 U6350/net19 U6350/net36 VSS nmos W=0.155u L=0.04u
M24238 U6350/net40 n5604 VSS VSS nmos W=0.31u L=0.04u
M24239 U6350/net36 g2244 VSS VSS nmos W=0.155u L=0.04u
M24240 U6350/net19 n5605 VDD VDD pmos W=0.205u L=0.04u
M24241 n2755 U6350/net19 U6350/net26 VDD pmos W=0.325u L=0.04u
M24242 U6350/net26 n5604 VDD VDD pmos W=0.41u L=0.04u
M24243 n2755 n5605 U6350/net30 VDD pmos W=0.325u L=0.04u
M24244 U6350/net30 g2244 VDD VDD pmos W=0.205u L=0.04u
M24245 U6351/net19 n5605 VSS VSS nmos W=0.155u L=0.04u
M24246 n2754 n5605 U6351/net40 VSS nmos W=0.155u L=0.04u
M24247 n2754 U6351/net19 U6351/net36 VSS nmos W=0.155u L=0.04u
M24248 U6351/net40 n4522 VSS VSS nmos W=0.31u L=0.04u
M24249 U6351/net36 g2247 VSS VSS nmos W=0.155u L=0.04u
M24250 U6351/net19 n5605 VDD VDD pmos W=0.205u L=0.04u
M24251 n2754 U6351/net19 U6351/net26 VDD pmos W=0.325u L=0.04u
M24252 U6351/net26 n4522 VDD VDD pmos W=0.41u L=0.04u
M24253 n2754 n5605 U6351/net30 VDD pmos W=0.325u L=0.04u
M24254 U6351/net30 g2247 VDD VDD pmos W=0.205u L=0.04u
M24255 U6352/net19 n5605 VSS VSS nmos W=0.155u L=0.04u
M24256 n2753 n5605 U6352/net40 VSS nmos W=0.155u L=0.04u
M24257 n2753 U6352/net19 U6352/net36 VSS nmos W=0.155u L=0.04u
M24258 U6352/net40 n4521 VSS VSS nmos W=0.31u L=0.04u
M24259 U6352/net36 g2250 VSS VSS nmos W=0.155u L=0.04u
M24260 U6352/net19 n5605 VDD VDD pmos W=0.205u L=0.04u
M24261 n2753 U6352/net19 U6352/net26 VDD pmos W=0.325u L=0.04u
M24262 U6352/net26 n4521 VDD VDD pmos W=0.41u L=0.04u
M24263 n2753 n5605 U6352/net30 VDD pmos W=0.325u L=0.04u
M24264 U6352/net30 g2250 VDD VDD pmos W=0.205u L=0.04u
M24265 U6353/net19 n5605 VSS VSS nmos W=0.155u L=0.04u
M24266 n2752 n5605 U6353/net40 VSS nmos W=0.155u L=0.04u
M24267 n2752 U6353/net19 U6353/net36 VSS nmos W=0.155u L=0.04u
M24268 U6353/net40 n4546 VSS VSS nmos W=0.31u L=0.04u
M24269 U6353/net36 g2253 VSS VSS nmos W=0.155u L=0.04u
M24270 U6353/net19 n5605 VDD VDD pmos W=0.205u L=0.04u
M24271 n2752 U6353/net19 U6353/net26 VDD pmos W=0.325u L=0.04u
M24272 U6353/net26 n4546 VDD VDD pmos W=0.41u L=0.04u
M24273 n2752 n5605 U6353/net30 VDD pmos W=0.325u L=0.04u
M24274 U6353/net30 g2253 VDD VDD pmos W=0.205u L=0.04u
M24275 n5605 n4549 VSS VSS nmos W=0.155u L=0.04u
M24276 n5605 n2792 VSS VSS nmos W=0.155u L=0.04u
M24277 U6354/XI1-net8 n2792 VDD VDD pmos W=0.205u L=0.04u
M24278 n5605 n4549 U6354/XI1-net8 VDD pmos W=0.205u L=0.04u
M24279 n4549 g2241 VSS VSS nmos W=0.135u L=0.04u
M24280 n4549 g2241 VDD VDD pmos W=0.205u L=0.04u
M24281 U6356/net19 n5606 VSS VSS nmos W=0.155u L=0.04u
M24282 n2751 n5606 U6356/net40 VSS nmos W=0.155u L=0.04u
M24283 n2751 U6356/net19 U6356/net36 VSS nmos W=0.155u L=0.04u
M24284 U6356/net40 n5604 VSS VSS nmos W=0.31u L=0.04u
M24285 U6356/net36 g2246 VSS VSS nmos W=0.155u L=0.04u
M24286 U6356/net19 n5606 VDD VDD pmos W=0.205u L=0.04u
M24287 n2751 U6356/net19 U6356/net26 VDD pmos W=0.325u L=0.04u
M24288 U6356/net26 n5604 VDD VDD pmos W=0.41u L=0.04u
M24289 n2751 n5606 U6356/net30 VDD pmos W=0.325u L=0.04u
M24290 U6356/net30 g2246 VDD VDD pmos W=0.205u L=0.04u
M24291 U6357/net19 n5607 VSS VSS nmos W=0.155u L=0.04u
M24292 n2750 n5607 U6357/net40 VSS nmos W=0.155u L=0.04u
M24293 n2750 U6357/net19 U6357/net36 VSS nmos W=0.155u L=0.04u
M24294 U6357/net40 n5604 VSS VSS nmos W=0.31u L=0.04u
M24295 U6357/net36 g2245 VSS VSS nmos W=0.155u L=0.04u
M24296 U6357/net19 n5607 VDD VDD pmos W=0.205u L=0.04u
M24297 n2750 U6357/net19 U6357/net26 VDD pmos W=0.325u L=0.04u
M24298 U6357/net26 n5604 VDD VDD pmos W=0.41u L=0.04u
M24299 n2750 n5607 U6357/net30 VDD pmos W=0.325u L=0.04u
M24300 U6357/net30 g2245 VDD VDD pmos W=0.205u L=0.04u
M24301 n5604 g2195 VSS VSS nmos W=0.155u L=0.04u
M24302 n5604 g2190 VSS VSS nmos W=0.155u L=0.04u
M24303 n5604 n4525 VSS VSS nmos W=0.155u L=0.04u
M24304 n5604 n4575 VSS VSS nmos W=0.155u L=0.04u
M24305 U6358/net49 g2190 U6358/net52 VDD pmos W=0.41u L=0.04u
M24306 U6358/net52 g2195 VDD VDD pmos W=0.41u L=0.04u
M24307 U6358/net46 n4525 U6358/net49 VDD pmos W=0.41u L=0.04u
M24308 n5604 n4575 U6358/net46 VDD pmos W=0.41u L=0.04u
M24309 U6359/net19 n5606 VSS VSS nmos W=0.155u L=0.04u
M24310 n2749 n5606 U6359/net40 VSS nmos W=0.155u L=0.04u
M24311 n2749 U6359/net19 U6359/net36 VSS nmos W=0.155u L=0.04u
M24312 U6359/net40 n4522 VSS VSS nmos W=0.31u L=0.04u
M24313 U6359/net36 g2249 VSS VSS nmos W=0.155u L=0.04u
M24314 U6359/net19 n5606 VDD VDD pmos W=0.205u L=0.04u
M24315 n2749 U6359/net19 U6359/net26 VDD pmos W=0.325u L=0.04u
M24316 U6359/net26 n4522 VDD VDD pmos W=0.41u L=0.04u
M24317 n2749 n5606 U6359/net30 VDD pmos W=0.325u L=0.04u
M24318 U6359/net30 g2249 VDD VDD pmos W=0.205u L=0.04u
M24319 U6360/net19 n5607 VSS VSS nmos W=0.155u L=0.04u
M24320 n2748 n5607 U6360/net40 VSS nmos W=0.155u L=0.04u
M24321 n2748 U6360/net19 U6360/net36 VSS nmos W=0.155u L=0.04u
M24322 U6360/net40 n4522 VSS VSS nmos W=0.31u L=0.04u
M24323 U6360/net36 g2248 VSS VSS nmos W=0.155u L=0.04u
M24324 U6360/net19 n5607 VDD VDD pmos W=0.205u L=0.04u
M24325 n2748 U6360/net19 U6360/net26 VDD pmos W=0.325u L=0.04u
M24326 U6360/net26 n4522 VDD VDD pmos W=0.41u L=0.04u
M24327 n2748 n5607 U6360/net30 VDD pmos W=0.325u L=0.04u
M24328 U6360/net30 g2248 VDD VDD pmos W=0.205u L=0.04u
M24329 U6361/net19 n5606 VSS VSS nmos W=0.155u L=0.04u
M24330 n2747 n5606 U6361/net40 VSS nmos W=0.155u L=0.04u
M24331 n2747 U6361/net19 U6361/net36 VSS nmos W=0.155u L=0.04u
M24332 U6361/net40 n4521 VSS VSS nmos W=0.31u L=0.04u
M24333 U6361/net36 g2252 VSS VSS nmos W=0.155u L=0.04u
M24334 U6361/net19 n5606 VDD VDD pmos W=0.205u L=0.04u
M24335 n2747 U6361/net19 U6361/net26 VDD pmos W=0.325u L=0.04u
M24336 U6361/net26 n4521 VDD VDD pmos W=0.41u L=0.04u
M24337 n2747 n5606 U6361/net30 VDD pmos W=0.325u L=0.04u
M24338 U6361/net30 g2252 VDD VDD pmos W=0.205u L=0.04u
M24339 U6362/net19 n5607 VSS VSS nmos W=0.155u L=0.04u
M24340 n2746 n5607 U6362/net40 VSS nmos W=0.155u L=0.04u
M24341 n2746 U6362/net19 U6362/net36 VSS nmos W=0.155u L=0.04u
M24342 U6362/net40 n4521 VSS VSS nmos W=0.31u L=0.04u
M24343 U6362/net36 g2251 VSS VSS nmos W=0.155u L=0.04u
M24344 U6362/net19 n5607 VDD VDD pmos W=0.205u L=0.04u
M24345 n2746 U6362/net19 U6362/net26 VDD pmos W=0.325u L=0.04u
M24346 U6362/net26 n4521 VDD VDD pmos W=0.41u L=0.04u
M24347 n2746 n5607 U6362/net30 VDD pmos W=0.325u L=0.04u
M24348 U6362/net30 g2251 VDD VDD pmos W=0.205u L=0.04u
M24349 U6363/net19 n5606 VSS VSS nmos W=0.155u L=0.04u
M24350 n2745 n5606 U6363/net40 VSS nmos W=0.155u L=0.04u
M24351 n2745 U6363/net19 U6363/net36 VSS nmos W=0.155u L=0.04u
M24352 U6363/net40 n4546 VSS VSS nmos W=0.31u L=0.04u
M24353 U6363/net36 g2255 VSS VSS nmos W=0.155u L=0.04u
M24354 U6363/net19 n5606 VDD VDD pmos W=0.205u L=0.04u
M24355 n2745 U6363/net19 U6363/net26 VDD pmos W=0.325u L=0.04u
M24356 U6363/net26 n4546 VDD VDD pmos W=0.41u L=0.04u
M24357 n2745 n5606 U6363/net30 VDD pmos W=0.325u L=0.04u
M24358 U6363/net30 g2255 VDD VDD pmos W=0.205u L=0.04u
M24359 n5606 n4550 VSS VSS nmos W=0.155u L=0.04u
M24360 n5606 n2792 VSS VSS nmos W=0.155u L=0.04u
M24361 U6364/XI1-net8 n2792 VDD VDD pmos W=0.205u L=0.04u
M24362 n5606 n4550 U6364/XI1-net8 VDD pmos W=0.205u L=0.04u
M24363 n4550 g7084 VSS VSS nmos W=0.135u L=0.04u
M24364 n4550 g7084 VDD VDD pmos W=0.205u L=0.04u
M24365 U6366/net19 n5607 VSS VSS nmos W=0.155u L=0.04u
M24366 n2744 n5607 U6366/net40 VSS nmos W=0.155u L=0.04u
M24367 n2744 U6366/net19 U6366/net36 VSS nmos W=0.155u L=0.04u
M24368 U6366/net40 n4546 VSS VSS nmos W=0.31u L=0.04u
M24369 U6366/net36 g2254 VSS VSS nmos W=0.155u L=0.04u
M24370 U6366/net19 n5607 VDD VDD pmos W=0.205u L=0.04u
M24371 n2744 U6366/net19 U6366/net26 VDD pmos W=0.325u L=0.04u
M24372 U6366/net26 n4546 VDD VDD pmos W=0.41u L=0.04u
M24373 n2744 n5607 U6366/net30 VDD pmos W=0.325u L=0.04u
M24374 U6366/net30 g2254 VDD VDD pmos W=0.205u L=0.04u
M24375 n5607 n4548 VSS VSS nmos W=0.155u L=0.04u
M24376 n5607 n2792 VSS VSS nmos W=0.155u L=0.04u
M24377 U6367/XI1-net8 n2792 VDD VDD pmos W=0.205u L=0.04u
M24378 n5607 n4548 U6367/XI1-net8 VDD pmos W=0.205u L=0.04u
M24379 U6368/p2 n5608 VSS VSS nmos W=0.155u L=0.04u
M24380 U6368/p0 n5522 U6368/p1 VSS nmos W=0.155u L=0.04u
M24381 U6368/p1 g2924 U6368/p2 VSS nmos W=0.155u L=0.04u
M24382 n2792 g2883 U6368/p0 VSS nmos W=0.155u L=0.04u
M24383 n2792 g2924 VDD VDD pmos W=0.205u L=0.04u
M24384 n2792 n5522 VDD VDD pmos W=0.205u L=0.04u
M24385 n2792 g2883 VDD VDD pmos W=0.205u L=0.04u
M24386 n2792 n5608 VDD VDD pmos W=0.205u L=0.04u
M24387 n5608 g2888 VSS VSS nmos W=0.155u L=0.04u
M24388 n5608 g2912 VSS VSS nmos W=0.155u L=0.04u
M24389 n5608 g2917 VSS VSS nmos W=0.155u L=0.04u
M24390 n5608 g2920 VSS VSS nmos W=0.155u L=0.04u
M24391 U6369/net49 g2912 U6369/net52 VDD pmos W=0.41u L=0.04u
M24392 U6369/net52 g2888 VDD VDD pmos W=0.41u L=0.04u
M24393 U6369/net46 g2917 U6369/net49 VDD pmos W=0.41u L=0.04u
M24394 n5608 g2920 U6369/net46 VDD pmos W=0.41u L=0.04u
M24395 n5522 n5437 VSS VSS nmos W=0.135u L=0.04u
M24396 n5522 n5437 VDD VDD pmos W=0.205u L=0.04u
M24397 n4548 g6837 VSS VSS nmos W=0.135u L=0.04u
M24398 n4548 g6837 VDD VDD pmos W=0.205u L=0.04u
M24399 U6372/XU1-net6 n5610 VSS VSS nmos W=0.155u L=0.04u
M24400 n4546 n5609 U6372/XU1-net6 VSS nmos W=0.155u L=0.04u
M24401 n4546 n5610 VDD VDD pmos W=0.155u L=0.04u
M24402 n4546 n5609 VDD VDD pmos W=0.155u L=0.04u
M24403 n5610 n4524 VSS VSS nmos W=0.155u L=0.04u
M24404 n5610 n4523 VSS VSS nmos W=0.155u L=0.04u
M24405 n5610 n4522 VSS VSS nmos W=0.155u L=0.04u
M24406 n5610 n4521 VSS VSS nmos W=0.155u L=0.04u
M24407 U6373/net49 n4523 U6373/net52 VDD pmos W=0.41u L=0.04u
M24408 U6373/net52 n4524 VDD VDD pmos W=0.41u L=0.04u
M24409 U6373/net46 n4522 U6373/net49 VDD pmos W=0.41u L=0.04u
M24410 n5610 n4521 U6373/net46 VDD pmos W=0.41u L=0.04u
M24411 n4524 g2180 VSS VSS nmos W=0.135u L=0.04u
M24412 n4524 g2180 VDD VDD pmos W=0.205u L=0.04u
M24413 n4523 g2175 VSS VSS nmos W=0.135u L=0.04u
M24414 n4523 g2175 VDD VDD pmos W=0.205u L=0.04u
M24415 n4522 g2170 VSS VSS nmos W=0.135u L=0.04u
M24416 n4522 g2170 VDD VDD pmos W=0.205u L=0.04u
M24417 n4521 g2165 VSS VSS nmos W=0.135u L=0.04u
M24418 n4521 g2165 VDD VDD pmos W=0.205u L=0.04u
M24419 n5609 n4575 VSS VSS nmos W=0.155u L=0.04u
M24420 n5609 n4527 VSS VSS nmos W=0.155u L=0.04u
M24421 n5609 n4526 VSS VSS nmos W=0.155u L=0.04u
M24422 n5609 n4525 VSS VSS nmos W=0.155u L=0.04u
M24423 U6378/net49 n4527 U6378/net52 VDD pmos W=0.41u L=0.04u
M24424 U6378/net52 n4575 VDD VDD pmos W=0.41u L=0.04u
M24425 U6378/net46 n4526 U6378/net49 VDD pmos W=0.41u L=0.04u
M24426 n5609 n4525 U6378/net46 VDD pmos W=0.41u L=0.04u
M24427 n4575 g2200 VSS VSS nmos W=0.135u L=0.04u
M24428 n4575 g2200 VDD VDD pmos W=0.205u L=0.04u
M24429 n4527 g2195 VSS VSS nmos W=0.135u L=0.04u
M24430 n4527 g2195 VDD VDD pmos W=0.205u L=0.04u
M24431 n4526 g2190 VSS VSS nmos W=0.135u L=0.04u
M24432 n4526 g2190 VDD VDD pmos W=0.205u L=0.04u
M24433 n4525 g2185 VSS VSS nmos W=0.135u L=0.04u
M24434 n4525 g2185 VDD VDD pmos W=0.205u L=0.04u
M24435 U6383/XU1-net6 n660 VSS VSS nmos W=0.155u L=0.04u
M24436 n2743 g2950 U6383/XU1-net6 VSS nmos W=0.155u L=0.04u
M24437 n2743 n660 VDD VDD pmos W=0.155u L=0.04u
M24438 n2743 g2950 VDD VDD pmos W=0.155u L=0.04u
M24439 U6384/XU1-net6 n660 VSS VSS nmos W=0.155u L=0.04u
M24440 n2742 g2817 U6384/XU1-net6 VSS nmos W=0.155u L=0.04u
M24441 n2742 n660 VDD VDD pmos W=0.155u L=0.04u
M24442 n2742 g2817 VDD VDD pmos W=0.155u L=0.04u
M24443 n660 g51 VSS VSS nmos W=0.135u L=0.04u
M24444 n660 g51 VDD VDD pmos W=0.205u L=0.04u
M24445 U6386/net36 n5612 U6386/net24 VSS nmos W=0.155u L=0.04u
M24446 U6386/net24 n5613 VSS VSS nmos W=0.155u L=0.04u
M24447 n2741 g2888 U6386/net36 VSS nmos W=0.155u L=0.04u
M24448 n2741 n5611 U6386/net36 VSS nmos W=0.155u L=0.04u
M24449 n2741 n5611 U6386/net35 VDD pmos W=0.205u L=0.04u
M24450 U6386/net35 g2888 VDD VDD pmos W=0.205u L=0.04u
M24451 n2741 n5613 VDD VDD pmos W=0.205u L=0.04u
M24452 n2741 n5612 VDD VDD pmos W=0.205u L=0.04u
M24453 U6387/net36 n5615 U6387/net24 VSS nmos W=0.155u L=0.04u
M24454 U6387/net24 n5613 VSS VSS nmos W=0.155u L=0.04u
M24455 n2740 g2896 U6387/net36 VSS nmos W=0.155u L=0.04u
M24456 n2740 n5614 U6387/net36 VSS nmos W=0.155u L=0.04u
M24457 n2740 n5614 U6387/net35 VDD pmos W=0.205u L=0.04u
M24458 U6387/net35 g2896 VDD VDD pmos W=0.205u L=0.04u
M24459 n2740 n5613 VDD VDD pmos W=0.205u L=0.04u
M24460 n2740 n5615 VDD VDD pmos W=0.205u L=0.04u
M24461 n2739 U6388/net27 VDD VDD pmos W=0.205u L=0.04u
M24462 U6388/net11 n5616 U6388/net27 VDD pmos W=0.205u L=0.04u
M24463 U6388/net11 n5615 U6388/net27 VDD pmos W=0.205u L=0.04u
M24464 U6388/net11 n5617 U6388/XI16-net11 VDD pmos W=0.205u L=0.04u
M24465 U6388/XI16-net11 n5618 VDD VDD pmos W=0.205u L=0.04u
M24466 U6388/net27 n5618 VSS VSS nmos W=0.155u L=0.04u
M24467 U6388/net27 n5617 VSS VSS nmos W=0.155u L=0.04u
M24468 n2739 U6388/net27 VSS VSS nmos W=0.155u L=0.04u
M24469 U6388/net27 n5616 U6388/XI12-net17 VSS nmos W=0.155u L=0.04u
M24470 U6388/XI12-net17 n5615 VSS VSS nmos W=0.155u L=0.04u
M24471 U6389/net36 n5619 U6389/net24 VSS nmos W=0.155u L=0.04u
M24472 U6389/net24 n5613 VSS VSS nmos W=0.155u L=0.04u
M24473 n2738 g2903 U6389/net36 VSS nmos W=0.155u L=0.04u
M24474 n2738 n5617 U6389/net36 VSS nmos W=0.155u L=0.04u
M24475 n2738 n5617 U6389/net35 VDD pmos W=0.205u L=0.04u
M24476 U6389/net35 g2903 VDD VDD pmos W=0.205u L=0.04u
M24477 n2738 n5613 VDD VDD pmos W=0.205u L=0.04u
M24478 n2738 n5619 VDD VDD pmos W=0.205u L=0.04u
M24479 U6390/XU1-net6 n5620 VSS VSS nmos W=0.155u L=0.04u
M24480 n2737 n5613 U6390/XU1-net6 VSS nmos W=0.155u L=0.04u
M24481 n2737 n5620 VDD VDD pmos W=0.155u L=0.04u
M24482 n2737 n5613 VDD VDD pmos W=0.155u L=0.04u
M24483 U6391/net4 n5619 U6391/net14 VSS nmos W=0.155u L=0.04u
M24484 U6391/net6 U6391/net10 U6391/net14 VSS nmos W=0.17u L=0.04u
M24485 U6391/net4 g2900 VSS VSS nmos W=0.155u L=0.04u
M24486 U6391/net6 U6391/net4 VSS VSS nmos W=0.17u L=0.04u
M24487 n5620 U6391/net14 VSS VSS nmos W=0.155u L=0.04u
M24488 U6391/net10 n5619 VSS VSS nmos W=0.155u L=0.04u
M24489 U6391/net4 U6391/net10 U6391/net14 VDD pmos W=0.255u L=0.04u
M24490 U6391/net6 n5619 U6391/net14 VDD pmos W=0.28u L=0.04u
M24491 U6391/net4 g2900 VDD VDD pmos W=0.205u L=0.04u
M24492 U6391/net6 U6391/net4 VDD VDD pmos W=0.24u L=0.04u
M24493 n5620 U6391/net14 VDD VDD pmos W=0.205u L=0.04u
M24494 U6391/net10 n5619 VDD VDD pmos W=0.205u L=0.04u
M24495 U6392/XU1-net6 n5621 VSS VSS nmos W=0.155u L=0.04u
M24496 n2736 n5613 U6392/XU1-net6 VSS nmos W=0.155u L=0.04u
M24497 n2736 n5621 VDD VDD pmos W=0.155u L=0.04u
M24498 n2736 n5613 VDD VDD pmos W=0.155u L=0.04u
M24499 U6393/net4 U6393/net10 U6393/net14 VSS nmos W=0.155u L=0.04u
M24500 U6393/net6 g2908 U6393/net14 VSS nmos W=0.155u L=0.04u
M24501 U6393/net4 n5622 VSS VSS nmos W=0.155u L=0.04u
M24502 U6393/net6 U6393/net4 VSS VSS nmos W=0.155u L=0.04u
M24503 n5621 U6393/net14 VSS VSS nmos W=0.155u L=0.04u
M24504 U6393/net10 g2908 VSS VSS nmos W=0.155u L=0.04u
M24505 U6393/net4 g2908 U6393/net14 VDD pmos W=0.205u L=0.04u
M24506 U6393/net6 U6393/net10 U6393/net14 VDD pmos W=0.205u L=0.04u
M24507 U6393/net4 n5622 VDD VDD pmos W=0.205u L=0.04u
M24508 U6393/net6 U6393/net4 VDD VDD pmos W=0.205u L=0.04u
M24509 n5621 U6393/net14 VDD VDD pmos W=0.205u L=0.04u
M24510 U6393/net10 g2908 VDD VDD pmos W=0.205u L=0.04u
M24511 n5622 n5623 VSS VSS nmos W=0.155u L=0.04u
M24512 n5622 n5619 VSS VSS nmos W=0.155u L=0.04u
M24513 U6394/XI1-net8 n5619 VDD VDD pmos W=0.205u L=0.04u
M24514 n5622 n5623 U6394/XI1-net8 VDD pmos W=0.205u L=0.04u
M24515 U6395/XU1-net6 g2903 VSS VSS nmos W=0.155u L=0.04u
M24516 n5619 n5617 U6395/XU1-net6 VSS nmos W=0.155u L=0.04u
M24517 n5619 g2903 VDD VDD pmos W=0.155u L=0.04u
M24518 n5619 n5617 VDD VDD pmos W=0.155u L=0.04u
M24519 n5617 n5615 VSS VSS nmos W=0.155u L=0.04u
M24520 n5617 n5616 VSS VSS nmos W=0.155u L=0.04u
M24521 U6396/XI1-net8 n5616 VDD VDD pmos W=0.205u L=0.04u
M24522 n5617 n5615 U6396/XI1-net8 VDD pmos W=0.205u L=0.04u
M24523 U6397/XU1-net6 n5614 VSS VSS nmos W=0.155u L=0.04u
M24524 n5615 g2896 U6397/XU1-net6 VSS nmos W=0.155u L=0.04u
M24525 n5615 n5614 VDD VDD pmos W=0.155u L=0.04u
M24526 n5615 g2896 VDD VDD pmos W=0.155u L=0.04u
M24527 n5614 n5612 VSS VSS nmos W=0.135u L=0.04u
M24528 n5614 n5612 VDD VDD pmos W=0.205u L=0.04u
M24529 U6399/XU1-net6 g2888 VSS VSS nmos W=0.155u L=0.04u
M24530 n5612 n5611 U6399/XU1-net6 VSS nmos W=0.155u L=0.04u
M24531 n5612 g2888 VDD VDD pmos W=0.155u L=0.04u
M24532 n5612 n5611 VDD VDD pmos W=0.155u L=0.04u
M24533 n5613 n5618 VSS VSS nmos W=0.135u L=0.04u
M24534 n5613 n5618 VDD VDD pmos W=0.205u L=0.04u
M24535 U6401/net36 n5625 U6401/net24 VSS nmos W=0.155u L=0.04u
M24536 U6401/net24 n5626 VSS VSS nmos W=0.155u L=0.04u
M24537 n2735 g2917 U6401/net36 VSS nmos W=0.155u L=0.04u
M24538 n2735 n5624 U6401/net36 VSS nmos W=0.155u L=0.04u
M24539 n2735 n5624 U6401/net35 VDD pmos W=0.205u L=0.04u
M24540 U6401/net35 g2917 VDD VDD pmos W=0.205u L=0.04u
M24541 n2735 n5626 VDD VDD pmos W=0.205u L=0.04u
M24542 n2735 n5625 VDD VDD pmos W=0.205u L=0.04u
M24543 U6402/net36 n5628 U6402/net24 VSS nmos W=0.155u L=0.04u
M24544 U6402/net24 n5626 VSS VSS nmos W=0.155u L=0.04u
M24545 n2734 g2924 U6402/net36 VSS nmos W=0.155u L=0.04u
M24546 n2734 n5627 U6402/net36 VSS nmos W=0.155u L=0.04u
M24547 n2734 n5627 U6402/net35 VDD pmos W=0.205u L=0.04u
M24548 U6402/net35 g2924 VDD VDD pmos W=0.205u L=0.04u
M24549 n2734 n5626 VDD VDD pmos W=0.205u L=0.04u
M24550 n2734 n5628 VDD VDD pmos W=0.205u L=0.04u
M24551 U6403/XU1-net6 n5626 VSS VSS nmos W=0.155u L=0.04u
M24552 n2733 n5629 U6403/XU1-net6 VSS nmos W=0.155u L=0.04u
M24553 n2733 n5626 VDD VDD pmos W=0.155u L=0.04u
M24554 n2733 n5629 VDD VDD pmos W=0.155u L=0.04u
M24555 U6404/net4 n5628 U6404/net14 VSS nmos W=0.155u L=0.04u
M24556 U6404/net6 U6404/net10 U6404/net14 VSS nmos W=0.17u L=0.04u
M24557 U6404/net4 g2920 VSS VSS nmos W=0.155u L=0.04u
M24558 U6404/net6 U6404/net4 VSS VSS nmos W=0.17u L=0.04u
M24559 n5629 U6404/net14 VSS VSS nmos W=0.155u L=0.04u
M24560 U6404/net10 n5628 VSS VSS nmos W=0.155u L=0.04u
M24561 U6404/net4 U6404/net10 U6404/net14 VDD pmos W=0.255u L=0.04u
M24562 U6404/net6 n5628 U6404/net14 VDD pmos W=0.28u L=0.04u
M24563 U6404/net4 g2920 VDD VDD pmos W=0.205u L=0.04u
M24564 U6404/net6 U6404/net4 VDD VDD pmos W=0.24u L=0.04u
M24565 n5629 U6404/net14 VDD VDD pmos W=0.205u L=0.04u
M24566 U6404/net10 n5628 VDD VDD pmos W=0.205u L=0.04u
M24567 U6405/XU1-net6 g2924 VSS VSS nmos W=0.155u L=0.04u
M24568 n5628 n5627 U6405/XU1-net6 VSS nmos W=0.155u L=0.04u
M24569 n5628 g2924 VDD VDD pmos W=0.155u L=0.04u
M24570 n5628 n5627 VDD VDD pmos W=0.155u L=0.04u
M24571 n5627 n5625 VSS VSS nmos W=0.135u L=0.04u
M24572 n5627 n5625 VDD VDD pmos W=0.205u L=0.04u
M24573 U6407/XU1-net6 n5624 VSS VSS nmos W=0.155u L=0.04u
M24574 n5625 g2917 U6407/XU1-net6 VSS nmos W=0.155u L=0.04u
M24575 n5625 n5624 VDD VDD pmos W=0.155u L=0.04u
M24576 n5625 g2917 VDD VDD pmos W=0.155u L=0.04u
M24577 g30970 g2584 U6408/net27 VSS nmos W=0.155u L=0.04u
M24578 U6408/net27 n5630 VSS VSS nmos W=0.155u L=0.04u
M24579 g30970 n5631 VSS VSS nmos W=0.155u L=0.04u
M24580 g30970 n5630 U6408/net13 VDD pmos W=0.205u L=0.04u
M24581 U6408/net13 n5631 VDD VDD pmos W=0.205u L=0.04u
M24582 g30970 g2584 U6408/net13 VDD pmos W=0.205u L=0.04u
M24583 n5631 n5632 U6409/net14 VSS nmos W=0.155u L=0.04u
M24584 U6409/net14 n3919 VSS VSS nmos W=0.155u L=0.04u
M24585 U6409/net14 n5635 VSS VSS nmos W=0.155u L=0.04u
M24586 n5631 n5634 U6409/net14 VSS nmos W=0.155u L=0.04u
M24587 n5631 n5633 U6409/net14 VSS nmos W=0.155u L=0.04u
M24588 n5631 n3919 U6409/XI16-net11 VDD pmos W=0.205u L=0.04u
M24589 U6409/XI16-net11 n5635 VDD VDD pmos W=0.205u L=0.04u
M24590 n5631 n5634 U6409/XI15-net11 VDD pmos W=0.205u L=0.04u
M24591 U6409/XI15-net11 n5633 U6409/XI15-net18 VDD pmos W=0.205u L=0.04u
M24592 U6409/XI15-net18 n5632 VDD VDD pmos W=0.205u L=0.04u
M24593 U6410/net4 n5636 U6410/net14 VSS nmos W=0.155u L=0.04u
M24594 U6410/net6 U6410/net10 U6410/net14 VSS nmos W=0.17u L=0.04u
M24595 U6410/net4 n5637 VSS VSS nmos W=0.155u L=0.04u
M24596 U6410/net6 U6410/net4 VSS VSS nmos W=0.17u L=0.04u
M24597 n5635 U6410/net14 VSS VSS nmos W=0.155u L=0.04u
M24598 U6410/net10 n5636 VSS VSS nmos W=0.155u L=0.04u
M24599 U6410/net4 U6410/net10 U6410/net14 VDD pmos W=0.255u L=0.04u
M24600 U6410/net6 n5636 U6410/net14 VDD pmos W=0.28u L=0.04u
M24601 U6410/net4 n5637 VDD VDD pmos W=0.205u L=0.04u
M24602 U6410/net6 U6410/net4 VDD VDD pmos W=0.24u L=0.04u
M24603 n5635 U6410/net14 VDD VDD pmos W=0.205u L=0.04u
M24604 U6410/net10 n5636 VDD VDD pmos W=0.205u L=0.04u
M24605 U6411/net19 n3937 VSS VSS nmos W=0.155u L=0.04u
M24606 n5632 n3937 U6411/net40 VSS nmos W=0.155u L=0.04u
M24607 n5632 U6411/net19 U6411/net36 VSS nmos W=0.155u L=0.04u
M24608 U6411/net40 g2615 VSS VSS nmos W=0.31u L=0.04u
M24609 U6411/net36 g2612 VSS VSS nmos W=0.155u L=0.04u
M24610 U6411/net19 n3937 VDD VDD pmos W=0.205u L=0.04u
M24611 n5632 U6411/net19 U6411/net26 VDD pmos W=0.325u L=0.04u
M24612 U6411/net26 g2615 VDD VDD pmos W=0.41u L=0.04u
M24613 n5632 n3937 U6411/net30 VDD pmos W=0.325u L=0.04u
M24614 U6411/net30 g2612 VDD VDD pmos W=0.205u L=0.04u
M24615 U6412/net4 U6412/net10 U6412/net14 VSS nmos W=0.155u L=0.04u
M24616 U6412/net6 n5638 U6412/net14 VSS nmos W=0.155u L=0.04u
M24617 U6412/net4 n5639 VSS VSS nmos W=0.155u L=0.04u
M24618 U6412/net6 U6412/net4 VSS VSS nmos W=0.155u L=0.04u
M24619 n5630 U6412/net14 VSS VSS nmos W=0.155u L=0.04u
M24620 U6412/net10 n5638 VSS VSS nmos W=0.155u L=0.04u
M24621 U6412/net4 n5638 U6412/net14 VDD pmos W=0.205u L=0.04u
M24622 U6412/net6 U6412/net10 U6412/net14 VDD pmos W=0.205u L=0.04u
M24623 U6412/net4 n5639 VDD VDD pmos W=0.205u L=0.04u
M24624 U6412/net6 U6412/net4 VDD VDD pmos W=0.205u L=0.04u
M24625 n5630 U6412/net14 VDD VDD pmos W=0.205u L=0.04u
M24626 U6412/net10 n5638 VDD VDD pmos W=0.205u L=0.04u
M24627 U6413/net28 U6413/net20 U6413/net64 VSS nmos W=0.155u L=0.04u
M24628 U6413/net24 U6413/net30 U6413/net32 VSS nmos W=0.155u L=0.04u
M24629 U6413/net28 U6413/net40 U6413/net24 VSS nmos W=0.155u L=0.04u
M24630 U6413/net40 n5643 U6413/net108 VSS nmos W=0.155u L=0.04u
M24631 U6413/net40 U6413/net106 U6413/net104 VSS nmos W=0.155u L=0.04u
M24632 U6413/net24 n5640 U6413/net050 VSS nmos W=0.155u L=0.04u
M24633 U6413/net050 U6413/net32 VSS VSS nmos W=0.155u L=0.04u
M24634 U6413/net20 U6413/net40 VSS VSS nmos W=0.155u L=0.04u
M24635 U6413/net106 n5643 VSS VSS nmos W=0.155u L=0.04u
M24636 U6413/net104 n5642 VSS VSS nmos W=0.155u L=0.04u
M24637 U6413/net30 n5640 VSS VSS nmos W=0.155u L=0.04u
M24638 U6413/net108 U6413/net104 VSS VSS nmos W=0.155u L=0.04u
M24639 n5639 U6413/net28 VSS VSS nmos W=0.155u L=0.04u
M24640 U6413/net32 n5641 VSS VSS nmos W=0.155u L=0.04u
M24641 U6413/net64 U6413/net24 VSS VSS nmos W=0.2u L=0.04u
M24642 U6413/net28 U6413/net40 U6413/net64 VDD pmos W=0.205u L=0.04u
M24643 U6413/net24 n5640 U6413/net32 VDD pmos W=0.205u L=0.04u
M24644 U6413/net28 U6413/net20 U6413/net24 VDD pmos W=0.205u L=0.04u
M24645 U6413/net40 U6413/net106 U6413/net108 VDD pmos W=0.205u L=0.04u
M24646 U6413/net40 n5643 U6413/net104 VDD pmos W=0.205u L=0.04u
M24647 U6413/net20 U6413/net40 VDD VDD pmos W=0.205u L=0.04u
M24648 U6413/net106 n5643 VDD VDD pmos W=0.205u L=0.04u
M24649 U6413/net104 n5642 VDD VDD pmos W=0.205u L=0.04u
M24650 U6413/net30 n5640 VDD VDD pmos W=0.205u L=0.04u
M24651 U6413/net108 U6413/net104 VDD VDD pmos W=0.205u L=0.04u
M24652 n5639 U6413/net28 VDD VDD pmos W=0.205u L=0.04u
M24653 U6413/net32 n5641 VDD VDD pmos W=0.205u L=0.04u
M24654 U6413/net64 U6413/net24 VDD VDD pmos W=0.28u L=0.04u
M24655 U6413/net24 U6413/net30 U6413/net045 VDD pmos W=0.205u L=0.04u
M24656 U6413/net045 U6413/net32 VDD VDD pmos W=0.205u L=0.04u
M24657 U6414/net28 U6414/net20 U6414/net64 VSS nmos W=0.155u L=0.04u
M24658 U6414/net24 U6414/net30 U6414/net32 VSS nmos W=0.155u L=0.04u
M24659 U6414/net28 U6414/net40 U6414/net24 VSS nmos W=0.155u L=0.04u
M24660 U6414/net40 n5647 U6414/net108 VSS nmos W=0.155u L=0.04u
M24661 U6414/net40 U6414/net106 U6414/net104 VSS nmos W=0.155u L=0.04u
M24662 U6414/net24 n5644 U6414/net050 VSS nmos W=0.155u L=0.04u
M24663 U6414/net050 U6414/net32 VSS VSS nmos W=0.155u L=0.04u
M24664 U6414/net20 U6414/net40 VSS VSS nmos W=0.155u L=0.04u
M24665 U6414/net106 n5647 VSS VSS nmos W=0.155u L=0.04u
M24666 U6414/net104 n5646 VSS VSS nmos W=0.155u L=0.04u
M24667 U6414/net30 n5644 VSS VSS nmos W=0.155u L=0.04u
M24668 U6414/net108 U6414/net104 VSS VSS nmos W=0.155u L=0.04u
M24669 n5638 U6414/net28 VSS VSS nmos W=0.155u L=0.04u
M24670 U6414/net32 n5645 VSS VSS nmos W=0.155u L=0.04u
M24671 U6414/net64 U6414/net24 VSS VSS nmos W=0.2u L=0.04u
M24672 U6414/net28 U6414/net40 U6414/net64 VDD pmos W=0.205u L=0.04u
M24673 U6414/net24 n5644 U6414/net32 VDD pmos W=0.205u L=0.04u
M24674 U6414/net28 U6414/net20 U6414/net24 VDD pmos W=0.205u L=0.04u
M24675 U6414/net40 U6414/net106 U6414/net108 VDD pmos W=0.205u L=0.04u
M24676 U6414/net40 n5647 U6414/net104 VDD pmos W=0.205u L=0.04u
M24677 U6414/net20 U6414/net40 VDD VDD pmos W=0.205u L=0.04u
M24678 U6414/net106 n5647 VDD VDD pmos W=0.205u L=0.04u
M24679 U6414/net104 n5646 VDD VDD pmos W=0.205u L=0.04u
M24680 U6414/net30 n5644 VDD VDD pmos W=0.205u L=0.04u
M24681 U6414/net108 U6414/net104 VDD VDD pmos W=0.205u L=0.04u
M24682 n5638 U6414/net28 VDD VDD pmos W=0.205u L=0.04u
M24683 U6414/net32 n5645 VDD VDD pmos W=0.205u L=0.04u
M24684 U6414/net64 U6414/net24 VDD VDD pmos W=0.28u L=0.04u
M24685 U6414/net24 U6414/net30 U6414/net045 VDD pmos W=0.205u L=0.04u
M24686 U6414/net045 U6414/net32 VDD VDD pmos W=0.205u L=0.04u
M24687 g30961 n5648 U6415/net27 VSS nmos W=0.155u L=0.04u
M24688 U6415/net27 n5649 VSS VSS nmos W=0.155u L=0.04u
M24689 g30961 n5650 VSS VSS nmos W=0.155u L=0.04u
M24690 g30961 n5649 U6415/net13 VDD pmos W=0.205u L=0.04u
M24691 U6415/net13 n5650 VDD VDD pmos W=0.205u L=0.04u
M24692 g30961 n5648 U6415/net13 VDD pmos W=0.205u L=0.04u
M24693 U6416/net17 n5633 VSS VSS nmos W=0.155u L=0.04u
M24694 U6416/net17 g2608 VSS VSS nmos W=0.155u L=0.04u
M24695 U6416/net63 n5651 VSS VSS nmos W=0.155u L=0.04u
M24696 n5648 U6416/net17 VSS VSS nmos W=0.155u L=0.04u
M24697 n5648 n5641 U6416/net63 VSS nmos W=0.155u L=0.04u
M24698 n5648 n5651 U6416/net31 VDD pmos W=0.205u L=0.04u
M24699 U6416/net39 n5633 VDD VDD pmos W=0.195u L=0.04u
M24700 U6416/net31 U6416/net17 VDD VDD pmos W=0.195u L=0.04u
M24701 n5648 n5641 U6416/net31 VDD pmos W=0.195u L=0.04u
M24702 U6416/net17 g2608 U6416/net39 VDD pmos W=0.195u L=0.04u
M24703 U6417/net7 n5652 U6417/X_u4-net10 VSS nmos W=0.155u L=0.04u
M24704 U6417/X_u4-net10 n5653 U6417/X_u4-net13 VSS nmos W=0.155u L=0.04u
M24705 U6417/X_u4-net13 n5654 VSS VSS nmos W=0.155u L=0.04u
M24706 n5641 U6417/net7 VSS VSS nmos W=0.155u L=0.04u
M24707 U6417/net7 n5654 VDD VDD pmos W=0.205u L=0.04u
M24708 U6417/net7 n5652 VDD VDD pmos W=0.205u L=0.04u
M24709 U6417/net7 n5653 VDD VDD pmos W=0.205u L=0.04u
M24710 n5641 U6417/net7 VDD VDD pmos W=0.205u L=0.04u
M24711 U6418/net19 n3899 VSS VSS nmos W=0.155u L=0.04u
M24712 n5654 n3899 U6418/net40 VSS nmos W=0.155u L=0.04u
M24713 n5654 U6418/net19 U6418/net36 VSS nmos W=0.155u L=0.04u
M24714 U6418/net40 n3951 VSS VSS nmos W=0.31u L=0.04u
M24715 U6418/net36 n5655 VSS VSS nmos W=0.155u L=0.04u
M24716 U6418/net19 n3899 VDD VDD pmos W=0.205u L=0.04u
M24717 n5654 U6418/net19 U6418/net26 VDD pmos W=0.325u L=0.04u
M24718 U6418/net26 n3951 VDD VDD pmos W=0.41u L=0.04u
M24719 n5654 n3899 U6418/net30 VDD pmos W=0.325u L=0.04u
M24720 U6418/net30 n5655 VDD VDD pmos W=0.205u L=0.04u
M24721 g30960 n5656 U6419/net27 VSS nmos W=0.155u L=0.04u
M24722 U6419/net27 n5649 VSS VSS nmos W=0.155u L=0.04u
M24723 g30960 n5657 VSS VSS nmos W=0.155u L=0.04u
M24724 g30960 n5649 U6419/net13 VDD pmos W=0.205u L=0.04u
M24725 U6419/net13 n5657 VDD VDD pmos W=0.205u L=0.04u
M24726 g30960 n5656 U6419/net13 VDD pmos W=0.205u L=0.04u
M24727 U6420/net17 n5633 VSS VSS nmos W=0.155u L=0.04u
M24728 U6420/net17 g2604 VSS VSS nmos W=0.155u L=0.04u
M24729 U6420/net63 n5651 VSS VSS nmos W=0.155u L=0.04u
M24730 n5656 U6420/net17 VSS VSS nmos W=0.155u L=0.04u
M24731 n5656 n5640 U6420/net63 VSS nmos W=0.155u L=0.04u
M24732 n5656 n5651 U6420/net31 VDD pmos W=0.205u L=0.04u
M24733 U6420/net39 n5633 VDD VDD pmos W=0.195u L=0.04u
M24734 U6420/net31 U6420/net17 VDD VDD pmos W=0.195u L=0.04u
M24735 n5656 n5640 U6420/net31 VDD pmos W=0.195u L=0.04u
M24736 U6420/net17 g2604 U6420/net39 VDD pmos W=0.195u L=0.04u
M24737 n5640 U6421/net6 VSS VSS nmos W=0.155u L=0.04u
M24738 U6421/X_u2-net6 n5652 VSS VSS nmos W=0.155u L=0.04u
M24739 U6421/net6 n5658 U6421/X_u2-net6 VSS nmos W=0.155u L=0.04u
M24740 n5640 U6421/net6 VDD VDD pmos W=0.205u L=0.04u
M24741 U6421/net6 n5652 VDD VDD pmos W=0.205u L=0.04u
M24742 U6421/net6 n5658 VDD VDD pmos W=0.205u L=0.04u
M24743 U6422/net19 n3908 VSS VSS nmos W=0.155u L=0.04u
M24744 n5658 n3908 U6422/net40 VSS nmos W=0.155u L=0.04u
M24745 n5658 U6422/net19 U6422/net36 VSS nmos W=0.155u L=0.04u
M24746 U6422/net40 n5655 VSS VSS nmos W=0.31u L=0.04u
M24747 U6422/net36 n3951 VSS VSS nmos W=0.155u L=0.04u
M24748 U6422/net19 n3908 VDD VDD pmos W=0.205u L=0.04u
M24749 n5658 U6422/net19 U6422/net26 VDD pmos W=0.325u L=0.04u
M24750 U6422/net26 n5655 VDD VDD pmos W=0.41u L=0.04u
M24751 n5658 n3908 U6422/net30 VDD pmos W=0.325u L=0.04u
M24752 U6422/net30 n3951 VDD VDD pmos W=0.205u L=0.04u
M24753 g30959 n5659 U6423/net27 VSS nmos W=0.155u L=0.04u
M24754 U6423/net27 n5649 VSS VSS nmos W=0.155u L=0.04u
M24755 g30959 n5650 VSS VSS nmos W=0.155u L=0.04u
M24756 g30959 n5649 U6423/net13 VDD pmos W=0.205u L=0.04u
M24757 U6423/net13 n5650 VDD VDD pmos W=0.205u L=0.04u
M24758 g30959 n5659 U6423/net13 VDD pmos W=0.205u L=0.04u
M24759 U6424/net17 n5633 VSS VSS nmos W=0.155u L=0.04u
M24760 U6424/net17 g2607 VSS VSS nmos W=0.155u L=0.04u
M24761 U6424/net63 n5651 VSS VSS nmos W=0.155u L=0.04u
M24762 n5659 U6424/net17 VSS VSS nmos W=0.155u L=0.04u
M24763 n5659 n5643 U6424/net63 VSS nmos W=0.155u L=0.04u
M24764 n5659 n5651 U6424/net31 VDD pmos W=0.205u L=0.04u
M24765 U6424/net39 n5633 VDD VDD pmos W=0.195u L=0.04u
M24766 U6424/net31 U6424/net17 VDD VDD pmos W=0.195u L=0.04u
M24767 n5659 n5643 U6424/net31 VDD pmos W=0.195u L=0.04u
M24768 U6424/net17 g2607 U6424/net39 VDD pmos W=0.195u L=0.04u
M24769 U6425/net7 n5652 U6425/X_u4-net10 VSS nmos W=0.155u L=0.04u
M24770 U6425/X_u4-net10 n5660 U6425/X_u4-net13 VSS nmos W=0.155u L=0.04u
M24771 U6425/X_u4-net13 n5661 VSS VSS nmos W=0.155u L=0.04u
M24772 n5643 U6425/net7 VSS VSS nmos W=0.155u L=0.04u
M24773 U6425/net7 n5661 VDD VDD pmos W=0.205u L=0.04u
M24774 U6425/net7 n5652 VDD VDD pmos W=0.205u L=0.04u
M24775 U6425/net7 n5660 VDD VDD pmos W=0.205u L=0.04u
M24776 n5643 U6425/net7 VDD VDD pmos W=0.205u L=0.04u
M24777 U6426/net19 n3903 VSS VSS nmos W=0.155u L=0.04u
M24778 n5661 n3903 U6426/net40 VSS nmos W=0.155u L=0.04u
M24779 n5661 U6426/net19 U6426/net36 VSS nmos W=0.155u L=0.04u
M24780 U6426/net40 n5662 VSS VSS nmos W=0.31u L=0.04u
M24781 U6426/net36 n4477 VSS VSS nmos W=0.155u L=0.04u
M24782 U6426/net19 n3903 VDD VDD pmos W=0.205u L=0.04u
M24783 n5661 U6426/net19 U6426/net26 VDD pmos W=0.325u L=0.04u
M24784 U6426/net26 n5662 VDD VDD pmos W=0.41u L=0.04u
M24785 n5661 n3903 U6426/net30 VDD pmos W=0.325u L=0.04u
M24786 U6426/net30 n4477 VDD VDD pmos W=0.205u L=0.04u
M24787 U6427/net29 n5637 VSS VSS nmos W=0.155u L=0.04u
M24788 g30958 n5664 U6427/net29 VSS nmos W=0.155u L=0.04u
M24789 g30958 n5663 U6427/net23 VSS nmos W=0.155u L=0.04u
M24790 U6427/net23 n5649 VSS VSS nmos W=0.155u L=0.04u
M24791 U6427/net20 n5649 g30958 VDD pmos W=0.205u L=0.04u
M24792 U6427/net20 n5663 g30958 VDD pmos W=0.205u L=0.04u
M24793 VDD n5664 U6427/net20 VDD pmos W=0.205u L=0.04u
M24794 VDD n5637 U6427/net20 VDD pmos W=0.205u L=0.04u
M24795 n5637 n5652 U6428/XI0-net10 VSS nmos W=0.155u L=0.04u
M24796 U6428/XI0-net10 n5653 U6428/XI0-net13 VSS nmos W=0.155u L=0.04u
M24797 U6428/XI0-net13 n5665 VSS VSS nmos W=0.155u L=0.04u
M24798 n5637 n5665 VDD VDD pmos W=0.205u L=0.04u
M24799 n5637 n5652 VDD VDD pmos W=0.205u L=0.04u
M24800 n5637 n5653 VDD VDD pmos W=0.205u L=0.04u
M24801 U6429/net19 n3897 VSS VSS nmos W=0.155u L=0.04u
M24802 n5665 n3897 U6429/net40 VSS nmos W=0.155u L=0.04u
M24803 n5665 U6429/net19 U6429/net36 VSS nmos W=0.155u L=0.04u
M24804 U6429/net40 n3951 VSS VSS nmos W=0.31u L=0.04u
M24805 U6429/net36 n5655 VSS VSS nmos W=0.155u L=0.04u
M24806 U6429/net19 n3897 VDD VDD pmos W=0.205u L=0.04u
M24807 n5665 U6429/net19 U6429/net26 VDD pmos W=0.325u L=0.04u
M24808 U6429/net26 n3951 VDD VDD pmos W=0.41u L=0.04u
M24809 n5665 n3897 U6429/net30 VDD pmos W=0.325u L=0.04u
M24810 U6429/net30 n5655 VDD VDD pmos W=0.205u L=0.04u
M24811 U6430/XU1-net6 n3951 VSS VSS nmos W=0.155u L=0.04u
M24812 n5653 n5666 U6430/XU1-net6 VSS nmos W=0.155u L=0.04u
M24813 n5653 n3951 VDD VDD pmos W=0.155u L=0.04u
M24814 n5653 n5666 VDD VDD pmos W=0.155u L=0.04u
M24815 U6431/net17 n5633 VSS VSS nmos W=0.155u L=0.04u
M24816 U6431/net17 g2611 VSS VSS nmos W=0.155u L=0.04u
M24817 U6431/net63 n5651 VSS VSS nmos W=0.155u L=0.04u
M24818 n5663 U6431/net17 VSS VSS nmos W=0.155u L=0.04u
M24819 n5663 n5642 U6431/net63 VSS nmos W=0.155u L=0.04u
M24820 n5663 n5651 U6431/net31 VDD pmos W=0.205u L=0.04u
M24821 U6431/net39 n5633 VDD VDD pmos W=0.195u L=0.04u
M24822 U6431/net31 U6431/net17 VDD VDD pmos W=0.195u L=0.04u
M24823 n5663 n5642 U6431/net31 VDD pmos W=0.195u L=0.04u
M24824 U6431/net17 g2611 U6431/net39 VDD pmos W=0.195u L=0.04u
M24825 n5642 U6432/net6 VSS VSS nmos W=0.155u L=0.04u
M24826 U6432/X_u2-net6 n5652 VSS VSS nmos W=0.155u L=0.04u
M24827 U6432/net6 n5667 U6432/X_u2-net6 VSS nmos W=0.155u L=0.04u
M24828 n5642 U6432/net6 VDD VDD pmos W=0.205u L=0.04u
M24829 U6432/net6 n5652 VDD VDD pmos W=0.205u L=0.04u
M24830 U6432/net6 n5667 VDD VDD pmos W=0.205u L=0.04u
M24831 U6433/net19 n3913 VSS VSS nmos W=0.155u L=0.04u
M24832 n5667 n3913 U6433/net40 VSS nmos W=0.155u L=0.04u
M24833 n5667 U6433/net19 U6433/net36 VSS nmos W=0.155u L=0.04u
M24834 U6433/net40 n3951 VSS VSS nmos W=0.31u L=0.04u
M24835 U6433/net36 n5655 VSS VSS nmos W=0.155u L=0.04u
M24836 U6433/net19 n3913 VDD VDD pmos W=0.205u L=0.04u
M24837 n5667 U6433/net19 U6433/net26 VDD pmos W=0.325u L=0.04u
M24838 U6433/net26 n3951 VDD VDD pmos W=0.41u L=0.04u
M24839 n5667 n3913 U6433/net30 VDD pmos W=0.325u L=0.04u
M24840 U6433/net30 n5655 VDD VDD pmos W=0.205u L=0.04u
M24841 U6434/net29 n5636 VSS VSS nmos W=0.155u L=0.04u
M24842 g30957 n5664 U6434/net29 VSS nmos W=0.155u L=0.04u
M24843 g30957 n5668 U6434/net23 VSS nmos W=0.155u L=0.04u
M24844 U6434/net23 n5649 VSS VSS nmos W=0.155u L=0.04u
M24845 U6434/net20 n5649 g30957 VDD pmos W=0.205u L=0.04u
M24846 U6434/net20 n5668 g30957 VDD pmos W=0.205u L=0.04u
M24847 VDD n5664 U6434/net20 VDD pmos W=0.205u L=0.04u
M24848 VDD n5636 U6434/net20 VDD pmos W=0.205u L=0.04u
M24849 n5636 n5652 U6435/XI0-net10 VSS nmos W=0.155u L=0.04u
M24850 U6435/XI0-net10 n5660 U6435/XI0-net13 VSS nmos W=0.155u L=0.04u
M24851 U6435/XI0-net13 n5669 VSS VSS nmos W=0.155u L=0.04u
M24852 n5636 n5669 VDD VDD pmos W=0.205u L=0.04u
M24853 n5636 n5652 VDD VDD pmos W=0.205u L=0.04u
M24854 n5636 n5660 VDD VDD pmos W=0.205u L=0.04u
M24855 U6436/net19 n3898 VSS VSS nmos W=0.155u L=0.04u
M24856 n5669 n3898 U6436/net40 VSS nmos W=0.155u L=0.04u
M24857 n5669 U6436/net19 U6436/net36 VSS nmos W=0.155u L=0.04u
M24858 U6436/net40 n4477 VSS VSS nmos W=0.31u L=0.04u
M24859 U6436/net36 n5662 VSS VSS nmos W=0.155u L=0.04u
M24860 U6436/net19 n3898 VDD VDD pmos W=0.205u L=0.04u
M24861 n5669 U6436/net19 U6436/net26 VDD pmos W=0.325u L=0.04u
M24862 U6436/net26 n4477 VDD VDD pmos W=0.41u L=0.04u
M24863 n5669 n3898 U6436/net30 VDD pmos W=0.325u L=0.04u
M24864 U6436/net30 n5662 VDD VDD pmos W=0.205u L=0.04u
M24865 U6437/net17 n5633 VSS VSS nmos W=0.155u L=0.04u
M24866 U6437/net17 g2610 VSS VSS nmos W=0.155u L=0.04u
M24867 U6437/net63 n5651 VSS VSS nmos W=0.155u L=0.04u
M24868 n5668 U6437/net17 VSS VSS nmos W=0.155u L=0.04u
M24869 n5668 n5645 U6437/net63 VSS nmos W=0.155u L=0.04u
M24870 n5668 n5651 U6437/net31 VDD pmos W=0.205u L=0.04u
M24871 U6437/net39 n5633 VDD VDD pmos W=0.195u L=0.04u
M24872 U6437/net31 U6437/net17 VDD VDD pmos W=0.195u L=0.04u
M24873 n5668 n5645 U6437/net31 VDD pmos W=0.195u L=0.04u
M24874 U6437/net17 g2610 U6437/net39 VDD pmos W=0.195u L=0.04u
M24875 U6438/net7 n5652 U6438/X_u4-net10 VSS nmos W=0.155u L=0.04u
M24876 U6438/X_u4-net10 n5660 U6438/X_u4-net13 VSS nmos W=0.155u L=0.04u
M24877 U6438/X_u4-net13 n5670 VSS VSS nmos W=0.155u L=0.04u
M24878 n5645 U6438/net7 VSS VSS nmos W=0.155u L=0.04u
M24879 U6438/net7 n5670 VDD VDD pmos W=0.205u L=0.04u
M24880 U6438/net7 n5652 VDD VDD pmos W=0.205u L=0.04u
M24881 U6438/net7 n5660 VDD VDD pmos W=0.205u L=0.04u
M24882 n5645 U6438/net7 VDD VDD pmos W=0.205u L=0.04u
M24883 U6439/net19 n3902 VSS VSS nmos W=0.155u L=0.04u
M24884 n5670 n3902 U6439/net40 VSS nmos W=0.155u L=0.04u
M24885 n5670 U6439/net19 U6439/net36 VSS nmos W=0.155u L=0.04u
M24886 U6439/net40 n5662 VSS VSS nmos W=0.31u L=0.04u
M24887 U6439/net36 n4477 VSS VSS nmos W=0.155u L=0.04u
M24888 U6439/net19 n3902 VDD VDD pmos W=0.205u L=0.04u
M24889 n5670 U6439/net19 U6439/net26 VDD pmos W=0.325u L=0.04u
M24890 U6439/net26 n5662 VDD VDD pmos W=0.41u L=0.04u
M24891 n5670 n3902 U6439/net30 VDD pmos W=0.325u L=0.04u
M24892 U6439/net30 n4477 VDD VDD pmos W=0.205u L=0.04u
M24893 U6440/XU1-net6 n4477 VSS VSS nmos W=0.155u L=0.04u
M24894 n5660 n5666 U6440/XU1-net6 VSS nmos W=0.155u L=0.04u
M24895 n5660 n4477 VDD VDD pmos W=0.155u L=0.04u
M24896 n5660 n5666 VDD VDD pmos W=0.155u L=0.04u
M24897 g30956 n5671 U6441/net27 VSS nmos W=0.155u L=0.04u
M24898 U6441/net27 n5649 VSS VSS nmos W=0.155u L=0.04u
M24899 g30956 n5672 VSS VSS nmos W=0.155u L=0.04u
M24900 g30956 n5649 U6441/net13 VDD pmos W=0.205u L=0.04u
M24901 U6441/net13 n5672 VDD VDD pmos W=0.205u L=0.04u
M24902 g30956 n5671 U6441/net13 VDD pmos W=0.205u L=0.04u
M24903 U6442/net17 n5633 VSS VSS nmos W=0.155u L=0.04u
M24904 U6442/net17 g2606 VSS VSS nmos W=0.155u L=0.04u
M24905 U6442/net63 n5651 VSS VSS nmos W=0.155u L=0.04u
M24906 n5671 U6442/net17 VSS VSS nmos W=0.155u L=0.04u
M24907 n5671 n5644 U6442/net63 VSS nmos W=0.155u L=0.04u
M24908 n5671 n5651 U6442/net31 VDD pmos W=0.205u L=0.04u
M24909 U6442/net39 n5633 VDD VDD pmos W=0.195u L=0.04u
M24910 U6442/net31 U6442/net17 VDD VDD pmos W=0.195u L=0.04u
M24911 n5671 n5644 U6442/net31 VDD pmos W=0.195u L=0.04u
M24912 U6442/net17 g2606 U6442/net39 VDD pmos W=0.195u L=0.04u
M24913 n5644 U6443/net6 VSS VSS nmos W=0.155u L=0.04u
M24914 U6443/X_u2-net6 n5652 VSS VSS nmos W=0.155u L=0.04u
M24915 U6443/net6 n5673 U6443/X_u2-net6 VSS nmos W=0.155u L=0.04u
M24916 n5644 U6443/net6 VDD VDD pmos W=0.205u L=0.04u
M24917 U6443/net6 n5652 VDD VDD pmos W=0.205u L=0.04u
M24918 U6443/net6 n5673 VDD VDD pmos W=0.205u L=0.04u
M24919 U6444/net19 n3910 VSS VSS nmos W=0.155u L=0.04u
M24920 n5673 n3910 U6444/net40 VSS nmos W=0.155u L=0.04u
M24921 n5673 U6444/net19 U6444/net36 VSS nmos W=0.155u L=0.04u
M24922 U6444/net40 n3951 VSS VSS nmos W=0.31u L=0.04u
M24923 U6444/net36 n5655 VSS VSS nmos W=0.155u L=0.04u
M24924 U6444/net19 n3910 VDD VDD pmos W=0.205u L=0.04u
M24925 n5673 U6444/net19 U6444/net26 VDD pmos W=0.325u L=0.04u
M24926 U6444/net26 n3951 VDD VDD pmos W=0.41u L=0.04u
M24927 n5673 n3910 U6444/net30 VDD pmos W=0.325u L=0.04u
M24928 U6444/net30 n5655 VDD VDD pmos W=0.205u L=0.04u
M24929 n5655 n3951 VSS VSS nmos W=0.155u L=0.04u
M24930 n5655 n5666 VSS VSS nmos W=0.155u L=0.04u
M24931 U6445/XI1-net8 n5666 VDD VDD pmos W=0.205u L=0.04u
M24932 n5655 n3951 U6445/XI1-net8 VDD pmos W=0.205u L=0.04u
M24933 n3951 n3930 VSS VSS nmos W=0.135u L=0.04u
M24934 n3951 n3930 VDD VDD pmos W=0.205u L=0.04u
M24935 n3930 g2624 U6447/XI21-net17 VSS nmos W=0.155u L=0.04u
M24936 U6447/XI21-net17 g2694 VSS VSS nmos W=0.155u L=0.04u
M24937 n3930 g7302 U6447/XI6-net17 VSS nmos W=0.155u L=0.04u
M24938 U6447/XI6-net17 g2688 VSS VSS nmos W=0.155u L=0.04u
M24939 n3930 g7390 U6447/XI20-net17 VSS nmos W=0.155u L=0.04u
M24940 U6447/XI20-net17 g2691 VSS VSS nmos W=0.155u L=0.04u
M24941 VDD g2624 U6447/net22 VDD pmos W=0.205u L=0.04u
M24942 VDD g2694 U6447/net22 VDD pmos W=0.205u L=0.04u
M24943 U6447/net16 g7302 n3930 VDD pmos W=0.205u L=0.04u
M24944 U6447/net16 g2688 n3930 VDD pmos W=0.205u L=0.04u
M24945 U6447/net22 g7390 U6447/net16 VDD pmos W=0.205u L=0.04u
M24946 U6447/net22 g2691 U6447/net16 VDD pmos W=0.205u L=0.04u
M24947 g30955 n5674 U6448/net27 VSS nmos W=0.155u L=0.04u
M24948 U6448/net27 n5649 VSS VSS nmos W=0.155u L=0.04u
M24949 g30955 n5672 VSS VSS nmos W=0.155u L=0.04u
M24950 g30955 n5649 U6448/net13 VDD pmos W=0.205u L=0.04u
M24951 U6448/net13 n5672 VDD VDD pmos W=0.205u L=0.04u
M24952 g30955 n5674 U6448/net13 VDD pmos W=0.205u L=0.04u
M24953 U6449/XU35-net6 n5664 VSS VSS nmos W=0.155u L=0.04u
M24954 U6449/net5 n5675 U6449/XU35-net6 VSS nmos W=0.155u L=0.04u
M24955 U6449/XU36-net6 U6449/net5 VSS VSS nmos W=0.155u L=0.04u
M24956 n5672 n5676 U6449/XU36-net6 VSS nmos W=0.155u L=0.04u
M24957 U6449/net5 n5664 VDD VDD pmos W=0.205u L=0.04u
M24958 U6449/net5 n5675 VDD VDD pmos W=0.205u L=0.04u
M24959 n5672 U6449/net5 VDD VDD pmos W=0.205u L=0.04u
M24960 n5672 n5676 VDD VDD pmos W=0.205u L=0.04u
M24961 U6450/net17 n5633 VSS VSS nmos W=0.155u L=0.04u
M24962 U6450/net17 g2603 VSS VSS nmos W=0.155u L=0.04u
M24963 U6450/net63 n5651 VSS VSS nmos W=0.155u L=0.04u
M24964 n5674 U6450/net17 VSS VSS nmos W=0.155u L=0.04u
M24965 n5674 n5647 U6450/net63 VSS nmos W=0.155u L=0.04u
M24966 n5674 n5651 U6450/net31 VDD pmos W=0.205u L=0.04u
M24967 U6450/net39 n5633 VDD VDD pmos W=0.195u L=0.04u
M24968 U6450/net31 U6450/net17 VDD VDD pmos W=0.195u L=0.04u
M24969 n5674 n5647 U6450/net31 VDD pmos W=0.195u L=0.04u
M24970 U6450/net17 g2603 U6450/net39 VDD pmos W=0.195u L=0.04u
M24971 n5647 U6451/net6 VSS VSS nmos W=0.155u L=0.04u
M24972 U6451/X_u2-net6 n5652 VSS VSS nmos W=0.155u L=0.04u
M24973 U6451/net6 n5677 U6451/X_u2-net6 VSS nmos W=0.155u L=0.04u
M24974 n5647 U6451/net6 VDD VDD pmos W=0.205u L=0.04u
M24975 U6451/net6 n5652 VDD VDD pmos W=0.205u L=0.04u
M24976 U6451/net6 n5677 VDD VDD pmos W=0.205u L=0.04u
M24977 U6452/net19 n3909 VSS VSS nmos W=0.155u L=0.04u
M24978 n5677 n3909 U6452/net40 VSS nmos W=0.155u L=0.04u
M24979 n5677 U6452/net19 U6452/net36 VSS nmos W=0.155u L=0.04u
M24980 U6452/net40 n5662 VSS VSS nmos W=0.31u L=0.04u
M24981 U6452/net36 n4477 VSS VSS nmos W=0.155u L=0.04u
M24982 U6452/net19 n3909 VDD VDD pmos W=0.205u L=0.04u
M24983 n5677 U6452/net19 U6452/net26 VDD pmos W=0.325u L=0.04u
M24984 U6452/net26 n5662 VDD VDD pmos W=0.41u L=0.04u
M24985 n5677 n3909 U6452/net30 VDD pmos W=0.325u L=0.04u
M24986 U6452/net30 n4477 VDD VDD pmos W=0.205u L=0.04u
M24987 g30954 n5678 U6453/net27 VSS nmos W=0.155u L=0.04u
M24988 U6453/net27 n5649 VSS VSS nmos W=0.155u L=0.04u
M24989 g30954 n5657 VSS VSS nmos W=0.155u L=0.04u
M24990 g30954 n5649 U6453/net13 VDD pmos W=0.205u L=0.04u
M24991 U6453/net13 n5657 VDD VDD pmos W=0.205u L=0.04u
M24992 g30954 n5678 U6453/net13 VDD pmos W=0.205u L=0.04u
M24993 n5657 n5679 U6454/net15 VSS nmos W=0.155u L=0.04u
M24994 n5657 n5675 U6454/net15 VSS nmos W=0.155u L=0.04u
M24995 U6454/net15 n5676 VSS VSS nmos W=0.155u L=0.04u
M24996 n5657 n5676 VDD VDD pmos W=0.205u L=0.04u
M24997 n5657 n5679 U6454/XI16-net11 VDD pmos W=0.205u L=0.04u
M24998 U6454/XI16-net11 n5675 VDD VDD pmos W=0.205u L=0.04u
M24999 n5676 n5650 VSS VSS nmos W=0.135u L=0.04u
M25000 n5676 n5650 VDD VDD pmos W=0.205u L=0.04u
M25001 n5650 n5679 VSS VSS nmos W=0.155u L=0.04u
M25002 n5650 n5680 VSS VSS nmos W=0.155u L=0.04u
M25003 U6456/XI1-net8 n5680 VDD VDD pmos W=0.205u L=0.04u
M25004 n5650 n5679 U6456/XI1-net8 VDD pmos W=0.205u L=0.04u
M25005 VSS g2574 U6457/net22 VSS nmos W=0.155u L=0.04u
M25006 U6457/net22 n5682 n5675 VSS nmos W=0.155u L=0.04u
M25007 U6457/net22 n5666 n5675 VSS nmos W=0.155u L=0.04u
M25008 U6457/net22 n5681 n5675 VSS nmos W=0.155u L=0.04u
M25009 U6457/net38 n5681 VDD VDD pmos W=0.205u L=0.04u
M25010 U6457/net35 n5666 U6457/net38 VDD pmos W=0.205u L=0.04u
M25011 n5675 n5682 U6457/net35 VDD pmos W=0.205u L=0.04u
M25012 n5675 g2574 VDD VDD pmos W=0.205u L=0.04u
M25013 n5682 g2808 VSS VSS nmos W=0.155u L=0.04u
M25014 n5682 n3853 VSS VSS nmos W=0.155u L=0.04u
M25015 U6458/XI1-net8 n3853 VDD VDD pmos W=0.205u L=0.04u
M25016 n5682 g2808 U6458/XI1-net8 VDD pmos W=0.205u L=0.04u
M25017 n5681 g2809 U6459/net10 VSS nmos W=0.155u L=0.04u
M25018 U6459/net10 n3916 VSS VSS nmos W=0.155u L=0.04u
M25019 n5681 n3886 U6459/net10 VSS nmos W=0.155u L=0.04u
M25020 U6459/net10 g2810 VSS VSS nmos W=0.155u L=0.04u
M25021 U6459/net30 n3916 VDD VDD pmos W=0.205u L=0.04u
M25022 n5681 g2809 U6459/net24 VDD pmos W=0.205u L=0.04u
M25023 U6459/net24 n3886 VDD VDD pmos W=0.205u L=0.04u
M25024 n5681 g2810 U6459/net30 VDD pmos W=0.205u L=0.04u
M25025 n5679 n5664 VSS VSS nmos W=0.135u L=0.04u
M25026 n5679 n5664 VDD VDD pmos W=0.205u L=0.04u
M25027 n5664 n5651 VSS VSS nmos W=0.155u L=0.04u
M25028 n5664 n5649 VSS VSS nmos W=0.155u L=0.04u
M25029 U6461/XI1-net8 n5649 VDD VDD pmos W=0.205u L=0.04u
M25030 n5664 n5651 U6461/XI1-net8 VDD pmos W=0.205u L=0.04u
M25031 n5649 n5634 VSS VSS nmos W=0.135u L=0.04u
M25032 n5649 n5634 VDD VDD pmos W=0.205u L=0.04u
M25033 n5634 g2584 U6463/net15 VSS nmos W=0.155u L=0.04u
M25034 n5634 g2599 U6463/net15 VSS nmos W=0.155u L=0.04u
M25035 U6463/net15 n3919 VSS VSS nmos W=0.155u L=0.04u
M25036 n5634 n3919 VDD VDD pmos W=0.205u L=0.04u
M25037 n5634 g2584 U6463/XI16-net11 VDD pmos W=0.205u L=0.04u
M25038 U6463/XI16-net11 g2599 VDD VDD pmos W=0.205u L=0.04u
M25039 n3919 g2631 VSS VSS nmos W=0.135u L=0.04u
M25040 n3919 g2631 VDD VDD pmos W=0.205u L=0.04u
M25041 U6465/net17 n5633 VSS VSS nmos W=0.155u L=0.04u
M25042 U6465/net17 g2605 VSS VSS nmos W=0.155u L=0.04u
M25043 U6465/net63 n5651 VSS VSS nmos W=0.155u L=0.04u
M25044 n5678 U6465/net17 VSS VSS nmos W=0.155u L=0.04u
M25045 n5678 n5646 U6465/net63 VSS nmos W=0.155u L=0.04u
M25046 n5678 n5651 U6465/net31 VDD pmos W=0.205u L=0.04u
M25047 U6465/net39 n5633 VDD VDD pmos W=0.195u L=0.04u
M25048 U6465/net31 U6465/net17 VDD VDD pmos W=0.195u L=0.04u
M25049 n5678 n5646 U6465/net31 VDD pmos W=0.195u L=0.04u
M25050 U6465/net17 g2605 U6465/net39 VDD pmos W=0.195u L=0.04u
M25051 U6466/XU1-net6 n5683 VSS VSS nmos W=0.155u L=0.04u
M25052 n5633 n5680 U6466/XU1-net6 VSS nmos W=0.155u L=0.04u
M25053 n5633 n5683 VDD VDD pmos W=0.155u L=0.04u
M25054 n5633 n5680 VDD VDD pmos W=0.155u L=0.04u
M25055 n5651 n5683 VSS VSS nmos W=0.135u L=0.04u
M25056 n5651 n5683 VDD VDD pmos W=0.205u L=0.04u
M25057 U6468/net11 g2599 VSS VSS nmos W=0.155u L=0.04u
M25058 U6468/net11 g2631 VSS VSS nmos W=0.155u L=0.04u
M25059 n5683 g2584 VSS VSS nmos W=0.155u L=0.04u
M25060 n5683 U6468/net11 VSS VSS nmos W=0.155u L=0.04u
M25061 U6468/XI1-net8 g2631 VDD VDD pmos W=0.205u L=0.04u
M25062 U6468/net11 g2599 U6468/XI1-net8 VDD pmos W=0.205u L=0.04u
M25063 U6468/XU39-net8 U6468/net11 VDD VDD pmos W=0.205u L=0.04u
M25064 n5683 g2584 U6468/XU39-net8 VDD pmos W=0.205u L=0.04u
M25065 n5646 U6469/net6 VSS VSS nmos W=0.155u L=0.04u
M25066 U6469/X_u2-net6 n5652 VSS VSS nmos W=0.155u L=0.04u
M25067 U6469/net6 n5684 U6469/X_u2-net6 VSS nmos W=0.155u L=0.04u
M25068 n5646 U6469/net6 VDD VDD pmos W=0.205u L=0.04u
M25069 U6469/net6 n5652 VDD VDD pmos W=0.205u L=0.04u
M25070 U6469/net6 n5684 VDD VDD pmos W=0.205u L=0.04u
M25071 n5652 II15517 VSS VSS nmos W=0.155u L=0.04u
M25072 n5652 U6470/net4 VSS VSS nmos W=0.155u L=0.04u
M25073 U6470/net4 n5680 VSS VSS nmos W=0.155u L=0.04u
M25074 U6470/XU1-net8 U6470/net4 VDD VDD pmos W=0.205u L=0.04u
M25075 n5652 II15517 U6470/XU1-net8 VDD pmos W=0.205u L=0.04u
M25076 U6470/net4 n5680 VDD VDD pmos W=0.205u L=0.04u
M25077 n5680 n4520 VSS VSS nmos W=0.155u L=0.04u
M25078 n5680 g2633 VSS VSS nmos W=0.155u L=0.04u
M25079 n5680 g2637 VSS VSS nmos W=0.155u L=0.04u
M25080 U6471/net25 n4520 VDD VDD pmos W=0.41u L=0.04u
M25081 U6471/net28 g2633 U6471/net25 VDD pmos W=0.41u L=0.04u
M25082 n5680 g2637 U6471/net28 VDD pmos W=0.41u L=0.04u
M25083 n4520 n3396 VSS VSS nmos W=0.135u L=0.04u
M25084 n4520 n3396 VDD VDD pmos W=0.205u L=0.04u
M25085 U6473/PG2 g2618 VSS VSS nmos W=0.31u L=0.04u
M25086 U6473/net55 n4519 VSS VSS nmos W=0.31u L=0.04u
M25087 U6473/net51 g7302 VSS VSS nmos W=0.155u L=0.04u
M25088 U6473/net53 g2622 VSS VSS nmos W=0.155u L=0.04u
M25089 U6473/net29 g2574 VSS VSS nmos W=0.155u L=0.04u
M25090 U6473/net53 U6473/net51 U6473/PG1 VSS nmos W=0.155u L=0.04u
M25091 U6473/net55 g7302 U6473/PG1 VSS nmos W=0.21u L=0.04u
M25092 U6473/PG2 g2574 n3396 VSS nmos W=0.22u L=0.04u
M25093 U6473/PG1 U6473/net29 n3396 VSS nmos W=0.155u L=0.04u
M25094 U6473/PG2 g2618 VDD VDD pmos W=0.41u L=0.04u
M25095 U6473/net55 n4519 VDD VDD pmos W=0.41u L=0.04u
M25096 U6473/net51 g7302 VDD VDD pmos W=0.205u L=0.04u
M25097 U6473/net53 g2622 VDD VDD pmos W=0.28u L=0.04u
M25098 U6473/net29 g2574 VDD VDD pmos W=0.205u L=0.04u
M25099 U6473/net53 g7302 U6473/PG1 VDD pmos W=0.27u L=0.04u
M25100 U6473/net55 U6473/net51 U6473/PG1 VDD pmos W=0.285u L=0.04u
M25101 U6473/PG2 U6473/net29 n3396 VDD pmos W=0.205u L=0.04u
M25102 U6473/PG1 g2574 n3396 VDD pmos W=0.28u L=0.04u
M25103 U6474/net19 n3914 VSS VSS nmos W=0.155u L=0.04u
M25104 n5684 n3914 U6474/net40 VSS nmos W=0.155u L=0.04u
M25105 n5684 U6474/net19 U6474/net36 VSS nmos W=0.155u L=0.04u
M25106 U6474/net40 n4477 VSS VSS nmos W=0.31u L=0.04u
M25107 U6474/net36 n5662 VSS VSS nmos W=0.155u L=0.04u
M25108 U6474/net19 n3914 VDD VDD pmos W=0.205u L=0.04u
M25109 n5684 U6474/net19 U6474/net26 VDD pmos W=0.325u L=0.04u
M25110 U6474/net26 n4477 VDD VDD pmos W=0.41u L=0.04u
M25111 n5684 n3914 U6474/net30 VDD pmos W=0.325u L=0.04u
M25112 U6474/net30 n5662 VDD VDD pmos W=0.205u L=0.04u
M25113 n5662 n4477 VSS VSS nmos W=0.155u L=0.04u
M25114 n5662 n5666 VSS VSS nmos W=0.155u L=0.04u
M25115 U6475/XI1-net8 n5666 VDD VDD pmos W=0.205u L=0.04u
M25116 n5662 n4477 U6475/XI1-net8 VDD pmos W=0.205u L=0.04u
M25117 n5666 U6476/net6 VSS VSS nmos W=0.155u L=0.04u
M25118 U6476/X_u2-net6 n5686 VSS VSS nmos W=0.155u L=0.04u
M25119 U6476/net6 n5685 U6476/X_u2-net6 VSS nmos W=0.155u L=0.04u
M25120 n5666 U6476/net6 VDD VDD pmos W=0.205u L=0.04u
M25121 U6476/net6 n5686 VDD VDD pmos W=0.205u L=0.04u
M25122 U6476/net6 n5685 VDD VDD pmos W=0.205u L=0.04u
M25123 n5686 n3899 VSS VSS nmos W=0.155u L=0.04u
M25124 n5686 n3898 VSS VSS nmos W=0.155u L=0.04u
M25125 n5686 n3897 VSS VSS nmos W=0.155u L=0.04u
M25126 n5686 n5687 VSS VSS nmos W=0.155u L=0.04u
M25127 U6477/net49 n3898 U6477/net52 VDD pmos W=0.41u L=0.04u
M25128 U6477/net52 n3899 VDD VDD pmos W=0.41u L=0.04u
M25129 U6477/net46 n3897 U6477/net49 VDD pmos W=0.41u L=0.04u
M25130 n5686 n5687 U6477/net46 VDD pmos W=0.41u L=0.04u
M25131 U6478/net36 n3886 U6478/net27 VSS nmos W=0.155u L=0.04u
M25132 U6478/net39 n3916 VSS VSS nmos W=0.155u L=0.04u
M25133 U6478/net27 g2778 U6478/net39 VSS nmos W=0.155u L=0.04u
M25134 U6478/net27 n3853 U6478/net39 VSS nmos W=0.155u L=0.04u
M25135 U6478/net36 g2779 U6478/net27 VSS nmos W=0.155u L=0.04u
M25136 U6478/net39 g2780 VSS VSS nmos W=0.155u L=0.04u
M25137 n3899 U6478/net36 VSS VSS nmos W=0.155u L=0.04u
M25138 n3899 U6478/net36 VDD VDD pmos W=0.205u L=0.04u
M25139 U6478/net36 n3916 U6478/net46 VDD pmos W=0.205u L=0.04u
M25140 U6478/net46 g2780 VDD VDD pmos W=0.205u L=0.04u
M25141 U6478/net36 g2779 U6478/net34 VDD pmos W=0.205u L=0.04u
M25142 U6478/net34 n3886 VDD VDD pmos W=0.205u L=0.04u
M25143 U6478/net36 n3853 U6478/net37 VDD pmos W=0.205u L=0.04u
M25144 U6478/net37 g2778 VDD VDD pmos W=0.205u L=0.04u
M25145 U6479/net36 n3886 U6479/net27 VSS nmos W=0.155u L=0.04u
M25146 U6479/net39 n3916 VSS VSS nmos W=0.155u L=0.04u
M25147 U6479/net27 g2799 U6479/net39 VSS nmos W=0.155u L=0.04u
M25148 U6479/net27 n3853 U6479/net39 VSS nmos W=0.155u L=0.04u
M25149 U6479/net36 g2800 U6479/net27 VSS nmos W=0.155u L=0.04u
M25150 U6479/net39 g2801 VSS VSS nmos W=0.155u L=0.04u
M25151 n3898 U6479/net36 VSS VSS nmos W=0.155u L=0.04u
M25152 n3898 U6479/net36 VDD VDD pmos W=0.205u L=0.04u
M25153 U6479/net36 n3916 U6479/net46 VDD pmos W=0.205u L=0.04u
M25154 U6479/net46 g2801 VDD VDD pmos W=0.205u L=0.04u
M25155 U6479/net36 g2800 U6479/net34 VDD pmos W=0.205u L=0.04u
M25156 U6479/net34 n3886 VDD VDD pmos W=0.205u L=0.04u
M25157 U6479/net36 n3853 U6479/net37 VDD pmos W=0.205u L=0.04u
M25158 U6479/net37 g2799 VDD VDD pmos W=0.205u L=0.04u
M25159 U6480/net36 n3886 U6480/net27 VSS nmos W=0.155u L=0.04u
M25160 U6480/net39 n3916 VSS VSS nmos W=0.155u L=0.04u
M25161 U6480/net27 g2796 U6480/net39 VSS nmos W=0.155u L=0.04u
M25162 U6480/net27 n3853 U6480/net39 VSS nmos W=0.155u L=0.04u
M25163 U6480/net36 g2797 U6480/net27 VSS nmos W=0.155u L=0.04u
M25164 U6480/net39 g2798 VSS VSS nmos W=0.155u L=0.04u
M25165 n3897 U6480/net36 VSS VSS nmos W=0.155u L=0.04u
M25166 n3897 U6480/net36 VDD VDD pmos W=0.205u L=0.04u
M25167 U6480/net36 n3916 U6480/net46 VDD pmos W=0.205u L=0.04u
M25168 U6480/net46 g2798 VDD VDD pmos W=0.205u L=0.04u
M25169 U6480/net36 g2797 U6480/net34 VDD pmos W=0.205u L=0.04u
M25170 U6480/net34 n3886 VDD VDD pmos W=0.205u L=0.04u
M25171 U6480/net36 n3853 U6480/net37 VDD pmos W=0.205u L=0.04u
M25172 U6480/net37 g2796 VDD VDD pmos W=0.205u L=0.04u
M25173 n5687 n3903 U6481/XI0-net10 VSS nmos W=0.155u L=0.04u
M25174 U6481/XI0-net10 n3915 U6481/XI0-net13 VSS nmos W=0.155u L=0.04u
M25175 U6481/XI0-net13 n3902 VSS VSS nmos W=0.155u L=0.04u
M25176 n5687 n3902 VDD VDD pmos W=0.205u L=0.04u
M25177 n5687 n3903 VDD VDD pmos W=0.205u L=0.04u
M25178 n5687 n3915 VDD VDD pmos W=0.205u L=0.04u
M25179 n3902 n3886 U6482/net27 VSS nmos W=0.155u L=0.04u
M25180 U6482/net39 n3916 VSS VSS nmos W=0.155u L=0.04u
M25181 U6482/net27 g2775 U6482/net39 VSS nmos W=0.155u L=0.04u
M25182 U6482/net27 n3853 U6482/net39 VSS nmos W=0.155u L=0.04u
M25183 n3902 g2776 U6482/net27 VSS nmos W=0.155u L=0.04u
M25184 U6482/net39 g2777 VSS VSS nmos W=0.155u L=0.04u
M25185 n3902 n3916 U6482/net46 VDD pmos W=0.205u L=0.04u
M25186 U6482/net46 g2777 VDD VDD pmos W=0.205u L=0.04u
M25187 n3902 g2776 U6482/net34 VDD pmos W=0.205u L=0.04u
M25188 U6482/net34 n3886 VDD VDD pmos W=0.205u L=0.04u
M25189 n3902 n3853 U6482/net37 VDD pmos W=0.205u L=0.04u
M25190 U6482/net37 g2775 VDD VDD pmos W=0.205u L=0.04u
M25191 n3915 n3886 U6483/net27 VSS nmos W=0.155u L=0.04u
M25192 U6483/net39 n3916 VSS VSS nmos W=0.155u L=0.04u
M25193 U6483/net27 g2805 U6483/net39 VSS nmos W=0.155u L=0.04u
M25194 U6483/net27 n3853 U6483/net39 VSS nmos W=0.155u L=0.04u
M25195 n3915 g2806 U6483/net27 VSS nmos W=0.155u L=0.04u
M25196 U6483/net39 g2807 VSS VSS nmos W=0.155u L=0.04u
M25197 n3915 n3916 U6483/net46 VDD pmos W=0.205u L=0.04u
M25198 U6483/net46 g2807 VDD VDD pmos W=0.205u L=0.04u
M25199 n3915 g2806 U6483/net34 VDD pmos W=0.205u L=0.04u
M25200 U6483/net34 n3886 VDD VDD pmos W=0.205u L=0.04u
M25201 n3915 n3853 U6483/net37 VDD pmos W=0.205u L=0.04u
M25202 U6483/net37 g2805 VDD VDD pmos W=0.205u L=0.04u
M25203 n3903 n3886 U6484/net27 VSS nmos W=0.155u L=0.04u
M25204 U6484/net39 n3916 VSS VSS nmos W=0.155u L=0.04u
M25205 U6484/net27 g2781 U6484/net39 VSS nmos W=0.155u L=0.04u
M25206 U6484/net27 n3853 U6484/net39 VSS nmos W=0.155u L=0.04u
M25207 n3903 g2782 U6484/net27 VSS nmos W=0.155u L=0.04u
M25208 U6484/net39 g2783 VSS VSS nmos W=0.155u L=0.04u
M25209 n3903 n3916 U6484/net46 VDD pmos W=0.205u L=0.04u
M25210 U6484/net46 g2783 VDD VDD pmos W=0.205u L=0.04u
M25211 n3903 g2782 U6484/net34 VDD pmos W=0.205u L=0.04u
M25212 U6484/net34 n3886 VDD VDD pmos W=0.205u L=0.04u
M25213 n3903 n3853 U6484/net37 VDD pmos W=0.205u L=0.04u
M25214 U6484/net37 g2781 VDD VDD pmos W=0.205u L=0.04u
M25215 n5685 n3909 VSS VSS nmos W=0.155u L=0.04u
M25216 n5685 n5689 VSS VSS nmos W=0.155u L=0.04u
M25217 n5685 n3908 VSS VSS nmos W=0.155u L=0.04u
M25218 n5685 n5688 VSS VSS nmos W=0.155u L=0.04u
M25219 U6485/net49 n5689 U6485/net52 VDD pmos W=0.41u L=0.04u
M25220 U6485/net52 n3909 VDD VDD pmos W=0.41u L=0.04u
M25221 U6485/net46 n3908 U6485/net49 VDD pmos W=0.41u L=0.04u
M25222 n5685 n5688 U6485/net46 VDD pmos W=0.41u L=0.04u
M25223 n3909 n3886 U6486/net27 VSS nmos W=0.155u L=0.04u
M25224 U6486/net39 n3916 VSS VSS nmos W=0.155u L=0.04u
M25225 U6486/net27 g2793 U6486/net39 VSS nmos W=0.155u L=0.04u
M25226 U6486/net27 n3853 U6486/net39 VSS nmos W=0.155u L=0.04u
M25227 n3909 g2794 U6486/net27 VSS nmos W=0.155u L=0.04u
M25228 U6486/net39 g2795 VSS VSS nmos W=0.155u L=0.04u
M25229 n3909 n3916 U6486/net46 VDD pmos W=0.205u L=0.04u
M25230 U6486/net46 g2795 VDD VDD pmos W=0.205u L=0.04u
M25231 n3909 g2794 U6486/net34 VDD pmos W=0.205u L=0.04u
M25232 U6486/net34 n3886 VDD VDD pmos W=0.205u L=0.04u
M25233 n3909 n3853 U6486/net37 VDD pmos W=0.205u L=0.04u
M25234 U6486/net37 g2793 VDD VDD pmos W=0.205u L=0.04u
M25235 U6487/net36 g2813 U6487/net27 VSS nmos W=0.155u L=0.04u
M25236 U6487/net39 g2812 VSS VSS nmos W=0.155u L=0.04u
M25237 U6487/net27 n3853 U6487/net39 VSS nmos W=0.155u L=0.04u
M25238 U6487/net27 g2811 U6487/net39 VSS nmos W=0.155u L=0.04u
M25239 U6487/net36 n3916 U6487/net27 VSS nmos W=0.155u L=0.04u
M25240 U6487/net39 n3886 VSS VSS nmos W=0.155u L=0.04u
M25241 n5689 U6487/net36 VSS VSS nmos W=0.155u L=0.04u
M25242 n5689 U6487/net36 VDD VDD pmos W=0.205u L=0.04u
M25243 U6487/net36 g2812 U6487/net46 VDD pmos W=0.205u L=0.04u
M25244 U6487/net46 n3886 VDD VDD pmos W=0.205u L=0.04u
M25245 U6487/net36 n3916 U6487/net34 VDD pmos W=0.205u L=0.04u
M25246 U6487/net34 g2813 VDD VDD pmos W=0.205u L=0.04u
M25247 U6487/net36 g2811 U6487/net37 VDD pmos W=0.205u L=0.04u
M25248 U6487/net37 n3853 VDD VDD pmos W=0.205u L=0.04u
M25249 n3908 n3886 U6488/net27 VSS nmos W=0.155u L=0.04u
M25250 U6488/net39 n3916 VSS VSS nmos W=0.155u L=0.04u
M25251 U6488/net27 g2790 U6488/net39 VSS nmos W=0.155u L=0.04u
M25252 U6488/net27 n3853 U6488/net39 VSS nmos W=0.155u L=0.04u
M25253 n3908 g2791 U6488/net27 VSS nmos W=0.155u L=0.04u
M25254 U6488/net39 g2792 VSS VSS nmos W=0.155u L=0.04u
M25255 n3908 n3916 U6488/net46 VDD pmos W=0.205u L=0.04u
M25256 U6488/net46 g2792 VDD VDD pmos W=0.205u L=0.04u
M25257 n3908 g2791 U6488/net34 VDD pmos W=0.205u L=0.04u
M25258 U6488/net34 n3886 VDD VDD pmos W=0.205u L=0.04u
M25259 n3908 n3853 U6488/net37 VDD pmos W=0.205u L=0.04u
M25260 U6488/net37 g2790 VDD VDD pmos W=0.205u L=0.04u
M25261 n5688 n3913 U6489/XI0-net10 VSS nmos W=0.155u L=0.04u
M25262 U6489/XI0-net10 n3910 U6489/XI0-net13 VSS nmos W=0.155u L=0.04u
M25263 U6489/XI0-net13 n3914 VSS VSS nmos W=0.155u L=0.04u
M25264 n5688 n3914 VDD VDD pmos W=0.205u L=0.04u
M25265 n5688 n3913 VDD VDD pmos W=0.205u L=0.04u
M25266 n5688 n3910 VDD VDD pmos W=0.205u L=0.04u
M25267 U6490/net36 n3886 U6490/net27 VSS nmos W=0.155u L=0.04u
M25268 U6490/net39 n3916 VSS VSS nmos W=0.155u L=0.04u
M25269 U6490/net27 g2787 U6490/net39 VSS nmos W=0.155u L=0.04u
M25270 U6490/net27 n3853 U6490/net39 VSS nmos W=0.155u L=0.04u
M25271 U6490/net36 g2788 U6490/net27 VSS nmos W=0.155u L=0.04u
M25272 U6490/net39 g2789 VSS VSS nmos W=0.155u L=0.04u
M25273 n3914 U6490/net36 VSS VSS nmos W=0.155u L=0.04u
M25274 n3914 U6490/net36 VDD VDD pmos W=0.205u L=0.04u
M25275 U6490/net36 n3916 U6490/net46 VDD pmos W=0.205u L=0.04u
M25276 U6490/net46 g2789 VDD VDD pmos W=0.205u L=0.04u
M25277 U6490/net36 g2788 U6490/net34 VDD pmos W=0.205u L=0.04u
M25278 U6490/net34 n3886 VDD VDD pmos W=0.205u L=0.04u
M25279 U6490/net36 n3853 U6490/net37 VDD pmos W=0.205u L=0.04u
M25280 U6490/net37 g2787 VDD VDD pmos W=0.205u L=0.04u
M25281 U6491/net36 n3886 U6491/net27 VSS nmos W=0.155u L=0.04u
M25282 U6491/net39 n3916 VSS VSS nmos W=0.155u L=0.04u
M25283 U6491/net27 g2784 U6491/net39 VSS nmos W=0.155u L=0.04u
M25284 U6491/net27 n3853 U6491/net39 VSS nmos W=0.155u L=0.04u
M25285 U6491/net36 g2785 U6491/net27 VSS nmos W=0.155u L=0.04u
M25286 U6491/net39 g2786 VSS VSS nmos W=0.155u L=0.04u
M25287 n3910 U6491/net36 VSS VSS nmos W=0.155u L=0.04u
M25288 n3910 U6491/net36 VDD VDD pmos W=0.205u L=0.04u
M25289 U6491/net36 n3916 U6491/net46 VDD pmos W=0.205u L=0.04u
M25290 U6491/net46 g2786 VDD VDD pmos W=0.205u L=0.04u
M25291 U6491/net36 g2785 U6491/net34 VDD pmos W=0.205u L=0.04u
M25292 U6491/net34 n3886 VDD VDD pmos W=0.205u L=0.04u
M25293 U6491/net36 n3853 U6491/net37 VDD pmos W=0.205u L=0.04u
M25294 U6491/net37 g2784 VDD VDD pmos W=0.205u L=0.04u
M25295 U6492/net36 n3886 U6492/net27 VSS nmos W=0.155u L=0.04u
M25296 U6492/net39 n3916 VSS VSS nmos W=0.155u L=0.04u
M25297 U6492/net27 g2772 U6492/net39 VSS nmos W=0.155u L=0.04u
M25298 U6492/net27 n3853 U6492/net39 VSS nmos W=0.155u L=0.04u
M25299 U6492/net36 g2773 U6492/net27 VSS nmos W=0.155u L=0.04u
M25300 U6492/net39 g2774 VSS VSS nmos W=0.155u L=0.04u
M25301 n3913 U6492/net36 VSS VSS nmos W=0.155u L=0.04u
M25302 n3913 U6492/net36 VDD VDD pmos W=0.205u L=0.04u
M25303 U6492/net36 n3916 U6492/net46 VDD pmos W=0.205u L=0.04u
M25304 U6492/net46 g2774 VDD VDD pmos W=0.205u L=0.04u
M25305 U6492/net36 g2773 U6492/net34 VDD pmos W=0.205u L=0.04u
M25306 U6492/net34 n3886 VDD VDD pmos W=0.205u L=0.04u
M25307 U6492/net36 n3853 U6492/net37 VDD pmos W=0.205u L=0.04u
M25308 U6492/net37 g2772 VDD VDD pmos W=0.205u L=0.04u
M25309 n3916 g7487 VSS VSS nmos W=0.135u L=0.04u
M25310 n3916 g7487 VDD VDD pmos W=0.205u L=0.04u
M25311 n3853 g2703 VSS VSS nmos W=0.135u L=0.04u
M25312 n3853 g2703 VDD VDD pmos W=0.205u L=0.04u
M25313 n3886 g7425 VSS VSS nmos W=0.135u L=0.04u
M25314 n3886 g7425 VDD VDD pmos W=0.205u L=0.04u
M25315 n4477 n3922 VSS VSS nmos W=0.135u L=0.04u
M25316 n4477 n3922 VDD VDD pmos W=0.205u L=0.04u
M25317 n3922 g2624 U6497/XI21-net17 VSS nmos W=0.155u L=0.04u
M25318 U6497/XI21-net17 g2685 VSS VSS nmos W=0.155u L=0.04u
M25319 n3922 g7302 U6497/XI6-net17 VSS nmos W=0.155u L=0.04u
M25320 U6497/XI6-net17 g2679 VSS VSS nmos W=0.155u L=0.04u
M25321 n3922 g7390 U6497/XI20-net17 VSS nmos W=0.155u L=0.04u
M25322 U6497/XI20-net17 g2682 VSS VSS nmos W=0.155u L=0.04u
M25323 VDD g2624 U6497/net22 VDD pmos W=0.205u L=0.04u
M25324 VDD g2685 U6497/net22 VDD pmos W=0.205u L=0.04u
M25325 U6497/net16 g7302 n3922 VDD pmos W=0.205u L=0.04u
M25326 U6497/net16 g2679 n3922 VDD pmos W=0.205u L=0.04u
M25327 U6497/net22 g7390 U6497/net16 VDD pmos W=0.205u L=0.04u
M25328 U6497/net22 g2682 U6497/net16 VDD pmos W=0.205u L=0.04u
M25329 g30685 g1890 U6498/net27 VSS nmos W=0.155u L=0.04u
M25330 U6498/net27 n5690 VSS VSS nmos W=0.155u L=0.04u
M25331 g30685 n5691 VSS VSS nmos W=0.155u L=0.04u
M25332 g30685 n5690 U6498/net13 VDD pmos W=0.205u L=0.04u
M25333 U6498/net13 n5691 VDD VDD pmos W=0.205u L=0.04u
M25334 g30685 g1890 U6498/net13 VDD pmos W=0.205u L=0.04u
M25335 n5691 n5692 U6499/net14 VSS nmos W=0.155u L=0.04u
M25336 U6499/net14 n4029 VSS VSS nmos W=0.155u L=0.04u
M25337 U6499/net14 n5695 VSS VSS nmos W=0.155u L=0.04u
M25338 n5691 n5694 U6499/net14 VSS nmos W=0.155u L=0.04u
M25339 n5691 n5693 U6499/net14 VSS nmos W=0.155u L=0.04u
M25340 n5691 n4029 U6499/XI16-net11 VDD pmos W=0.205u L=0.04u
M25341 U6499/XI16-net11 n5695 VDD VDD pmos W=0.205u L=0.04u
M25342 n5691 n5694 U6499/XI15-net11 VDD pmos W=0.205u L=0.04u
M25343 U6499/XI15-net11 n5693 U6499/XI15-net18 VDD pmos W=0.205u L=0.04u
M25344 U6499/XI15-net18 n5692 VDD VDD pmos W=0.205u L=0.04u
M25345 U6500/net4 n5696 U6500/net14 VSS nmos W=0.155u L=0.04u
M25346 U6500/net6 U6500/net10 U6500/net14 VSS nmos W=0.17u L=0.04u
M25347 U6500/net4 n5697 VSS VSS nmos W=0.155u L=0.04u
M25348 U6500/net6 U6500/net4 VSS VSS nmos W=0.17u L=0.04u
M25349 n5695 U6500/net14 VSS VSS nmos W=0.155u L=0.04u
M25350 U6500/net10 n5696 VSS VSS nmos W=0.155u L=0.04u
M25351 U6500/net4 U6500/net10 U6500/net14 VDD pmos W=0.255u L=0.04u
M25352 U6500/net6 n5696 U6500/net14 VDD pmos W=0.28u L=0.04u
M25353 U6500/net4 n5697 VDD VDD pmos W=0.205u L=0.04u
M25354 U6500/net6 U6500/net4 VDD VDD pmos W=0.24u L=0.04u
M25355 n5695 U6500/net14 VDD VDD pmos W=0.205u L=0.04u
M25356 U6500/net10 n5696 VDD VDD pmos W=0.205u L=0.04u
M25357 U6501/net19 n3937 VSS VSS nmos W=0.155u L=0.04u
M25358 n5692 n3937 U6501/net40 VSS nmos W=0.155u L=0.04u
M25359 n5692 U6501/net19 U6501/net36 VSS nmos W=0.155u L=0.04u
M25360 U6501/net40 g1921 VSS VSS nmos W=0.31u L=0.04u
M25361 U6501/net36 g1918 VSS VSS nmos W=0.155u L=0.04u
M25362 U6501/net19 n3937 VDD VDD pmos W=0.205u L=0.04u
M25363 n5692 U6501/net19 U6501/net26 VDD pmos W=0.325u L=0.04u
M25364 U6501/net26 g1921 VDD VDD pmos W=0.41u L=0.04u
M25365 n5692 n3937 U6501/net30 VDD pmos W=0.325u L=0.04u
M25366 U6501/net30 g1918 VDD VDD pmos W=0.205u L=0.04u
M25367 U6502/net4 U6502/net10 U6502/net14 VSS nmos W=0.155u L=0.04u
M25368 U6502/net6 n5698 U6502/net14 VSS nmos W=0.155u L=0.04u
M25369 U6502/net4 n5699 VSS VSS nmos W=0.155u L=0.04u
M25370 U6502/net6 U6502/net4 VSS VSS nmos W=0.155u L=0.04u
M25371 n5690 U6502/net14 VSS VSS nmos W=0.155u L=0.04u
M25372 U6502/net10 n5698 VSS VSS nmos W=0.155u L=0.04u
M25373 U6502/net4 n5698 U6502/net14 VDD pmos W=0.205u L=0.04u
M25374 U6502/net6 U6502/net10 U6502/net14 VDD pmos W=0.205u L=0.04u
M25375 U6502/net4 n5699 VDD VDD pmos W=0.205u L=0.04u
M25376 U6502/net6 U6502/net4 VDD VDD pmos W=0.205u L=0.04u
M25377 n5690 U6502/net14 VDD VDD pmos W=0.205u L=0.04u
M25378 U6502/net10 n5698 VDD VDD pmos W=0.205u L=0.04u
M25379 U6503/net28 U6503/net20 U6503/net64 VSS nmos W=0.155u L=0.04u
M25380 U6503/net24 U6503/net30 U6503/net32 VSS nmos W=0.155u L=0.04u
M25381 U6503/net28 U6503/net40 U6503/net24 VSS nmos W=0.155u L=0.04u
M25382 U6503/net40 n5703 U6503/net108 VSS nmos W=0.155u L=0.04u
M25383 U6503/net40 U6503/net106 U6503/net104 VSS nmos W=0.155u L=0.04u
M25384 U6503/net24 n5700 U6503/net050 VSS nmos W=0.155u L=0.04u
M25385 U6503/net050 U6503/net32 VSS VSS nmos W=0.155u L=0.04u
M25386 U6503/net20 U6503/net40 VSS VSS nmos W=0.155u L=0.04u
M25387 U6503/net106 n5703 VSS VSS nmos W=0.155u L=0.04u
M25388 U6503/net104 n5702 VSS VSS nmos W=0.155u L=0.04u
M25389 U6503/net30 n5700 VSS VSS nmos W=0.155u L=0.04u
M25390 U6503/net108 U6503/net104 VSS VSS nmos W=0.155u L=0.04u
M25391 n5699 U6503/net28 VSS VSS nmos W=0.155u L=0.04u
M25392 U6503/net32 n5701 VSS VSS nmos W=0.155u L=0.04u
M25393 U6503/net64 U6503/net24 VSS VSS nmos W=0.2u L=0.04u
M25394 U6503/net28 U6503/net40 U6503/net64 VDD pmos W=0.205u L=0.04u
M25395 U6503/net24 n5700 U6503/net32 VDD pmos W=0.205u L=0.04u
M25396 U6503/net28 U6503/net20 U6503/net24 VDD pmos W=0.205u L=0.04u
M25397 U6503/net40 U6503/net106 U6503/net108 VDD pmos W=0.205u L=0.04u
M25398 U6503/net40 n5703 U6503/net104 VDD pmos W=0.205u L=0.04u
M25399 U6503/net20 U6503/net40 VDD VDD pmos W=0.205u L=0.04u
M25400 U6503/net106 n5703 VDD VDD pmos W=0.205u L=0.04u
M25401 U6503/net104 n5702 VDD VDD pmos W=0.205u L=0.04u
M25402 U6503/net30 n5700 VDD VDD pmos W=0.205u L=0.04u
M25403 U6503/net108 U6503/net104 VDD VDD pmos W=0.205u L=0.04u
M25404 n5699 U6503/net28 VDD VDD pmos W=0.205u L=0.04u
M25405 U6503/net32 n5701 VDD VDD pmos W=0.205u L=0.04u
M25406 U6503/net64 U6503/net24 VDD VDD pmos W=0.28u L=0.04u
M25407 U6503/net24 U6503/net30 U6503/net045 VDD pmos W=0.205u L=0.04u
M25408 U6503/net045 U6503/net32 VDD VDD pmos W=0.205u L=0.04u
M25409 U6504/net28 U6504/net20 U6504/net64 VSS nmos W=0.155u L=0.04u
M25410 U6504/net24 U6504/net30 U6504/net32 VSS nmos W=0.155u L=0.04u
M25411 U6504/net28 U6504/net40 U6504/net24 VSS nmos W=0.155u L=0.04u
M25412 U6504/net40 n5707 U6504/net108 VSS nmos W=0.155u L=0.04u
M25413 U6504/net40 U6504/net106 U6504/net104 VSS nmos W=0.155u L=0.04u
M25414 U6504/net24 n5704 U6504/net050 VSS nmos W=0.155u L=0.04u
M25415 U6504/net050 U6504/net32 VSS VSS nmos W=0.155u L=0.04u
M25416 U6504/net20 U6504/net40 VSS VSS nmos W=0.155u L=0.04u
M25417 U6504/net106 n5707 VSS VSS nmos W=0.155u L=0.04u
M25418 U6504/net104 n5706 VSS VSS nmos W=0.155u L=0.04u
M25419 U6504/net30 n5704 VSS VSS nmos W=0.155u L=0.04u
M25420 U6504/net108 U6504/net104 VSS VSS nmos W=0.155u L=0.04u
M25421 n5698 U6504/net28 VSS VSS nmos W=0.155u L=0.04u
M25422 U6504/net32 n5705 VSS VSS nmos W=0.155u L=0.04u
M25423 U6504/net64 U6504/net24 VSS VSS nmos W=0.2u L=0.04u
M25424 U6504/net28 U6504/net40 U6504/net64 VDD pmos W=0.205u L=0.04u
M25425 U6504/net24 n5704 U6504/net32 VDD pmos W=0.205u L=0.04u
M25426 U6504/net28 U6504/net20 U6504/net24 VDD pmos W=0.205u L=0.04u
M25427 U6504/net40 U6504/net106 U6504/net108 VDD pmos W=0.205u L=0.04u
M25428 U6504/net40 n5707 U6504/net104 VDD pmos W=0.205u L=0.04u
M25429 U6504/net20 U6504/net40 VDD VDD pmos W=0.205u L=0.04u
M25430 U6504/net106 n5707 VDD VDD pmos W=0.205u L=0.04u
M25431 U6504/net104 n5706 VDD VDD pmos W=0.205u L=0.04u
M25432 U6504/net30 n5704 VDD VDD pmos W=0.205u L=0.04u
M25433 U6504/net108 U6504/net104 VDD VDD pmos W=0.205u L=0.04u
M25434 n5698 U6504/net28 VDD VDD pmos W=0.205u L=0.04u
M25435 U6504/net32 n5705 VDD VDD pmos W=0.205u L=0.04u
M25436 U6504/net64 U6504/net24 VDD VDD pmos W=0.28u L=0.04u
M25437 U6504/net24 U6504/net30 U6504/net045 VDD pmos W=0.205u L=0.04u
M25438 U6504/net045 U6504/net32 VDD VDD pmos W=0.205u L=0.04u
M25439 g30406 n5708 U6505/net27 VSS nmos W=0.155u L=0.04u
M25440 U6505/net27 n5709 VSS VSS nmos W=0.155u L=0.04u
M25441 g30406 n5710 VSS VSS nmos W=0.155u L=0.04u
M25442 g30406 n5709 U6505/net13 VDD pmos W=0.205u L=0.04u
M25443 U6505/net13 n5710 VDD VDD pmos W=0.205u L=0.04u
M25444 g30406 n5708 U6505/net13 VDD pmos W=0.205u L=0.04u
M25445 U6506/net17 n5693 VSS VSS nmos W=0.155u L=0.04u
M25446 U6506/net17 g1914 VSS VSS nmos W=0.155u L=0.04u
M25447 U6506/net63 n5711 VSS VSS nmos W=0.155u L=0.04u
M25448 n5708 U6506/net17 VSS VSS nmos W=0.155u L=0.04u
M25449 n5708 n5701 U6506/net63 VSS nmos W=0.155u L=0.04u
M25450 n5708 n5711 U6506/net31 VDD pmos W=0.205u L=0.04u
M25451 U6506/net39 n5693 VDD VDD pmos W=0.195u L=0.04u
M25452 U6506/net31 U6506/net17 VDD VDD pmos W=0.195u L=0.04u
M25453 n5708 n5701 U6506/net31 VDD pmos W=0.195u L=0.04u
M25454 U6506/net17 g1914 U6506/net39 VDD pmos W=0.195u L=0.04u
M25455 U6507/net7 n5712 U6507/X_u4-net10 VSS nmos W=0.155u L=0.04u
M25456 U6507/X_u4-net10 n5713 U6507/X_u4-net13 VSS nmos W=0.155u L=0.04u
M25457 U6507/X_u4-net13 n5714 VSS VSS nmos W=0.155u L=0.04u
M25458 n5701 U6507/net7 VSS VSS nmos W=0.155u L=0.04u
M25459 U6507/net7 n5714 VDD VDD pmos W=0.205u L=0.04u
M25460 U6507/net7 n5712 VDD VDD pmos W=0.205u L=0.04u
M25461 U6507/net7 n5713 VDD VDD pmos W=0.205u L=0.04u
M25462 n5701 U6507/net7 VDD VDD pmos W=0.205u L=0.04u
M25463 U6508/net19 n4010 VSS VSS nmos W=0.155u L=0.04u
M25464 n5714 n4010 U6508/net40 VSS nmos W=0.155u L=0.04u
M25465 n5714 U6508/net19 U6508/net36 VSS nmos W=0.155u L=0.04u
M25466 U6508/net40 n4059 VSS VSS nmos W=0.31u L=0.04u
M25467 U6508/net36 n5715 VSS VSS nmos W=0.155u L=0.04u
M25468 U6508/net19 n4010 VDD VDD pmos W=0.205u L=0.04u
M25469 n5714 U6508/net19 U6508/net26 VDD pmos W=0.325u L=0.04u
M25470 U6508/net26 n4059 VDD VDD pmos W=0.41u L=0.04u
M25471 n5714 n4010 U6508/net30 VDD pmos W=0.325u L=0.04u
M25472 U6508/net30 n5715 VDD VDD pmos W=0.205u L=0.04u
M25473 g30405 n5716 U6509/net27 VSS nmos W=0.155u L=0.04u
M25474 U6509/net27 n5709 VSS VSS nmos W=0.155u L=0.04u
M25475 g30405 n5717 VSS VSS nmos W=0.155u L=0.04u
M25476 g30405 n5709 U6509/net13 VDD pmos W=0.205u L=0.04u
M25477 U6509/net13 n5717 VDD VDD pmos W=0.205u L=0.04u
M25478 g30405 n5716 U6509/net13 VDD pmos W=0.205u L=0.04u
M25479 U6510/net17 n5693 VSS VSS nmos W=0.155u L=0.04u
M25480 U6510/net17 g1910 VSS VSS nmos W=0.155u L=0.04u
M25481 U6510/net63 n5711 VSS VSS nmos W=0.155u L=0.04u
M25482 n5716 U6510/net17 VSS VSS nmos W=0.155u L=0.04u
M25483 n5716 n5700 U6510/net63 VSS nmos W=0.155u L=0.04u
M25484 n5716 n5711 U6510/net31 VDD pmos W=0.205u L=0.04u
M25485 U6510/net39 n5693 VDD VDD pmos W=0.195u L=0.04u
M25486 U6510/net31 U6510/net17 VDD VDD pmos W=0.195u L=0.04u
M25487 n5716 n5700 U6510/net31 VDD pmos W=0.195u L=0.04u
M25488 U6510/net17 g1910 U6510/net39 VDD pmos W=0.195u L=0.04u
M25489 n5700 U6511/net6 VSS VSS nmos W=0.155u L=0.04u
M25490 U6511/X_u2-net6 n5712 VSS VSS nmos W=0.155u L=0.04u
M25491 U6511/net6 n5718 U6511/X_u2-net6 VSS nmos W=0.155u L=0.04u
M25492 n5700 U6511/net6 VDD VDD pmos W=0.205u L=0.04u
M25493 U6511/net6 n5712 VDD VDD pmos W=0.205u L=0.04u
M25494 U6511/net6 n5718 VDD VDD pmos W=0.205u L=0.04u
M25495 U6512/net19 n4019 VSS VSS nmos W=0.155u L=0.04u
M25496 n5718 n4019 U6512/net40 VSS nmos W=0.155u L=0.04u
M25497 n5718 U6512/net19 U6512/net36 VSS nmos W=0.155u L=0.04u
M25498 U6512/net40 n5715 VSS VSS nmos W=0.31u L=0.04u
M25499 U6512/net36 n4059 VSS VSS nmos W=0.155u L=0.04u
M25500 U6512/net19 n4019 VDD VDD pmos W=0.205u L=0.04u
M25501 n5718 U6512/net19 U6512/net26 VDD pmos W=0.325u L=0.04u
M25502 U6512/net26 n5715 VDD VDD pmos W=0.41u L=0.04u
M25503 n5718 n4019 U6512/net30 VDD pmos W=0.325u L=0.04u
M25504 U6512/net30 n4059 VDD VDD pmos W=0.205u L=0.04u
M25505 g30404 n5719 U6513/net27 VSS nmos W=0.155u L=0.04u
M25506 U6513/net27 n5709 VSS VSS nmos W=0.155u L=0.04u
M25507 g30404 n5710 VSS VSS nmos W=0.155u L=0.04u
M25508 g30404 n5709 U6513/net13 VDD pmos W=0.205u L=0.04u
M25509 U6513/net13 n5710 VDD VDD pmos W=0.205u L=0.04u
M25510 g30404 n5719 U6513/net13 VDD pmos W=0.205u L=0.04u
M25511 U6514/net17 n5693 VSS VSS nmos W=0.155u L=0.04u
M25512 U6514/net17 g1913 VSS VSS nmos W=0.155u L=0.04u
M25513 U6514/net63 n5711 VSS VSS nmos W=0.155u L=0.04u
M25514 n5719 U6514/net17 VSS VSS nmos W=0.155u L=0.04u
M25515 n5719 n5703 U6514/net63 VSS nmos W=0.155u L=0.04u
M25516 n5719 n5711 U6514/net31 VDD pmos W=0.205u L=0.04u
M25517 U6514/net39 n5693 VDD VDD pmos W=0.195u L=0.04u
M25518 U6514/net31 U6514/net17 VDD VDD pmos W=0.195u L=0.04u
M25519 n5719 n5703 U6514/net31 VDD pmos W=0.195u L=0.04u
M25520 U6514/net17 g1913 U6514/net39 VDD pmos W=0.195u L=0.04u
M25521 U6515/net7 n5712 U6515/X_u4-net10 VSS nmos W=0.155u L=0.04u
M25522 U6515/X_u4-net10 n5720 U6515/X_u4-net13 VSS nmos W=0.155u L=0.04u
M25523 U6515/X_u4-net13 n5721 VSS VSS nmos W=0.155u L=0.04u
M25524 n5703 U6515/net7 VSS VSS nmos W=0.155u L=0.04u
M25525 U6515/net7 n5721 VDD VDD pmos W=0.205u L=0.04u
M25526 U6515/net7 n5712 VDD VDD pmos W=0.205u L=0.04u
M25527 U6515/net7 n5720 VDD VDD pmos W=0.205u L=0.04u
M25528 n5703 U6515/net7 VDD VDD pmos W=0.205u L=0.04u
M25529 U6516/net19 n4014 VSS VSS nmos W=0.155u L=0.04u
M25530 n5721 n4014 U6516/net40 VSS nmos W=0.155u L=0.04u
M25531 n5721 U6516/net19 U6516/net36 VSS nmos W=0.155u L=0.04u
M25532 U6516/net40 n5722 VSS VSS nmos W=0.31u L=0.04u
M25533 U6516/net36 n4437 VSS VSS nmos W=0.155u L=0.04u
M25534 U6516/net19 n4014 VDD VDD pmos W=0.205u L=0.04u
M25535 n5721 U6516/net19 U6516/net26 VDD pmos W=0.325u L=0.04u
M25536 U6516/net26 n5722 VDD VDD pmos W=0.41u L=0.04u
M25537 n5721 n4014 U6516/net30 VDD pmos W=0.325u L=0.04u
M25538 U6516/net30 n4437 VDD VDD pmos W=0.205u L=0.04u
M25539 U6517/net29 n5697 VSS VSS nmos W=0.155u L=0.04u
M25540 g30403 n5724 U6517/net29 VSS nmos W=0.155u L=0.04u
M25541 g30403 n5723 U6517/net23 VSS nmos W=0.155u L=0.04u
M25542 U6517/net23 n5709 VSS VSS nmos W=0.155u L=0.04u
M25543 U6517/net20 n5709 g30403 VDD pmos W=0.205u L=0.04u
M25544 U6517/net20 n5723 g30403 VDD pmos W=0.205u L=0.04u
M25545 VDD n5724 U6517/net20 VDD pmos W=0.205u L=0.04u
M25546 VDD n5697 U6517/net20 VDD pmos W=0.205u L=0.04u
M25547 n5697 n5712 U6518/XI0-net10 VSS nmos W=0.155u L=0.04u
M25548 U6518/XI0-net10 n5713 U6518/XI0-net13 VSS nmos W=0.155u L=0.04u
M25549 U6518/XI0-net13 n5725 VSS VSS nmos W=0.155u L=0.04u
M25550 n5697 n5725 VDD VDD pmos W=0.205u L=0.04u
M25551 n5697 n5712 VDD VDD pmos W=0.205u L=0.04u
M25552 n5697 n5713 VDD VDD pmos W=0.205u L=0.04u
M25553 U6519/net19 n4008 VSS VSS nmos W=0.155u L=0.04u
M25554 n5725 n4008 U6519/net40 VSS nmos W=0.155u L=0.04u
M25555 n5725 U6519/net19 U6519/net36 VSS nmos W=0.155u L=0.04u
M25556 U6519/net40 n4059 VSS VSS nmos W=0.31u L=0.04u
M25557 U6519/net36 n5715 VSS VSS nmos W=0.155u L=0.04u
M25558 U6519/net19 n4008 VDD VDD pmos W=0.205u L=0.04u
M25559 n5725 U6519/net19 U6519/net26 VDD pmos W=0.325u L=0.04u
M25560 U6519/net26 n4059 VDD VDD pmos W=0.41u L=0.04u
M25561 n5725 n4008 U6519/net30 VDD pmos W=0.325u L=0.04u
M25562 U6519/net30 n5715 VDD VDD pmos W=0.205u L=0.04u
M25563 U6520/XU1-net6 n4059 VSS VSS nmos W=0.155u L=0.04u
M25564 n5713 n5726 U6520/XU1-net6 VSS nmos W=0.155u L=0.04u
M25565 n5713 n4059 VDD VDD pmos W=0.155u L=0.04u
M25566 n5713 n5726 VDD VDD pmos W=0.155u L=0.04u
M25567 U6521/net17 n5693 VSS VSS nmos W=0.155u L=0.04u
M25568 U6521/net17 g1917 VSS VSS nmos W=0.155u L=0.04u
M25569 U6521/net63 n5711 VSS VSS nmos W=0.155u L=0.04u
M25570 n5723 U6521/net17 VSS VSS nmos W=0.155u L=0.04u
M25571 n5723 n5702 U6521/net63 VSS nmos W=0.155u L=0.04u
M25572 n5723 n5711 U6521/net31 VDD pmos W=0.205u L=0.04u
M25573 U6521/net39 n5693 VDD VDD pmos W=0.195u L=0.04u
M25574 U6521/net31 U6521/net17 VDD VDD pmos W=0.195u L=0.04u
M25575 n5723 n5702 U6521/net31 VDD pmos W=0.195u L=0.04u
M25576 U6521/net17 g1917 U6521/net39 VDD pmos W=0.195u L=0.04u
M25577 n5702 U6522/net6 VSS VSS nmos W=0.155u L=0.04u
M25578 U6522/X_u2-net6 n5712 VSS VSS nmos W=0.155u L=0.04u
M25579 U6522/net6 n5727 U6522/X_u2-net6 VSS nmos W=0.155u L=0.04u
M25580 n5702 U6522/net6 VDD VDD pmos W=0.205u L=0.04u
M25581 U6522/net6 n5712 VDD VDD pmos W=0.205u L=0.04u
M25582 U6522/net6 n5727 VDD VDD pmos W=0.205u L=0.04u
M25583 U6523/net19 n4024 VSS VSS nmos W=0.155u L=0.04u
M25584 n5727 n4024 U6523/net40 VSS nmos W=0.155u L=0.04u
M25585 n5727 U6523/net19 U6523/net36 VSS nmos W=0.155u L=0.04u
M25586 U6523/net40 n4059 VSS VSS nmos W=0.31u L=0.04u
M25587 U6523/net36 n5715 VSS VSS nmos W=0.155u L=0.04u
M25588 U6523/net19 n4024 VDD VDD pmos W=0.205u L=0.04u
M25589 n5727 U6523/net19 U6523/net26 VDD pmos W=0.325u L=0.04u
M25590 U6523/net26 n4059 VDD VDD pmos W=0.41u L=0.04u
M25591 n5727 n4024 U6523/net30 VDD pmos W=0.325u L=0.04u
M25592 U6523/net30 n5715 VDD VDD pmos W=0.205u L=0.04u
M25593 U6524/net29 n5696 VSS VSS nmos W=0.155u L=0.04u
M25594 g30402 n5724 U6524/net29 VSS nmos W=0.155u L=0.04u
M25595 g30402 n5728 U6524/net23 VSS nmos W=0.155u L=0.04u
M25596 U6524/net23 n5709 VSS VSS nmos W=0.155u L=0.04u
M25597 U6524/net20 n5709 g30402 VDD pmos W=0.205u L=0.04u
M25598 U6524/net20 n5728 g30402 VDD pmos W=0.205u L=0.04u
M25599 VDD n5724 U6524/net20 VDD pmos W=0.205u L=0.04u
M25600 VDD n5696 U6524/net20 VDD pmos W=0.205u L=0.04u
M25601 n5696 n5712 U6525/XI0-net10 VSS nmos W=0.155u L=0.04u
M25602 U6525/XI0-net10 n5720 U6525/XI0-net13 VSS nmos W=0.155u L=0.04u
M25603 U6525/XI0-net13 n5729 VSS VSS nmos W=0.155u L=0.04u
M25604 n5696 n5729 VDD VDD pmos W=0.205u L=0.04u
M25605 n5696 n5712 VDD VDD pmos W=0.205u L=0.04u
M25606 n5696 n5720 VDD VDD pmos W=0.205u L=0.04u
M25607 U6526/net19 n4009 VSS VSS nmos W=0.155u L=0.04u
M25608 n5729 n4009 U6526/net40 VSS nmos W=0.155u L=0.04u
M25609 n5729 U6526/net19 U6526/net36 VSS nmos W=0.155u L=0.04u
M25610 U6526/net40 n4437 VSS VSS nmos W=0.31u L=0.04u
M25611 U6526/net36 n5722 VSS VSS nmos W=0.155u L=0.04u
M25612 U6526/net19 n4009 VDD VDD pmos W=0.205u L=0.04u
M25613 n5729 U6526/net19 U6526/net26 VDD pmos W=0.325u L=0.04u
M25614 U6526/net26 n4437 VDD VDD pmos W=0.41u L=0.04u
M25615 n5729 n4009 U6526/net30 VDD pmos W=0.325u L=0.04u
M25616 U6526/net30 n5722 VDD VDD pmos W=0.205u L=0.04u
M25617 U6527/net17 n5693 VSS VSS nmos W=0.155u L=0.04u
M25618 U6527/net17 g1916 VSS VSS nmos W=0.155u L=0.04u
M25619 U6527/net63 n5711 VSS VSS nmos W=0.155u L=0.04u
M25620 n5728 U6527/net17 VSS VSS nmos W=0.155u L=0.04u
M25621 n5728 n5705 U6527/net63 VSS nmos W=0.155u L=0.04u
M25622 n5728 n5711 U6527/net31 VDD pmos W=0.205u L=0.04u
M25623 U6527/net39 n5693 VDD VDD pmos W=0.195u L=0.04u
M25624 U6527/net31 U6527/net17 VDD VDD pmos W=0.195u L=0.04u
M25625 n5728 n5705 U6527/net31 VDD pmos W=0.195u L=0.04u
M25626 U6527/net17 g1916 U6527/net39 VDD pmos W=0.195u L=0.04u
M25627 U6528/net7 n5712 U6528/X_u4-net10 VSS nmos W=0.155u L=0.04u
M25628 U6528/X_u4-net10 n5720 U6528/X_u4-net13 VSS nmos W=0.155u L=0.04u
M25629 U6528/X_u4-net13 n5730 VSS VSS nmos W=0.155u L=0.04u
M25630 n5705 U6528/net7 VSS VSS nmos W=0.155u L=0.04u
M25631 U6528/net7 n5730 VDD VDD pmos W=0.205u L=0.04u
M25632 U6528/net7 n5712 VDD VDD pmos W=0.205u L=0.04u
M25633 U6528/net7 n5720 VDD VDD pmos W=0.205u L=0.04u
M25634 n5705 U6528/net7 VDD VDD pmos W=0.205u L=0.04u
M25635 U6529/net19 n4013 VSS VSS nmos W=0.155u L=0.04u
M25636 n5730 n4013 U6529/net40 VSS nmos W=0.155u L=0.04u
M25637 n5730 U6529/net19 U6529/net36 VSS nmos W=0.155u L=0.04u
M25638 U6529/net40 n5722 VSS VSS nmos W=0.31u L=0.04u
M25639 U6529/net36 n4437 VSS VSS nmos W=0.155u L=0.04u
M25640 U6529/net19 n4013 VDD VDD pmos W=0.205u L=0.04u
M25641 n5730 U6529/net19 U6529/net26 VDD pmos W=0.325u L=0.04u
M25642 U6529/net26 n5722 VDD VDD pmos W=0.41u L=0.04u
M25643 n5730 n4013 U6529/net30 VDD pmos W=0.325u L=0.04u
M25644 U6529/net30 n4437 VDD VDD pmos W=0.205u L=0.04u
M25645 U6530/XU1-net6 n4437 VSS VSS nmos W=0.155u L=0.04u
M25646 n5720 n5726 U6530/XU1-net6 VSS nmos W=0.155u L=0.04u
M25647 n5720 n4437 VDD VDD pmos W=0.155u L=0.04u
M25648 n5720 n5726 VDD VDD pmos W=0.155u L=0.04u
M25649 g30401 n5731 U6531/net27 VSS nmos W=0.155u L=0.04u
M25650 U6531/net27 n5709 VSS VSS nmos W=0.155u L=0.04u
M25651 g30401 n5732 VSS VSS nmos W=0.155u L=0.04u
M25652 g30401 n5709 U6531/net13 VDD pmos W=0.205u L=0.04u
M25653 U6531/net13 n5732 VDD VDD pmos W=0.205u L=0.04u
M25654 g30401 n5731 U6531/net13 VDD pmos W=0.205u L=0.04u
M25655 U6532/net17 n5693 VSS VSS nmos W=0.155u L=0.04u
M25656 U6532/net17 g1912 VSS VSS nmos W=0.155u L=0.04u
M25657 U6532/net63 n5711 VSS VSS nmos W=0.155u L=0.04u
M25658 n5731 U6532/net17 VSS VSS nmos W=0.155u L=0.04u
M25659 n5731 n5704 U6532/net63 VSS nmos W=0.155u L=0.04u
M25660 n5731 n5711 U6532/net31 VDD pmos W=0.205u L=0.04u
M25661 U6532/net39 n5693 VDD VDD pmos W=0.195u L=0.04u
M25662 U6532/net31 U6532/net17 VDD VDD pmos W=0.195u L=0.04u
M25663 n5731 n5704 U6532/net31 VDD pmos W=0.195u L=0.04u
M25664 U6532/net17 g1912 U6532/net39 VDD pmos W=0.195u L=0.04u
M25665 n5704 U6533/net6 VSS VSS nmos W=0.155u L=0.04u
M25666 U6533/X_u2-net6 n5712 VSS VSS nmos W=0.155u L=0.04u
M25667 U6533/net6 n5733 U6533/X_u2-net6 VSS nmos W=0.155u L=0.04u
M25668 n5704 U6533/net6 VDD VDD pmos W=0.205u L=0.04u
M25669 U6533/net6 n5712 VDD VDD pmos W=0.205u L=0.04u
M25670 U6533/net6 n5733 VDD VDD pmos W=0.205u L=0.04u
M25671 U6534/net19 n4021 VSS VSS nmos W=0.155u L=0.04u
M25672 n5733 n4021 U6534/net40 VSS nmos W=0.155u L=0.04u
M25673 n5733 U6534/net19 U6534/net36 VSS nmos W=0.155u L=0.04u
M25674 U6534/net40 n4059 VSS VSS nmos W=0.31u L=0.04u
M25675 U6534/net36 n5715 VSS VSS nmos W=0.155u L=0.04u
M25676 U6534/net19 n4021 VDD VDD pmos W=0.205u L=0.04u
M25677 n5733 U6534/net19 U6534/net26 VDD pmos W=0.325u L=0.04u
M25678 U6534/net26 n4059 VDD VDD pmos W=0.41u L=0.04u
M25679 n5733 n4021 U6534/net30 VDD pmos W=0.325u L=0.04u
M25680 U6534/net30 n5715 VDD VDD pmos W=0.205u L=0.04u
M25681 n5715 n4059 VSS VSS nmos W=0.155u L=0.04u
M25682 n5715 n5726 VSS VSS nmos W=0.155u L=0.04u
M25683 U6535/XI1-net8 n5726 VDD VDD pmos W=0.205u L=0.04u
M25684 n5715 n4059 U6535/XI1-net8 VDD pmos W=0.205u L=0.04u
M25685 n4059 n4040 VSS VSS nmos W=0.135u L=0.04u
M25686 n4059 n4040 VDD VDD pmos W=0.205u L=0.04u
M25687 n4040 g1930 U6537/XI21-net17 VSS nmos W=0.155u L=0.04u
M25688 U6537/XI21-net17 g2000 VSS VSS nmos W=0.155u L=0.04u
M25689 n4040 g7052 U6537/XI6-net17 VSS nmos W=0.155u L=0.04u
M25690 U6537/XI6-net17 g1994 VSS VSS nmos W=0.155u L=0.04u
M25691 n4040 g7194 U6537/XI20-net17 VSS nmos W=0.155u L=0.04u
M25692 U6537/XI20-net17 g1997 VSS VSS nmos W=0.155u L=0.04u
M25693 VDD g1930 U6537/net22 VDD pmos W=0.205u L=0.04u
M25694 VDD g2000 U6537/net22 VDD pmos W=0.205u L=0.04u
M25695 U6537/net16 g7052 n4040 VDD pmos W=0.205u L=0.04u
M25696 U6537/net16 g1994 n4040 VDD pmos W=0.205u L=0.04u
M25697 U6537/net22 g7194 U6537/net16 VDD pmos W=0.205u L=0.04u
M25698 U6537/net22 g1997 U6537/net16 VDD pmos W=0.205u L=0.04u
M25699 g30400 n5734 U6538/net27 VSS nmos W=0.155u L=0.04u
M25700 U6538/net27 n5709 VSS VSS nmos W=0.155u L=0.04u
M25701 g30400 n5732 VSS VSS nmos W=0.155u L=0.04u
M25702 g30400 n5709 U6538/net13 VDD pmos W=0.205u L=0.04u
M25703 U6538/net13 n5732 VDD VDD pmos W=0.205u L=0.04u
M25704 g30400 n5734 U6538/net13 VDD pmos W=0.205u L=0.04u
M25705 U6539/XU35-net6 n5724 VSS VSS nmos W=0.155u L=0.04u
M25706 U6539/net5 n5735 U6539/XU35-net6 VSS nmos W=0.155u L=0.04u
M25707 U6539/XU36-net6 U6539/net5 VSS VSS nmos W=0.155u L=0.04u
M25708 n5732 n5736 U6539/XU36-net6 VSS nmos W=0.155u L=0.04u
M25709 U6539/net5 n5724 VDD VDD pmos W=0.205u L=0.04u
M25710 U6539/net5 n5735 VDD VDD pmos W=0.205u L=0.04u
M25711 n5732 U6539/net5 VDD VDD pmos W=0.205u L=0.04u
M25712 n5732 n5736 VDD VDD pmos W=0.205u L=0.04u
M25713 U6540/net17 n5693 VSS VSS nmos W=0.155u L=0.04u
M25714 U6540/net17 g1909 VSS VSS nmos W=0.155u L=0.04u
M25715 U6540/net63 n5711 VSS VSS nmos W=0.155u L=0.04u
M25716 n5734 U6540/net17 VSS VSS nmos W=0.155u L=0.04u
M25717 n5734 n5707 U6540/net63 VSS nmos W=0.155u L=0.04u
M25718 n5734 n5711 U6540/net31 VDD pmos W=0.205u L=0.04u
M25719 U6540/net39 n5693 VDD VDD pmos W=0.195u L=0.04u
M25720 U6540/net31 U6540/net17 VDD VDD pmos W=0.195u L=0.04u
M25721 n5734 n5707 U6540/net31 VDD pmos W=0.195u L=0.04u
M25722 U6540/net17 g1909 U6540/net39 VDD pmos W=0.195u L=0.04u
M25723 n5707 U6541/net6 VSS VSS nmos W=0.155u L=0.04u
M25724 U6541/X_u2-net6 n5712 VSS VSS nmos W=0.155u L=0.04u
M25725 U6541/net6 n5737 U6541/X_u2-net6 VSS nmos W=0.155u L=0.04u
M25726 n5707 U6541/net6 VDD VDD pmos W=0.205u L=0.04u
M25727 U6541/net6 n5712 VDD VDD pmos W=0.205u L=0.04u
M25728 U6541/net6 n5737 VDD VDD pmos W=0.205u L=0.04u
M25729 U6542/net19 n4020 VSS VSS nmos W=0.155u L=0.04u
M25730 n5737 n4020 U6542/net40 VSS nmos W=0.155u L=0.04u
M25731 n5737 U6542/net19 U6542/net36 VSS nmos W=0.155u L=0.04u
M25732 U6542/net40 n5722 VSS VSS nmos W=0.31u L=0.04u
M25733 U6542/net36 n4437 VSS VSS nmos W=0.155u L=0.04u
M25734 U6542/net19 n4020 VDD VDD pmos W=0.205u L=0.04u
M25735 n5737 U6542/net19 U6542/net26 VDD pmos W=0.325u L=0.04u
M25736 U6542/net26 n5722 VDD VDD pmos W=0.41u L=0.04u
M25737 n5737 n4020 U6542/net30 VDD pmos W=0.325u L=0.04u
M25738 U6542/net30 n4437 VDD VDD pmos W=0.205u L=0.04u
M25739 g30399 n5738 U6543/net27 VSS nmos W=0.155u L=0.04u
M25740 U6543/net27 n5709 VSS VSS nmos W=0.155u L=0.04u
M25741 g30399 n5717 VSS VSS nmos W=0.155u L=0.04u
M25742 g30399 n5709 U6543/net13 VDD pmos W=0.205u L=0.04u
M25743 U6543/net13 n5717 VDD VDD pmos W=0.205u L=0.04u
M25744 g30399 n5738 U6543/net13 VDD pmos W=0.205u L=0.04u
M25745 n5717 n5739 U6544/net15 VSS nmos W=0.155u L=0.04u
M25746 n5717 n5735 U6544/net15 VSS nmos W=0.155u L=0.04u
M25747 U6544/net15 n5736 VSS VSS nmos W=0.155u L=0.04u
M25748 n5717 n5736 VDD VDD pmos W=0.205u L=0.04u
M25749 n5717 n5739 U6544/XI16-net11 VDD pmos W=0.205u L=0.04u
M25750 U6544/XI16-net11 n5735 VDD VDD pmos W=0.205u L=0.04u
M25751 n5736 n5710 VSS VSS nmos W=0.135u L=0.04u
M25752 n5736 n5710 VDD VDD pmos W=0.205u L=0.04u
M25753 n5710 n5739 VSS VSS nmos W=0.155u L=0.04u
M25754 n5710 n5740 VSS VSS nmos W=0.155u L=0.04u
M25755 U6546/XI1-net8 n5740 VDD VDD pmos W=0.205u L=0.04u
M25756 n5710 n5739 U6546/XI1-net8 VDD pmos W=0.205u L=0.04u
M25757 VSS g1880 U6547/net22 VSS nmos W=0.155u L=0.04u
M25758 U6547/net22 n5742 n5735 VSS nmos W=0.155u L=0.04u
M25759 U6547/net22 n5726 n5735 VSS nmos W=0.155u L=0.04u
M25760 U6547/net22 n5741 n5735 VSS nmos W=0.155u L=0.04u
M25761 U6547/net38 n5741 VDD VDD pmos W=0.205u L=0.04u
M25762 U6547/net35 n5726 U6547/net38 VDD pmos W=0.205u L=0.04u
M25763 n5735 n5742 U6547/net35 VDD pmos W=0.205u L=0.04u
M25764 n5735 g1880 VDD VDD pmos W=0.205u L=0.04u
M25765 n5742 g2114 VSS VSS nmos W=0.155u L=0.04u
M25766 n5742 n3964 VSS VSS nmos W=0.155u L=0.04u
M25767 U6548/XI1-net8 n3964 VDD VDD pmos W=0.205u L=0.04u
M25768 n5742 g2114 U6548/XI1-net8 VDD pmos W=0.205u L=0.04u
M25769 n5741 g2115 U6549/net10 VSS nmos W=0.155u L=0.04u
M25770 U6549/net10 n4027 VSS VSS nmos W=0.155u L=0.04u
M25771 n5741 n3997 U6549/net10 VSS nmos W=0.155u L=0.04u
M25772 U6549/net10 g2116 VSS VSS nmos W=0.155u L=0.04u
M25773 U6549/net30 n4027 VDD VDD pmos W=0.205u L=0.04u
M25774 n5741 g2115 U6549/net24 VDD pmos W=0.205u L=0.04u
M25775 U6549/net24 n3997 VDD VDD pmos W=0.205u L=0.04u
M25776 n5741 g2116 U6549/net30 VDD pmos W=0.205u L=0.04u
M25777 n5739 n5724 VSS VSS nmos W=0.135u L=0.04u
M25778 n5739 n5724 VDD VDD pmos W=0.205u L=0.04u
M25779 n5724 n5711 VSS VSS nmos W=0.155u L=0.04u
M25780 n5724 n5709 VSS VSS nmos W=0.155u L=0.04u
M25781 U6551/XI1-net8 n5709 VDD VDD pmos W=0.205u L=0.04u
M25782 n5724 n5711 U6551/XI1-net8 VDD pmos W=0.205u L=0.04u
M25783 n5709 n5694 VSS VSS nmos W=0.135u L=0.04u
M25784 n5709 n5694 VDD VDD pmos W=0.205u L=0.04u
M25785 n5694 g1890 U6553/net15 VSS nmos W=0.155u L=0.04u
M25786 n5694 g1905 U6553/net15 VSS nmos W=0.155u L=0.04u
M25787 U6553/net15 n4029 VSS VSS nmos W=0.155u L=0.04u
M25788 n5694 n4029 VDD VDD pmos W=0.205u L=0.04u
M25789 n5694 g1890 U6553/XI16-net11 VDD pmos W=0.205u L=0.04u
M25790 U6553/XI16-net11 g1905 VDD VDD pmos W=0.205u L=0.04u
M25791 n4029 g1937 VSS VSS nmos W=0.135u L=0.04u
M25792 n4029 g1937 VDD VDD pmos W=0.205u L=0.04u
M25793 U6555/net17 n5693 VSS VSS nmos W=0.155u L=0.04u
M25794 U6555/net17 g1911 VSS VSS nmos W=0.155u L=0.04u
M25795 U6555/net63 n5711 VSS VSS nmos W=0.155u L=0.04u
M25796 n5738 U6555/net17 VSS VSS nmos W=0.155u L=0.04u
M25797 n5738 n5706 U6555/net63 VSS nmos W=0.155u L=0.04u
M25798 n5738 n5711 U6555/net31 VDD pmos W=0.205u L=0.04u
M25799 U6555/net39 n5693 VDD VDD pmos W=0.195u L=0.04u
M25800 U6555/net31 U6555/net17 VDD VDD pmos W=0.195u L=0.04u
M25801 n5738 n5706 U6555/net31 VDD pmos W=0.195u L=0.04u
M25802 U6555/net17 g1911 U6555/net39 VDD pmos W=0.195u L=0.04u
M25803 U6556/XU1-net6 n5743 VSS VSS nmos W=0.155u L=0.04u
M25804 n5693 n5740 U6556/XU1-net6 VSS nmos W=0.155u L=0.04u
M25805 n5693 n5743 VDD VDD pmos W=0.155u L=0.04u
M25806 n5693 n5740 VDD VDD pmos W=0.155u L=0.04u
M25807 n5711 n5743 VSS VSS nmos W=0.135u L=0.04u
M25808 n5711 n5743 VDD VDD pmos W=0.205u L=0.04u
M25809 U6558/net11 g1905 VSS VSS nmos W=0.155u L=0.04u
M25810 U6558/net11 g1937 VSS VSS nmos W=0.155u L=0.04u
M25811 n5743 g1890 VSS VSS nmos W=0.155u L=0.04u
M25812 n5743 U6558/net11 VSS VSS nmos W=0.155u L=0.04u
M25813 U6558/XI1-net8 g1937 VDD VDD pmos W=0.205u L=0.04u
M25814 U6558/net11 g1905 U6558/XI1-net8 VDD pmos W=0.205u L=0.04u
M25815 U6558/XU39-net8 U6558/net11 VDD VDD pmos W=0.205u L=0.04u
M25816 n5743 g1890 U6558/XU39-net8 VDD pmos W=0.205u L=0.04u
M25817 n5706 U6559/net6 VSS VSS nmos W=0.155u L=0.04u
M25818 U6559/X_u2-net6 n5712 VSS VSS nmos W=0.155u L=0.04u
M25819 U6559/net6 n5744 U6559/X_u2-net6 VSS nmos W=0.155u L=0.04u
M25820 n5706 U6559/net6 VDD VDD pmos W=0.205u L=0.04u
M25821 U6559/net6 n5712 VDD VDD pmos W=0.205u L=0.04u
M25822 U6559/net6 n5744 VDD VDD pmos W=0.205u L=0.04u
M25823 n5712 II15511 VSS VSS nmos W=0.155u L=0.04u
M25824 n5712 U6560/net4 VSS VSS nmos W=0.155u L=0.04u
M25825 U6560/net4 n5740 VSS VSS nmos W=0.155u L=0.04u
M25826 U6560/XU1-net8 U6560/net4 VDD VDD pmos W=0.205u L=0.04u
M25827 n5712 II15511 U6560/XU1-net8 VDD pmos W=0.205u L=0.04u
M25828 U6560/net4 n5740 VDD VDD pmos W=0.205u L=0.04u
M25829 n5740 n4519 VSS VSS nmos W=0.155u L=0.04u
M25830 n5740 g1939 VSS VSS nmos W=0.155u L=0.04u
M25831 n5740 g1943 VSS VSS nmos W=0.155u L=0.04u
M25832 U6561/net25 n4519 VDD VDD pmos W=0.41u L=0.04u
M25833 U6561/net28 g1939 U6561/net25 VDD pmos W=0.41u L=0.04u
M25834 n5740 g1943 U6561/net28 VDD pmos W=0.41u L=0.04u
M25835 n4519 n3397 VSS VSS nmos W=0.135u L=0.04u
M25836 n4519 n3397 VDD VDD pmos W=0.205u L=0.04u
M25837 U6563/PG2 g1924 VSS VSS nmos W=0.31u L=0.04u
M25838 U6563/net55 n4518 VSS VSS nmos W=0.31u L=0.04u
M25839 U6563/net51 g7052 VSS VSS nmos W=0.155u L=0.04u
M25840 U6563/net53 g1928 VSS VSS nmos W=0.155u L=0.04u
M25841 U6563/net29 g1880 VSS VSS nmos W=0.155u L=0.04u
M25842 U6563/net53 U6563/net51 U6563/PG1 VSS nmos W=0.155u L=0.04u
M25843 U6563/net55 g7052 U6563/PG1 VSS nmos W=0.21u L=0.04u
M25844 U6563/PG2 g1880 n3397 VSS nmos W=0.22u L=0.04u
M25845 U6563/PG1 U6563/net29 n3397 VSS nmos W=0.155u L=0.04u
M25846 U6563/PG2 g1924 VDD VDD pmos W=0.41u L=0.04u
M25847 U6563/net55 n4518 VDD VDD pmos W=0.41u L=0.04u
M25848 U6563/net51 g7052 VDD VDD pmos W=0.205u L=0.04u
M25849 U6563/net53 g1928 VDD VDD pmos W=0.28u L=0.04u
M25850 U6563/net29 g1880 VDD VDD pmos W=0.205u L=0.04u
M25851 U6563/net53 g7052 U6563/PG1 VDD pmos W=0.27u L=0.04u
M25852 U6563/net55 U6563/net51 U6563/PG1 VDD pmos W=0.285u L=0.04u
M25853 U6563/PG2 U6563/net29 n3397 VDD pmos W=0.205u L=0.04u
M25854 U6563/PG1 g1880 n3397 VDD pmos W=0.28u L=0.04u
M25855 U6564/net19 n4025 VSS VSS nmos W=0.155u L=0.04u
M25856 n5744 n4025 U6564/net40 VSS nmos W=0.155u L=0.04u
M25857 n5744 U6564/net19 U6564/net36 VSS nmos W=0.155u L=0.04u
M25858 U6564/net40 n4437 VSS VSS nmos W=0.31u L=0.04u
M25859 U6564/net36 n5722 VSS VSS nmos W=0.155u L=0.04u
M25860 U6564/net19 n4025 VDD VDD pmos W=0.205u L=0.04u
M25861 n5744 U6564/net19 U6564/net26 VDD pmos W=0.325u L=0.04u
M25862 U6564/net26 n4437 VDD VDD pmos W=0.41u L=0.04u
M25863 n5744 n4025 U6564/net30 VDD pmos W=0.325u L=0.04u
M25864 U6564/net30 n5722 VDD VDD pmos W=0.205u L=0.04u
M25865 n5722 n4437 VSS VSS nmos W=0.155u L=0.04u
M25866 n5722 n5726 VSS VSS nmos W=0.155u L=0.04u
M25867 U6565/XI1-net8 n5726 VDD VDD pmos W=0.205u L=0.04u
M25868 n5722 n4437 U6565/XI1-net8 VDD pmos W=0.205u L=0.04u
M25869 n5726 U6566/net6 VSS VSS nmos W=0.155u L=0.04u
M25870 U6566/X_u2-net6 n5746 VSS VSS nmos W=0.155u L=0.04u
M25871 U6566/net6 n5745 U6566/X_u2-net6 VSS nmos W=0.155u L=0.04u
M25872 n5726 U6566/net6 VDD VDD pmos W=0.205u L=0.04u
M25873 U6566/net6 n5746 VDD VDD pmos W=0.205u L=0.04u
M25874 U6566/net6 n5745 VDD VDD pmos W=0.205u L=0.04u
M25875 n5746 n4010 VSS VSS nmos W=0.155u L=0.04u
M25876 n5746 n4009 VSS VSS nmos W=0.155u L=0.04u
M25877 n5746 n4008 VSS VSS nmos W=0.155u L=0.04u
M25878 n5746 n5747 VSS VSS nmos W=0.155u L=0.04u
M25879 U6567/net49 n4009 U6567/net52 VDD pmos W=0.41u L=0.04u
M25880 U6567/net52 n4010 VDD VDD pmos W=0.41u L=0.04u
M25881 U6567/net46 n4008 U6567/net49 VDD pmos W=0.41u L=0.04u
M25882 n5746 n5747 U6567/net46 VDD pmos W=0.41u L=0.04u
M25883 U6568/net36 n3997 U6568/net27 VSS nmos W=0.155u L=0.04u
M25884 U6568/net39 n4027 VSS VSS nmos W=0.155u L=0.04u
M25885 U6568/net27 g2084 U6568/net39 VSS nmos W=0.155u L=0.04u
M25886 U6568/net27 n3964 U6568/net39 VSS nmos W=0.155u L=0.04u
M25887 U6568/net36 g2085 U6568/net27 VSS nmos W=0.155u L=0.04u
M25888 U6568/net39 g2086 VSS VSS nmos W=0.155u L=0.04u
M25889 n4010 U6568/net36 VSS VSS nmos W=0.155u L=0.04u
M25890 n4010 U6568/net36 VDD VDD pmos W=0.205u L=0.04u
M25891 U6568/net36 n4027 U6568/net46 VDD pmos W=0.205u L=0.04u
M25892 U6568/net46 g2086 VDD VDD pmos W=0.205u L=0.04u
M25893 U6568/net36 g2085 U6568/net34 VDD pmos W=0.205u L=0.04u
M25894 U6568/net34 n3997 VDD VDD pmos W=0.205u L=0.04u
M25895 U6568/net36 n3964 U6568/net37 VDD pmos W=0.205u L=0.04u
M25896 U6568/net37 g2084 VDD VDD pmos W=0.205u L=0.04u
M25897 U6569/net36 n3997 U6569/net27 VSS nmos W=0.155u L=0.04u
M25898 U6569/net39 n4027 VSS VSS nmos W=0.155u L=0.04u
M25899 U6569/net27 g2105 U6569/net39 VSS nmos W=0.155u L=0.04u
M25900 U6569/net27 n3964 U6569/net39 VSS nmos W=0.155u L=0.04u
M25901 U6569/net36 g2106 U6569/net27 VSS nmos W=0.155u L=0.04u
M25902 U6569/net39 g2107 VSS VSS nmos W=0.155u L=0.04u
M25903 n4009 U6569/net36 VSS VSS nmos W=0.155u L=0.04u
M25904 n4009 U6569/net36 VDD VDD pmos W=0.205u L=0.04u
M25905 U6569/net36 n4027 U6569/net46 VDD pmos W=0.205u L=0.04u
M25906 U6569/net46 g2107 VDD VDD pmos W=0.205u L=0.04u
M25907 U6569/net36 g2106 U6569/net34 VDD pmos W=0.205u L=0.04u
M25908 U6569/net34 n3997 VDD VDD pmos W=0.205u L=0.04u
M25909 U6569/net36 n3964 U6569/net37 VDD pmos W=0.205u L=0.04u
M25910 U6569/net37 g2105 VDD VDD pmos W=0.205u L=0.04u
M25911 U6570/net36 n3997 U6570/net27 VSS nmos W=0.155u L=0.04u
M25912 U6570/net39 n4027 VSS VSS nmos W=0.155u L=0.04u
M25913 U6570/net27 g2102 U6570/net39 VSS nmos W=0.155u L=0.04u
M25914 U6570/net27 n3964 U6570/net39 VSS nmos W=0.155u L=0.04u
M25915 U6570/net36 g2103 U6570/net27 VSS nmos W=0.155u L=0.04u
M25916 U6570/net39 g2104 VSS VSS nmos W=0.155u L=0.04u
M25917 n4008 U6570/net36 VSS VSS nmos W=0.155u L=0.04u
M25918 n4008 U6570/net36 VDD VDD pmos W=0.205u L=0.04u
M25919 U6570/net36 n4027 U6570/net46 VDD pmos W=0.205u L=0.04u
M25920 U6570/net46 g2104 VDD VDD pmos W=0.205u L=0.04u
M25921 U6570/net36 g2103 U6570/net34 VDD pmos W=0.205u L=0.04u
M25922 U6570/net34 n3997 VDD VDD pmos W=0.205u L=0.04u
M25923 U6570/net36 n3964 U6570/net37 VDD pmos W=0.205u L=0.04u
M25924 U6570/net37 g2102 VDD VDD pmos W=0.205u L=0.04u
M25925 n5747 n4014 U6571/XI0-net10 VSS nmos W=0.155u L=0.04u
M25926 U6571/XI0-net10 n4026 U6571/XI0-net13 VSS nmos W=0.155u L=0.04u
M25927 U6571/XI0-net13 n4013 VSS VSS nmos W=0.155u L=0.04u
M25928 n5747 n4013 VDD VDD pmos W=0.205u L=0.04u
M25929 n5747 n4014 VDD VDD pmos W=0.205u L=0.04u
M25930 n5747 n4026 VDD VDD pmos W=0.205u L=0.04u
M25931 n4013 n3997 U6572/net27 VSS nmos W=0.155u L=0.04u
M25932 U6572/net39 n4027 VSS VSS nmos W=0.155u L=0.04u
M25933 U6572/net27 g2081 U6572/net39 VSS nmos W=0.155u L=0.04u
M25934 U6572/net27 n3964 U6572/net39 VSS nmos W=0.155u L=0.04u
M25935 n4013 g2082 U6572/net27 VSS nmos W=0.155u L=0.04u
M25936 U6572/net39 g2083 VSS VSS nmos W=0.155u L=0.04u
M25937 n4013 n4027 U6572/net46 VDD pmos W=0.205u L=0.04u
M25938 U6572/net46 g2083 VDD VDD pmos W=0.205u L=0.04u
M25939 n4013 g2082 U6572/net34 VDD pmos W=0.205u L=0.04u
M25940 U6572/net34 n3997 VDD VDD pmos W=0.205u L=0.04u
M25941 n4013 n3964 U6572/net37 VDD pmos W=0.205u L=0.04u
M25942 U6572/net37 g2081 VDD VDD pmos W=0.205u L=0.04u
M25943 n4026 n3997 U6573/net27 VSS nmos W=0.155u L=0.04u
M25944 U6573/net39 n4027 VSS VSS nmos W=0.155u L=0.04u
M25945 U6573/net27 g2111 U6573/net39 VSS nmos W=0.155u L=0.04u
M25946 U6573/net27 n3964 U6573/net39 VSS nmos W=0.155u L=0.04u
M25947 n4026 g2112 U6573/net27 VSS nmos W=0.155u L=0.04u
M25948 U6573/net39 g2113 VSS VSS nmos W=0.155u L=0.04u
M25949 n4026 n4027 U6573/net46 VDD pmos W=0.205u L=0.04u
M25950 U6573/net46 g2113 VDD VDD pmos W=0.205u L=0.04u
M25951 n4026 g2112 U6573/net34 VDD pmos W=0.205u L=0.04u
M25952 U6573/net34 n3997 VDD VDD pmos W=0.205u L=0.04u
M25953 n4026 n3964 U6573/net37 VDD pmos W=0.205u L=0.04u
M25954 U6573/net37 g2111 VDD VDD pmos W=0.205u L=0.04u
M25955 n4014 n3997 U6574/net27 VSS nmos W=0.155u L=0.04u
M25956 U6574/net39 n4027 VSS VSS nmos W=0.155u L=0.04u
M25957 U6574/net27 g2087 U6574/net39 VSS nmos W=0.155u L=0.04u
M25958 U6574/net27 n3964 U6574/net39 VSS nmos W=0.155u L=0.04u
M25959 n4014 g2088 U6574/net27 VSS nmos W=0.155u L=0.04u
M25960 U6574/net39 g2089 VSS VSS nmos W=0.155u L=0.04u
M25961 n4014 n4027 U6574/net46 VDD pmos W=0.205u L=0.04u
M25962 U6574/net46 g2089 VDD VDD pmos W=0.205u L=0.04u
M25963 n4014 g2088 U6574/net34 VDD pmos W=0.205u L=0.04u
M25964 U6574/net34 n3997 VDD VDD pmos W=0.205u L=0.04u
M25965 n4014 n3964 U6574/net37 VDD pmos W=0.205u L=0.04u
M25966 U6574/net37 g2087 VDD VDD pmos W=0.205u L=0.04u
M25967 n5745 n4020 VSS VSS nmos W=0.155u L=0.04u
M25968 n5745 n5749 VSS VSS nmos W=0.155u L=0.04u
M25969 n5745 n4019 VSS VSS nmos W=0.155u L=0.04u
M25970 n5745 n5748 VSS VSS nmos W=0.155u L=0.04u
M25971 U6575/net49 n5749 U6575/net52 VDD pmos W=0.41u L=0.04u
M25972 U6575/net52 n4020 VDD VDD pmos W=0.41u L=0.04u
M25973 U6575/net46 n4019 U6575/net49 VDD pmos W=0.41u L=0.04u
M25974 n5745 n5748 U6575/net46 VDD pmos W=0.41u L=0.04u
M25975 n4020 n3997 U6576/net27 VSS nmos W=0.155u L=0.04u
M25976 U6576/net39 n4027 VSS VSS nmos W=0.155u L=0.04u
M25977 U6576/net27 g2099 U6576/net39 VSS nmos W=0.155u L=0.04u
M25978 U6576/net27 n3964 U6576/net39 VSS nmos W=0.155u L=0.04u
M25979 n4020 g2100 U6576/net27 VSS nmos W=0.155u L=0.04u
M25980 U6576/net39 g2101 VSS VSS nmos W=0.155u L=0.04u
M25981 n4020 n4027 U6576/net46 VDD pmos W=0.205u L=0.04u
M25982 U6576/net46 g2101 VDD VDD pmos W=0.205u L=0.04u
M25983 n4020 g2100 U6576/net34 VDD pmos W=0.205u L=0.04u
M25984 U6576/net34 n3997 VDD VDD pmos W=0.205u L=0.04u
M25985 n4020 n3964 U6576/net37 VDD pmos W=0.205u L=0.04u
M25986 U6576/net37 g2099 VDD VDD pmos W=0.205u L=0.04u
M25987 U6577/net36 g2119 U6577/net27 VSS nmos W=0.155u L=0.04u
M25988 U6577/net39 g2118 VSS VSS nmos W=0.155u L=0.04u
M25989 U6577/net27 n3964 U6577/net39 VSS nmos W=0.155u L=0.04u
M25990 U6577/net27 g2117 U6577/net39 VSS nmos W=0.155u L=0.04u
M25991 U6577/net36 n4027 U6577/net27 VSS nmos W=0.155u L=0.04u
M25992 U6577/net39 n3997 VSS VSS nmos W=0.155u L=0.04u
M25993 n5749 U6577/net36 VSS VSS nmos W=0.155u L=0.04u
M25994 n5749 U6577/net36 VDD VDD pmos W=0.205u L=0.04u
M25995 U6577/net36 g2118 U6577/net46 VDD pmos W=0.205u L=0.04u
M25996 U6577/net46 n3997 VDD VDD pmos W=0.205u L=0.04u
M25997 U6577/net36 n4027 U6577/net34 VDD pmos W=0.205u L=0.04u
M25998 U6577/net34 g2119 VDD VDD pmos W=0.205u L=0.04u
M25999 U6577/net36 g2117 U6577/net37 VDD pmos W=0.205u L=0.04u
M26000 U6577/net37 n3964 VDD VDD pmos W=0.205u L=0.04u
M26001 n4019 n3997 U6578/net27 VSS nmos W=0.155u L=0.04u
M26002 U6578/net39 n4027 VSS VSS nmos W=0.155u L=0.04u
M26003 U6578/net27 g2096 U6578/net39 VSS nmos W=0.155u L=0.04u
M26004 U6578/net27 n3964 U6578/net39 VSS nmos W=0.155u L=0.04u
M26005 n4019 g2097 U6578/net27 VSS nmos W=0.155u L=0.04u
M26006 U6578/net39 g2098 VSS VSS nmos W=0.155u L=0.04u
M26007 n4019 n4027 U6578/net46 VDD pmos W=0.205u L=0.04u
M26008 U6578/net46 g2098 VDD VDD pmos W=0.205u L=0.04u
M26009 n4019 g2097 U6578/net34 VDD pmos W=0.205u L=0.04u
M26010 U6578/net34 n3997 VDD VDD pmos W=0.205u L=0.04u
M26011 n4019 n3964 U6578/net37 VDD pmos W=0.205u L=0.04u
M26012 U6578/net37 g2096 VDD VDD pmos W=0.205u L=0.04u
M26013 n5748 n4024 U6579/XI0-net10 VSS nmos W=0.155u L=0.04u
M26014 U6579/XI0-net10 n4021 U6579/XI0-net13 VSS nmos W=0.155u L=0.04u
M26015 U6579/XI0-net13 n4025 VSS VSS nmos W=0.155u L=0.04u
M26016 n5748 n4025 VDD VDD pmos W=0.205u L=0.04u
M26017 n5748 n4024 VDD VDD pmos W=0.205u L=0.04u
M26018 n5748 n4021 VDD VDD pmos W=0.205u L=0.04u
M26019 U6580/net36 n3997 U6580/net27 VSS nmos W=0.155u L=0.04u
M26020 U6580/net39 n4027 VSS VSS nmos W=0.155u L=0.04u
M26021 U6580/net27 g2093 U6580/net39 VSS nmos W=0.155u L=0.04u
M26022 U6580/net27 n3964 U6580/net39 VSS nmos W=0.155u L=0.04u
M26023 U6580/net36 g2094 U6580/net27 VSS nmos W=0.155u L=0.04u
M26024 U6580/net39 g2095 VSS VSS nmos W=0.155u L=0.04u
M26025 n4025 U6580/net36 VSS VSS nmos W=0.155u L=0.04u
M26026 n4025 U6580/net36 VDD VDD pmos W=0.205u L=0.04u
M26027 U6580/net36 n4027 U6580/net46 VDD pmos W=0.205u L=0.04u
M26028 U6580/net46 g2095 VDD VDD pmos W=0.205u L=0.04u
M26029 U6580/net36 g2094 U6580/net34 VDD pmos W=0.205u L=0.04u
M26030 U6580/net34 n3997 VDD VDD pmos W=0.205u L=0.04u
M26031 U6580/net36 n3964 U6580/net37 VDD pmos W=0.205u L=0.04u
M26032 U6580/net37 g2093 VDD VDD pmos W=0.205u L=0.04u
M26033 U6581/net36 n3997 U6581/net27 VSS nmos W=0.155u L=0.04u
M26034 U6581/net39 n4027 VSS VSS nmos W=0.155u L=0.04u
M26035 U6581/net27 g2090 U6581/net39 VSS nmos W=0.155u L=0.04u
M26036 U6581/net27 n3964 U6581/net39 VSS nmos W=0.155u L=0.04u
M26037 U6581/net36 g2091 U6581/net27 VSS nmos W=0.155u L=0.04u
M26038 U6581/net39 g2092 VSS VSS nmos W=0.155u L=0.04u
M26039 n4021 U6581/net36 VSS VSS nmos W=0.155u L=0.04u
M26040 n4021 U6581/net36 VDD VDD pmos W=0.205u L=0.04u
M26041 U6581/net36 n4027 U6581/net46 VDD pmos W=0.205u L=0.04u
M26042 U6581/net46 g2092 VDD VDD pmos W=0.205u L=0.04u
M26043 U6581/net36 g2091 U6581/net34 VDD pmos W=0.205u L=0.04u
M26044 U6581/net34 n3997 VDD VDD pmos W=0.205u L=0.04u
M26045 U6581/net36 n3964 U6581/net37 VDD pmos W=0.205u L=0.04u
M26046 U6581/net37 g2090 VDD VDD pmos W=0.205u L=0.04u
M26047 U6582/net36 n3997 U6582/net27 VSS nmos W=0.155u L=0.04u
M26048 U6582/net39 n4027 VSS VSS nmos W=0.155u L=0.04u
M26049 U6582/net27 g2078 U6582/net39 VSS nmos W=0.155u L=0.04u
M26050 U6582/net27 n3964 U6582/net39 VSS nmos W=0.155u L=0.04u
M26051 U6582/net36 g2079 U6582/net27 VSS nmos W=0.155u L=0.04u
M26052 U6582/net39 g2080 VSS VSS nmos W=0.155u L=0.04u
M26053 n4024 U6582/net36 VSS VSS nmos W=0.155u L=0.04u
M26054 n4024 U6582/net36 VDD VDD pmos W=0.205u L=0.04u
M26055 U6582/net36 n4027 U6582/net46 VDD pmos W=0.205u L=0.04u
M26056 U6582/net46 g2080 VDD VDD pmos W=0.205u L=0.04u
M26057 U6582/net36 g2079 U6582/net34 VDD pmos W=0.205u L=0.04u
M26058 U6582/net34 n3997 VDD VDD pmos W=0.205u L=0.04u
M26059 U6582/net36 n3964 U6582/net37 VDD pmos W=0.205u L=0.04u
M26060 U6582/net37 g2078 VDD VDD pmos W=0.205u L=0.04u
M26061 n4027 g7357 VSS VSS nmos W=0.135u L=0.04u
M26062 n4027 g7357 VDD VDD pmos W=0.205u L=0.04u
M26063 n3964 g2009 VSS VSS nmos W=0.135u L=0.04u
M26064 n3964 g2009 VDD VDD pmos W=0.205u L=0.04u
M26065 n3997 g7229 VSS VSS nmos W=0.135u L=0.04u
M26066 n3997 g7229 VDD VDD pmos W=0.205u L=0.04u
M26067 n4437 n4032 VSS VSS nmos W=0.135u L=0.04u
M26068 n4437 n4032 VDD VDD pmos W=0.205u L=0.04u
M26069 n4032 g1930 U6587/XI21-net17 VSS nmos W=0.155u L=0.04u
M26070 U6587/XI21-net17 g1991 VSS VSS nmos W=0.155u L=0.04u
M26071 n4032 g7052 U6587/XI6-net17 VSS nmos W=0.155u L=0.04u
M26072 U6587/XI6-net17 g1985 VSS VSS nmos W=0.155u L=0.04u
M26073 n4032 g7194 U6587/XI20-net17 VSS nmos W=0.155u L=0.04u
M26074 U6587/XI20-net17 g1988 VSS VSS nmos W=0.155u L=0.04u
M26075 VDD g1930 U6587/net22 VDD pmos W=0.205u L=0.04u
M26076 VDD g1991 U6587/net22 VDD pmos W=0.205u L=0.04u
M26077 U6587/net16 g7052 n4032 VDD pmos W=0.205u L=0.04u
M26078 U6587/net16 g1985 n4032 VDD pmos W=0.205u L=0.04u
M26079 U6587/net22 g7194 U6587/net16 VDD pmos W=0.205u L=0.04u
M26080 U6587/net22 g1988 U6587/net16 VDD pmos W=0.205u L=0.04u
M26081 g29761 g1196 U6588/net27 VSS nmos W=0.155u L=0.04u
M26082 U6588/net27 n5750 VSS VSS nmos W=0.155u L=0.04u
M26083 g29761 n5751 VSS VSS nmos W=0.155u L=0.04u
M26084 g29761 n5750 U6588/net13 VDD pmos W=0.205u L=0.04u
M26085 U6588/net13 n5751 VDD VDD pmos W=0.205u L=0.04u
M26086 g29761 g1196 U6588/net13 VDD pmos W=0.205u L=0.04u
M26087 n5751 n5752 U6589/net14 VSS nmos W=0.155u L=0.04u
M26088 U6589/net14 n4137 VSS VSS nmos W=0.155u L=0.04u
M26089 U6589/net14 n5755 VSS VSS nmos W=0.155u L=0.04u
M26090 n5751 n5754 U6589/net14 VSS nmos W=0.155u L=0.04u
M26091 n5751 n5753 U6589/net14 VSS nmos W=0.155u L=0.04u
M26092 n5751 n4137 U6589/XI16-net11 VDD pmos W=0.205u L=0.04u
M26093 U6589/XI16-net11 n5755 VDD VDD pmos W=0.205u L=0.04u
M26094 n5751 n5754 U6589/XI15-net11 VDD pmos W=0.205u L=0.04u
M26095 U6589/XI15-net11 n5753 U6589/XI15-net18 VDD pmos W=0.205u L=0.04u
M26096 U6589/XI15-net18 n5752 VDD VDD pmos W=0.205u L=0.04u
M26097 U6590/net4 n5756 U6590/net14 VSS nmos W=0.155u L=0.04u
M26098 U6590/net6 U6590/net10 U6590/net14 VSS nmos W=0.17u L=0.04u
M26099 U6590/net4 n5757 VSS VSS nmos W=0.155u L=0.04u
M26100 U6590/net6 U6590/net4 VSS VSS nmos W=0.17u L=0.04u
M26101 n5755 U6590/net14 VSS VSS nmos W=0.155u L=0.04u
M26102 U6590/net10 n5756 VSS VSS nmos W=0.155u L=0.04u
M26103 U6590/net4 U6590/net10 U6590/net14 VDD pmos W=0.255u L=0.04u
M26104 U6590/net6 n5756 U6590/net14 VDD pmos W=0.28u L=0.04u
M26105 U6590/net4 n5757 VDD VDD pmos W=0.205u L=0.04u
M26106 U6590/net6 U6590/net4 VDD VDD pmos W=0.24u L=0.04u
M26107 n5755 U6590/net14 VDD VDD pmos W=0.205u L=0.04u
M26108 U6590/net10 n5756 VDD VDD pmos W=0.205u L=0.04u
M26109 U6591/net19 n3937 VSS VSS nmos W=0.155u L=0.04u
M26110 n5752 n3937 U6591/net40 VSS nmos W=0.155u L=0.04u
M26111 n5752 U6591/net19 U6591/net36 VSS nmos W=0.155u L=0.04u
M26112 U6591/net40 g1227 VSS VSS nmos W=0.31u L=0.04u
M26113 U6591/net36 g1224 VSS VSS nmos W=0.155u L=0.04u
M26114 U6591/net19 n3937 VDD VDD pmos W=0.205u L=0.04u
M26115 n5752 U6591/net19 U6591/net26 VDD pmos W=0.325u L=0.04u
M26116 U6591/net26 g1227 VDD VDD pmos W=0.41u L=0.04u
M26117 n5752 n3937 U6591/net30 VDD pmos W=0.325u L=0.04u
M26118 U6591/net30 g1224 VDD VDD pmos W=0.205u L=0.04u
M26119 U6592/net4 U6592/net10 U6592/net14 VSS nmos W=0.155u L=0.04u
M26120 U6592/net6 n5758 U6592/net14 VSS nmos W=0.155u L=0.04u
M26121 U6592/net4 n5759 VSS VSS nmos W=0.155u L=0.04u
M26122 U6592/net6 U6592/net4 VSS VSS nmos W=0.155u L=0.04u
M26123 n5750 U6592/net14 VSS VSS nmos W=0.155u L=0.04u
M26124 U6592/net10 n5758 VSS VSS nmos W=0.155u L=0.04u
M26125 U6592/net4 n5758 U6592/net14 VDD pmos W=0.205u L=0.04u
M26126 U6592/net6 U6592/net10 U6592/net14 VDD pmos W=0.205u L=0.04u
M26127 U6592/net4 n5759 VDD VDD pmos W=0.205u L=0.04u
M26128 U6592/net6 U6592/net4 VDD VDD pmos W=0.205u L=0.04u
M26129 n5750 U6592/net14 VDD VDD pmos W=0.205u L=0.04u
M26130 U6592/net10 n5758 VDD VDD pmos W=0.205u L=0.04u
M26131 U6593/net28 U6593/net20 U6593/net64 VSS nmos W=0.155u L=0.04u
M26132 U6593/net24 U6593/net30 U6593/net32 VSS nmos W=0.155u L=0.04u
M26133 U6593/net28 U6593/net40 U6593/net24 VSS nmos W=0.155u L=0.04u
M26134 U6593/net40 n5763 U6593/net108 VSS nmos W=0.155u L=0.04u
M26135 U6593/net40 U6593/net106 U6593/net104 VSS nmos W=0.155u L=0.04u
M26136 U6593/net24 n5760 U6593/net050 VSS nmos W=0.155u L=0.04u
M26137 U6593/net050 U6593/net32 VSS VSS nmos W=0.155u L=0.04u
M26138 U6593/net20 U6593/net40 VSS VSS nmos W=0.155u L=0.04u
M26139 U6593/net106 n5763 VSS VSS nmos W=0.155u L=0.04u
M26140 U6593/net104 n5762 VSS VSS nmos W=0.155u L=0.04u
M26141 U6593/net30 n5760 VSS VSS nmos W=0.155u L=0.04u
M26142 U6593/net108 U6593/net104 VSS VSS nmos W=0.155u L=0.04u
M26143 n5759 U6593/net28 VSS VSS nmos W=0.155u L=0.04u
M26144 U6593/net32 n5761 VSS VSS nmos W=0.155u L=0.04u
M26145 U6593/net64 U6593/net24 VSS VSS nmos W=0.2u L=0.04u
M26146 U6593/net28 U6593/net40 U6593/net64 VDD pmos W=0.205u L=0.04u
M26147 U6593/net24 n5760 U6593/net32 VDD pmos W=0.205u L=0.04u
M26148 U6593/net28 U6593/net20 U6593/net24 VDD pmos W=0.205u L=0.04u
M26149 U6593/net40 U6593/net106 U6593/net108 VDD pmos W=0.205u L=0.04u
M26150 U6593/net40 n5763 U6593/net104 VDD pmos W=0.205u L=0.04u
M26151 U6593/net20 U6593/net40 VDD VDD pmos W=0.205u L=0.04u
M26152 U6593/net106 n5763 VDD VDD pmos W=0.205u L=0.04u
M26153 U6593/net104 n5762 VDD VDD pmos W=0.205u L=0.04u
M26154 U6593/net30 n5760 VDD VDD pmos W=0.205u L=0.04u
M26155 U6593/net108 U6593/net104 VDD VDD pmos W=0.205u L=0.04u
M26156 n5759 U6593/net28 VDD VDD pmos W=0.205u L=0.04u
M26157 U6593/net32 n5761 VDD VDD pmos W=0.205u L=0.04u
M26158 U6593/net64 U6593/net24 VDD VDD pmos W=0.28u L=0.04u
M26159 U6593/net24 U6593/net30 U6593/net045 VDD pmos W=0.205u L=0.04u
M26160 U6593/net045 U6593/net32 VDD VDD pmos W=0.205u L=0.04u
M26161 U6594/net28 U6594/net20 U6594/net64 VSS nmos W=0.155u L=0.04u
M26162 U6594/net24 U6594/net30 U6594/net32 VSS nmos W=0.155u L=0.04u
M26163 U6594/net28 U6594/net40 U6594/net24 VSS nmos W=0.155u L=0.04u
M26164 U6594/net40 n5767 U6594/net108 VSS nmos W=0.155u L=0.04u
M26165 U6594/net40 U6594/net106 U6594/net104 VSS nmos W=0.155u L=0.04u
M26166 U6594/net24 n5764 U6594/net050 VSS nmos W=0.155u L=0.04u
M26167 U6594/net050 U6594/net32 VSS VSS nmos W=0.155u L=0.04u
M26168 U6594/net20 U6594/net40 VSS VSS nmos W=0.155u L=0.04u
M26169 U6594/net106 n5767 VSS VSS nmos W=0.155u L=0.04u
M26170 U6594/net104 n5766 VSS VSS nmos W=0.155u L=0.04u
M26171 U6594/net30 n5764 VSS VSS nmos W=0.155u L=0.04u
M26172 U6594/net108 U6594/net104 VSS VSS nmos W=0.155u L=0.04u
M26173 n5758 U6594/net28 VSS VSS nmos W=0.155u L=0.04u
M26174 U6594/net32 n5765 VSS VSS nmos W=0.155u L=0.04u
M26175 U6594/net64 U6594/net24 VSS VSS nmos W=0.2u L=0.04u
M26176 U6594/net28 U6594/net40 U6594/net64 VDD pmos W=0.205u L=0.04u
M26177 U6594/net24 n5764 U6594/net32 VDD pmos W=0.205u L=0.04u
M26178 U6594/net28 U6594/net20 U6594/net24 VDD pmos W=0.205u L=0.04u
M26179 U6594/net40 U6594/net106 U6594/net108 VDD pmos W=0.205u L=0.04u
M26180 U6594/net40 n5767 U6594/net104 VDD pmos W=0.205u L=0.04u
M26181 U6594/net20 U6594/net40 VDD VDD pmos W=0.205u L=0.04u
M26182 U6594/net106 n5767 VDD VDD pmos W=0.205u L=0.04u
M26183 U6594/net104 n5766 VDD VDD pmos W=0.205u L=0.04u
M26184 U6594/net30 n5764 VDD VDD pmos W=0.205u L=0.04u
M26185 U6594/net108 U6594/net104 VDD VDD pmos W=0.205u L=0.04u
M26186 n5758 U6594/net28 VDD VDD pmos W=0.205u L=0.04u
M26187 U6594/net32 n5765 VDD VDD pmos W=0.205u L=0.04u
M26188 U6594/net64 U6594/net24 VDD VDD pmos W=0.28u L=0.04u
M26189 U6594/net24 U6594/net30 U6594/net045 VDD pmos W=0.205u L=0.04u
M26190 U6594/net045 U6594/net32 VDD VDD pmos W=0.205u L=0.04u
M26191 g29578 n5768 U6595/net27 VSS nmos W=0.155u L=0.04u
M26192 U6595/net27 n5769 VSS VSS nmos W=0.155u L=0.04u
M26193 g29578 n5770 VSS VSS nmos W=0.155u L=0.04u
M26194 g29578 n5769 U6595/net13 VDD pmos W=0.205u L=0.04u
M26195 U6595/net13 n5770 VDD VDD pmos W=0.205u L=0.04u
M26196 g29578 n5768 U6595/net13 VDD pmos W=0.205u L=0.04u
M26197 U6596/net17 n5753 VSS VSS nmos W=0.155u L=0.04u
M26198 U6596/net17 g1220 VSS VSS nmos W=0.155u L=0.04u
M26199 U6596/net63 n5771 VSS VSS nmos W=0.155u L=0.04u
M26200 n5768 U6596/net17 VSS VSS nmos W=0.155u L=0.04u
M26201 n5768 n5761 U6596/net63 VSS nmos W=0.155u L=0.04u
M26202 n5768 n5771 U6596/net31 VDD pmos W=0.205u L=0.04u
M26203 U6596/net39 n5753 VDD VDD pmos W=0.195u L=0.04u
M26204 U6596/net31 U6596/net17 VDD VDD pmos W=0.195u L=0.04u
M26205 n5768 n5761 U6596/net31 VDD pmos W=0.195u L=0.04u
M26206 U6596/net17 g1220 U6596/net39 VDD pmos W=0.195u L=0.04u
M26207 U6597/net7 n5772 U6597/X_u4-net10 VSS nmos W=0.155u L=0.04u
M26208 U6597/X_u4-net10 n5773 U6597/X_u4-net13 VSS nmos W=0.155u L=0.04u
M26209 U6597/X_u4-net13 n5774 VSS VSS nmos W=0.155u L=0.04u
M26210 n5761 U6597/net7 VSS VSS nmos W=0.155u L=0.04u
M26211 U6597/net7 n5774 VDD VDD pmos W=0.205u L=0.04u
M26212 U6597/net7 n5772 VDD VDD pmos W=0.205u L=0.04u
M26213 U6597/net7 n5773 VDD VDD pmos W=0.205u L=0.04u
M26214 n5761 U6597/net7 VDD VDD pmos W=0.205u L=0.04u
M26215 U6598/net19 n4118 VSS VSS nmos W=0.155u L=0.04u
M26216 n5774 n4118 U6598/net40 VSS nmos W=0.155u L=0.04u
M26217 n5774 U6598/net19 U6598/net36 VSS nmos W=0.155u L=0.04u
M26218 U6598/net40 n4167 VSS VSS nmos W=0.31u L=0.04u
M26219 U6598/net36 n5775 VSS VSS nmos W=0.155u L=0.04u
M26220 U6598/net19 n4118 VDD VDD pmos W=0.205u L=0.04u
M26221 n5774 U6598/net19 U6598/net26 VDD pmos W=0.325u L=0.04u
M26222 U6598/net26 n4167 VDD VDD pmos W=0.41u L=0.04u
M26223 n5774 n4118 U6598/net30 VDD pmos W=0.325u L=0.04u
M26224 U6598/net30 n5775 VDD VDD pmos W=0.205u L=0.04u
M26225 g29577 n5776 U6599/net27 VSS nmos W=0.155u L=0.04u
M26226 U6599/net27 n5769 VSS VSS nmos W=0.155u L=0.04u
M26227 g29577 n5777 VSS VSS nmos W=0.155u L=0.04u
M26228 g29577 n5769 U6599/net13 VDD pmos W=0.205u L=0.04u
M26229 U6599/net13 n5777 VDD VDD pmos W=0.205u L=0.04u
M26230 g29577 n5776 U6599/net13 VDD pmos W=0.205u L=0.04u
M26231 U6600/net17 n5753 VSS VSS nmos W=0.155u L=0.04u
M26232 U6600/net17 g1216 VSS VSS nmos W=0.155u L=0.04u
M26233 U6600/net63 n5771 VSS VSS nmos W=0.155u L=0.04u
M26234 n5776 U6600/net17 VSS VSS nmos W=0.155u L=0.04u
M26235 n5776 n5760 U6600/net63 VSS nmos W=0.155u L=0.04u
M26236 n5776 n5771 U6600/net31 VDD pmos W=0.205u L=0.04u
M26237 U6600/net39 n5753 VDD VDD pmos W=0.195u L=0.04u
M26238 U6600/net31 U6600/net17 VDD VDD pmos W=0.195u L=0.04u
M26239 n5776 n5760 U6600/net31 VDD pmos W=0.195u L=0.04u
M26240 U6600/net17 g1216 U6600/net39 VDD pmos W=0.195u L=0.04u
M26241 n5760 U6601/net6 VSS VSS nmos W=0.155u L=0.04u
M26242 U6601/X_u2-net6 n5772 VSS VSS nmos W=0.155u L=0.04u
M26243 U6601/net6 n5778 U6601/X_u2-net6 VSS nmos W=0.155u L=0.04u
M26244 n5760 U6601/net6 VDD VDD pmos W=0.205u L=0.04u
M26245 U6601/net6 n5772 VDD VDD pmos W=0.205u L=0.04u
M26246 U6601/net6 n5778 VDD VDD pmos W=0.205u L=0.04u
M26247 U6602/net19 n4127 VSS VSS nmos W=0.155u L=0.04u
M26248 n5778 n4127 U6602/net40 VSS nmos W=0.155u L=0.04u
M26249 n5778 U6602/net19 U6602/net36 VSS nmos W=0.155u L=0.04u
M26250 U6602/net40 n5775 VSS VSS nmos W=0.31u L=0.04u
M26251 U6602/net36 n4167 VSS VSS nmos W=0.155u L=0.04u
M26252 U6602/net19 n4127 VDD VDD pmos W=0.205u L=0.04u
M26253 n5778 U6602/net19 U6602/net26 VDD pmos W=0.325u L=0.04u
M26254 U6602/net26 n5775 VDD VDD pmos W=0.41u L=0.04u
M26255 n5778 n4127 U6602/net30 VDD pmos W=0.325u L=0.04u
M26256 U6602/net30 n4167 VDD VDD pmos W=0.205u L=0.04u
M26257 g29576 n5779 U6603/net27 VSS nmos W=0.155u L=0.04u
M26258 U6603/net27 n5769 VSS VSS nmos W=0.155u L=0.04u
M26259 g29576 n5770 VSS VSS nmos W=0.155u L=0.04u
M26260 g29576 n5769 U6603/net13 VDD pmos W=0.205u L=0.04u
M26261 U6603/net13 n5770 VDD VDD pmos W=0.205u L=0.04u
M26262 g29576 n5779 U6603/net13 VDD pmos W=0.205u L=0.04u
M26263 U6604/net17 n5753 VSS VSS nmos W=0.155u L=0.04u
M26264 U6604/net17 g1219 VSS VSS nmos W=0.155u L=0.04u
M26265 U6604/net63 n5771 VSS VSS nmos W=0.155u L=0.04u
M26266 n5779 U6604/net17 VSS VSS nmos W=0.155u L=0.04u
M26267 n5779 n5763 U6604/net63 VSS nmos W=0.155u L=0.04u
M26268 n5779 n5771 U6604/net31 VDD pmos W=0.205u L=0.04u
M26269 U6604/net39 n5753 VDD VDD pmos W=0.195u L=0.04u
M26270 U6604/net31 U6604/net17 VDD VDD pmos W=0.195u L=0.04u
M26271 n5779 n5763 U6604/net31 VDD pmos W=0.195u L=0.04u
M26272 U6604/net17 g1219 U6604/net39 VDD pmos W=0.195u L=0.04u
M26273 U6605/net7 n5772 U6605/X_u4-net10 VSS nmos W=0.155u L=0.04u
M26274 U6605/X_u4-net10 n5780 U6605/X_u4-net13 VSS nmos W=0.155u L=0.04u
M26275 U6605/X_u4-net13 n5781 VSS VSS nmos W=0.155u L=0.04u
M26276 n5763 U6605/net7 VSS VSS nmos W=0.155u L=0.04u
M26277 U6605/net7 n5781 VDD VDD pmos W=0.205u L=0.04u
M26278 U6605/net7 n5772 VDD VDD pmos W=0.205u L=0.04u
M26279 U6605/net7 n5780 VDD VDD pmos W=0.205u L=0.04u
M26280 n5763 U6605/net7 VDD VDD pmos W=0.205u L=0.04u
M26281 U6606/net19 n4122 VSS VSS nmos W=0.155u L=0.04u
M26282 n5781 n4122 U6606/net40 VSS nmos W=0.155u L=0.04u
M26283 n5781 U6606/net19 U6606/net36 VSS nmos W=0.155u L=0.04u
M26284 U6606/net40 n5782 VSS VSS nmos W=0.31u L=0.04u
M26285 U6606/net36 n4397 VSS VSS nmos W=0.155u L=0.04u
M26286 U6606/net19 n4122 VDD VDD pmos W=0.205u L=0.04u
M26287 n5781 U6606/net19 U6606/net26 VDD pmos W=0.325u L=0.04u
M26288 U6606/net26 n5782 VDD VDD pmos W=0.41u L=0.04u
M26289 n5781 n4122 U6606/net30 VDD pmos W=0.325u L=0.04u
M26290 U6606/net30 n4397 VDD VDD pmos W=0.205u L=0.04u
M26291 U6607/net29 n5757 VSS VSS nmos W=0.155u L=0.04u
M26292 g29574 n5784 U6607/net29 VSS nmos W=0.155u L=0.04u
M26293 g29574 n5783 U6607/net23 VSS nmos W=0.155u L=0.04u
M26294 U6607/net23 n5769 VSS VSS nmos W=0.155u L=0.04u
M26295 U6607/net20 n5769 g29574 VDD pmos W=0.205u L=0.04u
M26296 U6607/net20 n5783 g29574 VDD pmos W=0.205u L=0.04u
M26297 VDD n5784 U6607/net20 VDD pmos W=0.205u L=0.04u
M26298 VDD n5757 U6607/net20 VDD pmos W=0.205u L=0.04u
M26299 n5757 n5772 U6608/XI0-net10 VSS nmos W=0.155u L=0.04u
M26300 U6608/XI0-net10 n5773 U6608/XI0-net13 VSS nmos W=0.155u L=0.04u
M26301 U6608/XI0-net13 n5785 VSS VSS nmos W=0.155u L=0.04u
M26302 n5757 n5785 VDD VDD pmos W=0.205u L=0.04u
M26303 n5757 n5772 VDD VDD pmos W=0.205u L=0.04u
M26304 n5757 n5773 VDD VDD pmos W=0.205u L=0.04u
M26305 U6609/net19 n4116 VSS VSS nmos W=0.155u L=0.04u
M26306 n5785 n4116 U6609/net40 VSS nmos W=0.155u L=0.04u
M26307 n5785 U6609/net19 U6609/net36 VSS nmos W=0.155u L=0.04u
M26308 U6609/net40 n4167 VSS VSS nmos W=0.31u L=0.04u
M26309 U6609/net36 n5775 VSS VSS nmos W=0.155u L=0.04u
M26310 U6609/net19 n4116 VDD VDD pmos W=0.205u L=0.04u
M26311 n5785 U6609/net19 U6609/net26 VDD pmos W=0.325u L=0.04u
M26312 U6609/net26 n4167 VDD VDD pmos W=0.41u L=0.04u
M26313 n5785 n4116 U6609/net30 VDD pmos W=0.325u L=0.04u
M26314 U6609/net30 n5775 VDD VDD pmos W=0.205u L=0.04u
M26315 U6610/XU1-net6 n4167 VSS VSS nmos W=0.155u L=0.04u
M26316 n5773 n5786 U6610/XU1-net6 VSS nmos W=0.155u L=0.04u
M26317 n5773 n4167 VDD VDD pmos W=0.155u L=0.04u
M26318 n5773 n5786 VDD VDD pmos W=0.155u L=0.04u
M26319 U6611/net17 n5753 VSS VSS nmos W=0.155u L=0.04u
M26320 U6611/net17 g1223 VSS VSS nmos W=0.155u L=0.04u
M26321 U6611/net63 n5771 VSS VSS nmos W=0.155u L=0.04u
M26322 n5783 U6611/net17 VSS VSS nmos W=0.155u L=0.04u
M26323 n5783 n5762 U6611/net63 VSS nmos W=0.155u L=0.04u
M26324 n5783 n5771 U6611/net31 VDD pmos W=0.205u L=0.04u
M26325 U6611/net39 n5753 VDD VDD pmos W=0.195u L=0.04u
M26326 U6611/net31 U6611/net17 VDD VDD pmos W=0.195u L=0.04u
M26327 n5783 n5762 U6611/net31 VDD pmos W=0.195u L=0.04u
M26328 U6611/net17 g1223 U6611/net39 VDD pmos W=0.195u L=0.04u
M26329 n5762 U6612/net6 VSS VSS nmos W=0.155u L=0.04u
M26330 U6612/X_u2-net6 n5772 VSS VSS nmos W=0.155u L=0.04u
M26331 U6612/net6 n5787 U6612/X_u2-net6 VSS nmos W=0.155u L=0.04u
M26332 n5762 U6612/net6 VDD VDD pmos W=0.205u L=0.04u
M26333 U6612/net6 n5772 VDD VDD pmos W=0.205u L=0.04u
M26334 U6612/net6 n5787 VDD VDD pmos W=0.205u L=0.04u
M26335 U6613/net19 n4132 VSS VSS nmos W=0.155u L=0.04u
M26336 n5787 n4132 U6613/net40 VSS nmos W=0.155u L=0.04u
M26337 n5787 U6613/net19 U6613/net36 VSS nmos W=0.155u L=0.04u
M26338 U6613/net40 n4167 VSS VSS nmos W=0.31u L=0.04u
M26339 U6613/net36 n5775 VSS VSS nmos W=0.155u L=0.04u
M26340 U6613/net19 n4132 VDD VDD pmos W=0.205u L=0.04u
M26341 n5787 U6613/net19 U6613/net26 VDD pmos W=0.325u L=0.04u
M26342 U6613/net26 n4167 VDD VDD pmos W=0.41u L=0.04u
M26343 n5787 n4132 U6613/net30 VDD pmos W=0.325u L=0.04u
M26344 U6613/net30 n5775 VDD VDD pmos W=0.205u L=0.04u
M26345 U6614/net29 n5756 VSS VSS nmos W=0.155u L=0.04u
M26346 g29571 n5784 U6614/net29 VSS nmos W=0.155u L=0.04u
M26347 g29571 n5788 U6614/net23 VSS nmos W=0.155u L=0.04u
M26348 U6614/net23 n5769 VSS VSS nmos W=0.155u L=0.04u
M26349 U6614/net20 n5769 g29571 VDD pmos W=0.205u L=0.04u
M26350 U6614/net20 n5788 g29571 VDD pmos W=0.205u L=0.04u
M26351 VDD n5784 U6614/net20 VDD pmos W=0.205u L=0.04u
M26352 VDD n5756 U6614/net20 VDD pmos W=0.205u L=0.04u
M26353 n5756 n5772 U6615/XI0-net10 VSS nmos W=0.155u L=0.04u
M26354 U6615/XI0-net10 n5780 U6615/XI0-net13 VSS nmos W=0.155u L=0.04u
M26355 U6615/XI0-net13 n5789 VSS VSS nmos W=0.155u L=0.04u
M26356 n5756 n5789 VDD VDD pmos W=0.205u L=0.04u
M26357 n5756 n5772 VDD VDD pmos W=0.205u L=0.04u
M26358 n5756 n5780 VDD VDD pmos W=0.205u L=0.04u
M26359 U6616/net19 n4117 VSS VSS nmos W=0.155u L=0.04u
M26360 n5789 n4117 U6616/net40 VSS nmos W=0.155u L=0.04u
M26361 n5789 U6616/net19 U6616/net36 VSS nmos W=0.155u L=0.04u
M26362 U6616/net40 n4397 VSS VSS nmos W=0.31u L=0.04u
M26363 U6616/net36 n5782 VSS VSS nmos W=0.155u L=0.04u
M26364 U6616/net19 n4117 VDD VDD pmos W=0.205u L=0.04u
M26365 n5789 U6616/net19 U6616/net26 VDD pmos W=0.325u L=0.04u
M26366 U6616/net26 n4397 VDD VDD pmos W=0.41u L=0.04u
M26367 n5789 n4117 U6616/net30 VDD pmos W=0.325u L=0.04u
M26368 U6616/net30 n5782 VDD VDD pmos W=0.205u L=0.04u
M26369 U6617/net17 n5753 VSS VSS nmos W=0.155u L=0.04u
M26370 U6617/net17 g1222 VSS VSS nmos W=0.155u L=0.04u
M26371 U6617/net63 n5771 VSS VSS nmos W=0.155u L=0.04u
M26372 n5788 U6617/net17 VSS VSS nmos W=0.155u L=0.04u
M26373 n5788 n5765 U6617/net63 VSS nmos W=0.155u L=0.04u
M26374 n5788 n5771 U6617/net31 VDD pmos W=0.205u L=0.04u
M26375 U6617/net39 n5753 VDD VDD pmos W=0.195u L=0.04u
M26376 U6617/net31 U6617/net17 VDD VDD pmos W=0.195u L=0.04u
M26377 n5788 n5765 U6617/net31 VDD pmos W=0.195u L=0.04u
M26378 U6617/net17 g1222 U6617/net39 VDD pmos W=0.195u L=0.04u
M26379 U6618/net7 n5772 U6618/X_u4-net10 VSS nmos W=0.155u L=0.04u
M26380 U6618/X_u4-net10 n5780 U6618/X_u4-net13 VSS nmos W=0.155u L=0.04u
M26381 U6618/X_u4-net13 n5790 VSS VSS nmos W=0.155u L=0.04u
M26382 n5765 U6618/net7 VSS VSS nmos W=0.155u L=0.04u
M26383 U6618/net7 n5790 VDD VDD pmos W=0.205u L=0.04u
M26384 U6618/net7 n5772 VDD VDD pmos W=0.205u L=0.04u
M26385 U6618/net7 n5780 VDD VDD pmos W=0.205u L=0.04u
M26386 n5765 U6618/net7 VDD VDD pmos W=0.205u L=0.04u
M26387 U6619/net19 n4121 VSS VSS nmos W=0.155u L=0.04u
M26388 n5790 n4121 U6619/net40 VSS nmos W=0.155u L=0.04u
M26389 n5790 U6619/net19 U6619/net36 VSS nmos W=0.155u L=0.04u
M26390 U6619/net40 n5782 VSS VSS nmos W=0.31u L=0.04u
M26391 U6619/net36 n4397 VSS VSS nmos W=0.155u L=0.04u
M26392 U6619/net19 n4121 VDD VDD pmos W=0.205u L=0.04u
M26393 n5790 U6619/net19 U6619/net26 VDD pmos W=0.325u L=0.04u
M26394 U6619/net26 n5782 VDD VDD pmos W=0.41u L=0.04u
M26395 n5790 n4121 U6619/net30 VDD pmos W=0.325u L=0.04u
M26396 U6619/net30 n4397 VDD VDD pmos W=0.205u L=0.04u
M26397 U6620/XU1-net6 n4397 VSS VSS nmos W=0.155u L=0.04u
M26398 n5780 n5786 U6620/XU1-net6 VSS nmos W=0.155u L=0.04u
M26399 n5780 n4397 VDD VDD pmos W=0.155u L=0.04u
M26400 n5780 n5786 VDD VDD pmos W=0.155u L=0.04u
M26401 g29570 n5791 U6621/net27 VSS nmos W=0.155u L=0.04u
M26402 U6621/net27 n5769 VSS VSS nmos W=0.155u L=0.04u
M26403 g29570 n5792 VSS VSS nmos W=0.155u L=0.04u
M26404 g29570 n5769 U6621/net13 VDD pmos W=0.205u L=0.04u
M26405 U6621/net13 n5792 VDD VDD pmos W=0.205u L=0.04u
M26406 g29570 n5791 U6621/net13 VDD pmos W=0.205u L=0.04u
M26407 U6622/net17 n5753 VSS VSS nmos W=0.155u L=0.04u
M26408 U6622/net17 g1218 VSS VSS nmos W=0.155u L=0.04u
M26409 U6622/net63 n5771 VSS VSS nmos W=0.155u L=0.04u
M26410 n5791 U6622/net17 VSS VSS nmos W=0.155u L=0.04u
M26411 n5791 n5764 U6622/net63 VSS nmos W=0.155u L=0.04u
M26412 n5791 n5771 U6622/net31 VDD pmos W=0.205u L=0.04u
M26413 U6622/net39 n5753 VDD VDD pmos W=0.195u L=0.04u
M26414 U6622/net31 U6622/net17 VDD VDD pmos W=0.195u L=0.04u
M26415 n5791 n5764 U6622/net31 VDD pmos W=0.195u L=0.04u
M26416 U6622/net17 g1218 U6622/net39 VDD pmos W=0.195u L=0.04u
M26417 n5764 U6623/net6 VSS VSS nmos W=0.155u L=0.04u
M26418 U6623/X_u2-net6 n5772 VSS VSS nmos W=0.155u L=0.04u
M26419 U6623/net6 n5793 U6623/X_u2-net6 VSS nmos W=0.155u L=0.04u
M26420 n5764 U6623/net6 VDD VDD pmos W=0.205u L=0.04u
M26421 U6623/net6 n5772 VDD VDD pmos W=0.205u L=0.04u
M26422 U6623/net6 n5793 VDD VDD pmos W=0.205u L=0.04u
M26423 U6624/net19 n4129 VSS VSS nmos W=0.155u L=0.04u
M26424 n5793 n4129 U6624/net40 VSS nmos W=0.155u L=0.04u
M26425 n5793 U6624/net19 U6624/net36 VSS nmos W=0.155u L=0.04u
M26426 U6624/net40 n4167 VSS VSS nmos W=0.31u L=0.04u
M26427 U6624/net36 n5775 VSS VSS nmos W=0.155u L=0.04u
M26428 U6624/net19 n4129 VDD VDD pmos W=0.205u L=0.04u
M26429 n5793 U6624/net19 U6624/net26 VDD pmos W=0.325u L=0.04u
M26430 U6624/net26 n4167 VDD VDD pmos W=0.41u L=0.04u
M26431 n5793 n4129 U6624/net30 VDD pmos W=0.325u L=0.04u
M26432 U6624/net30 n5775 VDD VDD pmos W=0.205u L=0.04u
M26433 n5775 n4167 VSS VSS nmos W=0.155u L=0.04u
M26434 n5775 n5786 VSS VSS nmos W=0.155u L=0.04u
M26435 U6625/XI1-net8 n5786 VDD VDD pmos W=0.205u L=0.04u
M26436 n5775 n4167 U6625/XI1-net8 VDD pmos W=0.205u L=0.04u
M26437 n4167 n4148 VSS VSS nmos W=0.135u L=0.04u
M26438 n4167 n4148 VDD VDD pmos W=0.205u L=0.04u
M26439 n4148 g1236 U6627/XI21-net17 VSS nmos W=0.155u L=0.04u
M26440 U6627/XI21-net17 g1306 VSS VSS nmos W=0.155u L=0.04u
M26441 n4148 g6750 U6627/XI6-net17 VSS nmos W=0.155u L=0.04u
M26442 U6627/XI6-net17 g1300 VSS VSS nmos W=0.155u L=0.04u
M26443 n4148 g6944 U6627/XI20-net17 VSS nmos W=0.155u L=0.04u
M26444 U6627/XI20-net17 g1303 VSS VSS nmos W=0.155u L=0.04u
M26445 VDD g1236 U6627/net22 VDD pmos W=0.205u L=0.04u
M26446 VDD g1306 U6627/net22 VDD pmos W=0.205u L=0.04u
M26447 U6627/net16 g6750 n4148 VDD pmos W=0.205u L=0.04u
M26448 U6627/net16 g1300 n4148 VDD pmos W=0.205u L=0.04u
M26449 U6627/net22 g6944 U6627/net16 VDD pmos W=0.205u L=0.04u
M26450 U6627/net22 g1303 U6627/net16 VDD pmos W=0.205u L=0.04u
M26451 g29569 n5794 U6628/net27 VSS nmos W=0.155u L=0.04u
M26452 U6628/net27 n5769 VSS VSS nmos W=0.155u L=0.04u
M26453 g29569 n5792 VSS VSS nmos W=0.155u L=0.04u
M26454 g29569 n5769 U6628/net13 VDD pmos W=0.205u L=0.04u
M26455 U6628/net13 n5792 VDD VDD pmos W=0.205u L=0.04u
M26456 g29569 n5794 U6628/net13 VDD pmos W=0.205u L=0.04u
M26457 U6629/XU35-net6 n5784 VSS VSS nmos W=0.155u L=0.04u
M26458 U6629/net5 n5795 U6629/XU35-net6 VSS nmos W=0.155u L=0.04u
M26459 U6629/XU36-net6 U6629/net5 VSS VSS nmos W=0.155u L=0.04u
M26460 n5792 n5796 U6629/XU36-net6 VSS nmos W=0.155u L=0.04u
M26461 U6629/net5 n5784 VDD VDD pmos W=0.205u L=0.04u
M26462 U6629/net5 n5795 VDD VDD pmos W=0.205u L=0.04u
M26463 n5792 U6629/net5 VDD VDD pmos W=0.205u L=0.04u
M26464 n5792 n5796 VDD VDD pmos W=0.205u L=0.04u
M26465 U6630/net17 n5753 VSS VSS nmos W=0.155u L=0.04u
M26466 U6630/net17 g1215 VSS VSS nmos W=0.155u L=0.04u
M26467 U6630/net63 n5771 VSS VSS nmos W=0.155u L=0.04u
M26468 n5794 U6630/net17 VSS VSS nmos W=0.155u L=0.04u
M26469 n5794 n5767 U6630/net63 VSS nmos W=0.155u L=0.04u
M26470 n5794 n5771 U6630/net31 VDD pmos W=0.205u L=0.04u
M26471 U6630/net39 n5753 VDD VDD pmos W=0.195u L=0.04u
M26472 U6630/net31 U6630/net17 VDD VDD pmos W=0.195u L=0.04u
M26473 n5794 n5767 U6630/net31 VDD pmos W=0.195u L=0.04u
M26474 U6630/net17 g1215 U6630/net39 VDD pmos W=0.195u L=0.04u
M26475 n5767 U6631/net6 VSS VSS nmos W=0.155u L=0.04u
M26476 U6631/X_u2-net6 n5772 VSS VSS nmos W=0.155u L=0.04u
M26477 U6631/net6 n5797 U6631/X_u2-net6 VSS nmos W=0.155u L=0.04u
M26478 n5767 U6631/net6 VDD VDD pmos W=0.205u L=0.04u
M26479 U6631/net6 n5772 VDD VDD pmos W=0.205u L=0.04u
M26480 U6631/net6 n5797 VDD VDD pmos W=0.205u L=0.04u
M26481 U6632/net19 n4128 VSS VSS nmos W=0.155u L=0.04u
M26482 n5797 n4128 U6632/net40 VSS nmos W=0.155u L=0.04u
M26483 n5797 U6632/net19 U6632/net36 VSS nmos W=0.155u L=0.04u
M26484 U6632/net40 n5782 VSS VSS nmos W=0.31u L=0.04u
M26485 U6632/net36 n4397 VSS VSS nmos W=0.155u L=0.04u
M26486 U6632/net19 n4128 VDD VDD pmos W=0.205u L=0.04u
M26487 n5797 U6632/net19 U6632/net26 VDD pmos W=0.325u L=0.04u
M26488 U6632/net26 n5782 VDD VDD pmos W=0.41u L=0.04u
M26489 n5797 n4128 U6632/net30 VDD pmos W=0.325u L=0.04u
M26490 U6632/net30 n4397 VDD VDD pmos W=0.205u L=0.04u
M26491 g29552 n5798 U6633/net27 VSS nmos W=0.155u L=0.04u
M26492 U6633/net27 n5769 VSS VSS nmos W=0.155u L=0.04u
M26493 g29552 n5777 VSS VSS nmos W=0.155u L=0.04u
M26494 g29552 n5769 U6633/net13 VDD pmos W=0.205u L=0.04u
M26495 U6633/net13 n5777 VDD VDD pmos W=0.205u L=0.04u
M26496 g29552 n5798 U6633/net13 VDD pmos W=0.205u L=0.04u
M26497 n5777 n5799 U6634/net15 VSS nmos W=0.155u L=0.04u
M26498 n5777 n5795 U6634/net15 VSS nmos W=0.155u L=0.04u
M26499 U6634/net15 n5796 VSS VSS nmos W=0.155u L=0.04u
M26500 n5777 n5796 VDD VDD pmos W=0.205u L=0.04u
M26501 n5777 n5799 U6634/XI16-net11 VDD pmos W=0.205u L=0.04u
M26502 U6634/XI16-net11 n5795 VDD VDD pmos W=0.205u L=0.04u
M26503 n5796 n5770 VSS VSS nmos W=0.135u L=0.04u
M26504 n5796 n5770 VDD VDD pmos W=0.205u L=0.04u
M26505 n5770 n5799 VSS VSS nmos W=0.155u L=0.04u
M26506 n5770 n5800 VSS VSS nmos W=0.155u L=0.04u
M26507 U6636/XI1-net8 n5800 VDD VDD pmos W=0.205u L=0.04u
M26508 n5770 n5799 U6636/XI1-net8 VDD pmos W=0.205u L=0.04u
M26509 VSS g1186 U6637/net22 VSS nmos W=0.155u L=0.04u
M26510 U6637/net22 n5802 n5795 VSS nmos W=0.155u L=0.04u
M26511 U6637/net22 n5786 n5795 VSS nmos W=0.155u L=0.04u
M26512 U6637/net22 n5801 n5795 VSS nmos W=0.155u L=0.04u
M26513 U6637/net38 n5801 VDD VDD pmos W=0.205u L=0.04u
M26514 U6637/net35 n5786 U6637/net38 VDD pmos W=0.205u L=0.04u
M26515 n5795 n5802 U6637/net35 VDD pmos W=0.205u L=0.04u
M26516 n5795 g1186 VDD VDD pmos W=0.205u L=0.04u
M26517 n5802 g1420 VSS VSS nmos W=0.155u L=0.04u
M26518 n5802 n4072 VSS VSS nmos W=0.155u L=0.04u
M26519 U6638/XI1-net8 n4072 VDD VDD pmos W=0.205u L=0.04u
M26520 n5802 g1420 U6638/XI1-net8 VDD pmos W=0.205u L=0.04u
M26521 n5801 g1421 U6639/net10 VSS nmos W=0.155u L=0.04u
M26522 U6639/net10 n4135 VSS VSS nmos W=0.155u L=0.04u
M26523 n5801 n4105 U6639/net10 VSS nmos W=0.155u L=0.04u
M26524 U6639/net10 g1422 VSS VSS nmos W=0.155u L=0.04u
M26525 U6639/net30 n4135 VDD VDD pmos W=0.205u L=0.04u
M26526 n5801 g1421 U6639/net24 VDD pmos W=0.205u L=0.04u
M26527 U6639/net24 n4105 VDD VDD pmos W=0.205u L=0.04u
M26528 n5801 g1422 U6639/net30 VDD pmos W=0.205u L=0.04u
M26529 n5799 n5784 VSS VSS nmos W=0.135u L=0.04u
M26530 n5799 n5784 VDD VDD pmos W=0.205u L=0.04u
M26531 n5784 n5771 VSS VSS nmos W=0.155u L=0.04u
M26532 n5784 n5769 VSS VSS nmos W=0.155u L=0.04u
M26533 U6641/XI1-net8 n5769 VDD VDD pmos W=0.205u L=0.04u
M26534 n5784 n5771 U6641/XI1-net8 VDD pmos W=0.205u L=0.04u
M26535 n5769 n5754 VSS VSS nmos W=0.135u L=0.04u
M26536 n5769 n5754 VDD VDD pmos W=0.205u L=0.04u
M26537 n5754 g1196 U6643/net15 VSS nmos W=0.155u L=0.04u
M26538 n5754 g1211 U6643/net15 VSS nmos W=0.155u L=0.04u
M26539 U6643/net15 n4137 VSS VSS nmos W=0.155u L=0.04u
M26540 n5754 n4137 VDD VDD pmos W=0.205u L=0.04u
M26541 n5754 g1196 U6643/XI16-net11 VDD pmos W=0.205u L=0.04u
M26542 U6643/XI16-net11 g1211 VDD VDD pmos W=0.205u L=0.04u
M26543 n4137 g1243 VSS VSS nmos W=0.135u L=0.04u
M26544 n4137 g1243 VDD VDD pmos W=0.205u L=0.04u
M26545 U6645/net17 n5753 VSS VSS nmos W=0.155u L=0.04u
M26546 U6645/net17 g1217 VSS VSS nmos W=0.155u L=0.04u
M26547 U6645/net63 n5771 VSS VSS nmos W=0.155u L=0.04u
M26548 n5798 U6645/net17 VSS VSS nmos W=0.155u L=0.04u
M26549 n5798 n5766 U6645/net63 VSS nmos W=0.155u L=0.04u
M26550 n5798 n5771 U6645/net31 VDD pmos W=0.205u L=0.04u
M26551 U6645/net39 n5753 VDD VDD pmos W=0.195u L=0.04u
M26552 U6645/net31 U6645/net17 VDD VDD pmos W=0.195u L=0.04u
M26553 n5798 n5766 U6645/net31 VDD pmos W=0.195u L=0.04u
M26554 U6645/net17 g1217 U6645/net39 VDD pmos W=0.195u L=0.04u
M26555 U6646/XU1-net6 n5803 VSS VSS nmos W=0.155u L=0.04u
M26556 n5753 n5800 U6646/XU1-net6 VSS nmos W=0.155u L=0.04u
M26557 n5753 n5803 VDD VDD pmos W=0.155u L=0.04u
M26558 n5753 n5800 VDD VDD pmos W=0.155u L=0.04u
M26559 n5771 n5803 VSS VSS nmos W=0.135u L=0.04u
M26560 n5771 n5803 VDD VDD pmos W=0.205u L=0.04u
M26561 U6648/net11 g1211 VSS VSS nmos W=0.155u L=0.04u
M26562 U6648/net11 g1243 VSS VSS nmos W=0.155u L=0.04u
M26563 n5803 g1196 VSS VSS nmos W=0.155u L=0.04u
M26564 n5803 U6648/net11 VSS VSS nmos W=0.155u L=0.04u
M26565 U6648/XI1-net8 g1243 VDD VDD pmos W=0.205u L=0.04u
M26566 U6648/net11 g1211 U6648/XI1-net8 VDD pmos W=0.205u L=0.04u
M26567 U6648/XU39-net8 U6648/net11 VDD VDD pmos W=0.205u L=0.04u
M26568 n5803 g1196 U6648/XU39-net8 VDD pmos W=0.205u L=0.04u
M26569 n5766 U6649/net6 VSS VSS nmos W=0.155u L=0.04u
M26570 U6649/X_u2-net6 n5772 VSS VSS nmos W=0.155u L=0.04u
M26571 U6649/net6 n5804 U6649/X_u2-net6 VSS nmos W=0.155u L=0.04u
M26572 n5766 U6649/net6 VDD VDD pmos W=0.205u L=0.04u
M26573 U6649/net6 n5772 VDD VDD pmos W=0.205u L=0.04u
M26574 U6649/net6 n5804 VDD VDD pmos W=0.205u L=0.04u
M26575 n5772 II15505 VSS VSS nmos W=0.155u L=0.04u
M26576 n5772 U6650/net4 VSS VSS nmos W=0.155u L=0.04u
M26577 U6650/net4 n5800 VSS VSS nmos W=0.155u L=0.04u
M26578 U6650/XU1-net8 U6650/net4 VDD VDD pmos W=0.205u L=0.04u
M26579 n5772 II15505 U6650/XU1-net8 VDD pmos W=0.205u L=0.04u
M26580 U6650/net4 n5800 VDD VDD pmos W=0.205u L=0.04u
M26581 n5800 n4518 VSS VSS nmos W=0.155u L=0.04u
M26582 n5800 g1245 VSS VSS nmos W=0.155u L=0.04u
M26583 n5800 g1249 VSS VSS nmos W=0.155u L=0.04u
M26584 U6651/net25 n4518 VDD VDD pmos W=0.41u L=0.04u
M26585 U6651/net28 g1245 U6651/net25 VDD pmos W=0.41u L=0.04u
M26586 n5800 g1249 U6651/net28 VDD pmos W=0.41u L=0.04u
M26587 n4518 n3398 VSS VSS nmos W=0.135u L=0.04u
M26588 n4518 n3398 VDD VDD pmos W=0.205u L=0.04u
M26589 U6653/PG2 g1230 VSS VSS nmos W=0.31u L=0.04u
M26590 U6653/net55 n4517 VSS VSS nmos W=0.31u L=0.04u
M26591 U6653/net51 g6750 VSS VSS nmos W=0.155u L=0.04u
M26592 U6653/net53 g1234 VSS VSS nmos W=0.155u L=0.04u
M26593 U6653/net29 g1186 VSS VSS nmos W=0.155u L=0.04u
M26594 U6653/net53 U6653/net51 U6653/PG1 VSS nmos W=0.155u L=0.04u
M26595 U6653/net55 g6750 U6653/PG1 VSS nmos W=0.21u L=0.04u
M26596 U6653/PG2 g1186 n3398 VSS nmos W=0.22u L=0.04u
M26597 U6653/PG1 U6653/net29 n3398 VSS nmos W=0.155u L=0.04u
M26598 U6653/PG2 g1230 VDD VDD pmos W=0.41u L=0.04u
M26599 U6653/net55 n4517 VDD VDD pmos W=0.41u L=0.04u
M26600 U6653/net51 g6750 VDD VDD pmos W=0.205u L=0.04u
M26601 U6653/net53 g1234 VDD VDD pmos W=0.28u L=0.04u
M26602 U6653/net29 g1186 VDD VDD pmos W=0.205u L=0.04u
M26603 U6653/net53 g6750 U6653/PG1 VDD pmos W=0.27u L=0.04u
M26604 U6653/net55 U6653/net51 U6653/PG1 VDD pmos W=0.285u L=0.04u
M26605 U6653/PG2 U6653/net29 n3398 VDD pmos W=0.205u L=0.04u
M26606 U6653/PG1 g1186 n3398 VDD pmos W=0.28u L=0.04u
M26607 U6654/net19 n4133 VSS VSS nmos W=0.155u L=0.04u
M26608 n5804 n4133 U6654/net40 VSS nmos W=0.155u L=0.04u
M26609 n5804 U6654/net19 U6654/net36 VSS nmos W=0.155u L=0.04u
M26610 U6654/net40 n4397 VSS VSS nmos W=0.31u L=0.04u
M26611 U6654/net36 n5782 VSS VSS nmos W=0.155u L=0.04u
M26612 U6654/net19 n4133 VDD VDD pmos W=0.205u L=0.04u
M26613 n5804 U6654/net19 U6654/net26 VDD pmos W=0.325u L=0.04u
M26614 U6654/net26 n4397 VDD VDD pmos W=0.41u L=0.04u
M26615 n5804 n4133 U6654/net30 VDD pmos W=0.325u L=0.04u
M26616 U6654/net30 n5782 VDD VDD pmos W=0.205u L=0.04u
M26617 n5782 n4397 VSS VSS nmos W=0.155u L=0.04u
M26618 n5782 n5786 VSS VSS nmos W=0.155u L=0.04u
M26619 U6655/XI1-net8 n5786 VDD VDD pmos W=0.205u L=0.04u
M26620 n5782 n4397 U6655/XI1-net8 VDD pmos W=0.205u L=0.04u
M26621 n5786 U6656/net6 VSS VSS nmos W=0.155u L=0.04u
M26622 U6656/X_u2-net6 n5806 VSS VSS nmos W=0.155u L=0.04u
M26623 U6656/net6 n5805 U6656/X_u2-net6 VSS nmos W=0.155u L=0.04u
M26624 n5786 U6656/net6 VDD VDD pmos W=0.205u L=0.04u
M26625 U6656/net6 n5806 VDD VDD pmos W=0.205u L=0.04u
M26626 U6656/net6 n5805 VDD VDD pmos W=0.205u L=0.04u
M26627 n5806 n4118 VSS VSS nmos W=0.155u L=0.04u
M26628 n5806 n4117 VSS VSS nmos W=0.155u L=0.04u
M26629 n5806 n4116 VSS VSS nmos W=0.155u L=0.04u
M26630 n5806 n5807 VSS VSS nmos W=0.155u L=0.04u
M26631 U6657/net49 n4117 U6657/net52 VDD pmos W=0.41u L=0.04u
M26632 U6657/net52 n4118 VDD VDD pmos W=0.41u L=0.04u
M26633 U6657/net46 n4116 U6657/net49 VDD pmos W=0.41u L=0.04u
M26634 n5806 n5807 U6657/net46 VDD pmos W=0.41u L=0.04u
M26635 U6658/net36 n4105 U6658/net27 VSS nmos W=0.155u L=0.04u
M26636 U6658/net39 n4135 VSS VSS nmos W=0.155u L=0.04u
M26637 U6658/net27 g1390 U6658/net39 VSS nmos W=0.155u L=0.04u
M26638 U6658/net27 n4072 U6658/net39 VSS nmos W=0.155u L=0.04u
M26639 U6658/net36 g1391 U6658/net27 VSS nmos W=0.155u L=0.04u
M26640 U6658/net39 g1392 VSS VSS nmos W=0.155u L=0.04u
M26641 n4118 U6658/net36 VSS VSS nmos W=0.155u L=0.04u
M26642 n4118 U6658/net36 VDD VDD pmos W=0.205u L=0.04u
M26643 U6658/net36 n4135 U6658/net46 VDD pmos W=0.205u L=0.04u
M26644 U6658/net46 g1392 VDD VDD pmos W=0.205u L=0.04u
M26645 U6658/net36 g1391 U6658/net34 VDD pmos W=0.205u L=0.04u
M26646 U6658/net34 n4105 VDD VDD pmos W=0.205u L=0.04u
M26647 U6658/net36 n4072 U6658/net37 VDD pmos W=0.205u L=0.04u
M26648 U6658/net37 g1390 VDD VDD pmos W=0.205u L=0.04u
M26649 U6659/net36 n4105 U6659/net27 VSS nmos W=0.155u L=0.04u
M26650 U6659/net39 n4135 VSS VSS nmos W=0.155u L=0.04u
M26651 U6659/net27 g1411 U6659/net39 VSS nmos W=0.155u L=0.04u
M26652 U6659/net27 n4072 U6659/net39 VSS nmos W=0.155u L=0.04u
M26653 U6659/net36 g1412 U6659/net27 VSS nmos W=0.155u L=0.04u
M26654 U6659/net39 g1413 VSS VSS nmos W=0.155u L=0.04u
M26655 n4117 U6659/net36 VSS VSS nmos W=0.155u L=0.04u
M26656 n4117 U6659/net36 VDD VDD pmos W=0.205u L=0.04u
M26657 U6659/net36 n4135 U6659/net46 VDD pmos W=0.205u L=0.04u
M26658 U6659/net46 g1413 VDD VDD pmos W=0.205u L=0.04u
M26659 U6659/net36 g1412 U6659/net34 VDD pmos W=0.205u L=0.04u
M26660 U6659/net34 n4105 VDD VDD pmos W=0.205u L=0.04u
M26661 U6659/net36 n4072 U6659/net37 VDD pmos W=0.205u L=0.04u
M26662 U6659/net37 g1411 VDD VDD pmos W=0.205u L=0.04u
M26663 U6660/net36 n4105 U6660/net27 VSS nmos W=0.155u L=0.04u
M26664 U6660/net39 n4135 VSS VSS nmos W=0.155u L=0.04u
M26665 U6660/net27 g1408 U6660/net39 VSS nmos W=0.155u L=0.04u
M26666 U6660/net27 n4072 U6660/net39 VSS nmos W=0.155u L=0.04u
M26667 U6660/net36 g1409 U6660/net27 VSS nmos W=0.155u L=0.04u
M26668 U6660/net39 g1410 VSS VSS nmos W=0.155u L=0.04u
M26669 n4116 U6660/net36 VSS VSS nmos W=0.155u L=0.04u
M26670 n4116 U6660/net36 VDD VDD pmos W=0.205u L=0.04u
M26671 U6660/net36 n4135 U6660/net46 VDD pmos W=0.205u L=0.04u
M26672 U6660/net46 g1410 VDD VDD pmos W=0.205u L=0.04u
M26673 U6660/net36 g1409 U6660/net34 VDD pmos W=0.205u L=0.04u
M26674 U6660/net34 n4105 VDD VDD pmos W=0.205u L=0.04u
M26675 U6660/net36 n4072 U6660/net37 VDD pmos W=0.205u L=0.04u
M26676 U6660/net37 g1408 VDD VDD pmos W=0.205u L=0.04u
M26677 n5807 n4122 U6661/XI0-net10 VSS nmos W=0.155u L=0.04u
M26678 U6661/XI0-net10 n4134 U6661/XI0-net13 VSS nmos W=0.155u L=0.04u
M26679 U6661/XI0-net13 n4121 VSS VSS nmos W=0.155u L=0.04u
M26680 n5807 n4121 VDD VDD pmos W=0.205u L=0.04u
M26681 n5807 n4122 VDD VDD pmos W=0.205u L=0.04u
M26682 n5807 n4134 VDD VDD pmos W=0.205u L=0.04u
M26683 n4121 n4105 U6662/net27 VSS nmos W=0.155u L=0.04u
M26684 U6662/net39 n4135 VSS VSS nmos W=0.155u L=0.04u
M26685 U6662/net27 g1387 U6662/net39 VSS nmos W=0.155u L=0.04u
M26686 U6662/net27 n4072 U6662/net39 VSS nmos W=0.155u L=0.04u
M26687 n4121 g1388 U6662/net27 VSS nmos W=0.155u L=0.04u
M26688 U6662/net39 g1389 VSS VSS nmos W=0.155u L=0.04u
M26689 n4121 n4135 U6662/net46 VDD pmos W=0.205u L=0.04u
M26690 U6662/net46 g1389 VDD VDD pmos W=0.205u L=0.04u
M26691 n4121 g1388 U6662/net34 VDD pmos W=0.205u L=0.04u
M26692 U6662/net34 n4105 VDD VDD pmos W=0.205u L=0.04u
M26693 n4121 n4072 U6662/net37 VDD pmos W=0.205u L=0.04u
M26694 U6662/net37 g1387 VDD VDD pmos W=0.205u L=0.04u
M26695 n4134 n4105 U6663/net27 VSS nmos W=0.155u L=0.04u
M26696 U6663/net39 n4135 VSS VSS nmos W=0.155u L=0.04u
M26697 U6663/net27 g1417 U6663/net39 VSS nmos W=0.155u L=0.04u
M26698 U6663/net27 n4072 U6663/net39 VSS nmos W=0.155u L=0.04u
M26699 n4134 g1418 U6663/net27 VSS nmos W=0.155u L=0.04u
M26700 U6663/net39 g1419 VSS VSS nmos W=0.155u L=0.04u
M26701 n4134 n4135 U6663/net46 VDD pmos W=0.205u L=0.04u
M26702 U6663/net46 g1419 VDD VDD pmos W=0.205u L=0.04u
M26703 n4134 g1418 U6663/net34 VDD pmos W=0.205u L=0.04u
M26704 U6663/net34 n4105 VDD VDD pmos W=0.205u L=0.04u
M26705 n4134 n4072 U6663/net37 VDD pmos W=0.205u L=0.04u
M26706 U6663/net37 g1417 VDD VDD pmos W=0.205u L=0.04u
M26707 n4122 n4105 U6664/net27 VSS nmos W=0.155u L=0.04u
M26708 U6664/net39 n4135 VSS VSS nmos W=0.155u L=0.04u
M26709 U6664/net27 g1393 U6664/net39 VSS nmos W=0.155u L=0.04u
M26710 U6664/net27 n4072 U6664/net39 VSS nmos W=0.155u L=0.04u
M26711 n4122 g1394 U6664/net27 VSS nmos W=0.155u L=0.04u
M26712 U6664/net39 g1395 VSS VSS nmos W=0.155u L=0.04u
M26713 n4122 n4135 U6664/net46 VDD pmos W=0.205u L=0.04u
M26714 U6664/net46 g1395 VDD VDD pmos W=0.205u L=0.04u
M26715 n4122 g1394 U6664/net34 VDD pmos W=0.205u L=0.04u
M26716 U6664/net34 n4105 VDD VDD pmos W=0.205u L=0.04u
M26717 n4122 n4072 U6664/net37 VDD pmos W=0.205u L=0.04u
M26718 U6664/net37 g1393 VDD VDD pmos W=0.205u L=0.04u
M26719 n5805 n4128 VSS VSS nmos W=0.155u L=0.04u
M26720 n5805 n5809 VSS VSS nmos W=0.155u L=0.04u
M26721 n5805 n4127 VSS VSS nmos W=0.155u L=0.04u
M26722 n5805 n5808 VSS VSS nmos W=0.155u L=0.04u
M26723 U6665/net49 n5809 U6665/net52 VDD pmos W=0.41u L=0.04u
M26724 U6665/net52 n4128 VDD VDD pmos W=0.41u L=0.04u
M26725 U6665/net46 n4127 U6665/net49 VDD pmos W=0.41u L=0.04u
M26726 n5805 n5808 U6665/net46 VDD pmos W=0.41u L=0.04u
M26727 n4128 n4105 U6666/net27 VSS nmos W=0.155u L=0.04u
M26728 U6666/net39 n4135 VSS VSS nmos W=0.155u L=0.04u
M26729 U6666/net27 g1405 U6666/net39 VSS nmos W=0.155u L=0.04u
M26730 U6666/net27 n4072 U6666/net39 VSS nmos W=0.155u L=0.04u
M26731 n4128 g1406 U6666/net27 VSS nmos W=0.155u L=0.04u
M26732 U6666/net39 g1407 VSS VSS nmos W=0.155u L=0.04u
M26733 n4128 n4135 U6666/net46 VDD pmos W=0.205u L=0.04u
M26734 U6666/net46 g1407 VDD VDD pmos W=0.205u L=0.04u
M26735 n4128 g1406 U6666/net34 VDD pmos W=0.205u L=0.04u
M26736 U6666/net34 n4105 VDD VDD pmos W=0.205u L=0.04u
M26737 n4128 n4072 U6666/net37 VDD pmos W=0.205u L=0.04u
M26738 U6666/net37 g1405 VDD VDD pmos W=0.205u L=0.04u
M26739 U6667/net36 g1425 U6667/net27 VSS nmos W=0.155u L=0.04u
M26740 U6667/net39 g1424 VSS VSS nmos W=0.155u L=0.04u
M26741 U6667/net27 n4072 U6667/net39 VSS nmos W=0.155u L=0.04u
M26742 U6667/net27 g1423 U6667/net39 VSS nmos W=0.155u L=0.04u
M26743 U6667/net36 n4135 U6667/net27 VSS nmos W=0.155u L=0.04u
M26744 U6667/net39 n4105 VSS VSS nmos W=0.155u L=0.04u
M26745 n5809 U6667/net36 VSS VSS nmos W=0.155u L=0.04u
M26746 n5809 U6667/net36 VDD VDD pmos W=0.205u L=0.04u
M26747 U6667/net36 g1424 U6667/net46 VDD pmos W=0.205u L=0.04u
M26748 U6667/net46 n4105 VDD VDD pmos W=0.205u L=0.04u
M26749 U6667/net36 n4135 U6667/net34 VDD pmos W=0.205u L=0.04u
M26750 U6667/net34 g1425 VDD VDD pmos W=0.205u L=0.04u
M26751 U6667/net36 g1423 U6667/net37 VDD pmos W=0.205u L=0.04u
M26752 U6667/net37 n4072 VDD VDD pmos W=0.205u L=0.04u
M26753 n4127 n4105 U6668/net27 VSS nmos W=0.155u L=0.04u
M26754 U6668/net39 n4135 VSS VSS nmos W=0.155u L=0.04u
M26755 U6668/net27 g1402 U6668/net39 VSS nmos W=0.155u L=0.04u
M26756 U6668/net27 n4072 U6668/net39 VSS nmos W=0.155u L=0.04u
M26757 n4127 g1403 U6668/net27 VSS nmos W=0.155u L=0.04u
M26758 U6668/net39 g1404 VSS VSS nmos W=0.155u L=0.04u
M26759 n4127 n4135 U6668/net46 VDD pmos W=0.205u L=0.04u
M26760 U6668/net46 g1404 VDD VDD pmos W=0.205u L=0.04u
M26761 n4127 g1403 U6668/net34 VDD pmos W=0.205u L=0.04u
M26762 U6668/net34 n4105 VDD VDD pmos W=0.205u L=0.04u
M26763 n4127 n4072 U6668/net37 VDD pmos W=0.205u L=0.04u
M26764 U6668/net37 g1402 VDD VDD pmos W=0.205u L=0.04u
M26765 n5808 n4132 U6669/XI0-net10 VSS nmos W=0.155u L=0.04u
M26766 U6669/XI0-net10 n4129 U6669/XI0-net13 VSS nmos W=0.155u L=0.04u
M26767 U6669/XI0-net13 n4133 VSS VSS nmos W=0.155u L=0.04u
M26768 n5808 n4133 VDD VDD pmos W=0.205u L=0.04u
M26769 n5808 n4132 VDD VDD pmos W=0.205u L=0.04u
M26770 n5808 n4129 VDD VDD pmos W=0.205u L=0.04u
M26771 U6670/net36 n4105 U6670/net27 VSS nmos W=0.155u L=0.04u
M26772 U6670/net39 n4135 VSS VSS nmos W=0.155u L=0.04u
M26773 U6670/net27 g1399 U6670/net39 VSS nmos W=0.155u L=0.04u
M26774 U6670/net27 n4072 U6670/net39 VSS nmos W=0.155u L=0.04u
M26775 U6670/net36 g1400 U6670/net27 VSS nmos W=0.155u L=0.04u
M26776 U6670/net39 g1401 VSS VSS nmos W=0.155u L=0.04u
M26777 n4133 U6670/net36 VSS VSS nmos W=0.155u L=0.04u
M26778 n4133 U6670/net36 VDD VDD pmos W=0.205u L=0.04u
M26779 U6670/net36 n4135 U6670/net46 VDD pmos W=0.205u L=0.04u
M26780 U6670/net46 g1401 VDD VDD pmos W=0.205u L=0.04u
M26781 U6670/net36 g1400 U6670/net34 VDD pmos W=0.205u L=0.04u
M26782 U6670/net34 n4105 VDD VDD pmos W=0.205u L=0.04u
M26783 U6670/net36 n4072 U6670/net37 VDD pmos W=0.205u L=0.04u
M26784 U6670/net37 g1399 VDD VDD pmos W=0.205u L=0.04u
M26785 U6671/net36 n4105 U6671/net27 VSS nmos W=0.155u L=0.04u
M26786 U6671/net39 n4135 VSS VSS nmos W=0.155u L=0.04u
M26787 U6671/net27 g1396 U6671/net39 VSS nmos W=0.155u L=0.04u
M26788 U6671/net27 n4072 U6671/net39 VSS nmos W=0.155u L=0.04u
M26789 U6671/net36 g1397 U6671/net27 VSS nmos W=0.155u L=0.04u
M26790 U6671/net39 g1398 VSS VSS nmos W=0.155u L=0.04u
M26791 n4129 U6671/net36 VSS VSS nmos W=0.155u L=0.04u
M26792 n4129 U6671/net36 VDD VDD pmos W=0.205u L=0.04u
M26793 U6671/net36 n4135 U6671/net46 VDD pmos W=0.205u L=0.04u
M26794 U6671/net46 g1398 VDD VDD pmos W=0.205u L=0.04u
M26795 U6671/net36 g1397 U6671/net34 VDD pmos W=0.205u L=0.04u
M26796 U6671/net34 n4105 VDD VDD pmos W=0.205u L=0.04u
M26797 U6671/net36 n4072 U6671/net37 VDD pmos W=0.205u L=0.04u
M26798 U6671/net37 g1396 VDD VDD pmos W=0.205u L=0.04u
M26799 U6672/net36 n4105 U6672/net27 VSS nmos W=0.155u L=0.04u
M26800 U6672/net39 n4135 VSS VSS nmos W=0.155u L=0.04u
M26801 U6672/net27 g1384 U6672/net39 VSS nmos W=0.155u L=0.04u
M26802 U6672/net27 n4072 U6672/net39 VSS nmos W=0.155u L=0.04u
M26803 U6672/net36 g1385 U6672/net27 VSS nmos W=0.155u L=0.04u
M26804 U6672/net39 g1386 VSS VSS nmos W=0.155u L=0.04u
M26805 n4132 U6672/net36 VSS VSS nmos W=0.155u L=0.04u
M26806 n4132 U6672/net36 VDD VDD pmos W=0.205u L=0.04u
M26807 U6672/net36 n4135 U6672/net46 VDD pmos W=0.205u L=0.04u
M26808 U6672/net46 g1386 VDD VDD pmos W=0.205u L=0.04u
M26809 U6672/net36 g1385 U6672/net34 VDD pmos W=0.205u L=0.04u
M26810 U6672/net34 n4105 VDD VDD pmos W=0.205u L=0.04u
M26811 U6672/net36 n4072 U6672/net37 VDD pmos W=0.205u L=0.04u
M26812 U6672/net37 g1384 VDD VDD pmos W=0.205u L=0.04u
M26813 n4135 g7161 VSS VSS nmos W=0.135u L=0.04u
M26814 n4135 g7161 VDD VDD pmos W=0.205u L=0.04u
M26815 n4072 g1315 VSS VSS nmos W=0.135u L=0.04u
M26816 n4072 g1315 VDD VDD pmos W=0.205u L=0.04u
M26817 n4105 g6979 VSS VSS nmos W=0.135u L=0.04u
M26818 n4105 g6979 VDD VDD pmos W=0.205u L=0.04u
M26819 n4397 n4140 VSS VSS nmos W=0.135u L=0.04u
M26820 n4397 n4140 VDD VDD pmos W=0.205u L=0.04u
M26821 n4140 g1236 U6677/XI21-net17 VSS nmos W=0.155u L=0.04u
M26822 U6677/XI21-net17 g1297 VSS VSS nmos W=0.155u L=0.04u
M26823 n4140 g6750 U6677/XI6-net17 VSS nmos W=0.155u L=0.04u
M26824 U6677/XI6-net17 g1291 VSS VSS nmos W=0.155u L=0.04u
M26825 n4140 g6944 U6677/XI20-net17 VSS nmos W=0.155u L=0.04u
M26826 U6677/XI20-net17 g1294 VSS VSS nmos W=0.155u L=0.04u
M26827 VDD g1236 U6677/net22 VDD pmos W=0.205u L=0.04u
M26828 VDD g1297 U6677/net22 VDD pmos W=0.205u L=0.04u
M26829 U6677/net16 g6750 n4140 VDD pmos W=0.205u L=0.04u
M26830 U6677/net16 g1291 n4140 VDD pmos W=0.205u L=0.04u
M26831 U6677/net22 g6944 U6677/net16 VDD pmos W=0.205u L=0.04u
M26832 U6677/net22 g1294 U6677/net16 VDD pmos W=0.205u L=0.04u
M26833 g28954 g510 U6678/net27 VSS nmos W=0.155u L=0.04u
M26834 U6678/net27 n5810 VSS VSS nmos W=0.155u L=0.04u
M26835 g28954 n5811 VSS VSS nmos W=0.155u L=0.04u
M26836 g28954 n5810 U6678/net13 VDD pmos W=0.205u L=0.04u
M26837 U6678/net13 n5811 VDD VDD pmos W=0.205u L=0.04u
M26838 g28954 g510 U6678/net13 VDD pmos W=0.205u L=0.04u
M26839 n5811 n5812 U6679/net14 VSS nmos W=0.155u L=0.04u
M26840 U6679/net14 n4245 VSS VSS nmos W=0.155u L=0.04u
M26841 U6679/net14 n5815 VSS VSS nmos W=0.155u L=0.04u
M26842 n5811 n5814 U6679/net14 VSS nmos W=0.155u L=0.04u
M26843 n5811 n5813 U6679/net14 VSS nmos W=0.155u L=0.04u
M26844 n5811 n4245 U6679/XI16-net11 VDD pmos W=0.205u L=0.04u
M26845 U6679/XI16-net11 n5815 VDD VDD pmos W=0.205u L=0.04u
M26846 n5811 n5814 U6679/XI15-net11 VDD pmos W=0.205u L=0.04u
M26847 U6679/XI15-net11 n5813 U6679/XI15-net18 VDD pmos W=0.205u L=0.04u
M26848 U6679/XI15-net18 n5812 VDD VDD pmos W=0.205u L=0.04u
M26849 U6680/net4 n5816 U6680/net14 VSS nmos W=0.155u L=0.04u
M26850 U6680/net6 U6680/net10 U6680/net14 VSS nmos W=0.17u L=0.04u
M26851 U6680/net4 n5817 VSS VSS nmos W=0.155u L=0.04u
M26852 U6680/net6 U6680/net4 VSS VSS nmos W=0.17u L=0.04u
M26853 n5815 U6680/net14 VSS VSS nmos W=0.155u L=0.04u
M26854 U6680/net10 n5816 VSS VSS nmos W=0.155u L=0.04u
M26855 U6680/net4 U6680/net10 U6680/net14 VDD pmos W=0.255u L=0.04u
M26856 U6680/net6 n5816 U6680/net14 VDD pmos W=0.28u L=0.04u
M26857 U6680/net4 n5817 VDD VDD pmos W=0.205u L=0.04u
M26858 U6680/net6 U6680/net4 VDD VDD pmos W=0.24u L=0.04u
M26859 n5815 U6680/net14 VDD VDD pmos W=0.205u L=0.04u
M26860 U6680/net10 n5816 VDD VDD pmos W=0.205u L=0.04u
M26861 U6681/net19 n3937 VSS VSS nmos W=0.155u L=0.04u
M26862 n5812 n3937 U6681/net40 VSS nmos W=0.155u L=0.04u
M26863 n5812 U6681/net19 U6681/net36 VSS nmos W=0.155u L=0.04u
M26864 U6681/net40 g541 VSS VSS nmos W=0.31u L=0.04u
M26865 U6681/net36 g538 VSS VSS nmos W=0.155u L=0.04u
M26866 U6681/net19 n3937 VDD VDD pmos W=0.205u L=0.04u
M26867 n5812 U6681/net19 U6681/net26 VDD pmos W=0.325u L=0.04u
M26868 U6681/net26 g541 VDD VDD pmos W=0.41u L=0.04u
M26869 n5812 n3937 U6681/net30 VDD pmos W=0.325u L=0.04u
M26870 U6681/net30 g538 VDD VDD pmos W=0.205u L=0.04u
M26871 U6682/net4 U6682/net10 U6682/net14 VSS nmos W=0.155u L=0.04u
M26872 U6682/net6 n5818 U6682/net14 VSS nmos W=0.155u L=0.04u
M26873 U6682/net4 n5819 VSS VSS nmos W=0.155u L=0.04u
M26874 U6682/net6 U6682/net4 VSS VSS nmos W=0.155u L=0.04u
M26875 n5810 U6682/net14 VSS VSS nmos W=0.155u L=0.04u
M26876 U6682/net10 n5818 VSS VSS nmos W=0.155u L=0.04u
M26877 U6682/net4 n5818 U6682/net14 VDD pmos W=0.205u L=0.04u
M26878 U6682/net6 U6682/net10 U6682/net14 VDD pmos W=0.205u L=0.04u
M26879 U6682/net4 n5819 VDD VDD pmos W=0.205u L=0.04u
M26880 U6682/net6 U6682/net4 VDD VDD pmos W=0.205u L=0.04u
M26881 n5810 U6682/net14 VDD VDD pmos W=0.205u L=0.04u
M26882 U6682/net10 n5818 VDD VDD pmos W=0.205u L=0.04u
M26883 U6683/net28 U6683/net20 U6683/net64 VSS nmos W=0.155u L=0.04u
M26884 U6683/net24 U6683/net30 U6683/net32 VSS nmos W=0.155u L=0.04u
M26885 U6683/net28 U6683/net40 U6683/net24 VSS nmos W=0.155u L=0.04u
M26886 U6683/net40 n5823 U6683/net108 VSS nmos W=0.155u L=0.04u
M26887 U6683/net40 U6683/net106 U6683/net104 VSS nmos W=0.155u L=0.04u
M26888 U6683/net24 n5820 U6683/net050 VSS nmos W=0.155u L=0.04u
M26889 U6683/net050 U6683/net32 VSS VSS nmos W=0.155u L=0.04u
M26890 U6683/net20 U6683/net40 VSS VSS nmos W=0.155u L=0.04u
M26891 U6683/net106 n5823 VSS VSS nmos W=0.155u L=0.04u
M26892 U6683/net104 n5822 VSS VSS nmos W=0.155u L=0.04u
M26893 U6683/net30 n5820 VSS VSS nmos W=0.155u L=0.04u
M26894 U6683/net108 U6683/net104 VSS VSS nmos W=0.155u L=0.04u
M26895 n5819 U6683/net28 VSS VSS nmos W=0.155u L=0.04u
M26896 U6683/net32 n5821 VSS VSS nmos W=0.155u L=0.04u
M26897 U6683/net64 U6683/net24 VSS VSS nmos W=0.2u L=0.04u
M26898 U6683/net28 U6683/net40 U6683/net64 VDD pmos W=0.205u L=0.04u
M26899 U6683/net24 n5820 U6683/net32 VDD pmos W=0.205u L=0.04u
M26900 U6683/net28 U6683/net20 U6683/net24 VDD pmos W=0.205u L=0.04u
M26901 U6683/net40 U6683/net106 U6683/net108 VDD pmos W=0.205u L=0.04u
M26902 U6683/net40 n5823 U6683/net104 VDD pmos W=0.205u L=0.04u
M26903 U6683/net20 U6683/net40 VDD VDD pmos W=0.205u L=0.04u
M26904 U6683/net106 n5823 VDD VDD pmos W=0.205u L=0.04u
M26905 U6683/net104 n5822 VDD VDD pmos W=0.205u L=0.04u
M26906 U6683/net30 n5820 VDD VDD pmos W=0.205u L=0.04u
M26907 U6683/net108 U6683/net104 VDD VDD pmos W=0.205u L=0.04u
M26908 n5819 U6683/net28 VDD VDD pmos W=0.205u L=0.04u
M26909 U6683/net32 n5821 VDD VDD pmos W=0.205u L=0.04u
M26910 U6683/net64 U6683/net24 VDD VDD pmos W=0.28u L=0.04u
M26911 U6683/net24 U6683/net30 U6683/net045 VDD pmos W=0.205u L=0.04u
M26912 U6683/net045 U6683/net32 VDD VDD pmos W=0.205u L=0.04u
M26913 U6684/net28 U6684/net20 U6684/net64 VSS nmos W=0.155u L=0.04u
M26914 U6684/net24 U6684/net30 U6684/net32 VSS nmos W=0.155u L=0.04u
M26915 U6684/net28 U6684/net40 U6684/net24 VSS nmos W=0.155u L=0.04u
M26916 U6684/net40 n5827 U6684/net108 VSS nmos W=0.155u L=0.04u
M26917 U6684/net40 U6684/net106 U6684/net104 VSS nmos W=0.155u L=0.04u
M26918 U6684/net24 n5824 U6684/net050 VSS nmos W=0.155u L=0.04u
M26919 U6684/net050 U6684/net32 VSS VSS nmos W=0.155u L=0.04u
M26920 U6684/net20 U6684/net40 VSS VSS nmos W=0.155u L=0.04u
M26921 U6684/net106 n5827 VSS VSS nmos W=0.155u L=0.04u
M26922 U6684/net104 n5826 VSS VSS nmos W=0.155u L=0.04u
M26923 U6684/net30 n5824 VSS VSS nmos W=0.155u L=0.04u
M26924 U6684/net108 U6684/net104 VSS VSS nmos W=0.155u L=0.04u
M26925 n5818 U6684/net28 VSS VSS nmos W=0.155u L=0.04u
M26926 U6684/net32 n5825 VSS VSS nmos W=0.155u L=0.04u
M26927 U6684/net64 U6684/net24 VSS VSS nmos W=0.2u L=0.04u
M26928 U6684/net28 U6684/net40 U6684/net64 VDD pmos W=0.205u L=0.04u
M26929 U6684/net24 n5824 U6684/net32 VDD pmos W=0.205u L=0.04u
M26930 U6684/net28 U6684/net20 U6684/net24 VDD pmos W=0.205u L=0.04u
M26931 U6684/net40 U6684/net106 U6684/net108 VDD pmos W=0.205u L=0.04u
M26932 U6684/net40 n5827 U6684/net104 VDD pmos W=0.205u L=0.04u
M26933 U6684/net20 U6684/net40 VDD VDD pmos W=0.205u L=0.04u
M26934 U6684/net106 n5827 VDD VDD pmos W=0.205u L=0.04u
M26935 U6684/net104 n5826 VDD VDD pmos W=0.205u L=0.04u
M26936 U6684/net30 n5824 VDD VDD pmos W=0.205u L=0.04u
M26937 U6684/net108 U6684/net104 VDD VDD pmos W=0.205u L=0.04u
M26938 n5818 U6684/net28 VDD VDD pmos W=0.205u L=0.04u
M26939 U6684/net32 n5825 VDD VDD pmos W=0.205u L=0.04u
M26940 U6684/net64 U6684/net24 VDD VDD pmos W=0.28u L=0.04u
M26941 U6684/net24 U6684/net30 U6684/net045 VDD pmos W=0.205u L=0.04u
M26942 U6684/net045 U6684/net32 VDD VDD pmos W=0.205u L=0.04u
M26943 g28528 n5828 U6685/net27 VSS nmos W=0.155u L=0.04u
M26944 U6685/net27 n5829 VSS VSS nmos W=0.155u L=0.04u
M26945 g28528 n5830 VSS VSS nmos W=0.155u L=0.04u
M26946 g28528 n5829 U6685/net13 VDD pmos W=0.205u L=0.04u
M26947 U6685/net13 n5830 VDD VDD pmos W=0.205u L=0.04u
M26948 g28528 n5828 U6685/net13 VDD pmos W=0.205u L=0.04u
M26949 U6686/net17 n5813 VSS VSS nmos W=0.155u L=0.04u
M26950 U6686/net17 g534 VSS VSS nmos W=0.155u L=0.04u
M26951 U6686/net63 n5831 VSS VSS nmos W=0.155u L=0.04u
M26952 n5828 U6686/net17 VSS VSS nmos W=0.155u L=0.04u
M26953 n5828 n5820 U6686/net63 VSS nmos W=0.155u L=0.04u
M26954 n5828 n5831 U6686/net31 VDD pmos W=0.205u L=0.04u
M26955 U6686/net39 n5813 VDD VDD pmos W=0.195u L=0.04u
M26956 U6686/net31 U6686/net17 VDD VDD pmos W=0.195u L=0.04u
M26957 n5828 n5820 U6686/net31 VDD pmos W=0.195u L=0.04u
M26958 U6686/net17 g534 U6686/net39 VDD pmos W=0.195u L=0.04u
M26959 U6687/net36 n5833 U6687/net24 VSS nmos W=0.155u L=0.04u
M26960 U6687/net24 n5834 VSS VSS nmos W=0.155u L=0.04u
M26961 U6687/net33 n4226 U6687/net36 VSS nmos W=0.155u L=0.04u
M26962 U6687/net33 n5832 U6687/net36 VSS nmos W=0.155u L=0.04u
M26963 n5820 U6687/net33 VSS VSS nmos W=0.155u L=0.04u
M26964 n5820 U6687/net33 VDD VDD pmos W=0.205u L=0.04u
M26965 U6687/net33 n5832 U6687/net35 VDD pmos W=0.205u L=0.04u
M26966 U6687/net35 n4226 VDD VDD pmos W=0.205u L=0.04u
M26967 U6687/net33 n5834 VDD VDD pmos W=0.205u L=0.04u
M26968 U6687/net33 n5833 VDD VDD pmos W=0.205u L=0.04u
M26969 n5833 n5835 U6688/net15 VSS nmos W=0.155u L=0.04u
M26970 n5833 n4226 U6688/net15 VSS nmos W=0.155u L=0.04u
M26971 U6688/net15 n4300 VSS VSS nmos W=0.155u L=0.04u
M26972 n5833 n4300 VDD VDD pmos W=0.205u L=0.04u
M26973 n5833 n5835 U6688/XI16-net11 VDD pmos W=0.205u L=0.04u
M26974 U6688/XI16-net11 n4226 VDD VDD pmos W=0.205u L=0.04u
M26975 U6689/net11 n5814 VSS VSS nmos W=0.155u L=0.04u
M26976 U6689/net11 n5836 VSS VSS nmos W=0.155u L=0.04u
M26977 g28525 n5837 VSS VSS nmos W=0.155u L=0.04u
M26978 g28525 U6689/net11 VSS VSS nmos W=0.155u L=0.04u
M26979 U6689/XI1-net8 n5836 VDD VDD pmos W=0.205u L=0.04u
M26980 U6689/net11 n5814 U6689/XI1-net8 VDD pmos W=0.205u L=0.04u
M26981 U6689/XU39-net8 U6689/net11 VDD VDD pmos W=0.205u L=0.04u
M26982 g28525 n5837 U6689/XU39-net8 VDD pmos W=0.205u L=0.04u
M26983 n5836 g530 U6690/net10 VSS nmos W=0.155u L=0.04u
M26984 U6690/net10 n5821 VSS VSS nmos W=0.155u L=0.04u
M26985 n5836 n5813 U6690/net10 VSS nmos W=0.155u L=0.04u
M26986 U6690/net10 n5838 VSS VSS nmos W=0.155u L=0.04u
M26987 U6690/net30 n5821 VDD VDD pmos W=0.205u L=0.04u
M26988 n5836 g530 U6690/net24 VDD pmos W=0.205u L=0.04u
M26989 U6690/net24 n5813 VDD VDD pmos W=0.205u L=0.04u
M26990 n5836 n5838 U6690/net30 VDD pmos W=0.205u L=0.04u
M26991 U6691/XU1-net6 n5834 VSS VSS nmos W=0.155u L=0.04u
M26992 n5821 n5839 U6691/XU1-net6 VSS nmos W=0.155u L=0.04u
M26993 n5821 n5834 VDD VDD pmos W=0.155u L=0.04u
M26994 n5821 n5839 VDD VDD pmos W=0.155u L=0.04u
M26995 U6692/net19 n4235 VSS VSS nmos W=0.155u L=0.04u
M26996 n5839 n4235 U6692/net40 VSS nmos W=0.155u L=0.04u
M26997 n5839 U6692/net19 U6692/net36 VSS nmos W=0.155u L=0.04u
M26998 U6692/net40 n5840 VSS VSS nmos W=0.31u L=0.04u
M26999 U6692/net36 n4300 VSS VSS nmos W=0.155u L=0.04u
M27000 U6692/net19 n4235 VDD VDD pmos W=0.205u L=0.04u
M27001 n5839 U6692/net19 U6692/net26 VDD pmos W=0.325u L=0.04u
M27002 U6692/net26 n5840 VDD VDD pmos W=0.41u L=0.04u
M27003 n5839 n4235 U6692/net30 VDD pmos W=0.325u L=0.04u
M27004 U6692/net30 n4300 VDD VDD pmos W=0.205u L=0.04u
M27005 g28499 n5841 U6693/net27 VSS nmos W=0.155u L=0.04u
M27006 U6693/net27 n5829 VSS VSS nmos W=0.155u L=0.04u
M27007 g28499 n5830 VSS VSS nmos W=0.155u L=0.04u
M27008 g28499 n5829 U6693/net13 VDD pmos W=0.205u L=0.04u
M27009 U6693/net13 n5830 VDD VDD pmos W=0.205u L=0.04u
M27010 g28499 n5841 U6693/net13 VDD pmos W=0.205u L=0.04u
M27011 n5830 n5842 VSS VSS nmos W=0.135u L=0.04u
M27012 n5830 n5842 VDD VDD pmos W=0.205u L=0.04u
M27013 U6695/net29 n5813 VSS VSS nmos W=0.31u L=0.04u
M27014 U6695/net30 n5838 U6695/net29 VSS nmos W=0.31u L=0.04u
M27015 U6695/net30 n5823 U6695/net29 VSS nmos W=0.31u L=0.04u
M27016 U6695/net29 g533 VSS VSS nmos W=0.31u L=0.04u
M27017 n5841 U6695/net30 VSS VSS nmos W=0.31u L=0.04u
M27018 n5841 U6695/net30 VDD VDD pmos W=0.41u L=0.04u
M27019 U6695/net25 n5813 VDD VDD pmos W=0.41u L=0.04u
M27020 U6695/net22 n5838 VDD VDD pmos W=0.41u L=0.04u
M27021 U6695/net30 g533 U6695/net25 VDD pmos W=0.41u L=0.04u
M27022 U6695/net30 n5823 U6695/net22 VDD pmos W=0.41u L=0.04u
M27023 n5823 n5834 U6696/XI0-net10 VSS nmos W=0.155u L=0.04u
M27024 U6696/XI0-net10 n5843 U6696/XI0-net13 VSS nmos W=0.155u L=0.04u
M27025 U6696/XI0-net13 n5844 VSS VSS nmos W=0.155u L=0.04u
M27026 n5823 n5844 VDD VDD pmos W=0.205u L=0.04u
M27027 n5823 n5834 VDD VDD pmos W=0.205u L=0.04u
M27028 n5823 n5843 VDD VDD pmos W=0.205u L=0.04u
M27029 U6697/net19 n4230 VSS VSS nmos W=0.155u L=0.04u
M27030 n5844 n4230 U6697/net40 VSS nmos W=0.155u L=0.04u
M27031 n5844 U6697/net19 U6697/net36 VSS nmos W=0.155u L=0.04u
M27032 U6697/net40 n5845 VSS VSS nmos W=0.31u L=0.04u
M27033 U6697/net36 n4355 VSS VSS nmos W=0.155u L=0.04u
M27034 U6697/net19 n4230 VDD VDD pmos W=0.205u L=0.04u
M27035 n5844 U6697/net19 U6697/net26 VDD pmos W=0.325u L=0.04u
M27036 U6697/net26 n5845 VDD VDD pmos W=0.41u L=0.04u
M27037 n5844 n4230 U6697/net30 VDD pmos W=0.325u L=0.04u
M27038 U6697/net30 n4355 VDD VDD pmos W=0.205u L=0.04u
M27039 U6698/net29 n5817 VSS VSS nmos W=0.155u L=0.04u
M27040 g28495 n5847 U6698/net29 VSS nmos W=0.155u L=0.04u
M27041 g28495 n5846 U6698/net23 VSS nmos W=0.155u L=0.04u
M27042 U6698/net23 n5829 VSS VSS nmos W=0.155u L=0.04u
M27043 U6698/net20 n5829 g28495 VDD pmos W=0.205u L=0.04u
M27044 U6698/net20 n5846 g28495 VDD pmos W=0.205u L=0.04u
M27045 VDD n5847 U6698/net20 VDD pmos W=0.205u L=0.04u
M27046 VDD n5817 U6698/net20 VDD pmos W=0.205u L=0.04u
M27047 U6699/net36 n5848 U6699/net24 VSS nmos W=0.155u L=0.04u
M27048 U6699/net24 n5834 VSS VSS nmos W=0.155u L=0.04u
M27049 n5817 n4224 U6699/net36 VSS nmos W=0.155u L=0.04u
M27050 n5817 n5832 U6699/net36 VSS nmos W=0.155u L=0.04u
M27051 n5817 n5832 U6699/net35 VDD pmos W=0.205u L=0.04u
M27052 U6699/net35 n4224 VDD VDD pmos W=0.205u L=0.04u
M27053 n5817 n5834 VDD VDD pmos W=0.205u L=0.04u
M27054 n5817 n5848 VDD VDD pmos W=0.205u L=0.04u
M27055 n5848 n4224 U6700/net15 VSS nmos W=0.155u L=0.04u
M27056 n5848 n5835 U6700/net15 VSS nmos W=0.155u L=0.04u
M27057 U6700/net15 n4300 VSS VSS nmos W=0.155u L=0.04u
M27058 n5848 n4300 VDD VDD pmos W=0.205u L=0.04u
M27059 n5848 n4224 U6700/XI16-net11 VDD pmos W=0.205u L=0.04u
M27060 U6700/XI16-net11 n5835 VDD VDD pmos W=0.205u L=0.04u
M27061 n5832 n5840 VSS VSS nmos W=0.135u L=0.04u
M27062 n5832 n5840 VDD VDD pmos W=0.205u L=0.04u
M27063 U6702/net17 n5813 VSS VSS nmos W=0.155u L=0.04u
M27064 U6702/net17 g537 VSS VSS nmos W=0.155u L=0.04u
M27065 U6702/net63 n5831 VSS VSS nmos W=0.155u L=0.04u
M27066 n5846 U6702/net17 VSS VSS nmos W=0.155u L=0.04u
M27067 n5846 n5822 U6702/net63 VSS nmos W=0.155u L=0.04u
M27068 n5846 n5831 U6702/net31 VDD pmos W=0.205u L=0.04u
M27069 U6702/net39 n5813 VDD VDD pmos W=0.195u L=0.04u
M27070 U6702/net31 U6702/net17 VDD VDD pmos W=0.195u L=0.04u
M27071 n5846 n5822 U6702/net31 VDD pmos W=0.195u L=0.04u
M27072 U6702/net17 g537 U6702/net39 VDD pmos W=0.195u L=0.04u
M27073 n5822 U6703/net6 VSS VSS nmos W=0.155u L=0.04u
M27074 U6703/X_u2-net6 n5834 VSS VSS nmos W=0.155u L=0.04u
M27075 U6703/net6 n5849 U6703/X_u2-net6 VSS nmos W=0.155u L=0.04u
M27076 n5822 U6703/net6 VDD VDD pmos W=0.205u L=0.04u
M27077 U6703/net6 n5834 VDD VDD pmos W=0.205u L=0.04u
M27078 U6703/net6 n5849 VDD VDD pmos W=0.205u L=0.04u
M27079 U6704/net19 n4240 VSS VSS nmos W=0.155u L=0.04u
M27080 n5849 n4240 U6704/net40 VSS nmos W=0.155u L=0.04u
M27081 n5849 U6704/net19 U6704/net36 VSS nmos W=0.155u L=0.04u
M27082 U6704/net40 n4300 VSS VSS nmos W=0.31u L=0.04u
M27083 U6704/net36 n5840 VSS VSS nmos W=0.155u L=0.04u
M27084 U6704/net19 n4240 VDD VDD pmos W=0.205u L=0.04u
M27085 n5849 U6704/net19 U6704/net26 VDD pmos W=0.325u L=0.04u
M27086 U6704/net26 n4300 VDD VDD pmos W=0.41u L=0.04u
M27087 n5849 n4240 U6704/net30 VDD pmos W=0.325u L=0.04u
M27088 U6704/net30 n5840 VDD VDD pmos W=0.205u L=0.04u
M27089 U6705/net29 n5816 VSS VSS nmos W=0.155u L=0.04u
M27090 g28490 n5847 U6705/net29 VSS nmos W=0.155u L=0.04u
M27091 g28490 n5850 U6705/net23 VSS nmos W=0.155u L=0.04u
M27092 U6705/net23 n5829 VSS VSS nmos W=0.155u L=0.04u
M27093 U6705/net20 n5829 g28490 VDD pmos W=0.205u L=0.04u
M27094 U6705/net20 n5850 g28490 VDD pmos W=0.205u L=0.04u
M27095 VDD n5847 U6705/net20 VDD pmos W=0.205u L=0.04u
M27096 VDD n5816 U6705/net20 VDD pmos W=0.205u L=0.04u
M27097 n5816 n5834 U6706/XI0-net10 VSS nmos W=0.155u L=0.04u
M27098 U6706/XI0-net10 n5843 U6706/XI0-net13 VSS nmos W=0.155u L=0.04u
M27099 U6706/XI0-net13 n5851 VSS VSS nmos W=0.155u L=0.04u
M27100 n5816 n5851 VDD VDD pmos W=0.205u L=0.04u
M27101 n5816 n5834 VDD VDD pmos W=0.205u L=0.04u
M27102 n5816 n5843 VDD VDD pmos W=0.205u L=0.04u
M27103 U6707/net19 n4225 VSS VSS nmos W=0.155u L=0.04u
M27104 n5851 n4225 U6707/net40 VSS nmos W=0.155u L=0.04u
M27105 n5851 U6707/net19 U6707/net36 VSS nmos W=0.155u L=0.04u
M27106 U6707/net40 n4355 VSS VSS nmos W=0.31u L=0.04u
M27107 U6707/net36 n5845 VSS VSS nmos W=0.155u L=0.04u
M27108 U6707/net19 n4225 VDD VDD pmos W=0.205u L=0.04u
M27109 n5851 U6707/net19 U6707/net26 VDD pmos W=0.325u L=0.04u
M27110 U6707/net26 n4355 VDD VDD pmos W=0.41u L=0.04u
M27111 n5851 n4225 U6707/net30 VDD pmos W=0.325u L=0.04u
M27112 U6707/net30 n5845 VDD VDD pmos W=0.205u L=0.04u
M27113 U6708/net29 n5813 VSS VSS nmos W=0.31u L=0.04u
M27114 U6708/net30 n5838 U6708/net29 VSS nmos W=0.31u L=0.04u
M27115 U6708/net30 n5824 U6708/net29 VSS nmos W=0.31u L=0.04u
M27116 U6708/net29 g536 VSS VSS nmos W=0.31u L=0.04u
M27117 n5850 U6708/net30 VSS VSS nmos W=0.31u L=0.04u
M27118 n5850 U6708/net30 VDD VDD pmos W=0.41u L=0.04u
M27119 U6708/net25 n5813 VDD VDD pmos W=0.41u L=0.04u
M27120 U6708/net22 n5838 VDD VDD pmos W=0.41u L=0.04u
M27121 U6708/net30 g536 U6708/net25 VDD pmos W=0.41u L=0.04u
M27122 U6708/net30 n5824 U6708/net22 VDD pmos W=0.41u L=0.04u
M27123 n5824 n5834 U6709/XI0-net10 VSS nmos W=0.155u L=0.04u
M27124 U6709/XI0-net10 n5843 U6709/XI0-net13 VSS nmos W=0.155u L=0.04u
M27125 U6709/XI0-net13 n5852 VSS VSS nmos W=0.155u L=0.04u
M27126 n5824 n5852 VDD VDD pmos W=0.205u L=0.04u
M27127 n5824 n5834 VDD VDD pmos W=0.205u L=0.04u
M27128 n5824 n5843 VDD VDD pmos W=0.205u L=0.04u
M27129 U6710/net19 n4229 VSS VSS nmos W=0.155u L=0.04u
M27130 n5852 n4229 U6710/net40 VSS nmos W=0.155u L=0.04u
M27131 n5852 U6710/net19 U6710/net36 VSS nmos W=0.155u L=0.04u
M27132 U6710/net40 n5845 VSS VSS nmos W=0.31u L=0.04u
M27133 U6710/net36 n4355 VSS VSS nmos W=0.155u L=0.04u
M27134 U6710/net19 n4229 VDD VDD pmos W=0.205u L=0.04u
M27135 n5852 U6710/net19 U6710/net26 VDD pmos W=0.325u L=0.04u
M27136 U6710/net26 n5845 VDD VDD pmos W=0.41u L=0.04u
M27137 n5852 n4229 U6710/net30 VDD pmos W=0.325u L=0.04u
M27138 U6710/net30 n4355 VDD VDD pmos W=0.205u L=0.04u
M27139 U6711/XU1-net6 n4355 VSS VSS nmos W=0.155u L=0.04u
M27140 n5843 n5835 U6711/XU1-net6 VSS nmos W=0.155u L=0.04u
M27141 n5843 n4355 VDD VDD pmos W=0.155u L=0.04u
M27142 n5843 n5835 VDD VDD pmos W=0.155u L=0.04u
M27143 U6712/net11 n5814 VSS VSS nmos W=0.155u L=0.04u
M27144 U6712/net11 n5853 VSS VSS nmos W=0.155u L=0.04u
M27145 g28489 n5854 VSS VSS nmos W=0.155u L=0.04u
M27146 g28489 U6712/net11 VSS VSS nmos W=0.155u L=0.04u
M27147 U6712/XI1-net8 n5853 VDD VDD pmos W=0.205u L=0.04u
M27148 U6712/net11 n5814 U6712/XI1-net8 VDD pmos W=0.205u L=0.04u
M27149 U6712/XU39-net8 U6712/net11 VDD VDD pmos W=0.205u L=0.04u
M27150 g28489 n5854 U6712/XU39-net8 VDD pmos W=0.205u L=0.04u
M27151 n5853 g532 U6713/net10 VSS nmos W=0.155u L=0.04u
M27152 U6713/net10 n5825 VSS VSS nmos W=0.155u L=0.04u
M27153 n5853 n5813 U6713/net10 VSS nmos W=0.155u L=0.04u
M27154 U6713/net10 n5838 VSS VSS nmos W=0.155u L=0.04u
M27155 U6713/net30 n5825 VDD VDD pmos W=0.205u L=0.04u
M27156 n5853 g532 U6713/net24 VDD pmos W=0.205u L=0.04u
M27157 U6713/net24 n5813 VDD VDD pmos W=0.205u L=0.04u
M27158 n5853 n5838 U6713/net30 VDD pmos W=0.205u L=0.04u
M27159 U6714/XU1-net6 n5834 VSS VSS nmos W=0.155u L=0.04u
M27160 n5825 n5855 U6714/XU1-net6 VSS nmos W=0.155u L=0.04u
M27161 n5825 n5834 VDD VDD pmos W=0.155u L=0.04u
M27162 n5825 n5855 VDD VDD pmos W=0.155u L=0.04u
M27163 U6715/net19 n4237 VSS VSS nmos W=0.155u L=0.04u
M27164 n5855 n4237 U6715/net40 VSS nmos W=0.155u L=0.04u
M27165 n5855 U6715/net19 U6715/net36 VSS nmos W=0.155u L=0.04u
M27166 U6715/net40 n4300 VSS VSS nmos W=0.31u L=0.04u
M27167 U6715/net36 n5840 VSS VSS nmos W=0.155u L=0.04u
M27168 U6715/net19 n4237 VDD VDD pmos W=0.205u L=0.04u
M27169 n5855 U6715/net19 U6715/net26 VDD pmos W=0.325u L=0.04u
M27170 U6715/net26 n4300 VDD VDD pmos W=0.41u L=0.04u
M27171 n5855 n4237 U6715/net30 VDD pmos W=0.325u L=0.04u
M27172 U6715/net30 n5840 VDD VDD pmos W=0.205u L=0.04u
M27173 n5840 n4300 VSS VSS nmos W=0.155u L=0.04u
M27174 n5840 n5835 VSS VSS nmos W=0.155u L=0.04u
M27175 U6716/XI1-net8 n5835 VDD VDD pmos W=0.205u L=0.04u
M27176 n5840 n4300 U6716/XI1-net8 VDD pmos W=0.205u L=0.04u
M27177 n4300 n4280 VSS VSS nmos W=0.135u L=0.04u
M27178 n4300 n4280 VDD VDD pmos W=0.205u L=0.04u
M27179 n4280 g550 U6718/XI21-net17 VSS nmos W=0.155u L=0.04u
M27180 U6718/XI21-net17 g620 VSS VSS nmos W=0.155u L=0.04u
M27181 n4280 g6485 U6718/XI6-net17 VSS nmos W=0.155u L=0.04u
M27182 U6718/XI6-net17 g614 VSS VSS nmos W=0.155u L=0.04u
M27183 n4280 g6642 U6718/XI20-net17 VSS nmos W=0.155u L=0.04u
M27184 U6718/XI20-net17 g617 VSS VSS nmos W=0.155u L=0.04u
M27185 VDD g550 U6718/net22 VDD pmos W=0.205u L=0.04u
M27186 VDD g620 U6718/net22 VDD pmos W=0.205u L=0.04u
M27187 U6718/net16 g6485 n4280 VDD pmos W=0.205u L=0.04u
M27188 U6718/net16 g614 n4280 VDD pmos W=0.205u L=0.04u
M27189 U6718/net22 g6642 U6718/net16 VDD pmos W=0.205u L=0.04u
M27190 U6718/net22 g617 U6718/net16 VDD pmos W=0.205u L=0.04u
M27191 U6719/net11 n5814 VSS VSS nmos W=0.155u L=0.04u
M27192 U6719/net11 n5856 VSS VSS nmos W=0.155u L=0.04u
M27193 g28488 n5854 VSS VSS nmos W=0.155u L=0.04u
M27194 g28488 U6719/net11 VSS VSS nmos W=0.155u L=0.04u
M27195 U6719/XI1-net8 n5856 VDD VDD pmos W=0.205u L=0.04u
M27196 U6719/net11 n5814 U6719/XI1-net8 VDD pmos W=0.205u L=0.04u
M27197 U6719/XU39-net8 U6719/net11 VDD VDD pmos W=0.205u L=0.04u
M27198 g28488 n5854 U6719/XU39-net8 VDD pmos W=0.205u L=0.04u
M27199 U6720/XU35-net6 n5847 VSS VSS nmos W=0.155u L=0.04u
M27200 U6720/net5 n5857 U6720/XU35-net6 VSS nmos W=0.155u L=0.04u
M27201 U6720/XU36-net6 U6720/net5 VSS VSS nmos W=0.155u L=0.04u
M27202 n5854 n5842 U6720/XU36-net6 VSS nmos W=0.155u L=0.04u
M27203 U6720/net5 n5847 VDD VDD pmos W=0.205u L=0.04u
M27204 U6720/net5 n5857 VDD VDD pmos W=0.205u L=0.04u
M27205 n5854 U6720/net5 VDD VDD pmos W=0.205u L=0.04u
M27206 n5854 n5842 VDD VDD pmos W=0.205u L=0.04u
M27207 n5856 g529 U6721/net10 VSS nmos W=0.155u L=0.04u
M27208 U6721/net10 n5827 VSS VSS nmos W=0.155u L=0.04u
M27209 n5856 n5813 U6721/net10 VSS nmos W=0.155u L=0.04u
M27210 U6721/net10 n5838 VSS VSS nmos W=0.155u L=0.04u
M27211 U6721/net30 n5827 VDD VDD pmos W=0.205u L=0.04u
M27212 n5856 g529 U6721/net24 VDD pmos W=0.205u L=0.04u
M27213 U6721/net24 n5813 VDD VDD pmos W=0.205u L=0.04u
M27214 n5856 n5838 U6721/net30 VDD pmos W=0.205u L=0.04u
M27215 U6722/XU1-net6 n5834 VSS VSS nmos W=0.155u L=0.04u
M27216 n5827 n5858 U6722/XU1-net6 VSS nmos W=0.155u L=0.04u
M27217 n5827 n5834 VDD VDD pmos W=0.155u L=0.04u
M27218 n5827 n5858 VDD VDD pmos W=0.155u L=0.04u
M27219 U6723/net19 n4236 VSS VSS nmos W=0.155u L=0.04u
M27220 n5858 n4236 U6723/net40 VSS nmos W=0.155u L=0.04u
M27221 n5858 U6723/net19 U6723/net36 VSS nmos W=0.155u L=0.04u
M27222 U6723/net40 n5845 VSS VSS nmos W=0.31u L=0.04u
M27223 U6723/net36 n4355 VSS VSS nmos W=0.155u L=0.04u
M27224 U6723/net19 n4236 VDD VDD pmos W=0.205u L=0.04u
M27225 n5858 U6723/net19 U6723/net26 VDD pmos W=0.325u L=0.04u
M27226 U6723/net26 n5845 VDD VDD pmos W=0.41u L=0.04u
M27227 n5858 n4236 U6723/net30 VDD pmos W=0.325u L=0.04u
M27228 U6723/net30 n4355 VDD VDD pmos W=0.205u L=0.04u
M27229 U6724/net11 n5814 VSS VSS nmos W=0.155u L=0.04u
M27230 U6724/net11 n5859 VSS VSS nmos W=0.155u L=0.04u
M27231 g28470 n5837 VSS VSS nmos W=0.155u L=0.04u
M27232 g28470 U6724/net11 VSS VSS nmos W=0.155u L=0.04u
M27233 U6724/XI1-net8 n5859 VDD VDD pmos W=0.205u L=0.04u
M27234 U6724/net11 n5814 U6724/XI1-net8 VDD pmos W=0.205u L=0.04u
M27235 U6724/XU39-net8 U6724/net11 VDD VDD pmos W=0.205u L=0.04u
M27236 g28470 n5837 U6724/XU39-net8 VDD pmos W=0.205u L=0.04u
M27237 n5837 n5860 U6725/net15 VSS nmos W=0.155u L=0.04u
M27238 n5837 n5857 U6725/net15 VSS nmos W=0.155u L=0.04u
M27239 U6725/net15 n5842 VSS VSS nmos W=0.155u L=0.04u
M27240 n5837 n5842 VDD VDD pmos W=0.205u L=0.04u
M27241 n5837 n5860 U6725/XI16-net11 VDD pmos W=0.205u L=0.04u
M27242 U6725/XI16-net11 n5857 VDD VDD pmos W=0.205u L=0.04u
M27243 U6726/XU1-net6 n5861 VSS VSS nmos W=0.155u L=0.04u
M27244 n5842 n5847 U6726/XU1-net6 VSS nmos W=0.155u L=0.04u
M27245 n5842 n5861 VDD VDD pmos W=0.155u L=0.04u
M27246 n5842 n5847 VDD VDD pmos W=0.155u L=0.04u
M27247 VSS g499 U6727/net22 VSS nmos W=0.155u L=0.04u
M27248 U6727/net22 n5863 n5857 VSS nmos W=0.155u L=0.04u
M27249 U6727/net22 n5835 n5857 VSS nmos W=0.155u L=0.04u
M27250 U6727/net22 n5862 n5857 VSS nmos W=0.155u L=0.04u
M27251 U6727/net38 n5862 VDD VDD pmos W=0.205u L=0.04u
M27252 U6727/net35 n5835 U6727/net38 VDD pmos W=0.205u L=0.04u
M27253 n5857 n5863 U6727/net35 VDD pmos W=0.205u L=0.04u
M27254 n5857 g499 VDD VDD pmos W=0.205u L=0.04u
M27255 n5863 g734 VSS VSS nmos W=0.155u L=0.04u
M27256 n5863 n4180 VSS VSS nmos W=0.155u L=0.04u
M27257 U6728/XI1-net8 n4180 VDD VDD pmos W=0.205u L=0.04u
M27258 n5863 g734 U6728/XI1-net8 VDD pmos W=0.205u L=0.04u
M27259 n5862 g735 U6729/net10 VSS nmos W=0.155u L=0.04u
M27260 U6729/net10 n4243 VSS VSS nmos W=0.155u L=0.04u
M27261 n5862 n4213 U6729/net10 VSS nmos W=0.155u L=0.04u
M27262 U6729/net10 g736 VSS VSS nmos W=0.155u L=0.04u
M27263 U6729/net30 n4243 VDD VDD pmos W=0.205u L=0.04u
M27264 n5862 g735 U6729/net24 VDD pmos W=0.205u L=0.04u
M27265 U6729/net24 n4213 VDD VDD pmos W=0.205u L=0.04u
M27266 n5862 g736 U6729/net30 VDD pmos W=0.205u L=0.04u
M27267 n5860 n5847 VSS VSS nmos W=0.135u L=0.04u
M27268 n5860 n5847 VDD VDD pmos W=0.205u L=0.04u
M27269 n5847 n5831 VSS VSS nmos W=0.155u L=0.04u
M27270 n5847 n5829 VSS VSS nmos W=0.155u L=0.04u
M27271 U6731/XI1-net8 n5829 VDD VDD pmos W=0.205u L=0.04u
M27272 n5847 n5831 U6731/XI1-net8 VDD pmos W=0.205u L=0.04u
M27273 n5829 n5814 VSS VSS nmos W=0.135u L=0.04u
M27274 n5829 n5814 VDD VDD pmos W=0.205u L=0.04u
M27275 n5831 n5838 VSS VSS nmos W=0.135u L=0.04u
M27276 n5831 n5838 VDD VDD pmos W=0.205u L=0.04u
M27277 n5859 n5838 U6734/net10 VSS nmos W=0.155u L=0.04u
M27278 U6734/net10 n5813 VSS VSS nmos W=0.155u L=0.04u
M27279 n5859 n5826 U6734/net10 VSS nmos W=0.155u L=0.04u
M27280 U6734/net10 g531 VSS VSS nmos W=0.155u L=0.04u
M27281 U6734/net30 n5813 VDD VDD pmos W=0.205u L=0.04u
M27282 n5859 n5838 U6734/net24 VDD pmos W=0.205u L=0.04u
M27283 U6734/net24 n5826 VDD VDD pmos W=0.205u L=0.04u
M27284 n5859 g531 U6734/net30 VDD pmos W=0.205u L=0.04u
M27285 U6735/net13 n5861 VSS VSS nmos W=0.155u L=0.04u
M27286 U6735/net16 U6735/net13 VSS VSS nmos W=0.155u L=0.04u
M27287 n5813 n5838 U6735/net16 VSS nmos W=0.155u L=0.04u
M27288 U6735/net13 n5861 VDD VDD pmos W=0.205u L=0.04u
M27289 VDD U6735/net13 n5813 VDD pmos W=0.205u L=0.04u
M27290 VDD n5838 n5813 VDD pmos W=0.205u L=0.04u
M27291 U6736/XU1-net6 n5834 VSS VSS nmos W=0.155u L=0.04u
M27292 n5826 n5864 U6736/XU1-net6 VSS nmos W=0.155u L=0.04u
M27293 n5826 n5834 VDD VDD pmos W=0.155u L=0.04u
M27294 n5826 n5864 VDD VDD pmos W=0.155u L=0.04u
M27295 n5834 n5861 VSS VSS nmos W=0.155u L=0.04u
M27296 n5834 II15499 VSS VSS nmos W=0.155u L=0.04u
M27297 U6737/XI1-net8 II15499 VDD VDD pmos W=0.205u L=0.04u
M27298 n5834 n5861 U6737/XI1-net8 VDD pmos W=0.205u L=0.04u
M27299 U6738/net36 n3399 U6738/net24 VSS nmos W=0.155u L=0.04u
M27300 U6738/net24 n5865 VSS VSS nmos W=0.155u L=0.04u
M27301 n5861 g499 U6738/net36 VSS nmos W=0.155u L=0.04u
M27302 n5861 n4271 U6738/net36 VSS nmos W=0.155u L=0.04u
M27303 n5861 n4271 U6738/net35 VDD pmos W=0.205u L=0.04u
M27304 U6738/net35 g499 VDD VDD pmos W=0.205u L=0.04u
M27305 n5861 n5865 VDD VDD pmos W=0.205u L=0.04u
M27306 n5861 n3399 VDD VDD pmos W=0.205u L=0.04u
M27307 n5865 g563 VSS VSS nmos W=0.155u L=0.04u
M27308 n5865 g559 VSS VSS nmos W=0.155u L=0.04u
M27309 U6739/XI1-net8 g559 VDD VDD pmos W=0.205u L=0.04u
M27310 n5865 g563 U6739/XI1-net8 VDD pmos W=0.205u L=0.04u
M27311 n3399 n4517 VSS VSS nmos W=0.135u L=0.04u
M27312 n3399 n4517 VDD VDD pmos W=0.205u L=0.04u
M27313 U6741/net19 II15499 VSS VSS nmos W=0.155u L=0.04u
M27314 n4517 II15499 U6741/net40 VSS nmos W=0.155u L=0.04u
M27315 n4517 U6741/net19 U6741/net36 VSS nmos W=0.155u L=0.04u
M27316 U6741/net40 n5867 VSS VSS nmos W=0.31u L=0.04u
M27317 U6741/net36 n5866 VSS VSS nmos W=0.155u L=0.04u
M27318 U6741/net19 II15499 VDD VDD pmos W=0.205u L=0.04u
M27319 n4517 U6741/net19 U6741/net26 VDD pmos W=0.325u L=0.04u
M27320 U6741/net26 n5867 VDD VDD pmos W=0.41u L=0.04u
M27321 n4517 II15499 U6741/net30 VDD pmos W=0.325u L=0.04u
M27322 U6741/net30 n5866 VDD VDD pmos W=0.205u L=0.04u
M27323 U6742/XU1-net6 n4271 VSS VSS nmos W=0.155u L=0.04u
M27324 n5867 g548 U6742/XU1-net6 VSS nmos W=0.155u L=0.04u
M27325 n5867 n4271 VDD VDD pmos W=0.155u L=0.04u
M27326 n5867 g548 VDD VDD pmos W=0.155u L=0.04u
M27327 n5866 g544 VSS VSS nmos W=0.135u L=0.04u
M27328 n5866 g544 VDD VDD pmos W=0.205u L=0.04u
M27329 n4271 g6485 VSS VSS nmos W=0.135u L=0.04u
M27330 n4271 g6485 VDD VDD pmos W=0.205u L=0.04u
M27331 U6745/net19 n4241 VSS VSS nmos W=0.155u L=0.04u
M27332 n5864 n4241 U6745/net40 VSS nmos W=0.155u L=0.04u
M27333 n5864 U6745/net19 U6745/net36 VSS nmos W=0.155u L=0.04u
M27334 U6745/net40 n4355 VSS VSS nmos W=0.31u L=0.04u
M27335 U6745/net36 n5845 VSS VSS nmos W=0.155u L=0.04u
M27336 U6745/net19 n4241 VDD VDD pmos W=0.205u L=0.04u
M27337 n5864 U6745/net19 U6745/net26 VDD pmos W=0.325u L=0.04u
M27338 U6745/net26 n4355 VDD VDD pmos W=0.41u L=0.04u
M27339 n5864 n4241 U6745/net30 VDD pmos W=0.325u L=0.04u
M27340 U6745/net30 n5845 VDD VDD pmos W=0.205u L=0.04u
M27341 n5845 n4355 VSS VSS nmos W=0.155u L=0.04u
M27342 n5845 n5835 VSS VSS nmos W=0.155u L=0.04u
M27343 U6746/XI1-net8 n5835 VDD VDD pmos W=0.205u L=0.04u
M27344 n5845 n4355 U6746/XI1-net8 VDD pmos W=0.205u L=0.04u
M27345 n5835 U6747/net6 VSS VSS nmos W=0.155u L=0.04u
M27346 U6747/X_u2-net6 n5869 VSS VSS nmos W=0.155u L=0.04u
M27347 U6747/net6 n5868 U6747/X_u2-net6 VSS nmos W=0.155u L=0.04u
M27348 n5835 U6747/net6 VDD VDD pmos W=0.205u L=0.04u
M27349 U6747/net6 n5869 VDD VDD pmos W=0.205u L=0.04u
M27350 U6747/net6 n5868 VDD VDD pmos W=0.205u L=0.04u
M27351 n5869 n4226 VSS VSS nmos W=0.155u L=0.04u
M27352 n5869 n4225 VSS VSS nmos W=0.155u L=0.04u
M27353 n5869 n4224 VSS VSS nmos W=0.155u L=0.04u
M27354 n5869 n5870 VSS VSS nmos W=0.155u L=0.04u
M27355 U6748/net49 n4225 U6748/net52 VDD pmos W=0.41u L=0.04u
M27356 U6748/net52 n4226 VDD VDD pmos W=0.41u L=0.04u
M27357 U6748/net46 n4224 U6748/net49 VDD pmos W=0.41u L=0.04u
M27358 n5869 n5870 U6748/net46 VDD pmos W=0.41u L=0.04u
M27359 U6749/net36 n4213 U6749/net27 VSS nmos W=0.155u L=0.04u
M27360 U6749/net39 n4180 VSS VSS nmos W=0.155u L=0.04u
M27361 U6749/net27 g706 U6749/net39 VSS nmos W=0.155u L=0.04u
M27362 U6749/net27 n4243 U6749/net39 VSS nmos W=0.155u L=0.04u
M27363 U6749/net36 g705 U6749/net27 VSS nmos W=0.155u L=0.04u
M27364 U6749/net39 g704 VSS VSS nmos W=0.155u L=0.04u
M27365 n4226 U6749/net36 VSS VSS nmos W=0.155u L=0.04u
M27366 n4226 U6749/net36 VDD VDD pmos W=0.205u L=0.04u
M27367 U6749/net36 n4180 U6749/net46 VDD pmos W=0.205u L=0.04u
M27368 U6749/net46 g704 VDD VDD pmos W=0.205u L=0.04u
M27369 U6749/net36 g705 U6749/net34 VDD pmos W=0.205u L=0.04u
M27370 U6749/net34 n4213 VDD VDD pmos W=0.205u L=0.04u
M27371 U6749/net36 n4243 U6749/net37 VDD pmos W=0.205u L=0.04u
M27372 U6749/net37 g706 VDD VDD pmos W=0.205u L=0.04u
M27373 U6750/net36 n4213 U6750/net27 VSS nmos W=0.155u L=0.04u
M27374 U6750/net39 n4180 VSS VSS nmos W=0.155u L=0.04u
M27375 U6750/net27 g727 U6750/net39 VSS nmos W=0.155u L=0.04u
M27376 U6750/net27 n4243 U6750/net39 VSS nmos W=0.155u L=0.04u
M27377 U6750/net36 g726 U6750/net27 VSS nmos W=0.155u L=0.04u
M27378 U6750/net39 g725 VSS VSS nmos W=0.155u L=0.04u
M27379 n4225 U6750/net36 VSS VSS nmos W=0.155u L=0.04u
M27380 n4225 U6750/net36 VDD VDD pmos W=0.205u L=0.04u
M27381 U6750/net36 n4180 U6750/net46 VDD pmos W=0.205u L=0.04u
M27382 U6750/net46 g725 VDD VDD pmos W=0.205u L=0.04u
M27383 U6750/net36 g726 U6750/net34 VDD pmos W=0.205u L=0.04u
M27384 U6750/net34 n4213 VDD VDD pmos W=0.205u L=0.04u
M27385 U6750/net36 n4243 U6750/net37 VDD pmos W=0.205u L=0.04u
M27386 U6750/net37 g727 VDD VDD pmos W=0.205u L=0.04u
M27387 U6751/net36 n4213 U6751/net27 VSS nmos W=0.155u L=0.04u
M27388 U6751/net39 n4180 VSS VSS nmos W=0.155u L=0.04u
M27389 U6751/net27 g724 U6751/net39 VSS nmos W=0.155u L=0.04u
M27390 U6751/net27 n4243 U6751/net39 VSS nmos W=0.155u L=0.04u
M27391 U6751/net36 g723 U6751/net27 VSS nmos W=0.155u L=0.04u
M27392 U6751/net39 g722 VSS VSS nmos W=0.155u L=0.04u
M27393 n4224 U6751/net36 VSS VSS nmos W=0.155u L=0.04u
M27394 n4224 U6751/net36 VDD VDD pmos W=0.205u L=0.04u
M27395 U6751/net36 n4180 U6751/net46 VDD pmos W=0.205u L=0.04u
M27396 U6751/net46 g722 VDD VDD pmos W=0.205u L=0.04u
M27397 U6751/net36 g723 U6751/net34 VDD pmos W=0.205u L=0.04u
M27398 U6751/net34 n4213 VDD VDD pmos W=0.205u L=0.04u
M27399 U6751/net36 n4243 U6751/net37 VDD pmos W=0.205u L=0.04u
M27400 U6751/net37 g724 VDD VDD pmos W=0.205u L=0.04u
M27401 n5870 n4230 U6752/XI0-net10 VSS nmos W=0.155u L=0.04u
M27402 U6752/XI0-net10 n4242 U6752/XI0-net13 VSS nmos W=0.155u L=0.04u
M27403 U6752/XI0-net13 n4229 VSS VSS nmos W=0.155u L=0.04u
M27404 n5870 n4229 VDD VDD pmos W=0.205u L=0.04u
M27405 n5870 n4230 VDD VDD pmos W=0.205u L=0.04u
M27406 n5870 n4242 VDD VDD pmos W=0.205u L=0.04u
M27407 n4229 n4213 U6753/net27 VSS nmos W=0.155u L=0.04u
M27408 U6753/net39 n4243 VSS VSS nmos W=0.155u L=0.04u
M27409 U6753/net27 g701 U6753/net39 VSS nmos W=0.155u L=0.04u
M27410 U6753/net27 n4180 U6753/net39 VSS nmos W=0.155u L=0.04u
M27411 n4229 g702 U6753/net27 VSS nmos W=0.155u L=0.04u
M27412 U6753/net39 g703 VSS VSS nmos W=0.155u L=0.04u
M27413 n4229 n4243 U6753/net46 VDD pmos W=0.205u L=0.04u
M27414 U6753/net46 g703 VDD VDD pmos W=0.205u L=0.04u
M27415 n4229 g702 U6753/net34 VDD pmos W=0.205u L=0.04u
M27416 U6753/net34 n4213 VDD VDD pmos W=0.205u L=0.04u
M27417 n4229 n4180 U6753/net37 VDD pmos W=0.205u L=0.04u
M27418 U6753/net37 g701 VDD VDD pmos W=0.205u L=0.04u
M27419 n4242 n4213 U6754/net27 VSS nmos W=0.155u L=0.04u
M27420 U6754/net39 n4243 VSS VSS nmos W=0.155u L=0.04u
M27421 U6754/net27 g731 U6754/net39 VSS nmos W=0.155u L=0.04u
M27422 U6754/net27 n4180 U6754/net39 VSS nmos W=0.155u L=0.04u
M27423 n4242 g732 U6754/net27 VSS nmos W=0.155u L=0.04u
M27424 U6754/net39 g733 VSS VSS nmos W=0.155u L=0.04u
M27425 n4242 n4243 U6754/net46 VDD pmos W=0.205u L=0.04u
M27426 U6754/net46 g733 VDD VDD pmos W=0.205u L=0.04u
M27427 n4242 g732 U6754/net34 VDD pmos W=0.205u L=0.04u
M27428 U6754/net34 n4213 VDD VDD pmos W=0.205u L=0.04u
M27429 n4242 n4180 U6754/net37 VDD pmos W=0.205u L=0.04u
M27430 U6754/net37 g731 VDD VDD pmos W=0.205u L=0.04u
M27431 n4230 n4213 U6755/net27 VSS nmos W=0.155u L=0.04u
M27432 U6755/net39 n4243 VSS VSS nmos W=0.155u L=0.04u
M27433 U6755/net27 g707 U6755/net39 VSS nmos W=0.155u L=0.04u
M27434 U6755/net27 n4180 U6755/net39 VSS nmos W=0.155u L=0.04u
M27435 n4230 g708 U6755/net27 VSS nmos W=0.155u L=0.04u
M27436 U6755/net39 g709 VSS VSS nmos W=0.155u L=0.04u
M27437 n4230 n4243 U6755/net46 VDD pmos W=0.205u L=0.04u
M27438 U6755/net46 g709 VDD VDD pmos W=0.205u L=0.04u
M27439 n4230 g708 U6755/net34 VDD pmos W=0.205u L=0.04u
M27440 U6755/net34 n4213 VDD VDD pmos W=0.205u L=0.04u
M27441 n4230 n4180 U6755/net37 VDD pmos W=0.205u L=0.04u
M27442 U6755/net37 g707 VDD VDD pmos W=0.205u L=0.04u
M27443 n5868 n4236 VSS VSS nmos W=0.155u L=0.04u
M27444 n5868 n5872 VSS VSS nmos W=0.155u L=0.04u
M27445 n5868 n4235 VSS VSS nmos W=0.155u L=0.04u
M27446 n5868 n5871 VSS VSS nmos W=0.155u L=0.04u
M27447 U6756/net49 n5872 U6756/net52 VDD pmos W=0.41u L=0.04u
M27448 U6756/net52 n4236 VDD VDD pmos W=0.41u L=0.04u
M27449 U6756/net46 n4235 U6756/net49 VDD pmos W=0.41u L=0.04u
M27450 n5868 n5871 U6756/net46 VDD pmos W=0.41u L=0.04u
M27451 n4236 n4213 U6757/net27 VSS nmos W=0.155u L=0.04u
M27452 U6757/net39 n4243 VSS VSS nmos W=0.155u L=0.04u
M27453 U6757/net27 g719 U6757/net39 VSS nmos W=0.155u L=0.04u
M27454 U6757/net27 n4180 U6757/net39 VSS nmos W=0.155u L=0.04u
M27455 n4236 g720 U6757/net27 VSS nmos W=0.155u L=0.04u
M27456 U6757/net39 g721 VSS VSS nmos W=0.155u L=0.04u
M27457 n4236 n4243 U6757/net46 VDD pmos W=0.205u L=0.04u
M27458 U6757/net46 g721 VDD VDD pmos W=0.205u L=0.04u
M27459 n4236 g720 U6757/net34 VDD pmos W=0.205u L=0.04u
M27460 U6757/net34 n4213 VDD VDD pmos W=0.205u L=0.04u
M27461 n4236 n4180 U6757/net37 VDD pmos W=0.205u L=0.04u
M27462 U6757/net37 g719 VDD VDD pmos W=0.205u L=0.04u
M27463 U6758/net36 g739 U6758/net27 VSS nmos W=0.155u L=0.04u
M27464 U6758/net39 g738 VSS VSS nmos W=0.155u L=0.04u
M27465 U6758/net27 n4180 U6758/net39 VSS nmos W=0.155u L=0.04u
M27466 U6758/net27 g737 U6758/net39 VSS nmos W=0.155u L=0.04u
M27467 U6758/net36 n4243 U6758/net27 VSS nmos W=0.155u L=0.04u
M27468 U6758/net39 n4213 VSS VSS nmos W=0.155u L=0.04u
M27469 n5872 U6758/net36 VSS VSS nmos W=0.155u L=0.04u
M27470 n5872 U6758/net36 VDD VDD pmos W=0.205u L=0.04u
M27471 U6758/net36 g738 U6758/net46 VDD pmos W=0.205u L=0.04u
M27472 U6758/net46 n4213 VDD VDD pmos W=0.205u L=0.04u
M27473 U6758/net36 n4243 U6758/net34 VDD pmos W=0.205u L=0.04u
M27474 U6758/net34 g739 VDD VDD pmos W=0.205u L=0.04u
M27475 U6758/net36 g737 U6758/net37 VDD pmos W=0.205u L=0.04u
M27476 U6758/net37 n4180 VDD VDD pmos W=0.205u L=0.04u
M27477 n4235 n4213 U6759/net27 VSS nmos W=0.155u L=0.04u
M27478 U6759/net39 n4243 VSS VSS nmos W=0.155u L=0.04u
M27479 U6759/net27 g716 U6759/net39 VSS nmos W=0.155u L=0.04u
M27480 U6759/net27 n4180 U6759/net39 VSS nmos W=0.155u L=0.04u
M27481 n4235 g717 U6759/net27 VSS nmos W=0.155u L=0.04u
M27482 U6759/net39 g718 VSS VSS nmos W=0.155u L=0.04u
M27483 n4235 n4243 U6759/net46 VDD pmos W=0.205u L=0.04u
M27484 U6759/net46 g718 VDD VDD pmos W=0.205u L=0.04u
M27485 n4235 g717 U6759/net34 VDD pmos W=0.205u L=0.04u
M27486 U6759/net34 n4213 VDD VDD pmos W=0.205u L=0.04u
M27487 n4235 n4180 U6759/net37 VDD pmos W=0.205u L=0.04u
M27488 U6759/net37 g716 VDD VDD pmos W=0.205u L=0.04u
M27489 n5871 n4240 U6760/XI0-net10 VSS nmos W=0.155u L=0.04u
M27490 U6760/XI0-net10 n4237 U6760/XI0-net13 VSS nmos W=0.155u L=0.04u
M27491 U6760/XI0-net13 n4241 VSS VSS nmos W=0.155u L=0.04u
M27492 n5871 n4241 VDD VDD pmos W=0.205u L=0.04u
M27493 n5871 n4240 VDD VDD pmos W=0.205u L=0.04u
M27494 n5871 n4237 VDD VDD pmos W=0.205u L=0.04u
M27495 U6761/net36 n4213 U6761/net27 VSS nmos W=0.155u L=0.04u
M27496 U6761/net39 n4243 VSS VSS nmos W=0.155u L=0.04u
M27497 U6761/net27 g713 U6761/net39 VSS nmos W=0.155u L=0.04u
M27498 U6761/net27 n4180 U6761/net39 VSS nmos W=0.155u L=0.04u
M27499 U6761/net36 g714 U6761/net27 VSS nmos W=0.155u L=0.04u
M27500 U6761/net39 g715 VSS VSS nmos W=0.155u L=0.04u
M27501 n4241 U6761/net36 VSS VSS nmos W=0.155u L=0.04u
M27502 n4241 U6761/net36 VDD VDD pmos W=0.205u L=0.04u
M27503 U6761/net36 n4243 U6761/net46 VDD pmos W=0.205u L=0.04u
M27504 U6761/net46 g715 VDD VDD pmos W=0.205u L=0.04u
M27505 U6761/net36 g714 U6761/net34 VDD pmos W=0.205u L=0.04u
M27506 U6761/net34 n4213 VDD VDD pmos W=0.205u L=0.04u
M27507 U6761/net36 n4180 U6761/net37 VDD pmos W=0.205u L=0.04u
M27508 U6761/net37 g713 VDD VDD pmos W=0.205u L=0.04u
M27509 U6762/net36 n4213 U6762/net27 VSS nmos W=0.155u L=0.04u
M27510 U6762/net39 n4243 VSS VSS nmos W=0.155u L=0.04u
M27511 U6762/net27 g710 U6762/net39 VSS nmos W=0.155u L=0.04u
M27512 U6762/net27 n4180 U6762/net39 VSS nmos W=0.155u L=0.04u
M27513 U6762/net36 g711 U6762/net27 VSS nmos W=0.155u L=0.04u
M27514 U6762/net39 g712 VSS VSS nmos W=0.155u L=0.04u
M27515 n4237 U6762/net36 VSS VSS nmos W=0.155u L=0.04u
M27516 n4237 U6762/net36 VDD VDD pmos W=0.205u L=0.04u
M27517 U6762/net36 n4243 U6762/net46 VDD pmos W=0.205u L=0.04u
M27518 U6762/net46 g712 VDD VDD pmos W=0.205u L=0.04u
M27519 U6762/net36 g711 U6762/net34 VDD pmos W=0.205u L=0.04u
M27520 U6762/net34 n4213 VDD VDD pmos W=0.205u L=0.04u
M27521 U6762/net36 n4180 U6762/net37 VDD pmos W=0.205u L=0.04u
M27522 U6762/net37 g710 VDD VDD pmos W=0.205u L=0.04u
M27523 U6763/net36 n4213 U6763/net27 VSS nmos W=0.155u L=0.04u
M27524 U6763/net39 n4243 VSS VSS nmos W=0.155u L=0.04u
M27525 U6763/net27 g698 U6763/net39 VSS nmos W=0.155u L=0.04u
M27526 U6763/net27 n4180 U6763/net39 VSS nmos W=0.155u L=0.04u
M27527 U6763/net36 g699 U6763/net27 VSS nmos W=0.155u L=0.04u
M27528 U6763/net39 g700 VSS VSS nmos W=0.155u L=0.04u
M27529 n4240 U6763/net36 VSS VSS nmos W=0.155u L=0.04u
M27530 n4240 U6763/net36 VDD VDD pmos W=0.205u L=0.04u
M27531 U6763/net36 n4243 U6763/net46 VDD pmos W=0.205u L=0.04u
M27532 U6763/net46 g700 VDD VDD pmos W=0.205u L=0.04u
M27533 U6763/net36 g699 U6763/net34 VDD pmos W=0.205u L=0.04u
M27534 U6763/net34 n4213 VDD VDD pmos W=0.205u L=0.04u
M27535 U6763/net36 n4180 U6763/net37 VDD pmos W=0.205u L=0.04u
M27536 U6763/net37 g698 VDD VDD pmos W=0.205u L=0.04u
M27537 n4243 g6911 VSS VSS nmos W=0.135u L=0.04u
M27538 n4243 g6911 VDD VDD pmos W=0.205u L=0.04u
M27539 n4180 g629 VSS VSS nmos W=0.135u L=0.04u
M27540 n4180 g629 VDD VDD pmos W=0.205u L=0.04u
M27541 n4213 g6677 VSS VSS nmos W=0.135u L=0.04u
M27542 n4213 g6677 VDD VDD pmos W=0.205u L=0.04u
M27543 n4355 n4272 VSS VSS nmos W=0.135u L=0.04u
M27544 n4355 n4272 VDD VDD pmos W=0.205u L=0.04u
M27545 n4272 g550 U6768/XI21-net17 VSS nmos W=0.155u L=0.04u
M27546 U6768/XI21-net17 g611 VSS VSS nmos W=0.155u L=0.04u
M27547 n4272 g6485 U6768/XI6-net17 VSS nmos W=0.155u L=0.04u
M27548 U6768/XI6-net17 g605 VSS VSS nmos W=0.155u L=0.04u
M27549 n4272 g6642 U6768/XI20-net17 VSS nmos W=0.155u L=0.04u
M27550 U6768/XI20-net17 g608 VSS VSS nmos W=0.155u L=0.04u
M27551 VDD g550 U6768/net22 VDD pmos W=0.205u L=0.04u
M27552 VDD g611 U6768/net22 VDD pmos W=0.205u L=0.04u
M27553 U6768/net16 g6485 n4272 VDD pmos W=0.205u L=0.04u
M27554 U6768/net16 g605 n4272 VDD pmos W=0.205u L=0.04u
M27555 U6768/net22 g6642 U6768/net16 VDD pmos W=0.205u L=0.04u
M27556 U6768/net22 g608 U6768/net16 VDD pmos W=0.205u L=0.04u
M27557 U6769/net11 g525 VSS VSS nmos W=0.155u L=0.04u
M27558 U6769/net11 g557 VSS VSS nmos W=0.155u L=0.04u
M27559 n5838 g510 VSS VSS nmos W=0.155u L=0.04u
M27560 n5838 U6769/net11 VSS VSS nmos W=0.155u L=0.04u
M27561 U6769/XI1-net8 g557 VDD VDD pmos W=0.205u L=0.04u
M27562 U6769/net11 g525 U6769/XI1-net8 VDD pmos W=0.205u L=0.04u
M27563 U6769/XU39-net8 U6769/net11 VDD VDD pmos W=0.205u L=0.04u
M27564 n5838 g510 U6769/XU39-net8 VDD pmos W=0.205u L=0.04u
M27565 n5814 g510 U6770/net15 VSS nmos W=0.155u L=0.04u
M27566 n5814 g525 U6770/net15 VSS nmos W=0.155u L=0.04u
M27567 U6770/net15 n4245 VSS VSS nmos W=0.155u L=0.04u
M27568 n5814 n4245 VDD VDD pmos W=0.205u L=0.04u
M27569 n5814 g510 U6770/XI16-net11 VDD pmos W=0.205u L=0.04u
M27570 U6770/XI16-net11 g525 VDD VDD pmos W=0.205u L=0.04u
M27571 n4245 g557 VSS VSS nmos W=0.135u L=0.04u
M27572 n4245 g557 VDD VDD pmos W=0.205u L=0.04u
M27573 g26974 n329 VSS VSS nmos W=0.135u L=0.04u
M27574 g26974 n329 VDD VDD pmos W=0.205u L=0.04u
M27575 n329 n5875 VSS VSS nmos W=0.155u L=0.04u
M27576 n329 n5874 VSS VSS nmos W=0.155u L=0.04u
M27577 n329 n5873 VSS VSS nmos W=0.155u L=0.04u
M27578 U6773/net25 n5875 VDD VDD pmos W=0.41u L=0.04u
M27579 U6773/net28 n5874 U6773/net25 VDD pmos W=0.41u L=0.04u
M27580 n329 n5873 U6773/net28 VDD pmos W=0.41u L=0.04u
M27581 U6774/net36 n5877 U6774/net24 VSS nmos W=0.155u L=0.04u
M27582 U6774/net24 n5878 VSS VSS nmos W=0.155u L=0.04u
M27583 n5875 g3133 U6774/net36 VSS nmos W=0.155u L=0.04u
M27584 n5875 n5876 U6774/net36 VSS nmos W=0.155u L=0.04u
M27585 n5875 n5876 U6774/net35 VDD pmos W=0.205u L=0.04u
M27586 U6774/net35 g3133 VDD VDD pmos W=0.205u L=0.04u
M27587 n5875 n5878 VDD VDD pmos W=0.205u L=0.04u
M27588 n5875 n5877 VDD VDD pmos W=0.205u L=0.04u
M27589 U6775/net17 n5882 VSS VSS nmos W=0.155u L=0.04u
M27590 U6775/net17 n5881 VSS VSS nmos W=0.155u L=0.04u
M27591 U6775/net63 n5880 VSS VSS nmos W=0.155u L=0.04u
M27592 n5878 U6775/net17 VSS VSS nmos W=0.155u L=0.04u
M27593 n5878 n5879 U6775/net63 VSS nmos W=0.155u L=0.04u
M27594 n5878 n5880 U6775/net31 VDD pmos W=0.205u L=0.04u
M27595 U6775/net39 n5882 VDD VDD pmos W=0.195u L=0.04u
M27596 U6775/net31 U6775/net17 VDD VDD pmos W=0.195u L=0.04u
M27597 n5878 n5879 U6775/net31 VDD pmos W=0.195u L=0.04u
M27598 U6775/net17 n5881 U6775/net39 VDD pmos W=0.195u L=0.04u
M27599 n5874 n5883 U6776/net14 VSS nmos W=0.155u L=0.04u
M27600 U6776/net14 n5415 VSS VSS nmos W=0.155u L=0.04u
M27601 U6776/net14 n5885 VSS VSS nmos W=0.155u L=0.04u
M27602 n5874 n5884 U6776/net14 VSS nmos W=0.155u L=0.04u
M27603 n5874 g185 U6776/net14 VSS nmos W=0.155u L=0.04u
M27604 n5874 n5415 U6776/XI16-net11 VDD pmos W=0.205u L=0.04u
M27605 U6776/XI16-net11 n5885 VDD VDD pmos W=0.205u L=0.04u
M27606 n5874 n5884 U6776/XI15-net11 VDD pmos W=0.205u L=0.04u
M27607 U6776/XI15-net11 g185 U6776/XI15-net18 VDD pmos W=0.205u L=0.04u
M27608 U6776/XI15-net18 n5883 VDD VDD pmos W=0.205u L=0.04u
M27609 n5415 g3139 VSS VSS nmos W=0.135u L=0.04u
M27610 n5415 g3139 VDD VDD pmos W=0.205u L=0.04u
M27611 VSS n5888 U6778/net22 VSS nmos W=0.155u L=0.04u
M27612 U6778/net22 n5887 n5873 VSS nmos W=0.155u L=0.04u
M27613 U6778/net22 n5884 n5873 VSS nmos W=0.155u L=0.04u
M27614 U6778/net22 n5886 n5873 VSS nmos W=0.155u L=0.04u
M27615 U6778/net38 n5886 VDD VDD pmos W=0.205u L=0.04u
M27616 U6778/net35 n5884 U6778/net38 VDD pmos W=0.205u L=0.04u
M27617 n5873 n5887 U6778/net35 VDD pmos W=0.205u L=0.04u
M27618 n5873 n5888 VDD VDD pmos W=0.205u L=0.04u
M27619 n5887 n5889 VSS VSS nmos W=0.135u L=0.04u
M27620 n5887 n5889 VDD VDD pmos W=0.205u L=0.04u
M27621 n5886 n5890 U6780/net10 VSS nmos W=0.155u L=0.04u
M27622 U6780/net10 n5893 VSS VSS nmos W=0.155u L=0.04u
M27623 n5886 n5891 U6780/net10 VSS nmos W=0.155u L=0.04u
M27624 U6780/net10 n5892 VSS VSS nmos W=0.155u L=0.04u
M27625 U6780/net30 n5893 VDD VDD pmos W=0.205u L=0.04u
M27626 n5886 n5890 U6780/net24 VDD pmos W=0.205u L=0.04u
M27627 U6780/net24 n5891 VDD VDD pmos W=0.205u L=0.04u
M27628 n5886 n5892 U6780/net30 VDD pmos W=0.205u L=0.04u
M27629 n5891 g3114 VSS VSS nmos W=0.135u L=0.04u
M27630 n5891 g3114 VDD VDD pmos W=0.205u L=0.04u
M27631 U6782/p2 n5897 VSS VSS nmos W=0.155u L=0.04u
M27632 U6782/p0 n5895 U6782/p1 VSS nmos W=0.155u L=0.04u
M27633 U6782/p1 n5896 U6782/p2 VSS nmos W=0.155u L=0.04u
M27634 g26135 n5894 U6782/p0 VSS nmos W=0.155u L=0.04u
M27635 g26135 n5896 VDD VDD pmos W=0.205u L=0.04u
M27636 g26135 n5895 VDD VDD pmos W=0.205u L=0.04u
M27637 g26135 n5894 VDD VDD pmos W=0.205u L=0.04u
M27638 g26135 n5897 VDD VDD pmos W=0.205u L=0.04u
M27639 U6783/net36 n5899 U6783/net24 VSS nmos W=0.155u L=0.04u
M27640 U6783/net24 n5900 VSS VSS nmos W=0.155u L=0.04u
M27641 U6783/net33 n5882 U6783/net36 VSS nmos W=0.155u L=0.04u
M27642 U6783/net33 n5898 U6783/net36 VSS nmos W=0.155u L=0.04u
M27643 n5897 U6783/net33 VSS VSS nmos W=0.155u L=0.04u
M27644 n5897 U6783/net33 VDD VDD pmos W=0.205u L=0.04u
M27645 U6783/net33 n5898 U6783/net35 VDD pmos W=0.205u L=0.04u
M27646 U6783/net35 n5882 VDD VDD pmos W=0.205u L=0.04u
M27647 U6783/net33 n5900 VDD VDD pmos W=0.205u L=0.04u
M27648 U6783/net33 n5899 VDD VDD pmos W=0.205u L=0.04u
M27649 U6784/net29 n5902 VSS VSS nmos W=0.155u L=0.04u
M27650 n5900 g3100 U6784/net29 VSS nmos W=0.155u L=0.04u
M27651 n5900 g3099 U6784/net23 VSS nmos W=0.155u L=0.04u
M27652 U6784/net23 n5901 VSS VSS nmos W=0.155u L=0.04u
M27653 U6784/net20 n5901 n5900 VDD pmos W=0.205u L=0.04u
M27654 U6784/net20 g3099 n5900 VDD pmos W=0.205u L=0.04u
M27655 VDD g3100 U6784/net20 VDD pmos W=0.205u L=0.04u
M27656 VDD n5902 U6784/net20 VDD pmos W=0.205u L=0.04u
M27657 n5899 n5903 U6785/net23 VDD pmos W=0.205u L=0.04u
M27658 n5899 g3097 U6785/net23 VDD pmos W=0.205u L=0.04u
M27659 n5899 n5904 U6785/net23 VDD pmos W=0.205u L=0.04u
M27660 U6785/net23 g3134 VDD VDD pmos W=0.205u L=0.04u
M27661 U6785/net23 n5905 VDD VDD pmos W=0.205u L=0.04u
M27662 U6785/XI20-net13 g3097 VSS VSS nmos W=0.155u L=0.04u
M27663 n5899 n5903 U6785/XI20-net17 VSS nmos W=0.155u L=0.04u
M27664 U6785/XI20-net17 n5904 U6785/XI20-net13 VSS nmos W=0.155u L=0.04u
M27665 n5899 g3134 U6785/XI17-net17 VSS nmos W=0.155u L=0.04u
M27666 U6785/XI17-net17 n5905 VSS VSS nmos W=0.155u L=0.04u
M27667 n5896 n5908 VSS VSS nmos W=0.155u L=0.04u
M27668 n5896 g3114 U6786/XI17-net17 VSS nmos W=0.155u L=0.04u
M27669 U6786/XI17-net17 n5907 VSS VSS nmos W=0.155u L=0.04u
M27670 n5896 g3098 U6786/XI10-net17 VSS nmos W=0.155u L=0.04u
M27671 U6786/XI10-net17 n5906 VSS VSS nmos W=0.155u L=0.04u
M27672 U6786/net30 g3098 n5896 VDD pmos W=0.205u L=0.04u
M27673 U6786/net30 n5906 n5896 VDD pmos W=0.205u L=0.04u
M27674 VDD n5908 U6786/net36 VDD pmos W=0.205u L=0.04u
M27675 U6786/net36 n5907 U6786/net30 VDD pmos W=0.205u L=0.04u
M27676 U6786/net36 g3114 U6786/net30 VDD pmos W=0.205u L=0.04u
M27677 n5908 n5909 U6787/net14 VSS nmos W=0.155u L=0.04u
M27678 U6787/net14 n5876 VSS VSS nmos W=0.155u L=0.04u
M27679 U6787/net14 g3128 VSS VSS nmos W=0.155u L=0.04u
M27680 n5908 n5911 U6787/net14 VSS nmos W=0.155u L=0.04u
M27681 n5908 n5910 U6787/net14 VSS nmos W=0.155u L=0.04u
M27682 n5908 n5876 U6787/XI16-net11 VDD pmos W=0.205u L=0.04u
M27683 U6787/XI16-net11 g3128 VDD VDD pmos W=0.205u L=0.04u
M27684 n5908 n5911 U6787/XI15-net11 VDD pmos W=0.205u L=0.04u
M27685 U6787/XI15-net11 n5910 U6787/XI15-net18 VDD pmos W=0.205u L=0.04u
M27686 U6787/XI15-net18 n5909 VDD VDD pmos W=0.205u L=0.04u
M27687 n5909 g3106 VSS VSS nmos W=0.135u L=0.04u
M27688 n5909 g3106 VDD VDD pmos W=0.205u L=0.04u
M27689 U6789/net36 n5912 U6789/net24 VSS nmos W=0.155u L=0.04u
M27690 U6789/net24 n5913 VSS VSS nmos W=0.155u L=0.04u
M27691 U6789/net33 n5888 U6789/net36 VSS nmos W=0.155u L=0.04u
M27692 U6789/net33 n5890 U6789/net36 VSS nmos W=0.155u L=0.04u
M27693 n5895 U6789/net33 VSS VSS nmos W=0.155u L=0.04u
M27694 n5895 U6789/net33 VDD VDD pmos W=0.205u L=0.04u
M27695 U6789/net33 n5890 U6789/net35 VDD pmos W=0.205u L=0.04u
M27696 U6789/net35 n5888 VDD VDD pmos W=0.205u L=0.04u
M27697 U6789/net33 n5913 VDD VDD pmos W=0.205u L=0.04u
M27698 U6789/net33 n5912 VDD VDD pmos W=0.205u L=0.04u
M27699 U6790/net29 g3101 VSS VSS nmos W=0.155u L=0.04u
M27700 n5913 n5915 U6790/net29 VSS nmos W=0.155u L=0.04u
M27701 n5913 n5914 U6790/net23 VSS nmos W=0.155u L=0.04u
M27702 U6790/net23 g3102 VSS VSS nmos W=0.155u L=0.04u
M27703 U6790/net20 g3102 n5913 VDD pmos W=0.205u L=0.04u
M27704 U6790/net20 n5914 n5913 VDD pmos W=0.205u L=0.04u
M27705 VDD n5915 U6790/net20 VDD pmos W=0.205u L=0.04u
M27706 VDD g3101 U6790/net20 VDD pmos W=0.205u L=0.04u
M27707 n5912 g3105 U6791/net23 VDD pmos W=0.205u L=0.04u
M27708 n5912 n5903 U6791/net23 VDD pmos W=0.205u L=0.04u
M27709 n5912 n5889 U6791/net23 VDD pmos W=0.205u L=0.04u
M27710 U6791/net23 n5916 VDD VDD pmos W=0.205u L=0.04u
M27711 U6791/net23 g3103 VDD VDD pmos W=0.205u L=0.04u
M27712 U6791/XI20-net13 n5903 VSS VSS nmos W=0.155u L=0.04u
M27713 n5912 g3105 U6791/XI20-net17 VSS nmos W=0.155u L=0.04u
M27714 U6791/XI20-net17 n5889 U6791/XI20-net13 VSS nmos W=0.155u L=0.04u
M27715 n5912 n5916 U6791/XI17-net17 VSS nmos W=0.155u L=0.04u
M27716 U6791/XI17-net17 g3103 VSS VSS nmos W=0.155u L=0.04u
M27717 U6792/net11 g3108 n5894 VDD pmos W=0.205u L=0.04u
M27718 U6792/net11 n5917 n5894 VDD pmos W=0.205u L=0.04u
M27719 U6792/net11 n5918 U6792/XI16-net11 VDD pmos W=0.205u L=0.04u
M27720 U6792/XI16-net11 n5919 VDD VDD pmos W=0.205u L=0.04u
M27721 n5894 n5919 VSS VSS nmos W=0.155u L=0.04u
M27722 n5894 n5918 VSS VSS nmos W=0.155u L=0.04u
M27723 n5894 g3108 U6792/XI12-net17 VSS nmos W=0.155u L=0.04u
M27724 U6792/XI12-net17 n5917 VSS VSS nmos W=0.155u L=0.04u
M27725 U6793/net29 g3107 VSS VSS nmos W=0.155u L=0.04u
M27726 U6793/net26 n5921 U6793/net20 VSS nmos W=0.155u L=0.04u
M27727 U6793/net20 g3104 VSS VSS nmos W=0.155u L=0.04u
M27728 U6793/net26 n5920 U6793/net29 VSS nmos W=0.155u L=0.04u
M27729 n5918 U6793/net26 VSS VSS nmos W=0.155u L=0.04u
M27730 n5918 U6793/net26 VDD VDD pmos W=0.205u L=0.04u
M27731 U6793/net26 n5920 U6793/net40 VDD pmos W=0.205u L=0.04u
M27732 U6793/net26 g3107 U6793/net40 VDD pmos W=0.205u L=0.04u
M27733 U6793/net40 g3104 VDD VDD pmos W=0.205u L=0.04u
M27734 U6793/net40 n5921 VDD VDD pmos W=0.205u L=0.04u
M27735 U6794/p2 n5925 VSS VSS nmos W=0.155u L=0.04u
M27736 U6794/p0 n5923 U6794/p1 VSS nmos W=0.155u L=0.04u
M27737 U6794/p1 n5924 U6794/p2 VSS nmos W=0.155u L=0.04u
M27738 g25566 n5922 U6794/p0 VSS nmos W=0.155u L=0.04u
M27739 g25566 n5924 VDD VDD pmos W=0.205u L=0.04u
M27740 g25566 n5923 VDD VDD pmos W=0.205u L=0.04u
M27741 g25566 n5922 VDD VDD pmos W=0.205u L=0.04u
M27742 g25566 n5925 VDD VDD pmos W=0.205u L=0.04u
M27743 n5925 n5927 VSS VSS nmos W=0.155u L=0.04u
M27744 n5925 n5903 U6795/XI17-net17 VSS nmos W=0.155u L=0.04u
M27745 U6795/XI17-net17 n5926 VSS VSS nmos W=0.155u L=0.04u
M27746 n5925 g3167 U6795/XI10-net17 VSS nmos W=0.155u L=0.04u
M27747 U6795/XI10-net17 n5915 VSS VSS nmos W=0.155u L=0.04u
M27748 U6795/net30 g3167 n5925 VDD pmos W=0.205u L=0.04u
M27749 U6795/net30 n5915 n5925 VDD pmos W=0.205u L=0.04u
M27750 VDD n5927 U6795/net36 VDD pmos W=0.205u L=0.04u
M27751 U6795/net36 n5926 U6795/net30 VDD pmos W=0.205u L=0.04u
M27752 U6795/net36 n5903 U6795/net30 VDD pmos W=0.205u L=0.04u
M27753 U6796/net29 g3173 VSS VSS nmos W=0.155u L=0.04u
M27754 U6796/net26 n5914 U6796/net20 VSS nmos W=0.155u L=0.04u
M27755 U6796/net20 g3170 VSS VSS nmos W=0.155u L=0.04u
M27756 U6796/net26 n5916 U6796/net29 VSS nmos W=0.155u L=0.04u
M27757 n5927 U6796/net26 VSS VSS nmos W=0.155u L=0.04u
M27758 n5927 U6796/net26 VDD VDD pmos W=0.205u L=0.04u
M27759 U6796/net26 n5916 U6796/net40 VDD pmos W=0.205u L=0.04u
M27760 U6796/net26 g3173 U6796/net40 VDD pmos W=0.205u L=0.04u
M27761 U6796/net40 g3170 VDD VDD pmos W=0.205u L=0.04u
M27762 U6796/net40 n5914 VDD VDD pmos W=0.205u L=0.04u
M27763 n5926 U6797/net39 VDD VDD pmos W=0.205u L=0.04u
M27764 VDD n5904 U6797/net22 VDD pmos W=0.205u L=0.04u
M27765 VDD g3155 U6797/net22 VDD pmos W=0.205u L=0.04u
M27766 U6797/net16 n5889 U6797/net39 VDD pmos W=0.205u L=0.04u
M27767 U6797/net16 g3179 U6797/net39 VDD pmos W=0.205u L=0.04u
M27768 U6797/net22 n5928 U6797/net16 VDD pmos W=0.205u L=0.04u
M27769 U6797/net22 g3182 U6797/net16 VDD pmos W=0.205u L=0.04u
M27770 n5926 U6797/net39 VSS VSS nmos W=0.155u L=0.04u
M27771 U6797/net39 n5904 U6797/XI22-net17 VSS nmos W=0.155u L=0.04u
M27772 U6797/XI22-net17 g3155 VSS VSS nmos W=0.155u L=0.04u
M27773 U6797/net39 n5889 U6797/XI6-net17 VSS nmos W=0.155u L=0.04u
M27774 U6797/XI6-net17 g3179 VSS VSS nmos W=0.155u L=0.04u
M27775 U6797/net39 n5928 U6797/XI21-net17 VSS nmos W=0.155u L=0.04u
M27776 U6797/XI21-net17 g3182 VSS VSS nmos W=0.155u L=0.04u
M27777 n5924 g3185 U6798/XI21-net17 VSS nmos W=0.155u L=0.04u
M27778 U6798/XI21-net17 n5920 VSS VSS nmos W=0.155u L=0.04u
M27779 n5924 g3088 U6798/XI6-net17 VSS nmos W=0.155u L=0.04u
M27780 U6798/XI6-net17 n5917 VSS VSS nmos W=0.155u L=0.04u
M27781 n5924 g3176 U6798/XI20-net17 VSS nmos W=0.155u L=0.04u
M27782 U6798/XI20-net17 n5921 VSS VSS nmos W=0.155u L=0.04u
M27783 VDD g3185 U6798/net22 VDD pmos W=0.205u L=0.04u
M27784 VDD n5920 U6798/net22 VDD pmos W=0.205u L=0.04u
M27785 U6798/net16 g3088 n5924 VDD pmos W=0.205u L=0.04u
M27786 U6798/net16 n5917 n5924 VDD pmos W=0.205u L=0.04u
M27787 U6798/net22 g3176 U6798/net16 VDD pmos W=0.205u L=0.04u
M27788 U6798/net22 n5921 U6798/net16 VDD pmos W=0.205u L=0.04u
M27789 n5923 n5929 VSS VSS nmos W=0.155u L=0.04u
M27790 n5923 g3161 U6799/XI17-net17 VSS nmos W=0.155u L=0.04u
M27791 U6799/XI17-net17 n5901 VSS VSS nmos W=0.155u L=0.04u
M27792 n5923 g3135 U6799/XI10-net17 VSS nmos W=0.155u L=0.04u
M27793 U6799/XI10-net17 n5905 VSS VSS nmos W=0.155u L=0.04u
M27794 U6799/net30 g3135 n5923 VDD pmos W=0.205u L=0.04u
M27795 U6799/net30 n5905 n5923 VDD pmos W=0.205u L=0.04u
M27796 VDD n5929 U6799/net36 VDD pmos W=0.205u L=0.04u
M27797 U6799/net36 n5901 U6799/net30 VDD pmos W=0.205u L=0.04u
M27798 U6799/net36 g3161 U6799/net30 VDD pmos W=0.205u L=0.04u
M27799 U6800/net29 g3158 VSS VSS nmos W=0.155u L=0.04u
M27800 U6800/net26 n5902 U6800/net20 VSS nmos W=0.155u L=0.04u
M27801 U6800/net20 g3164 VSS VSS nmos W=0.155u L=0.04u
M27802 U6800/net26 n5906 U6800/net29 VSS nmos W=0.155u L=0.04u
M27803 n5929 U6800/net26 VSS VSS nmos W=0.155u L=0.04u
M27804 n5929 U6800/net26 VDD VDD pmos W=0.205u L=0.04u
M27805 U6800/net26 n5906 U6800/net40 VDD pmos W=0.205u L=0.04u
M27806 U6800/net26 g3158 U6800/net40 VDD pmos W=0.205u L=0.04u
M27807 U6800/net40 g3164 VDD VDD pmos W=0.205u L=0.04u
M27808 U6800/net40 n5902 VDD VDD pmos W=0.205u L=0.04u
M27809 n5922 n5919 VSS VSS nmos W=0.155u L=0.04u
M27810 n5922 g3127 U6801/XI17-net17 VSS nmos W=0.155u L=0.04u
M27811 U6801/XI17-net17 n5930 VSS VSS nmos W=0.155u L=0.04u
M27812 n5922 g3113 U6801/XI10-net17 VSS nmos W=0.155u L=0.04u
M27813 U6801/XI10-net17 n5907 VSS VSS nmos W=0.155u L=0.04u
M27814 U6801/net30 g3113 n5922 VDD pmos W=0.205u L=0.04u
M27815 U6801/net30 n5907 n5922 VDD pmos W=0.205u L=0.04u
M27816 VDD n5919 U6801/net36 VDD pmos W=0.205u L=0.04u
M27817 U6801/net36 n5930 U6801/net30 VDD pmos W=0.205u L=0.04u
M27818 U6801/net36 g3127 U6801/net30 VDD pmos W=0.205u L=0.04u
M27819 U6802/p2 n5934 VSS VSS nmos W=0.155u L=0.04u
M27820 U6802/p0 n5932 U6802/p1 VSS nmos W=0.155u L=0.04u
M27821 U6802/p1 n5933 U6802/p2 VSS nmos W=0.155u L=0.04u
M27822 g25490 n5931 U6802/p0 VSS nmos W=0.155u L=0.04u
M27823 g25490 n5933 VDD VDD pmos W=0.205u L=0.04u
M27824 g25490 n5932 VDD VDD pmos W=0.205u L=0.04u
M27825 g25490 n5931 VDD VDD pmos W=0.205u L=0.04u
M27826 g25490 n5934 VDD VDD pmos W=0.205u L=0.04u
M27827 n5934 n5936 VSS VSS nmos W=0.155u L=0.04u
M27828 n5934 g3087 U6803/XI17-net17 VSS nmos W=0.155u L=0.04u
M27829 U6803/XI17-net17 n5914 VSS VSS nmos W=0.155u L=0.04u
M27830 n5934 n5903 U6803/XI10-net17 VSS nmos W=0.155u L=0.04u
M27831 U6803/XI10-net17 n5935 VSS VSS nmos W=0.155u L=0.04u
M27832 U6803/net30 n5903 n5934 VDD pmos W=0.205u L=0.04u
M27833 U6803/net30 n5935 n5934 VDD pmos W=0.205u L=0.04u
M27834 VDD n5936 U6803/net36 VDD pmos W=0.205u L=0.04u
M27835 U6803/net36 n5914 U6803/net30 VDD pmos W=0.205u L=0.04u
M27836 U6803/net36 g3087 U6803/net30 VDD pmos W=0.205u L=0.04u
M27837 U6804/net8 n5915 U6804/net26 VSS nmos W=0.155u L=0.04u
M27838 U6804/net26 g3086 VSS VSS nmos W=0.155u L=0.04u
M27839 U6804/net29 U6804/net8 VSS VSS nmos W=0.155u L=0.04u
M27840 U6804/net29 n5892 n5936 VSS nmos W=0.155u L=0.04u
M27841 U6804/net29 n5888 n5936 VSS nmos W=0.155u L=0.04u
M27842 U6804/net8 g3086 VDD VDD pmos W=0.205u L=0.04u
M27843 U6804/net8 n5915 VDD VDD pmos W=0.205u L=0.04u
M27844 n5936 U6804/net8 VDD VDD pmos W=0.205u L=0.04u
M27845 n5936 n5892 U6804/net20 VDD pmos W=0.205u L=0.04u
M27846 U6804/net20 n5888 VDD VDD pmos W=0.205u L=0.04u
M27847 n5915 n5884 VSS VSS nmos W=0.155u L=0.04u
M27848 n5915 n5937 VSS VSS nmos W=0.155u L=0.04u
M27849 U6805/XI1-net8 n5937 VDD VDD pmos W=0.205u L=0.04u
M27850 n5915 n5884 U6805/XI1-net8 VDD pmos W=0.205u L=0.04u
M27851 U6806/XU1-net6 n5904 VSS VSS nmos W=0.155u L=0.04u
M27852 n5888 n5880 U6806/XU1-net6 VSS nmos W=0.155u L=0.04u
M27853 n5888 n5904 VDD VDD pmos W=0.155u L=0.04u
M27854 n5888 n5880 VDD VDD pmos W=0.155u L=0.04u
M27855 n5914 n5939 VSS VSS nmos W=0.155u L=0.04u
M27856 n5914 n5884 VSS VSS nmos W=0.155u L=0.04u
M27857 n5914 U6807/net12 VSS VSS nmos W=0.155u L=0.04u
M27858 U6807/net12 n5938 VSS VSS nmos W=0.155u L=0.04u
M27859 U6807/XU9-net9 U6807/net12 VDD VDD pmos W=0.41u L=0.04u
M27860 U6807/XU9-net12 n5884 U6807/XU9-net9 VDD pmos W=0.41u L=0.04u
M27861 n5914 n5939 U6807/XU9-net12 VDD pmos W=0.41u L=0.04u
M27862 U6807/net12 n5938 VDD VDD pmos W=0.31u L=0.04u
M27863 n5935 U6808/net39 VDD VDD pmos W=0.205u L=0.04u
M27864 VDD n5904 U6808/net22 VDD pmos W=0.205u L=0.04u
M27865 VDD g3210 U6808/net22 VDD pmos W=0.205u L=0.04u
M27866 U6808/net16 n5889 U6808/net39 VDD pmos W=0.205u L=0.04u
M27867 U6808/net16 g3093 U6808/net39 VDD pmos W=0.205u L=0.04u
M27868 U6808/net22 n5928 U6808/net16 VDD pmos W=0.205u L=0.04u
M27869 U6808/net22 g3094 U6808/net16 VDD pmos W=0.205u L=0.04u
M27870 n5935 U6808/net39 VSS VSS nmos W=0.155u L=0.04u
M27871 U6808/net39 n5904 U6808/XI22-net17 VSS nmos W=0.155u L=0.04u
M27872 U6808/XI22-net17 g3210 VSS VSS nmos W=0.155u L=0.04u
M27873 U6808/net39 n5889 U6808/XI6-net17 VSS nmos W=0.155u L=0.04u
M27874 U6808/XI6-net17 g3093 VSS VSS nmos W=0.155u L=0.04u
M27875 U6808/net39 n5928 U6808/XI21-net17 VSS nmos W=0.155u L=0.04u
M27876 U6808/XI21-net17 g3094 VSS VSS nmos W=0.155u L=0.04u
M27877 n5928 n5883 VSS VSS nmos W=0.135u L=0.04u
M27878 n5928 n5883 VDD VDD pmos W=0.205u L=0.04u
M27879 U6810/XU1-net6 n5879 VSS VSS nmos W=0.155u L=0.04u
M27880 n5883 g3188 U6810/XU1-net6 VSS nmos W=0.155u L=0.04u
M27881 n5883 n5879 VDD VDD pmos W=0.155u L=0.04u
M27882 n5883 g3188 VDD VDD pmos W=0.155u L=0.04u
M27883 n5933 n5940 VSS VSS nmos W=0.155u L=0.04u
M27884 n5933 g3096 U6811/XI17-net17 VSS nmos W=0.155u L=0.04u
M27885 U6811/XI17-net17 n5917 VSS VSS nmos W=0.155u L=0.04u
M27886 n5933 g3095 U6811/XI10-net17 VSS nmos W=0.155u L=0.04u
M27887 U6811/XI10-net17 n5920 VSS VSS nmos W=0.155u L=0.04u
M27888 U6811/net30 g3095 n5933 VDD pmos W=0.205u L=0.04u
M27889 U6811/net30 n5920 n5933 VDD pmos W=0.205u L=0.04u
M27890 VDD n5940 U6811/net36 VDD pmos W=0.205u L=0.04u
M27891 U6811/net36 n5917 U6811/net30 VDD pmos W=0.205u L=0.04u
M27892 U6811/net36 g3096 U6811/net30 VDD pmos W=0.205u L=0.04u
M27893 U6812/net29 g3092 VSS VSS nmos W=0.155u L=0.04u
M27894 U6812/net26 n5916 U6812/net20 VSS nmos W=0.155u L=0.04u
M27895 U6812/net20 g3091 VSS VSS nmos W=0.155u L=0.04u
M27896 U6812/net26 n5921 U6812/net29 VSS nmos W=0.155u L=0.04u
M27897 n5940 U6812/net26 VSS VSS nmos W=0.155u L=0.04u
M27898 n5940 U6812/net26 VDD VDD pmos W=0.205u L=0.04u
M27899 U6812/net26 n5921 U6812/net40 VDD pmos W=0.205u L=0.04u
M27900 U6812/net26 g3092 U6812/net40 VDD pmos W=0.205u L=0.04u
M27901 U6812/net40 g3091 VDD VDD pmos W=0.205u L=0.04u
M27902 U6812/net40 n5916 VDD VDD pmos W=0.205u L=0.04u
M27903 n5916 n5884 VSS VSS nmos W=0.155u L=0.04u
M27904 n5916 g3201 VSS VSS nmos W=0.155u L=0.04u
M27905 n5916 U6813/net12 VSS VSS nmos W=0.155u L=0.04u
M27906 U6813/net12 n5941 VSS VSS nmos W=0.155u L=0.04u
M27907 U6813/XU9-net9 U6813/net12 VDD VDD pmos W=0.41u L=0.04u
M27908 U6813/XU9-net12 g3201 U6813/XU9-net9 VDD pmos W=0.41u L=0.04u
M27909 n5916 n5884 U6813/XU9-net12 VDD pmos W=0.41u L=0.04u
M27910 U6813/net12 n5941 VDD VDD pmos W=0.31u L=0.04u
M27911 n5921 g3201 VSS VSS nmos W=0.155u L=0.04u
M27912 n5921 n5942 VSS VSS nmos W=0.155u L=0.04u
M27913 n5921 n5884 VSS VSS nmos W=0.155u L=0.04u
M27914 n5921 n5939 VSS VSS nmos W=0.155u L=0.04u
M27915 U6814/net49 n5942 U6814/net52 VDD pmos W=0.41u L=0.04u
M27916 U6814/net52 g3201 VDD VDD pmos W=0.41u L=0.04u
M27917 U6814/net46 n5884 U6814/net49 VDD pmos W=0.41u L=0.04u
M27918 n5921 n5939 U6814/net46 VDD pmos W=0.41u L=0.04u
M27919 n5884 g3204 U6815/XI0-net10 VSS nmos W=0.155u L=0.04u
M27920 U6815/XI0-net10 n5943 U6815/XI0-net13 VSS nmos W=0.155u L=0.04u
M27921 U6815/XI0-net13 g3197 VSS VSS nmos W=0.155u L=0.04u
M27922 n5884 g3197 VDD VDD pmos W=0.205u L=0.04u
M27923 n5884 g3204 VDD VDD pmos W=0.205u L=0.04u
M27924 n5884 n5943 VDD VDD pmos W=0.205u L=0.04u
M27925 n5917 n5911 VSS VSS nmos W=0.155u L=0.04u
M27926 n5917 n5942 VSS VSS nmos W=0.155u L=0.04u
M27927 n5917 n5944 VSS VSS nmos W=0.155u L=0.04u
M27928 U6816/net25 n5911 VDD VDD pmos W=0.41u L=0.04u
M27929 U6816/net28 n5942 U6816/net25 VDD pmos W=0.41u L=0.04u
M27930 n5917 n5944 U6816/net28 VDD pmos W=0.41u L=0.04u
M27931 n5920 n5945 VSS VSS nmos W=0.155u L=0.04u
M27932 n5920 n5944 VSS VSS nmos W=0.155u L=0.04u
M27933 n5920 U6817/net12 VSS VSS nmos W=0.155u L=0.04u
M27934 U6817/net12 n5941 VSS VSS nmos W=0.155u L=0.04u
M27935 U6817/XU9-net9 U6817/net12 VDD VDD pmos W=0.41u L=0.04u
M27936 U6817/XU9-net12 n5944 U6817/XU9-net9 VDD pmos W=0.41u L=0.04u
M27937 n5920 n5945 U6817/XU9-net12 VDD pmos W=0.41u L=0.04u
M27938 U6817/net12 n5941 VDD VDD pmos W=0.31u L=0.04u
M27939 n5932 n5946 VSS VSS nmos W=0.155u L=0.04u
M27940 n5932 g3085 U6818/XI17-net17 VSS nmos W=0.155u L=0.04u
M27941 U6818/XI17-net17 n5902 VSS VSS nmos W=0.155u L=0.04u
M27942 n5932 g3084 U6818/XI10-net17 VSS nmos W=0.155u L=0.04u
M27943 U6818/XI10-net17 n5901 VSS VSS nmos W=0.155u L=0.04u
M27944 U6818/net30 g3084 n5932 VDD pmos W=0.205u L=0.04u
M27945 U6818/net30 n5901 n5932 VDD pmos W=0.205u L=0.04u
M27946 VDD n5946 U6818/net36 VDD pmos W=0.205u L=0.04u
M27947 U6818/net36 n5902 U6818/net30 VDD pmos W=0.205u L=0.04u
M27948 U6818/net36 g3085 U6818/net30 VDD pmos W=0.205u L=0.04u
M27949 U6819/net8 n5905 U6819/net26 VSS nmos W=0.155u L=0.04u
M27950 U6819/net26 g3136 VSS VSS nmos W=0.155u L=0.04u
M27951 U6819/net29 U6819/net8 VSS VSS nmos W=0.155u L=0.04u
M27952 U6819/net29 n5882 n5946 VSS nmos W=0.155u L=0.04u
M27953 U6819/net29 n5947 n5946 VSS nmos W=0.155u L=0.04u
M27954 U6819/net8 g3136 VDD VDD pmos W=0.205u L=0.04u
M27955 U6819/net8 n5905 VDD VDD pmos W=0.205u L=0.04u
M27956 n5946 U6819/net8 VDD VDD pmos W=0.205u L=0.04u
M27957 n5946 n5882 U6819/net20 VDD pmos W=0.205u L=0.04u
M27958 U6819/net20 n5947 VDD VDD pmos W=0.205u L=0.04u
M27959 n5905 n5885 VSS VSS nmos W=0.135u L=0.04u
M27960 n5905 n5885 VDD VDD pmos W=0.205u L=0.04u
M27961 U6821/XU1-net6 n5948 VSS VSS nmos W=0.155u L=0.04u
M27962 n5885 n5889 U6821/XU1-net6 VSS nmos W=0.155u L=0.04u
M27963 n5885 n5948 VDD VDD pmos W=0.155u L=0.04u
M27964 n5885 n5889 VDD VDD pmos W=0.155u L=0.04u
M27965 n5889 n5910 VSS VSS nmos W=0.155u L=0.04u
M27966 n5889 g3188 VSS VSS nmos W=0.155u L=0.04u
M27967 U6822/XI1-net8 g3188 VDD VDD pmos W=0.205u L=0.04u
M27968 n5889 n5910 U6822/XI1-net8 VDD pmos W=0.205u L=0.04u
M27969 n5910 n5879 VSS VSS nmos W=0.135u L=0.04u
M27970 n5910 n5879 VDD VDD pmos W=0.205u L=0.04u
M27971 n5879 n5944 VSS VSS nmos W=0.155u L=0.04u
M27972 n5879 g3207 VSS VSS nmos W=0.155u L=0.04u
M27973 U6824/XI1-net8 g3207 VDD VDD pmos W=0.205u L=0.04u
M27974 n5879 n5944 U6824/XI1-net8 VDD pmos W=0.205u L=0.04u
M27975 n5947 g3142 VSS VSS nmos W=0.135u L=0.04u
M27976 n5947 g3142 VDD VDD pmos W=0.205u L=0.04u
M27977 n5882 n5941 U6826/XI0-net10 VSS nmos W=0.155u L=0.04u
M27978 U6826/XI0-net10 n5948 U6826/XI0-net13 VSS nmos W=0.155u L=0.04u
M27979 U6826/XI0-net13 g3201 VSS VSS nmos W=0.155u L=0.04u
M27980 n5882 g3201 VDD VDD pmos W=0.205u L=0.04u
M27981 n5882 n5941 VDD VDD pmos W=0.205u L=0.04u
M27982 n5882 n5948 VDD VDD pmos W=0.205u L=0.04u
M27983 n5902 n5911 VSS VSS nmos W=0.155u L=0.04u
M27984 n5902 g3201 VSS VSS nmos W=0.155u L=0.04u
M27985 n5902 n5942 VSS VSS nmos W=0.155u L=0.04u
M27986 U6827/net25 n5911 VDD VDD pmos W=0.41u L=0.04u
M27987 U6827/net28 g3201 U6827/net25 VDD pmos W=0.41u L=0.04u
M27988 n5902 n5942 U6827/net28 VDD pmos W=0.41u L=0.04u
M27989 U6828/net7 n5941 U6828/X_u4-net10 VSS nmos W=0.155u L=0.04u
M27990 U6828/X_u4-net10 n5944 U6828/X_u4-net13 VSS nmos W=0.155u L=0.04u
M27991 U6828/X_u4-net13 n5903 VSS VSS nmos W=0.155u L=0.04u
M27992 n5901 U6828/net7 VSS VSS nmos W=0.155u L=0.04u
M27993 U6828/net7 n5903 VDD VDD pmos W=0.205u L=0.04u
M27994 U6828/net7 n5941 VDD VDD pmos W=0.205u L=0.04u
M27995 U6828/net7 n5944 VDD VDD pmos W=0.205u L=0.04u
M27996 n5901 U6828/net7 VDD VDD pmos W=0.205u L=0.04u
M27997 n5944 g3201 VSS VSS nmos W=0.135u L=0.04u
M27998 n5944 g3201 VDD VDD pmos W=0.205u L=0.04u
M27999 U6830/net11 g3132 n5931 VDD pmos W=0.205u L=0.04u
M28000 U6830/net11 n5930 n5931 VDD pmos W=0.205u L=0.04u
M28001 U6830/net11 n5949 U6830/XI16-net11 VDD pmos W=0.205u L=0.04u
M28002 U6830/XI16-net11 n5919 VDD VDD pmos W=0.205u L=0.04u
M28003 n5931 n5919 VSS VSS nmos W=0.155u L=0.04u
M28004 n5931 n5949 VSS VSS nmos W=0.155u L=0.04u
M28005 n5931 g3132 U6830/XI12-net17 VSS nmos W=0.155u L=0.04u
M28006 U6830/XI12-net17 n5930 VSS VSS nmos W=0.155u L=0.04u
M28007 U6831/net8 n5906 U6831/net26 VSS nmos W=0.155u L=0.04u
M28008 U6831/net26 g3211 VSS VSS nmos W=0.155u L=0.04u
M28009 U6831/net29 U6831/net8 VSS VSS nmos W=0.155u L=0.04u
M28010 U6831/net29 n5950 n5949 VSS nmos W=0.155u L=0.04u
M28011 U6831/net29 n5893 n5949 VSS nmos W=0.155u L=0.04u
M28012 U6831/net8 g3211 VDD VDD pmos W=0.205u L=0.04u
M28013 U6831/net8 n5906 VDD VDD pmos W=0.205u L=0.04u
M28014 n5949 U6831/net8 VDD VDD pmos W=0.205u L=0.04u
M28015 n5949 n5950 U6831/net20 VDD pmos W=0.205u L=0.04u
M28016 U6831/net20 n5893 VDD VDD pmos W=0.205u L=0.04u
M28017 n5906 n5911 VSS VSS nmos W=0.155u L=0.04u
M28018 n5906 U6832/net4 VSS VSS nmos W=0.155u L=0.04u
M28019 U6832/net4 n5938 VSS VSS nmos W=0.155u L=0.04u
M28020 U6832/XU1-net8 U6832/net4 VDD VDD pmos W=0.205u L=0.04u
M28021 n5906 n5911 U6832/XU1-net8 VDD pmos W=0.205u L=0.04u
M28022 U6832/net4 n5938 VDD VDD pmos W=0.205u L=0.04u
M28023 U6833/XU1-net6 g3188 VSS VSS nmos W=0.155u L=0.04u
M28024 n5911 n5903 U6833/XU1-net6 VSS nmos W=0.155u L=0.04u
M28025 n5911 g3188 VDD VDD pmos W=0.155u L=0.04u
M28026 n5911 n5903 VDD VDD pmos W=0.155u L=0.04u
M28027 n5903 n5945 VSS VSS nmos W=0.135u L=0.04u
M28028 n5903 n5945 VDD VDD pmos W=0.205u L=0.04u
M28029 n5945 n5943 U6835/XI0-net10 VSS nmos W=0.155u L=0.04u
M28030 U6835/XI0-net10 n5951 U6835/XI0-net13 VSS nmos W=0.155u L=0.04u
M28031 U6835/XI0-net13 g3197 VSS VSS nmos W=0.155u L=0.04u
M28032 n5945 g3197 VDD VDD pmos W=0.205u L=0.04u
M28033 n5945 n5943 VDD VDD pmos W=0.205u L=0.04u
M28034 n5945 n5951 VDD VDD pmos W=0.205u L=0.04u
M28035 n5893 g3120 VSS VSS nmos W=0.135u L=0.04u
M28036 n5893 g3120 VDD VDD pmos W=0.205u L=0.04u
M28037 U6837/net19 n5898 VSS VSS nmos W=0.155u L=0.04u
M28038 g25489 n5898 U6837/net40 VSS nmos W=0.155u L=0.04u
M28039 g25489 U6837/net19 U6837/net36 VSS nmos W=0.155u L=0.04u
M28040 U6837/net40 n5953 VSS VSS nmos W=0.31u L=0.04u
M28041 U6837/net36 n5952 VSS VSS nmos W=0.155u L=0.04u
M28042 U6837/net19 n5898 VDD VDD pmos W=0.205u L=0.04u
M28043 g25489 U6837/net19 U6837/net26 VDD pmos W=0.325u L=0.04u
M28044 U6837/net26 n5953 VDD VDD pmos W=0.41u L=0.04u
M28045 g25489 n5898 U6837/net30 VDD pmos W=0.325u L=0.04u
M28046 U6837/net30 n5952 VDD VDD pmos W=0.205u L=0.04u
M28047 n5898 g3147 VSS VSS nmos W=0.135u L=0.04u
M28048 n5898 g3147 VDD VDD pmos W=0.205u L=0.04u
M28049 U6839/net17 n5892 VSS VSS nmos W=0.155u L=0.04u
M28050 U6839/net17 g3142 VSS VSS nmos W=0.155u L=0.04u
M28051 U6839/net63 n5954 VSS VSS nmos W=0.155u L=0.04u
M28052 n5953 U6839/net17 VSS VSS nmos W=0.155u L=0.04u
M28053 n5953 n5881 U6839/net63 VSS nmos W=0.155u L=0.04u
M28054 n5953 n5954 U6839/net31 VDD pmos W=0.205u L=0.04u
M28055 U6839/net39 n5892 VDD VDD pmos W=0.195u L=0.04u
M28056 U6839/net31 U6839/net17 VDD VDD pmos W=0.195u L=0.04u
M28057 n5953 n5881 U6839/net31 VDD pmos W=0.195u L=0.04u
M28058 U6839/net17 g3142 U6839/net39 VDD pmos W=0.195u L=0.04u
M28059 n5892 g2984 VSS VSS nmos W=0.155u L=0.04u
M28060 n5892 g2985 VSS VSS nmos W=0.155u L=0.04u
M28061 U6840/XI1-net8 g2985 VDD VDD pmos W=0.205u L=0.04u
M28062 n5892 g2984 U6840/XI1-net8 VDD pmos W=0.205u L=0.04u
M28063 U6841/XU1-net6 g3142 VSS VSS nmos W=0.155u L=0.04u
M28064 n5954 n5890 U6841/XU1-net6 VSS nmos W=0.155u L=0.04u
M28065 n5954 g3142 VDD VDD pmos W=0.155u L=0.04u
M28066 n5954 n5890 VDD VDD pmos W=0.155u L=0.04u
M28067 n5890 g2991 VSS VSS nmos W=0.155u L=0.04u
M28068 n5890 g2992 VSS VSS nmos W=0.155u L=0.04u
M28069 U6842/XI1-net8 g2992 VDD VDD pmos W=0.205u L=0.04u
M28070 n5890 g2991 U6842/XI1-net8 VDD pmos W=0.205u L=0.04u
M28071 n5881 g3151 VSS VSS nmos W=0.135u L=0.04u
M28072 n5881 g3151 VDD VDD pmos W=0.205u L=0.04u
M28073 n5952 g3151 U6844/XI0-net10 VSS nmos W=0.155u L=0.04u
M28074 U6844/XI0-net10 g3097 U6844/XI0-net13 VSS nmos W=0.155u L=0.04u
M28075 U6844/XI0-net13 g3142 VSS VSS nmos W=0.155u L=0.04u
M28076 n5952 g3142 VDD VDD pmos W=0.205u L=0.04u
M28077 n5952 g3151 VDD VDD pmos W=0.205u L=0.04u
M28078 n5952 g3097 VDD VDD pmos W=0.205u L=0.04u
M28079 g25442 n3307 VSS VSS nmos W=0.135u L=0.04u
M28080 g25442 n3307 VDD VDD pmos W=0.205u L=0.04u
M28081 n3307 n5919 VSS VSS nmos W=0.155u L=0.04u
M28082 n3307 g3124 U6846/XI17-net17 VSS nmos W=0.155u L=0.04u
M28083 U6846/XI17-net17 n5930 VSS VSS nmos W=0.155u L=0.04u
M28084 n3307 g3111 U6846/XI10-net17 VSS nmos W=0.155u L=0.04u
M28085 U6846/XI10-net17 n5907 VSS VSS nmos W=0.155u L=0.04u
M28086 U6846/net30 g3111 n3307 VDD pmos W=0.205u L=0.04u
M28087 U6846/net30 n5907 n3307 VDD pmos W=0.205u L=0.04u
M28088 VDD n5919 U6846/net36 VDD pmos W=0.205u L=0.04u
M28089 U6846/net36 n5930 U6846/net30 VDD pmos W=0.205u L=0.04u
M28090 U6846/net36 g3124 U6846/net30 VDD pmos W=0.205u L=0.04u
M28091 g25420 n3306 VSS VSS nmos W=0.135u L=0.04u
M28092 g25420 n3306 VDD VDD pmos W=0.205u L=0.04u
M28093 n3306 n5919 VSS VSS nmos W=0.155u L=0.04u
M28094 n3306 g3126 U6848/XI17-net17 VSS nmos W=0.155u L=0.04u
M28095 U6848/XI17-net17 n5930 VSS VSS nmos W=0.155u L=0.04u
M28096 n3306 g3112 U6848/XI10-net17 VSS nmos W=0.155u L=0.04u
M28097 U6848/XI10-net17 n5907 VSS VSS nmos W=0.155u L=0.04u
M28098 U6848/net30 g3112 n3306 VDD pmos W=0.205u L=0.04u
M28099 U6848/net30 n5907 n3306 VDD pmos W=0.205u L=0.04u
M28100 VDD n5919 U6848/net36 VDD pmos W=0.205u L=0.04u
M28101 U6848/net36 n5930 U6848/net30 VDD pmos W=0.205u L=0.04u
M28102 U6848/net36 g3126 U6848/net30 VDD pmos W=0.205u L=0.04u
M28103 n5919 n5877 VSS VSS nmos W=0.135u L=0.04u
M28104 n5919 n5877 VDD VDD pmos W=0.205u L=0.04u
M28105 n5930 n5876 VSS VSS nmos W=0.135u L=0.04u
M28106 n5930 n5876 VDD VDD pmos W=0.205u L=0.04u
M28107 U6851/net36 n5955 U6851/net24 VSS nmos W=0.155u L=0.04u
M28108 U6851/net24 n5877 VSS VSS nmos W=0.155u L=0.04u
M28109 g24909 g3125 U6851/net36 VSS nmos W=0.155u L=0.04u
M28110 g24909 n5876 U6851/net36 VSS nmos W=0.155u L=0.04u
M28111 g24909 n5876 U6851/net35 VDD pmos W=0.205u L=0.04u
M28112 U6851/net35 g3125 VDD VDD pmos W=0.205u L=0.04u
M28113 g24909 n5877 VDD VDD pmos W=0.205u L=0.04u
M28114 g24909 n5955 VDD VDD pmos W=0.205u L=0.04u
M28115 U6852/XU1-net6 n5907 VSS VSS nmos W=0.155u L=0.04u
M28116 n5955 g3110 U6852/XU1-net6 VSS nmos W=0.155u L=0.04u
M28117 n5955 n5907 VDD VDD pmos W=0.155u L=0.04u
M28118 n5955 g3110 VDD VDD pmos W=0.155u L=0.04u
M28119 n5907 n5950 VSS VSS nmos W=0.135u L=0.04u
M28120 n5907 n5950 VDD VDD pmos W=0.205u L=0.04u
M28121 U6854/XU1-net6 n5904 VSS VSS nmos W=0.155u L=0.04u
M28122 n5950 n5948 U6854/XU1-net6 VSS nmos W=0.155u L=0.04u
M28123 n5950 n5904 VDD VDD pmos W=0.155u L=0.04u
M28124 n5950 n5948 VDD VDD pmos W=0.155u L=0.04u
M28125 n5904 n5937 VSS VSS nmos W=0.135u L=0.04u
M28126 n5904 n5937 VDD VDD pmos W=0.205u L=0.04u
M28127 U6856/XU1-net6 n5939 VSS VSS nmos W=0.155u L=0.04u
M28128 n5937 n5938 U6856/XU1-net6 VSS nmos W=0.155u L=0.04u
M28129 n5937 n5939 VDD VDD pmos W=0.155u L=0.04u
M28130 n5937 n5938 VDD VDD pmos W=0.155u L=0.04u
M28131 n5939 g3188 VSS VSS nmos W=0.135u L=0.04u
M28132 n5939 g3188 VDD VDD pmos W=0.205u L=0.04u
M28133 n5938 g3201 VSS VSS nmos W=0.155u L=0.04u
M28134 n5938 g3207 VSS VSS nmos W=0.155u L=0.04u
M28135 U6858/XI1-net8 g3207 VDD VDD pmos W=0.205u L=0.04u
M28136 n5938 g3201 U6858/XI1-net8 VDD pmos W=0.205u L=0.04u
M28137 n5948 n5951 VSS VSS nmos W=0.155u L=0.04u
M28138 n5948 g3197 VSS VSS nmos W=0.155u L=0.04u
M28139 n5948 U6859/net12 VSS VSS nmos W=0.155u L=0.04u
M28140 U6859/net12 n5943 VSS VSS nmos W=0.155u L=0.04u
M28141 U6859/XU9-net9 U6859/net12 VDD VDD pmos W=0.41u L=0.04u
M28142 U6859/XU9-net12 g3197 U6859/XU9-net9 VDD pmos W=0.41u L=0.04u
M28143 n5948 n5951 U6859/XU9-net12 VDD pmos W=0.41u L=0.04u
M28144 U6859/net12 n5943 VDD VDD pmos W=0.31u L=0.04u
M28145 n5951 g3204 VSS VSS nmos W=0.135u L=0.04u
M28146 n5951 g3204 VDD VDD pmos W=0.205u L=0.04u
M28147 g23919 g3123 U6861/net15 VSS nmos W=0.155u L=0.04u
M28148 g23919 n5876 U6861/net15 VSS nmos W=0.155u L=0.04u
M28149 U6861/net15 n5877 VSS VSS nmos W=0.155u L=0.04u
M28150 g23919 n5877 VDD VDD pmos W=0.205u L=0.04u
M28151 g23919 g3123 U6861/XI16-net11 VDD pmos W=0.205u L=0.04u
M28152 U6861/XI16-net11 n5876 VDD VDD pmos W=0.205u L=0.04u
M28153 n5877 g3230 VSS VSS nmos W=0.155u L=0.04u
M28154 n5877 U6862/net4 VSS VSS nmos W=0.155u L=0.04u
M28155 U6862/net4 g3233 VSS VSS nmos W=0.155u L=0.04u
M28156 U6862/XU1-net8 U6862/net4 VDD VDD pmos W=0.205u L=0.04u
M28157 n5877 g3230 U6862/XU1-net8 VDD pmos W=0.205u L=0.04u
M28158 U6862/net4 g3233 VDD VDD pmos W=0.205u L=0.04u
M28159 n5876 n5941 U6863/XI0-net10 VSS nmos W=0.155u L=0.04u
M28160 U6863/XI0-net10 n5880 U6863/XI0-net13 VSS nmos W=0.155u L=0.04u
M28161 U6863/XI0-net13 g3201 VSS VSS nmos W=0.155u L=0.04u
M28162 n5876 g3201 VDD VDD pmos W=0.205u L=0.04u
M28163 n5876 n5941 VDD VDD pmos W=0.205u L=0.04u
M28164 n5876 n5880 VDD VDD pmos W=0.205u L=0.04u
M28165 n5880 g3204 VSS VSS nmos W=0.155u L=0.04u
M28166 n5880 g3197 VSS VSS nmos W=0.155u L=0.04u
M28167 n5880 U6864/net12 VSS VSS nmos W=0.155u L=0.04u
M28168 U6864/net12 n5943 VSS VSS nmos W=0.155u L=0.04u
M28169 U6864/XU9-net9 U6864/net12 VDD VDD pmos W=0.41u L=0.04u
M28170 U6864/XU9-net12 g3197 U6864/XU9-net9 VDD pmos W=0.41u L=0.04u
M28171 n5880 g3204 U6864/XU9-net12 VDD pmos W=0.41u L=0.04u
M28172 U6864/net12 n5943 VDD VDD pmos W=0.31u L=0.04u
M28173 n5943 g3191 VSS VSS nmos W=0.155u L=0.04u
M28174 n5943 g3194 VSS VSS nmos W=0.155u L=0.04u
M28175 n5943 g3198 VSS VSS nmos W=0.155u L=0.04u
M28176 U6865/net25 g3191 VDD VDD pmos W=0.41u L=0.04u
M28177 U6865/net28 g3194 U6865/net25 VDD pmos W=0.41u L=0.04u
M28178 n5943 g3198 U6865/net28 VDD pmos W=0.41u L=0.04u
M28179 n5941 n5942 VSS VSS nmos W=0.155u L=0.04u
M28180 n5941 g3188 VSS VSS nmos W=0.155u L=0.04u
M28181 U6866/XI1-net8 g3188 VDD VDD pmos W=0.205u L=0.04u
M28182 n5941 n5942 U6866/XI1-net8 VDD pmos W=0.205u L=0.04u
M28183 n5942 g3207 VSS VSS nmos W=0.135u L=0.04u
M28184 n5942 g3207 VDD VDD pmos W=0.205u L=0.04u
M28185 g12268 II18743 U6868/XI21-net17 VSS nmos W=0.155u L=0.04u
M28186 U6868/XI21-net17 g2476 VSS VSS nmos W=0.155u L=0.04u
M28187 g12268 II18737 U6868/XI6-net17 VSS nmos W=0.155u L=0.04u
M28188 U6868/XI6-net17 g5555 VSS VSS nmos W=0.155u L=0.04u
M28189 g12268 II18740 U6868/XI20-net17 VSS nmos W=0.155u L=0.04u
M28190 U6868/XI20-net17 g7264 VSS VSS nmos W=0.155u L=0.04u
M28191 VDD II18743 U6868/net22 VDD pmos W=0.205u L=0.04u
M28192 VDD g2476 U6868/net22 VDD pmos W=0.205u L=0.04u
M28193 U6868/net16 II18737 g12268 VDD pmos W=0.205u L=0.04u
M28194 U6868/net16 g5555 g12268 VDD pmos W=0.205u L=0.04u
M28195 U6868/net22 II18740 U6868/net16 VDD pmos W=0.205u L=0.04u
M28196 U6868/net22 g7264 U6868/net16 VDD pmos W=0.205u L=0.04u
M28197 g12224 II18734 U6869/XI21-net17 VSS nmos W=0.155u L=0.04u
M28198 U6869/XI21-net17 g2476 VSS VSS nmos W=0.155u L=0.04u
M28199 g12224 II18728 U6869/XI6-net17 VSS nmos W=0.155u L=0.04u
M28200 U6869/XI6-net17 g5555 VSS VSS nmos W=0.155u L=0.04u
M28201 g12224 II18731 U6869/XI20-net17 VSS nmos W=0.155u L=0.04u
M28202 U6869/XI20-net17 g7264 VSS VSS nmos W=0.155u L=0.04u
M28203 VDD II18734 U6869/net22 VDD pmos W=0.205u L=0.04u
M28204 VDD g2476 U6869/net22 VDD pmos W=0.205u L=0.04u
M28205 U6869/net16 II18728 g12224 VDD pmos W=0.205u L=0.04u
M28206 U6869/net16 g5555 g12224 VDD pmos W=0.205u L=0.04u
M28207 U6869/net22 II18731 U6869/net16 VDD pmos W=0.205u L=0.04u
M28208 U6869/net22 g7264 U6869/net16 VDD pmos W=0.205u L=0.04u
M28209 g12213 II18662 U6870/XI21-net17 VSS nmos W=0.155u L=0.04u
M28210 U6870/XI21-net17 g1782 VSS VSS nmos W=0.155u L=0.04u
M28211 g12213 II18656 U6870/XI6-net17 VSS nmos W=0.155u L=0.04u
M28212 U6870/XI6-net17 g5511 VSS VSS nmos W=0.155u L=0.04u
M28213 g12213 II18659 U6870/XI20-net17 VSS nmos W=0.155u L=0.04u
M28214 U6870/XI20-net17 g7014 VSS VSS nmos W=0.155u L=0.04u
M28215 VDD II18662 U6870/net22 VDD pmos W=0.205u L=0.04u
M28216 VDD g1782 U6870/net22 VDD pmos W=0.205u L=0.04u
M28217 U6870/net16 II18656 g12213 VDD pmos W=0.205u L=0.04u
M28218 U6870/net16 g5511 g12213 VDD pmos W=0.205u L=0.04u
M28219 U6870/net22 II18659 U6870/net16 VDD pmos W=0.205u L=0.04u
M28220 U6870/net22 g7014 U6870/net16 VDD pmos W=0.205u L=0.04u
M28221 g12179 II18725 U6871/XI21-net17 VSS nmos W=0.155u L=0.04u
M28222 U6871/XI21-net17 g2476 VSS VSS nmos W=0.155u L=0.04u
M28223 g12179 II18719 U6871/XI6-net17 VSS nmos W=0.155u L=0.04u
M28224 U6871/XI6-net17 g5555 VSS VSS nmos W=0.155u L=0.04u
M28225 g12179 II18722 U6871/XI20-net17 VSS nmos W=0.155u L=0.04u
M28226 U6871/XI20-net17 g7264 VSS VSS nmos W=0.155u L=0.04u
M28227 VDD II18725 U6871/net22 VDD pmos W=0.205u L=0.04u
M28228 VDD g2476 U6871/net22 VDD pmos W=0.205u L=0.04u
M28229 U6871/net16 II18719 g12179 VDD pmos W=0.205u L=0.04u
M28230 U6871/net16 g5555 g12179 VDD pmos W=0.205u L=0.04u
M28231 U6871/net22 II18722 U6871/net16 VDD pmos W=0.205u L=0.04u
M28232 U6871/net22 g7264 U6871/net16 VDD pmos W=0.205u L=0.04u
M28233 g12162 II18653 U6872/XI21-net17 VSS nmos W=0.155u L=0.04u
M28234 U6872/XI21-net17 g1782 VSS VSS nmos W=0.155u L=0.04u
M28235 g12162 II18647 U6872/XI6-net17 VSS nmos W=0.155u L=0.04u
M28236 U6872/XI6-net17 g5511 VSS VSS nmos W=0.155u L=0.04u
M28237 g12162 II18650 U6872/XI20-net17 VSS nmos W=0.155u L=0.04u
M28238 U6872/XI20-net17 g7014 VSS VSS nmos W=0.155u L=0.04u
M28239 VDD II18653 U6872/net22 VDD pmos W=0.205u L=0.04u
M28240 VDD g1782 U6872/net22 VDD pmos W=0.205u L=0.04u
M28241 U6872/net16 II18647 g12162 VDD pmos W=0.205u L=0.04u
M28242 U6872/net16 g5511 g12162 VDD pmos W=0.205u L=0.04u
M28243 U6872/net22 II18650 U6872/net16 VDD pmos W=0.205u L=0.04u
M28244 U6872/net22 g7014 U6872/net16 VDD pmos W=0.205u L=0.04u
M28245 g12151 II18581 U6873/XI21-net17 VSS nmos W=0.155u L=0.04u
M28246 U6873/XI21-net17 g1088 VSS VSS nmos W=0.155u L=0.04u
M28247 g12151 II18575 U6873/XI6-net17 VSS nmos W=0.155u L=0.04u
M28248 U6873/XI6-net17 g5472 VSS VSS nmos W=0.155u L=0.04u
M28249 g12151 II18578 U6873/XI20-net17 VSS nmos W=0.155u L=0.04u
M28250 U6873/XI20-net17 g6712 VSS VSS nmos W=0.155u L=0.04u
M28251 VDD II18581 U6873/net22 VDD pmos W=0.205u L=0.04u
M28252 VDD g1088 U6873/net22 VDD pmos W=0.205u L=0.04u
M28253 U6873/net16 II18575 g12151 VDD pmos W=0.205u L=0.04u
M28254 U6873/net16 g5472 g12151 VDD pmos W=0.205u L=0.04u
M28255 U6873/net22 II18578 U6873/net16 VDD pmos W=0.205u L=0.04u
M28256 U6873/net22 g6712 U6873/net16 VDD pmos W=0.205u L=0.04u
M28257 g12120 II18716 U6874/XI21-net17 VSS nmos W=0.155u L=0.04u
M28258 U6874/XI21-net17 g2476 VSS VSS nmos W=0.155u L=0.04u
M28259 g12120 II18710 U6874/XI6-net17 VSS nmos W=0.155u L=0.04u
M28260 U6874/XI6-net17 g5555 VSS VSS nmos W=0.155u L=0.04u
M28261 g12120 II18713 U6874/XI20-net17 VSS nmos W=0.155u L=0.04u
M28262 U6874/XI20-net17 g7264 VSS VSS nmos W=0.155u L=0.04u
M28263 VDD II18716 U6874/net22 VDD pmos W=0.205u L=0.04u
M28264 VDD g2476 U6874/net22 VDD pmos W=0.205u L=0.04u
M28265 U6874/net16 II18710 g12120 VDD pmos W=0.205u L=0.04u
M28266 U6874/net16 g5555 g12120 VDD pmos W=0.205u L=0.04u
M28267 U6874/net22 II18713 U6874/net16 VDD pmos W=0.205u L=0.04u
M28268 U6874/net22 g7264 U6874/net16 VDD pmos W=0.205u L=0.04u
M28269 g12107 II18644 U6875/XI21-net17 VSS nmos W=0.155u L=0.04u
M28270 U6875/XI21-net17 g1782 VSS VSS nmos W=0.155u L=0.04u
M28271 g12107 II18638 U6875/XI6-net17 VSS nmos W=0.155u L=0.04u
M28272 U6875/XI6-net17 g5511 VSS VSS nmos W=0.155u L=0.04u
M28273 g12107 II18641 U6875/XI20-net17 VSS nmos W=0.155u L=0.04u
M28274 U6875/XI20-net17 g7014 VSS VSS nmos W=0.155u L=0.04u
M28275 VDD II18644 U6875/net22 VDD pmos W=0.205u L=0.04u
M28276 VDD g1782 U6875/net22 VDD pmos W=0.205u L=0.04u
M28277 U6875/net16 II18638 g12107 VDD pmos W=0.205u L=0.04u
M28278 U6875/net16 g5511 g12107 VDD pmos W=0.205u L=0.04u
M28279 U6875/net22 II18641 U6875/net16 VDD pmos W=0.205u L=0.04u
M28280 U6875/net22 g7014 U6875/net16 VDD pmos W=0.205u L=0.04u
M28281 g12090 II18572 U6876/XI21-net17 VSS nmos W=0.155u L=0.04u
M28282 U6876/XI21-net17 g1088 VSS VSS nmos W=0.155u L=0.04u
M28283 g12090 II18566 U6876/XI6-net17 VSS nmos W=0.155u L=0.04u
M28284 U6876/XI6-net17 g5472 VSS VSS nmos W=0.155u L=0.04u
M28285 g12090 II18569 U6876/XI20-net17 VSS nmos W=0.155u L=0.04u
M28286 U6876/XI20-net17 g6712 VSS VSS nmos W=0.155u L=0.04u
M28287 VDD II18572 U6876/net22 VDD pmos W=0.205u L=0.04u
M28288 VDD g1088 U6876/net22 VDD pmos W=0.205u L=0.04u
M28289 U6876/net16 II18566 g12090 VDD pmos W=0.205u L=0.04u
M28290 U6876/net16 g5472 g12090 VDD pmos W=0.205u L=0.04u
M28291 U6876/net22 II18569 U6876/net16 VDD pmos W=0.205u L=0.04u
M28292 U6876/net22 g6712 U6876/net16 VDD pmos W=0.205u L=0.04u
M28293 g12079 II18500 U6877/XI21-net17 VSS nmos W=0.155u L=0.04u
M28294 U6877/XI21-net17 g401 VSS VSS nmos W=0.155u L=0.04u
M28295 g12079 II18494 U6877/XI6-net17 VSS nmos W=0.155u L=0.04u
M28296 U6877/XI6-net17 g5437 VSS VSS nmos W=0.155u L=0.04u
M28297 g12079 II18497 U6877/XI20-net17 VSS nmos W=0.155u L=0.04u
M28298 U6877/XI20-net17 g6447 VSS VSS nmos W=0.155u L=0.04u
M28299 VDD II18500 U6877/net22 VDD pmos W=0.205u L=0.04u
M28300 VDD g401 U6877/net22 VDD pmos W=0.205u L=0.04u
M28301 U6877/net16 II18494 g12079 VDD pmos W=0.205u L=0.04u
M28302 U6877/net16 g5437 g12079 VDD pmos W=0.205u L=0.04u
M28303 U6877/net22 II18497 U6877/net16 VDD pmos W=0.205u L=0.04u
M28304 U6877/net22 g6447 U6877/net16 VDD pmos W=0.205u L=0.04u
M28305 g12056 II18635 U6878/XI21-net17 VSS nmos W=0.155u L=0.04u
M28306 U6878/XI21-net17 g1782 VSS VSS nmos W=0.155u L=0.04u
M28307 g12056 II18629 U6878/XI6-net17 VSS nmos W=0.155u L=0.04u
M28308 U6878/XI6-net17 g5511 VSS VSS nmos W=0.155u L=0.04u
M28309 g12056 II18632 U6878/XI20-net17 VSS nmos W=0.155u L=0.04u
M28310 U6878/XI20-net17 g7014 VSS VSS nmos W=0.155u L=0.04u
M28311 VDD II18635 U6878/net22 VDD pmos W=0.205u L=0.04u
M28312 VDD g1782 U6878/net22 VDD pmos W=0.205u L=0.04u
M28313 U6878/net16 II18629 g12056 VDD pmos W=0.205u L=0.04u
M28314 U6878/net16 g5511 g12056 VDD pmos W=0.205u L=0.04u
M28315 U6878/net22 II18632 U6878/net16 VDD pmos W=0.205u L=0.04u
M28316 U6878/net22 g7014 U6878/net16 VDD pmos W=0.205u L=0.04u
M28317 g12043 II18563 U6879/XI21-net17 VSS nmos W=0.155u L=0.04u
M28318 U6879/XI21-net17 g1088 VSS VSS nmos W=0.155u L=0.04u
M28319 g12043 II18557 U6879/XI6-net17 VSS nmos W=0.155u L=0.04u
M28320 U6879/XI6-net17 g5472 VSS VSS nmos W=0.155u L=0.04u
M28321 g12043 II18560 U6879/XI20-net17 VSS nmos W=0.155u L=0.04u
M28322 U6879/XI20-net17 g6712 VSS VSS nmos W=0.155u L=0.04u
M28323 VDD II18563 U6879/net22 VDD pmos W=0.205u L=0.04u
M28324 VDD g1088 U6879/net22 VDD pmos W=0.205u L=0.04u
M28325 U6879/net16 II18557 g12043 VDD pmos W=0.205u L=0.04u
M28326 U6879/net16 g5472 g12043 VDD pmos W=0.205u L=0.04u
M28327 U6879/net22 II18560 U6879/net16 VDD pmos W=0.205u L=0.04u
M28328 U6879/net22 g6712 U6879/net16 VDD pmos W=0.205u L=0.04u
M28329 g12026 II18491 U6880/XI21-net17 VSS nmos W=0.155u L=0.04u
M28330 U6880/XI21-net17 g401 VSS VSS nmos W=0.155u L=0.04u
M28331 g12026 II18485 U6880/XI6-net17 VSS nmos W=0.155u L=0.04u
M28332 U6880/XI6-net17 g5437 VSS VSS nmos W=0.155u L=0.04u
M28333 g12026 II18488 U6880/XI20-net17 VSS nmos W=0.155u L=0.04u
M28334 U6880/XI20-net17 g6447 VSS VSS nmos W=0.155u L=0.04u
M28335 VDD II18491 U6880/net22 VDD pmos W=0.205u L=0.04u
M28336 VDD g401 U6880/net22 VDD pmos W=0.205u L=0.04u
M28337 U6880/net16 II18485 g12026 VDD pmos W=0.205u L=0.04u
M28338 U6880/net16 g5437 g12026 VDD pmos W=0.205u L=0.04u
M28339 U6880/net22 II18488 U6880/net16 VDD pmos W=0.205u L=0.04u
M28340 U6880/net22 g6447 U6880/net16 VDD pmos W=0.205u L=0.04u
M28341 g12005 g2476 U6881/XI21-net17 VSS nmos W=0.155u L=0.04u
M28342 U6881/XI21-net17 g2498 VSS VSS nmos W=0.155u L=0.04u
M28343 g12005 g5555 U6881/XI6-net17 VSS nmos W=0.155u L=0.04u
M28344 U6881/XI6-net17 g2492 VSS VSS nmos W=0.155u L=0.04u
M28345 g12005 g7264 U6881/XI20-net17 VSS nmos W=0.155u L=0.04u
M28346 U6881/XI20-net17 g2495 VSS VSS nmos W=0.155u L=0.04u
M28347 VDD g2476 U6881/net22 VDD pmos W=0.205u L=0.04u
M28348 VDD g2498 U6881/net22 VDD pmos W=0.205u L=0.04u
M28349 U6881/net16 g5555 g12005 VDD pmos W=0.205u L=0.04u
M28350 U6881/net16 g2492 g12005 VDD pmos W=0.205u L=0.04u
M28351 U6881/net22 g7264 U6881/net16 VDD pmos W=0.205u L=0.04u
M28352 U6881/net22 g2495 U6881/net16 VDD pmos W=0.205u L=0.04u
M28353 g11987 II18554 U6882/XI21-net17 VSS nmos W=0.155u L=0.04u
M28354 U6882/XI21-net17 g1088 VSS VSS nmos W=0.155u L=0.04u
M28355 g11987 II18548 U6882/XI6-net17 VSS nmos W=0.155u L=0.04u
M28356 U6882/XI6-net17 g5472 VSS VSS nmos W=0.155u L=0.04u
M28357 g11987 II18551 U6882/XI20-net17 VSS nmos W=0.155u L=0.04u
M28358 U6882/XI20-net17 g6712 VSS VSS nmos W=0.155u L=0.04u
M28359 VDD II18554 U6882/net22 VDD pmos W=0.205u L=0.04u
M28360 VDD g1088 U6882/net22 VDD pmos W=0.205u L=0.04u
M28361 U6882/net16 II18548 g11987 VDD pmos W=0.205u L=0.04u
M28362 U6882/net16 g5472 g11987 VDD pmos W=0.205u L=0.04u
M28363 U6882/net22 II18551 U6882/net16 VDD pmos W=0.205u L=0.04u
M28364 U6882/net22 g6712 U6882/net16 VDD pmos W=0.205u L=0.04u
M28365 g11974 II18482 U6883/XI21-net17 VSS nmos W=0.155u L=0.04u
M28366 U6883/XI21-net17 g401 VSS VSS nmos W=0.155u L=0.04u
M28367 g11974 II18476 U6883/XI6-net17 VSS nmos W=0.155u L=0.04u
M28368 U6883/XI6-net17 g5437 VSS VSS nmos W=0.155u L=0.04u
M28369 g11974 II18479 U6883/XI20-net17 VSS nmos W=0.155u L=0.04u
M28370 U6883/XI20-net17 g6447 VSS VSS nmos W=0.155u L=0.04u
M28371 VDD II18482 U6883/net22 VDD pmos W=0.205u L=0.04u
M28372 VDD g401 U6883/net22 VDD pmos W=0.205u L=0.04u
M28373 U6883/net16 II18476 g11974 VDD pmos W=0.205u L=0.04u
M28374 U6883/net16 g5437 g11974 VDD pmos W=0.205u L=0.04u
M28375 U6883/net22 II18479 U6883/net16 VDD pmos W=0.205u L=0.04u
M28376 U6883/net22 g6447 U6883/net16 VDD pmos W=0.205u L=0.04u
M28377 g11952 g1782 U6884/XI21-net17 VSS nmos W=0.155u L=0.04u
M28378 U6884/XI21-net17 g1804 VSS VSS nmos W=0.155u L=0.04u
M28379 g11952 g5511 U6884/XI6-net17 VSS nmos W=0.155u L=0.04u
M28380 U6884/XI6-net17 g1798 VSS VSS nmos W=0.155u L=0.04u
M28381 g11952 g7014 U6884/XI20-net17 VSS nmos W=0.155u L=0.04u
M28382 U6884/XI20-net17 g1801 VSS VSS nmos W=0.155u L=0.04u
M28383 VDD g1782 U6884/net22 VDD pmos W=0.205u L=0.04u
M28384 VDD g1804 U6884/net22 VDD pmos W=0.205u L=0.04u
M28385 U6884/net16 g5511 g11952 VDD pmos W=0.205u L=0.04u
M28386 U6884/net16 g1798 g11952 VDD pmos W=0.205u L=0.04u
M28387 U6884/net22 g7014 U6884/net16 VDD pmos W=0.205u L=0.04u
M28388 U6884/net22 g1801 U6884/net16 VDD pmos W=0.205u L=0.04u
M28389 g11934 II18473 U6885/XI21-net17 VSS nmos W=0.155u L=0.04u
M28390 U6885/XI21-net17 g401 VSS VSS nmos W=0.155u L=0.04u
M28391 g11934 II18467 U6885/XI6-net17 VSS nmos W=0.155u L=0.04u
M28392 U6885/XI6-net17 g5437 VSS VSS nmos W=0.155u L=0.04u
M28393 g11934 II18470 U6885/XI20-net17 VSS nmos W=0.155u L=0.04u
M28394 U6885/XI20-net17 g6447 VSS VSS nmos W=0.155u L=0.04u
M28395 VDD II18473 U6885/net22 VDD pmos W=0.205u L=0.04u
M28396 VDD g401 U6885/net22 VDD pmos W=0.205u L=0.04u
M28397 U6885/net16 II18467 g11934 VDD pmos W=0.205u L=0.04u
M28398 U6885/net16 g5437 g11934 VDD pmos W=0.205u L=0.04u
M28399 U6885/net22 II18470 U6885/net16 VDD pmos W=0.205u L=0.04u
M28400 U6885/net22 g6447 U6885/net16 VDD pmos W=0.205u L=0.04u
M28401 g11902 g1088 U6886/XI21-net17 VSS nmos W=0.155u L=0.04u
M28402 U6886/XI21-net17 g1110 VSS VSS nmos W=0.155u L=0.04u
M28403 g11902 g5472 U6886/XI6-net17 VSS nmos W=0.155u L=0.04u
M28404 U6886/XI6-net17 g1104 VSS VSS nmos W=0.155u L=0.04u
M28405 g11902 g6712 U6886/XI20-net17 VSS nmos W=0.155u L=0.04u
M28406 U6886/XI20-net17 g1107 VSS VSS nmos W=0.155u L=0.04u
M28407 VDD g1088 U6886/net22 VDD pmos W=0.205u L=0.04u
M28408 VDD g1110 U6886/net22 VDD pmos W=0.205u L=0.04u
M28409 U6886/net16 g5472 g11902 VDD pmos W=0.205u L=0.04u
M28410 U6886/net16 g1104 g11902 VDD pmos W=0.205u L=0.04u
M28411 U6886/net22 g6712 U6886/net16 VDD pmos W=0.205u L=0.04u
M28412 U6886/net22 g1107 U6886/net16 VDD pmos W=0.205u L=0.04u
M28413 g11860 g401 U6887/XI21-net17 VSS nmos W=0.155u L=0.04u
M28414 U6887/XI21-net17 g423 VSS VSS nmos W=0.155u L=0.04u
M28415 g11860 g5437 U6887/XI6-net17 VSS nmos W=0.155u L=0.04u
M28416 U6887/XI6-net17 g417 VSS VSS nmos W=0.155u L=0.04u
M28417 g11860 g6447 U6887/XI20-net17 VSS nmos W=0.155u L=0.04u
M28418 U6887/XI20-net17 g420 VSS VSS nmos W=0.155u L=0.04u
M28419 VDD g401 U6887/net22 VDD pmos W=0.205u L=0.04u
M28420 VDD g423 U6887/net22 VDD pmos W=0.205u L=0.04u
M28421 U6887/net16 g5437 g11860 VDD pmos W=0.205u L=0.04u
M28422 U6887/net16 g417 g11860 VDD pmos W=0.205u L=0.04u
M28423 U6887/net22 g6447 U6887/net16 VDD pmos W=0.205u L=0.04u
M28424 U6887/net22 g420 U6887/net16 VDD pmos W=0.205u L=0.04u
M28425 U6888/net4 U6888/net10 U6888/net14 VSS nmos W=0.155u L=0.04u
M28426 U6888/net6 n3830 U6888/net14 VSS nmos W=0.155u L=0.04u
M28427 U6888/net4 n5956 VSS VSS nmos W=0.155u L=0.04u
M28428 U6888/net6 U6888/net4 VSS VSS nmos W=0.155u L=0.04u
M28429 N930 U6888/net14 VSS VSS nmos W=0.155u L=0.04u
M28430 U6888/net10 n3830 VSS VSS nmos W=0.155u L=0.04u
M28431 U6888/net4 n3830 U6888/net14 VDD pmos W=0.205u L=0.04u
M28432 U6888/net6 U6888/net10 U6888/net14 VDD pmos W=0.205u L=0.04u
M28433 U6888/net4 n5956 VDD VDD pmos W=0.205u L=0.04u
M28434 U6888/net6 U6888/net4 VDD VDD pmos W=0.205u L=0.04u
M28435 N930 U6888/net14 VDD VDD pmos W=0.205u L=0.04u
M28436 U6888/net10 n3830 VDD VDD pmos W=0.205u L=0.04u
M28437 U6889/net4 n5957 U6889/net14 VSS nmos W=0.155u L=0.04u
M28438 U6889/net6 U6889/net10 U6889/net14 VSS nmos W=0.17u L=0.04u
M28439 U6889/net4 n5958 VSS VSS nmos W=0.155u L=0.04u
M28440 U6889/net6 U6889/net4 VSS VSS nmos W=0.17u L=0.04u
M28441 n3830 U6889/net14 VSS VSS nmos W=0.155u L=0.04u
M28442 U6889/net10 n5957 VSS VSS nmos W=0.155u L=0.04u
M28443 U6889/net4 U6889/net10 U6889/net14 VDD pmos W=0.255u L=0.04u
M28444 U6889/net6 n5957 U6889/net14 VDD pmos W=0.28u L=0.04u
M28445 U6889/net4 n5958 VDD VDD pmos W=0.205u L=0.04u
M28446 U6889/net6 U6889/net4 VDD VDD pmos W=0.24u L=0.04u
M28447 n3830 U6889/net14 VDD VDD pmos W=0.205u L=0.04u
M28448 U6889/net10 n5957 VDD VDD pmos W=0.205u L=0.04u
M28449 U6890/net28 U6890/net20 U6890/net64 VSS nmos W=0.155u L=0.04u
M28450 U6890/net24 U6890/net30 U6890/net32 VSS nmos W=0.155u L=0.04u
M28451 U6890/net28 U6890/net40 U6890/net24 VSS nmos W=0.155u L=0.04u
M28452 U6890/net20 g17 U6890/net108 VSS nmos W=0.155u L=0.04u
M28453 U6890/net20 U6890/net106 U6890/net104 VSS nmos W=0.155u L=0.04u
M28454 U6890/net24 g14 U6890/net046 VSS nmos W=0.155u L=0.04u
M28455 U6890/net046 U6890/net32 VSS VSS nmos W=0.155u L=0.04u
M28456 U6890/net106 g17 VSS VSS nmos W=0.155u L=0.04u
M28457 U6890/net32 g11 VSS VSS nmos W=0.155u L=0.04u
M28458 U6890/net30 g14 VSS VSS nmos W=0.155u L=0.04u
M28459 U6890/net108 U6890/net104 VSS VSS nmos W=0.155u L=0.04u
M28460 n5958 U6890/net28 VSS VSS nmos W=0.155u L=0.04u
M28461 U6890/net104 g2 VSS VSS nmos W=0.155u L=0.04u
M28462 U6890/net64 U6890/net24 VSS VSS nmos W=0.155u L=0.04u
M28463 U6890/net40 U6890/net20 VSS VSS nmos W=0.155u L=0.04u
M28464 U6890/net28 U6890/net40 U6890/net64 VDD pmos W=0.205u L=0.04u
M28465 U6890/net24 g14 U6890/net32 VDD pmos W=0.205u L=0.04u
M28466 U6890/net28 U6890/net20 U6890/net24 VDD pmos W=0.205u L=0.04u
M28467 U6890/net20 U6890/net106 U6890/net108 VDD pmos W=0.205u L=0.04u
M28468 U6890/net20 g17 U6890/net104 VDD pmos W=0.205u L=0.04u
M28469 U6890/net106 g17 VDD VDD pmos W=0.205u L=0.04u
M28470 U6890/net32 g11 VDD VDD pmos W=0.205u L=0.04u
M28471 U6890/net30 g14 VDD VDD pmos W=0.205u L=0.04u
M28472 U6890/net108 U6890/net104 VDD VDD pmos W=0.205u L=0.04u
M28473 n5958 U6890/net28 VDD VDD pmos W=0.205u L=0.04u
M28474 U6890/net104 g2 VDD VDD pmos W=0.205u L=0.04u
M28475 U6890/net64 U6890/net24 VDD VDD pmos W=0.205u L=0.04u
M28476 U6890/net40 U6890/net20 VDD VDD pmos W=0.205u L=0.04u
M28477 U6890/net24 U6890/net30 U6890/net045 VDD pmos W=0.205u L=0.04u
M28478 U6890/net045 U6890/net32 VDD VDD pmos W=0.205u L=0.04u
M28479 U6891/net28 U6891/net20 U6891/net64 VSS nmos W=0.155u L=0.04u
M28480 U6891/net24 U6891/net30 U6891/net32 VSS nmos W=0.155u L=0.04u
M28481 U6891/net28 U6891/net40 U6891/net24 VSS nmos W=0.155u L=0.04u
M28482 U6891/net40 g5 U6891/net108 VSS nmos W=0.155u L=0.04u
M28483 U6891/net40 U6891/net106 U6891/net104 VSS nmos W=0.155u L=0.04u
M28484 U6891/net24 g23 U6891/net050 VSS nmos W=0.155u L=0.04u
M28485 U6891/net050 U6891/net32 VSS VSS nmos W=0.155u L=0.04u
M28486 U6891/net20 U6891/net40 VSS VSS nmos W=0.155u L=0.04u
M28487 U6891/net106 g5 VSS VSS nmos W=0.155u L=0.04u
M28488 U6891/net104 g8 VSS VSS nmos W=0.155u L=0.04u
M28489 U6891/net30 g23 VSS VSS nmos W=0.155u L=0.04u
M28490 U6891/net108 U6891/net104 VSS VSS nmos W=0.155u L=0.04u
M28491 n5957 U6891/net28 VSS VSS nmos W=0.155u L=0.04u
M28492 U6891/net32 g20 VSS VSS nmos W=0.155u L=0.04u
M28493 U6891/net64 U6891/net24 VSS VSS nmos W=0.2u L=0.04u
M28494 U6891/net28 U6891/net40 U6891/net64 VDD pmos W=0.205u L=0.04u
M28495 U6891/net24 g23 U6891/net32 VDD pmos W=0.205u L=0.04u
M28496 U6891/net28 U6891/net20 U6891/net24 VDD pmos W=0.205u L=0.04u
M28497 U6891/net40 U6891/net106 U6891/net108 VDD pmos W=0.205u L=0.04u
M28498 U6891/net40 g5 U6891/net104 VDD pmos W=0.205u L=0.04u
M28499 U6891/net20 U6891/net40 VDD VDD pmos W=0.205u L=0.04u
M28500 U6891/net106 g5 VDD VDD pmos W=0.205u L=0.04u
M28501 U6891/net104 g8 VDD VDD pmos W=0.205u L=0.04u
M28502 U6891/net30 g23 VDD VDD pmos W=0.205u L=0.04u
M28503 U6891/net108 U6891/net104 VDD VDD pmos W=0.205u L=0.04u
M28504 n5957 U6891/net28 VDD VDD pmos W=0.205u L=0.04u
M28505 U6891/net32 g20 VDD VDD pmos W=0.205u L=0.04u
M28506 U6891/net64 U6891/net24 VDD VDD pmos W=0.28u L=0.04u
M28507 U6891/net24 U6891/net30 U6891/net045 VDD pmos W=0.205u L=0.04u
M28508 U6891/net045 U6891/net32 VDD VDD pmos W=0.205u L=0.04u
M28509 U6892/net4 U6892/net10 U6892/net14 VSS nmos W=0.155u L=0.04u
M28510 U6892/net6 n3831 U6892/net14 VSS nmos W=0.155u L=0.04u
M28511 U6892/net4 n5956 VSS VSS nmos W=0.155u L=0.04u
M28512 U6892/net6 U6892/net4 VSS VSS nmos W=0.155u L=0.04u
M28513 N478 U6892/net14 VSS VSS nmos W=0.155u L=0.04u
M28514 U6892/net10 n3831 VSS VSS nmos W=0.155u L=0.04u
M28515 U6892/net4 n3831 U6892/net14 VDD pmos W=0.205u L=0.04u
M28516 U6892/net6 U6892/net10 U6892/net14 VDD pmos W=0.205u L=0.04u
M28517 U6892/net4 n5956 VDD VDD pmos W=0.205u L=0.04u
M28518 U6892/net6 U6892/net4 VDD VDD pmos W=0.205u L=0.04u
M28519 N478 U6892/net14 VDD VDD pmos W=0.205u L=0.04u
M28520 U6892/net10 n3831 VDD VDD pmos W=0.205u L=0.04u
M28521 U6893/net13 g3231 VSS VSS nmos W=0.155u L=0.04u
M28522 U6893/net16 U6893/net13 VSS VSS nmos W=0.155u L=0.04u
M28523 n5956 g3136 U6893/net16 VSS nmos W=0.155u L=0.04u
M28524 U6893/net13 g3231 VDD VDD pmos W=0.205u L=0.04u
M28525 VDD U6893/net13 n5956 VDD pmos W=0.205u L=0.04u
M28526 VDD g3136 n5956 VDD pmos W=0.205u L=0.04u
M28527 U6894/net4 n5959 U6894/net14 VSS nmos W=0.155u L=0.04u
M28528 U6894/net6 U6894/net10 U6894/net14 VSS nmos W=0.17u L=0.04u
M28529 U6894/net4 n5960 VSS VSS nmos W=0.155u L=0.04u
M28530 U6894/net6 U6894/net4 VSS VSS nmos W=0.17u L=0.04u
M28531 n3831 U6894/net14 VSS VSS nmos W=0.155u L=0.04u
M28532 U6894/net10 n5959 VSS VSS nmos W=0.155u L=0.04u
M28533 U6894/net4 U6894/net10 U6894/net14 VDD pmos W=0.255u L=0.04u
M28534 U6894/net6 n5959 U6894/net14 VDD pmos W=0.28u L=0.04u
M28535 U6894/net4 n5960 VDD VDD pmos W=0.205u L=0.04u
M28536 U6894/net6 U6894/net4 VDD VDD pmos W=0.24u L=0.04u
M28537 n3831 U6894/net14 VDD VDD pmos W=0.205u L=0.04u
M28538 U6894/net10 n5959 VDD VDD pmos W=0.205u L=0.04u
M28539 U6895/net28 U6895/net20 U6895/net64 VSS nmos W=0.155u L=0.04u
M28540 U6895/net24 U6895/net30 U6895/net32 VSS nmos W=0.155u L=0.04u
M28541 U6895/net28 U6895/net40 U6895/net24 VSS nmos W=0.155u L=0.04u
M28542 U6895/net20 g33 U6895/net108 VSS nmos W=0.155u L=0.04u
M28543 U6895/net20 U6895/net106 U6895/net104 VSS nmos W=0.155u L=0.04u
M28544 U6895/net24 g30 U6895/net046 VSS nmos W=0.155u L=0.04u
M28545 U6895/net046 U6895/net32 VSS VSS nmos W=0.155u L=0.04u
M28546 U6895/net106 g33 VSS VSS nmos W=0.155u L=0.04u
M28547 U6895/net32 g27 VSS VSS nmos W=0.155u L=0.04u
M28548 U6895/net30 g30 VSS VSS nmos W=0.155u L=0.04u
M28549 U6895/net108 U6895/net104 VSS VSS nmos W=0.155u L=0.04u
M28550 n5960 U6895/net28 VSS VSS nmos W=0.155u L=0.04u
M28551 U6895/net104 g36 VSS VSS nmos W=0.155u L=0.04u
M28552 U6895/net64 U6895/net24 VSS VSS nmos W=0.155u L=0.04u
M28553 U6895/net40 U6895/net20 VSS VSS nmos W=0.155u L=0.04u
M28554 U6895/net28 U6895/net40 U6895/net64 VDD pmos W=0.205u L=0.04u
M28555 U6895/net24 g30 U6895/net32 VDD pmos W=0.205u L=0.04u
M28556 U6895/net28 U6895/net20 U6895/net24 VDD pmos W=0.205u L=0.04u
M28557 U6895/net20 U6895/net106 U6895/net108 VDD pmos W=0.205u L=0.04u
M28558 U6895/net20 g33 U6895/net104 VDD pmos W=0.205u L=0.04u
M28559 U6895/net106 g33 VDD VDD pmos W=0.205u L=0.04u
M28560 U6895/net32 g27 VDD VDD pmos W=0.205u L=0.04u
M28561 U6895/net30 g30 VDD VDD pmos W=0.205u L=0.04u
M28562 U6895/net108 U6895/net104 VDD VDD pmos W=0.205u L=0.04u
M28563 n5960 U6895/net28 VDD VDD pmos W=0.205u L=0.04u
M28564 U6895/net104 g36 VDD VDD pmos W=0.205u L=0.04u
M28565 U6895/net64 U6895/net24 VDD VDD pmos W=0.205u L=0.04u
M28566 U6895/net40 U6895/net20 VDD VDD pmos W=0.205u L=0.04u
M28567 U6895/net24 U6895/net30 U6895/net045 VDD pmos W=0.205u L=0.04u
M28568 U6895/net045 U6895/net32 VDD VDD pmos W=0.205u L=0.04u
M28569 U6896/net28 U6896/net20 U6896/net64 VSS nmos W=0.155u L=0.04u
M28570 U6896/net24 U6896/net30 U6896/net32 VSS nmos W=0.155u L=0.04u
M28571 U6896/net28 U6896/net40 U6896/net24 VSS nmos W=0.155u L=0.04u
M28572 U6896/net40 g45 U6896/net108 VSS nmos W=0.155u L=0.04u
M28573 U6896/net40 U6896/net106 U6896/net104 VSS nmos W=0.155u L=0.04u
M28574 U6896/net24 g42 U6896/net050 VSS nmos W=0.155u L=0.04u
M28575 U6896/net050 U6896/net32 VSS VSS nmos W=0.155u L=0.04u
M28576 U6896/net20 U6896/net40 VSS VSS nmos W=0.155u L=0.04u
M28577 U6896/net106 g45 VSS VSS nmos W=0.155u L=0.04u
M28578 U6896/net104 g48 VSS VSS nmos W=0.155u L=0.04u
M28579 U6896/net30 g42 VSS VSS nmos W=0.155u L=0.04u
M28580 U6896/net108 U6896/net104 VSS VSS nmos W=0.155u L=0.04u
M28581 n5959 U6896/net28 VSS VSS nmos W=0.155u L=0.04u
M28582 U6896/net32 g39 VSS VSS nmos W=0.155u L=0.04u
M28583 U6896/net64 U6896/net24 VSS VSS nmos W=0.2u L=0.04u
M28584 U6896/net28 U6896/net40 U6896/net64 VDD pmos W=0.205u L=0.04u
M28585 U6896/net24 g42 U6896/net32 VDD pmos W=0.205u L=0.04u
M28586 U6896/net28 U6896/net20 U6896/net24 VDD pmos W=0.205u L=0.04u
M28587 U6896/net40 U6896/net106 U6896/net108 VDD pmos W=0.205u L=0.04u
M28588 U6896/net40 g45 U6896/net104 VDD pmos W=0.205u L=0.04u
M28589 U6896/net20 U6896/net40 VDD VDD pmos W=0.205u L=0.04u
M28590 U6896/net106 g45 VDD VDD pmos W=0.205u L=0.04u
M28591 U6896/net104 g48 VDD VDD pmos W=0.205u L=0.04u
M28592 U6896/net30 g42 VDD VDD pmos W=0.205u L=0.04u
M28593 U6896/net108 U6896/net104 VDD VDD pmos W=0.205u L=0.04u
M28594 n5959 U6896/net28 VDD VDD pmos W=0.205u L=0.04u
M28595 U6896/net32 g39 VDD VDD pmos W=0.205u L=0.04u
M28596 U6896/net64 U6896/net24 VDD VDD pmos W=0.28u L=0.04u
M28597 U6896/net24 U6896/net30 U6896/net045 VDD pmos W=0.205u L=0.04u
M28598 U6896/net045 U6896/net32 VDD VDD pmos W=0.205u L=0.04u
M28599 U6897/net4 g2934 U6897/net14 VSS nmos W=0.155u L=0.04u
M28600 U6897/net6 U6897/net10 U6897/net14 VSS nmos W=0.17u L=0.04u
M28601 U6897/net4 n5413 VSS VSS nmos W=0.155u L=0.04u
M28602 U6897/net6 U6897/net4 VSS VSS nmos W=0.17u L=0.04u
M28603 N466 U6897/net14 VSS VSS nmos W=0.155u L=0.04u
M28604 U6897/net10 g2934 VSS VSS nmos W=0.155u L=0.04u
M28605 U6897/net4 U6897/net10 U6897/net14 VDD pmos W=0.255u L=0.04u
M28606 U6897/net6 g2934 U6897/net14 VDD pmos W=0.28u L=0.04u
M28607 U6897/net4 n5413 VDD VDD pmos W=0.205u L=0.04u
M28608 U6897/net6 U6897/net4 VDD VDD pmos W=0.24u L=0.04u
M28609 N466 U6897/net14 VDD VDD pmos W=0.205u L=0.04u
M28610 U6897/net10 g2934 VDD VDD pmos W=0.205u L=0.04u
M28611 U6898/net4 U6898/net10 U6898/net14 VSS nmos W=0.155u L=0.04u
M28612 U6898/net6 n5961 U6898/net14 VSS nmos W=0.155u L=0.04u
M28613 U6898/net4 n5962 VSS VSS nmos W=0.155u L=0.04u
M28614 U6898/net6 U6898/net4 VSS VSS nmos W=0.155u L=0.04u
M28615 n5413 U6898/net14 VSS VSS nmos W=0.155u L=0.04u
M28616 U6898/net10 n5961 VSS VSS nmos W=0.155u L=0.04u
M28617 U6898/net4 n5961 U6898/net14 VDD pmos W=0.205u L=0.04u
M28618 U6898/net6 U6898/net10 U6898/net14 VDD pmos W=0.205u L=0.04u
M28619 U6898/net4 n5962 VDD VDD pmos W=0.205u L=0.04u
M28620 U6898/net6 U6898/net4 VDD VDD pmos W=0.205u L=0.04u
M28621 n5413 U6898/net14 VDD VDD pmos W=0.205u L=0.04u
M28622 U6898/net10 n5961 VDD VDD pmos W=0.205u L=0.04u
M28623 U6899/net28 U6899/net20 U6899/net64 VSS nmos W=0.155u L=0.04u
M28624 U6899/net24 U6899/net30 U6899/net32 VSS nmos W=0.155u L=0.04u
M28625 U6899/net28 U6899/net40 U6899/net24 VSS nmos W=0.155u L=0.04u
M28626 U6899/net40 g2938 U6899/net108 VSS nmos W=0.155u L=0.04u
M28627 U6899/net40 U6899/net106 U6899/net104 VSS nmos W=0.155u L=0.04u
M28628 U6899/net24 g2944 U6899/net050 VSS nmos W=0.155u L=0.04u
M28629 U6899/net050 U6899/net32 VSS VSS nmos W=0.155u L=0.04u
M28630 U6899/net20 U6899/net40 VSS VSS nmos W=0.155u L=0.04u
M28631 U6899/net106 g2938 VSS VSS nmos W=0.155u L=0.04u
M28632 U6899/net104 g2935 VSS VSS nmos W=0.155u L=0.04u
M28633 U6899/net30 g2944 VSS VSS nmos W=0.155u L=0.04u
M28634 U6899/net108 U6899/net104 VSS VSS nmos W=0.155u L=0.04u
M28635 n5962 U6899/net28 VSS VSS nmos W=0.155u L=0.04u
M28636 U6899/net32 g2941 VSS VSS nmos W=0.155u L=0.04u
M28637 U6899/net64 U6899/net24 VSS VSS nmos W=0.2u L=0.04u
M28638 U6899/net28 U6899/net40 U6899/net64 VDD pmos W=0.205u L=0.04u
M28639 U6899/net24 g2944 U6899/net32 VDD pmos W=0.205u L=0.04u
M28640 U6899/net28 U6899/net20 U6899/net24 VDD pmos W=0.205u L=0.04u
M28641 U6899/net40 U6899/net106 U6899/net108 VDD pmos W=0.205u L=0.04u
M28642 U6899/net40 g2938 U6899/net104 VDD pmos W=0.205u L=0.04u
M28643 U6899/net20 U6899/net40 VDD VDD pmos W=0.205u L=0.04u
M28644 U6899/net106 g2938 VDD VDD pmos W=0.205u L=0.04u
M28645 U6899/net104 g2935 VDD VDD pmos W=0.205u L=0.04u
M28646 U6899/net30 g2944 VDD VDD pmos W=0.205u L=0.04u
M28647 U6899/net108 U6899/net104 VDD VDD pmos W=0.205u L=0.04u
M28648 n5962 U6899/net28 VDD VDD pmos W=0.205u L=0.04u
M28649 U6899/net32 g2941 VDD VDD pmos W=0.205u L=0.04u
M28650 U6899/net64 U6899/net24 VDD VDD pmos W=0.28u L=0.04u
M28651 U6899/net24 U6899/net30 U6899/net045 VDD pmos W=0.205u L=0.04u
M28652 U6899/net045 U6899/net32 VDD VDD pmos W=0.205u L=0.04u
M28653 U6900/net28 U6900/net20 U6900/net64 VSS nmos W=0.155u L=0.04u
M28654 U6900/net24 U6900/net30 U6900/net32 VSS nmos W=0.155u L=0.04u
M28655 U6900/net28 U6900/net40 U6900/net24 VSS nmos W=0.155u L=0.04u
M28656 U6900/net40 g2956 U6900/net108 VSS nmos W=0.155u L=0.04u
M28657 U6900/net40 U6900/net106 U6900/net104 VSS nmos W=0.155u L=0.04u
M28658 U6900/net24 g2953 U6900/net050 VSS nmos W=0.155u L=0.04u
M28659 U6900/net050 U6900/net32 VSS VSS nmos W=0.155u L=0.04u
M28660 U6900/net20 U6900/net40 VSS VSS nmos W=0.155u L=0.04u
M28661 U6900/net106 g2956 VSS VSS nmos W=0.155u L=0.04u
M28662 U6900/net104 g2959 VSS VSS nmos W=0.155u L=0.04u
M28663 U6900/net30 g2953 VSS VSS nmos W=0.155u L=0.04u
M28664 U6900/net108 U6900/net104 VSS VSS nmos W=0.155u L=0.04u
M28665 n5961 U6900/net28 VSS VSS nmos W=0.155u L=0.04u
M28666 U6900/net32 g2947 VSS VSS nmos W=0.155u L=0.04u
M28667 U6900/net64 U6900/net24 VSS VSS nmos W=0.2u L=0.04u
M28668 U6900/net28 U6900/net40 U6900/net64 VDD pmos W=0.205u L=0.04u
M28669 U6900/net24 g2953 U6900/net32 VDD pmos W=0.205u L=0.04u
M28670 U6900/net28 U6900/net20 U6900/net24 VDD pmos W=0.205u L=0.04u
M28671 U6900/net40 U6900/net106 U6900/net108 VDD pmos W=0.205u L=0.04u
M28672 U6900/net40 g2956 U6900/net104 VDD pmos W=0.205u L=0.04u
M28673 U6900/net20 U6900/net40 VDD VDD pmos W=0.205u L=0.04u
M28674 U6900/net106 g2956 VDD VDD pmos W=0.205u L=0.04u
M28675 U6900/net104 g2959 VDD VDD pmos W=0.205u L=0.04u
M28676 U6900/net30 g2953 VDD VDD pmos W=0.205u L=0.04u
M28677 U6900/net108 U6900/net104 VDD VDD pmos W=0.205u L=0.04u
M28678 n5961 U6900/net28 VDD VDD pmos W=0.205u L=0.04u
M28679 U6900/net32 g2947 VDD VDD pmos W=0.205u L=0.04u
M28680 U6900/net64 U6900/net24 VDD VDD pmos W=0.28u L=0.04u
M28681 U6900/net24 U6900/net30 U6900/net045 VDD pmos W=0.205u L=0.04u
M28682 U6900/net045 U6900/net32 VDD VDD pmos W=0.205u L=0.04u
M28683 U6901/net4 g2962 U6901/net14 VSS nmos W=0.155u L=0.04u
M28684 U6901/net6 U6901/net10 U6901/net14 VSS nmos W=0.17u L=0.04u
M28685 U6901/net4 n5408 VSS VSS nmos W=0.155u L=0.04u
M28686 U6901/net6 U6901/net4 VSS VSS nmos W=0.17u L=0.04u
M28687 N461 U6901/net14 VSS VSS nmos W=0.155u L=0.04u
M28688 U6901/net10 g2962 VSS VSS nmos W=0.155u L=0.04u
M28689 U6901/net4 U6901/net10 U6901/net14 VDD pmos W=0.255u L=0.04u
M28690 U6901/net6 g2962 U6901/net14 VDD pmos W=0.28u L=0.04u
M28691 U6901/net4 n5408 VDD VDD pmos W=0.205u L=0.04u
M28692 U6901/net6 U6901/net4 VDD VDD pmos W=0.24u L=0.04u
M28693 N461 U6901/net14 VDD VDD pmos W=0.205u L=0.04u
M28694 U6901/net10 g2962 VDD VDD pmos W=0.205u L=0.04u
M28695 U6902/net4 U6902/net10 U6902/net14 VSS nmos W=0.155u L=0.04u
M28696 U6902/net6 n5963 U6902/net14 VSS nmos W=0.155u L=0.04u
M28697 U6902/net4 n5964 VSS VSS nmos W=0.155u L=0.04u
M28698 U6902/net6 U6902/net4 VSS VSS nmos W=0.155u L=0.04u
M28699 n5408 U6902/net14 VSS VSS nmos W=0.155u L=0.04u
M28700 U6902/net10 n5963 VSS VSS nmos W=0.155u L=0.04u
M28701 U6902/net4 n5963 U6902/net14 VDD pmos W=0.205u L=0.04u
M28702 U6902/net6 U6902/net10 U6902/net14 VDD pmos W=0.205u L=0.04u
M28703 U6902/net4 n5964 VDD VDD pmos W=0.205u L=0.04u
M28704 U6902/net6 U6902/net4 VDD VDD pmos W=0.205u L=0.04u
M28705 n5408 U6902/net14 VDD VDD pmos W=0.205u L=0.04u
M28706 U6902/net10 n5963 VDD VDD pmos W=0.205u L=0.04u
M28707 U6903/net28 U6903/net20 U6903/net64 VSS nmos W=0.155u L=0.04u
M28708 U6903/net24 U6903/net30 U6903/net32 VSS nmos W=0.155u L=0.04u
M28709 U6903/net28 U6903/net40 U6903/net24 VSS nmos W=0.155u L=0.04u
M28710 U6903/net40 g2963 U6903/net108 VSS nmos W=0.155u L=0.04u
M28711 U6903/net40 U6903/net106 U6903/net104 VSS nmos W=0.155u L=0.04u
M28712 U6903/net24 g2969 U6903/net050 VSS nmos W=0.155u L=0.04u
M28713 U6903/net050 U6903/net32 VSS VSS nmos W=0.155u L=0.04u
M28714 U6903/net20 U6903/net40 VSS VSS nmos W=0.155u L=0.04u
M28715 U6903/net106 g2963 VSS VSS nmos W=0.155u L=0.04u
M28716 U6903/net104 g2874 VSS VSS nmos W=0.155u L=0.04u
M28717 U6903/net30 g2969 VSS VSS nmos W=0.155u L=0.04u
M28718 U6903/net108 U6903/net104 VSS VSS nmos W=0.155u L=0.04u
M28719 n5964 U6903/net28 VSS VSS nmos W=0.155u L=0.04u
M28720 U6903/net32 g2966 VSS VSS nmos W=0.155u L=0.04u
M28721 U6903/net64 U6903/net24 VSS VSS nmos W=0.2u L=0.04u
M28722 U6903/net28 U6903/net40 U6903/net64 VDD pmos W=0.205u L=0.04u
M28723 U6903/net24 g2969 U6903/net32 VDD pmos W=0.205u L=0.04u
M28724 U6903/net28 U6903/net20 U6903/net24 VDD pmos W=0.205u L=0.04u
M28725 U6903/net40 U6903/net106 U6903/net108 VDD pmos W=0.205u L=0.04u
M28726 U6903/net40 g2963 U6903/net104 VDD pmos W=0.205u L=0.04u
M28727 U6903/net20 U6903/net40 VDD VDD pmos W=0.205u L=0.04u
M28728 U6903/net106 g2963 VDD VDD pmos W=0.205u L=0.04u
M28729 U6903/net104 g2874 VDD VDD pmos W=0.205u L=0.04u
M28730 U6903/net30 g2969 VDD VDD pmos W=0.205u L=0.04u
M28731 U6903/net108 U6903/net104 VDD VDD pmos W=0.205u L=0.04u
M28732 n5964 U6903/net28 VDD VDD pmos W=0.205u L=0.04u
M28733 U6903/net32 g2966 VDD VDD pmos W=0.205u L=0.04u
M28734 U6903/net64 U6903/net24 VDD VDD pmos W=0.28u L=0.04u
M28735 U6903/net24 U6903/net30 U6903/net045 VDD pmos W=0.205u L=0.04u
M28736 U6903/net045 U6903/net32 VDD VDD pmos W=0.205u L=0.04u
M28737 U6904/net28 U6904/net20 U6904/net64 VSS nmos W=0.155u L=0.04u
M28738 U6904/net24 U6904/net30 U6904/net32 VSS nmos W=0.155u L=0.04u
M28739 U6904/net28 U6904/net40 U6904/net24 VSS nmos W=0.155u L=0.04u
M28740 U6904/net40 g2978 U6904/net108 VSS nmos W=0.155u L=0.04u
M28741 U6904/net40 U6904/net106 U6904/net104 VSS nmos W=0.155u L=0.04u
M28742 U6904/net24 g2975 U6904/net050 VSS nmos W=0.155u L=0.04u
M28743 U6904/net050 U6904/net32 VSS VSS nmos W=0.155u L=0.04u
M28744 U6904/net20 U6904/net40 VSS VSS nmos W=0.155u L=0.04u
M28745 U6904/net106 g2978 VSS VSS nmos W=0.155u L=0.04u
M28746 U6904/net104 g2981 VSS VSS nmos W=0.155u L=0.04u
M28747 U6904/net30 g2975 VSS VSS nmos W=0.155u L=0.04u
M28748 U6904/net108 U6904/net104 VSS VSS nmos W=0.155u L=0.04u
M28749 n5963 U6904/net28 VSS VSS nmos W=0.155u L=0.04u
M28750 U6904/net32 g2972 VSS VSS nmos W=0.155u L=0.04u
M28751 U6904/net64 U6904/net24 VSS VSS nmos W=0.2u L=0.04u
M28752 U6904/net28 U6904/net40 U6904/net64 VDD pmos W=0.205u L=0.04u
M28753 U6904/net24 g2975 U6904/net32 VDD pmos W=0.205u L=0.04u
M28754 U6904/net28 U6904/net20 U6904/net24 VDD pmos W=0.205u L=0.04u
M28755 U6904/net40 U6904/net106 U6904/net108 VDD pmos W=0.205u L=0.04u
M28756 U6904/net40 g2978 U6904/net104 VDD pmos W=0.205u L=0.04u
M28757 U6904/net20 U6904/net40 VDD VDD pmos W=0.205u L=0.04u
M28758 U6904/net106 g2978 VDD VDD pmos W=0.205u L=0.04u
M28759 U6904/net104 g2981 VDD VDD pmos W=0.205u L=0.04u
M28760 U6904/net30 g2975 VDD VDD pmos W=0.205u L=0.04u
M28761 U6904/net108 U6904/net104 VDD VDD pmos W=0.205u L=0.04u
M28762 n5963 U6904/net28 VDD VDD pmos W=0.205u L=0.04u
M28763 U6904/net32 g2972 VDD VDD pmos W=0.205u L=0.04u
M28764 U6904/net64 U6904/net24 VDD VDD pmos W=0.28u L=0.04u
M28765 U6904/net24 U6904/net30 U6904/net045 VDD pmos W=0.205u L=0.04u
M28766 U6904/net045 U6904/net32 VDD VDD pmos W=0.205u L=0.04u
M28767 U6905/net8 n4693 U6905/net26 VSS nmos W=0.155u L=0.04u
M28768 U6905/net26 n3954 VSS VSS nmos W=0.155u L=0.04u
M28769 U6905/net29 U6905/net8 VSS VSS nmos W=0.155u L=0.04u
M28770 U6905/net29 n5965 N1768 VSS nmos W=0.155u L=0.04u
M28771 U6905/net29 n5966 N1768 VSS nmos W=0.155u L=0.04u
M28772 U6905/net8 n3954 VDD VDD pmos W=0.205u L=0.04u
M28773 U6905/net8 n4693 VDD VDD pmos W=0.205u L=0.04u
M28774 N1768 U6905/net8 VDD VDD pmos W=0.205u L=0.04u
M28775 N1768 n5965 U6905/net20 VDD pmos W=0.205u L=0.04u
M28776 U6905/net20 n5966 VDD VDD pmos W=0.205u L=0.04u
M28777 n3954 n4652 VSS VSS nmos W=0.155u L=0.04u
M28778 n3954 n4587 VSS VSS nmos W=0.155u L=0.04u
M28779 n3954 n4653 VSS VSS nmos W=0.155u L=0.04u
M28780 U6906/net25 n4652 VDD VDD pmos W=0.41u L=0.04u
M28781 U6906/net28 n4587 U6906/net25 VDD pmos W=0.41u L=0.04u
M28782 n3954 n4653 U6906/net28 VDD pmos W=0.41u L=0.04u
M28783 n4693 U6907/net6 VSS VSS nmos W=0.155u L=0.04u
M28784 U6907/net6 n4626 U6907/XU30-net23 VSS nmos W=0.155u L=0.04u
M28785 U6907/XU30-net23 n4615 U6907/XU30-net26 VSS nmos W=0.155u L=0.04u
M28786 U6907/XU30-net26 n4739 U6907/XU30-net29 VSS nmos W=0.155u L=0.04u
M28787 U6907/XU30-net29 n5967 VSS VSS nmos W=0.155u L=0.04u
M28788 n4693 U6907/net6 VDD VDD pmos W=0.205u L=0.04u
M28789 U6907/net6 n5967 VDD VDD pmos W=0.205u L=0.04u
M28790 U6907/net6 n4739 VDD VDD pmos W=0.205u L=0.04u
M28791 U6907/net6 n4615 VDD VDD pmos W=0.205u L=0.04u
M28792 U6907/net6 n4626 VDD VDD pmos W=0.205u L=0.04u
M28793 n5967 n4690 VSS VSS nmos W=0.155u L=0.04u
M28794 n5967 n4730 VSS VSS nmos W=0.155u L=0.04u
M28795 n5967 n4689 VSS VSS nmos W=0.155u L=0.04u
M28796 U6908/net25 n4690 VDD VDD pmos W=0.41u L=0.04u
M28797 U6908/net28 n4730 U6908/net25 VDD pmos W=0.41u L=0.04u
M28798 n5967 n4689 U6908/net28 VDD pmos W=0.41u L=0.04u
M28799 n4730 n4612 VSS VSS nmos W=0.135u L=0.04u
M28800 n4730 n4612 VDD VDD pmos W=0.205u L=0.04u
M28801 n4739 U6910/net6 VSS VSS nmos W=0.155u L=0.04u
M28802 U6910/net6 n4738 U6910/XU30-net23 VSS nmos W=0.155u L=0.04u
M28803 U6910/XU30-net23 n4594 U6910/XU30-net26 VSS nmos W=0.155u L=0.04u
M28804 U6910/XU30-net26 n5968 U6910/XU30-net29 VSS nmos W=0.155u L=0.04u
M28805 U6910/XU30-net29 n4607 VSS VSS nmos W=0.155u L=0.04u
M28806 n4739 U6910/net6 VDD VDD pmos W=0.205u L=0.04u
M28807 U6910/net6 n4607 VDD VDD pmos W=0.205u L=0.04u
M28808 U6910/net6 n5968 VDD VDD pmos W=0.205u L=0.04u
M28809 U6910/net6 n4594 VDD VDD pmos W=0.205u L=0.04u
M28810 U6910/net6 n4738 VDD VDD pmos W=0.205u L=0.04u
M28811 n5968 n4621 VSS VSS nmos W=0.155u L=0.04u
M28812 n5968 n4691 VSS VSS nmos W=0.155u L=0.04u
M28813 U6911/XI1-net8 n4691 VDD VDD pmos W=0.205u L=0.04u
M28814 n5968 n4621 U6911/XI1-net8 VDD pmos W=0.205u L=0.04u
M28815 n4691 n4598 VSS VSS nmos W=0.135u L=0.04u
M28816 n4691 n4598 VDD VDD pmos W=0.205u L=0.04u
M28817 n4621 n4683 VSS VSS nmos W=0.135u L=0.04u
M28818 n4621 n4683 VDD VDD pmos W=0.205u L=0.04u
M28819 U6914/p2 n5972 VSS VSS nmos W=0.155u L=0.04u
M28820 U6914/p0 n5970 U6914/p1 VSS nmos W=0.155u L=0.04u
M28821 U6914/p1 n5971 U6914/p2 VSS nmos W=0.155u L=0.04u
M28822 n5966 n5969 U6914/p0 VSS nmos W=0.155u L=0.04u
M28823 n5966 n5971 VDD VDD pmos W=0.205u L=0.04u
M28824 n5966 n5970 VDD VDD pmos W=0.205u L=0.04u
M28825 n5966 n5969 VDD VDD pmos W=0.205u L=0.04u
M28826 n5966 n5972 VDD VDD pmos W=0.205u L=0.04u
M28827 n5972 n5975 VSS VSS nmos W=0.155u L=0.04u
M28828 n5972 n5974 VSS VSS nmos W=0.155u L=0.04u
M28829 n5972 n5973 VSS VSS nmos W=0.155u L=0.04u
M28830 U6915/net25 n5975 VDD VDD pmos W=0.41u L=0.04u
M28831 U6915/net28 n5974 U6915/net25 VDD pmos W=0.41u L=0.04u
M28832 n5972 n5973 U6915/net28 VDD pmos W=0.41u L=0.04u
M28833 U6916/net4 n4612 U6916/net14 VSS nmos W=0.155u L=0.04u
M28834 U6916/net6 U6916/net10 U6916/net14 VSS nmos W=0.17u L=0.04u
M28835 U6916/net4 g2120 VSS VSS nmos W=0.155u L=0.04u
M28836 U6916/net6 U6916/net4 VSS VSS nmos W=0.17u L=0.04u
M28837 n5975 U6916/net14 VSS VSS nmos W=0.155u L=0.04u
M28838 U6916/net10 n4612 VSS VSS nmos W=0.155u L=0.04u
M28839 U6916/net4 U6916/net10 U6916/net14 VDD pmos W=0.255u L=0.04u
M28840 U6916/net6 n4612 U6916/net14 VDD pmos W=0.28u L=0.04u
M28841 U6916/net4 g2120 VDD VDD pmos W=0.205u L=0.04u
M28842 U6916/net6 U6916/net4 VDD VDD pmos W=0.24u L=0.04u
M28843 n5975 U6916/net14 VDD VDD pmos W=0.205u L=0.04u
M28844 U6916/net10 n4612 VDD VDD pmos W=0.205u L=0.04u
M28845 n4612 g2241 U6917/XI21-net17 VSS nmos W=0.155u L=0.04u
M28846 U6917/XI21-net17 g2348 VSS VSS nmos W=0.155u L=0.04u
M28847 n4612 g6837 U6917/XI6-net17 VSS nmos W=0.155u L=0.04u
M28848 U6917/XI6-net17 g2342 VSS VSS nmos W=0.155u L=0.04u
M28849 n4612 g7084 U6917/XI20-net17 VSS nmos W=0.155u L=0.04u
M28850 U6917/XI20-net17 g2345 VSS VSS nmos W=0.155u L=0.04u
M28851 VDD g2241 U6917/net22 VDD pmos W=0.205u L=0.04u
M28852 VDD g2348 U6917/net22 VDD pmos W=0.205u L=0.04u
M28853 U6917/net16 g6837 n4612 VDD pmos W=0.205u L=0.04u
M28854 U6917/net16 g2342 n4612 VDD pmos W=0.205u L=0.04u
M28855 U6917/net22 g7084 U6917/net16 VDD pmos W=0.205u L=0.04u
M28856 U6917/net22 g2345 U6917/net16 VDD pmos W=0.205u L=0.04u
M28857 U6918/net4 n4683 U6918/net14 VSS nmos W=0.155u L=0.04u
M28858 U6918/net6 U6918/net10 U6918/net14 VSS nmos W=0.17u L=0.04u
M28859 U6918/net4 g2129 VSS VSS nmos W=0.155u L=0.04u
M28860 U6918/net6 U6918/net4 VSS VSS nmos W=0.17u L=0.04u
M28861 n5974 U6918/net14 VSS VSS nmos W=0.155u L=0.04u
M28862 U6918/net10 n4683 VSS VSS nmos W=0.155u L=0.04u
M28863 U6918/net4 U6918/net10 U6918/net14 VDD pmos W=0.255u L=0.04u
M28864 U6918/net6 n4683 U6918/net14 VDD pmos W=0.28u L=0.04u
M28865 U6918/net4 g2129 VDD VDD pmos W=0.205u L=0.04u
M28866 U6918/net6 U6918/net4 VDD VDD pmos W=0.24u L=0.04u
M28867 n5974 U6918/net14 VDD VDD pmos W=0.205u L=0.04u
M28868 U6918/net10 n4683 VDD VDD pmos W=0.205u L=0.04u
M28869 n4683 g2241 U6919/XI21-net17 VSS nmos W=0.155u L=0.04u
M28870 U6919/XI21-net17 g2339 VSS VSS nmos W=0.155u L=0.04u
M28871 n4683 g6837 U6919/XI6-net17 VSS nmos W=0.155u L=0.04u
M28872 U6919/XI6-net17 g2333 VSS VSS nmos W=0.155u L=0.04u
M28873 n4683 g7084 U6919/XI20-net17 VSS nmos W=0.155u L=0.04u
M28874 U6919/XI20-net17 g2336 VSS VSS nmos W=0.155u L=0.04u
M28875 VDD g2241 U6919/net22 VDD pmos W=0.205u L=0.04u
M28876 VDD g2339 U6919/net22 VDD pmos W=0.205u L=0.04u
M28877 U6919/net16 g6837 n4683 VDD pmos W=0.205u L=0.04u
M28878 U6919/net16 g2333 n4683 VDD pmos W=0.205u L=0.04u
M28879 U6919/net22 g7084 U6919/net16 VDD pmos W=0.205u L=0.04u
M28880 U6919/net22 g2336 U6919/net16 VDD pmos W=0.205u L=0.04u
M28881 U6920/net4 n4598 U6920/net14 VSS nmos W=0.155u L=0.04u
M28882 U6920/net6 U6920/net10 U6920/net14 VSS nmos W=0.17u L=0.04u
M28883 U6920/net4 g2138 VSS VSS nmos W=0.155u L=0.04u
M28884 U6920/net6 U6920/net4 VSS VSS nmos W=0.17u L=0.04u
M28885 n5973 U6920/net14 VSS VSS nmos W=0.155u L=0.04u
M28886 U6920/net10 n4598 VSS VSS nmos W=0.155u L=0.04u
M28887 U6920/net4 U6920/net10 U6920/net14 VDD pmos W=0.255u L=0.04u
M28888 U6920/net6 n4598 U6920/net14 VDD pmos W=0.28u L=0.04u
M28889 U6920/net4 g2138 VDD VDD pmos W=0.205u L=0.04u
M28890 U6920/net6 U6920/net4 VDD VDD pmos W=0.24u L=0.04u
M28891 n5973 U6920/net14 VDD VDD pmos W=0.205u L=0.04u
M28892 U6920/net10 n4598 VDD VDD pmos W=0.205u L=0.04u
M28893 n4598 g2241 U6921/XI21-net17 VSS nmos W=0.155u L=0.04u
M28894 U6921/XI21-net17 g2330 VSS VSS nmos W=0.155u L=0.04u
M28895 n4598 g6837 U6921/XI6-net17 VSS nmos W=0.155u L=0.04u
M28896 U6921/XI6-net17 g2324 VSS VSS nmos W=0.155u L=0.04u
M28897 n4598 g7084 U6921/XI20-net17 VSS nmos W=0.155u L=0.04u
M28898 U6921/XI20-net17 g2327 VSS VSS nmos W=0.155u L=0.04u
M28899 VDD g2241 U6921/net22 VDD pmos W=0.205u L=0.04u
M28900 VDD g2330 U6921/net22 VDD pmos W=0.205u L=0.04u
M28901 U6921/net16 g6837 n4598 VDD pmos W=0.205u L=0.04u
M28902 U6921/net16 g2324 n4598 VDD pmos W=0.205u L=0.04u
M28903 U6921/net22 g7084 U6921/net16 VDD pmos W=0.205u L=0.04u
M28904 U6921/net22 g2327 U6921/net16 VDD pmos W=0.205u L=0.04u
M28905 U6922/net4 U6922/net10 U6922/net14 VSS nmos W=0.155u L=0.04u
M28906 U6922/net6 g2151 U6922/net14 VSS nmos W=0.155u L=0.04u
M28907 U6922/net4 n4626 VSS VSS nmos W=0.155u L=0.04u
M28908 U6922/net6 U6922/net4 VSS VSS nmos W=0.155u L=0.04u
M28909 n5971 U6922/net14 VSS VSS nmos W=0.155u L=0.04u
M28910 U6922/net10 g2151 VSS VSS nmos W=0.155u L=0.04u
M28911 U6922/net4 g2151 U6922/net14 VDD pmos W=0.205u L=0.04u
M28912 U6922/net6 U6922/net10 U6922/net14 VDD pmos W=0.205u L=0.04u
M28913 U6922/net4 n4626 VDD VDD pmos W=0.205u L=0.04u
M28914 U6922/net6 U6922/net4 VDD VDD pmos W=0.205u L=0.04u
M28915 n5971 U6922/net14 VDD VDD pmos W=0.205u L=0.04u
M28916 U6922/net10 g2151 VDD VDD pmos W=0.205u L=0.04u
M28917 n4626 g2241 U6923/XI21-net17 VSS nmos W=0.155u L=0.04u
M28918 U6923/XI21-net17 g2276 VSS VSS nmos W=0.155u L=0.04u
M28919 n4626 g6837 U6923/XI6-net17 VSS nmos W=0.155u L=0.04u
M28920 U6923/XI6-net17 g2270 VSS VSS nmos W=0.155u L=0.04u
M28921 n4626 g7084 U6923/XI20-net17 VSS nmos W=0.155u L=0.04u
M28922 U6923/XI20-net17 g2273 VSS VSS nmos W=0.155u L=0.04u
M28923 VDD g2241 U6923/net22 VDD pmos W=0.205u L=0.04u
M28924 VDD g2276 U6923/net22 VDD pmos W=0.205u L=0.04u
M28925 U6923/net16 g6837 n4626 VDD pmos W=0.205u L=0.04u
M28926 U6923/net16 g2270 n4626 VDD pmos W=0.205u L=0.04u
M28927 U6923/net22 g7084 U6923/net16 VDD pmos W=0.205u L=0.04u
M28928 U6923/net22 g2273 U6923/net16 VDD pmos W=0.205u L=0.04u
M28929 U6924/net4 n5569 U6924/net14 VSS nmos W=0.155u L=0.04u
M28930 U6924/net6 U6924/net10 U6924/net14 VSS nmos W=0.17u L=0.04u
M28931 U6924/net4 n4615 VSS VSS nmos W=0.155u L=0.04u
M28932 U6924/net6 U6924/net4 VSS VSS nmos W=0.17u L=0.04u
M28933 n5970 U6924/net14 VSS VSS nmos W=0.155u L=0.04u
M28934 U6924/net10 n5569 VSS VSS nmos W=0.155u L=0.04u
M28935 U6924/net4 U6924/net10 U6924/net14 VDD pmos W=0.255u L=0.04u
M28936 U6924/net6 n5569 U6924/net14 VDD pmos W=0.28u L=0.04u
M28937 U6924/net4 n4615 VDD VDD pmos W=0.205u L=0.04u
M28938 U6924/net6 U6924/net4 VDD VDD pmos W=0.24u L=0.04u
M28939 n5970 U6924/net14 VDD VDD pmos W=0.205u L=0.04u
M28940 U6924/net10 n5569 VDD VDD pmos W=0.205u L=0.04u
M28941 n4615 g2241 U6925/XI21-net17 VSS nmos W=0.155u L=0.04u
M28942 U6925/XI21-net17 g2303 VSS VSS nmos W=0.155u L=0.04u
M28943 n4615 g6837 U6925/XI6-net17 VSS nmos W=0.155u L=0.04u
M28944 U6925/XI6-net17 g2297 VSS VSS nmos W=0.155u L=0.04u
M28945 n4615 g7084 U6925/XI20-net17 VSS nmos W=0.155u L=0.04u
M28946 U6925/XI20-net17 g2300 VSS VSS nmos W=0.155u L=0.04u
M28947 VDD g2241 U6925/net22 VDD pmos W=0.205u L=0.04u
M28948 VDD g2303 U6925/net22 VDD pmos W=0.205u L=0.04u
M28949 U6925/net16 g6837 n4615 VDD pmos W=0.205u L=0.04u
M28950 U6925/net16 g2297 n4615 VDD pmos W=0.205u L=0.04u
M28951 U6925/net22 g7084 U6925/net16 VDD pmos W=0.205u L=0.04u
M28952 U6925/net22 g2300 U6925/net16 VDD pmos W=0.205u L=0.04u
M28953 n5569 g2124 VSS VSS nmos W=0.135u L=0.04u
M28954 n5569 g2124 VDD VDD pmos W=0.205u L=0.04u
M28955 U6927/net4 g2133 U6927/net14 VSS nmos W=0.155u L=0.04u
M28956 U6927/net6 U6927/net10 U6927/net14 VSS nmos W=0.17u L=0.04u
M28957 U6927/net4 n4684 VSS VSS nmos W=0.155u L=0.04u
M28958 U6927/net6 U6927/net4 VSS VSS nmos W=0.17u L=0.04u
M28959 n5969 U6927/net14 VSS VSS nmos W=0.155u L=0.04u
M28960 U6927/net10 g2133 VSS VSS nmos W=0.155u L=0.04u
M28961 U6927/net4 U6927/net10 U6927/net14 VDD pmos W=0.255u L=0.04u
M28962 U6927/net6 g2133 U6927/net14 VDD pmos W=0.28u L=0.04u
M28963 U6927/net4 n4684 VDD VDD pmos W=0.205u L=0.04u
M28964 U6927/net6 U6927/net4 VDD VDD pmos W=0.24u L=0.04u
M28965 n5969 U6927/net14 VDD VDD pmos W=0.205u L=0.04u
M28966 U6927/net10 g2133 VDD VDD pmos W=0.205u L=0.04u
M28967 n4684 n4594 VSS VSS nmos W=0.135u L=0.04u
M28968 n4684 n4594 VDD VDD pmos W=0.205u L=0.04u
M28969 n4594 g2241 U6929/XI21-net17 VSS nmos W=0.155u L=0.04u
M28970 U6929/XI21-net17 g2294 VSS VSS nmos W=0.155u L=0.04u
M28971 n4594 g6837 U6929/XI6-net17 VSS nmos W=0.155u L=0.04u
M28972 U6929/XI6-net17 g2288 VSS VSS nmos W=0.155u L=0.04u
M28973 n4594 g7084 U6929/XI20-net17 VSS nmos W=0.155u L=0.04u
M28974 U6929/XI20-net17 g2291 VSS VSS nmos W=0.155u L=0.04u
M28975 VDD g2241 U6929/net22 VDD pmos W=0.205u L=0.04u
M28976 VDD g2294 U6929/net22 VDD pmos W=0.205u L=0.04u
M28977 U6929/net16 g6837 n4594 VDD pmos W=0.205u L=0.04u
M28978 U6929/net16 g2288 n4594 VDD pmos W=0.205u L=0.04u
M28979 U6929/net22 g7084 U6929/net16 VDD pmos W=0.205u L=0.04u
M28980 U6929/net22 g2291 U6929/net16 VDD pmos W=0.205u L=0.04u
M28981 U6930/p2 n5977 VSS VSS nmos W=0.155u L=0.04u
M28982 U6930/p0 n5437 U6930/p1 VSS nmos W=0.155u L=0.04u
M28983 U6930/p1 n5976 U6930/p2 VSS nmos W=0.155u L=0.04u
M28984 n5965 n3956 U6930/p0 VSS nmos W=0.155u L=0.04u
M28985 n5965 n5976 VDD VDD pmos W=0.205u L=0.04u
M28986 n5965 n5437 VDD VDD pmos W=0.205u L=0.04u
M28987 n5965 n3956 VDD VDD pmos W=0.205u L=0.04u
M28988 n5965 n5977 VDD VDD pmos W=0.205u L=0.04u
M28989 n5977 n5980 VSS VSS nmos W=0.155u L=0.04u
M28990 n5977 n5979 VSS VSS nmos W=0.155u L=0.04u
M28991 n5977 n5978 VSS VSS nmos W=0.155u L=0.04u
M28992 U6931/net25 n5980 VDD VDD pmos W=0.41u L=0.04u
M28993 U6931/net28 n5979 U6931/net25 VDD pmos W=0.41u L=0.04u
M28994 n5977 n5978 U6931/net28 VDD pmos W=0.41u L=0.04u
M28995 U6932/net4 n4689 U6932/net14 VSS nmos W=0.155u L=0.04u
M28996 U6932/net6 U6932/net10 U6932/net14 VSS nmos W=0.17u L=0.04u
M28997 U6932/net4 n5582 VSS VSS nmos W=0.155u L=0.04u
M28998 U6932/net6 U6932/net4 VSS VSS nmos W=0.17u L=0.04u
M28999 n5980 U6932/net14 VSS VSS nmos W=0.155u L=0.04u
M29000 U6932/net10 n4689 VSS VSS nmos W=0.155u L=0.04u
M29001 U6932/net4 U6932/net10 U6932/net14 VDD pmos W=0.255u L=0.04u
M29002 U6932/net6 n4689 U6932/net14 VDD pmos W=0.28u L=0.04u
M29003 U6932/net4 n5582 VDD VDD pmos W=0.205u L=0.04u
M29004 U6932/net6 U6932/net4 VDD VDD pmos W=0.24u L=0.04u
M29005 n5980 U6932/net14 VDD VDD pmos W=0.205u L=0.04u
M29006 U6932/net10 n4689 VDD VDD pmos W=0.205u L=0.04u
M29007 n5582 g2156 VSS VSS nmos W=0.135u L=0.04u
M29008 n5582 g2156 VDD VDD pmos W=0.205u L=0.04u
M29009 n4689 n4634 VSS VSS nmos W=0.135u L=0.04u
M29010 n4689 n4634 VDD VDD pmos W=0.205u L=0.04u
M29011 n4634 g2241 U6935/XI21-net17 VSS nmos W=0.155u L=0.04u
M29012 U6935/XI21-net17 g2312 VSS VSS nmos W=0.155u L=0.04u
M29013 n4634 g6837 U6935/XI6-net17 VSS nmos W=0.155u L=0.04u
M29014 U6935/XI6-net17 g2306 VSS VSS nmos W=0.155u L=0.04u
M29015 n4634 g7084 U6935/XI20-net17 VSS nmos W=0.155u L=0.04u
M29016 U6935/XI20-net17 g2309 VSS VSS nmos W=0.155u L=0.04u
M29017 VDD g2241 U6935/net22 VDD pmos W=0.205u L=0.04u
M29018 VDD g2312 U6935/net22 VDD pmos W=0.205u L=0.04u
M29019 U6935/net16 g6837 n4634 VDD pmos W=0.205u L=0.04u
M29020 U6935/net16 g2306 n4634 VDD pmos W=0.205u L=0.04u
M29021 U6935/net22 g7084 U6935/net16 VDD pmos W=0.205u L=0.04u
M29022 U6935/net22 g2309 U6935/net16 VDD pmos W=0.205u L=0.04u
M29023 U6936/net4 n4738 U6936/net14 VSS nmos W=0.155u L=0.04u
M29024 U6936/net6 U6936/net10 U6936/net14 VSS nmos W=0.17u L=0.04u
M29025 U6936/net4 g2142 VSS VSS nmos W=0.155u L=0.04u
M29026 U6936/net6 U6936/net4 VSS VSS nmos W=0.17u L=0.04u
M29027 n5979 U6936/net14 VSS VSS nmos W=0.155u L=0.04u
M29028 U6936/net10 n4738 VSS VSS nmos W=0.155u L=0.04u
M29029 U6936/net4 U6936/net10 U6936/net14 VDD pmos W=0.255u L=0.04u
M29030 U6936/net6 n4738 U6936/net14 VDD pmos W=0.28u L=0.04u
M29031 U6936/net4 g2142 VDD VDD pmos W=0.205u L=0.04u
M29032 U6936/net6 U6936/net4 VDD VDD pmos W=0.24u L=0.04u
M29033 n5979 U6936/net14 VDD VDD pmos W=0.205u L=0.04u
M29034 U6936/net10 n4738 VDD VDD pmos W=0.205u L=0.04u
M29035 n4738 g2241 U6937/XI21-net17 VSS nmos W=0.155u L=0.04u
M29036 U6937/XI21-net17 g2285 VSS VSS nmos W=0.155u L=0.04u
M29037 n4738 g6837 U6937/XI6-net17 VSS nmos W=0.155u L=0.04u
M29038 U6937/XI6-net17 g2279 VSS VSS nmos W=0.155u L=0.04u
M29039 n4738 g7084 U6937/XI20-net17 VSS nmos W=0.155u L=0.04u
M29040 U6937/XI20-net17 g2282 VSS VSS nmos W=0.155u L=0.04u
M29041 VDD g2241 U6937/net22 VDD pmos W=0.205u L=0.04u
M29042 VDD g2285 U6937/net22 VDD pmos W=0.205u L=0.04u
M29043 U6937/net16 g6837 n4738 VDD pmos W=0.205u L=0.04u
M29044 U6937/net16 g2279 n4738 VDD pmos W=0.205u L=0.04u
M29045 U6937/net22 g7084 U6937/net16 VDD pmos W=0.205u L=0.04u
M29046 U6937/net22 g2282 U6937/net16 VDD pmos W=0.205u L=0.04u
M29047 U6938/net4 n4607 U6938/net14 VSS nmos W=0.155u L=0.04u
M29048 U6938/net6 U6938/net10 U6938/net14 VSS nmos W=0.17u L=0.04u
M29049 U6938/net4 g2160 VSS VSS nmos W=0.155u L=0.04u
M29050 U6938/net6 U6938/net4 VSS VSS nmos W=0.17u L=0.04u
M29051 n5978 U6938/net14 VSS VSS nmos W=0.155u L=0.04u
M29052 U6938/net10 n4607 VSS VSS nmos W=0.155u L=0.04u
M29053 U6938/net4 U6938/net10 U6938/net14 VDD pmos W=0.255u L=0.04u
M29054 U6938/net6 n4607 U6938/net14 VDD pmos W=0.28u L=0.04u
M29055 U6938/net4 g2160 VDD VDD pmos W=0.205u L=0.04u
M29056 U6938/net6 U6938/net4 VDD VDD pmos W=0.24u L=0.04u
M29057 n5978 U6938/net14 VDD VDD pmos W=0.205u L=0.04u
M29058 U6938/net10 n4607 VDD VDD pmos W=0.205u L=0.04u
M29059 n4607 g2241 U6939/XI21-net17 VSS nmos W=0.155u L=0.04u
M29060 U6939/XI21-net17 g2267 VSS VSS nmos W=0.155u L=0.04u
M29061 n4607 g6837 U6939/XI6-net17 VSS nmos W=0.155u L=0.04u
M29062 U6939/XI6-net17 g2261 VSS VSS nmos W=0.155u L=0.04u
M29063 n4607 g7084 U6939/XI20-net17 VSS nmos W=0.155u L=0.04u
M29064 U6939/XI20-net17 g2264 VSS VSS nmos W=0.155u L=0.04u
M29065 VDD g2241 U6939/net22 VDD pmos W=0.205u L=0.04u
M29066 VDD g2267 U6939/net22 VDD pmos W=0.205u L=0.04u
M29067 U6939/net16 g6837 n4607 VDD pmos W=0.205u L=0.04u
M29068 U6939/net16 g2261 n4607 VDD pmos W=0.205u L=0.04u
M29069 U6939/net22 g7084 U6939/net16 VDD pmos W=0.205u L=0.04u
M29070 U6939/net22 g2264 U6939/net16 VDD pmos W=0.205u L=0.04u
M29071 U6940/net4 g2147 U6940/net14 VSS nmos W=0.155u L=0.04u
M29072 U6940/net6 U6940/net10 U6940/net14 VSS nmos W=0.17u L=0.04u
M29073 U6940/net4 n4690 VSS VSS nmos W=0.155u L=0.04u
M29074 U6940/net6 U6940/net4 VSS VSS nmos W=0.17u L=0.04u
M29075 n5976 U6940/net14 VSS VSS nmos W=0.155u L=0.04u
M29076 U6940/net10 g2147 VSS VSS nmos W=0.155u L=0.04u
M29077 U6940/net4 U6940/net10 U6940/net14 VDD pmos W=0.255u L=0.04u
M29078 U6940/net6 g2147 U6940/net14 VDD pmos W=0.28u L=0.04u
M29079 U6940/net4 n4690 VDD VDD pmos W=0.205u L=0.04u
M29080 U6940/net6 U6940/net4 VDD VDD pmos W=0.24u L=0.04u
M29081 n5976 U6940/net14 VDD VDD pmos W=0.205u L=0.04u
M29082 U6940/net10 g2147 VDD VDD pmos W=0.205u L=0.04u
M29083 n4690 n4625 VSS VSS nmos W=0.135u L=0.04u
M29084 n4690 n4625 VDD VDD pmos W=0.205u L=0.04u
M29085 n4625 g2241 U6942/XI21-net17 VSS nmos W=0.155u L=0.04u
M29086 U6942/XI21-net17 g2321 VSS VSS nmos W=0.155u L=0.04u
M29087 n4625 g6837 U6942/XI6-net17 VSS nmos W=0.155u L=0.04u
M29088 U6942/XI6-net17 g2315 VSS VSS nmos W=0.155u L=0.04u
M29089 n4625 g7084 U6942/XI20-net17 VSS nmos W=0.155u L=0.04u
M29090 U6942/XI20-net17 g2318 VSS VSS nmos W=0.155u L=0.04u
M29091 VDD g2241 U6942/net22 VDD pmos W=0.205u L=0.04u
M29092 VDD g2321 U6942/net22 VDD pmos W=0.205u L=0.04u
M29093 U6942/net16 g6837 n4625 VDD pmos W=0.205u L=0.04u
M29094 U6942/net16 g2315 n4625 VDD pmos W=0.205u L=0.04u
M29095 U6942/net22 g7084 U6942/net16 VDD pmos W=0.205u L=0.04u
M29096 U6942/net22 g2318 U6942/net16 VDD pmos W=0.205u L=0.04u
M29097 U6943/XU1-net6 n4653 VSS VSS nmos W=0.155u L=0.04u
M29098 n3956 n4658 U6943/XU1-net6 VSS nmos W=0.155u L=0.04u
M29099 n3956 n4653 VDD VDD pmos W=0.155u L=0.04u
M29100 n3956 n4658 VDD VDD pmos W=0.155u L=0.04u
M29101 n4653 n4330 U6944/net27 VSS nmos W=0.155u L=0.04u
M29102 U6944/net39 n4530 VSS VSS nmos W=0.155u L=0.04u
M29103 U6944/net27 g2393 U6944/net39 VSS nmos W=0.155u L=0.04u
M29104 U6944/net27 n4529 U6944/net39 VSS nmos W=0.155u L=0.04u
M29105 n4653 g2394 U6944/net27 VSS nmos W=0.155u L=0.04u
M29106 U6944/net39 g2395 VSS VSS nmos W=0.155u L=0.04u
M29107 n4653 n4530 U6944/net46 VDD pmos W=0.205u L=0.04u
M29108 U6944/net46 g2395 VDD VDD pmos W=0.205u L=0.04u
M29109 n4653 g2394 U6944/net34 VDD pmos W=0.205u L=0.04u
M29110 U6944/net34 n4330 VDD VDD pmos W=0.205u L=0.04u
M29111 n4653 n4529 U6944/net37 VDD pmos W=0.205u L=0.04u
M29112 U6944/net37 g2393 VDD VDD pmos W=0.205u L=0.04u
M29113 n4658 n4587 VSS VSS nmos W=0.155u L=0.04u
M29114 n4658 n4654 VSS VSS nmos W=0.155u L=0.04u
M29115 U6945/XI1-net8 n4654 VDD VDD pmos W=0.205u L=0.04u
M29116 n4658 n4587 U6945/XI1-net8 VDD pmos W=0.205u L=0.04u
M29117 n4654 n4652 VSS VSS nmos W=0.135u L=0.04u
M29118 n4654 n4652 VDD VDD pmos W=0.205u L=0.04u
M29119 n4652 n4330 U6947/net27 VSS nmos W=0.155u L=0.04u
M29120 U6947/net39 n4530 VSS VSS nmos W=0.155u L=0.04u
M29121 U6947/net27 g2390 U6947/net39 VSS nmos W=0.155u L=0.04u
M29122 U6947/net27 n4529 U6947/net39 VSS nmos W=0.155u L=0.04u
M29123 n4652 g2391 U6947/net27 VSS nmos W=0.155u L=0.04u
M29124 U6947/net39 g2392 VSS VSS nmos W=0.155u L=0.04u
M29125 n4652 n4530 U6947/net46 VDD pmos W=0.205u L=0.04u
M29126 U6947/net46 g2392 VDD VDD pmos W=0.205u L=0.04u
M29127 n4652 g2391 U6947/net34 VDD pmos W=0.205u L=0.04u
M29128 U6947/net34 n4330 VDD VDD pmos W=0.205u L=0.04u
M29129 n4652 n4529 U6947/net37 VDD pmos W=0.205u L=0.04u
M29130 U6947/net37 g2390 VDD VDD pmos W=0.205u L=0.04u
M29131 n4587 n4330 U6948/net27 VSS nmos W=0.155u L=0.04u
M29132 U6948/net39 n4530 VSS VSS nmos W=0.155u L=0.04u
M29133 U6948/net27 g2387 U6948/net39 VSS nmos W=0.155u L=0.04u
M29134 U6948/net27 n4529 U6948/net39 VSS nmos W=0.155u L=0.04u
M29135 n4587 g2388 U6948/net27 VSS nmos W=0.155u L=0.04u
M29136 U6948/net39 g2389 VSS VSS nmos W=0.155u L=0.04u
M29137 n4587 n4530 U6948/net46 VDD pmos W=0.205u L=0.04u
M29138 U6948/net46 g2389 VDD VDD pmos W=0.205u L=0.04u
M29139 n4587 g2388 U6948/net34 VDD pmos W=0.205u L=0.04u
M29140 U6948/net34 n4330 VDD VDD pmos W=0.205u L=0.04u
M29141 n4587 n4529 U6948/net37 VDD pmos W=0.205u L=0.04u
M29142 U6948/net37 g2387 VDD VDD pmos W=0.205u L=0.04u
M29143 n4530 g2476 VSS VSS nmos W=0.135u L=0.04u
M29144 n4530 g2476 VDD VDD pmos W=0.205u L=0.04u
M29145 n4529 g5555 VSS VSS nmos W=0.135u L=0.04u
M29146 n4529 g5555 VDD VDD pmos W=0.205u L=0.04u
M29147 n4330 g7264 VSS VSS nmos W=0.135u L=0.04u
M29148 n4330 g7264 VDD VDD pmos W=0.205u L=0.04u
M29149 U6952/net8 n5355 U6952/net26 VSS nmos W=0.155u L=0.04u
M29150 U6952/net26 n4062 VSS VSS nmos W=0.155u L=0.04u
M29151 U6952/net29 U6952/net8 VSS VSS nmos W=0.155u L=0.04u
M29152 U6952/net29 n5981 N1766 VSS nmos W=0.155u L=0.04u
M29153 U6952/net29 n5982 N1766 VSS nmos W=0.155u L=0.04u
M29154 U6952/net8 n4062 VDD VDD pmos W=0.205u L=0.04u
M29155 U6952/net8 n5355 VDD VDD pmos W=0.205u L=0.04u
M29156 N1766 U6952/net8 VDD VDD pmos W=0.205u L=0.04u
M29157 N1766 n5981 U6952/net20 VDD pmos W=0.205u L=0.04u
M29158 U6952/net20 n5982 VDD VDD pmos W=0.205u L=0.04u
M29159 n4062 n5314 VSS VSS nmos W=0.155u L=0.04u
M29160 n4062 n5249 VSS VSS nmos W=0.155u L=0.04u
M29161 n4062 n5315 VSS VSS nmos W=0.155u L=0.04u
M29162 U6953/net25 n5314 VDD VDD pmos W=0.41u L=0.04u
M29163 U6953/net28 n5249 U6953/net25 VDD pmos W=0.41u L=0.04u
M29164 n4062 n5315 U6953/net28 VDD pmos W=0.41u L=0.04u
M29165 n5355 U6954/net6 VSS VSS nmos W=0.155u L=0.04u
M29166 U6954/net6 n5288 U6954/XU30-net23 VSS nmos W=0.155u L=0.04u
M29167 U6954/XU30-net23 n5277 U6954/XU30-net26 VSS nmos W=0.155u L=0.04u
M29168 U6954/XU30-net26 n5401 U6954/XU30-net29 VSS nmos W=0.155u L=0.04u
M29169 U6954/XU30-net29 n5983 VSS VSS nmos W=0.155u L=0.04u
M29170 n5355 U6954/net6 VDD VDD pmos W=0.205u L=0.04u
M29171 U6954/net6 n5983 VDD VDD pmos W=0.205u L=0.04u
M29172 U6954/net6 n5401 VDD VDD pmos W=0.205u L=0.04u
M29173 U6954/net6 n5277 VDD VDD pmos W=0.205u L=0.04u
M29174 U6954/net6 n5288 VDD VDD pmos W=0.205u L=0.04u
M29175 n5983 n5352 VSS VSS nmos W=0.155u L=0.04u
M29176 n5983 n5392 VSS VSS nmos W=0.155u L=0.04u
M29177 n5983 n5351 VSS VSS nmos W=0.155u L=0.04u
M29178 U6955/net25 n5352 VDD VDD pmos W=0.41u L=0.04u
M29179 U6955/net28 n5392 U6955/net25 VDD pmos W=0.41u L=0.04u
M29180 n5983 n5351 U6955/net28 VDD pmos W=0.41u L=0.04u
M29181 n5392 n5274 VSS VSS nmos W=0.135u L=0.04u
M29182 n5392 n5274 VDD VDD pmos W=0.205u L=0.04u
M29183 n5401 U6957/net6 VSS VSS nmos W=0.155u L=0.04u
M29184 U6957/net6 n5400 U6957/XU30-net23 VSS nmos W=0.155u L=0.04u
M29185 U6957/XU30-net23 n5256 U6957/XU30-net26 VSS nmos W=0.155u L=0.04u
M29186 U6957/XU30-net26 n5984 U6957/XU30-net29 VSS nmos W=0.155u L=0.04u
M29187 U6957/XU30-net29 n5269 VSS VSS nmos W=0.155u L=0.04u
M29188 n5401 U6957/net6 VDD VDD pmos W=0.205u L=0.04u
M29189 U6957/net6 n5269 VDD VDD pmos W=0.205u L=0.04u
M29190 U6957/net6 n5984 VDD VDD pmos W=0.205u L=0.04u
M29191 U6957/net6 n5256 VDD VDD pmos W=0.205u L=0.04u
M29192 U6957/net6 n5400 VDD VDD pmos W=0.205u L=0.04u
M29193 n5984 n5283 VSS VSS nmos W=0.155u L=0.04u
M29194 n5984 n5353 VSS VSS nmos W=0.155u L=0.04u
M29195 U6958/XI1-net8 n5353 VDD VDD pmos W=0.205u L=0.04u
M29196 n5984 n5283 U6958/XI1-net8 VDD pmos W=0.205u L=0.04u
M29197 n5353 n5260 VSS VSS nmos W=0.135u L=0.04u
M29198 n5353 n5260 VDD VDD pmos W=0.205u L=0.04u
M29199 n5283 n5345 VSS VSS nmos W=0.135u L=0.04u
M29200 n5283 n5345 VDD VDD pmos W=0.205u L=0.04u
M29201 U6961/p2 n5988 VSS VSS nmos W=0.155u L=0.04u
M29202 U6961/p0 n5986 U6961/p1 VSS nmos W=0.155u L=0.04u
M29203 U6961/p1 n5987 U6961/p2 VSS nmos W=0.155u L=0.04u
M29204 n5982 n5985 U6961/p0 VSS nmos W=0.155u L=0.04u
M29205 n5982 n5987 VDD VDD pmos W=0.205u L=0.04u
M29206 n5982 n5986 VDD VDD pmos W=0.205u L=0.04u
M29207 n5982 n5985 VDD VDD pmos W=0.205u L=0.04u
M29208 n5982 n5988 VDD VDD pmos W=0.205u L=0.04u
M29209 n5988 n5991 VSS VSS nmos W=0.155u L=0.04u
M29210 n5988 n5990 VSS VSS nmos W=0.155u L=0.04u
M29211 n5988 n5989 VSS VSS nmos W=0.155u L=0.04u
M29212 U6962/net25 n5991 VDD VDD pmos W=0.41u L=0.04u
M29213 U6962/net28 n5990 U6962/net25 VDD pmos W=0.41u L=0.04u
M29214 n5988 n5989 U6962/net28 VDD pmos W=0.41u L=0.04u
M29215 U6963/net4 n5274 U6963/net14 VSS nmos W=0.155u L=0.04u
M29216 U6963/net6 U6963/net10 U6963/net14 VSS nmos W=0.17u L=0.04u
M29217 U6963/net4 g1426 VSS VSS nmos W=0.155u L=0.04u
M29218 U6963/net6 U6963/net4 VSS VSS nmos W=0.17u L=0.04u
M29219 n5991 U6963/net14 VSS VSS nmos W=0.155u L=0.04u
M29220 U6963/net10 n5274 VSS VSS nmos W=0.155u L=0.04u
M29221 U6963/net4 U6963/net10 U6963/net14 VDD pmos W=0.255u L=0.04u
M29222 U6963/net6 n5274 U6963/net14 VDD pmos W=0.28u L=0.04u
M29223 U6963/net4 g1426 VDD VDD pmos W=0.205u L=0.04u
M29224 U6963/net6 U6963/net4 VDD VDD pmos W=0.24u L=0.04u
M29225 n5991 U6963/net14 VDD VDD pmos W=0.205u L=0.04u
M29226 U6963/net10 n5274 VDD VDD pmos W=0.205u L=0.04u
M29227 n5274 g1547 U6964/XI21-net17 VSS nmos W=0.155u L=0.04u
M29228 U6964/XI21-net17 g1654 VSS VSS nmos W=0.155u L=0.04u
M29229 n5274 g6573 U6964/XI6-net17 VSS nmos W=0.155u L=0.04u
M29230 U6964/XI6-net17 g1648 VSS VSS nmos W=0.155u L=0.04u
M29231 n5274 g6782 U6964/XI20-net17 VSS nmos W=0.155u L=0.04u
M29232 U6964/XI20-net17 g1651 VSS VSS nmos W=0.155u L=0.04u
M29233 VDD g1547 U6964/net22 VDD pmos W=0.205u L=0.04u
M29234 VDD g1654 U6964/net22 VDD pmos W=0.205u L=0.04u
M29235 U6964/net16 g6573 n5274 VDD pmos W=0.205u L=0.04u
M29236 U6964/net16 g1648 n5274 VDD pmos W=0.205u L=0.04u
M29237 U6964/net22 g6782 U6964/net16 VDD pmos W=0.205u L=0.04u
M29238 U6964/net22 g1651 U6964/net16 VDD pmos W=0.205u L=0.04u
M29239 U6965/net4 n5345 U6965/net14 VSS nmos W=0.155u L=0.04u
M29240 U6965/net6 U6965/net10 U6965/net14 VSS nmos W=0.17u L=0.04u
M29241 U6965/net4 g1435 VSS VSS nmos W=0.155u L=0.04u
M29242 U6965/net6 U6965/net4 VSS VSS nmos W=0.17u L=0.04u
M29243 n5990 U6965/net14 VSS VSS nmos W=0.155u L=0.04u
M29244 U6965/net10 n5345 VSS VSS nmos W=0.155u L=0.04u
M29245 U6965/net4 U6965/net10 U6965/net14 VDD pmos W=0.255u L=0.04u
M29246 U6965/net6 n5345 U6965/net14 VDD pmos W=0.28u L=0.04u
M29247 U6965/net4 g1435 VDD VDD pmos W=0.205u L=0.04u
M29248 U6965/net6 U6965/net4 VDD VDD pmos W=0.24u L=0.04u
M29249 n5990 U6965/net14 VDD VDD pmos W=0.205u L=0.04u
M29250 U6965/net10 n5345 VDD VDD pmos W=0.205u L=0.04u
M29251 n5345 g1547 U6966/XI21-net17 VSS nmos W=0.155u L=0.04u
M29252 U6966/XI21-net17 g1645 VSS VSS nmos W=0.155u L=0.04u
M29253 n5345 g6573 U6966/XI6-net17 VSS nmos W=0.155u L=0.04u
M29254 U6966/XI6-net17 g1639 VSS VSS nmos W=0.155u L=0.04u
M29255 n5345 g6782 U6966/XI20-net17 VSS nmos W=0.155u L=0.04u
M29256 U6966/XI20-net17 g1642 VSS VSS nmos W=0.155u L=0.04u
M29257 VDD g1547 U6966/net22 VDD pmos W=0.205u L=0.04u
M29258 VDD g1645 U6966/net22 VDD pmos W=0.205u L=0.04u
M29259 U6966/net16 g6573 n5345 VDD pmos W=0.205u L=0.04u
M29260 U6966/net16 g1639 n5345 VDD pmos W=0.205u L=0.04u
M29261 U6966/net22 g6782 U6966/net16 VDD pmos W=0.205u L=0.04u
M29262 U6966/net22 g1642 U6966/net16 VDD pmos W=0.205u L=0.04u
M29263 U6967/net4 n5260 U6967/net14 VSS nmos W=0.155u L=0.04u
M29264 U6967/net6 U6967/net10 U6967/net14 VSS nmos W=0.17u L=0.04u
M29265 U6967/net4 g1444 VSS VSS nmos W=0.155u L=0.04u
M29266 U6967/net6 U6967/net4 VSS VSS nmos W=0.17u L=0.04u
M29267 n5989 U6967/net14 VSS VSS nmos W=0.155u L=0.04u
M29268 U6967/net10 n5260 VSS VSS nmos W=0.155u L=0.04u
M29269 U6967/net4 U6967/net10 U6967/net14 VDD pmos W=0.255u L=0.04u
M29270 U6967/net6 n5260 U6967/net14 VDD pmos W=0.28u L=0.04u
M29271 U6967/net4 g1444 VDD VDD pmos W=0.205u L=0.04u
M29272 U6967/net6 U6967/net4 VDD VDD pmos W=0.24u L=0.04u
M29273 n5989 U6967/net14 VDD VDD pmos W=0.205u L=0.04u
M29274 U6967/net10 n5260 VDD VDD pmos W=0.205u L=0.04u
M29275 n5260 g1547 U6968/XI21-net17 VSS nmos W=0.155u L=0.04u
M29276 U6968/XI21-net17 g1636 VSS VSS nmos W=0.155u L=0.04u
M29277 n5260 g6573 U6968/XI6-net17 VSS nmos W=0.155u L=0.04u
M29278 U6968/XI6-net17 g1630 VSS VSS nmos W=0.155u L=0.04u
M29279 n5260 g6782 U6968/XI20-net17 VSS nmos W=0.155u L=0.04u
M29280 U6968/XI20-net17 g1633 VSS VSS nmos W=0.155u L=0.04u
M29281 VDD g1547 U6968/net22 VDD pmos W=0.205u L=0.04u
M29282 VDD g1636 U6968/net22 VDD pmos W=0.205u L=0.04u
M29283 U6968/net16 g6573 n5260 VDD pmos W=0.205u L=0.04u
M29284 U6968/net16 g1630 n5260 VDD pmos W=0.205u L=0.04u
M29285 U6968/net22 g6782 U6968/net16 VDD pmos W=0.205u L=0.04u
M29286 U6968/net22 g1633 U6968/net16 VDD pmos W=0.205u L=0.04u
M29287 U6969/net4 U6969/net10 U6969/net14 VSS nmos W=0.155u L=0.04u
M29288 U6969/net6 g1457 U6969/net14 VSS nmos W=0.155u L=0.04u
M29289 U6969/net4 n5288 VSS VSS nmos W=0.155u L=0.04u
M29290 U6969/net6 U6969/net4 VSS VSS nmos W=0.155u L=0.04u
M29291 n5987 U6969/net14 VSS VSS nmos W=0.155u L=0.04u
M29292 U6969/net10 g1457 VSS VSS nmos W=0.155u L=0.04u
M29293 U6969/net4 g1457 U6969/net14 VDD pmos W=0.205u L=0.04u
M29294 U6969/net6 U6969/net10 U6969/net14 VDD pmos W=0.205u L=0.04u
M29295 U6969/net4 n5288 VDD VDD pmos W=0.205u L=0.04u
M29296 U6969/net6 U6969/net4 VDD VDD pmos W=0.205u L=0.04u
M29297 n5987 U6969/net14 VDD VDD pmos W=0.205u L=0.04u
M29298 U6969/net10 g1457 VDD VDD pmos W=0.205u L=0.04u
M29299 n5288 g1547 U6970/XI21-net17 VSS nmos W=0.155u L=0.04u
M29300 U6970/XI21-net17 g1582 VSS VSS nmos W=0.155u L=0.04u
M29301 n5288 g6573 U6970/XI6-net17 VSS nmos W=0.155u L=0.04u
M29302 U6970/XI6-net17 g1576 VSS VSS nmos W=0.155u L=0.04u
M29303 n5288 g6782 U6970/XI20-net17 VSS nmos W=0.155u L=0.04u
M29304 U6970/XI20-net17 g1579 VSS VSS nmos W=0.155u L=0.04u
M29305 VDD g1547 U6970/net22 VDD pmos W=0.205u L=0.04u
M29306 VDD g1582 U6970/net22 VDD pmos W=0.205u L=0.04u
M29307 U6970/net16 g6573 n5288 VDD pmos W=0.205u L=0.04u
M29308 U6970/net16 g1576 n5288 VDD pmos W=0.205u L=0.04u
M29309 U6970/net22 g6782 U6970/net16 VDD pmos W=0.205u L=0.04u
M29310 U6970/net22 g1579 U6970/net16 VDD pmos W=0.205u L=0.04u
M29311 U6971/net4 n5548 U6971/net14 VSS nmos W=0.155u L=0.04u
M29312 U6971/net6 U6971/net10 U6971/net14 VSS nmos W=0.17u L=0.04u
M29313 U6971/net4 n5277 VSS VSS nmos W=0.155u L=0.04u
M29314 U6971/net6 U6971/net4 VSS VSS nmos W=0.17u L=0.04u
M29315 n5986 U6971/net14 VSS VSS nmos W=0.155u L=0.04u
M29316 U6971/net10 n5548 VSS VSS nmos W=0.155u L=0.04u
M29317 U6971/net4 U6971/net10 U6971/net14 VDD pmos W=0.255u L=0.04u
M29318 U6971/net6 n5548 U6971/net14 VDD pmos W=0.28u L=0.04u
M29319 U6971/net4 n5277 VDD VDD pmos W=0.205u L=0.04u
M29320 U6971/net6 U6971/net4 VDD VDD pmos W=0.24u L=0.04u
M29321 n5986 U6971/net14 VDD VDD pmos W=0.205u L=0.04u
M29322 U6971/net10 n5548 VDD VDD pmos W=0.205u L=0.04u
M29323 n5277 g1547 U6972/XI21-net17 VSS nmos W=0.155u L=0.04u
M29324 U6972/XI21-net17 g1609 VSS VSS nmos W=0.155u L=0.04u
M29325 n5277 g6573 U6972/XI6-net17 VSS nmos W=0.155u L=0.04u
M29326 U6972/XI6-net17 g1603 VSS VSS nmos W=0.155u L=0.04u
M29327 n5277 g6782 U6972/XI20-net17 VSS nmos W=0.155u L=0.04u
M29328 U6972/XI20-net17 g1606 VSS VSS nmos W=0.155u L=0.04u
M29329 VDD g1547 U6972/net22 VDD pmos W=0.205u L=0.04u
M29330 VDD g1609 U6972/net22 VDD pmos W=0.205u L=0.04u
M29331 U6972/net16 g6573 n5277 VDD pmos W=0.205u L=0.04u
M29332 U6972/net16 g1603 n5277 VDD pmos W=0.205u L=0.04u
M29333 U6972/net22 g6782 U6972/net16 VDD pmos W=0.205u L=0.04u
M29334 U6972/net22 g1606 U6972/net16 VDD pmos W=0.205u L=0.04u
M29335 n5548 g1430 VSS VSS nmos W=0.135u L=0.04u
M29336 n5548 g1430 VDD VDD pmos W=0.205u L=0.04u
M29337 U6974/net4 g1439 U6974/net14 VSS nmos W=0.155u L=0.04u
M29338 U6974/net6 U6974/net10 U6974/net14 VSS nmos W=0.17u L=0.04u
M29339 U6974/net4 n5346 VSS VSS nmos W=0.155u L=0.04u
M29340 U6974/net6 U6974/net4 VSS VSS nmos W=0.17u L=0.04u
M29341 n5985 U6974/net14 VSS VSS nmos W=0.155u L=0.04u
M29342 U6974/net10 g1439 VSS VSS nmos W=0.155u L=0.04u
M29343 U6974/net4 U6974/net10 U6974/net14 VDD pmos W=0.255u L=0.04u
M29344 U6974/net6 g1439 U6974/net14 VDD pmos W=0.28u L=0.04u
M29345 U6974/net4 n5346 VDD VDD pmos W=0.205u L=0.04u
M29346 U6974/net6 U6974/net4 VDD VDD pmos W=0.24u L=0.04u
M29347 n5985 U6974/net14 VDD VDD pmos W=0.205u L=0.04u
M29348 U6974/net10 g1439 VDD VDD pmos W=0.205u L=0.04u
M29349 n5346 n5256 VSS VSS nmos W=0.135u L=0.04u
M29350 n5346 n5256 VDD VDD pmos W=0.205u L=0.04u
M29351 n5256 g1547 U6976/XI21-net17 VSS nmos W=0.155u L=0.04u
M29352 U6976/XI21-net17 g1600 VSS VSS nmos W=0.155u L=0.04u
M29353 n5256 g6573 U6976/XI6-net17 VSS nmos W=0.155u L=0.04u
M29354 U6976/XI6-net17 g1594 VSS VSS nmos W=0.155u L=0.04u
M29355 n5256 g6782 U6976/XI20-net17 VSS nmos W=0.155u L=0.04u
M29356 U6976/XI20-net17 g1597 VSS VSS nmos W=0.155u L=0.04u
M29357 VDD g1547 U6976/net22 VDD pmos W=0.205u L=0.04u
M29358 VDD g1600 U6976/net22 VDD pmos W=0.205u L=0.04u
M29359 U6976/net16 g6573 n5256 VDD pmos W=0.205u L=0.04u
M29360 U6976/net16 g1594 n5256 VDD pmos W=0.205u L=0.04u
M29361 U6976/net22 g6782 U6976/net16 VDD pmos W=0.205u L=0.04u
M29362 U6976/net22 g1597 U6976/net16 VDD pmos W=0.205u L=0.04u
M29363 U6977/p2 n5993 VSS VSS nmos W=0.155u L=0.04u
M29364 U6977/p0 n5437 U6977/p1 VSS nmos W=0.155u L=0.04u
M29365 U6977/p1 n5992 U6977/p2 VSS nmos W=0.155u L=0.04u
M29366 n5981 n4064 U6977/p0 VSS nmos W=0.155u L=0.04u
M29367 n5981 n5992 VDD VDD pmos W=0.205u L=0.04u
M29368 n5981 n5437 VDD VDD pmos W=0.205u L=0.04u
M29369 n5981 n4064 VDD VDD pmos W=0.205u L=0.04u
M29370 n5981 n5993 VDD VDD pmos W=0.205u L=0.04u
M29371 n5993 n5996 VSS VSS nmos W=0.155u L=0.04u
M29372 n5993 n5995 VSS VSS nmos W=0.155u L=0.04u
M29373 n5993 n5994 VSS VSS nmos W=0.155u L=0.04u
M29374 U6978/net25 n5996 VDD VDD pmos W=0.41u L=0.04u
M29375 U6978/net28 n5995 U6978/net25 VDD pmos W=0.41u L=0.04u
M29376 n5993 n5994 U6978/net28 VDD pmos W=0.41u L=0.04u
M29377 U6979/net4 n5351 U6979/net14 VSS nmos W=0.155u L=0.04u
M29378 U6979/net6 U6979/net10 U6979/net14 VSS nmos W=0.17u L=0.04u
M29379 U6979/net4 n5561 VSS VSS nmos W=0.155u L=0.04u
M29380 U6979/net6 U6979/net4 VSS VSS nmos W=0.17u L=0.04u
M29381 n5996 U6979/net14 VSS VSS nmos W=0.155u L=0.04u
M29382 U6979/net10 n5351 VSS VSS nmos W=0.155u L=0.04u
M29383 U6979/net4 U6979/net10 U6979/net14 VDD pmos W=0.255u L=0.04u
M29384 U6979/net6 n5351 U6979/net14 VDD pmos W=0.28u L=0.04u
M29385 U6979/net4 n5561 VDD VDD pmos W=0.205u L=0.04u
M29386 U6979/net6 U6979/net4 VDD VDD pmos W=0.24u L=0.04u
M29387 n5996 U6979/net14 VDD VDD pmos W=0.205u L=0.04u
M29388 U6979/net10 n5351 VDD VDD pmos W=0.205u L=0.04u
M29389 n5561 g1462 VSS VSS nmos W=0.135u L=0.04u
M29390 n5561 g1462 VDD VDD pmos W=0.205u L=0.04u
M29391 n5351 n5296 VSS VSS nmos W=0.135u L=0.04u
M29392 n5351 n5296 VDD VDD pmos W=0.205u L=0.04u
M29393 n5296 g1547 U6982/XI21-net17 VSS nmos W=0.155u L=0.04u
M29394 U6982/XI21-net17 g1618 VSS VSS nmos W=0.155u L=0.04u
M29395 n5296 g6573 U6982/XI6-net17 VSS nmos W=0.155u L=0.04u
M29396 U6982/XI6-net17 g1612 VSS VSS nmos W=0.155u L=0.04u
M29397 n5296 g6782 U6982/XI20-net17 VSS nmos W=0.155u L=0.04u
M29398 U6982/XI20-net17 g1615 VSS VSS nmos W=0.155u L=0.04u
M29399 VDD g1547 U6982/net22 VDD pmos W=0.205u L=0.04u
M29400 VDD g1618 U6982/net22 VDD pmos W=0.205u L=0.04u
M29401 U6982/net16 g6573 n5296 VDD pmos W=0.205u L=0.04u
M29402 U6982/net16 g1612 n5296 VDD pmos W=0.205u L=0.04u
M29403 U6982/net22 g6782 U6982/net16 VDD pmos W=0.205u L=0.04u
M29404 U6982/net22 g1615 U6982/net16 VDD pmos W=0.205u L=0.04u
M29405 U6983/net4 n5400 U6983/net14 VSS nmos W=0.155u L=0.04u
M29406 U6983/net6 U6983/net10 U6983/net14 VSS nmos W=0.17u L=0.04u
M29407 U6983/net4 g1448 VSS VSS nmos W=0.155u L=0.04u
M29408 U6983/net6 U6983/net4 VSS VSS nmos W=0.17u L=0.04u
M29409 n5995 U6983/net14 VSS VSS nmos W=0.155u L=0.04u
M29410 U6983/net10 n5400 VSS VSS nmos W=0.155u L=0.04u
M29411 U6983/net4 U6983/net10 U6983/net14 VDD pmos W=0.255u L=0.04u
M29412 U6983/net6 n5400 U6983/net14 VDD pmos W=0.28u L=0.04u
M29413 U6983/net4 g1448 VDD VDD pmos W=0.205u L=0.04u
M29414 U6983/net6 U6983/net4 VDD VDD pmos W=0.24u L=0.04u
M29415 n5995 U6983/net14 VDD VDD pmos W=0.205u L=0.04u
M29416 U6983/net10 n5400 VDD VDD pmos W=0.205u L=0.04u
M29417 n5400 g1547 U6984/XI21-net17 VSS nmos W=0.155u L=0.04u
M29418 U6984/XI21-net17 g1591 VSS VSS nmos W=0.155u L=0.04u
M29419 n5400 g6573 U6984/XI6-net17 VSS nmos W=0.155u L=0.04u
M29420 U6984/XI6-net17 g1585 VSS VSS nmos W=0.155u L=0.04u
M29421 n5400 g6782 U6984/XI20-net17 VSS nmos W=0.155u L=0.04u
M29422 U6984/XI20-net17 g1588 VSS VSS nmos W=0.155u L=0.04u
M29423 VDD g1547 U6984/net22 VDD pmos W=0.205u L=0.04u
M29424 VDD g1591 U6984/net22 VDD pmos W=0.205u L=0.04u
M29425 U6984/net16 g6573 n5400 VDD pmos W=0.205u L=0.04u
M29426 U6984/net16 g1585 n5400 VDD pmos W=0.205u L=0.04u
M29427 U6984/net22 g6782 U6984/net16 VDD pmos W=0.205u L=0.04u
M29428 U6984/net22 g1588 U6984/net16 VDD pmos W=0.205u L=0.04u
M29429 U6985/net4 n5269 U6985/net14 VSS nmos W=0.155u L=0.04u
M29430 U6985/net6 U6985/net10 U6985/net14 VSS nmos W=0.17u L=0.04u
M29431 U6985/net4 g1466 VSS VSS nmos W=0.155u L=0.04u
M29432 U6985/net6 U6985/net4 VSS VSS nmos W=0.17u L=0.04u
M29433 n5994 U6985/net14 VSS VSS nmos W=0.155u L=0.04u
M29434 U6985/net10 n5269 VSS VSS nmos W=0.155u L=0.04u
M29435 U6985/net4 U6985/net10 U6985/net14 VDD pmos W=0.255u L=0.04u
M29436 U6985/net6 n5269 U6985/net14 VDD pmos W=0.28u L=0.04u
M29437 U6985/net4 g1466 VDD VDD pmos W=0.205u L=0.04u
M29438 U6985/net6 U6985/net4 VDD VDD pmos W=0.24u L=0.04u
M29439 n5994 U6985/net14 VDD VDD pmos W=0.205u L=0.04u
M29440 U6985/net10 n5269 VDD VDD pmos W=0.205u L=0.04u
M29441 n5269 g1547 U6986/XI21-net17 VSS nmos W=0.155u L=0.04u
M29442 U6986/XI21-net17 g1573 VSS VSS nmos W=0.155u L=0.04u
M29443 n5269 g6573 U6986/XI6-net17 VSS nmos W=0.155u L=0.04u
M29444 U6986/XI6-net17 g1567 VSS VSS nmos W=0.155u L=0.04u
M29445 n5269 g6782 U6986/XI20-net17 VSS nmos W=0.155u L=0.04u
M29446 U6986/XI20-net17 g1570 VSS VSS nmos W=0.155u L=0.04u
M29447 VDD g1547 U6986/net22 VDD pmos W=0.205u L=0.04u
M29448 VDD g1573 U6986/net22 VDD pmos W=0.205u L=0.04u
M29449 U6986/net16 g6573 n5269 VDD pmos W=0.205u L=0.04u
M29450 U6986/net16 g1567 n5269 VDD pmos W=0.205u L=0.04u
M29451 U6986/net22 g6782 U6986/net16 VDD pmos W=0.205u L=0.04u
M29452 U6986/net22 g1570 U6986/net16 VDD pmos W=0.205u L=0.04u
M29453 U6987/net4 g1453 U6987/net14 VSS nmos W=0.155u L=0.04u
M29454 U6987/net6 U6987/net10 U6987/net14 VSS nmos W=0.17u L=0.04u
M29455 U6987/net4 n5352 VSS VSS nmos W=0.155u L=0.04u
M29456 U6987/net6 U6987/net4 VSS VSS nmos W=0.17u L=0.04u
M29457 n5992 U6987/net14 VSS VSS nmos W=0.155u L=0.04u
M29458 U6987/net10 g1453 VSS VSS nmos W=0.155u L=0.04u
M29459 U6987/net4 U6987/net10 U6987/net14 VDD pmos W=0.255u L=0.04u
M29460 U6987/net6 g1453 U6987/net14 VDD pmos W=0.28u L=0.04u
M29461 U6987/net4 n5352 VDD VDD pmos W=0.205u L=0.04u
M29462 U6987/net6 U6987/net4 VDD VDD pmos W=0.24u L=0.04u
M29463 n5992 U6987/net14 VDD VDD pmos W=0.205u L=0.04u
M29464 U6987/net10 g1453 VDD VDD pmos W=0.205u L=0.04u
M29465 n5352 n5287 VSS VSS nmos W=0.135u L=0.04u
M29466 n5352 n5287 VDD VDD pmos W=0.205u L=0.04u
M29467 n5287 g1547 U6989/XI21-net17 VSS nmos W=0.155u L=0.04u
M29468 U6989/XI21-net17 g1627 VSS VSS nmos W=0.155u L=0.04u
M29469 n5287 g6573 U6989/XI6-net17 VSS nmos W=0.155u L=0.04u
M29470 U6989/XI6-net17 g1621 VSS VSS nmos W=0.155u L=0.04u
M29471 n5287 g6782 U6989/XI20-net17 VSS nmos W=0.155u L=0.04u
M29472 U6989/XI20-net17 g1624 VSS VSS nmos W=0.155u L=0.04u
M29473 VDD g1547 U6989/net22 VDD pmos W=0.205u L=0.04u
M29474 VDD g1627 U6989/net22 VDD pmos W=0.205u L=0.04u
M29475 U6989/net16 g6573 n5287 VDD pmos W=0.205u L=0.04u
M29476 U6989/net16 g1621 n5287 VDD pmos W=0.205u L=0.04u
M29477 U6989/net22 g6782 U6989/net16 VDD pmos W=0.205u L=0.04u
M29478 U6989/net22 g1624 U6989/net16 VDD pmos W=0.205u L=0.04u
M29479 U6990/XU1-net6 n5315 VSS VSS nmos W=0.155u L=0.04u
M29480 n4064 n5320 U6990/XU1-net6 VSS nmos W=0.155u L=0.04u
M29481 n4064 n5315 VDD VDD pmos W=0.155u L=0.04u
M29482 n4064 n5320 VDD VDD pmos W=0.155u L=0.04u
M29483 n5315 n4334 U6991/net27 VSS nmos W=0.155u L=0.04u
M29484 U6991/net39 n5192 VSS VSS nmos W=0.155u L=0.04u
M29485 U6991/net27 g1699 U6991/net39 VSS nmos W=0.155u L=0.04u
M29486 U6991/net27 n5191 U6991/net39 VSS nmos W=0.155u L=0.04u
M29487 n5315 g1700 U6991/net27 VSS nmos W=0.155u L=0.04u
M29488 U6991/net39 g1701 VSS VSS nmos W=0.155u L=0.04u
M29489 n5315 n5192 U6991/net46 VDD pmos W=0.205u L=0.04u
M29490 U6991/net46 g1701 VDD VDD pmos W=0.205u L=0.04u
M29491 n5315 g1700 U6991/net34 VDD pmos W=0.205u L=0.04u
M29492 U6991/net34 n4334 VDD VDD pmos W=0.205u L=0.04u
M29493 n5315 n5191 U6991/net37 VDD pmos W=0.205u L=0.04u
M29494 U6991/net37 g1699 VDD VDD pmos W=0.205u L=0.04u
M29495 n5320 n5249 VSS VSS nmos W=0.155u L=0.04u
M29496 n5320 n5316 VSS VSS nmos W=0.155u L=0.04u
M29497 U6992/XI1-net8 n5316 VDD VDD pmos W=0.205u L=0.04u
M29498 n5320 n5249 U6992/XI1-net8 VDD pmos W=0.205u L=0.04u
M29499 n5316 n5314 VSS VSS nmos W=0.135u L=0.04u
M29500 n5316 n5314 VDD VDD pmos W=0.205u L=0.04u
M29501 n5314 n4334 U6994/net27 VSS nmos W=0.155u L=0.04u
M29502 U6994/net39 n5192 VSS VSS nmos W=0.155u L=0.04u
M29503 U6994/net27 g1696 U6994/net39 VSS nmos W=0.155u L=0.04u
M29504 U6994/net27 n5191 U6994/net39 VSS nmos W=0.155u L=0.04u
M29505 n5314 g1697 U6994/net27 VSS nmos W=0.155u L=0.04u
M29506 U6994/net39 g1698 VSS VSS nmos W=0.155u L=0.04u
M29507 n5314 n5192 U6994/net46 VDD pmos W=0.205u L=0.04u
M29508 U6994/net46 g1698 VDD VDD pmos W=0.205u L=0.04u
M29509 n5314 g1697 U6994/net34 VDD pmos W=0.205u L=0.04u
M29510 U6994/net34 n4334 VDD VDD pmos W=0.205u L=0.04u
M29511 n5314 n5191 U6994/net37 VDD pmos W=0.205u L=0.04u
M29512 U6994/net37 g1696 VDD VDD pmos W=0.205u L=0.04u
M29513 n5249 n4334 U6995/net27 VSS nmos W=0.155u L=0.04u
M29514 U6995/net39 n5192 VSS VSS nmos W=0.155u L=0.04u
M29515 U6995/net27 g1693 U6995/net39 VSS nmos W=0.155u L=0.04u
M29516 U6995/net27 n5191 U6995/net39 VSS nmos W=0.155u L=0.04u
M29517 n5249 g1694 U6995/net27 VSS nmos W=0.155u L=0.04u
M29518 U6995/net39 g1695 VSS VSS nmos W=0.155u L=0.04u
M29519 n5249 n5192 U6995/net46 VDD pmos W=0.205u L=0.04u
M29520 U6995/net46 g1695 VDD VDD pmos W=0.205u L=0.04u
M29521 n5249 g1694 U6995/net34 VDD pmos W=0.205u L=0.04u
M29522 U6995/net34 n4334 VDD VDD pmos W=0.205u L=0.04u
M29523 n5249 n5191 U6995/net37 VDD pmos W=0.205u L=0.04u
M29524 U6995/net37 g1693 VDD VDD pmos W=0.205u L=0.04u
M29525 n5192 g1782 VSS VSS nmos W=0.135u L=0.04u
M29526 n5192 g1782 VDD VDD pmos W=0.205u L=0.04u
M29527 n5191 g5511 VSS VSS nmos W=0.135u L=0.04u
M29528 n5191 g5511 VDD VDD pmos W=0.205u L=0.04u
M29529 n4334 g7014 VSS VSS nmos W=0.135u L=0.04u
M29530 n4334 g7014 VDD VDD pmos W=0.205u L=0.04u
M29531 N1764 n5997 U6999/net14 VSS nmos W=0.155u L=0.04u
M29532 U6999/net14 n6000 VSS VSS nmos W=0.155u L=0.04u
M29533 U6999/net14 n5182 VSS VSS nmos W=0.155u L=0.04u
M29534 N1764 n5999 U6999/net14 VSS nmos W=0.155u L=0.04u
M29535 N1764 n5998 U6999/net14 VSS nmos W=0.155u L=0.04u
M29536 N1764 n6000 U6999/XI16-net11 VDD pmos W=0.205u L=0.04u
M29537 U6999/XI16-net11 n5182 VDD VDD pmos W=0.205u L=0.04u
M29538 N1764 n5999 U6999/XI15-net11 VDD pmos W=0.205u L=0.04u
M29539 U6999/XI15-net11 n5998 U6999/XI15-net18 VDD pmos W=0.205u L=0.04u
M29540 U6999/XI15-net18 n5997 VDD VDD pmos W=0.205u L=0.04u
M29541 n6000 n4170 VSS VSS nmos W=0.135u L=0.04u
M29542 n6000 n4170 VDD VDD pmos W=0.205u L=0.04u
M29543 n4170 n5094 VSS VSS nmos W=0.155u L=0.04u
M29544 n4170 n5028 VSS VSS nmos W=0.155u L=0.04u
M29545 n4170 n5095 VSS VSS nmos W=0.155u L=0.04u
M29546 U7001/net25 n5094 VDD VDD pmos W=0.41u L=0.04u
M29547 U7001/net28 n5028 U7001/net25 VDD pmos W=0.41u L=0.04u
M29548 n4170 n5095 U7001/net28 VDD pmos W=0.41u L=0.04u
M29549 U7002/p2 n6001 VSS VSS nmos W=0.155u L=0.04u
M29550 U7002/p0 n5057 U7002/p1 VSS nmos W=0.155u L=0.04u
M29551 U7002/p1 n5179 U7002/p2 VSS nmos W=0.155u L=0.04u
M29552 n5182 n5069 U7002/p0 VSS nmos W=0.155u L=0.04u
M29553 n5182 n5179 VDD VDD pmos W=0.205u L=0.04u
M29554 n5182 n5057 VDD VDD pmos W=0.205u L=0.04u
M29555 n5182 n5069 VDD VDD pmos W=0.205u L=0.04u
M29556 n5182 n6001 VDD VDD pmos W=0.205u L=0.04u
M29557 n6001 n5131 VSS VSS nmos W=0.155u L=0.04u
M29558 n6001 n5052 VSS VSS nmos W=0.155u L=0.04u
M29559 n6001 n5130 VSS VSS nmos W=0.155u L=0.04u
M29560 U7003/net25 n5131 VDD VDD pmos W=0.41u L=0.04u
M29561 U7003/net28 n5052 U7003/net25 VDD pmos W=0.41u L=0.04u
M29562 n6001 n5130 U7003/net28 VDD pmos W=0.41u L=0.04u
M29563 n5052 n5181 VSS VSS nmos W=0.135u L=0.04u
M29564 n5052 n5181 VDD VDD pmos W=0.205u L=0.04u
M29565 n5179 U7005/net6 VSS VSS nmos W=0.155u L=0.04u
M29566 U7005/net6 n6002 U7005/XU30-net23 VSS nmos W=0.155u L=0.04u
M29567 U7005/XU30-net23 n5063 U7005/XU30-net26 VSS nmos W=0.155u L=0.04u
M29568 U7005/XU30-net26 n6003 U7005/XU30-net29 VSS nmos W=0.155u L=0.04u
M29569 U7005/XU30-net29 n5129 VSS VSS nmos W=0.155u L=0.04u
M29570 n5179 U7005/net6 VDD VDD pmos W=0.205u L=0.04u
M29571 U7005/net6 n5129 VDD VDD pmos W=0.205u L=0.04u
M29572 U7005/net6 n6003 VDD VDD pmos W=0.205u L=0.04u
M29573 U7005/net6 n5063 VDD VDD pmos W=0.205u L=0.04u
M29574 U7005/net6 n6002 VDD VDD pmos W=0.205u L=0.04u
M29575 n6003 n5064 VSS VSS nmos W=0.155u L=0.04u
M29576 n6003 n5132 VSS VSS nmos W=0.155u L=0.04u
M29577 U7006/XI1-net8 n5132 VDD VDD pmos W=0.205u L=0.04u
M29578 n6003 n5064 U7006/XI1-net8 VDD pmos W=0.205u L=0.04u
M29579 n5064 n5125 VSS VSS nmos W=0.135u L=0.04u
M29580 n5064 n5125 VDD VDD pmos W=0.205u L=0.04u
M29581 n5999 n6004 U7008/XI0-net10 VSS nmos W=0.155u L=0.04u
M29582 U7008/XI0-net10 n6005 U7008/XI0-net13 VSS nmos W=0.155u L=0.04u
M29583 U7008/XI0-net13 n6006 VSS VSS nmos W=0.155u L=0.04u
M29584 n5999 n6006 VDD VDD pmos W=0.205u L=0.04u
M29585 n5999 n6004 VDD VDD pmos W=0.205u L=0.04u
M29586 n5999 n6005 VDD VDD pmos W=0.205u L=0.04u
M29587 U7009/net4 g780 U7009/net14 VSS nmos W=0.155u L=0.04u
M29588 U7009/net6 U7009/net10 U7009/net14 VSS nmos W=0.17u L=0.04u
M29589 U7009/net4 n5048 VSS VSS nmos W=0.155u L=0.04u
M29590 U7009/net6 U7009/net4 VSS VSS nmos W=0.17u L=0.04u
M29591 n6006 U7009/net14 VSS VSS nmos W=0.155u L=0.04u
M29592 U7009/net10 g780 VSS VSS nmos W=0.155u L=0.04u
M29593 U7009/net4 U7009/net10 U7009/net14 VDD pmos W=0.255u L=0.04u
M29594 U7009/net6 g780 U7009/net14 VDD pmos W=0.28u L=0.04u
M29595 U7009/net4 n5048 VDD VDD pmos W=0.205u L=0.04u
M29596 U7009/net6 U7009/net4 VDD VDD pmos W=0.24u L=0.04u
M29597 n6006 U7009/net14 VDD VDD pmos W=0.205u L=0.04u
M29598 U7009/net10 g780 VDD VDD pmos W=0.205u L=0.04u
M29599 n5048 n5129 VSS VSS nmos W=0.135u L=0.04u
M29600 n5048 n5129 VDD VDD pmos W=0.205u L=0.04u
M29601 n5129 g6368 U7011/XI21-net17 VSS nmos W=0.155u L=0.04u
M29602 U7011/XI21-net17 g873 VSS VSS nmos W=0.155u L=0.04u
M29603 n5129 g6518 U7011/XI6-net17 VSS nmos W=0.155u L=0.04u
M29604 U7011/XI6-net17 g876 VSS VSS nmos W=0.155u L=0.04u
M29605 n5129 g853 U7011/XI20-net17 VSS nmos W=0.155u L=0.04u
M29606 U7011/XI20-net17 g879 VSS VSS nmos W=0.155u L=0.04u
M29607 VDD g6368 U7011/net22 VDD pmos W=0.205u L=0.04u
M29608 VDD g873 U7011/net22 VDD pmos W=0.205u L=0.04u
M29609 U7011/net16 g6518 n5129 VDD pmos W=0.205u L=0.04u
M29610 U7011/net16 g876 n5129 VDD pmos W=0.205u L=0.04u
M29611 U7011/net22 g853 U7011/net16 VDD pmos W=0.205u L=0.04u
M29612 U7011/net22 g879 U7011/net16 VDD pmos W=0.205u L=0.04u
M29613 U7012/net4 g762 U7012/net14 VSS nmos W=0.155u L=0.04u
M29614 U7012/net6 U7012/net10 U7012/net14 VSS nmos W=0.17u L=0.04u
M29615 U7012/net4 n5044 VSS VSS nmos W=0.155u L=0.04u
M29616 U7012/net6 U7012/net4 VSS VSS nmos W=0.17u L=0.04u
M29617 n6005 U7012/net14 VSS VSS nmos W=0.155u L=0.04u
M29618 U7012/net10 g762 VSS VSS nmos W=0.155u L=0.04u
M29619 U7012/net4 U7012/net10 U7012/net14 VDD pmos W=0.255u L=0.04u
M29620 U7012/net6 g762 U7012/net14 VDD pmos W=0.28u L=0.04u
M29621 U7012/net4 n5044 VDD VDD pmos W=0.205u L=0.04u
M29622 U7012/net6 U7012/net4 VDD VDD pmos W=0.24u L=0.04u
M29623 n6005 U7012/net14 VDD VDD pmos W=0.205u L=0.04u
M29624 U7012/net10 g762 VDD VDD pmos W=0.205u L=0.04u
M29625 n5044 n6002 VSS VSS nmos W=0.135u L=0.04u
M29626 n5044 n6002 VDD VDD pmos W=0.205u L=0.04u
M29627 n6002 g6368 U7014/XI21-net17 VSS nmos W=0.155u L=0.04u
M29628 U7014/XI21-net17 g891 VSS VSS nmos W=0.155u L=0.04u
M29629 n6002 g6518 U7014/XI6-net17 VSS nmos W=0.155u L=0.04u
M29630 U7014/XI6-net17 g894 VSS VSS nmos W=0.155u L=0.04u
M29631 n6002 g853 U7014/XI20-net17 VSS nmos W=0.155u L=0.04u
M29632 U7014/XI20-net17 g897 VSS VSS nmos W=0.155u L=0.04u
M29633 VDD g6368 U7014/net22 VDD pmos W=0.205u L=0.04u
M29634 VDD g891 U7014/net22 VDD pmos W=0.205u L=0.04u
M29635 U7014/net16 g6518 n6002 VDD pmos W=0.205u L=0.04u
M29636 U7014/net16 g894 n6002 VDD pmos W=0.205u L=0.04u
M29637 U7014/net22 g853 U7014/net16 VDD pmos W=0.205u L=0.04u
M29638 U7014/net22 g897 U7014/net16 VDD pmos W=0.205u L=0.04u
M29639 U7015/net4 g776 U7015/net14 VSS nmos W=0.155u L=0.04u
M29640 U7015/net6 U7015/net10 U7015/net14 VSS nmos W=0.17u L=0.04u
M29641 U7015/net4 n5130 VSS VSS nmos W=0.155u L=0.04u
M29642 U7015/net6 U7015/net4 VSS VSS nmos W=0.17u L=0.04u
M29643 n6004 U7015/net14 VSS VSS nmos W=0.155u L=0.04u
M29644 U7015/net10 g776 VSS VSS nmos W=0.155u L=0.04u
M29645 U7015/net4 U7015/net10 U7015/net14 VDD pmos W=0.255u L=0.04u
M29646 U7015/net6 g776 U7015/net14 VDD pmos W=0.28u L=0.04u
M29647 U7015/net4 n5130 VDD VDD pmos W=0.205u L=0.04u
M29648 U7015/net6 U7015/net4 VDD VDD pmos W=0.24u L=0.04u
M29649 n6004 U7015/net14 VDD VDD pmos W=0.205u L=0.04u
M29650 U7015/net10 g776 VDD VDD pmos W=0.205u L=0.04u
M29651 n5130 n5077 VSS VSS nmos W=0.135u L=0.04u
M29652 n5130 n5077 VDD VDD pmos W=0.205u L=0.04u
M29653 n5077 g6368 U7017/XI21-net17 VSS nmos W=0.155u L=0.04u
M29654 U7017/XI21-net17 g918 VSS VSS nmos W=0.155u L=0.04u
M29655 n5077 g6518 U7017/XI6-net17 VSS nmos W=0.155u L=0.04u
M29656 U7017/XI6-net17 g921 VSS VSS nmos W=0.155u L=0.04u
M29657 n5077 g853 U7017/XI20-net17 VSS nmos W=0.155u L=0.04u
M29658 U7017/XI20-net17 g924 VSS VSS nmos W=0.155u L=0.04u
M29659 VDD g6368 U7017/net22 VDD pmos W=0.205u L=0.04u
M29660 VDD g918 U7017/net22 VDD pmos W=0.205u L=0.04u
M29661 U7017/net16 g6518 n5077 VDD pmos W=0.205u L=0.04u
M29662 U7017/net16 g921 n5077 VDD pmos W=0.205u L=0.04u
M29663 U7017/net22 g853 U7017/net16 VDD pmos W=0.205u L=0.04u
M29664 U7017/net22 g924 U7017/net16 VDD pmos W=0.205u L=0.04u
M29665 n5998 n4172 U7018/XI0-net10 VSS nmos W=0.155u L=0.04u
M29666 U7018/XI0-net10 n5437 U7018/XI0-net13 VSS nmos W=0.155u L=0.04u
M29667 U7018/XI0-net13 n6007 VSS VSS nmos W=0.155u L=0.04u
M29668 n5998 n6007 VDD VDD pmos W=0.205u L=0.04u
M29669 n5998 n4172 VDD VDD pmos W=0.205u L=0.04u
M29670 n5998 n5437 VDD VDD pmos W=0.205u L=0.04u
M29671 U7019/net4 g767 U7019/net14 VSS nmos W=0.155u L=0.04u
M29672 U7019/net6 U7019/net10 U7019/net14 VSS nmos W=0.17u L=0.04u
M29673 U7019/net4 n5131 VSS VSS nmos W=0.155u L=0.04u
M29674 U7019/net6 U7019/net4 VSS VSS nmos W=0.17u L=0.04u
M29675 n6007 U7019/net14 VSS VSS nmos W=0.155u L=0.04u
M29676 U7019/net10 g767 VSS VSS nmos W=0.155u L=0.04u
M29677 U7019/net4 U7019/net10 U7019/net14 VDD pmos W=0.255u L=0.04u
M29678 U7019/net6 g767 U7019/net14 VDD pmos W=0.28u L=0.04u
M29679 U7019/net4 n5131 VDD VDD pmos W=0.205u L=0.04u
M29680 U7019/net6 U7019/net4 VDD VDD pmos W=0.24u L=0.04u
M29681 n6007 U7019/net14 VDD VDD pmos W=0.205u L=0.04u
M29682 U7019/net10 g767 VDD VDD pmos W=0.205u L=0.04u
M29683 n5131 n5068 VSS VSS nmos W=0.135u L=0.04u
M29684 n5131 n5068 VDD VDD pmos W=0.205u L=0.04u
M29685 n5068 g6368 U7021/XI21-net17 VSS nmos W=0.155u L=0.04u
M29686 U7021/XI21-net17 g927 VSS VSS nmos W=0.155u L=0.04u
M29687 n5068 g6518 U7021/XI6-net17 VSS nmos W=0.155u L=0.04u
M29688 U7021/XI6-net17 g930 VSS VSS nmos W=0.155u L=0.04u
M29689 n5068 g853 U7021/XI20-net17 VSS nmos W=0.155u L=0.04u
M29690 U7021/XI20-net17 g933 VSS VSS nmos W=0.155u L=0.04u
M29691 VDD g6368 U7021/net22 VDD pmos W=0.205u L=0.04u
M29692 VDD g927 U7021/net22 VDD pmos W=0.205u L=0.04u
M29693 U7021/net16 g6518 n5068 VDD pmos W=0.205u L=0.04u
M29694 U7021/net16 g930 n5068 VDD pmos W=0.205u L=0.04u
M29695 U7021/net22 g853 U7021/net16 VDD pmos W=0.205u L=0.04u
M29696 U7021/net22 g933 U7021/net16 VDD pmos W=0.205u L=0.04u
M29697 U7022/XU1-net6 n5095 VSS VSS nmos W=0.155u L=0.04u
M29698 n4172 n5100 U7022/XU1-net6 VSS nmos W=0.155u L=0.04u
M29699 n4172 n5095 VDD VDD pmos W=0.155u L=0.04u
M29700 n4172 n5100 VDD VDD pmos W=0.155u L=0.04u
M29701 n5095 n4333 U7023/net27 VSS nmos W=0.155u L=0.04u
M29702 U7023/net39 n4971 VSS VSS nmos W=0.155u L=0.04u
M29703 U7023/net27 g1005 U7023/net39 VSS nmos W=0.155u L=0.04u
M29704 U7023/net27 n4970 U7023/net39 VSS nmos W=0.155u L=0.04u
M29705 n5095 g1006 U7023/net27 VSS nmos W=0.155u L=0.04u
M29706 U7023/net39 g1007 VSS VSS nmos W=0.155u L=0.04u
M29707 n5095 n4971 U7023/net46 VDD pmos W=0.205u L=0.04u
M29708 U7023/net46 g1007 VDD VDD pmos W=0.205u L=0.04u
M29709 n5095 g1006 U7023/net34 VDD pmos W=0.205u L=0.04u
M29710 U7023/net34 n4333 VDD VDD pmos W=0.205u L=0.04u
M29711 n5095 n4970 U7023/net37 VDD pmos W=0.205u L=0.04u
M29712 U7023/net37 g1005 VDD VDD pmos W=0.205u L=0.04u
M29713 n5100 n5028 VSS VSS nmos W=0.155u L=0.04u
M29714 n5100 n5096 VSS VSS nmos W=0.155u L=0.04u
M29715 U7024/XI1-net8 n5096 VDD VDD pmos W=0.205u L=0.04u
M29716 n5100 n5028 U7024/XI1-net8 VDD pmos W=0.205u L=0.04u
M29717 n5096 n5094 VSS VSS nmos W=0.135u L=0.04u
M29718 n5096 n5094 VDD VDD pmos W=0.205u L=0.04u
M29719 n5094 n4333 U7026/net27 VSS nmos W=0.155u L=0.04u
M29720 U7026/net39 n4971 VSS VSS nmos W=0.155u L=0.04u
M29721 U7026/net27 g1002 U7026/net39 VSS nmos W=0.155u L=0.04u
M29722 U7026/net27 n4970 U7026/net39 VSS nmos W=0.155u L=0.04u
M29723 n5094 g1003 U7026/net27 VSS nmos W=0.155u L=0.04u
M29724 U7026/net39 g1004 VSS VSS nmos W=0.155u L=0.04u
M29725 n5094 n4971 U7026/net46 VDD pmos W=0.205u L=0.04u
M29726 U7026/net46 g1004 VDD VDD pmos W=0.205u L=0.04u
M29727 n5094 g1003 U7026/net34 VDD pmos W=0.205u L=0.04u
M29728 U7026/net34 n4333 VDD VDD pmos W=0.205u L=0.04u
M29729 n5094 n4970 U7026/net37 VDD pmos W=0.205u L=0.04u
M29730 U7026/net37 g1002 VDD VDD pmos W=0.205u L=0.04u
M29731 n5028 n4971 U7027/net27 VSS nmos W=0.155u L=0.04u
M29732 U7027/net39 n4970 VSS VSS nmos W=0.155u L=0.04u
M29733 U7027/net27 g1000 U7027/net39 VSS nmos W=0.155u L=0.04u
M29734 U7027/net27 n4333 U7027/net39 VSS nmos W=0.155u L=0.04u
M29735 n5028 g1001 U7027/net27 VSS nmos W=0.155u L=0.04u
M29736 U7027/net39 g999 VSS VSS nmos W=0.155u L=0.04u
M29737 n5028 n4970 U7027/net46 VDD pmos W=0.205u L=0.04u
M29738 U7027/net46 g999 VDD VDD pmos W=0.205u L=0.04u
M29739 n5028 g1001 U7027/net34 VDD pmos W=0.205u L=0.04u
M29740 U7027/net34 n4971 VDD VDD pmos W=0.205u L=0.04u
M29741 n5028 n4333 U7027/net37 VDD pmos W=0.205u L=0.04u
M29742 U7027/net37 g1000 VDD VDD pmos W=0.205u L=0.04u
M29743 n4970 g5472 VSS VSS nmos W=0.135u L=0.04u
M29744 n4970 g5472 VDD VDD pmos W=0.205u L=0.04u
M29745 n4333 g6712 VSS VSS nmos W=0.135u L=0.04u
M29746 n4333 g6712 VDD VDD pmos W=0.205u L=0.04u
M29747 n4971 g1088 VSS VSS nmos W=0.135u L=0.04u
M29748 n4971 g1088 VDD VDD pmos W=0.205u L=0.04u
M29749 U7031/p2 n6011 VSS VSS nmos W=0.155u L=0.04u
M29750 U7031/p0 n6009 U7031/p1 VSS nmos W=0.155u L=0.04u
M29751 U7031/p1 n6010 U7031/p2 VSS nmos W=0.155u L=0.04u
M29752 n5997 n6008 U7031/p0 VSS nmos W=0.155u L=0.04u
M29753 n5997 n6010 VDD VDD pmos W=0.205u L=0.04u
M29754 n5997 n6009 VDD VDD pmos W=0.205u L=0.04u
M29755 n5997 n6008 VDD VDD pmos W=0.205u L=0.04u
M29756 n5997 n6011 VDD VDD pmos W=0.205u L=0.04u
M29757 n6011 n6014 VSS VSS nmos W=0.155u L=0.04u
M29758 n6011 n6013 VSS VSS nmos W=0.155u L=0.04u
M29759 n6011 n6012 VSS VSS nmos W=0.155u L=0.04u
M29760 U7032/net25 n6014 VDD VDD pmos W=0.41u L=0.04u
M29761 U7032/net28 n6013 U7032/net25 VDD pmos W=0.41u L=0.04u
M29762 n6011 n6012 U7032/net28 VDD pmos W=0.41u L=0.04u
M29763 U7033/net4 n5181 U7033/net14 VSS nmos W=0.155u L=0.04u
M29764 U7033/net6 U7033/net10 U7033/net14 VSS nmos W=0.17u L=0.04u
M29765 U7033/net4 g740 VSS VSS nmos W=0.155u L=0.04u
M29766 U7033/net6 U7033/net4 VSS VSS nmos W=0.17u L=0.04u
M29767 n6014 U7033/net14 VSS VSS nmos W=0.155u L=0.04u
M29768 U7033/net10 n5181 VSS VSS nmos W=0.155u L=0.04u
M29769 U7033/net4 U7033/net10 U7033/net14 VDD pmos W=0.255u L=0.04u
M29770 U7033/net6 n5181 U7033/net14 VDD pmos W=0.28u L=0.04u
M29771 U7033/net4 g740 VDD VDD pmos W=0.205u L=0.04u
M29772 U7033/net6 U7033/net4 VDD VDD pmos W=0.24u L=0.04u
M29773 n6014 U7033/net14 VDD VDD pmos W=0.205u L=0.04u
M29774 U7033/net10 n5181 VDD VDD pmos W=0.205u L=0.04u
M29775 n5181 g6368 U7034/XI21-net17 VSS nmos W=0.155u L=0.04u
M29776 U7034/XI21-net17 g954 VSS VSS nmos W=0.155u L=0.04u
M29777 n5181 g6518 U7034/XI6-net17 VSS nmos W=0.155u L=0.04u
M29778 U7034/XI6-net17 g957 VSS VSS nmos W=0.155u L=0.04u
M29779 n5181 g853 U7034/XI20-net17 VSS nmos W=0.155u L=0.04u
M29780 U7034/XI20-net17 g960 VSS VSS nmos W=0.155u L=0.04u
M29781 VDD g6368 U7034/net22 VDD pmos W=0.205u L=0.04u
M29782 VDD g954 U7034/net22 VDD pmos W=0.205u L=0.04u
M29783 U7034/net16 g6518 n5181 VDD pmos W=0.205u L=0.04u
M29784 U7034/net16 g957 n5181 VDD pmos W=0.205u L=0.04u
M29785 U7034/net22 g853 U7034/net16 VDD pmos W=0.205u L=0.04u
M29786 U7034/net22 g960 U7034/net16 VDD pmos W=0.205u L=0.04u
M29787 U7035/net4 n5125 U7035/net14 VSS nmos W=0.155u L=0.04u
M29788 U7035/net6 U7035/net10 U7035/net14 VSS nmos W=0.17u L=0.04u
M29789 U7035/net4 g749 VSS VSS nmos W=0.155u L=0.04u
M29790 U7035/net6 U7035/net4 VSS VSS nmos W=0.17u L=0.04u
M29791 n6013 U7035/net14 VSS VSS nmos W=0.155u L=0.04u
M29792 U7035/net10 n5125 VSS VSS nmos W=0.155u L=0.04u
M29793 U7035/net4 U7035/net10 U7035/net14 VDD pmos W=0.255u L=0.04u
M29794 U7035/net6 n5125 U7035/net14 VDD pmos W=0.28u L=0.04u
M29795 U7035/net4 g749 VDD VDD pmos W=0.205u L=0.04u
M29796 U7035/net6 U7035/net4 VDD VDD pmos W=0.24u L=0.04u
M29797 n6013 U7035/net14 VDD VDD pmos W=0.205u L=0.04u
M29798 U7035/net10 n5125 VDD VDD pmos W=0.205u L=0.04u
M29799 n5125 g6368 U7036/XI21-net17 VSS nmos W=0.155u L=0.04u
M29800 U7036/XI21-net17 g945 VSS VSS nmos W=0.155u L=0.04u
M29801 n5125 g6518 U7036/XI6-net17 VSS nmos W=0.155u L=0.04u
M29802 U7036/XI6-net17 g948 VSS VSS nmos W=0.155u L=0.04u
M29803 n5125 g853 U7036/XI20-net17 VSS nmos W=0.155u L=0.04u
M29804 U7036/XI20-net17 g951 VSS VSS nmos W=0.155u L=0.04u
M29805 VDD g6368 U7036/net22 VDD pmos W=0.205u L=0.04u
M29806 VDD g945 U7036/net22 VDD pmos W=0.205u L=0.04u
M29807 U7036/net16 g6518 n5125 VDD pmos W=0.205u L=0.04u
M29808 U7036/net16 g948 n5125 VDD pmos W=0.205u L=0.04u
M29809 U7036/net22 g853 U7036/net16 VDD pmos W=0.205u L=0.04u
M29810 U7036/net22 g951 U7036/net16 VDD pmos W=0.205u L=0.04u
M29811 U7037/net4 n5132 U7037/net14 VSS nmos W=0.155u L=0.04u
M29812 U7037/net6 U7037/net10 U7037/net14 VSS nmos W=0.17u L=0.04u
M29813 U7037/net4 n5532 VSS VSS nmos W=0.155u L=0.04u
M29814 U7037/net6 U7037/net4 VSS VSS nmos W=0.17u L=0.04u
M29815 n6012 U7037/net14 VSS VSS nmos W=0.155u L=0.04u
M29816 U7037/net10 n5132 VSS VSS nmos W=0.155u L=0.04u
M29817 U7037/net4 U7037/net10 U7037/net14 VDD pmos W=0.255u L=0.04u
M29818 U7037/net6 n5132 U7037/net14 VDD pmos W=0.28u L=0.04u
M29819 U7037/net4 n5532 VDD VDD pmos W=0.205u L=0.04u
M29820 U7037/net6 U7037/net4 VDD VDD pmos W=0.24u L=0.04u
M29821 n6012 U7037/net14 VDD VDD pmos W=0.205u L=0.04u
M29822 U7037/net10 n5132 VDD VDD pmos W=0.205u L=0.04u
M29823 n5532 g758 VSS VSS nmos W=0.135u L=0.04u
M29824 n5532 g758 VDD VDD pmos W=0.205u L=0.04u
M29825 n5132 n5039 VSS VSS nmos W=0.135u L=0.04u
M29826 n5132 n5039 VDD VDD pmos W=0.205u L=0.04u
M29827 n5039 g6368 U7040/XI21-net17 VSS nmos W=0.155u L=0.04u
M29828 U7040/XI21-net17 g936 VSS VSS nmos W=0.155u L=0.04u
M29829 n5039 g6518 U7040/XI6-net17 VSS nmos W=0.155u L=0.04u
M29830 U7040/XI6-net17 g939 VSS VSS nmos W=0.155u L=0.04u
M29831 n5039 g853 U7040/XI20-net17 VSS nmos W=0.155u L=0.04u
M29832 U7040/XI20-net17 g942 VSS VSS nmos W=0.155u L=0.04u
M29833 VDD g6368 U7040/net22 VDD pmos W=0.205u L=0.04u
M29834 VDD g936 U7040/net22 VDD pmos W=0.205u L=0.04u
M29835 U7040/net16 g6518 n5039 VDD pmos W=0.205u L=0.04u
M29836 U7040/net16 g939 n5039 VDD pmos W=0.205u L=0.04u
M29837 U7040/net22 g853 U7040/net16 VDD pmos W=0.205u L=0.04u
M29838 U7040/net22 g942 U7040/net16 VDD pmos W=0.205u L=0.04u
M29839 U7041/net4 U7041/net10 U7041/net14 VSS nmos W=0.155u L=0.04u
M29840 U7041/net6 g771 U7041/net14 VSS nmos W=0.155u L=0.04u
M29841 U7041/net4 n5069 VSS VSS nmos W=0.155u L=0.04u
M29842 U7041/net6 U7041/net4 VSS VSS nmos W=0.155u L=0.04u
M29843 n6010 U7041/net14 VSS VSS nmos W=0.155u L=0.04u
M29844 U7041/net10 g771 VSS VSS nmos W=0.155u L=0.04u
M29845 U7041/net4 g771 U7041/net14 VDD pmos W=0.205u L=0.04u
M29846 U7041/net6 U7041/net10 U7041/net14 VDD pmos W=0.205u L=0.04u
M29847 U7041/net4 n5069 VDD VDD pmos W=0.205u L=0.04u
M29848 U7041/net6 U7041/net4 VDD VDD pmos W=0.205u L=0.04u
M29849 n6010 U7041/net14 VDD VDD pmos W=0.205u L=0.04u
M29850 U7041/net10 g771 VDD VDD pmos W=0.205u L=0.04u
M29851 n5069 g6368 U7042/XI21-net17 VSS nmos W=0.155u L=0.04u
M29852 U7042/XI21-net17 g882 VSS VSS nmos W=0.155u L=0.04u
M29853 n5069 g6518 U7042/XI6-net17 VSS nmos W=0.155u L=0.04u
M29854 U7042/XI6-net17 g885 VSS VSS nmos W=0.155u L=0.04u
M29855 n5069 g853 U7042/XI20-net17 VSS nmos W=0.155u L=0.04u
M29856 U7042/XI20-net17 g888 VSS VSS nmos W=0.155u L=0.04u
M29857 VDD g6368 U7042/net22 VDD pmos W=0.205u L=0.04u
M29858 VDD g882 U7042/net22 VDD pmos W=0.205u L=0.04u
M29859 U7042/net16 g6518 n5069 VDD pmos W=0.205u L=0.04u
M29860 U7042/net16 g885 n5069 VDD pmos W=0.205u L=0.04u
M29861 U7042/net22 g853 U7042/net16 VDD pmos W=0.205u L=0.04u
M29862 U7042/net22 g888 U7042/net16 VDD pmos W=0.205u L=0.04u
M29863 U7043/net4 n5527 U7043/net14 VSS nmos W=0.155u L=0.04u
M29864 U7043/net6 U7043/net10 U7043/net14 VSS nmos W=0.17u L=0.04u
M29865 U7043/net4 n5057 VSS VSS nmos W=0.155u L=0.04u
M29866 U7043/net6 U7043/net4 VSS VSS nmos W=0.17u L=0.04u
M29867 n6009 U7043/net14 VSS VSS nmos W=0.155u L=0.04u
M29868 U7043/net10 n5527 VSS VSS nmos W=0.155u L=0.04u
M29869 U7043/net4 U7043/net10 U7043/net14 VDD pmos W=0.255u L=0.04u
M29870 U7043/net6 n5527 U7043/net14 VDD pmos W=0.28u L=0.04u
M29871 U7043/net4 n5057 VDD VDD pmos W=0.205u L=0.04u
M29872 U7043/net6 U7043/net4 VDD VDD pmos W=0.24u L=0.04u
M29873 n6009 U7043/net14 VDD VDD pmos W=0.205u L=0.04u
M29874 U7043/net10 n5527 VDD VDD pmos W=0.205u L=0.04u
M29875 n5057 g6368 U7044/XI21-net17 VSS nmos W=0.155u L=0.04u
M29876 U7044/XI21-net17 g909 VSS VSS nmos W=0.155u L=0.04u
M29877 n5057 g6518 U7044/XI6-net17 VSS nmos W=0.155u L=0.04u
M29878 U7044/XI6-net17 g912 VSS VSS nmos W=0.155u L=0.04u
M29879 n5057 g853 U7044/XI20-net17 VSS nmos W=0.155u L=0.04u
M29880 U7044/XI20-net17 g915 VSS VSS nmos W=0.155u L=0.04u
M29881 VDD g6368 U7044/net22 VDD pmos W=0.205u L=0.04u
M29882 VDD g909 U7044/net22 VDD pmos W=0.205u L=0.04u
M29883 U7044/net16 g6518 n5057 VDD pmos W=0.205u L=0.04u
M29884 U7044/net16 g912 n5057 VDD pmos W=0.205u L=0.04u
M29885 U7044/net22 g853 U7044/net16 VDD pmos W=0.205u L=0.04u
M29886 U7044/net22 g915 U7044/net16 VDD pmos W=0.205u L=0.04u
M29887 n5527 g744 VSS VSS nmos W=0.135u L=0.04u
M29888 n5527 g744 VDD VDD pmos W=0.205u L=0.04u
M29889 U7046/net4 g753 U7046/net14 VSS nmos W=0.155u L=0.04u
M29890 U7046/net6 U7046/net10 U7046/net14 VSS nmos W=0.17u L=0.04u
M29891 U7046/net4 n5034 VSS VSS nmos W=0.155u L=0.04u
M29892 U7046/net6 U7046/net4 VSS VSS nmos W=0.17u L=0.04u
M29893 n6008 U7046/net14 VSS VSS nmos W=0.155u L=0.04u
M29894 U7046/net10 g753 VSS VSS nmos W=0.155u L=0.04u
M29895 U7046/net4 U7046/net10 U7046/net14 VDD pmos W=0.255u L=0.04u
M29896 U7046/net6 g753 U7046/net14 VDD pmos W=0.28u L=0.04u
M29897 U7046/net4 n5034 VDD VDD pmos W=0.205u L=0.04u
M29898 U7046/net6 U7046/net4 VDD VDD pmos W=0.24u L=0.04u
M29899 n6008 U7046/net14 VDD VDD pmos W=0.205u L=0.04u
M29900 U7046/net10 g753 VDD VDD pmos W=0.205u L=0.04u
M29901 n5034 n5063 VSS VSS nmos W=0.135u L=0.04u
M29902 n5034 n5063 VDD VDD pmos W=0.205u L=0.04u
M29903 n5063 g6368 U7048/XI21-net17 VSS nmos W=0.155u L=0.04u
M29904 U7048/XI21-net17 g900 VSS VSS nmos W=0.155u L=0.04u
M29905 n5063 g6518 U7048/XI6-net17 VSS nmos W=0.155u L=0.04u
M29906 U7048/XI6-net17 g903 VSS VSS nmos W=0.155u L=0.04u
M29907 n5063 g853 U7048/XI20-net17 VSS nmos W=0.155u L=0.04u
M29908 U7048/XI20-net17 g906 VSS VSS nmos W=0.155u L=0.04u
M29909 VDD g6368 U7048/net22 VDD pmos W=0.205u L=0.04u
M29910 VDD g900 U7048/net22 VDD pmos W=0.205u L=0.04u
M29911 U7048/net16 g6518 n5063 VDD pmos W=0.205u L=0.04u
M29912 U7048/net16 g903 n5063 VDD pmos W=0.205u L=0.04u
M29913 U7048/net22 g853 U7048/net16 VDD pmos W=0.205u L=0.04u
M29914 U7048/net22 g906 U7048/net16 VDD pmos W=0.205u L=0.04u
M29915 U7049/net8 n4914 U7049/net26 VSS nmos W=0.155u L=0.04u
M29916 U7049/net26 n4335 VSS VSS nmos W=0.155u L=0.04u
M29917 U7049/net29 U7049/net8 VSS VSS nmos W=0.155u L=0.04u
M29918 U7049/net29 n6015 N1762 VSS nmos W=0.155u L=0.04u
M29919 U7049/net29 n6016 N1762 VSS nmos W=0.155u L=0.04u
M29920 U7049/net8 n4335 VDD VDD pmos W=0.205u L=0.04u
M29921 U7049/net8 n4914 VDD VDD pmos W=0.205u L=0.04u
M29922 N1762 U7049/net8 VDD VDD pmos W=0.205u L=0.04u
M29923 N1762 n6015 U7049/net20 VDD pmos W=0.205u L=0.04u
M29924 U7049/net20 n6016 VDD VDD pmos W=0.205u L=0.04u
M29925 n4335 n4873 VSS VSS nmos W=0.155u L=0.04u
M29926 n4335 n4808 VSS VSS nmos W=0.155u L=0.04u
M29927 n4335 n4874 VSS VSS nmos W=0.155u L=0.04u
M29928 U7050/net25 n4873 VDD VDD pmos W=0.41u L=0.04u
M29929 U7050/net28 n4808 U7050/net25 VDD pmos W=0.41u L=0.04u
M29930 n4335 n4874 U7050/net28 VDD pmos W=0.41u L=0.04u
M29931 n4914 U7051/net6 VSS VSS nmos W=0.155u L=0.04u
M29932 U7051/net6 n4847 U7051/XU30-net23 VSS nmos W=0.155u L=0.04u
M29933 U7051/XU30-net23 n4836 U7051/XU30-net26 VSS nmos W=0.155u L=0.04u
M29934 U7051/XU30-net26 n4960 U7051/XU30-net29 VSS nmos W=0.155u L=0.04u
M29935 U7051/XU30-net29 n6017 VSS VSS nmos W=0.155u L=0.04u
M29936 n4914 U7051/net6 VDD VDD pmos W=0.205u L=0.04u
M29937 U7051/net6 n6017 VDD VDD pmos W=0.205u L=0.04u
M29938 U7051/net6 n4960 VDD VDD pmos W=0.205u L=0.04u
M29939 U7051/net6 n4836 VDD VDD pmos W=0.205u L=0.04u
M29940 U7051/net6 n4847 VDD VDD pmos W=0.205u L=0.04u
M29941 n6017 n4911 VSS VSS nmos W=0.155u L=0.04u
M29942 n6017 n4951 VSS VSS nmos W=0.155u L=0.04u
M29943 n6017 n4910 VSS VSS nmos W=0.155u L=0.04u
M29944 U7052/net25 n4911 VDD VDD pmos W=0.41u L=0.04u
M29945 U7052/net28 n4951 U7052/net25 VDD pmos W=0.41u L=0.04u
M29946 n6017 n4910 U7052/net28 VDD pmos W=0.41u L=0.04u
M29947 n4951 n4833 VSS VSS nmos W=0.135u L=0.04u
M29948 n4951 n4833 VDD VDD pmos W=0.205u L=0.04u
M29949 n4960 U7054/net6 VSS VSS nmos W=0.155u L=0.04u
M29950 U7054/net6 n4959 U7054/XU30-net23 VSS nmos W=0.155u L=0.04u
M29951 U7054/XU30-net23 n4815 U7054/XU30-net26 VSS nmos W=0.155u L=0.04u
M29952 U7054/XU30-net26 n6018 U7054/XU30-net29 VSS nmos W=0.155u L=0.04u
M29953 U7054/XU30-net29 n4828 VSS VSS nmos W=0.155u L=0.04u
M29954 n4960 U7054/net6 VDD VDD pmos W=0.205u L=0.04u
M29955 U7054/net6 n4828 VDD VDD pmos W=0.205u L=0.04u
M29956 U7054/net6 n6018 VDD VDD pmos W=0.205u L=0.04u
M29957 U7054/net6 n4815 VDD VDD pmos W=0.205u L=0.04u
M29958 U7054/net6 n4959 VDD VDD pmos W=0.205u L=0.04u
M29959 n6018 n4842 VSS VSS nmos W=0.155u L=0.04u
M29960 n6018 n4912 VSS VSS nmos W=0.155u L=0.04u
M29961 U7055/XI1-net8 n4912 VDD VDD pmos W=0.205u L=0.04u
M29962 n6018 n4842 U7055/XI1-net8 VDD pmos W=0.205u L=0.04u
M29963 n4912 n4819 VSS VSS nmos W=0.135u L=0.04u
M29964 n4912 n4819 VDD VDD pmos W=0.205u L=0.04u
M29965 n4842 n4904 VSS VSS nmos W=0.135u L=0.04u
M29966 n4842 n4904 VDD VDD pmos W=0.205u L=0.04u
M29967 U7058/p2 n6022 VSS VSS nmos W=0.155u L=0.04u
M29968 U7058/p0 n6020 U7058/p1 VSS nmos W=0.155u L=0.04u
M29969 U7058/p1 n6021 U7058/p2 VSS nmos W=0.155u L=0.04u
M29970 n6016 n6019 U7058/p0 VSS nmos W=0.155u L=0.04u
M29971 n6016 n6021 VDD VDD pmos W=0.205u L=0.04u
M29972 n6016 n6020 VDD VDD pmos W=0.205u L=0.04u
M29973 n6016 n6019 VDD VDD pmos W=0.205u L=0.04u
M29974 n6016 n6022 VDD VDD pmos W=0.205u L=0.04u
M29975 n6022 n6025 VSS VSS nmos W=0.155u L=0.04u
M29976 n6022 n6024 VSS VSS nmos W=0.155u L=0.04u
M29977 n6022 n6023 VSS VSS nmos W=0.155u L=0.04u
M29978 U7059/net25 n6025 VDD VDD pmos W=0.41u L=0.04u
M29979 U7059/net28 n6024 U7059/net25 VDD pmos W=0.41u L=0.04u
M29980 n6022 n6023 U7059/net28 VDD pmos W=0.41u L=0.04u
M29981 U7060/net4 n4833 U7060/net14 VSS nmos W=0.155u L=0.04u
M29982 U7060/net6 U7060/net10 U7060/net14 VSS nmos W=0.17u L=0.04u
M29983 U7060/net4 g52 VSS VSS nmos W=0.155u L=0.04u
M29984 U7060/net6 U7060/net4 VSS VSS nmos W=0.17u L=0.04u
M29985 n6025 U7060/net14 VSS VSS nmos W=0.155u L=0.04u
M29986 U7060/net10 n4833 VSS VSS nmos W=0.155u L=0.04u
M29987 U7060/net4 U7060/net10 U7060/net14 VDD pmos W=0.255u L=0.04u
M29988 U7060/net6 n4833 U7060/net14 VDD pmos W=0.28u L=0.04u
M29989 U7060/net4 g52 VDD VDD pmos W=0.205u L=0.04u
M29990 U7060/net6 U7060/net4 VDD VDD pmos W=0.24u L=0.04u
M29991 n6025 U7060/net14 VDD VDD pmos W=0.205u L=0.04u
M29992 U7060/net10 n4833 VDD VDD pmos W=0.205u L=0.04u
M29993 n4833 g165 U7061/XI21-net17 VSS nmos W=0.155u L=0.04u
M29994 U7061/XI21-net17 g273 VSS VSS nmos W=0.155u L=0.04u
M29995 n4833 g6231 U7061/XI6-net17 VSS nmos W=0.155u L=0.04u
M29996 U7061/XI6-net17 g267 VSS VSS nmos W=0.155u L=0.04u
M29997 n4833 g6313 U7061/XI20-net17 VSS nmos W=0.155u L=0.04u
M29998 U7061/XI20-net17 g270 VSS VSS nmos W=0.155u L=0.04u
M29999 VDD g165 U7061/net22 VDD pmos W=0.205u L=0.04u
M30000 VDD g273 U7061/net22 VDD pmos W=0.205u L=0.04u
M30001 U7061/net16 g6231 n4833 VDD pmos W=0.205u L=0.04u
M30002 U7061/net16 g267 n4833 VDD pmos W=0.205u L=0.04u
M30003 U7061/net22 g6313 U7061/net16 VDD pmos W=0.205u L=0.04u
M30004 U7061/net22 g270 U7061/net16 VDD pmos W=0.205u L=0.04u
M30005 U7062/net4 n4904 U7062/net14 VSS nmos W=0.155u L=0.04u
M30006 U7062/net6 U7062/net10 U7062/net14 VSS nmos W=0.17u L=0.04u
M30007 U7062/net4 g61 VSS VSS nmos W=0.155u L=0.04u
M30008 U7062/net6 U7062/net4 VSS VSS nmos W=0.17u L=0.04u
M30009 n6024 U7062/net14 VSS VSS nmos W=0.155u L=0.04u
M30010 U7062/net10 n4904 VSS VSS nmos W=0.155u L=0.04u
M30011 U7062/net4 U7062/net10 U7062/net14 VDD pmos W=0.255u L=0.04u
M30012 U7062/net6 n4904 U7062/net14 VDD pmos W=0.28u L=0.04u
M30013 U7062/net4 g61 VDD VDD pmos W=0.205u L=0.04u
M30014 U7062/net6 U7062/net4 VDD VDD pmos W=0.24u L=0.04u
M30015 n6024 U7062/net14 VDD VDD pmos W=0.205u L=0.04u
M30016 U7062/net10 n4904 VDD VDD pmos W=0.205u L=0.04u
M30017 n4904 g165 U7063/XI21-net17 VSS nmos W=0.155u L=0.04u
M30018 U7063/XI21-net17 g264 VSS VSS nmos W=0.155u L=0.04u
M30019 n4904 g6231 U7063/XI6-net17 VSS nmos W=0.155u L=0.04u
M30020 U7063/XI6-net17 g258 VSS VSS nmos W=0.155u L=0.04u
M30021 n4904 g6313 U7063/XI20-net17 VSS nmos W=0.155u L=0.04u
M30022 U7063/XI20-net17 g261 VSS VSS nmos W=0.155u L=0.04u
M30023 VDD g165 U7063/net22 VDD pmos W=0.205u L=0.04u
M30024 VDD g264 U7063/net22 VDD pmos W=0.205u L=0.04u
M30025 U7063/net16 g6231 n4904 VDD pmos W=0.205u L=0.04u
M30026 U7063/net16 g258 n4904 VDD pmos W=0.205u L=0.04u
M30027 U7063/net22 g6313 U7063/net16 VDD pmos W=0.205u L=0.04u
M30028 U7063/net22 g261 U7063/net16 VDD pmos W=0.205u L=0.04u
M30029 U7064/net4 n4819 U7064/net14 VSS nmos W=0.155u L=0.04u
M30030 U7064/net6 U7064/net10 U7064/net14 VSS nmos W=0.17u L=0.04u
M30031 U7064/net4 g70 VSS VSS nmos W=0.155u L=0.04u
M30032 U7064/net6 U7064/net4 VSS VSS nmos W=0.17u L=0.04u
M30033 n6023 U7064/net14 VSS VSS nmos W=0.155u L=0.04u
M30034 U7064/net10 n4819 VSS VSS nmos W=0.155u L=0.04u
M30035 U7064/net4 U7064/net10 U7064/net14 VDD pmos W=0.255u L=0.04u
M30036 U7064/net6 n4819 U7064/net14 VDD pmos W=0.28u L=0.04u
M30037 U7064/net4 g70 VDD VDD pmos W=0.205u L=0.04u
M30038 U7064/net6 U7064/net4 VDD VDD pmos W=0.24u L=0.04u
M30039 n6023 U7064/net14 VDD VDD pmos W=0.205u L=0.04u
M30040 U7064/net10 n4819 VDD VDD pmos W=0.205u L=0.04u
M30041 n4819 g165 U7065/XI21-net17 VSS nmos W=0.155u L=0.04u
M30042 U7065/XI21-net17 g255 VSS VSS nmos W=0.155u L=0.04u
M30043 n4819 g6231 U7065/XI6-net17 VSS nmos W=0.155u L=0.04u
M30044 U7065/XI6-net17 g249 VSS VSS nmos W=0.155u L=0.04u
M30045 n4819 g6313 U7065/XI20-net17 VSS nmos W=0.155u L=0.04u
M30046 U7065/XI20-net17 g252 VSS VSS nmos W=0.155u L=0.04u
M30047 VDD g165 U7065/net22 VDD pmos W=0.205u L=0.04u
M30048 VDD g255 U7065/net22 VDD pmos W=0.205u L=0.04u
M30049 U7065/net16 g6231 n4819 VDD pmos W=0.205u L=0.04u
M30050 U7065/net16 g249 n4819 VDD pmos W=0.205u L=0.04u
M30051 U7065/net22 g6313 U7065/net16 VDD pmos W=0.205u L=0.04u
M30052 U7065/net22 g252 U7065/net16 VDD pmos W=0.205u L=0.04u
M30053 U7066/net4 U7066/net10 U7066/net14 VSS nmos W=0.155u L=0.04u
M30054 U7066/net6 g83 U7066/net14 VSS nmos W=0.155u L=0.04u
M30055 U7066/net4 n4847 VSS VSS nmos W=0.155u L=0.04u
M30056 U7066/net6 U7066/net4 VSS VSS nmos W=0.155u L=0.04u
M30057 n6021 U7066/net14 VSS VSS nmos W=0.155u L=0.04u
M30058 U7066/net10 g83 VSS VSS nmos W=0.155u L=0.04u
M30059 U7066/net4 g83 U7066/net14 VDD pmos W=0.205u L=0.04u
M30060 U7066/net6 U7066/net10 U7066/net14 VDD pmos W=0.205u L=0.04u
M30061 U7066/net4 n4847 VDD VDD pmos W=0.205u L=0.04u
M30062 U7066/net6 U7066/net4 VDD VDD pmos W=0.205u L=0.04u
M30063 n6021 U7066/net14 VDD VDD pmos W=0.205u L=0.04u
M30064 U7066/net10 g83 VDD VDD pmos W=0.205u L=0.04u
M30065 n4847 g165 U7067/XI21-net17 VSS nmos W=0.155u L=0.04u
M30066 U7067/XI21-net17 g201 VSS VSS nmos W=0.155u L=0.04u
M30067 n4847 g6231 U7067/XI6-net17 VSS nmos W=0.155u L=0.04u
M30068 U7067/XI6-net17 g195 VSS VSS nmos W=0.155u L=0.04u
M30069 n4847 g6313 U7067/XI20-net17 VSS nmos W=0.155u L=0.04u
M30070 U7067/XI20-net17 g198 VSS VSS nmos W=0.155u L=0.04u
M30071 VDD g165 U7067/net22 VDD pmos W=0.205u L=0.04u
M30072 VDD g201 U7067/net22 VDD pmos W=0.205u L=0.04u
M30073 U7067/net16 g6231 n4847 VDD pmos W=0.205u L=0.04u
M30074 U7067/net16 g195 n4847 VDD pmos W=0.205u L=0.04u
M30075 U7067/net22 g6313 U7067/net16 VDD pmos W=0.205u L=0.04u
M30076 U7067/net22 g198 U7067/net16 VDD pmos W=0.205u L=0.04u
M30077 U7068/net4 n5505 U7068/net14 VSS nmos W=0.155u L=0.04u
M30078 U7068/net6 U7068/net10 U7068/net14 VSS nmos W=0.17u L=0.04u
M30079 U7068/net4 n4836 VSS VSS nmos W=0.155u L=0.04u
M30080 U7068/net6 U7068/net4 VSS VSS nmos W=0.17u L=0.04u
M30081 n6020 U7068/net14 VSS VSS nmos W=0.155u L=0.04u
M30082 U7068/net10 n5505 VSS VSS nmos W=0.155u L=0.04u
M30083 U7068/net4 U7068/net10 U7068/net14 VDD pmos W=0.255u L=0.04u
M30084 U7068/net6 n5505 U7068/net14 VDD pmos W=0.28u L=0.04u
M30085 U7068/net4 n4836 VDD VDD pmos W=0.205u L=0.04u
M30086 U7068/net6 U7068/net4 VDD VDD pmos W=0.24u L=0.04u
M30087 n6020 U7068/net14 VDD VDD pmos W=0.205u L=0.04u
M30088 U7068/net10 n5505 VDD VDD pmos W=0.205u L=0.04u
M30089 n4836 g165 U7069/XI21-net17 VSS nmos W=0.155u L=0.04u
M30090 U7069/XI21-net17 g228 VSS VSS nmos W=0.155u L=0.04u
M30091 n4836 g6231 U7069/XI6-net17 VSS nmos W=0.155u L=0.04u
M30092 U7069/XI6-net17 g222 VSS VSS nmos W=0.155u L=0.04u
M30093 n4836 g6313 U7069/XI20-net17 VSS nmos W=0.155u L=0.04u
M30094 U7069/XI20-net17 g225 VSS VSS nmos W=0.155u L=0.04u
M30095 VDD g165 U7069/net22 VDD pmos W=0.205u L=0.04u
M30096 VDD g228 U7069/net22 VDD pmos W=0.205u L=0.04u
M30097 U7069/net16 g6231 n4836 VDD pmos W=0.205u L=0.04u
M30098 U7069/net16 g222 n4836 VDD pmos W=0.205u L=0.04u
M30099 U7069/net22 g6313 U7069/net16 VDD pmos W=0.205u L=0.04u
M30100 U7069/net22 g225 U7069/net16 VDD pmos W=0.205u L=0.04u
M30101 n5505 g56 VSS VSS nmos W=0.135u L=0.04u
M30102 n5505 g56 VDD VDD pmos W=0.205u L=0.04u
M30103 U7071/net4 g65 U7071/net14 VSS nmos W=0.155u L=0.04u
M30104 U7071/net6 U7071/net10 U7071/net14 VSS nmos W=0.17u L=0.04u
M30105 U7071/net4 n4905 VSS VSS nmos W=0.155u L=0.04u
M30106 U7071/net6 U7071/net4 VSS VSS nmos W=0.17u L=0.04u
M30107 n6019 U7071/net14 VSS VSS nmos W=0.155u L=0.04u
M30108 U7071/net10 g65 VSS VSS nmos W=0.155u L=0.04u
M30109 U7071/net4 U7071/net10 U7071/net14 VDD pmos W=0.255u L=0.04u
M30110 U7071/net6 g65 U7071/net14 VDD pmos W=0.28u L=0.04u
M30111 U7071/net4 n4905 VDD VDD pmos W=0.205u L=0.04u
M30112 U7071/net6 U7071/net4 VDD VDD pmos W=0.24u L=0.04u
M30113 n6019 U7071/net14 VDD VDD pmos W=0.205u L=0.04u
M30114 U7071/net10 g65 VDD VDD pmos W=0.205u L=0.04u
M30115 n4905 n4815 VSS VSS nmos W=0.135u L=0.04u
M30116 n4905 n4815 VDD VDD pmos W=0.205u L=0.04u
M30117 n4815 g165 U7073/XI21-net17 VSS nmos W=0.155u L=0.04u
M30118 U7073/XI21-net17 g219 VSS VSS nmos W=0.155u L=0.04u
M30119 n4815 g6231 U7073/XI6-net17 VSS nmos W=0.155u L=0.04u
M30120 U7073/XI6-net17 g213 VSS VSS nmos W=0.155u L=0.04u
M30121 n4815 g6313 U7073/XI20-net17 VSS nmos W=0.155u L=0.04u
M30122 U7073/XI20-net17 g216 VSS VSS nmos W=0.155u L=0.04u
M30123 VDD g165 U7073/net22 VDD pmos W=0.205u L=0.04u
M30124 VDD g219 U7073/net22 VDD pmos W=0.205u L=0.04u
M30125 U7073/net16 g6231 n4815 VDD pmos W=0.205u L=0.04u
M30126 U7073/net16 g213 n4815 VDD pmos W=0.205u L=0.04u
M30127 U7073/net22 g6313 U7073/net16 VDD pmos W=0.205u L=0.04u
M30128 U7073/net22 g216 U7073/net16 VDD pmos W=0.205u L=0.04u
M30129 U7074/p2 n6027 VSS VSS nmos W=0.155u L=0.04u
M30130 U7074/p0 n4337 U7074/p1 VSS nmos W=0.155u L=0.04u
M30131 U7074/p1 n6026 U7074/p2 VSS nmos W=0.155u L=0.04u
M30132 n6015 n5437 U7074/p0 VSS nmos W=0.155u L=0.04u
M30133 n6015 n6026 VDD VDD pmos W=0.205u L=0.04u
M30134 n6015 n4337 VDD VDD pmos W=0.205u L=0.04u
M30135 n6015 n5437 VDD VDD pmos W=0.205u L=0.04u
M30136 n6015 n6027 VDD VDD pmos W=0.205u L=0.04u
M30137 n6027 n6030 VSS VSS nmos W=0.155u L=0.04u
M30138 n6027 n6029 VSS VSS nmos W=0.155u L=0.04u
M30139 n6027 n6028 VSS VSS nmos W=0.155u L=0.04u
M30140 U7075/net25 n6030 VDD VDD pmos W=0.41u L=0.04u
M30141 U7075/net28 n6029 U7075/net25 VDD pmos W=0.41u L=0.04u
M30142 n6027 n6028 U7075/net28 VDD pmos W=0.41u L=0.04u
M30143 U7076/net4 n4910 U7076/net14 VSS nmos W=0.155u L=0.04u
M30144 U7076/net6 U7076/net10 U7076/net14 VSS nmos W=0.17u L=0.04u
M30145 U7076/net4 n5518 VSS VSS nmos W=0.155u L=0.04u
M30146 U7076/net6 U7076/net4 VSS VSS nmos W=0.17u L=0.04u
M30147 n6030 U7076/net14 VSS VSS nmos W=0.155u L=0.04u
M30148 U7076/net10 n4910 VSS VSS nmos W=0.155u L=0.04u
M30149 U7076/net4 U7076/net10 U7076/net14 VDD pmos W=0.255u L=0.04u
M30150 U7076/net6 n4910 U7076/net14 VDD pmos W=0.28u L=0.04u
M30151 U7076/net4 n5518 VDD VDD pmos W=0.205u L=0.04u
M30152 U7076/net6 U7076/net4 VDD VDD pmos W=0.24u L=0.04u
M30153 n6030 U7076/net14 VDD VDD pmos W=0.205u L=0.04u
M30154 U7076/net10 n4910 VDD VDD pmos W=0.205u L=0.04u
M30155 n5518 g88 VSS VSS nmos W=0.135u L=0.04u
M30156 n5518 g88 VDD VDD pmos W=0.205u L=0.04u
M30157 n4910 n4855 VSS VSS nmos W=0.135u L=0.04u
M30158 n4910 n4855 VDD VDD pmos W=0.205u L=0.04u
M30159 n4855 g165 U7079/XI21-net17 VSS nmos W=0.155u L=0.04u
M30160 U7079/XI21-net17 g237 VSS VSS nmos W=0.155u L=0.04u
M30161 n4855 g6231 U7079/XI6-net17 VSS nmos W=0.155u L=0.04u
M30162 U7079/XI6-net17 g231 VSS VSS nmos W=0.155u L=0.04u
M30163 n4855 g6313 U7079/XI20-net17 VSS nmos W=0.155u L=0.04u
M30164 U7079/XI20-net17 g234 VSS VSS nmos W=0.155u L=0.04u
M30165 VDD g165 U7079/net22 VDD pmos W=0.205u L=0.04u
M30166 VDD g237 U7079/net22 VDD pmos W=0.205u L=0.04u
M30167 U7079/net16 g6231 n4855 VDD pmos W=0.205u L=0.04u
M30168 U7079/net16 g231 n4855 VDD pmos W=0.205u L=0.04u
M30169 U7079/net22 g6313 U7079/net16 VDD pmos W=0.205u L=0.04u
M30170 U7079/net22 g234 U7079/net16 VDD pmos W=0.205u L=0.04u
M30171 U7080/net4 n4959 U7080/net14 VSS nmos W=0.155u L=0.04u
M30172 U7080/net6 U7080/net10 U7080/net14 VSS nmos W=0.17u L=0.04u
M30173 U7080/net4 g74 VSS VSS nmos W=0.155u L=0.04u
M30174 U7080/net6 U7080/net4 VSS VSS nmos W=0.17u L=0.04u
M30175 n6029 U7080/net14 VSS VSS nmos W=0.155u L=0.04u
M30176 U7080/net10 n4959 VSS VSS nmos W=0.155u L=0.04u
M30177 U7080/net4 U7080/net10 U7080/net14 VDD pmos W=0.255u L=0.04u
M30178 U7080/net6 n4959 U7080/net14 VDD pmos W=0.28u L=0.04u
M30179 U7080/net4 g74 VDD VDD pmos W=0.205u L=0.04u
M30180 U7080/net6 U7080/net4 VDD VDD pmos W=0.24u L=0.04u
M30181 n6029 U7080/net14 VDD VDD pmos W=0.205u L=0.04u
M30182 U7080/net10 n4959 VDD VDD pmos W=0.205u L=0.04u
M30183 n4959 g165 U7081/XI21-net17 VSS nmos W=0.155u L=0.04u
M30184 U7081/XI21-net17 g210 VSS VSS nmos W=0.155u L=0.04u
M30185 n4959 g6231 U7081/XI6-net17 VSS nmos W=0.155u L=0.04u
M30186 U7081/XI6-net17 g204 VSS VSS nmos W=0.155u L=0.04u
M30187 n4959 g6313 U7081/XI20-net17 VSS nmos W=0.155u L=0.04u
M30188 U7081/XI20-net17 g207 VSS VSS nmos W=0.155u L=0.04u
M30189 VDD g165 U7081/net22 VDD pmos W=0.205u L=0.04u
M30190 VDD g210 U7081/net22 VDD pmos W=0.205u L=0.04u
M30191 U7081/net16 g6231 n4959 VDD pmos W=0.205u L=0.04u
M30192 U7081/net16 g204 n4959 VDD pmos W=0.205u L=0.04u
M30193 U7081/net22 g6313 U7081/net16 VDD pmos W=0.205u L=0.04u
M30194 U7081/net22 g207 U7081/net16 VDD pmos W=0.205u L=0.04u
M30195 U7082/net4 n4828 U7082/net14 VSS nmos W=0.155u L=0.04u
M30196 U7082/net6 U7082/net10 U7082/net14 VSS nmos W=0.17u L=0.04u
M30197 U7082/net4 g92 VSS VSS nmos W=0.155u L=0.04u
M30198 U7082/net6 U7082/net4 VSS VSS nmos W=0.17u L=0.04u
M30199 n6028 U7082/net14 VSS VSS nmos W=0.155u L=0.04u
M30200 U7082/net10 n4828 VSS VSS nmos W=0.155u L=0.04u
M30201 U7082/net4 U7082/net10 U7082/net14 VDD pmos W=0.255u L=0.04u
M30202 U7082/net6 n4828 U7082/net14 VDD pmos W=0.28u L=0.04u
M30203 U7082/net4 g92 VDD VDD pmos W=0.205u L=0.04u
M30204 U7082/net6 U7082/net4 VDD VDD pmos W=0.24u L=0.04u
M30205 n6028 U7082/net14 VDD VDD pmos W=0.205u L=0.04u
M30206 U7082/net10 n4828 VDD VDD pmos W=0.205u L=0.04u
M30207 n4828 g165 U7083/XI21-net17 VSS nmos W=0.155u L=0.04u
M30208 U7083/XI21-net17 g192 VSS VSS nmos W=0.155u L=0.04u
M30209 n4828 g6231 U7083/XI6-net17 VSS nmos W=0.155u L=0.04u
M30210 U7083/XI6-net17 g186 VSS VSS nmos W=0.155u L=0.04u
M30211 n4828 g6313 U7083/XI20-net17 VSS nmos W=0.155u L=0.04u
M30212 U7083/XI20-net17 g189 VSS VSS nmos W=0.155u L=0.04u
M30213 VDD g165 U7083/net22 VDD pmos W=0.205u L=0.04u
M30214 VDD g192 U7083/net22 VDD pmos W=0.205u L=0.04u
M30215 U7083/net16 g6231 n4828 VDD pmos W=0.205u L=0.04u
M30216 U7083/net16 g186 n4828 VDD pmos W=0.205u L=0.04u
M30217 U7083/net22 g6313 U7083/net16 VDD pmos W=0.205u L=0.04u
M30218 U7083/net22 g189 U7083/net16 VDD pmos W=0.205u L=0.04u
M30219 U7084/net4 g79 U7084/net14 VSS nmos W=0.155u L=0.04u
M30220 U7084/net6 U7084/net10 U7084/net14 VSS nmos W=0.17u L=0.04u
M30221 U7084/net4 n4911 VSS VSS nmos W=0.155u L=0.04u
M30222 U7084/net6 U7084/net4 VSS VSS nmos W=0.17u L=0.04u
M30223 n6026 U7084/net14 VSS VSS nmos W=0.155u L=0.04u
M30224 U7084/net10 g79 VSS VSS nmos W=0.155u L=0.04u
M30225 U7084/net4 U7084/net10 U7084/net14 VDD pmos W=0.255u L=0.04u
M30226 U7084/net6 g79 U7084/net14 VDD pmos W=0.28u L=0.04u
M30227 U7084/net4 n4911 VDD VDD pmos W=0.205u L=0.04u
M30228 U7084/net6 U7084/net4 VDD VDD pmos W=0.24u L=0.04u
M30229 n6026 U7084/net14 VDD VDD pmos W=0.205u L=0.04u
M30230 U7084/net10 g79 VDD VDD pmos W=0.205u L=0.04u
M30231 n4911 n4846 VSS VSS nmos W=0.135u L=0.04u
M30232 n4911 n4846 VDD VDD pmos W=0.205u L=0.04u
M30233 n4846 g165 U7086/XI21-net17 VSS nmos W=0.155u L=0.04u
M30234 U7086/XI21-net17 g246 VSS VSS nmos W=0.155u L=0.04u
M30235 n4846 g6231 U7086/XI6-net17 VSS nmos W=0.155u L=0.04u
M30236 U7086/XI6-net17 g240 VSS VSS nmos W=0.155u L=0.04u
M30237 n4846 g6313 U7086/XI20-net17 VSS nmos W=0.155u L=0.04u
M30238 U7086/XI20-net17 g243 VSS VSS nmos W=0.155u L=0.04u
M30239 VDD g165 U7086/net22 VDD pmos W=0.205u L=0.04u
M30240 VDD g246 U7086/net22 VDD pmos W=0.205u L=0.04u
M30241 U7086/net16 g6231 n4846 VDD pmos W=0.205u L=0.04u
M30242 U7086/net16 g240 n4846 VDD pmos W=0.205u L=0.04u
M30243 U7086/net22 g6313 U7086/net16 VDD pmos W=0.205u L=0.04u
M30244 U7086/net22 g243 U7086/net16 VDD pmos W=0.205u L=0.04u
M30245 U7087/XU1-net6 n4874 VSS VSS nmos W=0.155u L=0.04u
M30246 n4337 n4879 U7087/XU1-net6 VSS nmos W=0.155u L=0.04u
M30247 n4337 n4874 VDD VDD pmos W=0.155u L=0.04u
M30248 n4337 n4879 VDD VDD pmos W=0.155u L=0.04u
M30249 n4874 n4750 U7088/net27 VSS nmos W=0.155u L=0.04u
M30250 U7088/net39 n4751 VSS VSS nmos W=0.155u L=0.04u
M30251 U7088/net27 g318 U7088/net39 VSS nmos W=0.155u L=0.04u
M30252 U7088/net27 n4749 U7088/net39 VSS nmos W=0.155u L=0.04u
M30253 n4874 g319 U7088/net27 VSS nmos W=0.155u L=0.04u
M30254 U7088/net39 g320 VSS VSS nmos W=0.155u L=0.04u
M30255 n4874 n4751 U7088/net46 VDD pmos W=0.205u L=0.04u
M30256 U7088/net46 g320 VDD VDD pmos W=0.205u L=0.04u
M30257 n4874 g319 U7088/net34 VDD pmos W=0.205u L=0.04u
M30258 U7088/net34 n4750 VDD VDD pmos W=0.205u L=0.04u
M30259 n4874 n4749 U7088/net37 VDD pmos W=0.205u L=0.04u
M30260 U7088/net37 g318 VDD VDD pmos W=0.205u L=0.04u
M30261 n4879 n4808 VSS VSS nmos W=0.155u L=0.04u
M30262 n4879 n4875 VSS VSS nmos W=0.155u L=0.04u
M30263 U7089/XI1-net8 n4875 VDD VDD pmos W=0.205u L=0.04u
M30264 n4879 n4808 U7089/XI1-net8 VDD pmos W=0.205u L=0.04u
M30265 n4875 n4873 VSS VSS nmos W=0.135u L=0.04u
M30266 n4875 n4873 VDD VDD pmos W=0.205u L=0.04u
M30267 n4873 n4750 U7091/net27 VSS nmos W=0.155u L=0.04u
M30268 U7091/net39 n4751 VSS VSS nmos W=0.155u L=0.04u
M30269 U7091/net27 g315 U7091/net39 VSS nmos W=0.155u L=0.04u
M30270 U7091/net27 n4749 U7091/net39 VSS nmos W=0.155u L=0.04u
M30271 n4873 g316 U7091/net27 VSS nmos W=0.155u L=0.04u
M30272 U7091/net39 g317 VSS VSS nmos W=0.155u L=0.04u
M30273 n4873 n4751 U7091/net46 VDD pmos W=0.205u L=0.04u
M30274 U7091/net46 g317 VDD VDD pmos W=0.205u L=0.04u
M30275 n4873 g316 U7091/net34 VDD pmos W=0.205u L=0.04u
M30276 U7091/net34 n4750 VDD VDD pmos W=0.205u L=0.04u
M30277 n4873 n4749 U7091/net37 VDD pmos W=0.205u L=0.04u
M30278 U7091/net37 g315 VDD VDD pmos W=0.205u L=0.04u
M30279 n4808 n4750 U7092/net27 VSS nmos W=0.155u L=0.04u
M30280 U7092/net39 n4751 VSS VSS nmos W=0.155u L=0.04u
M30281 U7092/net27 g312 U7092/net39 VSS nmos W=0.155u L=0.04u
M30282 U7092/net27 n4749 U7092/net39 VSS nmos W=0.155u L=0.04u
M30283 n4808 g313 U7092/net27 VSS nmos W=0.155u L=0.04u
M30284 U7092/net39 g314 VSS VSS nmos W=0.155u L=0.04u
M30285 n4808 n4751 U7092/net46 VDD pmos W=0.205u L=0.04u
M30286 U7092/net46 g314 VDD VDD pmos W=0.205u L=0.04u
M30287 n4808 g313 U7092/net34 VDD pmos W=0.205u L=0.04u
M30288 U7092/net34 n4750 VDD VDD pmos W=0.205u L=0.04u
M30289 n4808 n4749 U7092/net37 VDD pmos W=0.205u L=0.04u
M30290 U7092/net37 g312 VDD VDD pmos W=0.205u L=0.04u
M30291 n4751 g401 VSS VSS nmos W=0.135u L=0.04u
M30292 n4751 g401 VDD VDD pmos W=0.205u L=0.04u
M30293 n4749 g5437 VSS VSS nmos W=0.135u L=0.04u
M30294 n4749 g5437 VDD VDD pmos W=0.205u L=0.04u
M30295 n4750 g6447 VSS VSS nmos W=0.135u L=0.04u
M30296 n4750 g6447 VDD VDD pmos W=0.205u L=0.04u
M30297 U7096/net20 g2896 VSS VSS nmos W=0.155u L=0.04u
M30298 n5437 n5623 U7096/p0 VSS nmos W=0.155u L=0.04u
M30299 U7096/p2 U7096/net20 VSS VSS nmos W=0.155u L=0.04u
M30300 U7096/p1 n5616 U7096/p2 VSS nmos W=0.155u L=0.04u
M30301 U7096/p0 n6031 U7096/p1 VSS nmos W=0.155u L=0.04u
M30302 U7096/net20 g2896 VDD VDD pmos W=0.205u L=0.04u
M30303 n5437 n5616 VDD VDD pmos W=0.205u L=0.04u
M30304 n5437 n5623 VDD VDD pmos W=0.205u L=0.04u
M30305 n5437 n6031 VDD VDD pmos W=0.205u L=0.04u
M30306 n5437 U7096/net20 VDD VDD pmos W=0.205u L=0.04u
M30307 n5623 g2900 VSS VSS nmos W=0.135u L=0.04u
M30308 n5623 g2900 VDD VDD pmos W=0.205u L=0.04u
M30309 n6031 g2908 VSS VSS nmos W=0.155u L=0.04u
M30310 n6031 g2903 VSS VSS nmos W=0.155u L=0.04u
M30311 U7098/XI1-net8 g2903 VDD VDD pmos W=0.205u L=0.04u
M30312 n6031 g2908 U7098/XI1-net8 VDD pmos W=0.205u L=0.04u
M30313 n5616 g2892 VSS VSS nmos W=0.135u L=0.04u
M30314 n5616 g2892 VDD VDD pmos W=0.205u L=0.04u
M30315 U7100/net14 g2929 U7100/net20 VSS nmos W=0.155u L=0.04u
M30316 U7100/net14 n6032 U7100/net20 VSS nmos W=0.155u L=0.04u
M30317 U7100/net20 g2879 VSS VSS nmos W=0.155u L=0.04u
M30318 N159 U7100/net14 VSS VSS nmos W=0.155u L=0.04u
M30319 N159 U7100/net14 VDD VDD pmos W=0.205u L=0.04u
M30320 U7100/net14 g2879 VDD VDD pmos W=0.205u L=0.04u
M30321 U7100/net24 g2929 VDD VDD pmos W=0.205u L=0.04u
M30322 U7100/net14 n6032 U7100/net24 VDD pmos W=0.205u L=0.04u
M30323 n6032 g8021 VSS VSS nmos W=0.135u L=0.04u
M30324 n6032 g8021 VDD VDD pmos W=0.205u L=0.04u
M30325 N141 g16496 VSS VSS nmos W=0.135u L=0.04u
M30326 N141 g16496 VDD VDD pmos W=0.205u L=0.04u
M30327 g16496 g2986 U7103/net15 VSS nmos W=0.155u L=0.04u
M30328 g16496 n6033 U7103/net15 VSS nmos W=0.155u L=0.04u
M30329 U7103/net15 g2987 VSS VSS nmos W=0.155u L=0.04u
M30330 g16496 g2987 VDD VDD pmos W=0.205u L=0.04u
M30331 g16496 g2986 U7103/XI16-net11 VDD pmos W=0.205u L=0.04u
M30332 U7103/XI16-net11 n6033 VDD VDD pmos W=0.205u L=0.04u
M30333 n6033 g5388 VSS VSS nmos W=0.135u L=0.04u
M30334 n6033 g5388 VDD VDD pmos W=0.205u L=0.04u
M30335 N1285 n6034 VSS VSS nmos W=0.155u L=0.04u
M30336 N1285 U7105/net4 VSS VSS nmos W=0.155u L=0.04u
M30337 U7105/net4 n3833 VSS VSS nmos W=0.155u L=0.04u
M30338 U7105/XU1-net8 U7105/net4 VDD VDD pmos W=0.205u L=0.04u
M30339 N1285 n6034 U7105/XU1-net8 VDD pmos W=0.205u L=0.04u
M30340 U7105/net4 n3833 VDD VDD pmos W=0.205u L=0.04u
M30341 n6034 n6035 U7106/net27 VSS nmos W=0.155u L=0.04u
M30342 U7106/net27 n6036 VSS VSS nmos W=0.155u L=0.04u
M30343 n6034 n3837 VSS VSS nmos W=0.155u L=0.04u
M30344 n6034 n6036 U7106/net13 VDD pmos W=0.205u L=0.04u
M30345 U7106/net13 n3837 VDD VDD pmos W=0.205u L=0.04u
M30346 n6034 n6035 U7106/net13 VDD pmos W=0.205u L=0.04u
M30347 n3837 n6035 VSS VSS nmos W=0.155u L=0.04u
M30348 n3837 n6036 VSS VSS nmos W=0.155u L=0.04u
M30349 U7107/XI1-net8 n6036 VDD VDD pmos W=0.205u L=0.04u
M30350 n3837 n6035 U7107/XI1-net8 VDD pmos W=0.205u L=0.04u
M30351 n3833 g3234 U7108/net15 VSS nmos W=0.155u L=0.04u
M30352 n3833 n6037 U7108/net15 VSS nmos W=0.155u L=0.04u
M30353 U7108/net15 n3847 VSS VSS nmos W=0.155u L=0.04u
M30354 n3833 n3847 VDD VDD pmos W=0.205u L=0.04u
M30355 n3833 g3234 U7108/XI16-net11 VDD pmos W=0.205u L=0.04u
M30356 U7108/XI16-net11 n6037 VDD VDD pmos W=0.205u L=0.04u
M30357 U7109/XU1-net6 n6035 VSS VSS nmos W=0.155u L=0.04u
M30358 n3847 n659 U7109/XU1-net6 VSS nmos W=0.155u L=0.04u
M30359 n3847 n6035 VDD VDD pmos W=0.155u L=0.04u
M30360 n3847 n659 VDD VDD pmos W=0.155u L=0.04u
M30361 U7110/XU1-net6 g3080 VSS VSS nmos W=0.155u L=0.04u
M30362 n6035 n4484 U7110/XU1-net6 VSS nmos W=0.155u L=0.04u
M30363 n6035 g3080 VDD VDD pmos W=0.155u L=0.04u
M30364 n6035 n4484 VDD VDD pmos W=0.155u L=0.04u
M30365 n4484 U7111/net6 VSS VSS nmos W=0.155u L=0.04u
M30366 U7111/net6 g3013 U7111/XU30-net23 VSS nmos W=0.155u L=0.04u
M30367 U7111/XU30-net23 g3002 U7111/XU30-net26 VSS nmos W=0.155u L=0.04u
M30368 U7111/XU30-net26 g3024 U7111/XU30-net29 VSS nmos W=0.155u L=0.04u
M30369 U7111/XU30-net29 n6038 VSS VSS nmos W=0.155u L=0.04u
M30370 n4484 U7111/net6 VDD VDD pmos W=0.205u L=0.04u
M30371 U7111/net6 n6038 VDD VDD pmos W=0.205u L=0.04u
M30372 U7111/net6 g3024 VDD VDD pmos W=0.205u L=0.04u
M30373 U7111/net6 g3002 VDD VDD pmos W=0.205u L=0.04u
M30374 U7111/net6 g3013 VDD VDD pmos W=0.205u L=0.04u
M30375 n6038 n3851 VSS VSS nmos W=0.155u L=0.04u
M30376 n6038 g2993 VSS VSS nmos W=0.155u L=0.04u
M30377 n6038 g3006 VSS VSS nmos W=0.155u L=0.04u
M30378 n6038 g3010 VSS VSS nmos W=0.155u L=0.04u
M30379 U7112/net49 g2993 U7112/net52 VDD pmos W=0.41u L=0.04u
M30380 U7112/net52 n3851 VDD VDD pmos W=0.41u L=0.04u
M30381 U7112/net46 g3006 U7112/net49 VDD pmos W=0.41u L=0.04u
M30382 n6038 g3010 U7112/net46 VDD pmos W=0.41u L=0.04u
M30383 n3851 g2998 VSS VSS nmos W=0.135u L=0.04u
M30384 n3851 g2998 VDD VDD pmos W=0.205u L=0.04u
M30385 n659 g3234 VSS VSS nmos W=0.135u L=0.04u
M30386 n659 g3234 VDD VDD pmos W=0.205u L=0.04u
M30387 n6037 U7115/net15 VSS VSS nmos W=0.155u L=0.04u
M30388 n6037 g3036 VSS VSS nmos W=0.155u L=0.04u
M30389 n6037 g3028 VSS VSS nmos W=0.155u L=0.04u
M30390 n6037 n6036 VSS VSS nmos W=0.155u L=0.04u
M30391 U7115/net15 g3032 VSS VSS nmos W=0.155u L=0.04u
M30392 n6037 n6036 U7115/XU8-net7 VDD pmos W=0.41u L=0.04u
M30393 U7115/XU8-net7 g3028 U7115/XU8-net10 VDD pmos W=0.41u L=0.04u
M30394 U7115/XU8-net10 g3036 U7115/XU8-net13 VDD pmos W=0.41u L=0.04u
M30395 U7115/XU8-net13 U7115/net15 VDD VDD pmos W=0.41u L=0.04u
M30396 U7115/net15 g3032 VDD VDD pmos W=0.31u L=0.04u
M30397 n6036 g3018 VSS VSS nmos W=0.135u L=0.04u
M30398 n6036 g3018 VDD VDD pmos W=0.205u L=0.04u
M30399 N1282 n6039 VSS VSS nmos W=0.155u L=0.04u
M30400 N1282 U7117/net4 VSS VSS nmos W=0.155u L=0.04u
M30401 U7117/net4 n5626 VSS VSS nmos W=0.155u L=0.04u
M30402 U7117/XU1-net8 U7117/net4 VDD VDD pmos W=0.205u L=0.04u
M30403 N1282 n6039 U7117/XU1-net8 VDD pmos W=0.205u L=0.04u
M30404 U7117/net4 n5626 VDD VDD pmos W=0.205u L=0.04u
M30405 n6039 n6040 U7118/net27 VSS nmos W=0.155u L=0.04u
M30406 U7118/net27 n6041 VSS VSS nmos W=0.155u L=0.04u
M30407 n6039 n5624 VSS VSS nmos W=0.155u L=0.04u
M30408 n6039 n6041 U7118/net13 VDD pmos W=0.205u L=0.04u
M30409 U7118/net13 n5624 VDD VDD pmos W=0.205u L=0.04u
M30410 n6039 n6040 U7118/net13 VDD pmos W=0.205u L=0.04u
M30411 n5624 n6040 VSS VSS nmos W=0.155u L=0.04u
M30412 n5624 n6041 VSS VSS nmos W=0.155u L=0.04u
M30413 U7119/XI1-net8 n6041 VDD VDD pmos W=0.205u L=0.04u
M30414 n5624 n6040 U7119/XI1-net8 VDD pmos W=0.205u L=0.04u
M30415 n5626 g2814 U7120/net15 VSS nmos W=0.155u L=0.04u
M30416 n5626 n6042 U7120/net15 VSS nmos W=0.155u L=0.04u
M30417 U7120/net15 n5618 VSS VSS nmos W=0.155u L=0.04u
M30418 n5626 n5618 VDD VDD pmos W=0.205u L=0.04u
M30419 n5626 g2814 U7120/XI16-net11 VDD pmos W=0.205u L=0.04u
M30420 U7120/XI16-net11 n6042 VDD VDD pmos W=0.205u L=0.04u
M30421 n6042 U7121/net15 VSS VSS nmos W=0.155u L=0.04u
M30422 n6042 g2924 VSS VSS nmos W=0.155u L=0.04u
M30423 n6042 g2917 VSS VSS nmos W=0.155u L=0.04u
M30424 n6042 n6041 VSS VSS nmos W=0.155u L=0.04u
M30425 U7121/net15 g2920 VSS VSS nmos W=0.155u L=0.04u
M30426 n6042 n6041 U7121/XU8-net7 VDD pmos W=0.41u L=0.04u
M30427 U7121/XU8-net7 g2917 U7121/XU8-net10 VDD pmos W=0.41u L=0.04u
M30428 U7121/XU8-net10 g2924 U7121/XU8-net13 VDD pmos W=0.41u L=0.04u
M30429 U7121/XU8-net13 U7121/net15 VDD VDD pmos W=0.41u L=0.04u
M30430 U7121/net15 g2920 VDD VDD pmos W=0.31u L=0.04u
M30431 n6041 g2912 VSS VSS nmos W=0.135u L=0.04u
M30432 n6041 g2912 VDD VDD pmos W=0.205u L=0.04u
M30433 N1202 n6043 VSS VSS nmos W=0.155u L=0.04u
M30434 N1202 n5618 VSS VSS nmos W=0.155u L=0.04u
M30435 U7123/XI1-net8 n5618 VDD VDD pmos W=0.205u L=0.04u
M30436 N1202 n6043 U7123/XI1-net8 VDD pmos W=0.205u L=0.04u
M30437 U7124/net13 g2814 VSS VSS nmos W=0.155u L=0.04u
M30438 U7124/net16 U7124/net13 VSS VSS nmos W=0.155u L=0.04u
M30439 n5618 n6040 U7124/net16 VSS nmos W=0.155u L=0.04u
M30440 U7124/net13 g2814 VDD VDD pmos W=0.205u L=0.04u
M30441 VDD U7124/net13 n5618 VDD pmos W=0.205u L=0.04u
M30442 VDD n6040 n5618 VDD pmos W=0.205u L=0.04u
M30443 U7125/XU1-net6 n6045 VSS VSS nmos W=0.155u L=0.04u
M30444 n6040 n6044 U7125/XU1-net6 VSS nmos W=0.155u L=0.04u
M30445 n6040 n6045 VDD VDD pmos W=0.155u L=0.04u
M30446 n6040 n6044 VDD VDD pmos W=0.155u L=0.04u
M30447 n6045 II20514 VSS VSS nmos W=0.155u L=0.04u
M30448 n6045 g2883 VSS VSS nmos W=0.155u L=0.04u
M30449 n6045 g2896 VSS VSS nmos W=0.155u L=0.04u
M30450 n6045 g2900 VSS VSS nmos W=0.155u L=0.04u
M30451 U7126/net49 g2883 U7126/net52 VDD pmos W=0.41u L=0.04u
M30452 U7126/net52 II20514 VDD VDD pmos W=0.41u L=0.04u
M30453 U7126/net46 g2896 U7126/net49 VDD pmos W=0.41u L=0.04u
M30454 n6045 g2900 U7126/net46 VDD pmos W=0.41u L=0.04u
M30455 n6044 U7127/net6 VSS VSS nmos W=0.155u L=0.04u
M30456 U7127/net6 g2888 U7127/XU30-net23 VSS nmos W=0.155u L=0.04u
M30457 U7127/XU30-net23 g2892 U7127/XU30-net26 VSS nmos W=0.155u L=0.04u
M30458 U7127/XU30-net26 g2903 U7127/XU30-net29 VSS nmos W=0.155u L=0.04u
M30459 U7127/XU30-net29 g2908 VSS VSS nmos W=0.155u L=0.04u
M30460 n6044 U7127/net6 VDD VDD pmos W=0.205u L=0.04u
M30461 U7127/net6 g2908 VDD VDD pmos W=0.205u L=0.04u
M30462 U7127/net6 g2903 VDD VDD pmos W=0.205u L=0.04u
M30463 U7127/net6 g2892 VDD VDD pmos W=0.205u L=0.04u
M30464 U7127/net6 g2888 VDD VDD pmos W=0.205u L=0.04u
M30465 n6043 n6046 U7128/net27 VSS nmos W=0.155u L=0.04u
M30466 U7128/net27 II20514 VSS VSS nmos W=0.155u L=0.04u
M30467 n6043 n5611 VSS VSS nmos W=0.155u L=0.04u
M30468 n6043 II20514 U7128/net13 VDD pmos W=0.205u L=0.04u
M30469 U7128/net13 n5611 VDD VDD pmos W=0.205u L=0.04u
M30470 n6043 n6046 U7128/net13 VDD pmos W=0.205u L=0.04u
M30471 n5611 n6046 VSS VSS nmos W=0.155u L=0.04u
M30472 n5611 II20514 VSS VSS nmos W=0.155u L=0.04u
M30473 U7129/XI1-net8 II20514 VDD VDD pmos W=0.205u L=0.04u
M30474 n5611 n6046 U7129/XI1-net8 VDD pmos W=0.205u L=0.04u
M30475 n6046 g2883 VSS VSS nmos W=0.135u L=0.04u
M30476 n6046 g2883 VDD VDD pmos W=0.205u L=0.04u
M30477 N1181 g3234 VSS VSS nmos W=0.155u L=0.04u
M30478 N1181 g3079 VSS VSS nmos W=0.155u L=0.04u
M30479 U7131/XI1-net8 g3079 VDD VDD pmos W=0.205u L=0.04u
M30480 N1181 g3234 U7131/XI1-net8 VDD pmos W=0.205u L=0.04u
M30481 N1004 g51 VSS VSS nmos W=0.155u L=0.04u
M30482 N1004 g2933 VSS VSS nmos W=0.155u L=0.04u
M30483 U7132/XI1-net8 g2933 VDD VDD pmos W=0.205u L=0.04u
M30484 N1004 g51 U7132/XI1-net8 VDD pmos W=0.205u L=0.04u
M30485 II20664 g2878 VSS VSS nmos W=0.135u L=0.04u
M30486 II20664 g2878 VDD VDD pmos W=0.205u L=0.04u
M30487 II20616 g2877 VSS VSS nmos W=0.135u L=0.04u
M30488 II20616 g2877 VDD VDD pmos W=0.205u L=0.04u
M30489 II20568 g2873 VSS VSS nmos W=0.135u L=0.04u
M30490 II20568 g2873 VDD VDD pmos W=0.205u L=0.04u
M30491 II20523 g3080 VSS VSS nmos W=0.135u L=0.04u
M30492 II20523 g3080 VDD VDD pmos W=0.205u L=0.04u
M30493 II20520 g2857 VSS VSS nmos W=0.135u L=0.04u
M30494 II20520 g2857 VDD VDD pmos W=0.205u L=0.04u
M30495 II20514 g2950 VSS VSS nmos W=0.135u L=0.04u
M30496 II20514 g2950 VDD VDD pmos W=0.205u L=0.04u
M30497 II18770 g2540 VSS VSS nmos W=0.135u L=0.04u
M30498 II18770 g2540 VDD VDD pmos W=0.205u L=0.04u
M30499 II18767 g2536 VSS VSS nmos W=0.135u L=0.04u
M30500 II18767 g2536 VDD VDD pmos W=0.205u L=0.04u
M30501 II18764 g2533 VSS VSS nmos W=0.135u L=0.04u
M30502 II18764 g2533 VDD VDD pmos W=0.205u L=0.04u
M30503 II18761 g2546 VSS VSS nmos W=0.135u L=0.04u
M30504 II18761 g2546 VDD VDD pmos W=0.205u L=0.04u
M30505 II18758 g2543 VSS VSS nmos W=0.135u L=0.04u
M30506 II18758 g2543 VDD VDD pmos W=0.205u L=0.04u
M30507 II18755 g2530 VSS VSS nmos W=0.135u L=0.04u
M30508 II18755 g2530 VDD VDD pmos W=0.205u L=0.04u
M30509 II18743 g2466 VSS VSS nmos W=0.135u L=0.04u
M30510 II18743 g2466 VDD VDD pmos W=0.205u L=0.04u
M30511 II18740 g2463 VSS VSS nmos W=0.135u L=0.04u
M30512 II18740 g2463 VDD VDD pmos W=0.205u L=0.04u
M30513 II18737 g2473 VSS VSS nmos W=0.135u L=0.04u
M30514 II18737 g2473 VDD VDD pmos W=0.205u L=0.04u
M30515 II18734 g2451 VSS VSS nmos W=0.135u L=0.04u
M30516 II18734 g2451 VDD VDD pmos W=0.205u L=0.04u
M30517 II18731 g2448 VSS VSS nmos W=0.135u L=0.04u
M30518 II18731 g2448 VDD VDD pmos W=0.205u L=0.04u
M30519 II18728 g2459 VSS VSS nmos W=0.135u L=0.04u
M30520 II18728 g2459 VDD VDD pmos W=0.205u L=0.04u
M30521 II18725 g2436 VSS VSS nmos W=0.135u L=0.04u
M30522 II18725 g2436 VDD VDD pmos W=0.205u L=0.04u
M30523 II18722 g2433 VSS VSS nmos W=0.135u L=0.04u
M30524 II18722 g2433 VDD VDD pmos W=0.205u L=0.04u
M30525 II18719 g2444 VSS VSS nmos W=0.135u L=0.04u
M30526 II18719 g2444 VDD VDD pmos W=0.205u L=0.04u
M30527 II18716 g2421 VSS VSS nmos W=0.135u L=0.04u
M30528 II18716 g2421 VDD VDD pmos W=0.205u L=0.04u
M30529 II18713 g2418 VSS VSS nmos W=0.135u L=0.04u
M30530 II18713 g2418 VDD VDD pmos W=0.205u L=0.04u
M30531 II18710 g2429 VSS VSS nmos W=0.135u L=0.04u
M30532 II18710 g2429 VDD VDD pmos W=0.205u L=0.04u
M30533 II18689 g1846 VSS VSS nmos W=0.135u L=0.04u
M30534 II18689 g1846 VDD VDD pmos W=0.205u L=0.04u
M30535 II18686 g1842 VSS VSS nmos W=0.135u L=0.04u
M30536 II18686 g1842 VDD VDD pmos W=0.205u L=0.04u
M30537 II18683 g1839 VSS VSS nmos W=0.135u L=0.04u
M30538 II18683 g1839 VDD VDD pmos W=0.205u L=0.04u
M30539 II18680 g1852 VSS VSS nmos W=0.135u L=0.04u
M30540 II18680 g1852 VDD VDD pmos W=0.205u L=0.04u
M30541 II18677 g1849 VSS VSS nmos W=0.135u L=0.04u
M30542 II18677 g1849 VDD VDD pmos W=0.205u L=0.04u
M30543 II18674 g1836 VSS VSS nmos W=0.135u L=0.04u
M30544 II18674 g1836 VDD VDD pmos W=0.205u L=0.04u
M30545 II18662 g1772 VSS VSS nmos W=0.135u L=0.04u
M30546 II18662 g1772 VDD VDD pmos W=0.205u L=0.04u
M30547 II18659 g1769 VSS VSS nmos W=0.135u L=0.04u
M30548 II18659 g1769 VDD VDD pmos W=0.205u L=0.04u
M30549 II18656 g1779 VSS VSS nmos W=0.135u L=0.04u
M30550 II18656 g1779 VDD VDD pmos W=0.205u L=0.04u
M30551 II18653 g1757 VSS VSS nmos W=0.135u L=0.04u
M30552 II18653 g1757 VDD VDD pmos W=0.205u L=0.04u
M30553 II18650 g1754 VSS VSS nmos W=0.135u L=0.04u
M30554 II18650 g1754 VDD VDD pmos W=0.205u L=0.04u
M30555 II18647 g1765 VSS VSS nmos W=0.135u L=0.04u
M30556 II18647 g1765 VDD VDD pmos W=0.205u L=0.04u
M30557 II18644 g1742 VSS VSS nmos W=0.135u L=0.04u
M30558 II18644 g1742 VDD VDD pmos W=0.205u L=0.04u
M30559 II18641 g1739 VSS VSS nmos W=0.135u L=0.04u
M30560 II18641 g1739 VDD VDD pmos W=0.205u L=0.04u
M30561 II18638 g1750 VSS VSS nmos W=0.135u L=0.04u
M30562 II18638 g1750 VDD VDD pmos W=0.205u L=0.04u
M30563 II18635 g1727 VSS VSS nmos W=0.135u L=0.04u
M30564 II18635 g1727 VDD VDD pmos W=0.205u L=0.04u
M30565 II18632 g1724 VSS VSS nmos W=0.135u L=0.04u
M30566 II18632 g1724 VDD VDD pmos W=0.205u L=0.04u
M30567 II18629 g1735 VSS VSS nmos W=0.135u L=0.04u
M30568 II18629 g1735 VDD VDD pmos W=0.205u L=0.04u
M30569 II18608 g1152 VSS VSS nmos W=0.135u L=0.04u
M30570 II18608 g1152 VDD VDD pmos W=0.205u L=0.04u
M30571 II18605 g1148 VSS VSS nmos W=0.135u L=0.04u
M30572 II18605 g1148 VDD VDD pmos W=0.205u L=0.04u
M30573 II18602 g1145 VSS VSS nmos W=0.135u L=0.04u
M30574 II18602 g1145 VDD VDD pmos W=0.205u L=0.04u
M30575 II18599 g1158 VSS VSS nmos W=0.135u L=0.04u
M30576 II18599 g1158 VDD VDD pmos W=0.205u L=0.04u
M30577 II18596 g1155 VSS VSS nmos W=0.135u L=0.04u
M30578 II18596 g1155 VDD VDD pmos W=0.205u L=0.04u
M30579 II18593 g1142 VSS VSS nmos W=0.135u L=0.04u
M30580 II18593 g1142 VDD VDD pmos W=0.205u L=0.04u
M30581 II18581 g1078 VSS VSS nmos W=0.135u L=0.04u
M30582 II18581 g1078 VDD VDD pmos W=0.205u L=0.04u
M30583 II18578 g1075 VSS VSS nmos W=0.135u L=0.04u
M30584 II18578 g1075 VDD VDD pmos W=0.205u L=0.04u
M30585 II18575 g1085 VSS VSS nmos W=0.135u L=0.04u
M30586 II18575 g1085 VDD VDD pmos W=0.205u L=0.04u
M30587 II18572 g1063 VSS VSS nmos W=0.135u L=0.04u
M30588 II18572 g1063 VDD VDD pmos W=0.205u L=0.04u
M30589 II18569 g1060 VSS VSS nmos W=0.135u L=0.04u
M30590 II18569 g1060 VDD VDD pmos W=0.205u L=0.04u
M30591 II18566 g1071 VSS VSS nmos W=0.135u L=0.04u
M30592 II18566 g1071 VDD VDD pmos W=0.205u L=0.04u
M30593 II18563 g1048 VSS VSS nmos W=0.135u L=0.04u
M30594 II18563 g1048 VDD VDD pmos W=0.205u L=0.04u
M30595 II18560 g1045 VSS VSS nmos W=0.135u L=0.04u
M30596 II18560 g1045 VDD VDD pmos W=0.205u L=0.04u
M30597 II18557 g1056 VSS VSS nmos W=0.135u L=0.04u
M30598 II18557 g1056 VDD VDD pmos W=0.205u L=0.04u
M30599 II18554 g1033 VSS VSS nmos W=0.135u L=0.04u
M30600 II18554 g1033 VDD VDD pmos W=0.205u L=0.04u
M30601 II18551 g1030 VSS VSS nmos W=0.135u L=0.04u
M30602 II18551 g1030 VDD VDD pmos W=0.205u L=0.04u
M30603 II18548 g1041 VSS VSS nmos W=0.135u L=0.04u
M30604 II18548 g1041 VDD VDD pmos W=0.205u L=0.04u
M30605 II18527 g465 VSS VSS nmos W=0.135u L=0.04u
M30606 II18527 g465 VDD VDD pmos W=0.205u L=0.04u
M30607 II18524 g461 VSS VSS nmos W=0.135u L=0.04u
M30608 II18524 g461 VDD VDD pmos W=0.205u L=0.04u
M30609 II18521 g458 VSS VSS nmos W=0.135u L=0.04u
M30610 II18521 g458 VDD VDD pmos W=0.205u L=0.04u
M30611 II18518 g471 VSS VSS nmos W=0.135u L=0.04u
M30612 II18518 g471 VDD VDD pmos W=0.205u L=0.04u
M30613 II18515 g468 VSS VSS nmos W=0.135u L=0.04u
M30614 II18515 g468 VDD VDD pmos W=0.205u L=0.04u
M30615 II18512 g455 VSS VSS nmos W=0.135u L=0.04u
M30616 II18512 g455 VDD VDD pmos W=0.205u L=0.04u
M30617 II18500 g391 VSS VSS nmos W=0.135u L=0.04u
M30618 II18500 g391 VDD VDD pmos W=0.205u L=0.04u
M30619 II18497 g388 VSS VSS nmos W=0.135u L=0.04u
M30620 II18497 g388 VDD VDD pmos W=0.205u L=0.04u
M30621 II18494 g398 VSS VSS nmos W=0.135u L=0.04u
M30622 II18494 g398 VDD VDD pmos W=0.205u L=0.04u
M30623 II18491 g376 VSS VSS nmos W=0.135u L=0.04u
M30624 II18491 g376 VDD VDD pmos W=0.205u L=0.04u
M30625 II18488 g373 VSS VSS nmos W=0.135u L=0.04u
M30626 II18488 g373 VDD VDD pmos W=0.205u L=0.04u
M30627 II18485 g384 VSS VSS nmos W=0.135u L=0.04u
M30628 II18485 g384 VDD VDD pmos W=0.205u L=0.04u
M30629 II18482 g361 VSS VSS nmos W=0.135u L=0.04u
M30630 II18482 g361 VDD VDD pmos W=0.205u L=0.04u
M30631 II18479 g358 VSS VSS nmos W=0.135u L=0.04u
M30632 II18479 g358 VDD VDD pmos W=0.205u L=0.04u
M30633 II18476 g369 VSS VSS nmos W=0.135u L=0.04u
M30634 II18476 g369 VDD VDD pmos W=0.205u L=0.04u
M30635 II18473 g346 VSS VSS nmos W=0.135u L=0.04u
M30636 II18473 g346 VDD VDD pmos W=0.205u L=0.04u
M30637 II18470 g343 VSS VSS nmos W=0.135u L=0.04u
M30638 II18470 g343 VDD VDD pmos W=0.205u L=0.04u
M30639 II18467 g354 VSS VSS nmos W=0.135u L=0.04u
M30640 II18467 g354 VDD VDD pmos W=0.205u L=0.04u
M30641 II15517 g2574 VSS VSS nmos W=0.135u L=0.04u
M30642 II15517 g2574 VDD VDD pmos W=0.205u L=0.04u
M30643 II15511 g1880 VSS VSS nmos W=0.135u L=0.04u
M30644 II15511 g1880 VDD VDD pmos W=0.205u L=0.04u
M30645 II15505 g1186 VSS VSS nmos W=0.135u L=0.04u
M30646 II15505 g1186 VDD VDD pmos W=0.205u L=0.04u
M30647 II15499 g499 VSS VSS nmos W=0.135u L=0.04u
M30648 II15499 g499 VDD VDD pmos W=0.205u L=0.04u
M30649 II14094 g5637 VSS VSS nmos W=0.135u L=0.04u
M30650 II14094 g5637 VDD VDD pmos W=0.205u L=0.04u
M30651 II14069 g5612 VSS VSS nmos W=0.135u L=0.04u
M30652 II14069 g5612 VDD VDD pmos W=0.205u L=0.04u
M30653 II14052 g5595 VSS VSS nmos W=0.135u L=0.04u
M30654 II14052 g5595 VDD VDD pmos W=0.205u L=0.04u
M30655 II14030 g5549 VSS VSS nmos W=0.135u L=0.04u
M30656 II14030 g5549 VDD VDD pmos W=0.205u L=0.04u
.ENDS
