.SUBCKT c5315 N1 N4 N11 N14 N17 N20 N23 N24 N25 N26 N27 N31 N34 N37 N40 N43 N46 N49 N52 N53 N54 N61 N64 N67 N70 N73 N76 N79 N80 N81 N82 N83 N86 N87 N88 N91 N94 N97 N100 N103 N106 N109 N112 N113 N114 N115 N116 N117 N118 N119 N120 N121 N122 N123 N126 N127 N128 N129 N130 N131 N132 N135 N136 N137 N140 N141 N145 N146 N149 N152 N155 N158 N161 N164 N167 N170 N173 N176 N179 N182 N185 N188 N191 N194 N197 N200 N203 N206 N209 N210 N217 N218 N225 N226 N233 N234 N241 N242 N245 N248 N251 N254 N257 N264 N265 N272 N273 N280 N281 N288 N289 N292 N293 N299 N302 N307 N308 N315 N316 N323 N324 N331 N332 N335 N338 N341 N348 N351 N358 N361 N366 N369 N372 N373 N374 N386 N389 N400 N411 N422 N435 N446 N457 N468 N479 N490 N503 N514 N523 N534 N545 N549 N552 N556 N559 N562 N566 N571 N574 N577 N580 N583 N588 N591 N592 N595 N596 N597 N598 N599 N603 N607 N610 N613 N616 N619 N625 N631 N1137 N1138 N1139 N1140 N1141 N1144 N1145 N1147 N1152 N1153 N1154 N1155 N0 N2054 N2060 N2061 N2590 N2623 N3613 N4272 N4278 N4279 N4737 N4738 N4739 N4740 N5240 N5388 N6648 N6646 N6716 N6877 N6926 N6927 N7015 N7363 N7365 N7432 N7449 N7465 N7466 N7467 N7469 N7470 N7471 N7472 N7473 N7474 N7476 N7503 N7504 N7506 N7511 N7515 N7516 N7517 N7518 N7519 N7520 N7521 N7522 N7600 N7601 N7602 N7603 N7604 N7605 N7606 N7607 N7626 N7698 N7699 N7700 N7701 N7702 N7703 N7704 N7705 N7706 N7707 N7735 N7736 N7737 N7738 N7739 N7740 N7741 N7742 N7754 N7755 N7756 N7757 N7758 N7759 N7760 N7761 N8075 N8076 N8123 N8124 N8127 N8128 VDD VSS
M1 U628/XU1-net6 N137 VSS VSS nmos W=0.155u L=0.04u
M2 N8128 n568 U628/XU1-net6 VSS nmos W=0.155u L=0.04u
M3 N8128 N137 VDD VDD pmos W=0.155u L=0.04u
M4 N8128 n568 VDD VDD pmos W=0.155u L=0.04u
M5 U629/net24 N580 VSS VSS nmos W=0.155u L=0.04u
M6 U629/net74 n571 VSS VSS nmos W=0.155u L=0.04u
M7 U629/net72 n569 VSS VSS nmos W=0.155u L=0.04u
M8 U629/net76 n572 VSS VSS nmos W=0.31u L=0.04u
M9 U629/net044 N577 VSS VSS nmos W=0.155u L=0.04u
M10 U629/net052 n570 VSS VSS nmos W=0.31u L=0.04u
M11 U629/PG2 N580 n568 VSS nmos W=0.22u L=0.04u
M12 U629/net74 U629/net044 U629/PG2 VSS nmos W=0.12u L=0.04u
M13 U629/net052 N577 U629/PG1 VSS nmos W=0.155u L=0.04u
M14 U629/PG1 U629/net24 n568 VSS nmos W=0.155u L=0.04u
M15 U629/net76 N577 U629/PG2 VSS nmos W=0.155u L=0.04u
M16 U629/net72 U629/net044 U629/PG1 VSS nmos W=0.12u L=0.04u
M17 U629/net24 N580 VDD VDD pmos W=0.205u L=0.04u
M18 U629/net74 n571 VDD VDD pmos W=0.205u L=0.04u
M19 U629/net72 n569 VDD VDD pmos W=0.205u L=0.04u
M20 U629/net76 n572 VDD VDD pmos W=0.41u L=0.04u
M21 U629/net044 N577 VDD VDD pmos W=0.205u L=0.04u
M22 U629/net052 n570 VDD VDD pmos W=0.41u L=0.04u
M23 U629/PG2 U629/net24 n568 VDD pmos W=0.205u L=0.04u
M24 U629/net74 N577 U629/PG2 VDD pmos W=0.205u L=0.04u
M25 U629/net052 U629/net044 U629/PG1 VDD pmos W=0.205u L=0.04u
M26 U629/PG1 N580 n568 VDD pmos W=0.29u L=0.04u
M27 U629/net76 U629/net044 U629/PG2 VDD pmos W=0.205u L=0.04u
M28 U629/net72 N577 U629/PG1 VDD pmos W=0.205u L=0.04u
M29 U630/XU1-net6 N137 VSS VSS nmos W=0.155u L=0.04u
M30 N8127 n573 U630/XU1-net6 VSS nmos W=0.155u L=0.04u
M31 N8127 N137 VDD VDD pmos W=0.155u L=0.04u
M32 N8127 n573 VDD VDD pmos W=0.155u L=0.04u
M33 U631/net24 N574 VSS VSS nmos W=0.155u L=0.04u
M34 U631/net74 n571 VSS VSS nmos W=0.155u L=0.04u
M35 U631/net72 n569 VSS VSS nmos W=0.155u L=0.04u
M36 U631/net76 n572 VSS VSS nmos W=0.31u L=0.04u
M37 U631/net044 N571 VSS VSS nmos W=0.155u L=0.04u
M38 U631/net052 n570 VSS VSS nmos W=0.31u L=0.04u
M39 U631/PG2 N574 n573 VSS nmos W=0.22u L=0.04u
M40 U631/net74 U631/net044 U631/PG2 VSS nmos W=0.12u L=0.04u
M41 U631/net052 N571 U631/PG1 VSS nmos W=0.155u L=0.04u
M42 U631/PG1 U631/net24 n573 VSS nmos W=0.155u L=0.04u
M43 U631/net76 N571 U631/PG2 VSS nmos W=0.155u L=0.04u
M44 U631/net72 U631/net044 U631/PG1 VSS nmos W=0.12u L=0.04u
M45 U631/net24 N574 VDD VDD pmos W=0.205u L=0.04u
M46 U631/net74 n571 VDD VDD pmos W=0.205u L=0.04u
M47 U631/net72 n569 VDD VDD pmos W=0.205u L=0.04u
M48 U631/net76 n572 VDD VDD pmos W=0.41u L=0.04u
M49 U631/net044 N571 VDD VDD pmos W=0.205u L=0.04u
M50 U631/net052 n570 VDD VDD pmos W=0.41u L=0.04u
M51 U631/PG2 U631/net24 n573 VDD pmos W=0.205u L=0.04u
M52 U631/net74 N571 U631/PG2 VDD pmos W=0.205u L=0.04u
M53 U631/net052 U631/net044 U631/PG1 VDD pmos W=0.205u L=0.04u
M54 U631/PG1 N574 n573 VDD pmos W=0.29u L=0.04u
M55 U631/net76 U631/net044 U631/PG2 VDD pmos W=0.205u L=0.04u
M56 U631/net72 N571 U631/PG1 VDD pmos W=0.205u L=0.04u
M57 n572 N179 VSS VSS nmos W=0.135u L=0.04u
M58 n572 N179 VDD VDD pmos W=0.205u L=0.04u
M59 n571 N176 VSS VSS nmos W=0.135u L=0.04u
M60 n571 N176 VDD VDD pmos W=0.205u L=0.04u
M61 N8124 n574 U634/net26 VSS nmos W=0.155u L=0.04u
M62 N8124 n569 U634/net26 VSS nmos W=0.155u L=0.04u
M63 U634/net29 n576 VSS VSS nmos W=0.155u L=0.04u
M64 U634/net26 n570 U634/net29 VSS nmos W=0.155u L=0.04u
M65 U634/net26 n575 U634/net29 VSS nmos W=0.155u L=0.04u
M66 N8124 n569 U634/net43 VDD pmos W=0.205u L=0.04u
M67 N8124 n575 U634/net49 VDD pmos W=0.205u L=0.04u
M68 U634/net49 n570 VDD VDD pmos W=0.205u L=0.04u
M69 U634/net43 n574 VDD VDD pmos W=0.205u L=0.04u
M70 N8124 n576 VDD VDD pmos W=0.205u L=0.04u
M71 U635/net29 n578 VSS VSS nmos W=0.155u L=0.04u
M72 n576 N14 U635/net29 VSS nmos W=0.155u L=0.04u
M73 n576 N64 U635/net23 VSS nmos W=0.155u L=0.04u
M74 U635/net23 n577 VSS VSS nmos W=0.155u L=0.04u
M75 U635/net20 n577 n576 VDD pmos W=0.205u L=0.04u
M76 U635/net20 N64 n576 VDD pmos W=0.205u L=0.04u
M77 VDD N14 U635/net20 VDD pmos W=0.205u L=0.04u
M78 VDD n578 U635/net20 VDD pmos W=0.205u L=0.04u
M79 N8123 n579 U636/net26 VSS nmos W=0.155u L=0.04u
M80 N8123 n569 U636/net26 VSS nmos W=0.155u L=0.04u
M81 U636/net29 n581 VSS VSS nmos W=0.155u L=0.04u
M82 U636/net26 n570 U636/net29 VSS nmos W=0.155u L=0.04u
M83 U636/net26 n580 U636/net29 VSS nmos W=0.155u L=0.04u
M84 N8123 n569 U636/net43 VDD pmos W=0.205u L=0.04u
M85 N8123 n580 U636/net49 VDD pmos W=0.205u L=0.04u
M86 U636/net49 n570 VDD VDD pmos W=0.205u L=0.04u
M87 U636/net43 n579 VDD VDD pmos W=0.205u L=0.04u
M88 N8123 n581 VDD VDD pmos W=0.205u L=0.04u
M89 U637/net29 N64 VSS VSS nmos W=0.155u L=0.04u
M90 n581 n583 U637/net29 VSS nmos W=0.155u L=0.04u
M91 n581 n582 U637/net23 VSS nmos W=0.155u L=0.04u
M92 U637/net23 N14 VSS VSS nmos W=0.155u L=0.04u
M93 U637/net20 N14 n581 VDD pmos W=0.205u L=0.04u
M94 U637/net20 n582 n581 VDD pmos W=0.205u L=0.04u
M95 VDD n583 U637/net20 VDD pmos W=0.205u L=0.04u
M96 VDD N64 U637/net20 VDD pmos W=0.205u L=0.04u
M97 n570 n586 U638/XI21-net17 VSS nmos W=0.155u L=0.04u
M98 U638/XI21-net17 n587 VSS VSS nmos W=0.155u L=0.04u
M99 n570 n584 U638/XI6-net17 VSS nmos W=0.155u L=0.04u
M100 U638/XI6-net17 n585 VSS VSS nmos W=0.155u L=0.04u
M101 n570 N97 U638/XI20-net17 VSS nmos W=0.155u L=0.04u
M102 U638/XI20-net17 N625 VSS VSS nmos W=0.155u L=0.04u
M103 VDD n586 U638/net22 VDD pmos W=0.205u L=0.04u
M104 VDD n587 U638/net22 VDD pmos W=0.205u L=0.04u
M105 U638/net16 n584 n570 VDD pmos W=0.205u L=0.04u
M106 U638/net16 n585 n570 VDD pmos W=0.205u L=0.04u
M107 U638/net22 N97 U638/net16 VDD pmos W=0.205u L=0.04u
M108 U638/net22 N625 U638/net16 VDD pmos W=0.205u L=0.04u
M109 n569 n586 U639/XI21-net17 VSS nmos W=0.155u L=0.04u
M110 U639/XI21-net17 n589 VSS VSS nmos W=0.155u L=0.04u
M111 n569 n588 U639/XI6-net17 VSS nmos W=0.155u L=0.04u
M112 U639/XI6-net17 n584 VSS VSS nmos W=0.155u L=0.04u
M113 n569 N94 U639/XI20-net17 VSS nmos W=0.155u L=0.04u
M114 U639/XI20-net17 N625 VSS VSS nmos W=0.155u L=0.04u
M115 VDD n586 U639/net22 VDD pmos W=0.205u L=0.04u
M116 VDD n589 U639/net22 VDD pmos W=0.205u L=0.04u
M117 U639/net16 n588 n569 VDD pmos W=0.205u L=0.04u
M118 U639/net16 n584 n569 VDD pmos W=0.205u L=0.04u
M119 U639/net22 N94 U639/net16 VDD pmos W=0.205u L=0.04u
M120 U639/net22 N625 U639/net16 VDD pmos W=0.205u L=0.04u
M121 N8076 n590 U640/net26 VSS nmos W=0.155u L=0.04u
M122 N8076 n587 U640/net26 VSS nmos W=0.155u L=0.04u
M123 U640/net29 n592 VSS VSS nmos W=0.155u L=0.04u
M124 U640/net26 n591 U640/net29 VSS nmos W=0.155u L=0.04u
M125 U640/net26 n585 U640/net29 VSS nmos W=0.155u L=0.04u
M126 N8076 n587 U640/net43 VDD pmos W=0.205u L=0.04u
M127 N8076 n585 U640/net49 VDD pmos W=0.205u L=0.04u
M128 U640/net49 n591 VDD VDD pmos W=0.205u L=0.04u
M129 U640/net43 n590 VDD VDD pmos W=0.205u L=0.04u
M130 N8076 n592 VDD VDD pmos W=0.205u L=0.04u
M131 n592 N118 U641/net15 VSS nmos W=0.155u L=0.04u
M132 n592 N619 U641/net15 VSS nmos W=0.155u L=0.04u
M133 U641/net15 N625 VSS VSS nmos W=0.155u L=0.04u
M134 n592 N625 VDD VDD pmos W=0.205u L=0.04u
M135 n592 N118 U641/XI16-net11 VDD pmos W=0.205u L=0.04u
M136 U641/XI16-net11 N619 VDD VDD pmos W=0.205u L=0.04u
M137 U642/net29 U642/net21 U642/net041 VSS nmos W=0.155u L=0.04u
M138 U642/net035 U642/net19 VSS VSS nmos W=0.155u L=0.04u
M139 U642/net041 U642/net13 VSS VSS nmos W=0.155u L=0.04u
M140 U642/net25 n594 U642/net035 VSS nmos W=0.155u L=0.04u
M141 U642/net19 U642/net17 U642/net25 VSS nmos W=0.155u L=0.04u
M142 U642/net13 U642/net25 U642/net29 VSS nmos W=0.155u L=0.04u
M143 n585 U642/net29 VSS VSS nmos W=0.155u L=0.04u
M144 U642/net13 n595 VSS VSS nmos W=0.155u L=0.04u
M145 U642/net17 n594 VSS VSS nmos W=0.155u L=0.04u
M146 U642/net19 n593 VSS VSS nmos W=0.155u L=0.04u
M147 U642/net21 U642/net25 VSS VSS nmos W=0.155u L=0.04u
M148 U642/net028 U642/net19 VDD VDD pmos W=0.205u L=0.04u
M149 U642/net25 U642/net17 U642/net028 VDD pmos W=0.205u L=0.04u
M150 U642/net29 U642/net25 U642/net029 VDD pmos W=0.205u L=0.04u
M151 U642/net029 U642/net13 VDD VDD pmos W=0.205u L=0.04u
M152 U642/net19 n594 U642/net25 VDD pmos W=0.205u L=0.04u
M153 U642/net13 U642/net21 U642/net29 VDD pmos W=0.205u L=0.04u
M154 n585 U642/net29 VDD VDD pmos W=0.205u L=0.04u
M155 U642/net13 n595 VDD VDD pmos W=0.205u L=0.04u
M156 U642/net17 n594 VDD VDD pmos W=0.205u L=0.04u
M157 U642/net19 n593 VDD VDD pmos W=0.205u L=0.04u
M158 U642/net21 U642/net25 VDD VDD pmos W=0.205u L=0.04u
M159 U643/net24 N468 VSS VSS nmos W=0.155u L=0.04u
M160 U643/net74 N251 VSS VSS nmos W=0.155u L=0.04u
M161 U643/net72 n596 VSS VSS nmos W=0.155u L=0.04u
M162 U643/net76 N248 VSS VSS nmos W=0.31u L=0.04u
M163 U643/net044 N218 VSS VSS nmos W=0.155u L=0.04u
M164 U643/net052 n597 VSS VSS nmos W=0.31u L=0.04u
M165 U643/PG2 N468 n595 VSS nmos W=0.22u L=0.04u
M166 U643/net74 U643/net044 U643/PG2 VSS nmos W=0.12u L=0.04u
M167 U643/net052 N218 U643/PG1 VSS nmos W=0.155u L=0.04u
M168 U643/PG1 U643/net24 n595 VSS nmos W=0.155u L=0.04u
M169 U643/net76 N218 U643/PG2 VSS nmos W=0.155u L=0.04u
M170 U643/net72 U643/net044 U643/PG1 VSS nmos W=0.12u L=0.04u
M171 U643/net24 N468 VDD VDD pmos W=0.205u L=0.04u
M172 U643/net74 N251 VDD VDD pmos W=0.205u L=0.04u
M173 U643/net72 n596 VDD VDD pmos W=0.205u L=0.04u
M174 U643/net76 N248 VDD VDD pmos W=0.41u L=0.04u
M175 U643/net044 N218 VDD VDD pmos W=0.205u L=0.04u
M176 U643/net052 n597 VDD VDD pmos W=0.41u L=0.04u
M177 U643/PG2 U643/net24 n595 VDD pmos W=0.205u L=0.04u
M178 U643/net74 N218 U643/PG2 VDD pmos W=0.205u L=0.04u
M179 U643/net052 U643/net044 U643/PG1 VDD pmos W=0.205u L=0.04u
M180 U643/PG1 N468 n595 VDD pmos W=0.29u L=0.04u
M181 U643/net76 U643/net044 U643/PG2 VDD pmos W=0.205u L=0.04u
M182 U643/net72 N218 U643/PG1 VDD pmos W=0.205u L=0.04u
M183 U644/net28 U644/net20 U644/net64 VSS nmos W=0.155u L=0.04u
M184 U644/net24 U644/net30 U644/net32 VSS nmos W=0.155u L=0.04u
M185 U644/net28 U644/net40 U644/net24 VSS nmos W=0.155u L=0.04u
M186 U644/net40 n601 U644/net108 VSS nmos W=0.155u L=0.04u
M187 U644/net40 U644/net106 U644/net104 VSS nmos W=0.155u L=0.04u
M188 U644/net24 n598 U644/net050 VSS nmos W=0.155u L=0.04u
M189 U644/net050 U644/net32 VSS VSS nmos W=0.155u L=0.04u
M190 U644/net20 U644/net40 VSS VSS nmos W=0.155u L=0.04u
M191 U644/net106 n601 VSS VSS nmos W=0.155u L=0.04u
M192 U644/net104 n600 VSS VSS nmos W=0.155u L=0.04u
M193 U644/net30 n598 VSS VSS nmos W=0.155u L=0.04u
M194 U644/net108 U644/net104 VSS VSS nmos W=0.155u L=0.04u
M195 n594 U644/net28 VSS VSS nmos W=0.155u L=0.04u
M196 U644/net32 n599 VSS VSS nmos W=0.155u L=0.04u
M197 U644/net64 U644/net24 VSS VSS nmos W=0.2u L=0.04u
M198 U644/net28 U644/net40 U644/net64 VDD pmos W=0.205u L=0.04u
M199 U644/net24 n598 U644/net32 VDD pmos W=0.205u L=0.04u
M200 U644/net28 U644/net20 U644/net24 VDD pmos W=0.205u L=0.04u
M201 U644/net40 U644/net106 U644/net108 VDD pmos W=0.205u L=0.04u
M202 U644/net40 n601 U644/net104 VDD pmos W=0.205u L=0.04u
M203 U644/net20 U644/net40 VDD VDD pmos W=0.205u L=0.04u
M204 U644/net106 n601 VDD VDD pmos W=0.205u L=0.04u
M205 U644/net104 n600 VDD VDD pmos W=0.205u L=0.04u
M206 U644/net30 n598 VDD VDD pmos W=0.205u L=0.04u
M207 U644/net108 U644/net104 VDD VDD pmos W=0.205u L=0.04u
M208 n594 U644/net28 VDD VDD pmos W=0.205u L=0.04u
M209 U644/net32 n599 VDD VDD pmos W=0.205u L=0.04u
M210 U644/net64 U644/net24 VDD VDD pmos W=0.28u L=0.04u
M211 U644/net24 U644/net30 U644/net045 VDD pmos W=0.205u L=0.04u
M212 U644/net045 U644/net32 VDD VDD pmos W=0.205u L=0.04u
M213 U645/net24 N257 VSS VSS nmos W=0.155u L=0.04u
M214 U645/net74 N242 VSS VSS nmos W=0.155u L=0.04u
M215 U645/net72 N254 VSS VSS nmos W=0.155u L=0.04u
M216 U645/net76 n603 VSS VSS nmos W=0.31u L=0.04u
M217 U645/net044 N389 VSS VSS nmos W=0.155u L=0.04u
M218 U645/net052 n602 VSS VSS nmos W=0.31u L=0.04u
M219 U645/PG2 N257 n600 VSS nmos W=0.22u L=0.04u
M220 U645/net74 U645/net044 U645/PG2 VSS nmos W=0.12u L=0.04u
M221 U645/net052 N389 U645/PG1 VSS nmos W=0.155u L=0.04u
M222 U645/PG1 U645/net24 n600 VSS nmos W=0.155u L=0.04u
M223 U645/net76 N389 U645/PG2 VSS nmos W=0.155u L=0.04u
M224 U645/net72 U645/net044 U645/PG1 VSS nmos W=0.12u L=0.04u
M225 U645/net24 N257 VDD VDD pmos W=0.205u L=0.04u
M226 U645/net74 N242 VDD VDD pmos W=0.205u L=0.04u
M227 U645/net72 N254 VDD VDD pmos W=0.205u L=0.04u
M228 U645/net76 n603 VDD VDD pmos W=0.41u L=0.04u
M229 U645/net044 N389 VDD VDD pmos W=0.205u L=0.04u
M230 U645/net052 n602 VDD VDD pmos W=0.41u L=0.04u
M231 U645/PG2 U645/net24 n600 VDD pmos W=0.205u L=0.04u
M232 U645/net74 N389 U645/PG2 VDD pmos W=0.205u L=0.04u
M233 U645/net052 U645/net044 U645/PG1 VDD pmos W=0.205u L=0.04u
M234 U645/PG1 N257 n600 VDD pmos W=0.29u L=0.04u
M235 U645/net76 U645/net044 U645/PG2 VDD pmos W=0.205u L=0.04u
M236 U645/net72 N389 U645/PG1 VDD pmos W=0.205u L=0.04u
M237 U646/net24 N273 VSS VSS nmos W=0.155u L=0.04u
M238 U646/net74 N242 VSS VSS nmos W=0.155u L=0.04u
M239 U646/net72 N254 VSS VSS nmos W=0.155u L=0.04u
M240 U646/net76 n603 VSS VSS nmos W=0.31u L=0.04u
M241 U646/net044 N411 VSS VSS nmos W=0.155u L=0.04u
M242 U646/net052 n602 VSS VSS nmos W=0.31u L=0.04u
M243 U646/PG2 N273 n599 VSS nmos W=0.22u L=0.04u
M244 U646/net74 U646/net044 U646/PG2 VSS nmos W=0.12u L=0.04u
M245 U646/net052 N411 U646/PG1 VSS nmos W=0.155u L=0.04u
M246 U646/PG1 U646/net24 n599 VSS nmos W=0.155u L=0.04u
M247 U646/net76 N411 U646/PG2 VSS nmos W=0.155u L=0.04u
M248 U646/net72 U646/net044 U646/PG1 VSS nmos W=0.12u L=0.04u
M249 U646/net24 N273 VDD VDD pmos W=0.205u L=0.04u
M250 U646/net74 N242 VDD VDD pmos W=0.205u L=0.04u
M251 U646/net72 N254 VDD VDD pmos W=0.205u L=0.04u
M252 U646/net76 n603 VDD VDD pmos W=0.41u L=0.04u
M253 U646/net044 N411 VDD VDD pmos W=0.205u L=0.04u
M254 U646/net052 n602 VDD VDD pmos W=0.41u L=0.04u
M255 U646/PG2 U646/net24 n599 VDD pmos W=0.205u L=0.04u
M256 U646/net74 N411 U646/PG2 VDD pmos W=0.205u L=0.04u
M257 U646/net052 U646/net044 U646/PG1 VDD pmos W=0.205u L=0.04u
M258 U646/PG1 N273 n599 VDD pmos W=0.29u L=0.04u
M259 U646/net76 U646/net044 U646/PG2 VDD pmos W=0.205u L=0.04u
M260 U646/net72 N411 U646/PG1 VDD pmos W=0.205u L=0.04u
M261 U647/net24 N226 VSS VSS nmos W=0.155u L=0.04u
M262 U647/net74 N242 VSS VSS nmos W=0.155u L=0.04u
M263 U647/net72 N254 VSS VSS nmos W=0.155u L=0.04u
M264 U647/net76 n603 VSS VSS nmos W=0.31u L=0.04u
M265 U647/net044 N422 VSS VSS nmos W=0.155u L=0.04u
M266 U647/net052 n602 VSS VSS nmos W=0.31u L=0.04u
M267 U647/PG2 N226 n598 VSS nmos W=0.22u L=0.04u
M268 U647/net74 U647/net044 U647/PG2 VSS nmos W=0.12u L=0.04u
M269 U647/net052 N422 U647/PG1 VSS nmos W=0.155u L=0.04u
M270 U647/PG1 U647/net24 n598 VSS nmos W=0.155u L=0.04u
M271 U647/net76 N422 U647/PG2 VSS nmos W=0.155u L=0.04u
M272 U647/net72 U647/net044 U647/PG1 VSS nmos W=0.12u L=0.04u
M273 U647/net24 N226 VDD VDD pmos W=0.205u L=0.04u
M274 U647/net74 N242 VDD VDD pmos W=0.205u L=0.04u
M275 U647/net72 N254 VDD VDD pmos W=0.205u L=0.04u
M276 U647/net76 n603 VDD VDD pmos W=0.41u L=0.04u
M277 U647/net044 N422 VDD VDD pmos W=0.205u L=0.04u
M278 U647/net052 n602 VDD VDD pmos W=0.41u L=0.04u
M279 U647/PG2 U647/net24 n598 VDD pmos W=0.205u L=0.04u
M280 U647/net74 N422 U647/PG2 VDD pmos W=0.205u L=0.04u
M281 U647/net052 U647/net044 U647/PG1 VDD pmos W=0.205u L=0.04u
M282 U647/PG1 N226 n598 VDD pmos W=0.29u L=0.04u
M283 U647/net76 U647/net044 U647/PG2 VDD pmos W=0.205u L=0.04u
M284 U647/net72 N422 U647/PG1 VDD pmos W=0.205u L=0.04u
M285 U648/net28 U648/net20 U648/net64 VSS nmos W=0.155u L=0.04u
M286 U648/net24 U648/net30 U648/net32 VSS nmos W=0.155u L=0.04u
M287 U648/net28 U648/net40 U648/net24 VSS nmos W=0.155u L=0.04u
M288 U648/net40 n607 U648/net108 VSS nmos W=0.155u L=0.04u
M289 U648/net40 U648/net106 U648/net104 VSS nmos W=0.155u L=0.04u
M290 U648/net24 n604 U648/net050 VSS nmos W=0.155u L=0.04u
M291 U648/net050 U648/net32 VSS VSS nmos W=0.155u L=0.04u
M292 U648/net20 U648/net40 VSS VSS nmos W=0.155u L=0.04u
M293 U648/net106 n607 VSS VSS nmos W=0.155u L=0.04u
M294 U648/net104 n606 VSS VSS nmos W=0.155u L=0.04u
M295 U648/net30 n604 VSS VSS nmos W=0.155u L=0.04u
M296 U648/net108 U648/net104 VSS VSS nmos W=0.155u L=0.04u
M297 n593 U648/net28 VSS VSS nmos W=0.155u L=0.04u
M298 U648/net32 n605 VSS VSS nmos W=0.155u L=0.04u
M299 U648/net64 U648/net24 VSS VSS nmos W=0.2u L=0.04u
M300 U648/net28 U648/net40 U648/net64 VDD pmos W=0.205u L=0.04u
M301 U648/net24 n604 U648/net32 VDD pmos W=0.205u L=0.04u
M302 U648/net28 U648/net20 U648/net24 VDD pmos W=0.205u L=0.04u
M303 U648/net40 U648/net106 U648/net108 VDD pmos W=0.205u L=0.04u
M304 U648/net40 n607 U648/net104 VDD pmos W=0.205u L=0.04u
M305 U648/net20 U648/net40 VDD VDD pmos W=0.205u L=0.04u
M306 U648/net106 n607 VDD VDD pmos W=0.205u L=0.04u
M307 U648/net104 n606 VDD VDD pmos W=0.205u L=0.04u
M308 U648/net30 n604 VDD VDD pmos W=0.205u L=0.04u
M309 U648/net108 U648/net104 VDD VDD pmos W=0.205u L=0.04u
M310 n593 U648/net28 VDD VDD pmos W=0.205u L=0.04u
M311 U648/net32 n605 VDD VDD pmos W=0.205u L=0.04u
M312 U648/net64 U648/net24 VDD VDD pmos W=0.28u L=0.04u
M313 U648/net24 U648/net30 U648/net045 VDD pmos W=0.205u L=0.04u
M314 U648/net045 U648/net32 VDD VDD pmos W=0.205u L=0.04u
M315 U649/net24 N281 VSS VSS nmos W=0.155u L=0.04u
M316 U649/net74 N242 VSS VSS nmos W=0.155u L=0.04u
M317 U649/net72 N254 VSS VSS nmos W=0.155u L=0.04u
M318 U649/net76 n603 VSS VSS nmos W=0.31u L=0.04u
M319 U649/net044 N374 VSS VSS nmos W=0.155u L=0.04u
M320 U649/net052 n602 VSS VSS nmos W=0.31u L=0.04u
M321 U649/PG2 N281 n607 VSS nmos W=0.22u L=0.04u
M322 U649/net74 U649/net044 U649/PG2 VSS nmos W=0.12u L=0.04u
M323 U649/net052 N374 U649/PG1 VSS nmos W=0.155u L=0.04u
M324 U649/PG1 U649/net24 n607 VSS nmos W=0.155u L=0.04u
M325 U649/net76 N374 U649/PG2 VSS nmos W=0.155u L=0.04u
M326 U649/net72 U649/net044 U649/PG1 VSS nmos W=0.12u L=0.04u
M327 U649/net24 N281 VDD VDD pmos W=0.205u L=0.04u
M328 U649/net74 N242 VDD VDD pmos W=0.205u L=0.04u
M329 U649/net72 N254 VDD VDD pmos W=0.205u L=0.04u
M330 U649/net76 n603 VDD VDD pmos W=0.41u L=0.04u
M331 U649/net044 N374 VDD VDD pmos W=0.205u L=0.04u
M332 U649/net052 n602 VDD VDD pmos W=0.41u L=0.04u
M333 U649/PG2 U649/net24 n607 VDD pmos W=0.205u L=0.04u
M334 U649/net74 N374 U649/PG2 VDD pmos W=0.205u L=0.04u
M335 U649/net052 U649/net044 U649/PG1 VDD pmos W=0.205u L=0.04u
M336 U649/PG1 N281 n607 VDD pmos W=0.29u L=0.04u
M337 U649/net76 U649/net044 U649/PG2 VDD pmos W=0.205u L=0.04u
M338 U649/net72 N374 U649/PG1 VDD pmos W=0.205u L=0.04u
M339 U650/net24 N265 VSS VSS nmos W=0.155u L=0.04u
M340 U650/net74 N242 VSS VSS nmos W=0.155u L=0.04u
M341 U650/net72 N254 VSS VSS nmos W=0.155u L=0.04u
M342 U650/net76 n603 VSS VSS nmos W=0.31u L=0.04u
M343 U650/net044 N400 VSS VSS nmos W=0.155u L=0.04u
M344 U650/net052 n602 VSS VSS nmos W=0.31u L=0.04u
M345 U650/PG2 N265 n606 VSS nmos W=0.22u L=0.04u
M346 U650/net74 U650/net044 U650/PG2 VSS nmos W=0.12u L=0.04u
M347 U650/net052 N400 U650/PG1 VSS nmos W=0.155u L=0.04u
M348 U650/PG1 U650/net24 n606 VSS nmos W=0.155u L=0.04u
M349 U650/net76 N400 U650/PG2 VSS nmos W=0.155u L=0.04u
M350 U650/net72 U650/net044 U650/PG1 VSS nmos W=0.12u L=0.04u
M351 U650/net24 N265 VDD VDD pmos W=0.205u L=0.04u
M352 U650/net74 N242 VDD VDD pmos W=0.205u L=0.04u
M353 U650/net72 N254 VDD VDD pmos W=0.205u L=0.04u
M354 U650/net76 n603 VDD VDD pmos W=0.41u L=0.04u
M355 U650/net044 N400 VDD VDD pmos W=0.205u L=0.04u
M356 U650/net052 n602 VDD VDD pmos W=0.41u L=0.04u
M357 U650/PG2 U650/net24 n606 VDD pmos W=0.205u L=0.04u
M358 U650/net74 N400 U650/PG2 VDD pmos W=0.205u L=0.04u
M359 U650/net052 U650/net044 U650/PG1 VDD pmos W=0.205u L=0.04u
M360 U650/PG1 N265 n606 VDD pmos W=0.29u L=0.04u
M361 U650/net76 U650/net044 U650/PG2 VDD pmos W=0.205u L=0.04u
M362 U650/net72 N400 U650/PG1 VDD pmos W=0.205u L=0.04u
M363 U651/net24 N234 VSS VSS nmos W=0.155u L=0.04u
M364 U651/net74 N242 VSS VSS nmos W=0.155u L=0.04u
M365 U651/net72 N254 VSS VSS nmos W=0.155u L=0.04u
M366 U651/net76 n603 VSS VSS nmos W=0.31u L=0.04u
M367 U651/net044 N435 VSS VSS nmos W=0.155u L=0.04u
M368 U651/net052 n602 VSS VSS nmos W=0.31u L=0.04u
M369 U651/PG2 N234 n605 VSS nmos W=0.22u L=0.04u
M370 U651/net74 U651/net044 U651/PG2 VSS nmos W=0.12u L=0.04u
M371 U651/net052 N435 U651/PG1 VSS nmos W=0.155u L=0.04u
M372 U651/PG1 U651/net24 n605 VSS nmos W=0.155u L=0.04u
M373 U651/net76 N435 U651/PG2 VSS nmos W=0.155u L=0.04u
M374 U651/net72 U651/net044 U651/PG1 VSS nmos W=0.12u L=0.04u
M375 U651/net24 N234 VDD VDD pmos W=0.205u L=0.04u
M376 U651/net74 N242 VDD VDD pmos W=0.205u L=0.04u
M377 U651/net72 N254 VDD VDD pmos W=0.205u L=0.04u
M378 U651/net76 n603 VDD VDD pmos W=0.41u L=0.04u
M379 U651/net044 N435 VDD VDD pmos W=0.205u L=0.04u
M380 U651/net052 n602 VDD VDD pmos W=0.41u L=0.04u
M381 U651/PG2 U651/net24 n605 VDD pmos W=0.205u L=0.04u
M382 U651/net74 N435 U651/PG2 VDD pmos W=0.205u L=0.04u
M383 U651/net052 U651/net044 U651/PG1 VDD pmos W=0.205u L=0.04u
M384 U651/PG1 N234 n605 VDD pmos W=0.29u L=0.04u
M385 U651/net76 U651/net044 U651/PG2 VDD pmos W=0.205u L=0.04u
M386 U651/net72 N435 U651/PG1 VDD pmos W=0.205u L=0.04u
M387 U652/net24 N210 VSS VSS nmos W=0.155u L=0.04u
M388 U652/net74 N242 VSS VSS nmos W=0.155u L=0.04u
M389 U652/net72 N254 VSS VSS nmos W=0.155u L=0.04u
M390 U652/net76 n603 VSS VSS nmos W=0.31u L=0.04u
M391 U652/net044 N457 VSS VSS nmos W=0.155u L=0.04u
M392 U652/net052 n602 VSS VSS nmos W=0.31u L=0.04u
M393 U652/PG2 N210 n604 VSS nmos W=0.22u L=0.04u
M394 U652/net74 U652/net044 U652/PG2 VSS nmos W=0.12u L=0.04u
M395 U652/net052 N457 U652/PG1 VSS nmos W=0.155u L=0.04u
M396 U652/PG1 U652/net24 n604 VSS nmos W=0.155u L=0.04u
M397 U652/net76 N457 U652/PG2 VSS nmos W=0.155u L=0.04u
M398 U652/net72 U652/net044 U652/PG1 VSS nmos W=0.12u L=0.04u
M399 U652/net24 N210 VDD VDD pmos W=0.205u L=0.04u
M400 U652/net74 N242 VDD VDD pmos W=0.205u L=0.04u
M401 U652/net72 N254 VDD VDD pmos W=0.205u L=0.04u
M402 U652/net76 n603 VDD VDD pmos W=0.41u L=0.04u
M403 U652/net044 N457 VDD VDD pmos W=0.205u L=0.04u
M404 U652/net052 n602 VDD VDD pmos W=0.41u L=0.04u
M405 U652/PG2 U652/net24 n604 VDD pmos W=0.205u L=0.04u
M406 U652/net74 N457 U652/PG2 VDD pmos W=0.205u L=0.04u
M407 U652/net052 U652/net044 U652/PG1 VDD pmos W=0.205u L=0.04u
M408 U652/PG1 N210 n604 VDD pmos W=0.29u L=0.04u
M409 U652/net76 U652/net044 U652/PG2 VDD pmos W=0.205u L=0.04u
M410 U652/net72 N457 U652/PG1 VDD pmos W=0.205u L=0.04u
M411 U653/net4 U653/net10 U653/net14 VSS nmos W=0.155u L=0.04u
M412 U653/net6 n608 U653/net14 VSS nmos W=0.155u L=0.04u
M413 U653/net4 n609 VSS VSS nmos W=0.155u L=0.04u
M414 U653/net6 U653/net4 VSS VSS nmos W=0.155u L=0.04u
M415 n587 U653/net14 VSS VSS nmos W=0.155u L=0.04u
M416 U653/net10 n608 VSS VSS nmos W=0.155u L=0.04u
M417 U653/net4 n608 U653/net14 VDD pmos W=0.205u L=0.04u
M418 U653/net6 U653/net10 U653/net14 VDD pmos W=0.205u L=0.04u
M419 U653/net4 n609 VDD VDD pmos W=0.205u L=0.04u
M420 U653/net6 U653/net4 VDD VDD pmos W=0.205u L=0.04u
M421 n587 U653/net14 VDD VDD pmos W=0.205u L=0.04u
M422 U653/net10 n608 VDD VDD pmos W=0.205u L=0.04u
M423 U654/net19 N566 VSS VSS nmos W=0.155u L=0.04u
M424 n609 N566 U654/net40 VSS nmos W=0.155u L=0.04u
M425 n609 U654/net19 U654/net36 VSS nmos W=0.155u L=0.04u
M426 U654/net40 n611 VSS VSS nmos W=0.31u L=0.04u
M427 U654/net36 n610 VSS VSS nmos W=0.155u L=0.04u
M428 U654/net19 N566 VDD VDD pmos W=0.205u L=0.04u
M429 n609 U654/net19 U654/net26 VDD pmos W=0.325u L=0.04u
M430 U654/net26 n611 VDD VDD pmos W=0.41u L=0.04u
M431 n609 N566 U654/net30 VDD pmos W=0.325u L=0.04u
M432 U654/net30 n610 VDD VDD pmos W=0.205u L=0.04u
M433 U655/net28 U655/net20 U655/net64 VSS nmos W=0.155u L=0.04u
M434 U655/net24 U655/net30 U655/net32 VSS nmos W=0.155u L=0.04u
M435 U655/net28 U655/net40 U655/net24 VSS nmos W=0.155u L=0.04u
M436 U655/net40 n615 U655/net108 VSS nmos W=0.155u L=0.04u
M437 U655/net40 U655/net106 U655/net104 VSS nmos W=0.155u L=0.04u
M438 U655/net24 n612 U655/net050 VSS nmos W=0.155u L=0.04u
M439 U655/net050 U655/net32 VSS VSS nmos W=0.155u L=0.04u
M440 U655/net20 U655/net40 VSS VSS nmos W=0.155u L=0.04u
M441 U655/net106 n615 VSS VSS nmos W=0.155u L=0.04u
M442 U655/net104 n614 VSS VSS nmos W=0.155u L=0.04u
M443 U655/net30 n612 VSS VSS nmos W=0.155u L=0.04u
M444 U655/net108 U655/net104 VSS VSS nmos W=0.155u L=0.04u
M445 n611 U655/net28 VSS VSS nmos W=0.155u L=0.04u
M446 U655/net32 n613 VSS VSS nmos W=0.155u L=0.04u
M447 U655/net64 U655/net24 VSS VSS nmos W=0.2u L=0.04u
M448 U655/net28 U655/net40 U655/net64 VDD pmos W=0.205u L=0.04u
M449 U655/net24 n612 U655/net32 VDD pmos W=0.205u L=0.04u
M450 U655/net28 U655/net20 U655/net24 VDD pmos W=0.205u L=0.04u
M451 U655/net40 U655/net106 U655/net108 VDD pmos W=0.205u L=0.04u
M452 U655/net40 n615 U655/net104 VDD pmos W=0.205u L=0.04u
M453 U655/net20 U655/net40 VDD VDD pmos W=0.205u L=0.04u
M454 U655/net106 n615 VDD VDD pmos W=0.205u L=0.04u
M455 U655/net104 n614 VDD VDD pmos W=0.205u L=0.04u
M456 U655/net30 n612 VDD VDD pmos W=0.205u L=0.04u
M457 U655/net108 U655/net104 VDD VDD pmos W=0.205u L=0.04u
M458 n611 U655/net28 VDD VDD pmos W=0.205u L=0.04u
M459 U655/net32 n613 VDD VDD pmos W=0.205u L=0.04u
M460 U655/net64 U655/net24 VDD VDD pmos W=0.28u L=0.04u
M461 U655/net24 U655/net30 U655/net045 VDD pmos W=0.205u L=0.04u
M462 U655/net045 U655/net32 VDD VDD pmos W=0.205u L=0.04u
M463 U656/net28 U656/net20 U656/net64 VSS nmos W=0.155u L=0.04u
M464 U656/net24 U656/net30 U656/net32 VSS nmos W=0.155u L=0.04u
M465 U656/net28 U656/net40 U656/net24 VSS nmos W=0.155u L=0.04u
M466 U656/net40 n619 U656/net108 VSS nmos W=0.155u L=0.04u
M467 U656/net40 U656/net106 U656/net104 VSS nmos W=0.155u L=0.04u
M468 U656/net24 n616 U656/net050 VSS nmos W=0.155u L=0.04u
M469 U656/net050 U656/net32 VSS VSS nmos W=0.155u L=0.04u
M470 U656/net20 U656/net40 VSS VSS nmos W=0.155u L=0.04u
M471 U656/net106 n619 VSS VSS nmos W=0.155u L=0.04u
M472 U656/net104 n618 VSS VSS nmos W=0.155u L=0.04u
M473 U656/net30 n616 VSS VSS nmos W=0.155u L=0.04u
M474 U656/net108 U656/net104 VSS VSS nmos W=0.155u L=0.04u
M475 n615 U656/net28 VSS VSS nmos W=0.155u L=0.04u
M476 U656/net32 n617 VSS VSS nmos W=0.155u L=0.04u
M477 U656/net64 U656/net24 VSS VSS nmos W=0.2u L=0.04u
M478 U656/net28 U656/net40 U656/net64 VDD pmos W=0.205u L=0.04u
M479 U656/net24 n616 U656/net32 VDD pmos W=0.205u L=0.04u
M480 U656/net28 U656/net20 U656/net24 VDD pmos W=0.205u L=0.04u
M481 U656/net40 U656/net106 U656/net108 VDD pmos W=0.205u L=0.04u
M482 U656/net40 n619 U656/net104 VDD pmos W=0.205u L=0.04u
M483 U656/net20 U656/net40 VDD VDD pmos W=0.205u L=0.04u
M484 U656/net106 n619 VDD VDD pmos W=0.205u L=0.04u
M485 U656/net104 n618 VDD VDD pmos W=0.205u L=0.04u
M486 U656/net30 n616 VDD VDD pmos W=0.205u L=0.04u
M487 U656/net108 U656/net104 VDD VDD pmos W=0.205u L=0.04u
M488 n615 U656/net28 VDD VDD pmos W=0.205u L=0.04u
M489 U656/net32 n617 VDD VDD pmos W=0.205u L=0.04u
M490 U656/net64 U656/net24 VDD VDD pmos W=0.28u L=0.04u
M491 U656/net24 U656/net30 U656/net045 VDD pmos W=0.205u L=0.04u
M492 U656/net045 U656/net32 VDD VDD pmos W=0.205u L=0.04u
M493 n619 n620 U657/net15 VSS nmos W=0.155u L=0.04u
M494 n619 n621 U657/net15 VSS nmos W=0.155u L=0.04u
M495 U657/net15 n622 VSS VSS nmos W=0.155u L=0.04u
M496 n619 n622 VDD VDD pmos W=0.205u L=0.04u
M497 n619 n620 U657/XI16-net11 VDD pmos W=0.205u L=0.04u
M498 U657/XI16-net11 n621 VDD VDD pmos W=0.205u L=0.04u
M499 n613 n623 VSS VSS nmos W=0.155u L=0.04u
M500 n613 n624 VSS VSS nmos W=0.155u L=0.04u
M501 U658/XI1-net8 n624 VDD VDD pmos W=0.205u L=0.04u
M502 n613 n623 U658/XI1-net8 VDD pmos W=0.205u L=0.04u
M503 n624 n625 VSS VSS nmos W=0.135u L=0.04u
M504 n624 n625 VDD VDD pmos W=0.205u L=0.04u
M505 n612 n626 VSS VSS nmos W=0.155u L=0.04u
M506 n612 U660/net4 VSS VSS nmos W=0.155u L=0.04u
M507 U660/net4 n621 VSS VSS nmos W=0.155u L=0.04u
M508 U660/XU1-net8 U660/net4 VDD VDD pmos W=0.205u L=0.04u
M509 n612 n626 U660/XU1-net8 VDD pmos W=0.205u L=0.04u
M510 U660/net4 n621 VDD VDD pmos W=0.205u L=0.04u
M511 U661/net28 U661/net20 U661/net64 VSS nmos W=0.155u L=0.04u
M512 U661/net24 U661/net30 U661/net32 VSS nmos W=0.155u L=0.04u
M513 U661/net28 U661/net40 U661/net24 VSS nmos W=0.155u L=0.04u
M514 U661/net40 n629 U661/net108 VSS nmos W=0.155u L=0.04u
M515 U661/net40 U661/net106 U661/net104 VSS nmos W=0.155u L=0.04u
M516 U661/net24 n616 U661/net050 VSS nmos W=0.155u L=0.04u
M517 U661/net050 U661/net32 VSS VSS nmos W=0.155u L=0.04u
M518 U661/net20 U661/net40 VSS VSS nmos W=0.155u L=0.04u
M519 U661/net106 n629 VSS VSS nmos W=0.155u L=0.04u
M520 U661/net104 n628 VSS VSS nmos W=0.155u L=0.04u
M521 U661/net30 n616 VSS VSS nmos W=0.155u L=0.04u
M522 U661/net108 U661/net104 VSS VSS nmos W=0.155u L=0.04u
M523 n610 U661/net28 VSS VSS nmos W=0.155u L=0.04u
M524 U661/net32 n627 VSS VSS nmos W=0.155u L=0.04u
M525 U661/net64 U661/net24 VSS VSS nmos W=0.2u L=0.04u
M526 U661/net28 U661/net40 U661/net64 VDD pmos W=0.205u L=0.04u
M527 U661/net24 n616 U661/net32 VDD pmos W=0.205u L=0.04u
M528 U661/net28 U661/net20 U661/net24 VDD pmos W=0.205u L=0.04u
M529 U661/net40 U661/net106 U661/net108 VDD pmos W=0.205u L=0.04u
M530 U661/net40 n629 U661/net104 VDD pmos W=0.205u L=0.04u
M531 U661/net20 U661/net40 VDD VDD pmos W=0.205u L=0.04u
M532 U661/net106 n629 VDD VDD pmos W=0.205u L=0.04u
M533 U661/net104 n628 VDD VDD pmos W=0.205u L=0.04u
M534 U661/net30 n616 VDD VDD pmos W=0.205u L=0.04u
M535 U661/net108 U661/net104 VDD VDD pmos W=0.205u L=0.04u
M536 n610 U661/net28 VDD VDD pmos W=0.205u L=0.04u
M537 U661/net32 n627 VDD VDD pmos W=0.205u L=0.04u
M538 U661/net64 U661/net24 VDD VDD pmos W=0.28u L=0.04u
M539 U661/net24 U661/net30 U661/net045 VDD pmos W=0.205u L=0.04u
M540 U661/net045 U661/net32 VDD VDD pmos W=0.205u L=0.04u
M541 n629 n630 U662/net27 VSS nmos W=0.155u L=0.04u
M542 U662/net27 n623 VSS VSS nmos W=0.155u L=0.04u
M543 n629 n631 VSS VSS nmos W=0.155u L=0.04u
M544 n629 n623 U662/net13 VDD pmos W=0.205u L=0.04u
M545 U662/net13 n631 VDD VDD pmos W=0.205u L=0.04u
M546 n629 n630 U662/net13 VDD pmos W=0.205u L=0.04u
M547 U663/net19 n633 VSS VSS nmos W=0.155u L=0.04u
M548 n631 n633 U663/net40 VSS nmos W=0.155u L=0.04u
M549 n631 U663/net19 U663/net36 VSS nmos W=0.155u L=0.04u
M550 U663/net40 n632 VSS VSS nmos W=0.31u L=0.04u
M551 U663/net36 n614 VSS VSS nmos W=0.155u L=0.04u
M552 U663/net19 n633 VDD VDD pmos W=0.205u L=0.04u
M553 n631 U663/net19 U663/net26 VDD pmos W=0.325u L=0.04u
M554 U663/net26 n632 VDD VDD pmos W=0.41u L=0.04u
M555 n631 n633 U663/net30 VDD pmos W=0.325u L=0.04u
M556 U663/net30 n614 VDD VDD pmos W=0.205u L=0.04u
M557 U664/XU1-net6 n635 VSS VSS nmos W=0.155u L=0.04u
M558 n632 n634 U664/XU1-net6 VSS nmos W=0.155u L=0.04u
M559 n632 n635 VDD VDD pmos W=0.155u L=0.04u
M560 n632 n634 VDD VDD pmos W=0.155u L=0.04u
M561 U665/net4 U665/net10 U665/net14 VSS nmos W=0.155u L=0.04u
M562 U665/net6 n630 U665/net14 VSS nmos W=0.155u L=0.04u
M563 U665/net4 n635 VSS VSS nmos W=0.155u L=0.04u
M564 U665/net6 U665/net4 VSS VSS nmos W=0.155u L=0.04u
M565 n614 U665/net14 VSS VSS nmos W=0.155u L=0.04u
M566 U665/net10 n630 VSS VSS nmos W=0.155u L=0.04u
M567 U665/net4 n630 U665/net14 VDD pmos W=0.205u L=0.04u
M568 U665/net6 U665/net10 U665/net14 VDD pmos W=0.205u L=0.04u
M569 U665/net4 n635 VDD VDD pmos W=0.205u L=0.04u
M570 U665/net6 U665/net4 VDD VDD pmos W=0.205u L=0.04u
M571 n614 U665/net14 VDD VDD pmos W=0.205u L=0.04u
M572 U665/net10 n630 VDD VDD pmos W=0.205u L=0.04u
M573 n630 n634 VSS VSS nmos W=0.135u L=0.04u
M574 n630 n634 VDD VDD pmos W=0.205u L=0.04u
M575 U667/net4 U667/net10 U667/net14 VSS nmos W=0.155u L=0.04u
M576 U667/net6 n636 U667/net14 VSS nmos W=0.155u L=0.04u
M577 U667/net4 n637 VSS VSS nmos W=0.155u L=0.04u
M578 U667/net6 U667/net4 VSS VSS nmos W=0.155u L=0.04u
M579 n634 U667/net14 VSS VSS nmos W=0.155u L=0.04u
M580 U667/net10 n636 VSS VSS nmos W=0.155u L=0.04u
M581 U667/net4 n636 U667/net14 VDD pmos W=0.205u L=0.04u
M582 U667/net6 U667/net10 U667/net14 VDD pmos W=0.205u L=0.04u
M583 U667/net4 n637 VDD VDD pmos W=0.205u L=0.04u
M584 U667/net6 U667/net4 VDD VDD pmos W=0.205u L=0.04u
M585 n634 U667/net14 VDD VDD pmos W=0.205u L=0.04u
M586 U667/net10 n636 VDD VDD pmos W=0.205u L=0.04u
M587 U668/net29 U668/net21 U668/net041 VSS nmos W=0.155u L=0.04u
M588 U668/net035 U668/net19 VSS VSS nmos W=0.155u L=0.04u
M589 U668/net041 U668/net13 VSS VSS nmos W=0.155u L=0.04u
M590 U668/net25 n626 U668/net035 VSS nmos W=0.155u L=0.04u
M591 U668/net19 U668/net17 U668/net25 VSS nmos W=0.155u L=0.04u
M592 U668/net13 U668/net25 U668/net29 VSS nmos W=0.155u L=0.04u
M593 n628 U668/net29 VSS VSS nmos W=0.155u L=0.04u
M594 U668/net13 n638 VSS VSS nmos W=0.155u L=0.04u
M595 U668/net17 n626 VSS VSS nmos W=0.155u L=0.04u
M596 U668/net19 n625 VSS VSS nmos W=0.155u L=0.04u
M597 U668/net21 U668/net25 VSS VSS nmos W=0.155u L=0.04u
M598 U668/net028 U668/net19 VDD VDD pmos W=0.205u L=0.04u
M599 U668/net25 U668/net17 U668/net028 VDD pmos W=0.205u L=0.04u
M600 U668/net29 U668/net25 U668/net029 VDD pmos W=0.205u L=0.04u
M601 U668/net029 U668/net13 VDD VDD pmos W=0.205u L=0.04u
M602 U668/net19 n626 U668/net25 VDD pmos W=0.205u L=0.04u
M603 U668/net13 U668/net21 U668/net29 VDD pmos W=0.205u L=0.04u
M604 n628 U668/net29 VDD VDD pmos W=0.205u L=0.04u
M605 U668/net13 n638 VDD VDD pmos W=0.205u L=0.04u
M606 U668/net17 n626 VDD VDD pmos W=0.205u L=0.04u
M607 U668/net19 n625 VDD VDD pmos W=0.205u L=0.04u
M608 U668/net21 U668/net25 VDD VDD pmos W=0.205u L=0.04u
M609 U669/net19 n641 VSS VSS nmos W=0.155u L=0.04u
M610 n608 n641 U669/net40 VSS nmos W=0.155u L=0.04u
M611 n608 U669/net19 U669/net36 VSS nmos W=0.155u L=0.04u
M612 U669/net40 n640 VSS VSS nmos W=0.31u L=0.04u
M613 U669/net36 n639 VSS VSS nmos W=0.155u L=0.04u
M614 U669/net19 n641 VDD VDD pmos W=0.205u L=0.04u
M615 n608 U669/net19 U669/net26 VDD pmos W=0.325u L=0.04u
M616 U669/net26 n640 VDD VDD pmos W=0.41u L=0.04u
M617 n608 n641 U669/net30 VDD pmos W=0.325u L=0.04u
M618 U669/net30 n639 VDD VDD pmos W=0.205u L=0.04u
M619 n641 n642 U670/net27 VSS nmos W=0.155u L=0.04u
M620 U670/net27 N566 VSS VSS nmos W=0.155u L=0.04u
M621 n641 n643 VSS VSS nmos W=0.155u L=0.04u
M622 n641 N566 U670/net13 VDD pmos W=0.205u L=0.04u
M623 U670/net13 n643 VDD VDD pmos W=0.205u L=0.04u
M624 n641 n642 U670/net13 VDD pmos W=0.205u L=0.04u
M625 U671/net4 U671/net10 U671/net14 VSS nmos W=0.155u L=0.04u
M626 U671/net6 n644 U671/net14 VSS nmos W=0.155u L=0.04u
M627 U671/net4 n645 VSS VSS nmos W=0.155u L=0.04u
M628 U671/net6 U671/net4 VSS VSS nmos W=0.155u L=0.04u
M629 n640 U671/net14 VSS VSS nmos W=0.155u L=0.04u
M630 U671/net10 n644 VSS VSS nmos W=0.155u L=0.04u
M631 U671/net4 n644 U671/net14 VDD pmos W=0.205u L=0.04u
M632 U671/net6 U671/net10 U671/net14 VDD pmos W=0.205u L=0.04u
M633 U671/net4 n645 VDD VDD pmos W=0.205u L=0.04u
M634 U671/net6 U671/net4 VDD VDD pmos W=0.205u L=0.04u
M635 n640 U671/net14 VDD VDD pmos W=0.205u L=0.04u
M636 U671/net10 n644 VDD VDD pmos W=0.205u L=0.04u
M637 n645 n646 U672/net15 VSS nmos W=0.155u L=0.04u
M638 n645 n647 U672/net15 VSS nmos W=0.155u L=0.04u
M639 U672/net15 n648 VSS VSS nmos W=0.155u L=0.04u
M640 n645 n648 VDD VDD pmos W=0.205u L=0.04u
M641 n645 n646 U672/XI16-net11 VDD pmos W=0.205u L=0.04u
M642 U672/XI16-net11 n647 VDD VDD pmos W=0.205u L=0.04u
M643 U673/net19 n651 VSS VSS nmos W=0.155u L=0.04u
M644 n648 n651 U673/net40 VSS nmos W=0.155u L=0.04u
M645 n648 U673/net19 U673/net36 VSS nmos W=0.155u L=0.04u
M646 U673/net40 n650 VSS VSS nmos W=0.31u L=0.04u
M647 U673/net36 n649 VSS VSS nmos W=0.155u L=0.04u
M648 U673/net19 n651 VDD VDD pmos W=0.205u L=0.04u
M649 n648 U673/net19 U673/net26 VDD pmos W=0.325u L=0.04u
M650 U673/net26 n650 VDD VDD pmos W=0.41u L=0.04u
M651 n648 n651 U673/net30 VDD pmos W=0.325u L=0.04u
M652 U673/net30 n649 VDD VDD pmos W=0.205u L=0.04u
M653 n650 n652 VSS VSS nmos W=0.155u L=0.04u
M654 n650 U674/net4 VSS VSS nmos W=0.155u L=0.04u
M655 U674/net4 n646 VSS VSS nmos W=0.155u L=0.04u
M656 U674/XU1-net8 U674/net4 VDD VDD pmos W=0.205u L=0.04u
M657 n650 n652 U674/XU1-net8 VDD pmos W=0.205u L=0.04u
M658 U674/net4 n646 VDD VDD pmos W=0.205u L=0.04u
M659 U675/net4 n646 U675/net14 VSS nmos W=0.155u L=0.04u
M660 U675/net6 U675/net10 U675/net14 VSS nmos W=0.17u L=0.04u
M661 U675/net4 n652 VSS VSS nmos W=0.155u L=0.04u
M662 U675/net6 U675/net4 VSS VSS nmos W=0.17u L=0.04u
M663 n649 U675/net14 VSS VSS nmos W=0.155u L=0.04u
M664 U675/net10 n646 VSS VSS nmos W=0.155u L=0.04u
M665 U675/net4 U675/net10 U675/net14 VDD pmos W=0.255u L=0.04u
M666 U675/net6 n646 U675/net14 VDD pmos W=0.28u L=0.04u
M667 U675/net4 n652 VDD VDD pmos W=0.205u L=0.04u
M668 U675/net6 U675/net4 VDD VDD pmos W=0.24u L=0.04u
M669 n649 U675/net14 VDD VDD pmos W=0.205u L=0.04u
M670 U675/net10 n646 VDD VDD pmos W=0.205u L=0.04u
M671 U676/net4 U676/net10 U676/net14 VSS nmos W=0.155u L=0.04u
M672 U676/net6 n653 U676/net14 VSS nmos W=0.155u L=0.04u
M673 U676/net4 n654 VSS VSS nmos W=0.155u L=0.04u
M674 U676/net6 U676/net4 VSS VSS nmos W=0.155u L=0.04u
M675 n646 U676/net14 VSS VSS nmos W=0.155u L=0.04u
M676 U676/net10 n653 VSS VSS nmos W=0.155u L=0.04u
M677 U676/net4 n653 U676/net14 VDD pmos W=0.205u L=0.04u
M678 U676/net6 U676/net10 U676/net14 VDD pmos W=0.205u L=0.04u
M679 U676/net4 n654 VDD VDD pmos W=0.205u L=0.04u
M680 U676/net6 U676/net4 VDD VDD pmos W=0.205u L=0.04u
M681 n646 U676/net14 VDD VDD pmos W=0.205u L=0.04u
M682 U676/net10 n653 VDD VDD pmos W=0.205u L=0.04u
M683 U677/net28 U677/net20 U677/net64 VSS nmos W=0.155u L=0.04u
M684 U677/net24 U677/net30 U677/net32 VSS nmos W=0.155u L=0.04u
M685 U677/net28 U677/net40 U677/net24 VSS nmos W=0.155u L=0.04u
M686 U677/net40 n657 U677/net108 VSS nmos W=0.155u L=0.04u
M687 U677/net40 U677/net106 U677/net104 VSS nmos W=0.155u L=0.04u
M688 U677/net24 n655 U677/net050 VSS nmos W=0.155u L=0.04u
M689 U677/net050 U677/net32 VSS VSS nmos W=0.155u L=0.04u
M690 U677/net20 U677/net40 VSS VSS nmos W=0.155u L=0.04u
M691 U677/net106 n657 VSS VSS nmos W=0.155u L=0.04u
M692 U677/net104 n644 VSS VSS nmos W=0.155u L=0.04u
M693 U677/net30 n655 VSS VSS nmos W=0.155u L=0.04u
M694 U677/net108 U677/net104 VSS VSS nmos W=0.155u L=0.04u
M695 n639 U677/net28 VSS VSS nmos W=0.155u L=0.04u
M696 U677/net32 n656 VSS VSS nmos W=0.155u L=0.04u
M697 U677/net64 U677/net24 VSS VSS nmos W=0.2u L=0.04u
M698 U677/net28 U677/net40 U677/net64 VDD pmos W=0.205u L=0.04u
M699 U677/net24 n655 U677/net32 VDD pmos W=0.205u L=0.04u
M700 U677/net28 U677/net20 U677/net24 VDD pmos W=0.205u L=0.04u
M701 U677/net40 U677/net106 U677/net108 VDD pmos W=0.205u L=0.04u
M702 U677/net40 n657 U677/net104 VDD pmos W=0.205u L=0.04u
M703 U677/net20 U677/net40 VDD VDD pmos W=0.205u L=0.04u
M704 U677/net106 n657 VDD VDD pmos W=0.205u L=0.04u
M705 U677/net104 n644 VDD VDD pmos W=0.205u L=0.04u
M706 U677/net30 n655 VDD VDD pmos W=0.205u L=0.04u
M707 U677/net108 U677/net104 VDD VDD pmos W=0.205u L=0.04u
M708 n639 U677/net28 VDD VDD pmos W=0.205u L=0.04u
M709 U677/net32 n656 VDD VDD pmos W=0.205u L=0.04u
M710 U677/net64 U677/net24 VDD VDD pmos W=0.28u L=0.04u
M711 U677/net24 U677/net30 U677/net045 VDD pmos W=0.205u L=0.04u
M712 U677/net045 U677/net32 VDD VDD pmos W=0.205u L=0.04u
M713 U678/net17 n660 VSS VSS nmos W=0.155u L=0.04u
M714 U678/net17 n659 VSS VSS nmos W=0.155u L=0.04u
M715 U678/net63 n655 VSS VSS nmos W=0.155u L=0.04u
M716 n657 U678/net17 VSS VSS nmos W=0.155u L=0.04u
M717 n657 n658 U678/net63 VSS nmos W=0.155u L=0.04u
M718 n657 n655 U678/net31 VDD pmos W=0.205u L=0.04u
M719 U678/net39 n660 VDD VDD pmos W=0.195u L=0.04u
M720 U678/net31 U678/net17 VDD VDD pmos W=0.195u L=0.04u
M721 n657 n658 U678/net31 VDD pmos W=0.195u L=0.04u
M722 U678/net17 n659 U678/net39 VDD pmos W=0.195u L=0.04u
M723 U679/net11 n658 U679/net17 VSS nmos W=0.155u L=0.04u
M724 U679/net5 U679/net17 U679/net21 VSS nmos W=0.155u L=0.04u
M725 U679/net5 n662 VSS VSS nmos W=0.155u L=0.04u
M726 n644 U679/net21 VSS VSS nmos W=0.155u L=0.04u
M727 U679/net16 n658 VSS VSS nmos W=0.155u L=0.04u
M728 U679/net11 n661 VSS VSS nmos W=0.155u L=0.04u
M729 U679/net13 U679/net17 VSS VSS nmos W=0.155u L=0.04u
M730 U679/net17 U679/net16 U679/XI2-net16 VSS nmos W=0.155u L=0.04u
M731 U679/XI2-net16 U679/net11 VSS VSS nmos W=0.155u L=0.04u
M732 U679/net21 U679/net13 U679/XU21-net16 VSS nmos W=0.155u L=0.04u
M733 U679/XU21-net16 U679/net5 VSS VSS nmos W=0.155u L=0.04u
M734 U679/net11 U679/net16 U679/net17 VDD pmos W=0.205u L=0.04u
M735 U679/net5 U679/net13 U679/net21 VDD pmos W=0.205u L=0.04u
M736 U679/net5 n662 VDD VDD pmos W=0.205u L=0.04u
M737 n644 U679/net21 VDD VDD pmos W=0.205u L=0.04u
M738 U679/net16 n658 VDD VDD pmos W=0.205u L=0.04u
M739 U679/net11 n661 VDD VDD pmos W=0.205u L=0.04u
M740 U679/net13 U679/net17 VDD VDD pmos W=0.205u L=0.04u
M741 U679/net17 n658 U679/XI2-net6 VDD pmos W=0.205u L=0.04u
M742 U679/XI2-net6 U679/net11 VDD VDD pmos W=0.205u L=0.04u
M743 U679/net21 U679/net17 U679/XU21-net6 VDD pmos W=0.205u L=0.04u
M744 U679/XU21-net6 U679/net5 VDD VDD pmos W=0.205u L=0.04u
M745 U680/net4 U680/net10 U680/net14 VSS nmos W=0.155u L=0.04u
M746 U680/net6 n651 U680/net14 VSS nmos W=0.155u L=0.04u
M747 U680/net4 n663 VSS VSS nmos W=0.155u L=0.04u
M748 U680/net6 U680/net4 VSS VSS nmos W=0.155u L=0.04u
M749 n656 U680/net14 VSS VSS nmos W=0.155u L=0.04u
M750 U680/net10 n651 VSS VSS nmos W=0.155u L=0.04u
M751 U680/net4 n651 U680/net14 VDD pmos W=0.205u L=0.04u
M752 U680/net6 U680/net10 U680/net14 VDD pmos W=0.205u L=0.04u
M753 U680/net4 n663 VDD VDD pmos W=0.205u L=0.04u
M754 U680/net6 U680/net4 VDD VDD pmos W=0.205u L=0.04u
M755 n656 U680/net14 VDD VDD pmos W=0.205u L=0.04u
M756 U680/net10 n651 VDD VDD pmos W=0.205u L=0.04u
M757 N8075 n589 U681/net26 VSS nmos W=0.155u L=0.04u
M758 N8075 n590 U681/net26 VSS nmos W=0.155u L=0.04u
M759 U681/net29 n664 VSS VSS nmos W=0.155u L=0.04u
M760 U681/net26 n588 U681/net29 VSS nmos W=0.155u L=0.04u
M761 U681/net26 n591 U681/net29 VSS nmos W=0.155u L=0.04u
M762 N8075 n590 U681/net43 VDD pmos W=0.205u L=0.04u
M763 N8075 n591 U681/net49 VDD pmos W=0.205u L=0.04u
M764 U681/net49 n588 VDD VDD pmos W=0.205u L=0.04u
M765 U681/net43 n589 VDD VDD pmos W=0.205u L=0.04u
M766 N8075 n664 VDD VDD pmos W=0.205u L=0.04u
M767 n664 N120 U682/net15 VSS nmos W=0.155u L=0.04u
M768 n664 N619 U682/net15 VSS nmos W=0.155u L=0.04u
M769 U682/net15 N625 VSS VSS nmos W=0.155u L=0.04u
M770 n664 N625 VDD VDD pmos W=0.205u L=0.04u
M771 n664 N120 U682/XI16-net11 VDD pmos W=0.205u L=0.04u
M772 U682/XI16-net11 N619 VDD VDD pmos W=0.205u L=0.04u
M773 n591 n584 VSS VSS nmos W=0.135u L=0.04u
M774 n591 n584 VDD VDD pmos W=0.205u L=0.04u
M775 U684/net28 U684/net20 U684/net64 VSS nmos W=0.155u L=0.04u
M776 U684/net24 U684/net30 U684/net32 VSS nmos W=0.155u L=0.04u
M777 U684/net28 U684/net40 U684/net24 VSS nmos W=0.155u L=0.04u
M778 U684/net40 n668 U684/net108 VSS nmos W=0.155u L=0.04u
M779 U684/net40 U684/net106 U684/net104 VSS nmos W=0.155u L=0.04u
M780 U684/net24 n665 U684/net050 VSS nmos W=0.155u L=0.04u
M781 U684/net050 U684/net32 VSS VSS nmos W=0.155u L=0.04u
M782 U684/net20 U684/net40 VSS VSS nmos W=0.155u L=0.04u
M783 U684/net106 n668 VSS VSS nmos W=0.155u L=0.04u
M784 U684/net104 n667 VSS VSS nmos W=0.155u L=0.04u
M785 U684/net30 n665 VSS VSS nmos W=0.155u L=0.04u
M786 U684/net108 U684/net104 VSS VSS nmos W=0.155u L=0.04u
M787 n588 U684/net28 VSS VSS nmos W=0.155u L=0.04u
M788 U684/net32 n666 VSS VSS nmos W=0.155u L=0.04u
M789 U684/net64 U684/net24 VSS VSS nmos W=0.2u L=0.04u
M790 U684/net28 U684/net40 U684/net64 VDD pmos W=0.205u L=0.04u
M791 U684/net24 n665 U684/net32 VDD pmos W=0.205u L=0.04u
M792 U684/net28 U684/net20 U684/net24 VDD pmos W=0.205u L=0.04u
M793 U684/net40 U684/net106 U684/net108 VDD pmos W=0.205u L=0.04u
M794 U684/net40 n668 U684/net104 VDD pmos W=0.205u L=0.04u
M795 U684/net20 U684/net40 VDD VDD pmos W=0.205u L=0.04u
M796 U684/net106 n668 VDD VDD pmos W=0.205u L=0.04u
M797 U684/net104 n667 VDD VDD pmos W=0.205u L=0.04u
M798 U684/net30 n665 VDD VDD pmos W=0.205u L=0.04u
M799 U684/net108 U684/net104 VDD VDD pmos W=0.205u L=0.04u
M800 n588 U684/net28 VDD VDD pmos W=0.205u L=0.04u
M801 U684/net32 n666 VDD VDD pmos W=0.205u L=0.04u
M802 U684/net64 U684/net24 VDD VDD pmos W=0.28u L=0.04u
M803 U684/net24 U684/net30 U684/net045 VDD pmos W=0.205u L=0.04u
M804 U684/net045 U684/net32 VDD VDD pmos W=0.205u L=0.04u
M805 U685/net28 U685/net20 U685/net64 VSS nmos W=0.155u L=0.04u
M806 U685/net24 U685/net30 U685/net32 VSS nmos W=0.155u L=0.04u
M807 U685/net28 U685/net40 U685/net24 VSS nmos W=0.155u L=0.04u
M808 U685/net40 n672 U685/net108 VSS nmos W=0.155u L=0.04u
M809 U685/net40 U685/net106 U685/net104 VSS nmos W=0.155u L=0.04u
M810 U685/net24 n669 U685/net050 VSS nmos W=0.155u L=0.04u
M811 U685/net050 U685/net32 VSS VSS nmos W=0.155u L=0.04u
M812 U685/net20 U685/net40 VSS VSS nmos W=0.155u L=0.04u
M813 U685/net106 n672 VSS VSS nmos W=0.155u L=0.04u
M814 U685/net104 n671 VSS VSS nmos W=0.155u L=0.04u
M815 U685/net30 n669 VSS VSS nmos W=0.155u L=0.04u
M816 U685/net108 U685/net104 VSS VSS nmos W=0.155u L=0.04u
M817 n668 U685/net28 VSS VSS nmos W=0.155u L=0.04u
M818 U685/net32 n670 VSS VSS nmos W=0.155u L=0.04u
M819 U685/net64 U685/net24 VSS VSS nmos W=0.2u L=0.04u
M820 U685/net28 U685/net40 U685/net64 VDD pmos W=0.205u L=0.04u
M821 U685/net24 n669 U685/net32 VDD pmos W=0.205u L=0.04u
M822 U685/net28 U685/net20 U685/net24 VDD pmos W=0.205u L=0.04u
M823 U685/net40 U685/net106 U685/net108 VDD pmos W=0.205u L=0.04u
M824 U685/net40 n672 U685/net104 VDD pmos W=0.205u L=0.04u
M825 U685/net20 U685/net40 VDD VDD pmos W=0.205u L=0.04u
M826 U685/net106 n672 VDD VDD pmos W=0.205u L=0.04u
M827 U685/net104 n671 VDD VDD pmos W=0.205u L=0.04u
M828 U685/net30 n669 VDD VDD pmos W=0.205u L=0.04u
M829 U685/net108 U685/net104 VDD VDD pmos W=0.205u L=0.04u
M830 n668 U685/net28 VDD VDD pmos W=0.205u L=0.04u
M831 U685/net32 n670 VDD VDD pmos W=0.205u L=0.04u
M832 U685/net64 U685/net24 VDD VDD pmos W=0.28u L=0.04u
M833 U685/net24 U685/net30 U685/net045 VDD pmos W=0.205u L=0.04u
M834 U685/net045 U685/net32 VDD VDD pmos W=0.205u L=0.04u
M835 U686/net24 N351 VSS VSS nmos W=0.155u L=0.04u
M836 U686/net74 N242 VSS VSS nmos W=0.155u L=0.04u
M837 U686/net72 N254 VSS VSS nmos W=0.155u L=0.04u
M838 U686/net76 n603 VSS VSS nmos W=0.31u L=0.04u
M839 U686/net044 N534 VSS VSS nmos W=0.155u L=0.04u
M840 U686/net052 n602 VSS VSS nmos W=0.31u L=0.04u
M841 U686/PG2 N351 n669 VSS nmos W=0.22u L=0.04u
M842 U686/net74 U686/net044 U686/PG2 VSS nmos W=0.12u L=0.04u
M843 U686/net052 N534 U686/PG1 VSS nmos W=0.155u L=0.04u
M844 U686/PG1 U686/net24 n669 VSS nmos W=0.155u L=0.04u
M845 U686/net76 N534 U686/PG2 VSS nmos W=0.155u L=0.04u
M846 U686/net72 U686/net044 U686/PG1 VSS nmos W=0.12u L=0.04u
M847 U686/net24 N351 VDD VDD pmos W=0.205u L=0.04u
M848 U686/net74 N242 VDD VDD pmos W=0.205u L=0.04u
M849 U686/net72 N254 VDD VDD pmos W=0.205u L=0.04u
M850 U686/net76 n603 VDD VDD pmos W=0.41u L=0.04u
M851 U686/net044 N534 VDD VDD pmos W=0.205u L=0.04u
M852 U686/net052 n602 VDD VDD pmos W=0.41u L=0.04u
M853 U686/PG2 U686/net24 n669 VDD pmos W=0.205u L=0.04u
M854 U686/net74 N534 U686/PG2 VDD pmos W=0.205u L=0.04u
M855 U686/net052 U686/net044 U686/PG1 VDD pmos W=0.205u L=0.04u
M856 U686/PG1 N351 n669 VDD pmos W=0.29u L=0.04u
M857 U686/net76 U686/net044 U686/PG2 VDD pmos W=0.205u L=0.04u
M858 U686/net72 N534 U686/PG1 VDD pmos W=0.205u L=0.04u
M859 n602 N251 VSS VSS nmos W=0.135u L=0.04u
M860 n602 N251 VDD VDD pmos W=0.205u L=0.04u
M861 U688/net19 N514 VSS VSS nmos W=0.155u L=0.04u
M862 n667 N514 U688/net40 VSS nmos W=0.155u L=0.04u
M863 n667 U688/net19 U688/net36 VSS nmos W=0.155u L=0.04u
M864 U688/net40 n674 VSS VSS nmos W=0.31u L=0.04u
M865 U688/net36 n673 VSS VSS nmos W=0.155u L=0.04u
M866 U688/net19 N514 VDD VDD pmos W=0.205u L=0.04u
M867 n667 U688/net19 U688/net26 VDD pmos W=0.325u L=0.04u
M868 U688/net26 n674 VDD VDD pmos W=0.41u L=0.04u
M869 n667 N514 U688/net30 VDD pmos W=0.325u L=0.04u
M870 U688/net30 n673 VDD VDD pmos W=0.205u L=0.04u
M871 U689/net4 U689/net10 U689/net14 VSS nmos W=0.155u L=0.04u
M872 U689/net6 n675 U689/net14 VSS nmos W=0.155u L=0.04u
M873 U689/net4 n603 VSS VSS nmos W=0.155u L=0.04u
M874 U689/net6 U689/net4 VSS VSS nmos W=0.155u L=0.04u
M875 n674 U689/net14 VSS VSS nmos W=0.155u L=0.04u
M876 U689/net10 n675 VSS VSS nmos W=0.155u L=0.04u
M877 U689/net4 n675 U689/net14 VDD pmos W=0.205u L=0.04u
M878 U689/net6 U689/net10 U689/net14 VDD pmos W=0.205u L=0.04u
M879 U689/net4 n603 VDD VDD pmos W=0.205u L=0.04u
M880 U689/net6 U689/net4 VDD VDD pmos W=0.205u L=0.04u
M881 n674 U689/net14 VDD VDD pmos W=0.205u L=0.04u
M882 U689/net10 n675 VDD VDD pmos W=0.205u L=0.04u
M883 n603 N248 VSS VSS nmos W=0.135u L=0.04u
M884 n603 N248 VDD VDD pmos W=0.205u L=0.04u
M885 U691/net4 U691/net10 U691/net14 VSS nmos W=0.155u L=0.04u
M886 U691/net6 n675 U691/net14 VSS nmos W=0.155u L=0.04u
M887 U691/net4 N242 VSS VSS nmos W=0.155u L=0.04u
M888 U691/net6 U691/net4 VSS VSS nmos W=0.155u L=0.04u
M889 n673 U691/net14 VSS VSS nmos W=0.155u L=0.04u
M890 U691/net10 n675 VSS VSS nmos W=0.155u L=0.04u
M891 U691/net4 n675 U691/net14 VDD pmos W=0.205u L=0.04u
M892 U691/net6 U691/net10 U691/net14 VDD pmos W=0.205u L=0.04u
M893 U691/net4 N242 VDD VDD pmos W=0.205u L=0.04u
M894 U691/net6 U691/net4 VDD VDD pmos W=0.205u L=0.04u
M895 n673 U691/net14 VDD VDD pmos W=0.205u L=0.04u
M896 U691/net10 n675 VDD VDD pmos W=0.205u L=0.04u
M897 U692/net24 N503 VSS VSS nmos W=0.155u L=0.04u
M898 U692/net74 N251 VSS VSS nmos W=0.155u L=0.04u
M899 U692/net72 n596 VSS VSS nmos W=0.155u L=0.04u
M900 U692/net76 N248 VSS VSS nmos W=0.31u L=0.04u
M901 U692/net044 N324 VSS VSS nmos W=0.155u L=0.04u
M902 U692/net052 n597 VSS VSS nmos W=0.31u L=0.04u
M903 U692/PG2 N503 n675 VSS nmos W=0.22u L=0.04u
M904 U692/net74 U692/net044 U692/PG2 VSS nmos W=0.12u L=0.04u
M905 U692/net052 N324 U692/PG1 VSS nmos W=0.155u L=0.04u
M906 U692/PG1 U692/net24 n675 VSS nmos W=0.155u L=0.04u
M907 U692/net76 N324 U692/PG2 VSS nmos W=0.155u L=0.04u
M908 U692/net72 U692/net044 U692/PG1 VSS nmos W=0.12u L=0.04u
M909 U692/net24 N503 VDD VDD pmos W=0.205u L=0.04u
M910 U692/net74 N251 VDD VDD pmos W=0.205u L=0.04u
M911 U692/net72 n596 VDD VDD pmos W=0.205u L=0.04u
M912 U692/net76 N248 VDD VDD pmos W=0.41u L=0.04u
M913 U692/net044 N324 VDD VDD pmos W=0.205u L=0.04u
M914 U692/net052 n597 VDD VDD pmos W=0.41u L=0.04u
M915 U692/PG2 U692/net24 n675 VDD pmos W=0.205u L=0.04u
M916 U692/net74 N324 U692/PG2 VDD pmos W=0.205u L=0.04u
M917 U692/net052 U692/net044 U692/PG1 VDD pmos W=0.205u L=0.04u
M918 U692/PG1 N503 n675 VDD pmos W=0.29u L=0.04u
M919 U692/net76 U692/net044 U692/PG2 VDD pmos W=0.205u L=0.04u
M920 U692/net72 N324 U692/PG1 VDD pmos W=0.205u L=0.04u
M921 U693/net4 n676 U693/net14 VSS nmos W=0.155u L=0.04u
M922 U693/net6 U693/net10 U693/net14 VSS nmos W=0.17u L=0.04u
M923 U693/net4 n677 VSS VSS nmos W=0.155u L=0.04u
M924 U693/net6 U693/net4 VSS VSS nmos W=0.17u L=0.04u
M925 n666 U693/net14 VSS VSS nmos W=0.155u L=0.04u
M926 U693/net10 n676 VSS VSS nmos W=0.155u L=0.04u
M927 U693/net4 U693/net10 U693/net14 VDD pmos W=0.255u L=0.04u
M928 U693/net6 n676 U693/net14 VDD pmos W=0.28u L=0.04u
M929 U693/net4 n677 VDD VDD pmos W=0.205u L=0.04u
M930 U693/net6 U693/net4 VDD VDD pmos W=0.24u L=0.04u
M931 n666 U693/net14 VDD VDD pmos W=0.205u L=0.04u
M932 U693/net10 n676 VDD VDD pmos W=0.205u L=0.04u
M933 U694/net24 N523 VSS VSS nmos W=0.155u L=0.04u
M934 U694/net74 N251 VSS VSS nmos W=0.155u L=0.04u
M935 U694/net72 n596 VSS VSS nmos W=0.155u L=0.04u
M936 U694/net76 N248 VSS VSS nmos W=0.31u L=0.04u
M937 U694/net044 N341 VSS VSS nmos W=0.155u L=0.04u
M938 U694/net052 n597 VSS VSS nmos W=0.31u L=0.04u
M939 U694/PG2 N523 n676 VSS nmos W=0.22u L=0.04u
M940 U694/net74 U694/net044 U694/PG2 VSS nmos W=0.12u L=0.04u
M941 U694/net052 N341 U694/PG1 VSS nmos W=0.155u L=0.04u
M942 U694/PG1 U694/net24 n676 VSS nmos W=0.155u L=0.04u
M943 U694/net76 N341 U694/PG2 VSS nmos W=0.155u L=0.04u
M944 U694/net72 U694/net044 U694/PG1 VSS nmos W=0.12u L=0.04u
M945 U694/net24 N523 VDD VDD pmos W=0.205u L=0.04u
M946 U694/net74 N251 VDD VDD pmos W=0.205u L=0.04u
M947 U694/net72 n596 VDD VDD pmos W=0.205u L=0.04u
M948 U694/net76 N248 VDD VDD pmos W=0.41u L=0.04u
M949 U694/net044 N341 VDD VDD pmos W=0.205u L=0.04u
M950 U694/net052 n597 VDD VDD pmos W=0.41u L=0.04u
M951 U694/PG2 U694/net24 n676 VDD pmos W=0.205u L=0.04u
M952 U694/net74 N341 U694/PG2 VDD pmos W=0.205u L=0.04u
M953 U694/net052 U694/net044 U694/PG1 VDD pmos W=0.205u L=0.04u
M954 U694/PG1 N523 n676 VDD pmos W=0.29u L=0.04u
M955 U694/net76 U694/net044 U694/PG2 VDD pmos W=0.205u L=0.04u
M956 U694/net72 N341 U694/PG1 VDD pmos W=0.205u L=0.04u
M957 n589 U695/net28 VSS VSS nmos W=0.155u L=0.04u
M958 U695/net47 n678 VSS VSS nmos W=0.155u L=0.04u
M959 U695/net28 U695/net6 U695/net47 VSS nmos W=0.155u L=0.04u
M960 U695/net44 n679 VSS VSS nmos W=0.155u L=0.04u
M961 U695/net28 N583 U695/net44 VSS nmos W=0.155u L=0.04u
M962 U695/net6 N583 VSS VSS nmos W=0.155u L=0.04u
M963 n589 U695/net28 VDD VDD pmos W=0.205u L=0.04u
M964 VDD n678 U695/net47 VDD pmos W=0.205u L=0.04u
M965 U695/net47 N583 U695/net28 VDD pmos W=0.205u L=0.04u
M966 U695/net44 U695/net6 U695/net28 VDD pmos W=0.205u L=0.04u
M967 VDD n679 U695/net44 VDD pmos W=0.205u L=0.04u
M968 VDD N583 U695/net6 VDD pmos W=0.205u L=0.04u
M969 U696/net28 U696/net20 U696/net64 VSS nmos W=0.155u L=0.04u
M970 U696/net24 U696/net30 U696/net32 VSS nmos W=0.155u L=0.04u
M971 U696/net28 U696/net40 U696/net24 VSS nmos W=0.155u L=0.04u
M972 U696/net40 n683 U696/net108 VSS nmos W=0.155u L=0.04u
M973 U696/net40 U696/net106 U696/net104 VSS nmos W=0.155u L=0.04u
M974 U696/net24 n680 U696/net050 VSS nmos W=0.155u L=0.04u
M975 U696/net050 U696/net32 VSS VSS nmos W=0.155u L=0.04u
M976 U696/net20 U696/net40 VSS VSS nmos W=0.155u L=0.04u
M977 U696/net106 n683 VSS VSS nmos W=0.155u L=0.04u
M978 U696/net104 n682 VSS VSS nmos W=0.155u L=0.04u
M979 U696/net30 n680 VSS VSS nmos W=0.155u L=0.04u
M980 U696/net108 U696/net104 VSS VSS nmos W=0.155u L=0.04u
M981 n679 U696/net28 VSS VSS nmos W=0.155u L=0.04u
M982 U696/net32 n681 VSS VSS nmos W=0.155u L=0.04u
M983 U696/net64 U696/net24 VSS VSS nmos W=0.2u L=0.04u
M984 U696/net28 U696/net40 U696/net64 VDD pmos W=0.205u L=0.04u
M985 U696/net24 n680 U696/net32 VDD pmos W=0.205u L=0.04u
M986 U696/net28 U696/net20 U696/net24 VDD pmos W=0.205u L=0.04u
M987 U696/net40 U696/net106 U696/net108 VDD pmos W=0.205u L=0.04u
M988 U696/net40 n683 U696/net104 VDD pmos W=0.205u L=0.04u
M989 U696/net20 U696/net40 VDD VDD pmos W=0.205u L=0.04u
M990 U696/net106 n683 VDD VDD pmos W=0.205u L=0.04u
M991 U696/net104 n682 VDD VDD pmos W=0.205u L=0.04u
M992 U696/net30 n680 VDD VDD pmos W=0.205u L=0.04u
M993 U696/net108 U696/net104 VDD VDD pmos W=0.205u L=0.04u
M994 n679 U696/net28 VDD VDD pmos W=0.205u L=0.04u
M995 U696/net32 n681 VDD VDD pmos W=0.205u L=0.04u
M996 U696/net64 U696/net24 VDD VDD pmos W=0.28u L=0.04u
M997 U696/net24 U696/net30 U696/net045 VDD pmos W=0.205u L=0.04u
M998 U696/net045 U696/net32 VDD VDD pmos W=0.205u L=0.04u
M999 U697/net28 U697/net20 U697/net64 VSS nmos W=0.155u L=0.04u
M1000 U697/net24 U697/net30 U697/net32 VSS nmos W=0.155u L=0.04u
M1001 U697/net28 U697/net40 U697/net24 VSS nmos W=0.155u L=0.04u
M1002 U697/net40 n687 U697/net108 VSS nmos W=0.155u L=0.04u
M1003 U697/net40 U697/net106 U697/net104 VSS nmos W=0.155u L=0.04u
M1004 U697/net24 n684 U697/net050 VSS nmos W=0.155u L=0.04u
M1005 U697/net050 U697/net32 VSS VSS nmos W=0.155u L=0.04u
M1006 U697/net20 U697/net40 VSS VSS nmos W=0.155u L=0.04u
M1007 U697/net106 n687 VSS VSS nmos W=0.155u L=0.04u
M1008 U697/net104 n686 VSS VSS nmos W=0.155u L=0.04u
M1009 U697/net30 n684 VSS VSS nmos W=0.155u L=0.04u
M1010 U697/net108 U697/net104 VSS VSS nmos W=0.155u L=0.04u
M1011 n682 U697/net28 VSS VSS nmos W=0.155u L=0.04u
M1012 U697/net32 n685 VSS VSS nmos W=0.155u L=0.04u
M1013 U697/net64 U697/net24 VSS VSS nmos W=0.2u L=0.04u
M1014 U697/net28 U697/net40 U697/net64 VDD pmos W=0.205u L=0.04u
M1015 U697/net24 n684 U697/net32 VDD pmos W=0.205u L=0.04u
M1016 U697/net28 U697/net20 U697/net24 VDD pmos W=0.205u L=0.04u
M1017 U697/net40 U697/net106 U697/net108 VDD pmos W=0.205u L=0.04u
M1018 U697/net40 n687 U697/net104 VDD pmos W=0.205u L=0.04u
M1019 U697/net20 U697/net40 VDD VDD pmos W=0.205u L=0.04u
M1020 U697/net106 n687 VDD VDD pmos W=0.205u L=0.04u
M1021 U697/net104 n686 VDD VDD pmos W=0.205u L=0.04u
M1022 U697/net30 n684 VDD VDD pmos W=0.205u L=0.04u
M1023 U697/net108 U697/net104 VDD VDD pmos W=0.205u L=0.04u
M1024 n682 U697/net28 VDD VDD pmos W=0.205u L=0.04u
M1025 U697/net32 n685 VDD VDD pmos W=0.205u L=0.04u
M1026 U697/net64 U697/net24 VDD VDD pmos W=0.28u L=0.04u
M1027 U697/net24 U697/net30 U697/net045 VDD pmos W=0.205u L=0.04u
M1028 U697/net045 U697/net32 VDD VDD pmos W=0.205u L=0.04u
M1029 n687 n688 U698/net27 VSS nmos W=0.155u L=0.04u
M1030 U698/net27 n689 VSS VSS nmos W=0.155u L=0.04u
M1031 n687 n690 VSS VSS nmos W=0.155u L=0.04u
M1032 n687 n689 U698/net13 VDD pmos W=0.205u L=0.04u
M1033 U698/net13 n690 VDD VDD pmos W=0.205u L=0.04u
M1034 n687 n688 U698/net13 VDD pmos W=0.205u L=0.04u
M1035 n685 n689 VSS VSS nmos W=0.155u L=0.04u
M1036 n685 n691 VSS VSS nmos W=0.155u L=0.04u
M1037 U699/XI1-net8 n691 VDD VDD pmos W=0.205u L=0.04u
M1038 n685 n689 U699/XI1-net8 VDD pmos W=0.205u L=0.04u
M1039 n684 n689 U700/net27 VSS nmos W=0.155u L=0.04u
M1040 U700/net27 n692 VSS VSS nmos W=0.155u L=0.04u
M1041 n684 n693 VSS VSS nmos W=0.155u L=0.04u
M1042 n684 n692 U700/net13 VDD pmos W=0.205u L=0.04u
M1043 U700/net13 n693 VDD VDD pmos W=0.205u L=0.04u
M1044 n684 n689 U700/net13 VDD pmos W=0.205u L=0.04u
M1045 n692 n694 VSS VSS nmos W=0.135u L=0.04u
M1046 n692 n694 VDD VDD pmos W=0.205u L=0.04u
M1047 n689 n695 VSS VSS nmos W=0.135u L=0.04u
M1048 n689 n695 VDD VDD pmos W=0.205u L=0.04u
M1049 U703/net28 U703/net20 U703/net64 VSS nmos W=0.155u L=0.04u
M1050 U703/net24 U703/net30 U703/net32 VSS nmos W=0.155u L=0.04u
M1051 U703/net28 U703/net40 U703/net24 VSS nmos W=0.155u L=0.04u
M1052 U703/net40 n683 U703/net108 VSS nmos W=0.155u L=0.04u
M1053 U703/net40 U703/net106 U703/net104 VSS nmos W=0.155u L=0.04u
M1054 U703/net24 n696 U703/net050 VSS nmos W=0.155u L=0.04u
M1055 U703/net050 U703/net32 VSS VSS nmos W=0.155u L=0.04u
M1056 U703/net20 U703/net40 VSS VSS nmos W=0.155u L=0.04u
M1057 U703/net106 n683 VSS VSS nmos W=0.155u L=0.04u
M1058 U703/net104 n697 VSS VSS nmos W=0.155u L=0.04u
M1059 U703/net30 n696 VSS VSS nmos W=0.155u L=0.04u
M1060 U703/net108 U703/net104 VSS VSS nmos W=0.155u L=0.04u
M1061 n678 U703/net28 VSS VSS nmos W=0.155u L=0.04u
M1062 U703/net32 n680 VSS VSS nmos W=0.155u L=0.04u
M1063 U703/net64 U703/net24 VSS VSS nmos W=0.2u L=0.04u
M1064 U703/net28 U703/net40 U703/net64 VDD pmos W=0.205u L=0.04u
M1065 U703/net24 n696 U703/net32 VDD pmos W=0.205u L=0.04u
M1066 U703/net28 U703/net20 U703/net24 VDD pmos W=0.205u L=0.04u
M1067 U703/net40 U703/net106 U703/net108 VDD pmos W=0.205u L=0.04u
M1068 U703/net40 n683 U703/net104 VDD pmos W=0.205u L=0.04u
M1069 U703/net20 U703/net40 VDD VDD pmos W=0.205u L=0.04u
M1070 U703/net106 n683 VDD VDD pmos W=0.205u L=0.04u
M1071 U703/net104 n697 VDD VDD pmos W=0.205u L=0.04u
M1072 U703/net30 n696 VDD VDD pmos W=0.205u L=0.04u
M1073 U703/net108 U703/net104 VDD VDD pmos W=0.205u L=0.04u
M1074 n678 U703/net28 VDD VDD pmos W=0.205u L=0.04u
M1075 U703/net32 n680 VDD VDD pmos W=0.205u L=0.04u
M1076 U703/net64 U703/net24 VDD VDD pmos W=0.28u L=0.04u
M1077 U703/net24 U703/net30 U703/net045 VDD pmos W=0.205u L=0.04u
M1078 U703/net045 U703/net32 VDD VDD pmos W=0.205u L=0.04u
M1079 U704/net19 n700 VSS VSS nmos W=0.155u L=0.04u
M1080 n683 n700 U704/net40 VSS nmos W=0.155u L=0.04u
M1081 n683 U704/net19 U704/net36 VSS nmos W=0.155u L=0.04u
M1082 U704/net40 n699 VSS VSS nmos W=0.31u L=0.04u
M1083 U704/net36 n698 VSS VSS nmos W=0.155u L=0.04u
M1084 U704/net19 n700 VDD VDD pmos W=0.205u L=0.04u
M1085 n683 U704/net19 U704/net26 VDD pmos W=0.325u L=0.04u
M1086 U704/net26 n699 VDD VDD pmos W=0.41u L=0.04u
M1087 n683 n700 U704/net30 VDD pmos W=0.325u L=0.04u
M1088 U704/net30 n698 VDD VDD pmos W=0.205u L=0.04u
M1089 n700 N583 U705/net27 VSS nmos W=0.155u L=0.04u
M1090 U705/net27 n701 VSS VSS nmos W=0.155u L=0.04u
M1091 n700 n702 VSS VSS nmos W=0.155u L=0.04u
M1092 n700 n701 U705/net13 VDD pmos W=0.205u L=0.04u
M1093 U705/net13 n702 VDD VDD pmos W=0.205u L=0.04u
M1094 n700 N583 U705/net13 VDD pmos W=0.205u L=0.04u
M1095 U706/net28 U706/net20 U706/net64 VSS nmos W=0.155u L=0.04u
M1096 U706/net24 U706/net30 U706/net32 VSS nmos W=0.155u L=0.04u
M1097 U706/net28 U706/net40 U706/net24 VSS nmos W=0.155u L=0.04u
M1098 U706/net40 n706 U706/net108 VSS nmos W=0.155u L=0.04u
M1099 U706/net40 U706/net106 U706/net104 VSS nmos W=0.155u L=0.04u
M1100 U706/net24 n703 U706/net050 VSS nmos W=0.155u L=0.04u
M1101 U706/net050 U706/net32 VSS VSS nmos W=0.155u L=0.04u
M1102 U706/net20 U706/net40 VSS VSS nmos W=0.155u L=0.04u
M1103 U706/net106 n706 VSS VSS nmos W=0.155u L=0.04u
M1104 U706/net104 n705 VSS VSS nmos W=0.155u L=0.04u
M1105 U706/net30 n703 VSS VSS nmos W=0.155u L=0.04u
M1106 U706/net108 U706/net104 VSS VSS nmos W=0.155u L=0.04u
M1107 n699 U706/net28 VSS VSS nmos W=0.155u L=0.04u
M1108 U706/net32 n704 VSS VSS nmos W=0.155u L=0.04u
M1109 U706/net64 U706/net24 VSS VSS nmos W=0.2u L=0.04u
M1110 U706/net28 U706/net40 U706/net64 VDD pmos W=0.205u L=0.04u
M1111 U706/net24 n703 U706/net32 VDD pmos W=0.205u L=0.04u
M1112 U706/net28 U706/net20 U706/net24 VDD pmos W=0.205u L=0.04u
M1113 U706/net40 U706/net106 U706/net108 VDD pmos W=0.205u L=0.04u
M1114 U706/net40 n706 U706/net104 VDD pmos W=0.205u L=0.04u
M1115 U706/net20 U706/net40 VDD VDD pmos W=0.205u L=0.04u
M1116 U706/net106 n706 VDD VDD pmos W=0.205u L=0.04u
M1117 U706/net104 n705 VDD VDD pmos W=0.205u L=0.04u
M1118 U706/net30 n703 VDD VDD pmos W=0.205u L=0.04u
M1119 U706/net108 U706/net104 VDD VDD pmos W=0.205u L=0.04u
M1120 n699 U706/net28 VDD VDD pmos W=0.205u L=0.04u
M1121 U706/net32 n704 VDD VDD pmos W=0.205u L=0.04u
M1122 U706/net64 U706/net24 VDD VDD pmos W=0.28u L=0.04u
M1123 U706/net24 U706/net30 U706/net045 VDD pmos W=0.205u L=0.04u
M1124 U706/net045 U706/net32 VDD VDD pmos W=0.205u L=0.04u
M1125 U707/net28 U707/net20 U707/net64 VSS nmos W=0.155u L=0.04u
M1126 U707/net24 U707/net30 U707/net32 VSS nmos W=0.155u L=0.04u
M1127 U707/net28 U707/net40 U707/net24 VSS nmos W=0.155u L=0.04u
M1128 U707/net40 n710 U707/net108 VSS nmos W=0.155u L=0.04u
M1129 U707/net40 U707/net106 U707/net104 VSS nmos W=0.155u L=0.04u
M1130 U707/net24 n707 U707/net050 VSS nmos W=0.155u L=0.04u
M1131 U707/net050 U707/net32 VSS VSS nmos W=0.155u L=0.04u
M1132 U707/net20 U707/net40 VSS VSS nmos W=0.155u L=0.04u
M1133 U707/net106 n710 VSS VSS nmos W=0.155u L=0.04u
M1134 U707/net104 n709 VSS VSS nmos W=0.155u L=0.04u
M1135 U707/net30 n707 VSS VSS nmos W=0.155u L=0.04u
M1136 U707/net108 U707/net104 VSS VSS nmos W=0.155u L=0.04u
M1137 n698 U707/net28 VSS VSS nmos W=0.155u L=0.04u
M1138 U707/net32 n708 VSS VSS nmos W=0.155u L=0.04u
M1139 U707/net64 U707/net24 VSS VSS nmos W=0.2u L=0.04u
M1140 U707/net28 U707/net40 U707/net64 VDD pmos W=0.205u L=0.04u
M1141 U707/net24 n707 U707/net32 VDD pmos W=0.205u L=0.04u
M1142 U707/net28 U707/net20 U707/net24 VDD pmos W=0.205u L=0.04u
M1143 U707/net40 U707/net106 U707/net108 VDD pmos W=0.205u L=0.04u
M1144 U707/net40 n710 U707/net104 VDD pmos W=0.205u L=0.04u
M1145 U707/net20 U707/net40 VDD VDD pmos W=0.205u L=0.04u
M1146 U707/net106 n710 VDD VDD pmos W=0.205u L=0.04u
M1147 U707/net104 n709 VDD VDD pmos W=0.205u L=0.04u
M1148 U707/net30 n707 VDD VDD pmos W=0.205u L=0.04u
M1149 U707/net108 U707/net104 VDD VDD pmos W=0.205u L=0.04u
M1150 n698 U707/net28 VDD VDD pmos W=0.205u L=0.04u
M1151 U707/net32 n708 VDD VDD pmos W=0.205u L=0.04u
M1152 U707/net64 U707/net24 VDD VDD pmos W=0.28u L=0.04u
M1153 U707/net24 U707/net30 U707/net045 VDD pmos W=0.205u L=0.04u
M1154 U707/net045 U707/net32 VDD VDD pmos W=0.205u L=0.04u
M1155 U708/net4 U708/net10 U708/net14 VSS nmos W=0.155u L=0.04u
M1156 U708/net6 n705 U708/net14 VSS nmos W=0.155u L=0.04u
M1157 U708/net4 n703 VSS VSS nmos W=0.155u L=0.04u
M1158 U708/net6 U708/net4 VSS VSS nmos W=0.155u L=0.04u
M1159 n709 U708/net14 VSS VSS nmos W=0.155u L=0.04u
M1160 U708/net10 n705 VSS VSS nmos W=0.155u L=0.04u
M1161 U708/net4 n705 U708/net14 VDD pmos W=0.205u L=0.04u
M1162 U708/net6 U708/net10 U708/net14 VDD pmos W=0.205u L=0.04u
M1163 U708/net4 n703 VDD VDD pmos W=0.205u L=0.04u
M1164 U708/net6 U708/net4 VDD VDD pmos W=0.205u L=0.04u
M1165 n709 U708/net14 VDD VDD pmos W=0.205u L=0.04u
M1166 U708/net10 n705 VDD VDD pmos W=0.205u L=0.04u
M1167 n705 n711 U709/net15 VSS nmos W=0.155u L=0.04u
M1168 n705 n712 U709/net15 VSS nmos W=0.155u L=0.04u
M1169 U709/net15 n713 VSS VSS nmos W=0.155u L=0.04u
M1170 n705 n713 VDD VDD pmos W=0.205u L=0.04u
M1171 n705 n711 U709/XI16-net11 VDD pmos W=0.205u L=0.04u
M1172 U709/XI16-net11 n712 VDD VDD pmos W=0.205u L=0.04u
M1173 U710/net29 U710/net21 U710/net041 VSS nmos W=0.155u L=0.04u
M1174 U710/net035 U710/net19 VSS VSS nmos W=0.155u L=0.04u
M1175 U710/net041 U710/net13 VSS VSS nmos W=0.155u L=0.04u
M1176 U710/net25 n693 U710/net035 VSS nmos W=0.155u L=0.04u
M1177 U710/net19 U710/net17 U710/net25 VSS nmos W=0.155u L=0.04u
M1178 U710/net13 U710/net25 U710/net29 VSS nmos W=0.155u L=0.04u
M1179 n697 U710/net29 VSS VSS nmos W=0.155u L=0.04u
M1180 U710/net13 n690 VSS VSS nmos W=0.155u L=0.04u
M1181 U710/net17 n693 VSS VSS nmos W=0.155u L=0.04u
M1182 U710/net19 n691 VSS VSS nmos W=0.155u L=0.04u
M1183 U710/net21 U710/net25 VSS VSS nmos W=0.155u L=0.04u
M1184 U710/net028 U710/net19 VDD VDD pmos W=0.205u L=0.04u
M1185 U710/net25 U710/net17 U710/net028 VDD pmos W=0.205u L=0.04u
M1186 U710/net29 U710/net25 U710/net029 VDD pmos W=0.205u L=0.04u
M1187 U710/net029 U710/net13 VDD VDD pmos W=0.205u L=0.04u
M1188 U710/net19 n693 U710/net25 VDD pmos W=0.205u L=0.04u
M1189 U710/net13 U710/net21 U710/net29 VDD pmos W=0.205u L=0.04u
M1190 n697 U710/net29 VDD VDD pmos W=0.205u L=0.04u
M1191 U710/net13 n690 VDD VDD pmos W=0.205u L=0.04u
M1192 U710/net17 n693 VDD VDD pmos W=0.205u L=0.04u
M1193 U710/net19 n691 VDD VDD pmos W=0.205u L=0.04u
M1194 U710/net21 U710/net25 VDD VDD pmos W=0.205u L=0.04u
M1195 n693 n714 U711/net15 VSS nmos W=0.155u L=0.04u
M1196 n693 n694 U711/net15 VSS nmos W=0.155u L=0.04u
M1197 U711/net15 n715 VSS VSS nmos W=0.155u L=0.04u
M1198 n693 n715 VDD VDD pmos W=0.205u L=0.04u
M1199 n693 n714 U711/XI16-net11 VDD pmos W=0.205u L=0.04u
M1200 U711/XI16-net11 n694 VDD VDD pmos W=0.205u L=0.04u
M1201 U712/net29 U712/net21 U712/net041 VSS nmos W=0.155u L=0.04u
M1202 U712/net035 U712/net19 VSS VSS nmos W=0.155u L=0.04u
M1203 U712/net041 U712/net13 VSS VSS nmos W=0.155u L=0.04u
M1204 U712/net25 n716 U712/net035 VSS nmos W=0.155u L=0.04u
M1205 U712/net19 U712/net17 U712/net25 VSS nmos W=0.155u L=0.04u
M1206 U712/net13 U712/net25 U712/net29 VSS nmos W=0.155u L=0.04u
M1207 n680 U712/net29 VSS VSS nmos W=0.155u L=0.04u
M1208 U712/net13 n717 VSS VSS nmos W=0.155u L=0.04u
M1209 U712/net17 n716 VSS VSS nmos W=0.155u L=0.04u
M1210 U712/net19 n694 VSS VSS nmos W=0.155u L=0.04u
M1211 U712/net21 U712/net25 VSS VSS nmos W=0.155u L=0.04u
M1212 U712/net028 U712/net19 VDD VDD pmos W=0.205u L=0.04u
M1213 U712/net25 U712/net17 U712/net028 VDD pmos W=0.205u L=0.04u
M1214 U712/net29 U712/net25 U712/net029 VDD pmos W=0.205u L=0.04u
M1215 U712/net029 U712/net13 VDD VDD pmos W=0.205u L=0.04u
M1216 U712/net19 n716 U712/net25 VDD pmos W=0.205u L=0.04u
M1217 U712/net13 U712/net21 U712/net29 VDD pmos W=0.205u L=0.04u
M1218 n680 U712/net29 VDD VDD pmos W=0.205u L=0.04u
M1219 U712/net13 n717 VDD VDD pmos W=0.205u L=0.04u
M1220 U712/net17 n716 VDD VDD pmos W=0.205u L=0.04u
M1221 U712/net19 n694 VDD VDD pmos W=0.205u L=0.04u
M1222 U712/net21 U712/net25 VDD VDD pmos W=0.205u L=0.04u
M1223 N7761 n719 U713/net26 VSS nmos W=0.155u L=0.04u
M1224 N7761 n718 U713/net26 VSS nmos W=0.155u L=0.04u
M1225 U713/net29 n721 VSS VSS nmos W=0.155u L=0.04u
M1226 U713/net26 N7704 U713/net29 VSS nmos W=0.155u L=0.04u
M1227 U713/net26 n720 U713/net29 VSS nmos W=0.155u L=0.04u
M1228 N7761 n718 U713/net43 VDD pmos W=0.205u L=0.04u
M1229 N7761 n720 U713/net49 VDD pmos W=0.205u L=0.04u
M1230 U713/net49 N7704 VDD VDD pmos W=0.205u L=0.04u
M1231 U713/net43 n719 VDD VDD pmos W=0.205u L=0.04u
M1232 N7761 n721 VDD VDD pmos W=0.205u L=0.04u
M1233 U714/net29 n724 VSS VSS nmos W=0.155u L=0.04u
M1234 n721 N191 U714/net29 VSS nmos W=0.155u L=0.04u
M1235 n721 n722 U714/net23 VSS nmos W=0.155u L=0.04u
M1236 U714/net23 n723 VSS VSS nmos W=0.155u L=0.04u
M1237 U714/net20 n723 n721 VDD pmos W=0.205u L=0.04u
M1238 U714/net20 n722 n721 VDD pmos W=0.205u L=0.04u
M1239 VDD N191 U714/net20 VDD pmos W=0.205u L=0.04u
M1240 VDD n724 U714/net20 VDD pmos W=0.205u L=0.04u
M1241 N7760 n725 U715/net26 VSS nmos W=0.155u L=0.04u
M1242 N7760 n718 U715/net26 VSS nmos W=0.155u L=0.04u
M1243 U715/net29 n726 VSS VSS nmos W=0.155u L=0.04u
M1244 U715/net26 N7705 U715/net29 VSS nmos W=0.155u L=0.04u
M1245 U715/net26 n720 U715/net29 VSS nmos W=0.155u L=0.04u
M1246 N7760 n718 U715/net43 VDD pmos W=0.205u L=0.04u
M1247 N7760 n720 U715/net49 VDD pmos W=0.205u L=0.04u
M1248 U715/net49 N7705 VDD VDD pmos W=0.205u L=0.04u
M1249 U715/net43 n725 VDD VDD pmos W=0.205u L=0.04u
M1250 N7760 n726 VDD VDD pmos W=0.205u L=0.04u
M1251 U716/net29 n724 VSS VSS nmos W=0.155u L=0.04u
M1252 n726 N194 U716/net29 VSS nmos W=0.155u L=0.04u
M1253 n726 n722 U716/net23 VSS nmos W=0.155u L=0.04u
M1254 U716/net23 n727 VSS VSS nmos W=0.155u L=0.04u
M1255 U716/net20 n727 n726 VDD pmos W=0.205u L=0.04u
M1256 U716/net20 n722 n726 VDD pmos W=0.205u L=0.04u
M1257 VDD N194 U716/net20 VDD pmos W=0.205u L=0.04u
M1258 VDD n724 U716/net20 VDD pmos W=0.205u L=0.04u
M1259 N7759 n720 U717/net26 VSS nmos W=0.155u L=0.04u
M1260 N7759 N7706 U717/net26 VSS nmos W=0.155u L=0.04u
M1261 U717/net29 n729 VSS VSS nmos W=0.155u L=0.04u
M1262 U717/net26 N7701 U717/net29 VSS nmos W=0.155u L=0.04u
M1263 U717/net26 n728 U717/net29 VSS nmos W=0.155u L=0.04u
M1264 N7759 N7706 U717/net43 VDD pmos W=0.205u L=0.04u
M1265 N7759 n728 U717/net49 VDD pmos W=0.205u L=0.04u
M1266 U717/net49 N7701 VDD VDD pmos W=0.205u L=0.04u
M1267 U717/net43 n720 VDD VDD pmos W=0.205u L=0.04u
M1268 N7759 n729 VDD VDD pmos W=0.205u L=0.04u
M1269 U718/net29 n730 VSS VSS nmos W=0.155u L=0.04u
M1270 n729 N167 U718/net29 VSS nmos W=0.155u L=0.04u
M1271 n729 N197 U718/net23 VSS nmos W=0.155u L=0.04u
M1272 U718/net23 n724 VSS VSS nmos W=0.155u L=0.04u
M1273 U718/net20 n724 n729 VDD pmos W=0.205u L=0.04u
M1274 U718/net20 N197 n729 VDD pmos W=0.205u L=0.04u
M1275 VDD N167 U718/net20 VDD pmos W=0.205u L=0.04u
M1276 VDD n730 U718/net20 VDD pmos W=0.205u L=0.04u
M1277 N7758 n728 U719/net26 VSS nmos W=0.155u L=0.04u
M1278 N7758 N7702 U719/net26 VSS nmos W=0.155u L=0.04u
M1279 U719/net29 n733 VSS VSS nmos W=0.155u L=0.04u
M1280 U719/net26 n731 U719/net29 VSS nmos W=0.155u L=0.04u
M1281 U719/net26 n732 U719/net29 VSS nmos W=0.155u L=0.04u
M1282 N7758 N7702 U719/net43 VDD pmos W=0.205u L=0.04u
M1283 N7758 n732 U719/net49 VDD pmos W=0.205u L=0.04u
M1284 U719/net49 n731 VDD VDD pmos W=0.205u L=0.04u
M1285 U719/net43 n728 VDD VDD pmos W=0.205u L=0.04u
M1286 N7758 n733 VDD VDD pmos W=0.205u L=0.04u
M1287 U720/net17 N7707 VSS VSS nmos W=0.155u L=0.04u
M1288 U720/net17 n720 VSS VSS nmos W=0.155u L=0.04u
M1289 U720/net63 n730 VSS VSS nmos W=0.155u L=0.04u
M1290 n733 U720/net17 VSS VSS nmos W=0.155u L=0.04u
M1291 n733 N173 U720/net63 VSS nmos W=0.155u L=0.04u
M1292 n733 n730 U720/net31 VDD pmos W=0.205u L=0.04u
M1293 U720/net39 N7707 VDD VDD pmos W=0.195u L=0.04u
M1294 U720/net31 U720/net17 VDD VDD pmos W=0.195u L=0.04u
M1295 n733 N173 U720/net31 VDD pmos W=0.195u L=0.04u
M1296 U720/net17 n720 U720/net39 VDD pmos W=0.195u L=0.04u
M1297 n730 n718 VSS VSS nmos W=0.135u L=0.04u
M1298 n730 n718 VDD VDD pmos W=0.205u L=0.04u
M1299 N7757 n734 U722/net26 VSS nmos W=0.155u L=0.04u
M1300 N7757 n719 U722/net26 VSS nmos W=0.155u L=0.04u
M1301 U722/net29 n736 VSS VSS nmos W=0.155u L=0.04u
M1302 U722/net26 N7704 U722/net29 VSS nmos W=0.155u L=0.04u
M1303 U722/net26 n735 U722/net29 VSS nmos W=0.155u L=0.04u
M1304 N7757 n719 U722/net43 VDD pmos W=0.205u L=0.04u
M1305 N7757 n735 U722/net49 VDD pmos W=0.205u L=0.04u
M1306 U722/net49 N7704 VDD VDD pmos W=0.205u L=0.04u
M1307 U722/net43 n734 VDD VDD pmos W=0.205u L=0.04u
M1308 N7757 n736 VDD VDD pmos W=0.205u L=0.04u
M1309 U723/net29 N191 VSS VSS nmos W=0.155u L=0.04u
M1310 n736 n738 U723/net29 VSS nmos W=0.155u L=0.04u
M1311 n736 n737 U723/net23 VSS nmos W=0.155u L=0.04u
M1312 U723/net23 n723 VSS VSS nmos W=0.155u L=0.04u
M1313 U723/net20 n723 n736 VDD pmos W=0.205u L=0.04u
M1314 U723/net20 n737 n736 VDD pmos W=0.205u L=0.04u
M1315 VDD n738 U723/net20 VDD pmos W=0.205u L=0.04u
M1316 VDD N191 U723/net20 VDD pmos W=0.205u L=0.04u
M1317 n719 N161 VSS VSS nmos W=0.135u L=0.04u
M1318 n719 N161 VDD VDD pmos W=0.205u L=0.04u
M1319 N7756 n734 U725/net26 VSS nmos W=0.155u L=0.04u
M1320 N7756 n725 U725/net26 VSS nmos W=0.155u L=0.04u
M1321 U725/net29 n739 VSS VSS nmos W=0.155u L=0.04u
M1322 U725/net26 N7705 U725/net29 VSS nmos W=0.155u L=0.04u
M1323 U725/net26 n735 U725/net29 VSS nmos W=0.155u L=0.04u
M1324 N7756 n725 U725/net43 VDD pmos W=0.205u L=0.04u
M1325 N7756 n735 U725/net49 VDD pmos W=0.205u L=0.04u
M1326 U725/net49 N7705 VDD VDD pmos W=0.205u L=0.04u
M1327 U725/net43 n734 VDD VDD pmos W=0.205u L=0.04u
M1328 N7756 n739 VDD VDD pmos W=0.205u L=0.04u
M1329 U726/net29 N194 VSS VSS nmos W=0.155u L=0.04u
M1330 n739 n738 U726/net29 VSS nmos W=0.155u L=0.04u
M1331 n739 n737 U726/net23 VSS nmos W=0.155u L=0.04u
M1332 U726/net23 n727 VSS VSS nmos W=0.155u L=0.04u
M1333 U726/net20 n727 n739 VDD pmos W=0.205u L=0.04u
M1334 U726/net20 n737 n739 VDD pmos W=0.205u L=0.04u
M1335 VDD n738 U726/net20 VDD pmos W=0.205u L=0.04u
M1336 VDD N194 U726/net20 VDD pmos W=0.205u L=0.04u
M1337 n725 N164 VSS VSS nmos W=0.135u L=0.04u
M1338 n725 N164 VDD VDD pmos W=0.205u L=0.04u
M1339 N7755 n735 U728/net26 VSS nmos W=0.155u L=0.04u
M1340 N7755 N7706 U728/net26 VSS nmos W=0.155u L=0.04u
M1341 U728/net29 n741 VSS VSS nmos W=0.155u L=0.04u
M1342 U728/net26 N7701 U728/net29 VSS nmos W=0.155u L=0.04u
M1343 U728/net26 n740 U728/net29 VSS nmos W=0.155u L=0.04u
M1344 N7755 N7706 U728/net43 VDD pmos W=0.205u L=0.04u
M1345 N7755 n740 U728/net49 VDD pmos W=0.205u L=0.04u
M1346 U728/net49 N7701 VDD VDD pmos W=0.205u L=0.04u
M1347 U728/net43 n735 VDD VDD pmos W=0.205u L=0.04u
M1348 N7755 n741 VDD VDD pmos W=0.205u L=0.04u
M1349 U729/net29 N167 VSS VSS nmos W=0.155u L=0.04u
M1350 n741 n742 U729/net29 VSS nmos W=0.155u L=0.04u
M1351 n741 n738 U729/net23 VSS nmos W=0.155u L=0.04u
M1352 U729/net23 N197 VSS VSS nmos W=0.155u L=0.04u
M1353 U729/net20 N197 n741 VDD pmos W=0.205u L=0.04u
M1354 U729/net20 n738 n741 VDD pmos W=0.205u L=0.04u
M1355 VDD n742 U729/net20 VDD pmos W=0.205u L=0.04u
M1356 VDD N167 U729/net20 VDD pmos W=0.205u L=0.04u
M1357 N7754 n740 U730/net26 VSS nmos W=0.155u L=0.04u
M1358 N7754 N7702 U730/net26 VSS nmos W=0.155u L=0.04u
M1359 U730/net29 n744 VSS VSS nmos W=0.155u L=0.04u
M1360 U730/net26 n732 U730/net29 VSS nmos W=0.155u L=0.04u
M1361 U730/net26 n743 U730/net29 VSS nmos W=0.155u L=0.04u
M1362 N7754 N7702 U730/net43 VDD pmos W=0.205u L=0.04u
M1363 N7754 n743 U730/net49 VDD pmos W=0.205u L=0.04u
M1364 U730/net49 n732 VDD VDD pmos W=0.205u L=0.04u
M1365 U730/net43 n740 VDD VDD pmos W=0.205u L=0.04u
M1366 N7754 n744 VDD VDD pmos W=0.205u L=0.04u
M1367 U731/net17 N7707 VSS VSS nmos W=0.155u L=0.04u
M1368 U731/net17 n735 VSS VSS nmos W=0.155u L=0.04u
M1369 U731/net63 N173 VSS VSS nmos W=0.155u L=0.04u
M1370 n744 U731/net17 VSS VSS nmos W=0.155u L=0.04u
M1371 n744 n742 U731/net63 VSS nmos W=0.155u L=0.04u
M1372 n744 N173 U731/net31 VDD pmos W=0.205u L=0.04u
M1373 U731/net39 N7707 VDD VDD pmos W=0.195u L=0.04u
M1374 U731/net31 U731/net17 VDD VDD pmos W=0.195u L=0.04u
M1375 n744 n742 U731/net31 VDD pmos W=0.195u L=0.04u
M1376 U731/net17 n735 U731/net39 VDD pmos W=0.195u L=0.04u
M1377 n742 n734 VSS VSS nmos W=0.135u L=0.04u
M1378 n742 n734 VDD VDD pmos W=0.205u L=0.04u
M1379 n732 N203 VSS VSS nmos W=0.135u L=0.04u
M1380 n732 N203 VDD VDD pmos W=0.205u L=0.04u
M1381 N7742 n575 U734/net26 VSS nmos W=0.155u L=0.04u
M1382 N7742 N7707 U734/net26 VSS nmos W=0.155u L=0.04u
M1383 U734/net29 n745 VSS VSS nmos W=0.155u L=0.04u
M1384 U734/net26 N7702 U734/net29 VSS nmos W=0.155u L=0.04u
M1385 U734/net26 n574 U734/net29 VSS nmos W=0.155u L=0.04u
M1386 N7742 N7707 U734/net43 VDD pmos W=0.205u L=0.04u
M1387 N7742 n574 U734/net49 VDD pmos W=0.205u L=0.04u
M1388 U734/net49 N7702 VDD VDD pmos W=0.205u L=0.04u
M1389 U734/net43 n575 VDD VDD pmos W=0.205u L=0.04u
M1390 N7742 n745 VDD VDD pmos W=0.205u L=0.04u
M1391 U735/net29 n578 VSS VSS nmos W=0.155u L=0.04u
M1392 n745 N91 U735/net29 VSS nmos W=0.155u L=0.04u
M1393 n745 N40 U735/net23 VSS nmos W=0.155u L=0.04u
M1394 U735/net23 n577 VSS VSS nmos W=0.155u L=0.04u
M1395 U735/net20 n577 n745 VDD pmos W=0.205u L=0.04u
M1396 U735/net20 N40 n745 VDD pmos W=0.205u L=0.04u
M1397 VDD N91 U735/net20 VDD pmos W=0.205u L=0.04u
M1398 VDD n578 U735/net20 VDD pmos W=0.205u L=0.04u
M1399 N7741 n747 U736/net26 VSS nmos W=0.155u L=0.04u
M1400 N7741 n746 U736/net26 VSS nmos W=0.155u L=0.04u
M1401 U736/net29 n748 VSS VSS nmos W=0.155u L=0.04u
M1402 U736/net26 N7701 U736/net29 VSS nmos W=0.155u L=0.04u
M1403 U736/net26 n574 U736/net29 VSS nmos W=0.155u L=0.04u
M1404 N7741 n746 U736/net43 VDD pmos W=0.205u L=0.04u
M1405 N7741 n574 U736/net49 VDD pmos W=0.205u L=0.04u
M1406 U736/net49 N7701 VDD VDD pmos W=0.205u L=0.04u
M1407 U736/net43 n747 VDD VDD pmos W=0.205u L=0.04u
M1408 N7741 n748 VDD VDD pmos W=0.205u L=0.04u
M1409 U737/net17 N7706 VSS VSS nmos W=0.155u L=0.04u
M1410 U737/net17 n575 VSS VSS nmos W=0.155u L=0.04u
M1411 U737/net63 n577 VSS VSS nmos W=0.155u L=0.04u
M1412 n748 U737/net17 VSS VSS nmos W=0.155u L=0.04u
M1413 n748 N103 U737/net63 VSS nmos W=0.155u L=0.04u
M1414 n748 n577 U737/net31 VDD pmos W=0.205u L=0.04u
M1415 U737/net39 N7706 VDD VDD pmos W=0.195u L=0.04u
M1416 U737/net31 U737/net17 VDD VDD pmos W=0.195u L=0.04u
M1417 n748 N103 U737/net31 VDD pmos W=0.195u L=0.04u
M1418 U737/net17 n575 U737/net39 VDD pmos W=0.195u L=0.04u
M1419 n747 N100 VSS VSS nmos W=0.135u L=0.04u
M1420 n747 N100 VDD VDD pmos W=0.205u L=0.04u
M1421 N7740 n575 U739/net26 VSS nmos W=0.155u L=0.04u
M1422 N7740 N7705 U739/net26 VSS nmos W=0.155u L=0.04u
M1423 U739/net29 n749 VSS VSS nmos W=0.155u L=0.04u
M1424 U739/net26 N7700 U739/net29 VSS nmos W=0.155u L=0.04u
M1425 U739/net26 n574 U739/net29 VSS nmos W=0.155u L=0.04u
M1426 N7740 N7705 U739/net43 VDD pmos W=0.205u L=0.04u
M1427 N7740 n574 U739/net49 VDD pmos W=0.205u L=0.04u
M1428 U739/net49 N7700 VDD VDD pmos W=0.205u L=0.04u
M1429 U739/net43 n575 VDD VDD pmos W=0.205u L=0.04u
M1430 N7740 n749 VDD VDD pmos W=0.205u L=0.04u
M1431 U740/net29 n578 VSS VSS nmos W=0.155u L=0.04u
M1432 n749 N46 U740/net29 VSS nmos W=0.155u L=0.04u
M1433 n749 N49 U740/net23 VSS nmos W=0.155u L=0.04u
M1434 U740/net23 n577 VSS VSS nmos W=0.155u L=0.04u
M1435 U740/net20 n577 n749 VDD pmos W=0.205u L=0.04u
M1436 U740/net20 N49 n749 VDD pmos W=0.205u L=0.04u
M1437 VDD N46 U740/net20 VDD pmos W=0.205u L=0.04u
M1438 VDD n578 U740/net20 VDD pmos W=0.205u L=0.04u
M1439 N7739 n579 U741/net26 VSS nmos W=0.155u L=0.04u
M1440 N7739 N7702 U741/net26 VSS nmos W=0.155u L=0.04u
M1441 U741/net29 n752 VSS VSS nmos W=0.155u L=0.04u
M1442 U741/net26 n750 U741/net29 VSS nmos W=0.155u L=0.04u
M1443 U741/net26 n751 U741/net29 VSS nmos W=0.155u L=0.04u
M1444 N7739 N7702 U741/net43 VDD pmos W=0.205u L=0.04u
M1445 N7739 n751 U741/net49 VDD pmos W=0.205u L=0.04u
M1446 U741/net49 n750 VDD VDD pmos W=0.205u L=0.04u
M1447 U741/net43 n579 VDD VDD pmos W=0.205u L=0.04u
M1448 N7739 n752 VDD VDD pmos W=0.205u L=0.04u
M1449 U742/net17 N7707 VSS VSS nmos W=0.155u L=0.04u
M1450 U742/net17 n580 VSS VSS nmos W=0.155u L=0.04u
M1451 U742/net63 n583 VSS VSS nmos W=0.155u L=0.04u
M1452 n752 U742/net17 VSS VSS nmos W=0.155u L=0.04u
M1453 n752 N40 U742/net63 VSS nmos W=0.155u L=0.04u
M1454 n752 n583 U742/net31 VDD pmos W=0.205u L=0.04u
M1455 U742/net39 N7707 VDD VDD pmos W=0.195u L=0.04u
M1456 U742/net31 U742/net17 VDD VDD pmos W=0.195u L=0.04u
M1457 n752 N40 U742/net31 VDD pmos W=0.195u L=0.04u
M1458 U742/net17 n580 U742/net39 VDD pmos W=0.195u L=0.04u
M1459 n751 N91 VSS VSS nmos W=0.135u L=0.04u
M1460 n751 N91 VDD VDD pmos W=0.205u L=0.04u
M1461 n750 n582 VSS VSS nmos W=0.135u L=0.04u
M1462 n750 n582 VDD VDD pmos W=0.205u L=0.04u
M1463 N7738 n580 U745/net26 VSS nmos W=0.155u L=0.04u
M1464 N7738 N7706 U745/net26 VSS nmos W=0.155u L=0.04u
M1465 U745/net29 n753 VSS VSS nmos W=0.155u L=0.04u
M1466 U745/net26 N7701 U745/net29 VSS nmos W=0.155u L=0.04u
M1467 U745/net26 n579 U745/net29 VSS nmos W=0.155u L=0.04u
M1468 N7738 N7706 U745/net43 VDD pmos W=0.205u L=0.04u
M1469 N7738 n579 U745/net49 VDD pmos W=0.205u L=0.04u
M1470 U745/net49 N7701 VDD VDD pmos W=0.205u L=0.04u
M1471 U745/net43 n580 VDD VDD pmos W=0.205u L=0.04u
M1472 N7738 n753 VDD VDD pmos W=0.205u L=0.04u
M1473 U746/net29 n583 VSS VSS nmos W=0.155u L=0.04u
M1474 n753 N103 U746/net29 VSS nmos W=0.155u L=0.04u
M1475 n753 N100 U746/net23 VSS nmos W=0.155u L=0.04u
M1476 U746/net23 n582 VSS VSS nmos W=0.155u L=0.04u
M1477 U746/net20 n582 n753 VDD pmos W=0.205u L=0.04u
M1478 U746/net20 N100 n753 VDD pmos W=0.205u L=0.04u
M1479 VDD N103 U746/net20 VDD pmos W=0.205u L=0.04u
M1480 VDD n583 U746/net20 VDD pmos W=0.205u L=0.04u
M1481 n583 n754 VSS VSS nmos W=0.135u L=0.04u
M1482 n583 n754 VDD VDD pmos W=0.205u L=0.04u
M1483 n579 n755 VSS VSS nmos W=0.135u L=0.04u
M1484 n579 n755 VDD VDD pmos W=0.205u L=0.04u
M1485 N7737 n756 U749/net26 VSS nmos W=0.155u L=0.04u
M1486 N7737 n754 U749/net26 VSS nmos W=0.155u L=0.04u
M1487 U749/net29 n757 VSS VSS nmos W=0.155u L=0.04u
M1488 U749/net26 N7705 U749/net29 VSS nmos W=0.155u L=0.04u
M1489 U749/net26 n580 U749/net29 VSS nmos W=0.155u L=0.04u
M1490 N7737 n754 U749/net43 VDD pmos W=0.205u L=0.04u
M1491 N7737 n580 U749/net49 VDD pmos W=0.205u L=0.04u
M1492 U749/net49 N7705 VDD VDD pmos W=0.205u L=0.04u
M1493 U749/net43 n756 VDD VDD pmos W=0.205u L=0.04u
M1494 N7737 n757 VDD VDD pmos W=0.205u L=0.04u
M1495 U750/net29 n582 VSS VSS nmos W=0.155u L=0.04u
M1496 n757 N46 U750/net29 VSS nmos W=0.155u L=0.04u
M1497 n757 n755 U750/net23 VSS nmos W=0.155u L=0.04u
M1498 U750/net23 n727 VSS VSS nmos W=0.155u L=0.04u
M1499 U750/net20 n727 n757 VDD pmos W=0.205u L=0.04u
M1500 U750/net20 n755 n757 VDD pmos W=0.205u L=0.04u
M1501 VDD N46 U750/net20 VDD pmos W=0.205u L=0.04u
M1502 VDD n582 U750/net20 VDD pmos W=0.205u L=0.04u
M1503 n727 N7700 VSS VSS nmos W=0.135u L=0.04u
M1504 n727 N7700 VDD VDD pmos W=0.205u L=0.04u
M1505 n756 N49 VSS VSS nmos W=0.135u L=0.04u
M1506 n756 N49 VDD VDD pmos W=0.205u L=0.04u
M1507 N7736 n758 U753/net26 VSS nmos W=0.155u L=0.04u
M1508 N7736 n754 U753/net26 VSS nmos W=0.155u L=0.04u
M1509 U753/net29 n759 VSS VSS nmos W=0.155u L=0.04u
M1510 U753/net26 N7704 U753/net29 VSS nmos W=0.155u L=0.04u
M1511 U753/net26 n580 U753/net29 VSS nmos W=0.155u L=0.04u
M1512 N7736 n754 U753/net43 VDD pmos W=0.205u L=0.04u
M1513 N7736 n580 U753/net49 VDD pmos W=0.205u L=0.04u
M1514 U753/net49 N7704 VDD VDD pmos W=0.205u L=0.04u
M1515 U753/net43 n758 VDD VDD pmos W=0.205u L=0.04u
M1516 N7736 n759 VDD VDD pmos W=0.205u L=0.04u
M1517 U754/net29 n582 VSS VSS nmos W=0.155u L=0.04u
M1518 n759 N109 U754/net29 VSS nmos W=0.155u L=0.04u
M1519 n759 n755 U754/net23 VSS nmos W=0.155u L=0.04u
M1520 U754/net23 n723 VSS VSS nmos W=0.155u L=0.04u
M1521 U754/net20 n723 n759 VDD pmos W=0.205u L=0.04u
M1522 U754/net20 n755 n759 VDD pmos W=0.205u L=0.04u
M1523 VDD N109 U754/net20 VDD pmos W=0.205u L=0.04u
M1524 VDD n582 U754/net20 VDD pmos W=0.205u L=0.04u
M1525 n723 N7699 VSS VSS nmos W=0.135u L=0.04u
M1526 n723 N7699 VDD VDD pmos W=0.205u L=0.04u
M1527 n758 N106 VSS VSS nmos W=0.135u L=0.04u
M1528 n758 N106 VDD VDD pmos W=0.205u L=0.04u
M1529 N7735 n575 U757/net26 VSS nmos W=0.155u L=0.04u
M1530 N7735 N7704 U757/net26 VSS nmos W=0.155u L=0.04u
M1531 U757/net29 n760 VSS VSS nmos W=0.155u L=0.04u
M1532 U757/net26 N7699 U757/net29 VSS nmos W=0.155u L=0.04u
M1533 U757/net26 n574 U757/net29 VSS nmos W=0.155u L=0.04u
M1534 N7735 N7704 U757/net43 VDD pmos W=0.205u L=0.04u
M1535 N7735 n574 U757/net49 VDD pmos W=0.205u L=0.04u
M1536 U757/net49 N7699 VDD VDD pmos W=0.205u L=0.04u
M1537 U757/net43 n575 VDD VDD pmos W=0.205u L=0.04u
M1538 N7735 n760 VDD VDD pmos W=0.205u L=0.04u
M1539 U758/net29 n578 VSS VSS nmos W=0.155u L=0.04u
M1540 n760 N109 U758/net29 VSS nmos W=0.155u L=0.04u
M1541 n760 N106 U758/net23 VSS nmos W=0.155u L=0.04u
M1542 U758/net23 n577 VSS VSS nmos W=0.155u L=0.04u
M1543 U758/net20 n577 n760 VDD pmos W=0.205u L=0.04u
M1544 U758/net20 N106 n760 VDD pmos W=0.205u L=0.04u
M1545 VDD N109 U758/net20 VDD pmos W=0.205u L=0.04u
M1546 VDD n578 U758/net20 VDD pmos W=0.205u L=0.04u
M1547 N7707 n763 U759/XI21-net17 VSS nmos W=0.155u L=0.04u
M1548 U759/XI21-net17 n586 VSS VSS nmos W=0.155u L=0.04u
M1549 N7707 n761 U759/XI6-net17 VSS nmos W=0.155u L=0.04u
M1550 U759/XI6-net17 n584 VSS VSS nmos W=0.155u L=0.04u
M1551 N7707 N113 U759/XI20-net17 VSS nmos W=0.155u L=0.04u
M1552 U759/XI20-net17 n762 VSS VSS nmos W=0.155u L=0.04u
M1553 VDD n763 U759/net22 VDD pmos W=0.205u L=0.04u
M1554 VDD n586 U759/net22 VDD pmos W=0.205u L=0.04u
M1555 U759/net16 n761 N7707 VDD pmos W=0.205u L=0.04u
M1556 U759/net16 n584 N7707 VDD pmos W=0.205u L=0.04u
M1557 U759/net22 N113 U759/net16 VDD pmos W=0.205u L=0.04u
M1558 U759/net22 n762 U759/net16 VDD pmos W=0.205u L=0.04u
M1559 N7706 n765 U760/XI21-net17 VSS nmos W=0.155u L=0.04u
M1560 U760/XI21-net17 n584 VSS VSS nmos W=0.155u L=0.04u
M1561 N7706 N53 U760/XI6-net17 VSS nmos W=0.155u L=0.04u
M1562 U760/XI6-net17 n762 VSS VSS nmos W=0.155u L=0.04u
M1563 N7706 n764 U760/XI20-net17 VSS nmos W=0.155u L=0.04u
M1564 U760/XI20-net17 n586 VSS VSS nmos W=0.155u L=0.04u
M1565 VDD n765 U760/net22 VDD pmos W=0.205u L=0.04u
M1566 VDD n584 U760/net22 VDD pmos W=0.205u L=0.04u
M1567 U760/net16 N53 N7706 VDD pmos W=0.205u L=0.04u
M1568 U760/net16 n762 N7706 VDD pmos W=0.205u L=0.04u
M1569 U760/net22 n764 U760/net16 VDD pmos W=0.205u L=0.04u
M1570 U760/net22 n586 U760/net16 VDD pmos W=0.205u L=0.04u
M1571 N7705 n586 U761/XI21-net17 VSS nmos W=0.155u L=0.04u
M1572 U761/XI21-net17 n767 VSS VSS nmos W=0.155u L=0.04u
M1573 N7705 n766 U761/XI6-net17 VSS nmos W=0.155u L=0.04u
M1574 U761/XI6-net17 n584 VSS VSS nmos W=0.155u L=0.04u
M1575 N7705 N114 U761/XI20-net17 VSS nmos W=0.155u L=0.04u
M1576 U761/XI20-net17 n762 VSS VSS nmos W=0.155u L=0.04u
M1577 VDD n586 U761/net22 VDD pmos W=0.205u L=0.04u
M1578 VDD n767 U761/net22 VDD pmos W=0.205u L=0.04u
M1579 U761/net16 n766 N7705 VDD pmos W=0.205u L=0.04u
M1580 U761/net16 n584 N7705 VDD pmos W=0.205u L=0.04u
M1581 U761/net22 N114 U761/net16 VDD pmos W=0.205u L=0.04u
M1582 U761/net22 n762 U761/net16 VDD pmos W=0.205u L=0.04u
M1583 N7704 n768 U762/XI21-net17 VSS nmos W=0.155u L=0.04u
M1584 U762/XI21-net17 n586 VSS VSS nmos W=0.155u L=0.04u
M1585 N7704 n584 U762/XI6-net17 VSS nmos W=0.155u L=0.04u
M1586 U762/XI6-net17 n601 VSS VSS nmos W=0.155u L=0.04u
M1587 N7704 N115 U762/XI20-net17 VSS nmos W=0.155u L=0.04u
M1588 U762/XI20-net17 n762 VSS VSS nmos W=0.155u L=0.04u
M1589 VDD n768 U762/net22 VDD pmos W=0.205u L=0.04u
M1590 VDD n586 U762/net22 VDD pmos W=0.205u L=0.04u
M1591 U762/net16 n584 N7704 VDD pmos W=0.205u L=0.04u
M1592 U762/net16 n601 N7704 VDD pmos W=0.205u L=0.04u
M1593 U762/net22 N115 U762/net16 VDD pmos W=0.205u L=0.04u
M1594 U762/net22 n762 U762/net16 VDD pmos W=0.205u L=0.04u
M1595 N7703 U763/net15 VSS VSS nmos W=0.155u L=0.04u
M1596 N7703 n769 VSS VSS nmos W=0.155u L=0.04u
M1597 N7703 n770 VSS VSS nmos W=0.155u L=0.04u
M1598 N7703 N6716 VSS VSS nmos W=0.155u L=0.04u
M1599 U763/net15 N1140 VSS VSS nmos W=0.155u L=0.04u
M1600 N7703 N6716 U763/XU8-net7 VDD pmos W=0.41u L=0.04u
M1601 U763/XU8-net7 n770 U763/XU8-net10 VDD pmos W=0.41u L=0.04u
M1602 U763/XU8-net10 n769 U763/XU8-net13 VDD pmos W=0.41u L=0.04u
M1603 U763/XU8-net13 U763/net15 VDD VDD pmos W=0.41u L=0.04u
M1604 U763/net15 N1140 VDD VDD pmos W=0.31u L=0.04u
M1605 n770 U764/net7 VSS VSS nmos W=0.155u L=0.04u
M1606 U764/net7 N6877 VSS VSS nmos W=0.155u L=0.04u
M1607 U764/net7 N7474 VSS VSS nmos W=0.155u L=0.04u
M1608 n770 U764/net7 VDD VDD pmos W=0.205u L=0.04u
M1609 U764/X_u7-net8 N7474 VDD VDD pmos W=0.205u L=0.04u
M1610 U764/net7 N6877 U764/X_u7-net8 VDD pmos W=0.205u L=0.04u
M1611 U765/net14 N7476 VSS VSS nmos W=0.155u L=0.04u
M1612 U765/net14 N1152 VSS VSS nmos W=0.155u L=0.04u
M1613 U765/net14 N1155 VSS VSS nmos W=0.155u L=0.04u
M1614 U765/net14 N2061 VSS VSS nmos W=0.155u L=0.04u
M1615 n769 U765/net14 VSS VSS nmos W=0.155u L=0.04u
M1616 U765/net14 N2061 U765/XU8-net7 VDD pmos W=0.205u L=0.04u
M1617 U765/XU8-net7 N1155 U765/XU8-net10 VDD pmos W=0.205u L=0.04u
M1618 U765/XU8-net10 N1152 U765/XU8-net13 VDD pmos W=0.205u L=0.04u
M1619 U765/XU8-net13 N7476 VDD VDD pmos W=0.205u L=0.04u
M1620 n769 U765/net14 VDD VDD pmos W=0.205u L=0.04u
M1621 N7702 n771 U766/XI21-net17 VSS nmos W=0.155u L=0.04u
M1622 U766/XI21-net17 n586 VSS VSS nmos W=0.155u L=0.04u
M1623 N7702 n665 U766/XI6-net17 VSS nmos W=0.155u L=0.04u
M1624 U766/XI6-net17 n584 VSS VSS nmos W=0.155u L=0.04u
M1625 N7702 N112 U766/XI20-net17 VSS nmos W=0.155u L=0.04u
M1626 U766/XI20-net17 n762 VSS VSS nmos W=0.155u L=0.04u
M1627 VDD n771 U766/net22 VDD pmos W=0.205u L=0.04u
M1628 VDD n586 U766/net22 VDD pmos W=0.205u L=0.04u
M1629 U766/net16 n665 N7702 VDD pmos W=0.205u L=0.04u
M1630 U766/net16 n584 N7702 VDD pmos W=0.205u L=0.04u
M1631 U766/net22 N112 U766/net16 VDD pmos W=0.205u L=0.04u
M1632 U766/net22 n762 U766/net16 VDD pmos W=0.205u L=0.04u
M1633 N7701 n772 U767/XI21-net17 VSS nmos W=0.155u L=0.04u
M1634 U767/XI21-net17 n586 VSS VSS nmos W=0.155u L=0.04u
M1635 N7701 n672 U767/XI6-net17 VSS nmos W=0.155u L=0.04u
M1636 U767/XI6-net17 n584 VSS VSS nmos W=0.155u L=0.04u
M1637 N7701 N116 U767/XI20-net17 VSS nmos W=0.155u L=0.04u
M1638 U767/XI20-net17 n762 VSS VSS nmos W=0.155u L=0.04u
M1639 VDD n772 U767/net22 VDD pmos W=0.205u L=0.04u
M1640 VDD n586 U767/net22 VDD pmos W=0.205u L=0.04u
M1641 U767/net16 n672 N7701 VDD pmos W=0.205u L=0.04u
M1642 U767/net16 n584 N7701 VDD pmos W=0.205u L=0.04u
M1643 U767/net22 N116 U767/net16 VDD pmos W=0.205u L=0.04u
M1644 U767/net22 n762 U767/net16 VDD pmos W=0.205u L=0.04u
M1645 N7700 n773 U768/XI21-net17 VSS nmos W=0.155u L=0.04u
M1646 U768/XI21-net17 n586 VSS VSS nmos W=0.155u L=0.04u
M1647 N7700 n671 U768/XI6-net17 VSS nmos W=0.155u L=0.04u
M1648 U768/XI6-net17 n584 VSS VSS nmos W=0.155u L=0.04u
M1649 N7700 N121 U768/XI20-net17 VSS nmos W=0.155u L=0.04u
M1650 U768/XI20-net17 n762 VSS VSS nmos W=0.155u L=0.04u
M1651 VDD n773 U768/net22 VDD pmos W=0.205u L=0.04u
M1652 VDD n586 U768/net22 VDD pmos W=0.205u L=0.04u
M1653 U768/net16 n671 N7700 VDD pmos W=0.205u L=0.04u
M1654 U768/net16 n584 N7700 VDD pmos W=0.205u L=0.04u
M1655 U768/net22 N121 U768/net16 VDD pmos W=0.205u L=0.04u
M1656 U768/net22 n762 U768/net16 VDD pmos W=0.205u L=0.04u
M1657 N7699 n584 U769/XI21-net17 VSS nmos W=0.155u L=0.04u
M1658 U769/XI21-net17 n670 VSS VSS nmos W=0.155u L=0.04u
M1659 N7699 n774 U769/XI6-net17 VSS nmos W=0.155u L=0.04u
M1660 U769/XI6-net17 n586 VSS VSS nmos W=0.155u L=0.04u
M1661 N7699 n762 U769/XI20-net17 VSS nmos W=0.155u L=0.04u
M1662 U769/XI20-net17 N123 VSS VSS nmos W=0.155u L=0.04u
M1663 VDD n584 U769/net22 VDD pmos W=0.205u L=0.04u
M1664 VDD n670 U769/net22 VDD pmos W=0.205u L=0.04u
M1665 U769/net16 n774 N7699 VDD pmos W=0.205u L=0.04u
M1666 U769/net16 n586 N7699 VDD pmos W=0.205u L=0.04u
M1667 U769/net22 n762 U769/net16 VDD pmos W=0.205u L=0.04u
M1668 U769/net22 N123 U769/net16 VDD pmos W=0.205u L=0.04u
M1669 U770/net4 U770/net10 U770/net14 VSS nmos W=0.155u L=0.04u
M1670 U770/net6 n775 U770/net14 VSS nmos W=0.155u L=0.04u
M1671 U770/net4 n774 VSS VSS nmos W=0.155u L=0.04u
M1672 U770/net6 U770/net4 VSS VSS nmos W=0.155u L=0.04u
M1673 N7698 U770/net14 VSS VSS nmos W=0.155u L=0.04u
M1674 U770/net10 n775 VSS VSS nmos W=0.155u L=0.04u
M1675 U770/net4 n775 U770/net14 VDD pmos W=0.205u L=0.04u
M1676 U770/net6 U770/net10 U770/net14 VDD pmos W=0.205u L=0.04u
M1677 U770/net4 n774 VDD VDD pmos W=0.205u L=0.04u
M1678 U770/net6 U770/net4 VDD VDD pmos W=0.205u L=0.04u
M1679 N7698 U770/net14 VDD VDD pmos W=0.205u L=0.04u
M1680 U770/net10 n775 VDD VDD pmos W=0.205u L=0.04u
M1681 N7626 N631 U771/net27 VSS nmos W=0.155u L=0.04u
M1682 U771/net27 N135 VSS VSS nmos W=0.155u L=0.04u
M1683 N7626 n776 VSS VSS nmos W=0.155u L=0.04u
M1684 N7626 N135 U771/net13 VDD pmos W=0.205u L=0.04u
M1685 U771/net13 n776 VDD VDD pmos W=0.205u L=0.04u
M1686 N7626 N631 U771/net13 VDD pmos W=0.205u L=0.04u
M1687 U772/net24 N599 VSS VSS nmos W=0.155u L=0.04u
M1688 U772/net74 N123 VSS VSS nmos W=0.155u L=0.04u
M1689 U772/net72 n670 VSS VSS nmos W=0.155u L=0.04u
M1690 U772/net76 n774 VSS VSS nmos W=0.31u L=0.04u
M1691 U772/net044 N603 VSS VSS nmos W=0.155u L=0.04u
M1692 U772/net052 n775 VSS VSS nmos W=0.31u L=0.04u
M1693 U772/PG2 N599 n776 VSS nmos W=0.22u L=0.04u
M1694 U772/net74 U772/net044 U772/PG2 VSS nmos W=0.12u L=0.04u
M1695 U772/net052 N603 U772/PG1 VSS nmos W=0.155u L=0.04u
M1696 U772/PG1 U772/net24 n776 VSS nmos W=0.155u L=0.04u
M1697 U772/net76 N603 U772/PG2 VSS nmos W=0.155u L=0.04u
M1698 U772/net72 U772/net044 U772/PG1 VSS nmos W=0.12u L=0.04u
M1699 U772/net24 N599 VDD VDD pmos W=0.205u L=0.04u
M1700 U772/net74 N123 VDD VDD pmos W=0.205u L=0.04u
M1701 U772/net72 n670 VDD VDD pmos W=0.205u L=0.04u
M1702 U772/net76 n774 VDD VDD pmos W=0.41u L=0.04u
M1703 U772/net044 N603 VDD VDD pmos W=0.205u L=0.04u
M1704 U772/net052 n775 VDD VDD pmos W=0.41u L=0.04u
M1705 U772/PG2 U772/net24 n776 VDD pmos W=0.205u L=0.04u
M1706 U772/net74 N603 U772/PG2 VDD pmos W=0.205u L=0.04u
M1707 U772/net052 U772/net044 U772/PG1 VDD pmos W=0.205u L=0.04u
M1708 U772/PG1 N599 n776 VDD pmos W=0.29u L=0.04u
M1709 U772/net76 U772/net044 U772/PG2 VDD pmos W=0.205u L=0.04u
M1710 U772/net72 N603 U772/PG1 VDD pmos W=0.205u L=0.04u
M1711 U773/net4 U773/net10 U773/net14 VSS nmos W=0.155u L=0.04u
M1712 U773/net6 N132 U773/net14 VSS nmos W=0.155u L=0.04u
M1713 U773/net4 n777 VSS VSS nmos W=0.155u L=0.04u
M1714 U773/net6 U773/net4 VSS VSS nmos W=0.155u L=0.04u
M1715 n775 U773/net14 VSS VSS nmos W=0.155u L=0.04u
M1716 U773/net10 N132 VSS VSS nmos W=0.155u L=0.04u
M1717 U773/net4 N132 U773/net14 VDD pmos W=0.205u L=0.04u
M1718 U773/net6 U773/net10 U773/net14 VDD pmos W=0.205u L=0.04u
M1719 U773/net4 n777 VDD VDD pmos W=0.205u L=0.04u
M1720 U773/net6 U773/net4 VDD VDD pmos W=0.205u L=0.04u
M1721 n775 U773/net14 VDD VDD pmos W=0.205u L=0.04u
M1722 U773/net10 N132 VDD VDD pmos W=0.205u L=0.04u
M1723 N7607 n778 U774/net26 VSS nmos W=0.155u L=0.04u
M1724 N7607 n718 U774/net26 VSS nmos W=0.155u L=0.04u
M1725 U774/net29 n779 VSS VSS nmos W=0.155u L=0.04u
M1726 U774/net26 N7471 U774/net29 VSS nmos W=0.155u L=0.04u
M1727 U774/net26 n720 U774/net29 VSS nmos W=0.155u L=0.04u
M1728 N7607 n718 U774/net43 VDD pmos W=0.205u L=0.04u
M1729 N7607 n720 U774/net49 VDD pmos W=0.205u L=0.04u
M1730 U774/net49 N7471 VDD VDD pmos W=0.205u L=0.04u
M1731 U774/net43 n778 VDD VDD pmos W=0.205u L=0.04u
M1732 N7607 n779 VDD VDD pmos W=0.205u L=0.04u
M1733 U775/net29 n724 VSS VSS nmos W=0.155u L=0.04u
M1734 n779 N149 U775/net29 VSS nmos W=0.155u L=0.04u
M1735 n779 n722 U775/net23 VSS nmos W=0.155u L=0.04u
M1736 U775/net23 n780 VSS VSS nmos W=0.155u L=0.04u
M1737 U775/net20 n780 n779 VDD pmos W=0.205u L=0.04u
M1738 U775/net20 n722 n779 VDD pmos W=0.205u L=0.04u
M1739 VDD N149 U775/net20 VDD pmos W=0.205u L=0.04u
M1740 VDD n724 U775/net20 VDD pmos W=0.205u L=0.04u
M1741 N7606 n781 U776/net26 VSS nmos W=0.155u L=0.04u
M1742 N7606 n718 U776/net26 VSS nmos W=0.155u L=0.04u
M1743 U776/net29 n782 VSS VSS nmos W=0.155u L=0.04u
M1744 U776/net26 N7472 U776/net29 VSS nmos W=0.155u L=0.04u
M1745 U776/net26 n720 U776/net29 VSS nmos W=0.155u L=0.04u
M1746 N7606 n718 U776/net43 VDD pmos W=0.205u L=0.04u
M1747 N7606 n720 U776/net49 VDD pmos W=0.205u L=0.04u
M1748 U776/net49 N7472 VDD VDD pmos W=0.205u L=0.04u
M1749 U776/net43 n781 VDD VDD pmos W=0.205u L=0.04u
M1750 N7606 n782 VDD VDD pmos W=0.205u L=0.04u
M1751 U777/net29 n724 VSS VSS nmos W=0.155u L=0.04u
M1752 n782 N155 U777/net29 VSS nmos W=0.155u L=0.04u
M1753 n782 n722 U777/net23 VSS nmos W=0.155u L=0.04u
M1754 U777/net23 n783 VSS VSS nmos W=0.155u L=0.04u
M1755 U777/net20 n783 n782 VDD pmos W=0.205u L=0.04u
M1756 U777/net20 n722 n782 VDD pmos W=0.205u L=0.04u
M1757 VDD N155 U777/net20 VDD pmos W=0.205u L=0.04u
M1758 VDD n724 U777/net20 VDD pmos W=0.205u L=0.04u
M1759 N7605 n784 U778/net26 VSS nmos W=0.155u L=0.04u
M1760 N7605 n718 U778/net26 VSS nmos W=0.155u L=0.04u
M1761 U778/net29 n785 VSS VSS nmos W=0.155u L=0.04u
M1762 U778/net26 N7473 U778/net29 VSS nmos W=0.155u L=0.04u
M1763 U778/net26 n720 U778/net29 VSS nmos W=0.155u L=0.04u
M1764 N7605 n718 U778/net43 VDD pmos W=0.205u L=0.04u
M1765 N7605 n720 U778/net49 VDD pmos W=0.205u L=0.04u
M1766 U778/net49 N7473 VDD VDD pmos W=0.205u L=0.04u
M1767 U778/net43 n784 VDD VDD pmos W=0.205u L=0.04u
M1768 N7605 n785 VDD VDD pmos W=0.205u L=0.04u
M1769 U779/net29 n724 VSS VSS nmos W=0.155u L=0.04u
M1770 n785 N188 U779/net29 VSS nmos W=0.155u L=0.04u
M1771 n785 n722 U779/net23 VSS nmos W=0.155u L=0.04u
M1772 U779/net23 n786 VSS VSS nmos W=0.155u L=0.04u
M1773 U779/net20 n786 n785 VDD pmos W=0.205u L=0.04u
M1774 U779/net20 n722 n785 VDD pmos W=0.205u L=0.04u
M1775 VDD N188 U779/net20 VDD pmos W=0.205u L=0.04u
M1776 VDD n724 U779/net20 VDD pmos W=0.205u L=0.04u
M1777 N7604 n787 U780/net26 VSS nmos W=0.155u L=0.04u
M1778 N7604 n718 U780/net26 VSS nmos W=0.155u L=0.04u
M1779 U780/net29 n788 VSS VSS nmos W=0.155u L=0.04u
M1780 U780/net26 N7470 U780/net29 VSS nmos W=0.155u L=0.04u
M1781 U780/net26 n720 U780/net29 VSS nmos W=0.155u L=0.04u
M1782 N7604 n718 U780/net43 VDD pmos W=0.205u L=0.04u
M1783 N7604 n720 U780/net49 VDD pmos W=0.205u L=0.04u
M1784 U780/net49 N7470 VDD VDD pmos W=0.205u L=0.04u
M1785 U780/net43 n787 VDD VDD pmos W=0.205u L=0.04u
M1786 N7604 n788 VDD VDD pmos W=0.205u L=0.04u
M1787 U781/net29 n724 VSS VSS nmos W=0.155u L=0.04u
M1788 n788 N200 U781/net29 VSS nmos W=0.155u L=0.04u
M1789 n788 n722 U781/net23 VSS nmos W=0.155u L=0.04u
M1790 U781/net23 n789 VSS VSS nmos W=0.155u L=0.04u
M1791 U781/net20 n789 n788 VDD pmos W=0.205u L=0.04u
M1792 U781/net20 n722 n788 VDD pmos W=0.205u L=0.04u
M1793 VDD N200 U781/net20 VDD pmos W=0.205u L=0.04u
M1794 VDD n724 U781/net20 VDD pmos W=0.205u L=0.04u
M1795 N7603 n778 U782/net26 VSS nmos W=0.155u L=0.04u
M1796 N7603 n734 U782/net26 VSS nmos W=0.155u L=0.04u
M1797 U782/net29 n790 VSS VSS nmos W=0.155u L=0.04u
M1798 U782/net26 N7471 U782/net29 VSS nmos W=0.155u L=0.04u
M1799 U782/net26 n735 U782/net29 VSS nmos W=0.155u L=0.04u
M1800 N7603 n734 U782/net43 VDD pmos W=0.205u L=0.04u
M1801 N7603 n735 U782/net49 VDD pmos W=0.205u L=0.04u
M1802 U782/net49 N7471 VDD VDD pmos W=0.205u L=0.04u
M1803 U782/net43 n778 VDD VDD pmos W=0.205u L=0.04u
M1804 N7603 n790 VDD VDD pmos W=0.205u L=0.04u
M1805 U783/net29 n738 VSS VSS nmos W=0.155u L=0.04u
M1806 n790 N149 U783/net29 VSS nmos W=0.155u L=0.04u
M1807 n790 n737 U783/net23 VSS nmos W=0.155u L=0.04u
M1808 U783/net23 n780 VSS VSS nmos W=0.155u L=0.04u
M1809 U783/net20 n780 n790 VDD pmos W=0.205u L=0.04u
M1810 U783/net20 n737 n790 VDD pmos W=0.205u L=0.04u
M1811 VDD N149 U783/net20 VDD pmos W=0.205u L=0.04u
M1812 VDD n738 U783/net20 VDD pmos W=0.205u L=0.04u
M1813 n778 N146 VSS VSS nmos W=0.135u L=0.04u
M1814 n778 N146 VDD VDD pmos W=0.205u L=0.04u
M1815 N7602 n781 U785/net26 VSS nmos W=0.155u L=0.04u
M1816 N7602 n734 U785/net26 VSS nmos W=0.155u L=0.04u
M1817 U785/net29 n791 VSS VSS nmos W=0.155u L=0.04u
M1818 U785/net26 N7472 U785/net29 VSS nmos W=0.155u L=0.04u
M1819 U785/net26 n735 U785/net29 VSS nmos W=0.155u L=0.04u
M1820 N7602 n734 U785/net43 VDD pmos W=0.205u L=0.04u
M1821 N7602 n735 U785/net49 VDD pmos W=0.205u L=0.04u
M1822 U785/net49 N7472 VDD VDD pmos W=0.205u L=0.04u
M1823 U785/net43 n781 VDD VDD pmos W=0.205u L=0.04u
M1824 N7602 n791 VDD VDD pmos W=0.205u L=0.04u
M1825 U786/net29 n738 VSS VSS nmos W=0.155u L=0.04u
M1826 n791 N155 U786/net29 VSS nmos W=0.155u L=0.04u
M1827 n791 n737 U786/net23 VSS nmos W=0.155u L=0.04u
M1828 U786/net23 n783 VSS VSS nmos W=0.155u L=0.04u
M1829 U786/net20 n783 n791 VDD pmos W=0.205u L=0.04u
M1830 U786/net20 n737 n791 VDD pmos W=0.205u L=0.04u
M1831 VDD N155 U786/net20 VDD pmos W=0.205u L=0.04u
M1832 VDD n738 U786/net20 VDD pmos W=0.205u L=0.04u
M1833 n781 N152 VSS VSS nmos W=0.135u L=0.04u
M1834 n781 N152 VDD VDD pmos W=0.205u L=0.04u
M1835 N7601 n784 U788/net26 VSS nmos W=0.155u L=0.04u
M1836 N7601 n734 U788/net26 VSS nmos W=0.155u L=0.04u
M1837 U788/net29 n792 VSS VSS nmos W=0.155u L=0.04u
M1838 U788/net26 N7473 U788/net29 VSS nmos W=0.155u L=0.04u
M1839 U788/net26 n735 U788/net29 VSS nmos W=0.155u L=0.04u
M1840 N7601 n734 U788/net43 VDD pmos W=0.205u L=0.04u
M1841 N7601 n735 U788/net49 VDD pmos W=0.205u L=0.04u
M1842 U788/net49 N7473 VDD VDD pmos W=0.205u L=0.04u
M1843 U788/net43 n784 VDD VDD pmos W=0.205u L=0.04u
M1844 N7601 n792 VDD VDD pmos W=0.205u L=0.04u
M1845 U789/net29 n738 VSS VSS nmos W=0.155u L=0.04u
M1846 n792 N188 U789/net29 VSS nmos W=0.155u L=0.04u
M1847 n792 n737 U789/net23 VSS nmos W=0.155u L=0.04u
M1848 U789/net23 n786 VSS VSS nmos W=0.155u L=0.04u
M1849 U789/net20 n786 n792 VDD pmos W=0.205u L=0.04u
M1850 U789/net20 n737 n792 VDD pmos W=0.205u L=0.04u
M1851 VDD N188 U789/net20 VDD pmos W=0.205u L=0.04u
M1852 VDD n738 U789/net20 VDD pmos W=0.205u L=0.04u
M1853 n784 N158 VSS VSS nmos W=0.135u L=0.04u
M1854 n784 N158 VDD VDD pmos W=0.205u L=0.04u
M1855 N7600 n787 U791/net26 VSS nmos W=0.155u L=0.04u
M1856 N7600 n734 U791/net26 VSS nmos W=0.155u L=0.04u
M1857 U791/net29 n793 VSS VSS nmos W=0.155u L=0.04u
M1858 U791/net26 N7470 U791/net29 VSS nmos W=0.155u L=0.04u
M1859 U791/net26 n735 U791/net29 VSS nmos W=0.155u L=0.04u
M1860 N7600 n734 U791/net43 VDD pmos W=0.205u L=0.04u
M1861 N7600 n735 U791/net49 VDD pmos W=0.205u L=0.04u
M1862 U791/net49 N7470 VDD VDD pmos W=0.205u L=0.04u
M1863 U791/net43 n787 VDD VDD pmos W=0.205u L=0.04u
M1864 N7600 n793 VDD VDD pmos W=0.205u L=0.04u
M1865 U792/net29 n738 VSS VSS nmos W=0.155u L=0.04u
M1866 n793 N200 U792/net29 VSS nmos W=0.155u L=0.04u
M1867 n793 n737 U792/net23 VSS nmos W=0.155u L=0.04u
M1868 U792/net23 n789 VSS VSS nmos W=0.155u L=0.04u
M1869 U792/net20 n789 n793 VDD pmos W=0.205u L=0.04u
M1870 U792/net20 n737 n793 VDD pmos W=0.205u L=0.04u
M1871 VDD N200 U792/net20 VDD pmos W=0.205u L=0.04u
M1872 VDD n738 U792/net20 VDD pmos W=0.205u L=0.04u
M1873 n787 N170 VSS VSS nmos W=0.135u L=0.04u
M1874 n787 N170 VDD VDD pmos W=0.205u L=0.04u
M1875 N7522 n575 U794/net26 VSS nmos W=0.155u L=0.04u
M1876 N7522 N7473 U794/net26 VSS nmos W=0.155u L=0.04u
M1877 U794/net29 n794 VSS VSS nmos W=0.155u L=0.04u
M1878 U794/net26 N7363 U794/net29 VSS nmos W=0.155u L=0.04u
M1879 U794/net26 n574 U794/net29 VSS nmos W=0.155u L=0.04u
M1880 N7522 N7473 U794/net43 VDD pmos W=0.205u L=0.04u
M1881 N7522 n574 U794/net49 VDD pmos W=0.205u L=0.04u
M1882 U794/net49 N7363 VDD VDD pmos W=0.205u L=0.04u
M1883 U794/net43 n575 VDD VDD pmos W=0.205u L=0.04u
M1884 N7522 n794 VDD VDD pmos W=0.205u L=0.04u
M1885 U795/net29 n578 VSS VSS nmos W=0.155u L=0.04u
M1886 n794 N67 U795/net29 VSS nmos W=0.155u L=0.04u
M1887 n794 N70 U795/net23 VSS nmos W=0.155u L=0.04u
M1888 U795/net23 n577 VSS VSS nmos W=0.155u L=0.04u
M1889 U795/net20 n577 n794 VDD pmos W=0.205u L=0.04u
M1890 U795/net20 N70 n794 VDD pmos W=0.205u L=0.04u
M1891 VDD N67 U795/net20 VDD pmos W=0.205u L=0.04u
M1892 VDD n578 U795/net20 VDD pmos W=0.205u L=0.04u
M1893 N7521 n575 U796/net26 VSS nmos W=0.155u L=0.04u
M1894 N7521 N7472 U796/net26 VSS nmos W=0.155u L=0.04u
M1895 U796/net29 n795 VSS VSS nmos W=0.155u L=0.04u
M1896 U796/net26 N7467 U796/net29 VSS nmos W=0.155u L=0.04u
M1897 U796/net26 n574 U796/net29 VSS nmos W=0.155u L=0.04u
M1898 N7521 N7472 U796/net43 VDD pmos W=0.205u L=0.04u
M1899 N7521 n574 U796/net49 VDD pmos W=0.205u L=0.04u
M1900 U796/net49 N7467 VDD VDD pmos W=0.205u L=0.04u
M1901 U796/net43 n575 VDD VDD pmos W=0.205u L=0.04u
M1902 N7521 n795 VDD VDD pmos W=0.205u L=0.04u
M1903 U797/net29 n578 VSS VSS nmos W=0.155u L=0.04u
M1904 n795 N73 U797/net29 VSS nmos W=0.155u L=0.04u
M1905 n795 N17 U797/net23 VSS nmos W=0.155u L=0.04u
M1906 U797/net23 n577 VSS VSS nmos W=0.155u L=0.04u
M1907 U797/net20 n577 n795 VDD pmos W=0.205u L=0.04u
M1908 U797/net20 N17 n795 VDD pmos W=0.205u L=0.04u
M1909 VDD N73 U797/net20 VDD pmos W=0.205u L=0.04u
M1910 VDD n578 U797/net20 VDD pmos W=0.205u L=0.04u
M1911 N7520 n575 U798/net26 VSS nmos W=0.155u L=0.04u
M1912 N7520 N7471 U798/net26 VSS nmos W=0.155u L=0.04u
M1913 U798/net29 n796 VSS VSS nmos W=0.155u L=0.04u
M1914 U798/net26 N7466 U798/net29 VSS nmos W=0.155u L=0.04u
M1915 U798/net26 n574 U798/net29 VSS nmos W=0.155u L=0.04u
M1916 N7520 N7471 U798/net43 VDD pmos W=0.205u L=0.04u
M1917 N7520 n574 U798/net49 VDD pmos W=0.205u L=0.04u
M1918 U798/net49 N7466 VDD VDD pmos W=0.205u L=0.04u
M1919 U798/net43 n575 VDD VDD pmos W=0.205u L=0.04u
M1920 N7520 n796 VDD VDD pmos W=0.205u L=0.04u
M1921 U799/net29 n578 VSS VSS nmos W=0.155u L=0.04u
M1922 n796 N76 U799/net29 VSS nmos W=0.155u L=0.04u
M1923 n796 N20 U799/net23 VSS nmos W=0.155u L=0.04u
M1924 U799/net23 n577 VSS VSS nmos W=0.155u L=0.04u
M1925 U799/net20 n577 n796 VDD pmos W=0.205u L=0.04u
M1926 U799/net20 N20 n796 VDD pmos W=0.205u L=0.04u
M1927 VDD N76 U799/net20 VDD pmos W=0.205u L=0.04u
M1928 VDD n578 U799/net20 VDD pmos W=0.205u L=0.04u
M1929 N7519 n575 U800/net26 VSS nmos W=0.155u L=0.04u
M1930 N7519 N7470 U800/net26 VSS nmos W=0.155u L=0.04u
M1931 U800/net29 n797 VSS VSS nmos W=0.155u L=0.04u
M1932 U800/net26 N7465 U800/net29 VSS nmos W=0.155u L=0.04u
M1933 U800/net26 n574 U800/net29 VSS nmos W=0.155u L=0.04u
M1934 N7519 N7470 U800/net43 VDD pmos W=0.205u L=0.04u
M1935 N7519 n574 U800/net49 VDD pmos W=0.205u L=0.04u
M1936 U800/net49 N7465 VDD VDD pmos W=0.205u L=0.04u
M1937 U800/net43 n575 VDD VDD pmos W=0.205u L=0.04u
M1938 N7519 n797 VDD VDD pmos W=0.205u L=0.04u
M1939 U801/net29 n578 VSS VSS nmos W=0.155u L=0.04u
M1940 n797 N43 U801/net29 VSS nmos W=0.155u L=0.04u
M1941 n797 N37 U801/net23 VSS nmos W=0.155u L=0.04u
M1942 U801/net23 n577 VSS VSS nmos W=0.155u L=0.04u
M1943 U801/net20 n577 n797 VDD pmos W=0.205u L=0.04u
M1944 U801/net20 N37 n797 VDD pmos W=0.205u L=0.04u
M1945 VDD N43 U801/net20 VDD pmos W=0.205u L=0.04u
M1946 VDD n578 U801/net20 VDD pmos W=0.205u L=0.04u
M1947 N7518 n798 U802/net26 VSS nmos W=0.155u L=0.04u
M1948 N7518 n754 U802/net26 VSS nmos W=0.155u L=0.04u
M1949 U802/net29 n799 VSS VSS nmos W=0.155u L=0.04u
M1950 U802/net26 N7473 U802/net29 VSS nmos W=0.155u L=0.04u
M1951 U802/net26 n580 U802/net29 VSS nmos W=0.155u L=0.04u
M1952 N7518 n754 U802/net43 VDD pmos W=0.205u L=0.04u
M1953 N7518 n580 U802/net49 VDD pmos W=0.205u L=0.04u
M1954 U802/net49 N7473 VDD VDD pmos W=0.205u L=0.04u
M1955 U802/net43 n798 VDD VDD pmos W=0.205u L=0.04u
M1956 N7518 n799 VDD VDD pmos W=0.205u L=0.04u
M1957 U803/net29 n582 VSS VSS nmos W=0.155u L=0.04u
M1958 n799 N67 U803/net29 VSS nmos W=0.155u L=0.04u
M1959 n799 n755 U803/net23 VSS nmos W=0.155u L=0.04u
M1960 U803/net23 n786 VSS VSS nmos W=0.155u L=0.04u
M1961 U803/net20 n786 n799 VDD pmos W=0.205u L=0.04u
M1962 U803/net20 n755 n799 VDD pmos W=0.205u L=0.04u
M1963 VDD N67 U803/net20 VDD pmos W=0.205u L=0.04u
M1964 VDD n582 U803/net20 VDD pmos W=0.205u L=0.04u
M1965 n786 N7363 VSS VSS nmos W=0.135u L=0.04u
M1966 n786 N7363 VDD VDD pmos W=0.205u L=0.04u
M1967 n798 N70 VSS VSS nmos W=0.135u L=0.04u
M1968 n798 N70 VDD VDD pmos W=0.205u L=0.04u
M1969 N7517 n800 U806/net26 VSS nmos W=0.155u L=0.04u
M1970 N7517 n754 U806/net26 VSS nmos W=0.155u L=0.04u
M1971 U806/net29 n801 VSS VSS nmos W=0.155u L=0.04u
M1972 U806/net26 N7472 U806/net29 VSS nmos W=0.155u L=0.04u
M1973 U806/net26 n580 U806/net29 VSS nmos W=0.155u L=0.04u
M1974 N7517 n754 U806/net43 VDD pmos W=0.205u L=0.04u
M1975 N7517 n580 U806/net49 VDD pmos W=0.205u L=0.04u
M1976 U806/net49 N7472 VDD VDD pmos W=0.205u L=0.04u
M1977 U806/net43 n800 VDD VDD pmos W=0.205u L=0.04u
M1978 N7517 n801 VDD VDD pmos W=0.205u L=0.04u
M1979 U807/net29 n582 VSS VSS nmos W=0.155u L=0.04u
M1980 n801 N73 U807/net29 VSS nmos W=0.155u L=0.04u
M1981 n801 n755 U807/net23 VSS nmos W=0.155u L=0.04u
M1982 U807/net23 n783 VSS VSS nmos W=0.155u L=0.04u
M1983 U807/net20 n783 n801 VDD pmos W=0.205u L=0.04u
M1984 U807/net20 n755 n801 VDD pmos W=0.205u L=0.04u
M1985 VDD N73 U807/net20 VDD pmos W=0.205u L=0.04u
M1986 VDD n582 U807/net20 VDD pmos W=0.205u L=0.04u
M1987 n783 N7467 VSS VSS nmos W=0.135u L=0.04u
M1988 n783 N7467 VDD VDD pmos W=0.205u L=0.04u
M1989 n800 N17 VSS VSS nmos W=0.135u L=0.04u
M1990 n800 N17 VDD VDD pmos W=0.205u L=0.04u
M1991 N7516 n802 U810/net26 VSS nmos W=0.155u L=0.04u
M1992 N7516 n754 U810/net26 VSS nmos W=0.155u L=0.04u
M1993 U810/net29 n803 VSS VSS nmos W=0.155u L=0.04u
M1994 U810/net26 N7471 U810/net29 VSS nmos W=0.155u L=0.04u
M1995 U810/net26 n580 U810/net29 VSS nmos W=0.155u L=0.04u
M1996 N7516 n754 U810/net43 VDD pmos W=0.205u L=0.04u
M1997 N7516 n580 U810/net49 VDD pmos W=0.205u L=0.04u
M1998 U810/net49 N7471 VDD VDD pmos W=0.205u L=0.04u
M1999 U810/net43 n802 VDD VDD pmos W=0.205u L=0.04u
M2000 N7516 n803 VDD VDD pmos W=0.205u L=0.04u
M2001 U811/net29 n582 VSS VSS nmos W=0.155u L=0.04u
M2002 n803 N76 U811/net29 VSS nmos W=0.155u L=0.04u
M2003 n803 n755 U811/net23 VSS nmos W=0.155u L=0.04u
M2004 U811/net23 n780 VSS VSS nmos W=0.155u L=0.04u
M2005 U811/net20 n780 n803 VDD pmos W=0.205u L=0.04u
M2006 U811/net20 n755 n803 VDD pmos W=0.205u L=0.04u
M2007 VDD N76 U811/net20 VDD pmos W=0.205u L=0.04u
M2008 VDD n582 U811/net20 VDD pmos W=0.205u L=0.04u
M2009 n780 N7466 VSS VSS nmos W=0.135u L=0.04u
M2010 n780 N7466 VDD VDD pmos W=0.205u L=0.04u
M2011 n802 N20 VSS VSS nmos W=0.135u L=0.04u
M2012 n802 N20 VDD VDD pmos W=0.205u L=0.04u
M2013 N7515 n804 U814/net26 VSS nmos W=0.155u L=0.04u
M2014 N7515 n754 U814/net26 VSS nmos W=0.155u L=0.04u
M2015 U814/net29 n805 VSS VSS nmos W=0.155u L=0.04u
M2016 U814/net26 N7470 U814/net29 VSS nmos W=0.155u L=0.04u
M2017 U814/net26 n580 U814/net29 VSS nmos W=0.155u L=0.04u
M2018 N7515 n754 U814/net43 VDD pmos W=0.205u L=0.04u
M2019 N7515 n580 U814/net49 VDD pmos W=0.205u L=0.04u
M2020 U814/net49 N7470 VDD VDD pmos W=0.205u L=0.04u
M2021 U814/net43 n804 VDD VDD pmos W=0.205u L=0.04u
M2022 N7515 n805 VDD VDD pmos W=0.205u L=0.04u
M2023 U815/net29 n582 VSS VSS nmos W=0.155u L=0.04u
M2024 n805 N43 U815/net29 VSS nmos W=0.155u L=0.04u
M2025 n805 n755 U815/net23 VSS nmos W=0.155u L=0.04u
M2026 U815/net23 n789 VSS VSS nmos W=0.155u L=0.04u
M2027 U815/net20 n789 n805 VDD pmos W=0.205u L=0.04u
M2028 U815/net20 n755 n805 VDD pmos W=0.205u L=0.04u
M2029 VDD N43 U815/net20 VDD pmos W=0.205u L=0.04u
M2030 VDD n582 U815/net20 VDD pmos W=0.205u L=0.04u
M2031 n789 N7465 VSS VSS nmos W=0.135u L=0.04u
M2032 n789 N7465 VDD VDD pmos W=0.205u L=0.04u
M2033 n804 N37 VSS VSS nmos W=0.135u L=0.04u
M2034 n804 N37 VDD VDD pmos W=0.205u L=0.04u
M2035 N7511 n806 U818/net26 VSS nmos W=0.155u L=0.04u
M2036 N7511 n718 U818/net26 VSS nmos W=0.155u L=0.04u
M2037 U818/net29 n807 VSS VSS nmos W=0.155u L=0.04u
M2038 U818/net26 N7365 U818/net29 VSS nmos W=0.155u L=0.04u
M2039 U818/net26 n720 U818/net29 VSS nmos W=0.155u L=0.04u
M2040 N7511 n718 U818/net43 VDD pmos W=0.205u L=0.04u
M2041 N7511 n720 U818/net49 VDD pmos W=0.205u L=0.04u
M2042 U818/net49 N7365 VDD VDD pmos W=0.205u L=0.04u
M2043 U818/net43 n806 VDD VDD pmos W=0.205u L=0.04u
M2044 N7511 n807 VDD VDD pmos W=0.205u L=0.04u
M2045 U819/net29 n724 VSS VSS nmos W=0.155u L=0.04u
M2046 n807 N182 U819/net29 VSS nmos W=0.155u L=0.04u
M2047 n807 n722 U819/net23 VSS nmos W=0.155u L=0.04u
M2048 U819/net23 n808 VSS VSS nmos W=0.155u L=0.04u
M2049 U819/net20 n808 n807 VDD pmos W=0.205u L=0.04u
M2050 U819/net20 n722 n807 VDD pmos W=0.205u L=0.04u
M2051 VDD N182 U819/net20 VDD pmos W=0.205u L=0.04u
M2052 VDD n724 U819/net20 VDD pmos W=0.205u L=0.04u
M2053 n724 n731 VSS VSS nmos W=0.135u L=0.04u
M2054 n724 n731 VDD VDD pmos W=0.205u L=0.04u
M2055 n731 N580 U821/XI0-net10 VSS nmos W=0.155u L=0.04u
M2056 U821/XI0-net10 n809 U821/XI0-net13 VSS nmos W=0.155u L=0.04u
M2057 U821/XI0-net13 N137 VSS VSS nmos W=0.155u L=0.04u
M2058 n731 N137 VDD VDD pmos W=0.205u L=0.04u
M2059 n731 N580 VDD VDD pmos W=0.205u L=0.04u
M2060 n731 n809 VDD VDD pmos W=0.205u L=0.04u
M2061 n722 n728 VSS VSS nmos W=0.135u L=0.04u
M2062 n722 n728 VDD VDD pmos W=0.205u L=0.04u
M2063 n728 n809 U823/XI0-net10 VSS nmos W=0.155u L=0.04u
M2064 U823/XI0-net10 n810 U823/XI0-net13 VSS nmos W=0.155u L=0.04u
M2065 U823/XI0-net13 N137 VSS VSS nmos W=0.155u L=0.04u
M2066 n728 N137 VDD VDD pmos W=0.205u L=0.04u
M2067 n728 n809 VDD VDD pmos W=0.205u L=0.04u
M2068 n728 n810 VDD VDD pmos W=0.205u L=0.04u
M2069 n809 N577 VSS VSS nmos W=0.135u L=0.04u
M2070 n809 N577 VDD VDD pmos W=0.205u L=0.04u
M2071 n720 N577 U825/XI0-net10 VSS nmos W=0.155u L=0.04u
M2072 U825/XI0-net10 n810 U825/XI0-net13 VSS nmos W=0.155u L=0.04u
M2073 U825/XI0-net13 N137 VSS VSS nmos W=0.155u L=0.04u
M2074 n720 N137 VDD VDD pmos W=0.205u L=0.04u
M2075 n720 N577 VDD VDD pmos W=0.205u L=0.04u
M2076 n720 n810 VDD VDD pmos W=0.205u L=0.04u
M2077 n810 N580 VSS VSS nmos W=0.135u L=0.04u
M2078 n810 N580 VDD VDD pmos W=0.205u L=0.04u
M2079 n718 N580 U827/XI0-net10 VSS nmos W=0.155u L=0.04u
M2080 U827/XI0-net10 N577 U827/XI0-net13 VSS nmos W=0.155u L=0.04u
M2081 U827/XI0-net13 N137 VSS VSS nmos W=0.155u L=0.04u
M2082 n718 N137 VDD VDD pmos W=0.205u L=0.04u
M2083 n718 N580 VDD VDD pmos W=0.205u L=0.04u
M2084 n718 N577 VDD VDD pmos W=0.205u L=0.04u
M2085 N7506 n806 U828/net26 VSS nmos W=0.155u L=0.04u
M2086 N7506 n734 U828/net26 VSS nmos W=0.155u L=0.04u
M2087 U828/net29 n811 VSS VSS nmos W=0.155u L=0.04u
M2088 U828/net26 N7365 U828/net29 VSS nmos W=0.155u L=0.04u
M2089 U828/net26 n735 U828/net29 VSS nmos W=0.155u L=0.04u
M2090 N7506 n734 U828/net43 VDD pmos W=0.205u L=0.04u
M2091 N7506 n735 U828/net49 VDD pmos W=0.205u L=0.04u
M2092 U828/net49 N7365 VDD VDD pmos W=0.205u L=0.04u
M2093 U828/net43 n806 VDD VDD pmos W=0.205u L=0.04u
M2094 N7506 n811 VDD VDD pmos W=0.205u L=0.04u
M2095 U829/net29 n738 VSS VSS nmos W=0.155u L=0.04u
M2096 n811 N182 U829/net29 VSS nmos W=0.155u L=0.04u
M2097 n811 n737 U829/net23 VSS nmos W=0.155u L=0.04u
M2098 U829/net23 n808 VSS VSS nmos W=0.155u L=0.04u
M2099 U829/net20 n808 n811 VDD pmos W=0.205u L=0.04u
M2100 U829/net20 n737 n811 VDD pmos W=0.205u L=0.04u
M2101 VDD N182 U829/net20 VDD pmos W=0.205u L=0.04u
M2102 VDD n738 U829/net20 VDD pmos W=0.205u L=0.04u
M2103 n738 n743 VSS VSS nmos W=0.135u L=0.04u
M2104 n738 n743 VDD VDD pmos W=0.205u L=0.04u
M2105 n743 N137 U831/XI0-net10 VSS nmos W=0.155u L=0.04u
M2106 U831/XI0-net10 n812 U831/XI0-net13 VSS nmos W=0.155u L=0.04u
M2107 U831/XI0-net13 N574 VSS VSS nmos W=0.155u L=0.04u
M2108 n743 N574 VDD VDD pmos W=0.205u L=0.04u
M2109 n743 N137 VDD VDD pmos W=0.205u L=0.04u
M2110 n743 n812 VDD VDD pmos W=0.205u L=0.04u
M2111 n737 n740 VSS VSS nmos W=0.135u L=0.04u
M2112 n737 n740 VDD VDD pmos W=0.205u L=0.04u
M2113 n740 n812 U833/XI0-net10 VSS nmos W=0.155u L=0.04u
M2114 U833/XI0-net10 n813 U833/XI0-net13 VSS nmos W=0.155u L=0.04u
M2115 U833/XI0-net13 N137 VSS VSS nmos W=0.155u L=0.04u
M2116 n740 N137 VDD VDD pmos W=0.205u L=0.04u
M2117 n740 n812 VDD VDD pmos W=0.205u L=0.04u
M2118 n740 n813 VDD VDD pmos W=0.205u L=0.04u
M2119 n812 N571 VSS VSS nmos W=0.135u L=0.04u
M2120 n812 N571 VDD VDD pmos W=0.205u L=0.04u
M2121 n735 N137 U835/XI0-net10 VSS nmos W=0.155u L=0.04u
M2122 U835/XI0-net10 n813 U835/XI0-net13 VSS nmos W=0.155u L=0.04u
M2123 U835/XI0-net13 N571 VSS VSS nmos W=0.155u L=0.04u
M2124 n735 N571 VDD VDD pmos W=0.205u L=0.04u
M2125 n735 N137 VDD VDD pmos W=0.205u L=0.04u
M2126 n735 n813 VDD VDD pmos W=0.205u L=0.04u
M2127 n813 N574 VSS VSS nmos W=0.135u L=0.04u
M2128 n813 N574 VDD VDD pmos W=0.205u L=0.04u
M2129 n806 N185 VSS VSS nmos W=0.135u L=0.04u
M2130 n806 N185 VDD VDD pmos W=0.205u L=0.04u
M2131 n734 N571 U838/XI0-net10 VSS nmos W=0.155u L=0.04u
M2132 U838/XI0-net10 N137 U838/XI0-net13 VSS nmos W=0.155u L=0.04u
M2133 U838/XI0-net13 N574 VSS VSS nmos W=0.155u L=0.04u
M2134 n734 N574 VDD VDD pmos W=0.205u L=0.04u
M2135 n734 N571 VDD VDD pmos W=0.205u L=0.04u
M2136 n734 N137 VDD VDD pmos W=0.205u L=0.04u
M2137 N7504 n817 VSS VSS nmos W=0.155u L=0.04u
M2138 N7504 n816 VSS VSS nmos W=0.155u L=0.04u
M2139 N7504 n815 VSS VSS nmos W=0.155u L=0.04u
M2140 N7504 n814 VSS VSS nmos W=0.155u L=0.04u
M2141 U839/net49 n816 U839/net52 VDD pmos W=0.41u L=0.04u
M2142 U839/net52 n817 VDD VDD pmos W=0.41u L=0.04u
M2143 U839/net46 n815 U839/net49 VDD pmos W=0.41u L=0.04u
M2144 N7504 n814 U839/net46 VDD pmos W=0.41u L=0.04u
M2145 U840/net7 n773 VSS VSS nmos W=0.155u L=0.04u
M2146 U840/net7 n772 VSS VSS nmos W=0.155u L=0.04u
M2147 U840/net7 n771 VSS VSS nmos W=0.155u L=0.04u
M2148 n815 U840/net7 VSS VSS nmos W=0.155u L=0.04u
M2149 U840/XU42-net9 n771 VDD VDD pmos W=0.205u L=0.04u
M2150 U840/XU42-net12 n772 U840/XU42-net9 VDD pmos W=0.205u L=0.04u
M2151 U840/net7 n773 U840/XU42-net12 VDD pmos W=0.205u L=0.04u
M2152 n815 U840/net7 VDD VDD pmos W=0.205u L=0.04u
M2153 U841/net14 n818 U841/net20 VSS nmos W=0.155u L=0.04u
M2154 U841/net14 n706 U841/net20 VSS nmos W=0.155u L=0.04u
M2155 U841/net20 n819 VSS VSS nmos W=0.155u L=0.04u
M2156 n773 U841/net14 VSS VSS nmos W=0.155u L=0.04u
M2157 n773 U841/net14 VDD VDD pmos W=0.205u L=0.04u
M2158 U841/net14 n819 VDD VDD pmos W=0.205u L=0.04u
M2159 U841/net24 n818 VDD VDD pmos W=0.205u L=0.04u
M2160 U841/net14 n706 U841/net24 VDD pmos W=0.205u L=0.04u
M2161 U842/net19 n821 VSS VSS nmos W=0.155u L=0.04u
M2162 n819 n821 U842/net40 VSS nmos W=0.155u L=0.04u
M2163 n819 U842/net19 U842/net36 VSS nmos W=0.155u L=0.04u
M2164 U842/net40 n820 VSS VSS nmos W=0.31u L=0.04u
M2165 U842/net36 n708 VSS VSS nmos W=0.155u L=0.04u
M2166 U842/net19 n821 VDD VDD pmos W=0.205u L=0.04u
M2167 n819 U842/net19 U842/net26 VDD pmos W=0.325u L=0.04u
M2168 U842/net26 n820 VDD VDD pmos W=0.41u L=0.04u
M2169 n819 n821 U842/net30 VDD pmos W=0.325u L=0.04u
M2170 U842/net30 n708 VDD VDD pmos W=0.205u L=0.04u
M2171 n820 n822 U843/net27 VSS nmos W=0.155u L=0.04u
M2172 U843/net27 n823 VSS VSS nmos W=0.155u L=0.04u
M2173 n820 n708 VSS VSS nmos W=0.155u L=0.04u
M2174 n820 n823 U843/net13 VDD pmos W=0.205u L=0.04u
M2175 U843/net13 n708 VDD VDD pmos W=0.205u L=0.04u
M2176 n820 n822 U843/net13 VDD pmos W=0.205u L=0.04u
M2177 U844/XU1-net6 n824 VSS VSS nmos W=0.155u L=0.04u
M2178 n706 n823 U844/XU1-net6 VSS nmos W=0.155u L=0.04u
M2179 n706 n824 VDD VDD pmos W=0.155u L=0.04u
M2180 n706 n823 VDD VDD pmos W=0.155u L=0.04u
M2181 n772 U845/net6 VSS VSS nmos W=0.155u L=0.04u
M2182 U845/X_u2-net6 n826 VSS VSS nmos W=0.155u L=0.04u
M2183 U845/net6 n825 U845/X_u2-net6 VSS nmos W=0.155u L=0.04u
M2184 n772 U845/net6 VDD VDD pmos W=0.205u L=0.04u
M2185 U845/net6 n826 VDD VDD pmos W=0.205u L=0.04u
M2186 U845/net6 n825 VDD VDD pmos W=0.205u L=0.04u
M2187 U846/net19 n711 VSS VSS nmos W=0.155u L=0.04u
M2188 n825 n711 U846/net40 VSS nmos W=0.155u L=0.04u
M2189 n825 U846/net19 U846/net36 VSS nmos W=0.155u L=0.04u
M2190 U846/net40 n828 VSS VSS nmos W=0.31u L=0.04u
M2191 U846/net36 n827 VSS VSS nmos W=0.155u L=0.04u
M2192 U846/net19 n711 VDD VDD pmos W=0.205u L=0.04u
M2193 n825 U846/net19 U846/net26 VDD pmos W=0.325u L=0.04u
M2194 U846/net26 n828 VDD VDD pmos W=0.41u L=0.04u
M2195 n825 n711 U846/net30 VDD pmos W=0.325u L=0.04u
M2196 U846/net30 n827 VDD VDD pmos W=0.205u L=0.04u
M2197 n828 n707 VSS VSS nmos W=0.155u L=0.04u
M2198 n828 n822 VSS VSS nmos W=0.155u L=0.04u
M2199 U847/XI1-net8 n822 VDD VDD pmos W=0.205u L=0.04u
M2200 n828 n707 U847/XI1-net8 VDD pmos W=0.205u L=0.04u
M2201 n827 n704 U848/net15 VSS nmos W=0.155u L=0.04u
M2202 n827 n818 U848/net15 VSS nmos W=0.155u L=0.04u
M2203 U848/net15 n829 VSS VSS nmos W=0.155u L=0.04u
M2204 n827 n829 VDD VDD pmos W=0.205u L=0.04u
M2205 n827 n704 U848/XI16-net11 VDD pmos W=0.205u L=0.04u
M2206 U848/XI16-net11 n818 VDD VDD pmos W=0.205u L=0.04u
M2207 U849/net4 U849/net10 U849/net14 VSS nmos W=0.155u L=0.04u
M2208 U849/net6 n712 U849/net14 VSS nmos W=0.155u L=0.04u
M2209 U849/net4 n818 VSS VSS nmos W=0.155u L=0.04u
M2210 U849/net6 U849/net4 VSS VSS nmos W=0.155u L=0.04u
M2211 n771 U849/net14 VSS VSS nmos W=0.155u L=0.04u
M2212 U849/net10 n712 VSS VSS nmos W=0.155u L=0.04u
M2213 U849/net4 n712 U849/net14 VDD pmos W=0.205u L=0.04u
M2214 U849/net6 U849/net10 U849/net14 VDD pmos W=0.205u L=0.04u
M2215 U849/net4 n818 VDD VDD pmos W=0.205u L=0.04u
M2216 U849/net6 U849/net4 VDD VDD pmos W=0.205u L=0.04u
M2217 n771 U849/net14 VDD VDD pmos W=0.205u L=0.04u
M2218 U849/net10 n712 VDD VDD pmos W=0.205u L=0.04u
M2219 U850/net14 n830 VSS VSS nmos W=0.155u L=0.04u
M2220 U850/net14 n831 VSS VSS nmos W=0.155u L=0.04u
M2221 U850/net14 n832 VSS VSS nmos W=0.155u L=0.04u
M2222 U850/net14 n774 VSS VSS nmos W=0.155u L=0.04u
M2223 n814 U850/net14 VSS VSS nmos W=0.155u L=0.04u
M2224 U850/net14 n774 U850/XU8-net7 VDD pmos W=0.205u L=0.04u
M2225 U850/XU8-net7 n832 U850/XU8-net10 VDD pmos W=0.205u L=0.04u
M2226 U850/XU8-net10 n831 U850/XU8-net13 VDD pmos W=0.205u L=0.04u
M2227 U850/XU8-net13 n830 VDD VDD pmos W=0.205u L=0.04u
M2228 n814 U850/net14 VDD VDD pmos W=0.205u L=0.04u
M2229 N7503 n836 VSS VSS nmos W=0.155u L=0.04u
M2230 N7503 n835 VSS VSS nmos W=0.155u L=0.04u
M2231 N7503 n834 VSS VSS nmos W=0.155u L=0.04u
M2232 N7503 n833 VSS VSS nmos W=0.155u L=0.04u
M2233 U851/net49 n835 U851/net52 VDD pmos W=0.41u L=0.04u
M2234 U851/net52 n836 VDD VDD pmos W=0.41u L=0.04u
M2235 U851/net46 n834 U851/net49 VDD pmos W=0.41u L=0.04u
M2236 N7503 n833 U851/net46 VDD pmos W=0.41u L=0.04u
M2237 U852/net7 n763 VSS VSS nmos W=0.155u L=0.04u
M2238 U852/net7 n764 VSS VSS nmos W=0.155u L=0.04u
M2239 U852/net7 n768 VSS VSS nmos W=0.155u L=0.04u
M2240 n834 U852/net7 VSS VSS nmos W=0.155u L=0.04u
M2241 U852/XU42-net9 n768 VDD VDD pmos W=0.205u L=0.04u
M2242 U852/XU42-net12 n764 U852/XU42-net9 VDD pmos W=0.205u L=0.04u
M2243 U852/net7 n763 U852/XU42-net12 VDD pmos W=0.205u L=0.04u
M2244 n834 U852/net7 VDD VDD pmos W=0.205u L=0.04u
M2245 U853/net4 U853/net10 U853/net14 VSS nmos W=0.155u L=0.04u
M2246 U853/net6 n662 U853/net14 VSS nmos W=0.155u L=0.04u
M2247 U853/net4 n837 VSS VSS nmos W=0.155u L=0.04u
M2248 U853/net6 U853/net4 VSS VSS nmos W=0.155u L=0.04u
M2249 n763 U853/net14 VSS VSS nmos W=0.155u L=0.04u
M2250 U853/net10 n662 VSS VSS nmos W=0.155u L=0.04u
M2251 U853/net4 n662 U853/net14 VDD pmos W=0.205u L=0.04u
M2252 U853/net6 U853/net10 U853/net14 VDD pmos W=0.205u L=0.04u
M2253 U853/net4 n837 VDD VDD pmos W=0.205u L=0.04u
M2254 U853/net6 U853/net4 VDD VDD pmos W=0.205u L=0.04u
M2255 n763 U853/net14 VDD VDD pmos W=0.205u L=0.04u
M2256 U853/net10 n662 VDD VDD pmos W=0.205u L=0.04u
M2257 n764 U854/net6 VSS VSS nmos W=0.155u L=0.04u
M2258 U854/X_u2-net6 n647 VSS VSS nmos W=0.155u L=0.04u
M2259 U854/net6 n838 U854/X_u2-net6 VSS nmos W=0.155u L=0.04u
M2260 n764 U854/net6 VDD VDD pmos W=0.205u L=0.04u
M2261 U854/net6 n647 VDD VDD pmos W=0.205u L=0.04u
M2262 U854/net6 n838 VDD VDD pmos W=0.205u L=0.04u
M2263 U855/net19 n651 VSS VSS nmos W=0.155u L=0.04u
M2264 n838 n651 U855/net40 VSS nmos W=0.155u L=0.04u
M2265 n838 U855/net19 U855/net36 VSS nmos W=0.155u L=0.04u
M2266 U855/net40 n840 VSS VSS nmos W=0.31u L=0.04u
M2267 U855/net36 n839 VSS VSS nmos W=0.155u L=0.04u
M2268 U855/net19 n651 VDD VDD pmos W=0.205u L=0.04u
M2269 n838 U855/net19 U855/net26 VDD pmos W=0.325u L=0.04u
M2270 U855/net26 n840 VDD VDD pmos W=0.41u L=0.04u
M2271 n838 n651 U855/net30 VDD pmos W=0.325u L=0.04u
M2272 U855/net30 n839 VDD VDD pmos W=0.205u L=0.04u
M2273 n840 n841 VSS VSS nmos W=0.155u L=0.04u
M2274 n840 n663 VSS VSS nmos W=0.155u L=0.04u
M2275 U856/XI1-net8 n663 VDD VDD pmos W=0.205u L=0.04u
M2276 n840 n841 U856/XI1-net8 VDD pmos W=0.205u L=0.04u
M2277 n839 n652 U857/net15 VSS nmos W=0.155u L=0.04u
M2278 n839 n837 U857/net15 VSS nmos W=0.155u L=0.04u
M2279 U857/net15 n842 VSS VSS nmos W=0.155u L=0.04u
M2280 n839 n842 VDD VDD pmos W=0.205u L=0.04u
M2281 n839 n652 U857/XI16-net11 VDD pmos W=0.205u L=0.04u
M2282 U857/XI16-net11 n837 VDD VDD pmos W=0.205u L=0.04u
M2283 U858/net4 U858/net10 U858/net14 VSS nmos W=0.155u L=0.04u
M2284 U858/net6 n843 U858/net14 VSS nmos W=0.155u L=0.04u
M2285 U858/net4 n661 VSS VSS nmos W=0.155u L=0.04u
M2286 U858/net6 U858/net4 VSS VSS nmos W=0.155u L=0.04u
M2287 n768 U858/net14 VSS VSS nmos W=0.155u L=0.04u
M2288 U858/net10 n843 VSS VSS nmos W=0.155u L=0.04u
M2289 U858/net4 n843 U858/net14 VDD pmos W=0.205u L=0.04u
M2290 U858/net6 U858/net10 U858/net14 VDD pmos W=0.205u L=0.04u
M2291 U858/net4 n661 VDD VDD pmos W=0.205u L=0.04u
M2292 U858/net6 U858/net4 VDD VDD pmos W=0.205u L=0.04u
M2293 n768 U858/net14 VDD VDD pmos W=0.205u L=0.04u
M2294 U858/net10 n843 VDD VDD pmos W=0.205u L=0.04u
M2295 n843 n844 U859/net27 VSS nmos W=0.155u L=0.04u
M2296 U859/net27 n837 VSS VSS nmos W=0.155u L=0.04u
M2297 n843 n653 VSS VSS nmos W=0.155u L=0.04u
M2298 n843 n837 U859/net13 VDD pmos W=0.205u L=0.04u
M2299 U859/net13 n653 VDD VDD pmos W=0.205u L=0.04u
M2300 n843 n844 U859/net13 VDD pmos W=0.205u L=0.04u
M2301 U860/net14 n767 VSS VSS nmos W=0.155u L=0.04u
M2302 U860/net14 n845 VSS VSS nmos W=0.155u L=0.04u
M2303 U860/net14 n846 VSS VSS nmos W=0.155u L=0.04u
M2304 U860/net14 n847 VSS VSS nmos W=0.155u L=0.04u
M2305 n833 U860/net14 VSS VSS nmos W=0.155u L=0.04u
M2306 U860/net14 n847 U860/XU8-net7 VDD pmos W=0.205u L=0.04u
M2307 U860/XU8-net7 n846 U860/XU8-net10 VDD pmos W=0.205u L=0.04u
M2308 U860/XU8-net10 n845 U860/XU8-net13 VDD pmos W=0.205u L=0.04u
M2309 U860/XU8-net13 n767 VDD VDD pmos W=0.205u L=0.04u
M2310 n833 U860/net14 VDD VDD pmos W=0.205u L=0.04u
M2311 U861/net4 n848 U861/net14 VSS nmos W=0.155u L=0.04u
M2312 U861/net6 U861/net10 U861/net14 VSS nmos W=0.17u L=0.04u
M2313 U861/net4 n658 VSS VSS nmos W=0.155u L=0.04u
M2314 U861/net6 U861/net4 VSS VSS nmos W=0.17u L=0.04u
M2315 n767 U861/net14 VSS VSS nmos W=0.155u L=0.04u
M2316 U861/net10 n848 VSS VSS nmos W=0.155u L=0.04u
M2317 U861/net4 U861/net10 U861/net14 VDD pmos W=0.255u L=0.04u
M2318 U861/net6 n848 U861/net14 VDD pmos W=0.28u L=0.04u
M2319 U861/net4 n658 VDD VDD pmos W=0.205u L=0.04u
M2320 U861/net6 U861/net4 VDD VDD pmos W=0.24u L=0.04u
M2321 n767 U861/net14 VDD VDD pmos W=0.205u L=0.04u
M2322 U861/net10 n848 VDD VDD pmos W=0.205u L=0.04u
M2323 n848 n655 U862/net27 VSS nmos W=0.155u L=0.04u
M2324 U862/net27 n837 VSS VSS nmos W=0.155u L=0.04u
M2325 n848 n654 VSS VSS nmos W=0.155u L=0.04u
M2326 n848 n837 U862/net13 VDD pmos W=0.205u L=0.04u
M2327 U862/net13 n654 VDD VDD pmos W=0.205u L=0.04u
M2328 n848 n655 U862/net13 VDD pmos W=0.205u L=0.04u
M2329 n837 n841 VSS VSS nmos W=0.135u L=0.04u
M2330 n837 n841 VDD VDD pmos W=0.205u L=0.04u
M2331 n841 n642 U864/net27 VSS nmos W=0.155u L=0.04u
M2332 U864/net27 N4 VSS VSS nmos W=0.155u L=0.04u
M2333 n841 n643 VSS VSS nmos W=0.155u L=0.04u
M2334 n841 N4 U864/net13 VDD pmos W=0.205u L=0.04u
M2335 U864/net13 n643 VDD VDD pmos W=0.205u L=0.04u
M2336 n841 n642 U864/net13 VDD pmos W=0.205u L=0.04u
M2337 U865/net32 n662 VSS VSS nmos W=0.155u L=0.04u
M2338 U865/net59 n651 U865/net32 VSS nmos W=0.155u L=0.04u
M2339 U865/net59 n654 VSS VSS nmos W=0.155u L=0.04u
M2340 n655 U865/net59 VSS VSS nmos W=0.155u L=0.04u
M2341 n655 U865/net59 VDD VDD pmos W=0.2u L=0.04u
M2342 U865/net59 n651 U865/net22 VDD pmos W=0.205u L=0.04u
M2343 U865/net59 n662 U865/net22 VDD pmos W=0.205u L=0.04u
M2344 U865/net22 n654 VDD VDD pmos W=0.2u L=0.04u
M2345 U866/net11 n850 U866/net17 VSS nmos W=0.155u L=0.04u
M2346 U866/net5 U866/net17 U866/net21 VSS nmos W=0.155u L=0.04u
M2347 U866/net5 n851 VSS VSS nmos W=0.155u L=0.04u
M2348 N7476 U866/net21 VSS VSS nmos W=0.155u L=0.04u
M2349 U866/net16 n850 VSS VSS nmos W=0.155u L=0.04u
M2350 U866/net11 n849 VSS VSS nmos W=0.155u L=0.04u
M2351 U866/net13 U866/net17 VSS VSS nmos W=0.155u L=0.04u
M2352 U866/net17 U866/net16 U866/XI2-net16 VSS nmos W=0.155u L=0.04u
M2353 U866/XI2-net16 U866/net11 VSS VSS nmos W=0.155u L=0.04u
M2354 U866/net21 U866/net13 U866/XU21-net16 VSS nmos W=0.155u L=0.04u
M2355 U866/XU21-net16 U866/net5 VSS VSS nmos W=0.155u L=0.04u
M2356 U866/net11 U866/net16 U866/net17 VDD pmos W=0.205u L=0.04u
M2357 U866/net5 U866/net13 U866/net21 VDD pmos W=0.205u L=0.04u
M2358 U866/net5 n851 VDD VDD pmos W=0.205u L=0.04u
M2359 N7476 U866/net21 VDD VDD pmos W=0.205u L=0.04u
M2360 U866/net16 n850 VDD VDD pmos W=0.205u L=0.04u
M2361 U866/net11 n849 VDD VDD pmos W=0.205u L=0.04u
M2362 U866/net13 U866/net17 VDD VDD pmos W=0.205u L=0.04u
M2363 U866/net17 n850 U866/XI2-net6 VDD pmos W=0.205u L=0.04u
M2364 U866/XI2-net6 U866/net11 VDD VDD pmos W=0.205u L=0.04u
M2365 U866/net21 U866/net17 U866/XU21-net6 VDD pmos W=0.205u L=0.04u
M2366 U866/XU21-net6 U866/net5 VDD VDD pmos W=0.205u L=0.04u
M2367 U867/net28 U867/net20 U867/net64 VSS nmos W=0.155u L=0.04u
M2368 U867/net24 U867/net30 U867/net32 VSS nmos W=0.155u L=0.04u
M2369 U867/net28 U867/net40 U867/net24 VSS nmos W=0.155u L=0.04u
M2370 U867/net40 n854 U867/net108 VSS nmos W=0.155u L=0.04u
M2371 U867/net40 U867/net106 U867/net104 VSS nmos W=0.155u L=0.04u
M2372 U867/net24 n852 U867/net050 VSS nmos W=0.155u L=0.04u
M2373 U867/net050 U867/net32 VSS VSS nmos W=0.155u L=0.04u
M2374 U867/net20 U867/net40 VSS VSS nmos W=0.155u L=0.04u
M2375 U867/net106 n854 VSS VSS nmos W=0.155u L=0.04u
M2376 U867/net104 n660 VSS VSS nmos W=0.155u L=0.04u
M2377 U867/net30 n852 VSS VSS nmos W=0.155u L=0.04u
M2378 U867/net108 U867/net104 VSS VSS nmos W=0.155u L=0.04u
M2379 n851 U867/net28 VSS VSS nmos W=0.155u L=0.04u
M2380 U867/net32 n853 VSS VSS nmos W=0.155u L=0.04u
M2381 U867/net64 U867/net24 VSS VSS nmos W=0.2u L=0.04u
M2382 U867/net28 U867/net40 U867/net64 VDD pmos W=0.205u L=0.04u
M2383 U867/net24 n852 U867/net32 VDD pmos W=0.205u L=0.04u
M2384 U867/net28 U867/net20 U867/net24 VDD pmos W=0.205u L=0.04u
M2385 U867/net40 U867/net106 U867/net108 VDD pmos W=0.205u L=0.04u
M2386 U867/net40 n854 U867/net104 VDD pmos W=0.205u L=0.04u
M2387 U867/net20 U867/net40 VDD VDD pmos W=0.205u L=0.04u
M2388 U867/net106 n854 VDD VDD pmos W=0.205u L=0.04u
M2389 U867/net104 n660 VDD VDD pmos W=0.205u L=0.04u
M2390 U867/net30 n852 VDD VDD pmos W=0.205u L=0.04u
M2391 U867/net108 U867/net104 VDD VDD pmos W=0.205u L=0.04u
M2392 n851 U867/net28 VDD VDD pmos W=0.205u L=0.04u
M2393 U867/net32 n853 VDD VDD pmos W=0.205u L=0.04u
M2394 U867/net64 U867/net24 VDD VDD pmos W=0.28u L=0.04u
M2395 U867/net24 U867/net30 U867/net045 VDD pmos W=0.205u L=0.04u
M2396 U867/net045 U867/net32 VDD VDD pmos W=0.205u L=0.04u
M2397 U868/net19 N335 VSS VSS nmos W=0.155u L=0.04u
M2398 n854 N335 U868/net40 VSS nmos W=0.155u L=0.04u
M2399 n854 U868/net19 U868/net36 VSS nmos W=0.155u L=0.04u
M2400 U868/net40 n856 VSS VSS nmos W=0.31u L=0.04u
M2401 U868/net36 n855 VSS VSS nmos W=0.155u L=0.04u
M2402 U868/net19 N335 VDD VDD pmos W=0.205u L=0.04u
M2403 n854 U868/net19 U868/net26 VDD pmos W=0.325u L=0.04u
M2404 U868/net26 n856 VDD VDD pmos W=0.41u L=0.04u
M2405 n854 N335 U868/net30 VDD pmos W=0.325u L=0.04u
M2406 U868/net30 n855 VDD VDD pmos W=0.205u L=0.04u
M2407 U869/net4 N292 U869/net14 VSS nmos W=0.155u L=0.04u
M2408 U869/net6 U869/net10 U869/net14 VSS nmos W=0.17u L=0.04u
M2409 U869/net4 n857 VSS VSS nmos W=0.155u L=0.04u
M2410 U869/net6 U869/net4 VSS VSS nmos W=0.17u L=0.04u
M2411 n856 U869/net14 VSS VSS nmos W=0.155u L=0.04u
M2412 U869/net10 N292 VSS VSS nmos W=0.155u L=0.04u
M2413 U869/net4 U869/net10 U869/net14 VDD pmos W=0.255u L=0.04u
M2414 U869/net6 N292 U869/net14 VDD pmos W=0.28u L=0.04u
M2415 U869/net4 n857 VDD VDD pmos W=0.205u L=0.04u
M2416 U869/net6 U869/net4 VDD VDD pmos W=0.24u L=0.04u
M2417 n856 U869/net14 VDD VDD pmos W=0.205u L=0.04u
M2418 U869/net10 N292 VDD VDD pmos W=0.205u L=0.04u
M2419 U870/net4 n857 U870/net14 VSS nmos W=0.155u L=0.04u
M2420 U870/net6 U870/net10 U870/net14 VSS nmos W=0.17u L=0.04u
M2421 U870/net4 N289 VSS VSS nmos W=0.155u L=0.04u
M2422 U870/net6 U870/net4 VSS VSS nmos W=0.17u L=0.04u
M2423 n855 U870/net14 VSS VSS nmos W=0.155u L=0.04u
M2424 U870/net10 n857 VSS VSS nmos W=0.155u L=0.04u
M2425 U870/net4 U870/net10 U870/net14 VDD pmos W=0.255u L=0.04u
M2426 U870/net6 n857 U870/net14 VDD pmos W=0.28u L=0.04u
M2427 U870/net4 N289 VDD VDD pmos W=0.205u L=0.04u
M2428 U870/net6 U870/net4 VDD VDD pmos W=0.24u L=0.04u
M2429 n855 U870/net14 VDD VDD pmos W=0.205u L=0.04u
M2430 U870/net10 n857 VDD VDD pmos W=0.205u L=0.04u
M2431 U871/net28 U871/net20 U871/net64 VSS nmos W=0.155u L=0.04u
M2432 U871/net24 U871/net30 U871/net32 VSS nmos W=0.155u L=0.04u
M2433 U871/net28 U871/net40 U871/net24 VSS nmos W=0.155u L=0.04u
M2434 U871/net40 n861 U871/net108 VSS nmos W=0.155u L=0.04u
M2435 U871/net40 U871/net106 U871/net104 VSS nmos W=0.155u L=0.04u
M2436 U871/net24 n858 U871/net050 VSS nmos W=0.155u L=0.04u
M2437 U871/net050 U871/net32 VSS VSS nmos W=0.155u L=0.04u
M2438 U871/net20 U871/net40 VSS VSS nmos W=0.155u L=0.04u
M2439 U871/net106 n861 VSS VSS nmos W=0.155u L=0.04u
M2440 U871/net104 n860 VSS VSS nmos W=0.155u L=0.04u
M2441 U871/net30 n858 VSS VSS nmos W=0.155u L=0.04u
M2442 U871/net108 U871/net104 VSS VSS nmos W=0.155u L=0.04u
M2443 n849 U871/net28 VSS VSS nmos W=0.155u L=0.04u
M2444 U871/net32 n859 VSS VSS nmos W=0.155u L=0.04u
M2445 U871/net64 U871/net24 VSS VSS nmos W=0.2u L=0.04u
M2446 U871/net28 U871/net40 U871/net64 VDD pmos W=0.205u L=0.04u
M2447 U871/net24 n858 U871/net32 VDD pmos W=0.205u L=0.04u
M2448 U871/net28 U871/net20 U871/net24 VDD pmos W=0.205u L=0.04u
M2449 U871/net40 U871/net106 U871/net108 VDD pmos W=0.205u L=0.04u
M2450 U871/net40 n861 U871/net104 VDD pmos W=0.205u L=0.04u
M2451 U871/net20 U871/net40 VDD VDD pmos W=0.205u L=0.04u
M2452 U871/net106 n861 VDD VDD pmos W=0.205u L=0.04u
M2453 U871/net104 n860 VDD VDD pmos W=0.205u L=0.04u
M2454 U871/net30 n858 VDD VDD pmos W=0.205u L=0.04u
M2455 U871/net108 U871/net104 VDD VDD pmos W=0.205u L=0.04u
M2456 n849 U871/net28 VDD VDD pmos W=0.205u L=0.04u
M2457 U871/net32 n859 VDD VDD pmos W=0.205u L=0.04u
M2458 U871/net64 U871/net24 VDD VDD pmos W=0.28u L=0.04u
M2459 U871/net24 U871/net30 U871/net045 VDD pmos W=0.205u L=0.04u
M2460 U871/net045 U871/net32 VDD VDD pmos W=0.205u L=0.04u
M2461 U872/net28 U872/net20 U872/net64 VSS nmos W=0.155u L=0.04u
M2462 U872/net24 U872/net30 U872/net32 VSS nmos W=0.155u L=0.04u
M2463 U872/net28 U872/net40 U872/net24 VSS nmos W=0.155u L=0.04u
M2464 U872/net40 n865 U872/net108 VSS nmos W=0.155u L=0.04u
M2465 U872/net40 U872/net106 U872/net104 VSS nmos W=0.155u L=0.04u
M2466 U872/net24 n862 U872/net050 VSS nmos W=0.155u L=0.04u
M2467 U872/net050 U872/net32 VSS VSS nmos W=0.155u L=0.04u
M2468 U872/net20 U872/net40 VSS VSS nmos W=0.155u L=0.04u
M2469 U872/net106 n865 VSS VSS nmos W=0.155u L=0.04u
M2470 U872/net104 n864 VSS VSS nmos W=0.155u L=0.04u
M2471 U872/net30 n862 VSS VSS nmos W=0.155u L=0.04u
M2472 U872/net108 U872/net104 VSS VSS nmos W=0.155u L=0.04u
M2473 N7474 U872/net28 VSS VSS nmos W=0.155u L=0.04u
M2474 U872/net32 n863 VSS VSS nmos W=0.155u L=0.04u
M2475 U872/net64 U872/net24 VSS VSS nmos W=0.2u L=0.04u
M2476 U872/net28 U872/net40 U872/net64 VDD pmos W=0.205u L=0.04u
M2477 U872/net24 n862 U872/net32 VDD pmos W=0.205u L=0.04u
M2478 U872/net28 U872/net20 U872/net24 VDD pmos W=0.205u L=0.04u
M2479 U872/net40 U872/net106 U872/net108 VDD pmos W=0.205u L=0.04u
M2480 U872/net40 n865 U872/net104 VDD pmos W=0.205u L=0.04u
M2481 U872/net20 U872/net40 VDD VDD pmos W=0.205u L=0.04u
M2482 U872/net106 n865 VDD VDD pmos W=0.205u L=0.04u
M2483 U872/net104 n864 VDD VDD pmos W=0.205u L=0.04u
M2484 U872/net30 n862 VDD VDD pmos W=0.205u L=0.04u
M2485 U872/net108 U872/net104 VDD VDD pmos W=0.205u L=0.04u
M2486 N7474 U872/net28 VDD VDD pmos W=0.205u L=0.04u
M2487 U872/net32 n863 VDD VDD pmos W=0.205u L=0.04u
M2488 U872/net64 U872/net24 VDD VDD pmos W=0.28u L=0.04u
M2489 U872/net24 U872/net30 U872/net045 VDD pmos W=0.205u L=0.04u
M2490 U872/net045 U872/net32 VDD VDD pmos W=0.205u L=0.04u
M2491 U873/net28 U873/net20 U873/net64 VSS nmos W=0.155u L=0.04u
M2492 U873/net24 U873/net30 U873/net32 VSS nmos W=0.155u L=0.04u
M2493 U873/net28 U873/net40 U873/net24 VSS nmos W=0.155u L=0.04u
M2494 U873/net40 n703 U873/net108 VSS nmos W=0.155u L=0.04u
M2495 U873/net40 U873/net106 U873/net104 VSS nmos W=0.155u L=0.04u
M2496 U873/net24 n866 U873/net050 VSS nmos W=0.155u L=0.04u
M2497 U873/net050 U873/net32 VSS VSS nmos W=0.155u L=0.04u
M2498 U873/net20 U873/net40 VSS VSS nmos W=0.155u L=0.04u
M2499 U873/net106 n703 VSS VSS nmos W=0.155u L=0.04u
M2500 U873/net104 n868 VSS VSS nmos W=0.155u L=0.04u
M2501 U873/net30 n866 VSS VSS nmos W=0.155u L=0.04u
M2502 U873/net108 U873/net104 VSS VSS nmos W=0.155u L=0.04u
M2503 n865 U873/net28 VSS VSS nmos W=0.155u L=0.04u
M2504 U873/net32 n867 VSS VSS nmos W=0.155u L=0.04u
M2505 U873/net64 U873/net24 VSS VSS nmos W=0.2u L=0.04u
M2506 U873/net28 U873/net40 U873/net64 VDD pmos W=0.205u L=0.04u
M2507 U873/net24 n866 U873/net32 VDD pmos W=0.205u L=0.04u
M2508 U873/net28 U873/net20 U873/net24 VDD pmos W=0.205u L=0.04u
M2509 U873/net40 U873/net106 U873/net108 VDD pmos W=0.205u L=0.04u
M2510 U873/net40 n703 U873/net104 VDD pmos W=0.205u L=0.04u
M2511 U873/net20 U873/net40 VDD VDD pmos W=0.205u L=0.04u
M2512 U873/net106 n703 VDD VDD pmos W=0.205u L=0.04u
M2513 U873/net104 n868 VDD VDD pmos W=0.205u L=0.04u
M2514 U873/net30 n866 VDD VDD pmos W=0.205u L=0.04u
M2515 U873/net108 U873/net104 VDD VDD pmos W=0.205u L=0.04u
M2516 n865 U873/net28 VDD VDD pmos W=0.205u L=0.04u
M2517 U873/net32 n867 VDD VDD pmos W=0.205u L=0.04u
M2518 U873/net64 U873/net24 VDD VDD pmos W=0.28u L=0.04u
M2519 U873/net24 U873/net30 U873/net045 VDD pmos W=0.205u L=0.04u
M2520 U873/net045 U873/net32 VDD VDD pmos W=0.205u L=0.04u
M2521 U874/net4 n777 U874/net14 VSS nmos W=0.155u L=0.04u
M2522 U874/net6 U874/net10 U874/net14 VSS nmos W=0.17u L=0.04u
M2523 U874/net4 n824 VSS VSS nmos W=0.155u L=0.04u
M2524 U874/net6 U874/net4 VSS VSS nmos W=0.17u L=0.04u
M2525 n703 U874/net14 VSS VSS nmos W=0.155u L=0.04u
M2526 U874/net10 n777 VSS VSS nmos W=0.155u L=0.04u
M2527 U874/net4 U874/net10 U874/net14 VDD pmos W=0.255u L=0.04u
M2528 U874/net6 n777 U874/net14 VDD pmos W=0.28u L=0.04u
M2529 U874/net4 n824 VDD VDD pmos W=0.205u L=0.04u
M2530 U874/net6 U874/net4 VDD VDD pmos W=0.24u L=0.04u
M2531 n703 U874/net14 VDD VDD pmos W=0.205u L=0.04u
M2532 U874/net10 n777 VDD VDD pmos W=0.205u L=0.04u
M2533 n824 n821 VSS VSS nmos W=0.135u L=0.04u
M2534 n824 n821 VDD VDD pmos W=0.205u L=0.04u
M2535 U876/net4 U876/net10 U876/net14 VSS nmos W=0.155u L=0.04u
M2536 U876/net6 n869 U876/net14 VSS nmos W=0.155u L=0.04u
M2537 U876/net4 n870 VSS VSS nmos W=0.155u L=0.04u
M2538 U876/net6 U876/net4 VSS VSS nmos W=0.155u L=0.04u
M2539 n864 U876/net14 VSS VSS nmos W=0.155u L=0.04u
M2540 U876/net10 n869 VSS VSS nmos W=0.155u L=0.04u
M2541 U876/net4 n869 U876/net14 VDD pmos W=0.205u L=0.04u
M2542 U876/net6 U876/net10 U876/net14 VDD pmos W=0.205u L=0.04u
M2543 U876/net4 n870 VDD VDD pmos W=0.205u L=0.04u
M2544 U876/net6 U876/net4 VDD VDD pmos W=0.205u L=0.04u
M2545 n864 U876/net14 VDD VDD pmos W=0.205u L=0.04u
M2546 U876/net10 n869 VDD VDD pmos W=0.205u L=0.04u
M2547 U877/net19 N332 VSS VSS nmos W=0.155u L=0.04u
M2548 n863 N332 U877/net40 VSS nmos W=0.155u L=0.04u
M2549 n863 U877/net19 U877/net36 VSS nmos W=0.155u L=0.04u
M2550 U877/net40 n872 VSS VSS nmos W=0.31u L=0.04u
M2551 U877/net36 n871 VSS VSS nmos W=0.155u L=0.04u
M2552 U877/net19 N332 VDD VDD pmos W=0.205u L=0.04u
M2553 n863 U877/net19 U877/net26 VDD pmos W=0.325u L=0.04u
M2554 U877/net26 n872 VDD VDD pmos W=0.41u L=0.04u
M2555 n863 N332 U877/net30 VDD pmos W=0.325u L=0.04u
M2556 U877/net30 n871 VDD VDD pmos W=0.205u L=0.04u
M2557 U878/net4 U878/net10 U878/net14 VSS nmos W=0.155u L=0.04u
M2558 U878/net6 N372 U878/net14 VSS nmos W=0.155u L=0.04u
M2559 U878/net4 n681 VSS VSS nmos W=0.155u L=0.04u
M2560 U878/net6 U878/net4 VSS VSS nmos W=0.155u L=0.04u
M2561 n872 U878/net14 VSS VSS nmos W=0.155u L=0.04u
M2562 U878/net10 N372 VSS VSS nmos W=0.155u L=0.04u
M2563 U878/net4 N372 U878/net14 VDD pmos W=0.205u L=0.04u
M2564 U878/net6 U878/net10 U878/net14 VDD pmos W=0.205u L=0.04u
M2565 U878/net4 n681 VDD VDD pmos W=0.205u L=0.04u
M2566 U878/net6 U878/net4 VDD VDD pmos W=0.205u L=0.04u
M2567 n872 U878/net14 VDD VDD pmos W=0.205u L=0.04u
M2568 U878/net10 N372 VDD VDD pmos W=0.205u L=0.04u
M2569 U879/net4 U879/net10 U879/net14 VSS nmos W=0.155u L=0.04u
M2570 U879/net6 n681 U879/net14 VSS nmos W=0.155u L=0.04u
M2571 U879/net4 N369 VSS VSS nmos W=0.155u L=0.04u
M2572 U879/net6 U879/net4 VSS VSS nmos W=0.155u L=0.04u
M2573 n871 U879/net14 VSS VSS nmos W=0.155u L=0.04u
M2574 U879/net10 n681 VSS VSS nmos W=0.155u L=0.04u
M2575 U879/net4 n681 U879/net14 VDD pmos W=0.205u L=0.04u
M2576 U879/net6 U879/net10 U879/net14 VDD pmos W=0.205u L=0.04u
M2577 U879/net4 N369 VDD VDD pmos W=0.205u L=0.04u
M2578 U879/net6 U879/net4 VDD VDD pmos W=0.205u L=0.04u
M2579 n871 U879/net14 VDD VDD pmos W=0.205u L=0.04u
M2580 U879/net10 n681 VDD VDD pmos W=0.205u L=0.04u
M2581 N7473 n586 U880/XI21-net17 VSS nmos W=0.155u L=0.04u
M2582 U880/XI21-net17 n845 VSS VSS nmos W=0.155u L=0.04u
M2583 N7473 n873 U880/XI6-net17 VSS nmos W=0.155u L=0.04u
M2584 U880/XI6-net17 n584 VSS VSS nmos W=0.155u L=0.04u
M2585 N7473 N126 U880/XI20-net17 VSS nmos W=0.155u L=0.04u
M2586 U880/XI20-net17 n762 VSS VSS nmos W=0.155u L=0.04u
M2587 VDD n586 U880/net22 VDD pmos W=0.205u L=0.04u
M2588 VDD n845 U880/net22 VDD pmos W=0.205u L=0.04u
M2589 U880/net16 n873 N7473 VDD pmos W=0.205u L=0.04u
M2590 U880/net16 n584 N7473 VDD pmos W=0.205u L=0.04u
M2591 U880/net22 N126 U880/net16 VDD pmos W=0.205u L=0.04u
M2592 U880/net22 n762 U880/net16 VDD pmos W=0.205u L=0.04u
M2593 U881/net4 n874 U881/net14 VSS nmos W=0.155u L=0.04u
M2594 U881/net6 U881/net10 U881/net14 VSS nmos W=0.17u L=0.04u
M2595 U881/net4 n875 VSS VSS nmos W=0.155u L=0.04u
M2596 U881/net6 U881/net4 VSS VSS nmos W=0.17u L=0.04u
M2597 n845 U881/net14 VSS VSS nmos W=0.155u L=0.04u
M2598 U881/net10 n874 VSS VSS nmos W=0.155u L=0.04u
M2599 U881/net4 U881/net10 U881/net14 VDD pmos W=0.255u L=0.04u
M2600 U881/net6 n874 U881/net14 VDD pmos W=0.28u L=0.04u
M2601 U881/net4 n875 VDD VDD pmos W=0.205u L=0.04u
M2602 U881/net6 U881/net4 VDD VDD pmos W=0.24u L=0.04u
M2603 n845 U881/net14 VDD VDD pmos W=0.205u L=0.04u
M2604 U881/net10 n874 VDD VDD pmos W=0.205u L=0.04u
M2605 n874 N4 U882/net27 VSS nmos W=0.155u L=0.04u
M2606 U882/net27 n633 VSS VSS nmos W=0.155u L=0.04u
M2607 n874 n627 VSS VSS nmos W=0.155u L=0.04u
M2608 n874 n633 U882/net13 VDD pmos W=0.205u L=0.04u
M2609 U882/net13 n627 VDD VDD pmos W=0.205u L=0.04u
M2610 n874 N4 U882/net13 VDD pmos W=0.205u L=0.04u
M2611 N7472 n836 U883/XI21-net17 VSS nmos W=0.155u L=0.04u
M2612 U883/XI21-net17 n586 VSS VSS nmos W=0.155u L=0.04u
M2613 N7472 n876 U883/XI6-net17 VSS nmos W=0.155u L=0.04u
M2614 U883/XI6-net17 n584 VSS VSS nmos W=0.155u L=0.04u
M2615 N7472 N127 U883/XI20-net17 VSS nmos W=0.155u L=0.04u
M2616 U883/XI20-net17 n762 VSS VSS nmos W=0.155u L=0.04u
M2617 VDD n836 U883/net22 VDD pmos W=0.205u L=0.04u
M2618 VDD n586 U883/net22 VDD pmos W=0.205u L=0.04u
M2619 U883/net16 n876 N7472 VDD pmos W=0.205u L=0.04u
M2620 U883/net16 n584 N7472 VDD pmos W=0.205u L=0.04u
M2621 U883/net22 N127 U883/net16 VDD pmos W=0.205u L=0.04u
M2622 U883/net22 n762 U883/net16 VDD pmos W=0.205u L=0.04u
M2623 U884/net4 U884/net10 U884/net14 VSS nmos W=0.155u L=0.04u
M2624 U884/net6 n636 U884/net14 VSS nmos W=0.155u L=0.04u
M2625 U884/net4 n877 VSS VSS nmos W=0.155u L=0.04u
M2626 U884/net6 U884/net4 VSS VSS nmos W=0.155u L=0.04u
M2627 n836 U884/net14 VSS VSS nmos W=0.155u L=0.04u
M2628 U884/net10 n636 VSS VSS nmos W=0.155u L=0.04u
M2629 U884/net4 n636 U884/net14 VDD pmos W=0.205u L=0.04u
M2630 U884/net6 U884/net10 U884/net14 VDD pmos W=0.205u L=0.04u
M2631 U884/net4 n877 VDD VDD pmos W=0.205u L=0.04u
M2632 U884/net6 U884/net4 VDD VDD pmos W=0.205u L=0.04u
M2633 n836 U884/net14 VDD VDD pmos W=0.205u L=0.04u
M2634 U884/net10 n636 VDD VDD pmos W=0.205u L=0.04u
M2635 N7471 n835 U885/XI21-net17 VSS nmos W=0.155u L=0.04u
M2636 U885/XI21-net17 n586 VSS VSS nmos W=0.155u L=0.04u
M2637 N7471 n878 U885/XI6-net17 VSS nmos W=0.155u L=0.04u
M2638 U885/XI6-net17 n584 VSS VSS nmos W=0.155u L=0.04u
M2639 N7471 N128 U885/XI20-net17 VSS nmos W=0.155u L=0.04u
M2640 U885/XI20-net17 n762 VSS VSS nmos W=0.155u L=0.04u
M2641 VDD n835 U885/net22 VDD pmos W=0.205u L=0.04u
M2642 VDD n586 U885/net22 VDD pmos W=0.205u L=0.04u
M2643 U885/net16 n878 N7471 VDD pmos W=0.205u L=0.04u
M2644 U885/net16 n584 N7471 VDD pmos W=0.205u L=0.04u
M2645 U885/net22 N128 U885/net16 VDD pmos W=0.205u L=0.04u
M2646 U885/net22 n762 U885/net16 VDD pmos W=0.205u L=0.04u
M2647 U886/net4 U886/net10 U886/net14 VSS nmos W=0.155u L=0.04u
M2648 U886/net6 n879 U886/net14 VSS nmos W=0.155u L=0.04u
M2649 U886/net4 n620 VSS VSS nmos W=0.155u L=0.04u
M2650 U886/net6 U886/net4 VSS VSS nmos W=0.155u L=0.04u
M2651 n835 U886/net14 VSS VSS nmos W=0.155u L=0.04u
M2652 U886/net10 n879 VSS VSS nmos W=0.155u L=0.04u
M2653 U886/net4 n879 U886/net14 VDD pmos W=0.205u L=0.04u
M2654 U886/net6 U886/net10 U886/net14 VDD pmos W=0.205u L=0.04u
M2655 U886/net4 n620 VDD VDD pmos W=0.205u L=0.04u
M2656 U886/net6 U886/net4 VDD VDD pmos W=0.205u L=0.04u
M2657 n835 U886/net14 VDD VDD pmos W=0.205u L=0.04u
M2658 U886/net10 n879 VDD VDD pmos W=0.205u L=0.04u
M2659 N7470 n586 U887/XI21-net17 VSS nmos W=0.155u L=0.04u
M2660 U887/XI21-net17 n847 VSS VSS nmos W=0.155u L=0.04u
M2661 N7470 n880 U887/XI6-net17 VSS nmos W=0.155u L=0.04u
M2662 U887/XI6-net17 n584 VSS VSS nmos W=0.155u L=0.04u
M2663 N7470 N122 U887/XI20-net17 VSS nmos W=0.155u L=0.04u
M2664 U887/XI20-net17 n762 VSS VSS nmos W=0.155u L=0.04u
M2665 VDD n586 U887/net22 VDD pmos W=0.205u L=0.04u
M2666 VDD n847 U887/net22 VDD pmos W=0.205u L=0.04u
M2667 U887/net16 n880 N7470 VDD pmos W=0.205u L=0.04u
M2668 U887/net16 n584 N7470 VDD pmos W=0.205u L=0.04u
M2669 U887/net22 N122 U887/net16 VDD pmos W=0.205u L=0.04u
M2670 U887/net22 n762 U887/net16 VDD pmos W=0.205u L=0.04u
M2671 U888/net4 n637 U888/net14 VSS nmos W=0.155u L=0.04u
M2672 U888/net6 U888/net10 U888/net14 VSS nmos W=0.17u L=0.04u
M2673 U888/net4 n881 VSS VSS nmos W=0.155u L=0.04u
M2674 U888/net6 U888/net4 VSS VSS nmos W=0.17u L=0.04u
M2675 n847 U888/net14 VSS VSS nmos W=0.155u L=0.04u
M2676 U888/net10 n637 VSS VSS nmos W=0.155u L=0.04u
M2677 U888/net4 U888/net10 U888/net14 VDD pmos W=0.255u L=0.04u
M2678 U888/net6 n637 U888/net14 VDD pmos W=0.28u L=0.04u
M2679 U888/net4 n881 VDD VDD pmos W=0.205u L=0.04u
M2680 U888/net6 U888/net4 VDD VDD pmos W=0.24u L=0.04u
M2681 n847 U888/net14 VDD VDD pmos W=0.205u L=0.04u
M2682 U888/net10 n637 VDD VDD pmos W=0.205u L=0.04u
M2683 n881 n879 U889/net15 VSS nmos W=0.155u L=0.04u
M2684 n881 n620 U889/net15 VSS nmos W=0.155u L=0.04u
M2685 U889/net15 n882 VSS VSS nmos W=0.155u L=0.04u
M2686 n881 n882 VDD VDD pmos W=0.205u L=0.04u
M2687 n881 n879 U889/XI16-net11 VDD pmos W=0.205u L=0.04u
M2688 U889/XI16-net11 n620 VDD VDD pmos W=0.205u L=0.04u
M2689 U890/net17 n883 VSS VSS nmos W=0.155u L=0.04u
M2690 U890/net17 n861 VSS VSS nmos W=0.155u L=0.04u
M2691 U890/net63 n636 VSS VSS nmos W=0.155u L=0.04u
M2692 n879 U890/net17 VSS VSS nmos W=0.155u L=0.04u
M2693 n879 n877 U890/net63 VSS nmos W=0.155u L=0.04u
M2694 n879 n636 U890/net31 VDD pmos W=0.205u L=0.04u
M2695 U890/net39 n883 VDD VDD pmos W=0.195u L=0.04u
M2696 U890/net31 U890/net17 VDD VDD pmos W=0.195u L=0.04u
M2697 n879 n877 U890/net31 VDD pmos W=0.195u L=0.04u
M2698 U890/net17 n861 U890/net39 VDD pmos W=0.195u L=0.04u
M2699 U891/XU35-net6 N4 VSS VSS nmos W=0.155u L=0.04u
M2700 U891/net5 n623 U891/XU35-net6 VSS nmos W=0.155u L=0.04u
M2701 U891/XU36-net6 U891/net5 VSS VSS nmos W=0.155u L=0.04u
M2702 n877 n625 U891/XU36-net6 VSS nmos W=0.155u L=0.04u
M2703 U891/net5 N4 VDD VDD pmos W=0.205u L=0.04u
M2704 U891/net5 n623 VDD VDD pmos W=0.205u L=0.04u
M2705 n877 U891/net5 VDD VDD pmos W=0.205u L=0.04u
M2706 n877 n625 VDD VDD pmos W=0.205u L=0.04u
M2707 N7469 n575 U892/net26 VSS nmos W=0.155u L=0.04u
M2708 N7469 N7365 U892/net26 VSS nmos W=0.155u L=0.04u
M2709 U892/net29 n884 VSS VSS nmos W=0.155u L=0.04u
M2710 U892/net26 N7015 U892/net29 VSS nmos W=0.155u L=0.04u
M2711 U892/net26 n574 U892/net29 VSS nmos W=0.155u L=0.04u
M2712 N7469 N7365 U892/net43 VDD pmos W=0.205u L=0.04u
M2713 N7469 n574 U892/net49 VDD pmos W=0.205u L=0.04u
M2714 U892/net49 N7015 VDD VDD pmos W=0.205u L=0.04u
M2715 U892/net43 n575 VDD VDD pmos W=0.205u L=0.04u
M2716 N7469 n884 VDD VDD pmos W=0.205u L=0.04u
M2717 U893/net29 n578 VSS VSS nmos W=0.155u L=0.04u
M2718 n884 N11 U893/net29 VSS nmos W=0.155u L=0.04u
M2719 n884 N61 U893/net23 VSS nmos W=0.155u L=0.04u
M2720 U893/net23 n577 VSS VSS nmos W=0.155u L=0.04u
M2721 U893/net20 n577 n884 VDD pmos W=0.205u L=0.04u
M2722 U893/net20 N61 n884 VDD pmos W=0.205u L=0.04u
M2723 VDD N11 U893/net20 VDD pmos W=0.205u L=0.04u
M2724 VDD n578 U893/net20 VDD pmos W=0.205u L=0.04u
M2725 n578 n746 VSS VSS nmos W=0.135u L=0.04u
M2726 n578 n746 VDD VDD pmos W=0.205u L=0.04u
M2727 U895/XU1-net6 n885 VSS VSS nmos W=0.155u L=0.04u
M2728 n746 N616 U895/XU1-net6 VSS nmos W=0.155u L=0.04u
M2729 n746 n885 VDD VDD pmos W=0.155u L=0.04u
M2730 n746 N616 VDD VDD pmos W=0.155u L=0.04u
M2731 n577 n886 VSS VSS nmos W=0.155u L=0.04u
M2732 n577 n885 VSS VSS nmos W=0.155u L=0.04u
M2733 U896/XI1-net8 n885 VDD VDD pmos W=0.205u L=0.04u
M2734 n577 n886 U896/XI1-net8 VDD pmos W=0.205u L=0.04u
M2735 U897/XU1-net6 n885 VSS VSS nmos W=0.155u L=0.04u
M2736 n574 n886 U897/XU1-net6 VSS nmos W=0.155u L=0.04u
M2737 n574 n885 VDD VDD pmos W=0.155u L=0.04u
M2738 n574 n886 VDD VDD pmos W=0.155u L=0.04u
M2739 n885 N613 VSS VSS nmos W=0.135u L=0.04u
M2740 n885 N613 VDD VDD pmos W=0.205u L=0.04u
M2741 U899/XU1-net6 n886 VSS VSS nmos W=0.155u L=0.04u
M2742 n575 N613 U899/XU1-net6 VSS nmos W=0.155u L=0.04u
M2743 n575 n886 VDD VDD pmos W=0.155u L=0.04u
M2744 n575 N613 VDD VDD pmos W=0.155u L=0.04u
M2745 n886 N616 VSS VSS nmos W=0.135u L=0.04u
M2746 n886 N616 VDD VDD pmos W=0.205u L=0.04u
M2747 N7467 n817 U901/XI21-net17 VSS nmos W=0.155u L=0.04u
M2748 U901/XI21-net17 n586 VSS VSS nmos W=0.155u L=0.04u
M2749 N7467 n887 U901/XI6-net17 VSS nmos W=0.155u L=0.04u
M2750 U901/XI6-net17 n584 VSS VSS nmos W=0.155u L=0.04u
M2751 N7467 N119 U901/XI20-net17 VSS nmos W=0.155u L=0.04u
M2752 U901/XI20-net17 n762 VSS VSS nmos W=0.155u L=0.04u
M2753 VDD n817 U901/net22 VDD pmos W=0.205u L=0.04u
M2754 VDD n586 U901/net22 VDD pmos W=0.205u L=0.04u
M2755 U901/net16 n887 N7467 VDD pmos W=0.205u L=0.04u
M2756 U901/net16 n584 N7467 VDD pmos W=0.205u L=0.04u
M2757 U901/net22 N119 U901/net16 VDD pmos W=0.205u L=0.04u
M2758 U901/net22 n762 U901/net16 VDD pmos W=0.205u L=0.04u
M2759 U902/net4 U902/net10 U902/net14 VSS nmos W=0.155u L=0.04u
M2760 U902/net6 n694 U902/net14 VSS nmos W=0.155u L=0.04u
M2761 U902/net4 n888 VSS VSS nmos W=0.155u L=0.04u
M2762 U902/net6 U902/net4 VSS VSS nmos W=0.155u L=0.04u
M2763 n817 U902/net14 VSS VSS nmos W=0.155u L=0.04u
M2764 U902/net10 n694 VSS VSS nmos W=0.155u L=0.04u
M2765 U902/net4 n694 U902/net14 VDD pmos W=0.205u L=0.04u
M2766 U902/net6 U902/net10 U902/net14 VDD pmos W=0.205u L=0.04u
M2767 U902/net4 n888 VDD VDD pmos W=0.205u L=0.04u
M2768 U902/net6 U902/net4 VDD VDD pmos W=0.205u L=0.04u
M2769 n817 U902/net14 VDD VDD pmos W=0.205u L=0.04u
M2770 U902/net10 n694 VDD VDD pmos W=0.205u L=0.04u
M2771 N7466 n816 U903/XI21-net17 VSS nmos W=0.155u L=0.04u
M2772 U903/XI21-net17 n586 VSS VSS nmos W=0.155u L=0.04u
M2773 N7466 n584 U903/XI6-net17 VSS nmos W=0.155u L=0.04u
M2774 U903/XI6-net17 n889 VSS VSS nmos W=0.155u L=0.04u
M2775 N7466 N130 U903/XI20-net17 VSS nmos W=0.155u L=0.04u
M2776 U903/XI20-net17 n762 VSS VSS nmos W=0.155u L=0.04u
M2777 VDD n816 U903/net22 VDD pmos W=0.205u L=0.04u
M2778 VDD n586 U903/net22 VDD pmos W=0.205u L=0.04u
M2779 U903/net16 n584 N7466 VDD pmos W=0.205u L=0.04u
M2780 U903/net16 n889 N7466 VDD pmos W=0.205u L=0.04u
M2781 U903/net22 N130 U903/net16 VDD pmos W=0.205u L=0.04u
M2782 U903/net22 n762 U903/net16 VDD pmos W=0.205u L=0.04u
M2783 U904/net4 U904/net10 U904/net14 VSS nmos W=0.155u L=0.04u
M2784 U904/net6 n890 U904/net14 VSS nmos W=0.155u L=0.04u
M2785 U904/net4 n717 VSS VSS nmos W=0.155u L=0.04u
M2786 U904/net6 U904/net4 VSS VSS nmos W=0.155u L=0.04u
M2787 n816 U904/net14 VSS VSS nmos W=0.155u L=0.04u
M2788 U904/net10 n890 VSS VSS nmos W=0.155u L=0.04u
M2789 U904/net4 n890 U904/net14 VDD pmos W=0.205u L=0.04u
M2790 U904/net6 U904/net10 U904/net14 VDD pmos W=0.205u L=0.04u
M2791 U904/net4 n717 VDD VDD pmos W=0.205u L=0.04u
M2792 U904/net6 U904/net4 VDD VDD pmos W=0.205u L=0.04u
M2793 n816 U904/net14 VDD VDD pmos W=0.205u L=0.04u
M2794 U904/net10 n890 VDD VDD pmos W=0.205u L=0.04u
M2795 N7465 n832 U905/XI21-net17 VSS nmos W=0.155u L=0.04u
M2796 U905/XI21-net17 n586 VSS VSS nmos W=0.155u L=0.04u
M2797 N7465 n891 U905/XI6-net17 VSS nmos W=0.155u L=0.04u
M2798 U905/XI6-net17 n584 VSS VSS nmos W=0.155u L=0.04u
M2799 N7465 N52 U905/XI20-net17 VSS nmos W=0.155u L=0.04u
M2800 U905/XI20-net17 n762 VSS VSS nmos W=0.155u L=0.04u
M2801 VDD n832 U905/net22 VDD pmos W=0.205u L=0.04u
M2802 VDD n586 U905/net22 VDD pmos W=0.205u L=0.04u
M2803 U905/net16 n891 N7465 VDD pmos W=0.205u L=0.04u
M2804 U905/net16 n584 N7465 VDD pmos W=0.205u L=0.04u
M2805 U905/net22 N52 U905/net16 VDD pmos W=0.205u L=0.04u
M2806 U905/net22 n762 U905/net16 VDD pmos W=0.205u L=0.04u
M2807 U906/net4 n686 U906/net14 VSS nmos W=0.155u L=0.04u
M2808 U906/net6 U906/net10 U906/net14 VSS nmos W=0.17u L=0.04u
M2809 U906/net4 n892 VSS VSS nmos W=0.155u L=0.04u
M2810 U906/net6 U906/net4 VSS VSS nmos W=0.17u L=0.04u
M2811 n832 U906/net14 VSS VSS nmos W=0.155u L=0.04u
M2812 U906/net10 n686 VSS VSS nmos W=0.155u L=0.04u
M2813 U906/net4 U906/net10 U906/net14 VDD pmos W=0.255u L=0.04u
M2814 U906/net6 n686 U906/net14 VDD pmos W=0.28u L=0.04u
M2815 U906/net4 n892 VDD VDD pmos W=0.205u L=0.04u
M2816 U906/net6 U906/net4 VDD VDD pmos W=0.24u L=0.04u
M2817 n832 U906/net14 VDD VDD pmos W=0.205u L=0.04u
M2818 U906/net10 n686 VDD VDD pmos W=0.205u L=0.04u
M2819 n892 n890 U907/net15 VSS nmos W=0.155u L=0.04u
M2820 n892 n717 U907/net15 VSS nmos W=0.155u L=0.04u
M2821 U907/net15 n893 VSS VSS nmos W=0.155u L=0.04u
M2822 n892 n893 VDD VDD pmos W=0.205u L=0.04u
M2823 n892 n890 U907/XI16-net11 VDD pmos W=0.205u L=0.04u
M2824 U907/XI16-net11 n717 VDD VDD pmos W=0.205u L=0.04u
M2825 U908/net14 n694 U908/net20 VSS nmos W=0.155u L=0.04u
M2826 U908/net14 n888 U908/net20 VSS nmos W=0.155u L=0.04u
M2827 U908/net20 n715 VSS VSS nmos W=0.155u L=0.04u
M2828 n890 U908/net14 VSS VSS nmos W=0.155u L=0.04u
M2829 n890 U908/net14 VDD VDD pmos W=0.205u L=0.04u
M2830 U908/net14 n715 VDD VDD pmos W=0.205u L=0.04u
M2831 U908/net24 n694 VDD VDD pmos W=0.205u L=0.04u
M2832 U908/net14 n888 U908/net24 VDD pmos W=0.205u L=0.04u
M2833 n888 n894 U909/net27 VSS nmos W=0.155u L=0.04u
M2834 U909/net27 N54 VSS VSS nmos W=0.155u L=0.04u
M2835 n888 n691 VSS VSS nmos W=0.155u L=0.04u
M2836 n888 N54 U909/net13 VDD pmos W=0.205u L=0.04u
M2837 U909/net13 n691 VDD VDD pmos W=0.205u L=0.04u
M2838 n888 n894 U909/net13 VDD pmos W=0.205u L=0.04u
M2839 N7449 n895 U910/net26 VSS nmos W=0.155u L=0.04u
M2840 N7449 n754 U910/net26 VSS nmos W=0.155u L=0.04u
M2841 U910/net29 n896 VSS VSS nmos W=0.155u L=0.04u
M2842 U910/net26 N7365 U910/net29 VSS nmos W=0.155u L=0.04u
M2843 U910/net26 n580 U910/net29 VSS nmos W=0.155u L=0.04u
M2844 N7449 n754 U910/net43 VDD pmos W=0.205u L=0.04u
M2845 N7449 n580 U910/net49 VDD pmos W=0.205u L=0.04u
M2846 U910/net49 N7365 VDD VDD pmos W=0.205u L=0.04u
M2847 U910/net43 n895 VDD VDD pmos W=0.205u L=0.04u
M2848 N7449 n896 VDD VDD pmos W=0.205u L=0.04u
M2849 U911/net29 n582 VSS VSS nmos W=0.155u L=0.04u
M2850 n896 N11 U911/net29 VSS nmos W=0.155u L=0.04u
M2851 n896 n755 U911/net23 VSS nmos W=0.155u L=0.04u
M2852 U911/net23 n808 VSS VSS nmos W=0.155u L=0.04u
M2853 U911/net20 n808 n896 VDD pmos W=0.205u L=0.04u
M2854 U911/net20 n755 n896 VDD pmos W=0.205u L=0.04u
M2855 VDD N11 U911/net20 VDD pmos W=0.205u L=0.04u
M2856 VDD n582 U911/net20 VDD pmos W=0.205u L=0.04u
M2857 n582 N610 VSS VSS nmos W=0.155u L=0.04u
M2858 n582 U912/net4 VSS VSS nmos W=0.155u L=0.04u
M2859 U912/net4 N607 VSS VSS nmos W=0.155u L=0.04u
M2860 U912/XU1-net8 U912/net4 VDD VDD pmos W=0.205u L=0.04u
M2861 n582 N610 U912/XU1-net8 VDD pmos W=0.205u L=0.04u
M2862 U912/net4 N607 VDD VDD pmos W=0.205u L=0.04u
M2863 n808 N7015 VSS VSS nmos W=0.135u L=0.04u
M2864 n808 N7015 VDD VDD pmos W=0.205u L=0.04u
M2865 n755 N610 VSS VSS nmos W=0.155u L=0.04u
M2866 n755 N607 VSS VSS nmos W=0.155u L=0.04u
M2867 U914/XI1-net8 N607 VDD VDD pmos W=0.205u L=0.04u
M2868 n755 N610 U914/XI1-net8 VDD pmos W=0.205u L=0.04u
M2869 U915/net13 N607 VSS VSS nmos W=0.155u L=0.04u
M2870 U915/net16 U915/net13 VSS VSS nmos W=0.155u L=0.04u
M2871 n580 N610 U915/net16 VSS nmos W=0.155u L=0.04u
M2872 U915/net13 N607 VDD VDD pmos W=0.205u L=0.04u
M2873 VDD U915/net13 n580 VDD pmos W=0.205u L=0.04u
M2874 VDD N610 n580 VDD pmos W=0.205u L=0.04u
M2875 n895 N61 VSS VSS nmos W=0.135u L=0.04u
M2876 n895 N61 VDD VDD pmos W=0.205u L=0.04u
M2877 U917/XU1-net6 N610 VSS VSS nmos W=0.155u L=0.04u
M2878 n754 N607 U917/XU1-net6 VSS nmos W=0.155u L=0.04u
M2879 n754 N610 VDD VDD pmos W=0.155u L=0.04u
M2880 n754 N607 VDD VDD pmos W=0.155u L=0.04u
M2881 N7432 n774 VSS VSS nmos W=0.135u L=0.04u
M2882 N7432 n774 VDD VDD pmos W=0.205u L=0.04u
M2883 U919/net4 U919/net10 U919/net14 VSS nmos W=0.155u L=0.04u
M2884 U919/net6 n897 U919/net14 VSS nmos W=0.155u L=0.04u
M2885 U919/net4 n898 VSS VSS nmos W=0.155u L=0.04u
M2886 U919/net6 U919/net4 VSS VSS nmos W=0.155u L=0.04u
M2887 n774 U919/net14 VSS VSS nmos W=0.155u L=0.04u
M2888 U919/net10 n897 VSS VSS nmos W=0.155u L=0.04u
M2889 U919/net4 n897 U919/net14 VDD pmos W=0.205u L=0.04u
M2890 U919/net6 U919/net10 U919/net14 VDD pmos W=0.205u L=0.04u
M2891 U919/net4 n898 VDD VDD pmos W=0.205u L=0.04u
M2892 U919/net6 U919/net4 VDD VDD pmos W=0.205u L=0.04u
M2893 n774 U919/net14 VDD VDD pmos W=0.205u L=0.04u
M2894 U919/net10 n897 VDD VDD pmos W=0.205u L=0.04u
M2895 n897 n818 U920/net27 VSS nmos W=0.155u L=0.04u
M2896 U920/net27 n710 VSS VSS nmos W=0.155u L=0.04u
M2897 n897 n899 VSS VSS nmos W=0.155u L=0.04u
M2898 n897 n710 U920/net13 VDD pmos W=0.205u L=0.04u
M2899 U920/net13 n899 VDD VDD pmos W=0.205u L=0.04u
M2900 n897 n818 U920/net13 VDD pmos W=0.205u L=0.04u
M2901 U921/XU1-net6 n821 VSS VSS nmos W=0.155u L=0.04u
M2902 n710 n708 U921/XU1-net6 VSS nmos W=0.155u L=0.04u
M2903 n710 n821 VDD VDD pmos W=0.155u L=0.04u
M2904 n710 n708 VDD VDD pmos W=0.155u L=0.04u
M2905 n708 n900 VSS VSS nmos W=0.155u L=0.04u
M2906 n708 U922/net4 VSS VSS nmos W=0.155u L=0.04u
M2907 U922/net4 n823 VSS VSS nmos W=0.155u L=0.04u
M2908 U922/XU1-net8 U922/net4 VDD VDD pmos W=0.205u L=0.04u
M2909 n708 n900 U922/XU1-net8 VDD pmos W=0.205u L=0.04u
M2910 U922/net4 n823 VDD VDD pmos W=0.205u L=0.04u
M2911 n818 n822 VSS VSS nmos W=0.135u L=0.04u
M2912 n818 n822 VDD VDD pmos W=0.205u L=0.04u
M2913 n822 n701 U924/net27 VSS nmos W=0.155u L=0.04u
M2914 U924/net27 N54 VSS VSS nmos W=0.155u L=0.04u
M2915 n822 n702 VSS VSS nmos W=0.155u L=0.04u
M2916 n822 N54 U924/net13 VDD pmos W=0.205u L=0.04u
M2917 U924/net13 n702 VDD VDD pmos W=0.205u L=0.04u
M2918 n822 n701 U924/net13 VDD pmos W=0.205u L=0.04u
M2919 N7365 n586 U925/XI21-net17 VSS nmos W=0.155u L=0.04u
M2920 U925/XI21-net17 n846 VSS VSS nmos W=0.155u L=0.04u
M2921 N7365 n901 U925/XI6-net17 VSS nmos W=0.155u L=0.04u
M2922 U925/XI6-net17 n584 VSS VSS nmos W=0.155u L=0.04u
M2923 N7365 N117 U925/XI20-net17 VSS nmos W=0.155u L=0.04u
M2924 U925/XI20-net17 n762 VSS VSS nmos W=0.155u L=0.04u
M2925 VDD n586 U925/net22 VDD pmos W=0.205u L=0.04u
M2926 VDD n846 U925/net22 VDD pmos W=0.205u L=0.04u
M2927 U925/net16 n901 N7365 VDD pmos W=0.205u L=0.04u
M2928 U925/net16 n584 N7365 VDD pmos W=0.205u L=0.04u
M2929 U925/net22 N117 U925/net16 VDD pmos W=0.205u L=0.04u
M2930 U925/net22 n762 U925/net16 VDD pmos W=0.205u L=0.04u
M2931 U926/net4 U926/net10 U926/net14 VSS nmos W=0.155u L=0.04u
M2932 U926/net6 n633 U926/net14 VSS nmos W=0.155u L=0.04u
M2933 U926/net4 N4 VSS VSS nmos W=0.155u L=0.04u
M2934 U926/net6 U926/net4 VSS VSS nmos W=0.155u L=0.04u
M2935 n846 U926/net14 VSS VSS nmos W=0.155u L=0.04u
M2936 U926/net10 n633 VSS VSS nmos W=0.155u L=0.04u
M2937 U926/net4 n633 U926/net14 VDD pmos W=0.205u L=0.04u
M2938 U926/net6 U926/net10 U926/net14 VDD pmos W=0.205u L=0.04u
M2939 U926/net4 N4 VDD VDD pmos W=0.205u L=0.04u
M2940 U926/net6 U926/net4 VDD VDD pmos W=0.205u L=0.04u
M2941 n846 U926/net14 VDD VDD pmos W=0.205u L=0.04u
M2942 U926/net10 n633 VDD VDD pmos W=0.205u L=0.04u
M2943 N7363 n586 U927/XI21-net17 VSS nmos W=0.155u L=0.04u
M2944 U927/XI21-net17 n831 VSS VSS nmos W=0.155u L=0.04u
M2945 N7363 n902 U927/XI6-net17 VSS nmos W=0.155u L=0.04u
M2946 U927/XI6-net17 n584 VSS VSS nmos W=0.155u L=0.04u
M2947 N7363 N129 U927/XI20-net17 VSS nmos W=0.155u L=0.04u
M2948 U927/XI20-net17 n762 VSS VSS nmos W=0.155u L=0.04u
M2949 VDD n586 U927/net22 VDD pmos W=0.205u L=0.04u
M2950 VDD n831 U927/net22 VDD pmos W=0.205u L=0.04u
M2951 U927/net16 n902 N7363 VDD pmos W=0.205u L=0.04u
M2952 U927/net16 n584 N7363 VDD pmos W=0.205u L=0.04u
M2953 U927/net22 N129 U927/net16 VDD pmos W=0.205u L=0.04u
M2954 U927/net22 n762 U927/net16 VDD pmos W=0.205u L=0.04u
M2955 n831 N54 U928/net10 VSS nmos W=0.155u L=0.04u
M2956 U928/net10 n894 VSS VSS nmos W=0.155u L=0.04u
M2957 n831 n695 U928/net10 VSS nmos W=0.155u L=0.04u
M2958 U928/net10 n903 VSS VSS nmos W=0.155u L=0.04u
M2959 U928/net30 n894 VDD VDD pmos W=0.205u L=0.04u
M2960 n831 N54 U928/net24 VDD pmos W=0.205u L=0.04u
M2961 U928/net24 n695 VDD VDD pmos W=0.205u L=0.04u
M2962 n831 n903 U928/net30 VDD pmos W=0.205u L=0.04u
M2963 n903 N54 VSS VSS nmos W=0.155u L=0.04u
M2964 n903 n681 VSS VSS nmos W=0.155u L=0.04u
M2965 U929/XI1-net8 n681 VDD VDD pmos W=0.205u L=0.04u
M2966 n903 N54 U929/XI1-net8 VDD pmos W=0.205u L=0.04u
M2967 n681 n904 VSS VSS nmos W=0.135u L=0.04u
M2968 n681 n904 VDD VDD pmos W=0.205u L=0.04u
M2969 N7015 n586 U931/XI21-net17 VSS nmos W=0.155u L=0.04u
M2970 U931/XI21-net17 n830 VSS VSS nmos W=0.155u L=0.04u
M2971 N7015 n584 U931/XI6-net17 VSS nmos W=0.155u L=0.04u
M2972 U931/XI6-net17 n677 VSS VSS nmos W=0.155u L=0.04u
M2973 N7015 N131 U931/XI20-net17 VSS nmos W=0.155u L=0.04u
M2974 U931/XI20-net17 n762 VSS VSS nmos W=0.155u L=0.04u
M2975 VDD n586 U931/net22 VDD pmos W=0.205u L=0.04u
M2976 VDD n830 U931/net22 VDD pmos W=0.205u L=0.04u
M2977 U931/net16 n584 N7015 VDD pmos W=0.205u L=0.04u
M2978 U931/net16 n677 N7015 VDD pmos W=0.205u L=0.04u
M2979 U931/net22 N131 U931/net16 VDD pmos W=0.205u L=0.04u
M2980 U931/net22 n762 U931/net16 VDD pmos W=0.205u L=0.04u
M2981 U932/net4 U932/net10 U932/net14 VSS nmos W=0.155u L=0.04u
M2982 U932/net6 n904 U932/net14 VSS nmos W=0.155u L=0.04u
M2983 U932/net4 N54 VSS VSS nmos W=0.155u L=0.04u
M2984 U932/net6 U932/net4 VSS VSS nmos W=0.155u L=0.04u
M2985 n830 U932/net14 VSS VSS nmos W=0.155u L=0.04u
M2986 U932/net10 n904 VSS VSS nmos W=0.155u L=0.04u
M2987 U932/net4 n904 U932/net14 VDD pmos W=0.205u L=0.04u
M2988 U932/net6 U932/net10 U932/net14 VDD pmos W=0.205u L=0.04u
M2989 U932/net4 N54 VDD VDD pmos W=0.205u L=0.04u
M2990 U932/net6 U932/net4 VDD VDD pmos W=0.205u L=0.04u
M2991 n830 U932/net14 VDD VDD pmos W=0.205u L=0.04u
M2992 U932/net10 n904 VDD VDD pmos W=0.205u L=0.04u
M2993 n586 n590 VSS VSS nmos W=0.155u L=0.04u
M2994 n586 N625 VSS VSS nmos W=0.155u L=0.04u
M2995 U933/XI1-net8 N625 VDD VDD pmos W=0.205u L=0.04u
M2996 n586 n590 U933/XI1-net8 VDD pmos W=0.205u L=0.04u
M2997 n762 U934/net6 VSS VSS nmos W=0.155u L=0.04u
M2998 U934/X_u2-net6 n590 VSS VSS nmos W=0.155u L=0.04u
M2999 U934/net6 N625 U934/X_u2-net6 VSS nmos W=0.155u L=0.04u
M3000 n762 U934/net6 VDD VDD pmos W=0.205u L=0.04u
M3001 U934/net6 n590 VDD VDD pmos W=0.205u L=0.04u
M3002 U934/net6 N625 VDD VDD pmos W=0.205u L=0.04u
M3003 n590 N619 VSS VSS nmos W=0.135u L=0.04u
M3004 n590 N619 VDD VDD pmos W=0.205u L=0.04u
M3005 n584 N625 VSS VSS nmos W=0.155u L=0.04u
M3006 n584 N619 VSS VSS nmos W=0.155u L=0.04u
M3007 U936/XI1-net8 N619 VDD VDD pmos W=0.205u L=0.04u
M3008 n584 N625 U936/XI1-net8 VDD pmos W=0.205u L=0.04u
M3009 N6927 U937/net27 VDD VDD pmos W=0.205u L=0.04u
M3010 U937/net11 n702 U937/net27 VDD pmos W=0.205u L=0.04u
M3011 U937/net11 n900 U937/net27 VDD pmos W=0.205u L=0.04u
M3012 U937/net11 n898 U937/XI16-net11 VDD pmos W=0.205u L=0.04u
M3013 U937/XI16-net11 n899 VDD VDD pmos W=0.205u L=0.04u
M3014 U937/net27 n899 VSS VSS nmos W=0.155u L=0.04u
M3015 U937/net27 n898 VSS VSS nmos W=0.155u L=0.04u
M3016 N6927 U937/net27 VSS VSS nmos W=0.155u L=0.04u
M3017 U937/net27 n702 U937/XI12-net17 VSS nmos W=0.155u L=0.04u
M3018 U937/XI12-net17 n900 VSS VSS nmos W=0.155u L=0.04u
M3019 U938/XU1-net6 n821 VSS VSS nmos W=0.155u L=0.04u
M3020 n899 n823 U938/XU1-net6 VSS nmos W=0.155u L=0.04u
M3021 n899 n821 VDD VDD pmos W=0.155u L=0.04u
M3022 n899 n823 VDD VDD pmos W=0.155u L=0.04u
M3023 n823 U939/net6 VSS VSS nmos W=0.155u L=0.04u
M3024 U939/X_u2-net6 n905 VSS VSS nmos W=0.155u L=0.04u
M3025 U939/net6 n826 U939/X_u2-net6 VSS nmos W=0.155u L=0.04u
M3026 n823 U939/net6 VDD VDD pmos W=0.205u L=0.04u
M3027 U939/net6 n905 VDD VDD pmos W=0.205u L=0.04u
M3028 U939/net6 n826 VDD VDD pmos W=0.205u L=0.04u
M3029 U940/XU1-net6 n711 VSS VSS nmos W=0.155u L=0.04u
M3030 n826 n704 U940/XU1-net6 VSS nmos W=0.155u L=0.04u
M3031 n826 n711 VDD VDD pmos W=0.155u L=0.04u
M3032 n826 n704 VDD VDD pmos W=0.155u L=0.04u
M3033 n898 n777 VSS VSS nmos W=0.135u L=0.04u
M3034 n898 n777 VDD VDD pmos W=0.205u L=0.04u
M3035 U942/net8 n690 U942/net26 VSS nmos W=0.155u L=0.04u
M3036 U942/net26 n696 VSS VSS nmos W=0.155u L=0.04u
M3037 U942/net29 U942/net8 VSS VSS nmos W=0.155u L=0.04u
M3038 U942/net29 n869 n702 VSS nmos W=0.155u L=0.04u
M3039 U942/net29 n906 n702 VSS nmos W=0.155u L=0.04u
M3040 U942/net8 n696 VDD VDD pmos W=0.205u L=0.04u
M3041 U942/net8 n690 VDD VDD pmos W=0.205u L=0.04u
M3042 n702 U942/net8 VDD VDD pmos W=0.205u L=0.04u
M3043 n702 n869 U942/net20 VDD pmos W=0.205u L=0.04u
M3044 U942/net20 n906 VDD VDD pmos W=0.205u L=0.04u
M3045 n690 n907 U943/net26 VSS nmos W=0.155u L=0.04u
M3046 n690 n714 U943/net26 VSS nmos W=0.155u L=0.04u
M3047 U943/net29 n893 VSS VSS nmos W=0.155u L=0.04u
M3048 U943/net26 n717 U943/net29 VSS nmos W=0.155u L=0.04u
M3049 U943/net26 n715 U943/net29 VSS nmos W=0.155u L=0.04u
M3050 n690 n714 U943/net43 VDD pmos W=0.205u L=0.04u
M3051 n690 n715 U943/net49 VDD pmos W=0.205u L=0.04u
M3052 U943/net49 n717 VDD VDD pmos W=0.205u L=0.04u
M3053 U943/net43 n907 VDD VDD pmos W=0.205u L=0.04u
M3054 n690 n893 VDD VDD pmos W=0.205u L=0.04u
M3055 n714 n691 VSS VSS nmos W=0.135u L=0.04u
M3056 n714 n691 VDD VDD pmos W=0.205u L=0.04u
M3057 n691 n908 U945/net10 VSS nmos W=0.155u L=0.04u
M3058 U945/net10 n904 VSS VSS nmos W=0.155u L=0.04u
M3059 n691 n867 U945/net10 VSS nmos W=0.155u L=0.04u
M3060 U945/net10 n716 VSS VSS nmos W=0.155u L=0.04u
M3061 U945/net30 n904 VDD VDD pmos W=0.205u L=0.04u
M3062 n691 n908 U945/net24 VDD pmos W=0.205u L=0.04u
M3063 U945/net24 n867 VDD VDD pmos W=0.205u L=0.04u
M3064 n691 n716 U945/net30 VDD pmos W=0.205u L=0.04u
M3065 n716 n894 VSS VSS nmos W=0.135u L=0.04u
M3066 n716 n894 VDD VDD pmos W=0.205u L=0.04u
M3067 N6926 n857 U947/net10 VSS nmos W=0.155u L=0.04u
M3068 U947/net10 n661 VSS VSS nmos W=0.155u L=0.04u
M3069 N6926 n909 U947/net10 VSS nmos W=0.155u L=0.04u
M3070 U947/net10 n910 VSS VSS nmos W=0.155u L=0.04u
M3071 U947/net30 n661 VDD VDD pmos W=0.205u L=0.04u
M3072 N6926 n857 U947/net24 VDD pmos W=0.205u L=0.04u
M3073 U947/net24 n909 VDD VDD pmos W=0.205u L=0.04u
M3074 N6926 n910 U947/net30 VDD pmos W=0.205u L=0.04u
M3075 n661 n911 VSS VSS nmos W=0.135u L=0.04u
M3076 n661 n911 VDD VDD pmos W=0.205u L=0.04u
M3077 n910 n844 U949/net27 VSS nmos W=0.155u L=0.04u
M3078 U949/net27 n643 VSS VSS nmos W=0.155u L=0.04u
M3079 n910 n653 VSS VSS nmos W=0.155u L=0.04u
M3080 n910 n643 U949/net13 VDD pmos W=0.205u L=0.04u
M3081 U949/net13 n653 VDD VDD pmos W=0.205u L=0.04u
M3082 n910 n844 U949/net13 VDD pmos W=0.205u L=0.04u
M3083 U950/net8 n654 U950/net26 VSS nmos W=0.155u L=0.04u
M3084 U950/net26 n658 VSS VSS nmos W=0.155u L=0.04u
M3085 U950/net29 U950/net8 VSS VSS nmos W=0.155u L=0.04u
M3086 U950/net29 n660 n653 VSS nmos W=0.155u L=0.04u
M3087 U950/net29 n659 n653 VSS nmos W=0.155u L=0.04u
M3088 U950/net8 n658 VDD VDD pmos W=0.205u L=0.04u
M3089 U950/net8 n654 VDD VDD pmos W=0.205u L=0.04u
M3090 n653 U950/net8 VDD VDD pmos W=0.205u L=0.04u
M3091 n653 n660 U950/net20 VDD pmos W=0.205u L=0.04u
M3092 U950/net20 n659 VDD VDD pmos W=0.205u L=0.04u
M3093 U951/XU1-net6 n912 VSS VSS nmos W=0.155u L=0.04u
M3094 n654 n647 U951/XU1-net6 VSS nmos W=0.155u L=0.04u
M3095 n654 n912 VDD VDD pmos W=0.155u L=0.04u
M3096 n654 n647 VDD VDD pmos W=0.155u L=0.04u
M3097 U952/XU1-net6 n651 VSS VSS nmos W=0.155u L=0.04u
M3098 n647 n652 U952/XU1-net6 VSS nmos W=0.155u L=0.04u
M3099 n647 n651 VDD VDD pmos W=0.155u L=0.04u
M3100 n647 n652 VDD VDD pmos W=0.155u L=0.04u
M3101 n643 n913 U953/net10 VSS nmos W=0.155u L=0.04u
M3102 U953/net10 n637 VSS VSS nmos W=0.155u L=0.04u
M3103 n643 n858 U953/net10 VSS nmos W=0.155u L=0.04u
M3104 U953/net10 n622 VSS VSS nmos W=0.155u L=0.04u
M3105 U953/net30 n637 VDD VDD pmos W=0.205u L=0.04u
M3106 n643 n913 U953/net24 VDD pmos W=0.205u L=0.04u
M3107 U953/net24 n858 VDD VDD pmos W=0.205u L=0.04u
M3108 n643 n622 U953/net30 VDD pmos W=0.205u L=0.04u
M3109 n622 n638 VSS VSS nmos W=0.135u L=0.04u
M3110 n622 n638 VDD VDD pmos W=0.205u L=0.04u
M3111 U955/XU35-net6 n616 VSS VSS nmos W=0.155u L=0.04u
M3112 U955/net5 n626 U955/XU35-net6 VSS nmos W=0.155u L=0.04u
M3113 U955/XU36-net6 U955/net5 VSS VSS nmos W=0.155u L=0.04u
M3114 n638 n882 U955/XU36-net6 VSS nmos W=0.155u L=0.04u
M3115 U955/net5 n616 VDD VDD pmos W=0.205u L=0.04u
M3116 U955/net5 n626 VDD VDD pmos W=0.205u L=0.04u
M3117 n638 U955/net5 VDD VDD pmos W=0.205u L=0.04u
M3118 n638 n882 VDD VDD pmos W=0.205u L=0.04u
M3119 n616 n620 VSS VSS nmos W=0.135u L=0.04u
M3120 n616 n620 VDD VDD pmos W=0.205u L=0.04u
M3121 n626 n861 U957/net10 VSS nmos W=0.155u L=0.04u
M3122 U957/net10 n914 VSS VSS nmos W=0.155u L=0.04u
M3123 n626 n883 U957/net10 VSS nmos W=0.155u L=0.04u
M3124 U957/net10 n625 VSS VSS nmos W=0.155u L=0.04u
M3125 U957/net30 n914 VDD VDD pmos W=0.205u L=0.04u
M3126 n626 n861 U957/net24 VDD pmos W=0.205u L=0.04u
M3127 U957/net24 n883 VDD VDD pmos W=0.205u L=0.04u
M3128 n626 n625 U957/net30 VDD pmos W=0.205u L=0.04u
M3129 n914 n636 VSS VSS nmos W=0.135u L=0.04u
M3130 n914 n636 VDD VDD pmos W=0.205u L=0.04u
M3131 U959/net17 n850 VSS VSS nmos W=0.155u L=0.04u
M3132 U959/net17 n915 VSS VSS nmos W=0.155u L=0.04u
M3133 U959/net63 n627 VSS VSS nmos W=0.155u L=0.04u
M3134 n625 U959/net17 VSS VSS nmos W=0.155u L=0.04u
M3135 n625 n875 U959/net63 VSS nmos W=0.155u L=0.04u
M3136 n625 n627 U959/net31 VDD pmos W=0.205u L=0.04u
M3137 U959/net39 n850 VDD VDD pmos W=0.195u L=0.04u
M3138 U959/net31 U959/net17 VDD VDD pmos W=0.195u L=0.04u
M3139 n625 n875 U959/net31 VDD pmos W=0.195u L=0.04u
M3140 U959/net17 n915 U959/net39 VDD pmos W=0.195u L=0.04u
M3141 U960/net28 U960/net20 U960/net64 VSS nmos W=0.155u L=0.04u
M3142 U960/net24 U960/net30 U960/net32 VSS nmos W=0.155u L=0.04u
M3143 U960/net28 U960/net40 U960/net24 VSS nmos W=0.155u L=0.04u
M3144 U960/net40 N210 U960/net108 VSS nmos W=0.155u L=0.04u
M3145 U960/net40 U960/net106 U960/net104 VSS nmos W=0.155u L=0.04u
M3146 U960/net24 n916 U960/net050 VSS nmos W=0.155u L=0.04u
M3147 U960/net050 U960/net32 VSS VSS nmos W=0.155u L=0.04u
M3148 U960/net20 U960/net40 VSS VSS nmos W=0.155u L=0.04u
M3149 U960/net106 N210 VSS VSS nmos W=0.155u L=0.04u
M3150 U960/net104 N206 VSS VSS nmos W=0.155u L=0.04u
M3151 U960/net30 n916 VSS VSS nmos W=0.155u L=0.04u
M3152 U960/net108 U960/net104 VSS VSS nmos W=0.155u L=0.04u
M3153 N6877 U960/net28 VSS VSS nmos W=0.155u L=0.04u
M3154 U960/net32 n917 VSS VSS nmos W=0.155u L=0.04u
M3155 U960/net64 U960/net24 VSS VSS nmos W=0.2u L=0.04u
M3156 U960/net28 U960/net40 U960/net64 VDD pmos W=0.205u L=0.04u
M3157 U960/net24 n916 U960/net32 VDD pmos W=0.205u L=0.04u
M3158 U960/net28 U960/net20 U960/net24 VDD pmos W=0.205u L=0.04u
M3159 U960/net40 U960/net106 U960/net108 VDD pmos W=0.205u L=0.04u
M3160 U960/net40 N210 U960/net104 VDD pmos W=0.205u L=0.04u
M3161 U960/net20 U960/net40 VDD VDD pmos W=0.205u L=0.04u
M3162 U960/net106 N210 VDD VDD pmos W=0.205u L=0.04u
M3163 U960/net104 N206 VDD VDD pmos W=0.205u L=0.04u
M3164 U960/net30 n916 VDD VDD pmos W=0.205u L=0.04u
M3165 U960/net108 U960/net104 VDD VDD pmos W=0.205u L=0.04u
M3166 N6877 U960/net28 VDD VDD pmos W=0.205u L=0.04u
M3167 U960/net32 n917 VDD VDD pmos W=0.205u L=0.04u
M3168 U960/net64 U960/net24 VDD VDD pmos W=0.28u L=0.04u
M3169 U960/net24 U960/net30 U960/net045 VDD pmos W=0.205u L=0.04u
M3170 U960/net045 U960/net32 VDD VDD pmos W=0.205u L=0.04u
M3171 U961/net28 U961/net20 U961/net64 VSS nmos W=0.155u L=0.04u
M3172 U961/net24 U961/net30 U961/net32 VSS nmos W=0.155u L=0.04u
M3173 U961/net28 U961/net40 U961/net24 VSS nmos W=0.155u L=0.04u
M3174 U961/net40 N234 U961/net108 VSS nmos W=0.155u L=0.04u
M3175 U961/net40 U961/net106 U961/net104 VSS nmos W=0.155u L=0.04u
M3176 U961/net24 N226 U961/net050 VSS nmos W=0.155u L=0.04u
M3177 U961/net050 U961/net32 VSS VSS nmos W=0.155u L=0.04u
M3178 U961/net20 U961/net40 VSS VSS nmos W=0.155u L=0.04u
M3179 U961/net106 N234 VSS VSS nmos W=0.155u L=0.04u
M3180 U961/net104 N257 VSS VSS nmos W=0.155u L=0.04u
M3181 U961/net30 N226 VSS VSS nmos W=0.155u L=0.04u
M3182 U961/net108 U961/net104 VSS VSS nmos W=0.155u L=0.04u
M3183 n917 U961/net28 VSS VSS nmos W=0.155u L=0.04u
M3184 U961/net32 N218 VSS VSS nmos W=0.155u L=0.04u
M3185 U961/net64 U961/net24 VSS VSS nmos W=0.2u L=0.04u
M3186 U961/net28 U961/net40 U961/net64 VDD pmos W=0.205u L=0.04u
M3187 U961/net24 N226 U961/net32 VDD pmos W=0.205u L=0.04u
M3188 U961/net28 U961/net20 U961/net24 VDD pmos W=0.205u L=0.04u
M3189 U961/net40 U961/net106 U961/net108 VDD pmos W=0.205u L=0.04u
M3190 U961/net40 N234 U961/net104 VDD pmos W=0.205u L=0.04u
M3191 U961/net20 U961/net40 VDD VDD pmos W=0.205u L=0.04u
M3192 U961/net106 N234 VDD VDD pmos W=0.205u L=0.04u
M3193 U961/net104 N257 VDD VDD pmos W=0.205u L=0.04u
M3194 U961/net30 N226 VDD VDD pmos W=0.205u L=0.04u
M3195 U961/net108 U961/net104 VDD VDD pmos W=0.205u L=0.04u
M3196 n917 U961/net28 VDD VDD pmos W=0.205u L=0.04u
M3197 U961/net32 N218 VDD VDD pmos W=0.205u L=0.04u
M3198 U961/net64 U961/net24 VDD VDD pmos W=0.28u L=0.04u
M3199 U961/net24 U961/net30 U961/net045 VDD pmos W=0.205u L=0.04u
M3200 U961/net045 U961/net32 VDD VDD pmos W=0.205u L=0.04u
M3201 U962/net28 U962/net20 U962/net64 VSS nmos W=0.155u L=0.04u
M3202 U962/net24 U962/net30 U962/net32 VSS nmos W=0.155u L=0.04u
M3203 U962/net28 U962/net40 U962/net24 VSS nmos W=0.155u L=0.04u
M3204 U962/net40 N281 U962/net108 VSS nmos W=0.155u L=0.04u
M3205 U962/net40 U962/net106 U962/net104 VSS nmos W=0.155u L=0.04u
M3206 U962/net24 N273 U962/net050 VSS nmos W=0.155u L=0.04u
M3207 U962/net050 U962/net32 VSS VSS nmos W=0.155u L=0.04u
M3208 U962/net20 U962/net40 VSS VSS nmos W=0.155u L=0.04u
M3209 U962/net106 N281 VSS VSS nmos W=0.155u L=0.04u
M3210 U962/net104 N289 VSS VSS nmos W=0.155u L=0.04u
M3211 U962/net30 N273 VSS VSS nmos W=0.155u L=0.04u
M3212 U962/net108 U962/net104 VSS VSS nmos W=0.155u L=0.04u
M3213 n916 U962/net28 VSS VSS nmos W=0.155u L=0.04u
M3214 U962/net32 N265 VSS VSS nmos W=0.155u L=0.04u
M3215 U962/net64 U962/net24 VSS VSS nmos W=0.2u L=0.04u
M3216 U962/net28 U962/net40 U962/net64 VDD pmos W=0.205u L=0.04u
M3217 U962/net24 N273 U962/net32 VDD pmos W=0.205u L=0.04u
M3218 U962/net28 U962/net20 U962/net24 VDD pmos W=0.205u L=0.04u
M3219 U962/net40 U962/net106 U962/net108 VDD pmos W=0.205u L=0.04u
M3220 U962/net40 N281 U962/net104 VDD pmos W=0.205u L=0.04u
M3221 U962/net20 U962/net40 VDD VDD pmos W=0.205u L=0.04u
M3222 U962/net106 N281 VDD VDD pmos W=0.205u L=0.04u
M3223 U962/net104 N289 VDD VDD pmos W=0.205u L=0.04u
M3224 U962/net30 N273 VDD VDD pmos W=0.205u L=0.04u
M3225 U962/net108 U962/net104 VDD VDD pmos W=0.205u L=0.04u
M3226 n916 U962/net28 VDD VDD pmos W=0.205u L=0.04u
M3227 U962/net32 N265 VDD VDD pmos W=0.205u L=0.04u
M3228 U962/net64 U962/net24 VDD VDD pmos W=0.28u L=0.04u
M3229 U962/net24 U962/net30 U962/net045 VDD pmos W=0.205u L=0.04u
M3230 U962/net045 U962/net32 VDD VDD pmos W=0.205u L=0.04u
M3231 U963/net11 n919 U963/net17 VSS nmos W=0.155u L=0.04u
M3232 U963/net5 U963/net17 U963/net21 VSS nmos W=0.155u L=0.04u
M3233 U963/net5 N302 VSS VSS nmos W=0.155u L=0.04u
M3234 N6716 U963/net21 VSS VSS nmos W=0.155u L=0.04u
M3235 U963/net16 n919 VSS VSS nmos W=0.155u L=0.04u
M3236 U963/net11 n918 VSS VSS nmos W=0.155u L=0.04u
M3237 U963/net13 U963/net17 VSS VSS nmos W=0.155u L=0.04u
M3238 U963/net17 U963/net16 U963/XI2-net16 VSS nmos W=0.155u L=0.04u
M3239 U963/XI2-net16 U963/net11 VSS VSS nmos W=0.155u L=0.04u
M3240 U963/net21 U963/net13 U963/XU21-net16 VSS nmos W=0.155u L=0.04u
M3241 U963/XU21-net16 U963/net5 VSS VSS nmos W=0.155u L=0.04u
M3242 U963/net11 U963/net16 U963/net17 VDD pmos W=0.205u L=0.04u
M3243 U963/net5 U963/net13 U963/net21 VDD pmos W=0.205u L=0.04u
M3244 U963/net5 N302 VDD VDD pmos W=0.205u L=0.04u
M3245 N6716 U963/net21 VDD VDD pmos W=0.205u L=0.04u
M3246 U963/net16 n919 VDD VDD pmos W=0.205u L=0.04u
M3247 U963/net11 n918 VDD VDD pmos W=0.205u L=0.04u
M3248 U963/net13 U963/net17 VDD VDD pmos W=0.205u L=0.04u
M3249 U963/net17 n919 U963/XI2-net6 VDD pmos W=0.205u L=0.04u
M3250 U963/XI2-net6 U963/net11 VDD VDD pmos W=0.205u L=0.04u
M3251 U963/net21 U963/net17 U963/XU21-net6 VDD pmos W=0.205u L=0.04u
M3252 U963/XU21-net6 U963/net5 VDD VDD pmos W=0.205u L=0.04u
M3253 U964/net28 U964/net20 U964/net64 VSS nmos W=0.155u L=0.04u
M3254 U964/net24 U964/net30 U964/net32 VSS nmos W=0.155u L=0.04u
M3255 U964/net28 U964/net40 U964/net24 VSS nmos W=0.155u L=0.04u
M3256 U964/net40 N316 U964/net108 VSS nmos W=0.155u L=0.04u
M3257 U964/net40 U964/net106 U964/net104 VSS nmos W=0.155u L=0.04u
M3258 U964/net24 N308 U964/net050 VSS nmos W=0.155u L=0.04u
M3259 U964/net050 U964/net32 VSS VSS nmos W=0.155u L=0.04u
M3260 U964/net20 U964/net40 VSS VSS nmos W=0.155u L=0.04u
M3261 U964/net106 N316 VSS VSS nmos W=0.155u L=0.04u
M3262 U964/net104 N324 VSS VSS nmos W=0.155u L=0.04u
M3263 U964/net30 N308 VSS VSS nmos W=0.155u L=0.04u
M3264 U964/net108 U964/net104 VSS VSS nmos W=0.155u L=0.04u
M3265 n919 U964/net28 VSS VSS nmos W=0.155u L=0.04u
M3266 U964/net32 N293 VSS VSS nmos W=0.155u L=0.04u
M3267 U964/net64 U964/net24 VSS VSS nmos W=0.2u L=0.04u
M3268 U964/net28 U964/net40 U964/net64 VDD pmos W=0.205u L=0.04u
M3269 U964/net24 N308 U964/net32 VDD pmos W=0.205u L=0.04u
M3270 U964/net28 U964/net20 U964/net24 VDD pmos W=0.205u L=0.04u
M3271 U964/net40 U964/net106 U964/net108 VDD pmos W=0.205u L=0.04u
M3272 U964/net40 N316 U964/net104 VDD pmos W=0.205u L=0.04u
M3273 U964/net20 U964/net40 VDD VDD pmos W=0.205u L=0.04u
M3274 U964/net106 N316 VDD VDD pmos W=0.205u L=0.04u
M3275 U964/net104 N324 VDD VDD pmos W=0.205u L=0.04u
M3276 U964/net30 N308 VDD VDD pmos W=0.205u L=0.04u
M3277 U964/net108 U964/net104 VDD VDD pmos W=0.205u L=0.04u
M3278 n919 U964/net28 VDD VDD pmos W=0.205u L=0.04u
M3279 U964/net32 N293 VDD VDD pmos W=0.205u L=0.04u
M3280 U964/net64 U964/net24 VDD VDD pmos W=0.28u L=0.04u
M3281 U964/net24 U964/net30 U964/net045 VDD pmos W=0.205u L=0.04u
M3282 U964/net045 U964/net32 VDD VDD pmos W=0.205u L=0.04u
M3283 U965/net28 U965/net20 U965/net64 VSS nmos W=0.155u L=0.04u
M3284 U965/net24 U965/net30 U965/net32 VSS nmos W=0.155u L=0.04u
M3285 U965/net28 U965/net40 U965/net24 VSS nmos W=0.155u L=0.04u
M3286 U965/net40 N361 U965/net108 VSS nmos W=0.155u L=0.04u
M3287 U965/net40 U965/net106 U965/net104 VSS nmos W=0.155u L=0.04u
M3288 U965/net24 N351 U965/net050 VSS nmos W=0.155u L=0.04u
M3289 U965/net050 U965/net32 VSS VSS nmos W=0.155u L=0.04u
M3290 U965/net20 U965/net40 VSS VSS nmos W=0.155u L=0.04u
M3291 U965/net106 N361 VSS VSS nmos W=0.155u L=0.04u
M3292 U965/net104 N369 VSS VSS nmos W=0.155u L=0.04u
M3293 U965/net30 N351 VSS VSS nmos W=0.155u L=0.04u
M3294 U965/net108 U965/net104 VSS VSS nmos W=0.155u L=0.04u
M3295 n918 U965/net28 VSS VSS nmos W=0.155u L=0.04u
M3296 U965/net32 N341 VSS VSS nmos W=0.155u L=0.04u
M3297 U965/net64 U965/net24 VSS VSS nmos W=0.2u L=0.04u
M3298 U965/net28 U965/net40 U965/net64 VDD pmos W=0.205u L=0.04u
M3299 U965/net24 N351 U965/net32 VDD pmos W=0.205u L=0.04u
M3300 U965/net28 U965/net20 U965/net24 VDD pmos W=0.205u L=0.04u
M3301 U965/net40 U965/net106 U965/net108 VDD pmos W=0.205u L=0.04u
M3302 U965/net40 N361 U965/net104 VDD pmos W=0.205u L=0.04u
M3303 U965/net20 U965/net40 VDD VDD pmos W=0.205u L=0.04u
M3304 U965/net106 N361 VDD VDD pmos W=0.205u L=0.04u
M3305 U965/net104 N369 VDD VDD pmos W=0.205u L=0.04u
M3306 U965/net30 N351 VDD VDD pmos W=0.205u L=0.04u
M3307 U965/net108 U965/net104 VDD VDD pmos W=0.205u L=0.04u
M3308 n918 U965/net28 VDD VDD pmos W=0.205u L=0.04u
M3309 U965/net32 N341 VDD VDD pmos W=0.205u L=0.04u
M3310 U965/net64 U965/net24 VDD VDD pmos W=0.28u L=0.04u
M3311 U965/net24 U965/net30 U965/net045 VDD pmos W=0.205u L=0.04u
M3312 U965/net045 U965/net32 VDD VDD pmos W=0.205u L=0.04u
M3313 U966/net7 n844 U966/X_u4-net10 VSS nmos W=0.155u L=0.04u
M3314 U966/X_u4-net10 n642 U966/X_u4-net13 VSS nmos W=0.155u L=0.04u
M3315 U966/X_u4-net13 n911 VSS VSS nmos W=0.155u L=0.04u
M3316 N6648 U966/net7 VSS VSS nmos W=0.155u L=0.04u
M3317 U966/net7 n911 VDD VDD pmos W=0.205u L=0.04u
M3318 U966/net7 n844 VDD VDD pmos W=0.205u L=0.04u
M3319 U966/net7 n642 VDD VDD pmos W=0.205u L=0.04u
M3320 N6648 U966/net7 VDD VDD pmos W=0.205u L=0.04u
M3321 U967/net4 U967/net10 U967/net14 VSS nmos W=0.155u L=0.04u
M3322 U967/net6 n857 U967/net14 VSS nmos W=0.155u L=0.04u
M3323 U967/net4 n909 VSS VSS nmos W=0.155u L=0.04u
M3324 U967/net6 U967/net4 VSS VSS nmos W=0.155u L=0.04u
M3325 n911 U967/net14 VSS VSS nmos W=0.155u L=0.04u
M3326 U967/net10 n857 VSS VSS nmos W=0.155u L=0.04u
M3327 U967/net4 n857 U967/net14 VDD pmos W=0.205u L=0.04u
M3328 U967/net6 U967/net10 U967/net14 VDD pmos W=0.205u L=0.04u
M3329 U967/net4 n909 VDD VDD pmos W=0.205u L=0.04u
M3330 U967/net6 U967/net4 VDD VDD pmos W=0.205u L=0.04u
M3331 n911 U967/net14 VDD VDD pmos W=0.205u L=0.04u
M3332 U967/net10 n857 VDD VDD pmos W=0.205u L=0.04u
M3333 n909 N446 VSS VSS nmos W=0.135u L=0.04u
M3334 n909 N446 VDD VDD pmos W=0.205u L=0.04u
M3335 U969/net19 N335 VSS VSS nmos W=0.155u L=0.04u
M3336 n857 N335 U969/net40 VSS nmos W=0.155u L=0.04u
M3337 n857 U969/net19 U969/net36 VSS nmos W=0.155u L=0.04u
M3338 U969/net40 N209 VSS VSS nmos W=0.31u L=0.04u
M3339 U969/net36 N206 VSS VSS nmos W=0.155u L=0.04u
M3340 U969/net19 N335 VDD VDD pmos W=0.205u L=0.04u
M3341 n857 U969/net19 U969/net26 VDD pmos W=0.325u L=0.04u
M3342 U969/net26 N209 VDD VDD pmos W=0.41u L=0.04u
M3343 n857 N335 U969/net30 VDD pmos W=0.325u L=0.04u
M3344 U969/net30 N206 VDD VDD pmos W=0.205u L=0.04u
M3345 n642 n637 VSS VSS nmos W=0.155u L=0.04u
M3346 n642 n620 VSS VSS nmos W=0.155u L=0.04u
M3347 n642 n621 VSS VSS nmos W=0.155u L=0.04u
M3348 U970/net25 n637 VDD VDD pmos W=0.41u L=0.04u
M3349 U970/net28 n620 U970/net25 VDD pmos W=0.41u L=0.04u
M3350 n642 n621 U970/net28 VDD pmos W=0.41u L=0.04u
M3351 U971/net4 n858 U971/net14 VSS nmos W=0.155u L=0.04u
M3352 U971/net6 U971/net10 U971/net14 VSS nmos W=0.17u L=0.04u
M3353 U971/net4 n913 VSS VSS nmos W=0.155u L=0.04u
M3354 U971/net6 U971/net4 VSS VSS nmos W=0.17u L=0.04u
M3355 n637 U971/net14 VSS VSS nmos W=0.155u L=0.04u
M3356 U971/net10 n858 VSS VSS nmos W=0.155u L=0.04u
M3357 U971/net4 U971/net10 U971/net14 VDD pmos W=0.255u L=0.04u
M3358 U971/net6 n858 U971/net14 VDD pmos W=0.28u L=0.04u
M3359 U971/net4 n913 VDD VDD pmos W=0.205u L=0.04u
M3360 U971/net6 U971/net4 VDD VDD pmos W=0.24u L=0.04u
M3361 n637 U971/net14 VDD VDD pmos W=0.205u L=0.04u
M3362 U971/net10 n858 VDD VDD pmos W=0.205u L=0.04u
M3363 n913 N435 VSS VSS nmos W=0.135u L=0.04u
M3364 n913 N435 VDD VDD pmos W=0.205u L=0.04u
M3365 U973/net19 N335 VSS VSS nmos W=0.155u L=0.04u
M3366 n858 N335 U973/net40 VSS nmos W=0.155u L=0.04u
M3367 n858 U973/net19 U973/net36 VSS nmos W=0.155u L=0.04u
M3368 U973/net40 N241 VSS VSS nmos W=0.31u L=0.04u
M3369 U973/net36 N234 VSS VSS nmos W=0.155u L=0.04u
M3370 U973/net19 N335 VDD VDD pmos W=0.205u L=0.04u
M3371 n858 U973/net19 U973/net26 VDD pmos W=0.325u L=0.04u
M3372 U973/net26 N241 VDD VDD pmos W=0.41u L=0.04u
M3373 n858 N335 U973/net30 VDD pmos W=0.325u L=0.04u
M3374 U973/net30 N234 VDD VDD pmos W=0.205u L=0.04u
M3375 n620 N389 U974/net15 VSS nmos W=0.155u L=0.04u
M3376 n620 n859 U974/net15 VSS nmos W=0.155u L=0.04u
M3377 U974/net15 n882 VSS VSS nmos W=0.155u L=0.04u
M3378 n620 n882 VDD VDD pmos W=0.205u L=0.04u
M3379 n620 N389 U974/XI16-net11 VDD pmos W=0.205u L=0.04u
M3380 U974/XI16-net11 n859 VDD VDD pmos W=0.205u L=0.04u
M3381 U975/XU1-net6 N389 VSS VSS nmos W=0.155u L=0.04u
M3382 n882 n859 U975/XU1-net6 VSS nmos W=0.155u L=0.04u
M3383 n882 N389 VDD VDD pmos W=0.155u L=0.04u
M3384 n882 n859 VDD VDD pmos W=0.155u L=0.04u
M3385 n859 U976/net28 VSS VSS nmos W=0.155u L=0.04u
M3386 U976/net47 N257 VSS VSS nmos W=0.155u L=0.04u
M3387 U976/net28 U976/net6 U976/net47 VSS nmos W=0.155u L=0.04u
M3388 U976/net44 N264 VSS VSS nmos W=0.155u L=0.04u
M3389 U976/net28 N335 U976/net44 VSS nmos W=0.155u L=0.04u
M3390 U976/net6 N335 VSS VSS nmos W=0.155u L=0.04u
M3391 n859 U976/net28 VDD VDD pmos W=0.205u L=0.04u
M3392 VDD N257 U976/net47 VDD pmos W=0.205u L=0.04u
M3393 U976/net47 N335 U976/net28 VDD pmos W=0.205u L=0.04u
M3394 U976/net44 U976/net6 U976/net28 VDD pmos W=0.205u L=0.04u
M3395 VDD N264 U976/net44 VDD pmos W=0.205u L=0.04u
M3396 VDD N335 U976/net6 VDD pmos W=0.205u L=0.04u
M3397 U977/XU1-net6 n636 VSS VSS nmos W=0.155u L=0.04u
M3398 n621 n623 U977/XU1-net6 VSS nmos W=0.155u L=0.04u
M3399 n621 n636 VDD VDD pmos W=0.155u L=0.04u
M3400 n621 n623 VDD VDD pmos W=0.155u L=0.04u
M3401 U978/net4 U978/net10 U978/net14 VSS nmos W=0.155u L=0.04u
M3402 U978/net6 n861 U978/net14 VSS nmos W=0.155u L=0.04u
M3403 U978/net4 n883 VSS VSS nmos W=0.155u L=0.04u
M3404 U978/net6 U978/net4 VSS VSS nmos W=0.155u L=0.04u
M3405 n636 U978/net14 VSS VSS nmos W=0.155u L=0.04u
M3406 U978/net10 n861 VSS VSS nmos W=0.155u L=0.04u
M3407 U978/net4 n861 U978/net14 VDD pmos W=0.205u L=0.04u
M3408 U978/net6 U978/net10 U978/net14 VDD pmos W=0.205u L=0.04u
M3409 U978/net4 n883 VDD VDD pmos W=0.205u L=0.04u
M3410 U978/net6 U978/net4 VDD VDD pmos W=0.205u L=0.04u
M3411 n636 U978/net14 VDD VDD pmos W=0.205u L=0.04u
M3412 U978/net10 n861 VDD VDD pmos W=0.205u L=0.04u
M3413 n883 N400 VSS VSS nmos W=0.135u L=0.04u
M3414 n883 N400 VDD VDD pmos W=0.205u L=0.04u
M3415 U980/net19 N335 VSS VSS nmos W=0.155u L=0.04u
M3416 n861 N335 U980/net40 VSS nmos W=0.155u L=0.04u
M3417 n861 U980/net19 U980/net36 VSS nmos W=0.155u L=0.04u
M3418 U980/net40 N272 VSS VSS nmos W=0.31u L=0.04u
M3419 U980/net36 N265 VSS VSS nmos W=0.155u L=0.04u
M3420 U980/net19 N335 VDD VDD pmos W=0.205u L=0.04u
M3421 n861 U980/net19 U980/net26 VDD pmos W=0.325u L=0.04u
M3422 U980/net26 N272 VDD VDD pmos W=0.41u L=0.04u
M3423 n861 N335 U980/net30 VDD pmos W=0.325u L=0.04u
M3424 U980/net30 N265 VDD VDD pmos W=0.205u L=0.04u
M3425 n623 n618 VSS VSS nmos W=0.155u L=0.04u
M3426 n623 n635 VSS VSS nmos W=0.155u L=0.04u
M3427 U981/XI1-net8 n635 VDD VDD pmos W=0.205u L=0.04u
M3428 n623 n618 U981/XI1-net8 VDD pmos W=0.205u L=0.04u
M3429 n635 n875 VSS VSS nmos W=0.135u L=0.04u
M3430 n635 n875 VDD VDD pmos W=0.205u L=0.04u
M3431 U983/net4 U983/net10 U983/net14 VSS nmos W=0.155u L=0.04u
M3432 U983/net6 n850 U983/net14 VSS nmos W=0.155u L=0.04u
M3433 U983/net4 n915 VSS VSS nmos W=0.155u L=0.04u
M3434 U983/net6 U983/net4 VSS VSS nmos W=0.155u L=0.04u
M3435 n875 U983/net14 VSS VSS nmos W=0.155u L=0.04u
M3436 U983/net10 n850 VSS VSS nmos W=0.155u L=0.04u
M3437 U983/net4 n850 U983/net14 VDD pmos W=0.205u L=0.04u
M3438 U983/net6 U983/net10 U983/net14 VDD pmos W=0.205u L=0.04u
M3439 U983/net4 n915 VDD VDD pmos W=0.205u L=0.04u
M3440 U983/net6 U983/net4 VDD VDD pmos W=0.205u L=0.04u
M3441 n875 U983/net14 VDD VDD pmos W=0.205u L=0.04u
M3442 U983/net10 n850 VDD VDD pmos W=0.205u L=0.04u
M3443 n915 N411 VSS VSS nmos W=0.135u L=0.04u
M3444 n915 N411 VDD VDD pmos W=0.205u L=0.04u
M3445 U985/net19 N335 VSS VSS nmos W=0.155u L=0.04u
M3446 n850 N335 U985/net40 VSS nmos W=0.155u L=0.04u
M3447 n850 U985/net19 U985/net36 VSS nmos W=0.155u L=0.04u
M3448 U985/net40 N280 VSS VSS nmos W=0.31u L=0.04u
M3449 U985/net36 N273 VSS VSS nmos W=0.155u L=0.04u
M3450 U985/net19 N335 VDD VDD pmos W=0.205u L=0.04u
M3451 n850 U985/net19 U985/net26 VDD pmos W=0.325u L=0.04u
M3452 U985/net26 N280 VDD VDD pmos W=0.41u L=0.04u
M3453 n850 N335 U985/net30 VDD pmos W=0.325u L=0.04u
M3454 U985/net30 N273 VDD VDD pmos W=0.205u L=0.04u
M3455 n618 n633 VSS VSS nmos W=0.135u L=0.04u
M3456 n618 n633 VDD VDD pmos W=0.205u L=0.04u
M3457 n633 n627 VSS VSS nmos W=0.155u L=0.04u
M3458 n633 n617 VSS VSS nmos W=0.155u L=0.04u
M3459 U987/XI1-net8 n617 VDD VDD pmos W=0.205u L=0.04u
M3460 n633 n627 U987/XI1-net8 VDD pmos W=0.205u L=0.04u
M3461 n617 U988/net6 VSS VSS nmos W=0.155u L=0.04u
M3462 U988/X_u2-net6 n920 VSS VSS nmos W=0.155u L=0.04u
M3463 U988/net6 n860 U988/X_u2-net6 VSS nmos W=0.155u L=0.04u
M3464 n617 U988/net6 VDD VDD pmos W=0.205u L=0.04u
M3465 U988/net6 n920 VDD VDD pmos W=0.205u L=0.04u
M3466 U988/net6 n860 VDD VDD pmos W=0.205u L=0.04u
M3467 n627 n860 VSS VSS nmos W=0.155u L=0.04u
M3468 n627 n920 VSS VSS nmos W=0.155u L=0.04u
M3469 U989/XI1-net8 n920 VDD VDD pmos W=0.205u L=0.04u
M3470 n627 n860 U989/XI1-net8 VDD pmos W=0.205u L=0.04u
M3471 n920 N374 VSS VSS nmos W=0.135u L=0.04u
M3472 n920 N374 VDD VDD pmos W=0.205u L=0.04u
M3473 U991/net19 N335 VSS VSS nmos W=0.155u L=0.04u
M3474 n860 N335 U991/net40 VSS nmos W=0.155u L=0.04u
M3475 n860 U991/net19 U991/net36 VSS nmos W=0.155u L=0.04u
M3476 U991/net40 N288 VSS VSS nmos W=0.31u L=0.04u
M3477 U991/net36 N281 VSS VSS nmos W=0.155u L=0.04u
M3478 U991/net19 N335 VDD VDD pmos W=0.205u L=0.04u
M3479 n860 U991/net19 U991/net26 VDD pmos W=0.325u L=0.04u
M3480 U991/net26 N288 VDD VDD pmos W=0.41u L=0.04u
M3481 n860 N335 U991/net30 VDD pmos W=0.325u L=0.04u
M3482 U991/net30 N281 VDD VDD pmos W=0.205u L=0.04u
M3483 U992/net7 n658 U992/X_u4-net10 VSS nmos W=0.155u L=0.04u
M3484 U992/X_u4-net10 n651 U992/X_u4-net13 VSS nmos W=0.155u L=0.04u
M3485 U992/X_u4-net13 n662 VSS VSS nmos W=0.155u L=0.04u
M3486 n844 U992/net7 VSS VSS nmos W=0.155u L=0.04u
M3487 U992/net7 n662 VDD VDD pmos W=0.205u L=0.04u
M3488 U992/net7 n658 VDD VDD pmos W=0.205u L=0.04u
M3489 U992/net7 n651 VDD VDD pmos W=0.205u L=0.04u
M3490 n844 U992/net7 VDD VDD pmos W=0.205u L=0.04u
M3491 n662 n652 VSS VSS nmos W=0.155u L=0.04u
M3492 n662 n663 VSS VSS nmos W=0.155u L=0.04u
M3493 U993/XI1-net8 n663 VDD VDD pmos W=0.205u L=0.04u
M3494 n662 n652 U993/XI1-net8 VDD pmos W=0.205u L=0.04u
M3495 n663 n842 VSS VSS nmos W=0.135u L=0.04u
M3496 n663 n842 VDD VDD pmos W=0.205u L=0.04u
M3497 U995/XU1-net6 n921 VSS VSS nmos W=0.155u L=0.04u
M3498 n842 n853 U995/XU1-net6 VSS nmos W=0.155u L=0.04u
M3499 n842 n921 VDD VDD pmos W=0.155u L=0.04u
M3500 n842 n853 VDD VDD pmos W=0.155u L=0.04u
M3501 n652 n853 VSS VSS nmos W=0.155u L=0.04u
M3502 n652 n921 VSS VSS nmos W=0.155u L=0.04u
M3503 U996/XI1-net8 n921 VDD VDD pmos W=0.205u L=0.04u
M3504 n652 n853 U996/XI1-net8 VDD pmos W=0.205u L=0.04u
M3505 n921 N422 VSS VSS nmos W=0.135u L=0.04u
M3506 n921 N422 VDD VDD pmos W=0.205u L=0.04u
M3507 U998/net19 N335 VSS VSS nmos W=0.155u L=0.04u
M3508 n853 N335 U998/net40 VSS nmos W=0.155u L=0.04u
M3509 n853 U998/net19 U998/net36 VSS nmos W=0.155u L=0.04u
M3510 U998/net40 N233 VSS VSS nmos W=0.31u L=0.04u
M3511 U998/net36 N226 VSS VSS nmos W=0.155u L=0.04u
M3512 U998/net19 N335 VDD VDD pmos W=0.205u L=0.04u
M3513 n853 U998/net19 U998/net26 VDD pmos W=0.325u L=0.04u
M3514 U998/net26 N233 VDD VDD pmos W=0.41u L=0.04u
M3515 n853 N335 U998/net30 VDD pmos W=0.325u L=0.04u
M3516 U998/net30 N226 VDD VDD pmos W=0.205u L=0.04u
M3517 U999/net14 n852 U999/net20 VSS nmos W=0.155u L=0.04u
M3518 U999/net14 N468 U999/net20 VSS nmos W=0.155u L=0.04u
M3519 U999/net20 n912 VSS VSS nmos W=0.155u L=0.04u
M3520 n651 U999/net14 VSS VSS nmos W=0.155u L=0.04u
M3521 n651 U999/net14 VDD VDD pmos W=0.205u L=0.04u
M3522 U999/net14 n912 VDD VDD pmos W=0.205u L=0.04u
M3523 U999/net24 n852 VDD VDD pmos W=0.205u L=0.04u
M3524 U999/net14 N468 U999/net24 VDD pmos W=0.205u L=0.04u
M3525 U1000/XU1-net6 N468 VSS VSS nmos W=0.155u L=0.04u
M3526 n912 n852 U1000/XU1-net6 VSS nmos W=0.155u L=0.04u
M3527 n912 N468 VDD VDD pmos W=0.155u L=0.04u
M3528 n912 n852 VDD VDD pmos W=0.155u L=0.04u
M3529 n852 U1001/net28 VSS VSS nmos W=0.155u L=0.04u
M3530 U1001/net47 N218 VSS VSS nmos W=0.155u L=0.04u
M3531 U1001/net28 U1001/net6 U1001/net47 VSS nmos W=0.155u L=0.04u
M3532 U1001/net44 N225 VSS VSS nmos W=0.155u L=0.04u
M3533 U1001/net28 N335 U1001/net44 VSS nmos W=0.155u L=0.04u
M3534 U1001/net6 N335 VSS VSS nmos W=0.155u L=0.04u
M3535 n852 U1001/net28 VDD VDD pmos W=0.205u L=0.04u
M3536 VDD N218 U1001/net47 VDD pmos W=0.205u L=0.04u
M3537 U1001/net47 N335 U1001/net28 VDD pmos W=0.205u L=0.04u
M3538 U1001/net44 U1001/net6 U1001/net28 VDD pmos W=0.205u L=0.04u
M3539 VDD N225 U1001/net44 VDD pmos W=0.205u L=0.04u
M3540 VDD N335 U1001/net6 VDD pmos W=0.205u L=0.04u
M3541 U1002/net4 U1002/net10 U1002/net14 VSS nmos W=0.155u L=0.04u
M3542 U1002/net6 n660 U1002/net14 VSS nmos W=0.155u L=0.04u
M3543 U1002/net4 n659 VSS VSS nmos W=0.155u L=0.04u
M3544 U1002/net6 U1002/net4 VSS VSS nmos W=0.155u L=0.04u
M3545 n658 U1002/net14 VSS VSS nmos W=0.155u L=0.04u
M3546 U1002/net10 n660 VSS VSS nmos W=0.155u L=0.04u
M3547 U1002/net4 n660 U1002/net14 VDD pmos W=0.205u L=0.04u
M3548 U1002/net6 U1002/net10 U1002/net14 VDD pmos W=0.205u L=0.04u
M3549 U1002/net4 n659 VDD VDD pmos W=0.205u L=0.04u
M3550 U1002/net6 U1002/net4 VDD VDD pmos W=0.205u L=0.04u
M3551 n658 U1002/net14 VDD VDD pmos W=0.205u L=0.04u
M3552 U1002/net10 n660 VDD VDD pmos W=0.205u L=0.04u
M3553 n659 N457 VSS VSS nmos W=0.135u L=0.04u
M3554 n659 N457 VDD VDD pmos W=0.205u L=0.04u
M3555 U1004/net19 N335 VSS VSS nmos W=0.155u L=0.04u
M3556 n660 N335 U1004/net40 VSS nmos W=0.155u L=0.04u
M3557 n660 U1004/net19 U1004/net36 VSS nmos W=0.155u L=0.04u
M3558 U1004/net40 N217 VSS VSS nmos W=0.31u L=0.04u
M3559 U1004/net36 N210 VSS VSS nmos W=0.155u L=0.04u
M3560 U1004/net19 N335 VDD VDD pmos W=0.205u L=0.04u
M3561 n660 U1004/net19 U1004/net26 VDD pmos W=0.325u L=0.04u
M3562 U1004/net26 N217 VDD VDD pmos W=0.41u L=0.04u
M3563 n660 N335 U1004/net30 VDD pmos W=0.325u L=0.04u
M3564 U1004/net30 N210 VDD VDD pmos W=0.205u L=0.04u
M3565 N6646 U1005/net6 VSS VSS nmos W=0.155u L=0.04u
M3566 U1005/net6 n701 U1005/XU30-net23 VSS nmos W=0.155u L=0.04u
M3567 U1005/XU30-net23 n821 U1005/XU30-net26 VSS nmos W=0.155u L=0.04u
M3568 U1005/XU30-net26 n777 U1005/XU30-net29 VSS nmos W=0.155u L=0.04u
M3569 U1005/XU30-net29 n900 VSS VSS nmos W=0.155u L=0.04u
M3570 N6646 U1005/net6 VDD VDD pmos W=0.205u L=0.04u
M3571 U1005/net6 n900 VDD VDD pmos W=0.205u L=0.04u
M3572 U1005/net6 n777 VDD VDD pmos W=0.205u L=0.04u
M3573 U1005/net6 n821 VDD VDD pmos W=0.205u L=0.04u
M3574 U1005/net6 n701 VDD VDD pmos W=0.205u L=0.04u
M3575 n900 n713 VSS VSS nmos W=0.135u L=0.04u
M3576 n900 n713 VDD VDD pmos W=0.205u L=0.04u
M3577 U1007/XU1-net6 n712 VSS VSS nmos W=0.155u L=0.04u
M3578 n713 n711 U1007/XU1-net6 VSS nmos W=0.155u L=0.04u
M3579 n713 n712 VDD VDD pmos W=0.155u L=0.04u
M3580 n713 n711 VDD VDD pmos W=0.155u L=0.04u
M3581 n712 n704 VSS VSS nmos W=0.155u L=0.04u
M3582 n712 n707 VSS VSS nmos W=0.155u L=0.04u
M3583 U1008/XI1-net8 n707 VDD VDD pmos W=0.205u L=0.04u
M3584 n712 n704 U1008/XI1-net8 VDD pmos W=0.205u L=0.04u
M3585 n707 n829 VSS VSS nmos W=0.135u L=0.04u
M3586 n707 n829 VDD VDD pmos W=0.205u L=0.04u
M3587 U1010/XU1-net6 n922 VSS VSS nmos W=0.155u L=0.04u
M3588 n829 n870 U1010/XU1-net6 VSS nmos W=0.155u L=0.04u
M3589 n829 n922 VDD VDD pmos W=0.155u L=0.04u
M3590 n829 n870 VDD VDD pmos W=0.155u L=0.04u
M3591 n704 n870 VSS VSS nmos W=0.155u L=0.04u
M3592 n704 n922 VSS VSS nmos W=0.155u L=0.04u
M3593 U1011/XI1-net8 n922 VDD VDD pmos W=0.205u L=0.04u
M3594 n704 n870 U1011/XI1-net8 VDD pmos W=0.205u L=0.04u
M3595 n922 N490 VSS VSS nmos W=0.135u L=0.04u
M3596 n922 N490 VDD VDD pmos W=0.205u L=0.04u
M3597 U1013/net19 N332 VSS VSS nmos W=0.155u L=0.04u
M3598 n870 N332 U1013/net40 VSS nmos W=0.155u L=0.04u
M3599 n870 U1013/net19 U1013/net36 VSS nmos W=0.155u L=0.04u
M3600 U1013/net40 N323 VSS VSS nmos W=0.31u L=0.04u
M3601 U1013/net36 N316 VSS VSS nmos W=0.155u L=0.04u
M3602 U1013/net19 N332 VDD VDD pmos W=0.205u L=0.04u
M3603 n870 U1013/net19 U1013/net26 VDD pmos W=0.325u L=0.04u
M3604 U1013/net26 N323 VDD VDD pmos W=0.41u L=0.04u
M3605 n870 N332 U1013/net30 VDD pmos W=0.325u L=0.04u
M3606 U1013/net30 N316 VDD VDD pmos W=0.205u L=0.04u
M3607 U1014/net14 n862 U1014/net20 VSS nmos W=0.155u L=0.04u
M3608 U1014/net14 N479 U1014/net20 VSS nmos W=0.155u L=0.04u
M3609 U1014/net20 n905 VSS VSS nmos W=0.155u L=0.04u
M3610 n711 U1014/net14 VSS VSS nmos W=0.155u L=0.04u
M3611 n711 U1014/net14 VDD VDD pmos W=0.205u L=0.04u
M3612 U1014/net14 n905 VDD VDD pmos W=0.205u L=0.04u
M3613 U1014/net24 n862 VDD VDD pmos W=0.205u L=0.04u
M3614 U1014/net14 N479 U1014/net24 VDD pmos W=0.205u L=0.04u
M3615 U1015/XU1-net6 N479 VSS VSS nmos W=0.155u L=0.04u
M3616 n905 n862 U1015/XU1-net6 VSS nmos W=0.155u L=0.04u
M3617 n905 N479 VDD VDD pmos W=0.155u L=0.04u
M3618 n905 n862 VDD VDD pmos W=0.155u L=0.04u
M3619 n862 U1016/net28 VSS VSS nmos W=0.155u L=0.04u
M3620 U1016/net47 N308 VSS VSS nmos W=0.155u L=0.04u
M3621 U1016/net28 U1016/net6 U1016/net47 VSS nmos W=0.155u L=0.04u
M3622 U1016/net44 N315 VSS VSS nmos W=0.155u L=0.04u
M3623 U1016/net28 N332 U1016/net44 VSS nmos W=0.155u L=0.04u
M3624 U1016/net6 N332 VSS VSS nmos W=0.155u L=0.04u
M3625 n862 U1016/net28 VDD VDD pmos W=0.205u L=0.04u
M3626 VDD N308 U1016/net47 VDD pmos W=0.205u L=0.04u
M3627 U1016/net47 N332 U1016/net28 VDD pmos W=0.205u L=0.04u
M3628 U1016/net44 U1016/net6 U1016/net28 VDD pmos W=0.205u L=0.04u
M3629 VDD N315 U1016/net44 VDD pmos W=0.205u L=0.04u
M3630 VDD N332 U1016/net6 VDD pmos W=0.205u L=0.04u
M3631 U1017/net19 N332 VSS VSS nmos W=0.155u L=0.04u
M3632 n777 N332 U1017/net40 VSS nmos W=0.155u L=0.04u
M3633 n777 U1017/net19 U1017/net36 VSS nmos W=0.155u L=0.04u
M3634 U1017/net40 N299 VSS VSS nmos W=0.31u L=0.04u
M3635 U1017/net36 N293 VSS VSS nmos W=0.155u L=0.04u
M3636 U1017/net19 N332 VDD VDD pmos W=0.205u L=0.04u
M3637 n777 U1017/net19 U1017/net26 VDD pmos W=0.325u L=0.04u
M3638 U1017/net26 N299 VDD VDD pmos W=0.41u L=0.04u
M3639 n777 N332 U1017/net30 VDD pmos W=0.325u L=0.04u
M3640 U1017/net30 N293 VDD VDD pmos W=0.205u L=0.04u
M3641 U1018/net19 N332 VSS VSS nmos W=0.155u L=0.04u
M3642 n821 N332 U1018/net40 VSS nmos W=0.155u L=0.04u
M3643 n821 U1018/net19 U1018/net36 VSS nmos W=0.155u L=0.04u
M3644 U1018/net40 N307 VSS VSS nmos W=0.31u L=0.04u
M3645 U1018/net36 N302 VSS VSS nmos W=0.155u L=0.04u
M3646 U1018/net19 N332 VDD VDD pmos W=0.205u L=0.04u
M3647 n821 U1018/net19 U1018/net26 VDD pmos W=0.325u L=0.04u
M3648 U1018/net26 N307 VDD VDD pmos W=0.41u L=0.04u
M3649 n821 N332 U1018/net30 VDD pmos W=0.325u L=0.04u
M3650 U1018/net30 N302 VDD VDD pmos W=0.205u L=0.04u
M3651 n701 n907 VSS VSS nmos W=0.155u L=0.04u
M3652 n701 n695 VSS VSS nmos W=0.155u L=0.04u
M3653 n701 n686 VSS VSS nmos W=0.155u L=0.04u
M3654 U1019/net25 n907 VDD VDD pmos W=0.41u L=0.04u
M3655 U1019/net28 n695 U1019/net25 VDD pmos W=0.41u L=0.04u
M3656 n701 n686 U1019/net28 VDD pmos W=0.41u L=0.04u
M3657 n907 n688 VSS VSS nmos W=0.135u L=0.04u
M3658 n907 n688 VDD VDD pmos W=0.205u L=0.04u
M3659 n688 n717 VSS VSS nmos W=0.155u L=0.04u
M3660 n688 n694 VSS VSS nmos W=0.155u L=0.04u
M3661 U1021/XI1-net8 n694 VDD VDD pmos W=0.205u L=0.04u
M3662 n688 n717 U1021/XI1-net8 VDD pmos W=0.205u L=0.04u
M3663 n694 N523 U1022/net15 VSS nmos W=0.155u L=0.04u
M3664 n694 n866 U1022/net15 VSS nmos W=0.155u L=0.04u
M3665 U1022/net15 n715 VSS VSS nmos W=0.155u L=0.04u
M3666 n694 n715 VDD VDD pmos W=0.205u L=0.04u
M3667 n694 N523 U1022/XI16-net11 VDD pmos W=0.205u L=0.04u
M3668 U1022/XI16-net11 n866 VDD VDD pmos W=0.205u L=0.04u
M3669 U1023/XU1-net6 n866 VSS VSS nmos W=0.155u L=0.04u
M3670 n715 N523 U1023/XU1-net6 VSS nmos W=0.155u L=0.04u
M3671 n715 n866 VDD VDD pmos W=0.155u L=0.04u
M3672 n715 N523 VDD VDD pmos W=0.155u L=0.04u
M3673 n866 U1024/net28 VSS VSS nmos W=0.155u L=0.04u
M3674 U1024/net47 N341 VSS VSS nmos W=0.155u L=0.04u
M3675 U1024/net28 U1024/net6 U1024/net47 VSS nmos W=0.155u L=0.04u
M3676 U1024/net44 N348 VSS VSS nmos W=0.155u L=0.04u
M3677 U1024/net28 N332 U1024/net44 VSS nmos W=0.155u L=0.04u
M3678 U1024/net6 N332 VSS VSS nmos W=0.155u L=0.04u
M3679 n866 U1024/net28 VDD VDD pmos W=0.205u L=0.04u
M3680 VDD N341 U1024/net47 VDD pmos W=0.205u L=0.04u
M3681 U1024/net47 N332 U1024/net28 VDD pmos W=0.205u L=0.04u
M3682 U1024/net44 U1024/net6 U1024/net28 VDD pmos W=0.205u L=0.04u
M3683 VDD N348 U1024/net44 VDD pmos W=0.205u L=0.04u
M3684 VDD N332 U1024/net6 VDD pmos W=0.205u L=0.04u
M3685 n717 N514 U1025/net15 VSS nmos W=0.155u L=0.04u
M3686 n717 n868 U1025/net15 VSS nmos W=0.155u L=0.04u
M3687 U1025/net15 n893 VSS VSS nmos W=0.155u L=0.04u
M3688 n717 n893 VDD VDD pmos W=0.205u L=0.04u
M3689 n717 N514 U1025/XI16-net11 VDD pmos W=0.205u L=0.04u
M3690 U1025/XI16-net11 n868 VDD VDD pmos W=0.205u L=0.04u
M3691 U1026/XU1-net6 n868 VSS VSS nmos W=0.155u L=0.04u
M3692 n893 N514 U1026/XU1-net6 VSS nmos W=0.155u L=0.04u
M3693 n893 n868 VDD VDD pmos W=0.155u L=0.04u
M3694 n893 N514 VDD VDD pmos W=0.155u L=0.04u
M3695 U1027/XU1-net6 N1144 VSS VSS nmos W=0.155u L=0.04u
M3696 n868 N332 U1027/XU1-net6 VSS nmos W=0.155u L=0.04u
M3697 n868 N1144 VDD VDD pmos W=0.155u L=0.04u
M3698 n868 N332 VDD VDD pmos W=0.155u L=0.04u
M3699 U1028/XU1-net6 n904 VSS VSS nmos W=0.155u L=0.04u
M3700 n695 n894 U1028/XU1-net6 VSS nmos W=0.155u L=0.04u
M3701 n695 n904 VDD VDD pmos W=0.155u L=0.04u
M3702 n695 n894 VDD VDD pmos W=0.155u L=0.04u
M3703 U1029/net19 N332 VSS VSS nmos W=0.155u L=0.04u
M3704 n904 N332 U1029/net40 VSS nmos W=0.155u L=0.04u
M3705 n904 U1029/net19 U1029/net36 VSS nmos W=0.155u L=0.04u
M3706 U1029/net40 N366 VSS VSS nmos W=0.31u L=0.04u
M3707 U1029/net36 N361 VSS VSS nmos W=0.155u L=0.04u
M3708 U1029/net19 N332 VDD VDD pmos W=0.205u L=0.04u
M3709 n904 U1029/net19 U1029/net26 VDD pmos W=0.325u L=0.04u
M3710 U1029/net26 N366 VDD VDD pmos W=0.41u L=0.04u
M3711 n904 N332 U1029/net30 VDD pmos W=0.325u L=0.04u
M3712 U1029/net30 N361 VDD VDD pmos W=0.205u L=0.04u
M3713 U1030/net4 U1030/net10 U1030/net14 VSS nmos W=0.155u L=0.04u
M3714 U1030/net6 n867 U1030/net14 VSS nmos W=0.155u L=0.04u
M3715 U1030/net4 n908 VSS VSS nmos W=0.155u L=0.04u
M3716 U1030/net6 U1030/net4 VSS VSS nmos W=0.155u L=0.04u
M3717 n894 U1030/net14 VSS VSS nmos W=0.155u L=0.04u
M3718 U1030/net10 n867 VSS VSS nmos W=0.155u L=0.04u
M3719 U1030/net4 n867 U1030/net14 VDD pmos W=0.205u L=0.04u
M3720 U1030/net6 U1030/net10 U1030/net14 VDD pmos W=0.205u L=0.04u
M3721 U1030/net4 n908 VDD VDD pmos W=0.205u L=0.04u
M3722 U1030/net6 U1030/net4 VDD VDD pmos W=0.205u L=0.04u
M3723 n894 U1030/net14 VDD VDD pmos W=0.205u L=0.04u
M3724 U1030/net10 n867 VDD VDD pmos W=0.205u L=0.04u
M3725 n908 N534 VSS VSS nmos W=0.135u L=0.04u
M3726 n908 N534 VDD VDD pmos W=0.205u L=0.04u
M3727 U1032/net19 N332 VSS VSS nmos W=0.155u L=0.04u
M3728 n867 N332 U1032/net40 VSS nmos W=0.155u L=0.04u
M3729 n867 U1032/net19 U1032/net36 VSS nmos W=0.155u L=0.04u
M3730 U1032/net40 N358 VSS VSS nmos W=0.31u L=0.04u
M3731 U1032/net36 N351 VSS VSS nmos W=0.155u L=0.04u
M3732 U1032/net19 N332 VDD VDD pmos W=0.205u L=0.04u
M3733 n867 U1032/net19 U1032/net26 VDD pmos W=0.325u L=0.04u
M3734 U1032/net26 N358 VDD VDD pmos W=0.41u L=0.04u
M3735 n867 N332 U1032/net30 VDD pmos W=0.325u L=0.04u
M3736 U1032/net30 N351 VDD VDD pmos W=0.205u L=0.04u
M3737 n686 n696 VSS VSS nmos W=0.135u L=0.04u
M3738 n686 n696 VDD VDD pmos W=0.205u L=0.04u
M3739 U1034/net4 U1034/net10 U1034/net14 VSS nmos W=0.155u L=0.04u
M3740 U1034/net6 n869 U1034/net14 VSS nmos W=0.155u L=0.04u
M3741 U1034/net4 n906 VSS VSS nmos W=0.155u L=0.04u
M3742 U1034/net6 U1034/net4 VSS VSS nmos W=0.155u L=0.04u
M3743 n696 U1034/net14 VSS VSS nmos W=0.155u L=0.04u
M3744 U1034/net10 n869 VSS VSS nmos W=0.155u L=0.04u
M3745 U1034/net4 n869 U1034/net14 VDD pmos W=0.205u L=0.04u
M3746 U1034/net6 U1034/net10 U1034/net14 VDD pmos W=0.205u L=0.04u
M3747 U1034/net4 n906 VDD VDD pmos W=0.205u L=0.04u
M3748 U1034/net6 U1034/net4 VDD VDD pmos W=0.205u L=0.04u
M3749 n696 U1034/net14 VDD VDD pmos W=0.205u L=0.04u
M3750 U1034/net10 n869 VDD VDD pmos W=0.205u L=0.04u
M3751 n906 N503 VSS VSS nmos W=0.135u L=0.04u
M3752 n906 N503 VDD VDD pmos W=0.205u L=0.04u
M3753 U1036/net19 N332 VSS VSS nmos W=0.155u L=0.04u
M3754 n869 N332 U1036/net40 VSS nmos W=0.155u L=0.04u
M3755 n869 U1036/net19 U1036/net36 VSS nmos W=0.155u L=0.04u
M3756 U1036/net40 N331 VSS VSS nmos W=0.31u L=0.04u
M3757 U1036/net36 N324 VSS VSS nmos W=0.155u L=0.04u
M3758 U1036/net19 N332 VDD VDD pmos W=0.205u L=0.04u
M3759 n869 U1036/net19 U1036/net26 VDD pmos W=0.325u L=0.04u
M3760 U1036/net26 N331 VDD VDD pmos W=0.41u L=0.04u
M3761 n869 N332 U1036/net30 VDD pmos W=0.325u L=0.04u
M3762 U1036/net30 N324 VDD VDD pmos W=0.205u L=0.04u
M3763 N5388 n878 VSS VSS nmos W=0.155u L=0.04u
M3764 N5388 n761 VSS VSS nmos W=0.155u L=0.04u
M3765 N5388 n924 VSS VSS nmos W=0.155u L=0.04u
M3766 N5388 n923 VSS VSS nmos W=0.155u L=0.04u
M3767 U1037/net49 n761 U1037/net52 VDD pmos W=0.41u L=0.04u
M3768 U1037/net52 n878 VDD VDD pmos W=0.41u L=0.04u
M3769 U1037/net46 n924 U1037/net49 VDD pmos W=0.41u L=0.04u
M3770 N5388 n923 U1037/net46 VDD pmos W=0.41u L=0.04u
M3771 U1038/net24 N257 VSS VSS nmos W=0.155u L=0.04u
M3772 U1038/net74 N595 VSS VSS nmos W=0.155u L=0.04u
M3773 U1038/net72 N596 VSS VSS nmos W=0.155u L=0.04u
M3774 U1038/net76 n926 VSS VSS nmos W=0.31u L=0.04u
M3775 U1038/net044 N389 VSS VSS nmos W=0.155u L=0.04u
M3776 U1038/net052 n925 VSS VSS nmos W=0.31u L=0.04u
M3777 U1038/PG2 N257 n878 VSS nmos W=0.22u L=0.04u
M3778 U1038/net74 U1038/net044 U1038/PG2 VSS nmos W=0.12u L=0.04u
M3779 U1038/net052 N389 U1038/PG1 VSS nmos W=0.155u L=0.04u
M3780 U1038/PG1 U1038/net24 n878 VSS nmos W=0.155u L=0.04u
M3781 U1038/net76 N389 U1038/PG2 VSS nmos W=0.155u L=0.04u
M3782 U1038/net72 U1038/net044 U1038/PG1 VSS nmos W=0.12u L=0.04u
M3783 U1038/net24 N257 VDD VDD pmos W=0.205u L=0.04u
M3784 U1038/net74 N595 VDD VDD pmos W=0.205u L=0.04u
M3785 U1038/net72 N596 VDD VDD pmos W=0.205u L=0.04u
M3786 U1038/net76 n926 VDD VDD pmos W=0.41u L=0.04u
M3787 U1038/net044 N389 VDD VDD pmos W=0.205u L=0.04u
M3788 U1038/net052 n925 VDD VDD pmos W=0.41u L=0.04u
M3789 U1038/PG2 U1038/net24 n878 VDD pmos W=0.205u L=0.04u
M3790 U1038/net74 N389 U1038/PG2 VDD pmos W=0.205u L=0.04u
M3791 U1038/net052 U1038/net044 U1038/PG1 VDD pmos W=0.205u L=0.04u
M3792 U1038/PG1 N257 n878 VDD pmos W=0.29u L=0.04u
M3793 U1038/net76 U1038/net044 U1038/PG2 VDD pmos W=0.205u L=0.04u
M3794 U1038/net72 N389 U1038/PG1 VDD pmos W=0.205u L=0.04u
M3795 U1039/net24 N226 VSS VSS nmos W=0.155u L=0.04u
M3796 U1039/net74 N595 VSS VSS nmos W=0.155u L=0.04u
M3797 U1039/net72 N596 VSS VSS nmos W=0.155u L=0.04u
M3798 U1039/net76 n926 VSS VSS nmos W=0.31u L=0.04u
M3799 U1039/net044 N422 VSS VSS nmos W=0.155u L=0.04u
M3800 U1039/net052 n925 VSS VSS nmos W=0.31u L=0.04u
M3801 U1039/PG2 N226 n761 VSS nmos W=0.22u L=0.04u
M3802 U1039/net74 U1039/net044 U1039/PG2 VSS nmos W=0.12u L=0.04u
M3803 U1039/net052 N422 U1039/PG1 VSS nmos W=0.155u L=0.04u
M3804 U1039/PG1 U1039/net24 n761 VSS nmos W=0.155u L=0.04u
M3805 U1039/net76 N422 U1039/PG2 VSS nmos W=0.155u L=0.04u
M3806 U1039/net72 U1039/net044 U1039/PG1 VSS nmos W=0.12u L=0.04u
M3807 U1039/net24 N226 VDD VDD pmos W=0.205u L=0.04u
M3808 U1039/net74 N595 VDD VDD pmos W=0.205u L=0.04u
M3809 U1039/net72 N596 VDD VDD pmos W=0.205u L=0.04u
M3810 U1039/net76 n926 VDD VDD pmos W=0.41u L=0.04u
M3811 U1039/net044 N422 VDD VDD pmos W=0.205u L=0.04u
M3812 U1039/net052 n925 VDD VDD pmos W=0.41u L=0.04u
M3813 U1039/PG2 U1039/net24 n761 VDD pmos W=0.205u L=0.04u
M3814 U1039/net74 N422 U1039/PG2 VDD pmos W=0.205u L=0.04u
M3815 U1039/net052 U1039/net044 U1039/PG1 VDD pmos W=0.205u L=0.04u
M3816 U1039/PG1 N226 n761 VDD pmos W=0.29u L=0.04u
M3817 U1039/net76 U1039/net044 U1039/PG2 VDD pmos W=0.205u L=0.04u
M3818 U1039/net72 N422 U1039/PG1 VDD pmos W=0.205u L=0.04u
M3819 U1040/net7 n765 VSS VSS nmos W=0.155u L=0.04u
M3820 U1040/net7 n601 VSS VSS nmos W=0.155u L=0.04u
M3821 U1040/net7 n766 VSS VSS nmos W=0.155u L=0.04u
M3822 n924 U1040/net7 VSS VSS nmos W=0.155u L=0.04u
M3823 U1040/XU42-net9 n766 VDD VDD pmos W=0.205u L=0.04u
M3824 U1040/XU42-net12 n601 U1040/XU42-net9 VDD pmos W=0.205u L=0.04u
M3825 U1040/net7 n765 U1040/XU42-net12 VDD pmos W=0.205u L=0.04u
M3826 n924 U1040/net7 VDD VDD pmos W=0.205u L=0.04u
M3827 U1041/net24 N218 VSS VSS nmos W=0.155u L=0.04u
M3828 U1041/net74 N595 VSS VSS nmos W=0.155u L=0.04u
M3829 U1041/net72 N596 VSS VSS nmos W=0.155u L=0.04u
M3830 U1041/net76 n926 VSS VSS nmos W=0.31u L=0.04u
M3831 U1041/net044 N468 VSS VSS nmos W=0.155u L=0.04u
M3832 U1041/net052 n925 VSS VSS nmos W=0.31u L=0.04u
M3833 U1041/PG2 N218 n765 VSS nmos W=0.22u L=0.04u
M3834 U1041/net74 U1041/net044 U1041/PG2 VSS nmos W=0.12u L=0.04u
M3835 U1041/net052 N468 U1041/PG1 VSS nmos W=0.155u L=0.04u
M3836 U1041/PG1 U1041/net24 n765 VSS nmos W=0.155u L=0.04u
M3837 U1041/net76 N468 U1041/PG2 VSS nmos W=0.155u L=0.04u
M3838 U1041/net72 U1041/net044 U1041/PG1 VSS nmos W=0.12u L=0.04u
M3839 U1041/net24 N218 VDD VDD pmos W=0.205u L=0.04u
M3840 U1041/net74 N595 VDD VDD pmos W=0.205u L=0.04u
M3841 U1041/net72 N596 VDD VDD pmos W=0.205u L=0.04u
M3842 U1041/net76 n926 VDD VDD pmos W=0.41u L=0.04u
M3843 U1041/net044 N468 VDD VDD pmos W=0.205u L=0.04u
M3844 U1041/net052 n925 VDD VDD pmos W=0.41u L=0.04u
M3845 U1041/PG2 U1041/net24 n765 VDD pmos W=0.205u L=0.04u
M3846 U1041/net74 N468 U1041/PG2 VDD pmos W=0.205u L=0.04u
M3847 U1041/net052 U1041/net044 U1041/PG1 VDD pmos W=0.205u L=0.04u
M3848 U1041/PG1 N218 n765 VDD pmos W=0.29u L=0.04u
M3849 U1041/net76 U1041/net044 U1041/PG2 VDD pmos W=0.205u L=0.04u
M3850 U1041/net72 N468 U1041/PG1 VDD pmos W=0.205u L=0.04u
M3851 U1042/net24 N446 VSS VSS nmos W=0.155u L=0.04u
M3852 U1042/net74 N251 VSS VSS nmos W=0.155u L=0.04u
M3853 U1042/net72 n596 VSS VSS nmos W=0.155u L=0.04u
M3854 U1042/net76 N248 VSS VSS nmos W=0.31u L=0.04u
M3855 U1042/net044 N206 VSS VSS nmos W=0.155u L=0.04u
M3856 U1042/net052 n597 VSS VSS nmos W=0.31u L=0.04u
M3857 U1042/PG2 N446 n601 VSS nmos W=0.22u L=0.04u
M3858 U1042/net74 U1042/net044 U1042/PG2 VSS nmos W=0.12u L=0.04u
M3859 U1042/net052 N206 U1042/PG1 VSS nmos W=0.155u L=0.04u
M3860 U1042/PG1 U1042/net24 n601 VSS nmos W=0.155u L=0.04u
M3861 U1042/net76 N206 U1042/PG2 VSS nmos W=0.155u L=0.04u
M3862 U1042/net72 U1042/net044 U1042/PG1 VSS nmos W=0.12u L=0.04u
M3863 U1042/net24 N446 VDD VDD pmos W=0.205u L=0.04u
M3864 U1042/net74 N251 VDD VDD pmos W=0.205u L=0.04u
M3865 U1042/net72 n596 VDD VDD pmos W=0.205u L=0.04u
M3866 U1042/net76 N248 VDD VDD pmos W=0.41u L=0.04u
M3867 U1042/net044 N206 VDD VDD pmos W=0.205u L=0.04u
M3868 U1042/net052 n597 VDD VDD pmos W=0.41u L=0.04u
M3869 U1042/PG2 U1042/net24 n601 VDD pmos W=0.205u L=0.04u
M3870 U1042/net74 N206 U1042/PG2 VDD pmos W=0.205u L=0.04u
M3871 U1042/net052 U1042/net044 U1042/PG1 VDD pmos W=0.205u L=0.04u
M3872 U1042/PG1 N446 n601 VDD pmos W=0.29u L=0.04u
M3873 U1042/net76 U1042/net044 U1042/PG2 VDD pmos W=0.205u L=0.04u
M3874 U1042/net72 N206 U1042/PG1 VDD pmos W=0.205u L=0.04u
M3875 U1043/net24 N210 VSS VSS nmos W=0.155u L=0.04u
M3876 U1043/net74 N595 VSS VSS nmos W=0.155u L=0.04u
M3877 U1043/net72 N596 VSS VSS nmos W=0.155u L=0.04u
M3878 U1043/net76 n926 VSS VSS nmos W=0.31u L=0.04u
M3879 U1043/net044 N457 VSS VSS nmos W=0.155u L=0.04u
M3880 U1043/net052 n925 VSS VSS nmos W=0.31u L=0.04u
M3881 U1043/PG2 N210 n766 VSS nmos W=0.22u L=0.04u
M3882 U1043/net74 U1043/net044 U1043/PG2 VSS nmos W=0.12u L=0.04u
M3883 U1043/net052 N457 U1043/PG1 VSS nmos W=0.155u L=0.04u
M3884 U1043/PG1 U1043/net24 n766 VSS nmos W=0.155u L=0.04u
M3885 U1043/net76 N457 U1043/PG2 VSS nmos W=0.155u L=0.04u
M3886 U1043/net72 U1043/net044 U1043/PG1 VSS nmos W=0.12u L=0.04u
M3887 U1043/net24 N210 VDD VDD pmos W=0.205u L=0.04u
M3888 U1043/net74 N595 VDD VDD pmos W=0.205u L=0.04u
M3889 U1043/net72 N596 VDD VDD pmos W=0.205u L=0.04u
M3890 U1043/net76 n926 VDD VDD pmos W=0.41u L=0.04u
M3891 U1043/net044 N457 VDD VDD pmos W=0.205u L=0.04u
M3892 U1043/net052 n925 VDD VDD pmos W=0.41u L=0.04u
M3893 U1043/PG2 U1043/net24 n766 VDD pmos W=0.205u L=0.04u
M3894 U1043/net74 N457 U1043/PG2 VDD pmos W=0.205u L=0.04u
M3895 U1043/net052 U1043/net044 U1043/PG1 VDD pmos W=0.205u L=0.04u
M3896 U1043/PG1 N210 n766 VDD pmos W=0.29u L=0.04u
M3897 U1043/net76 U1043/net044 U1043/PG2 VDD pmos W=0.205u L=0.04u
M3898 U1043/net72 N457 U1043/PG1 VDD pmos W=0.205u L=0.04u
M3899 U1044/net14 n901 VSS VSS nmos W=0.155u L=0.04u
M3900 U1044/net14 n880 VSS VSS nmos W=0.155u L=0.04u
M3901 U1044/net14 n873 VSS VSS nmos W=0.155u L=0.04u
M3902 U1044/net14 n876 VSS VSS nmos W=0.155u L=0.04u
M3903 n923 U1044/net14 VSS VSS nmos W=0.155u L=0.04u
M3904 U1044/net14 n876 U1044/XU8-net7 VDD pmos W=0.205u L=0.04u
M3905 U1044/XU8-net7 n873 U1044/XU8-net10 VDD pmos W=0.205u L=0.04u
M3906 U1044/XU8-net10 n880 U1044/XU8-net13 VDD pmos W=0.205u L=0.04u
M3907 U1044/XU8-net13 n901 VDD VDD pmos W=0.205u L=0.04u
M3908 n923 U1044/net14 VDD VDD pmos W=0.205u L=0.04u
M3909 U1045/net24 N265 VSS VSS nmos W=0.155u L=0.04u
M3910 U1045/net74 N595 VSS VSS nmos W=0.155u L=0.04u
M3911 U1045/net72 N596 VSS VSS nmos W=0.155u L=0.04u
M3912 U1045/net76 n926 VSS VSS nmos W=0.31u L=0.04u
M3913 U1045/net044 N400 VSS VSS nmos W=0.155u L=0.04u
M3914 U1045/net052 n925 VSS VSS nmos W=0.31u L=0.04u
M3915 U1045/PG2 N265 n876 VSS nmos W=0.22u L=0.04u
M3916 U1045/net74 U1045/net044 U1045/PG2 VSS nmos W=0.12u L=0.04u
M3917 U1045/net052 N400 U1045/PG1 VSS nmos W=0.155u L=0.04u
M3918 U1045/PG1 U1045/net24 n876 VSS nmos W=0.155u L=0.04u
M3919 U1045/net76 N400 U1045/PG2 VSS nmos W=0.155u L=0.04u
M3920 U1045/net72 U1045/net044 U1045/PG1 VSS nmos W=0.12u L=0.04u
M3921 U1045/net24 N265 VDD VDD pmos W=0.205u L=0.04u
M3922 U1045/net74 N595 VDD VDD pmos W=0.205u L=0.04u
M3923 U1045/net72 N596 VDD VDD pmos W=0.205u L=0.04u
M3924 U1045/net76 n926 VDD VDD pmos W=0.41u L=0.04u
M3925 U1045/net044 N400 VDD VDD pmos W=0.205u L=0.04u
M3926 U1045/net052 n925 VDD VDD pmos W=0.41u L=0.04u
M3927 U1045/PG2 U1045/net24 n876 VDD pmos W=0.205u L=0.04u
M3928 U1045/net74 N400 U1045/PG2 VDD pmos W=0.205u L=0.04u
M3929 U1045/net052 U1045/net044 U1045/PG1 VDD pmos W=0.205u L=0.04u
M3930 U1045/PG1 N265 n876 VDD pmos W=0.29u L=0.04u
M3931 U1045/net76 U1045/net044 U1045/PG2 VDD pmos W=0.205u L=0.04u
M3932 U1045/net72 N400 U1045/PG1 VDD pmos W=0.205u L=0.04u
M3933 U1046/net24 N273 VSS VSS nmos W=0.155u L=0.04u
M3934 U1046/net74 N595 VSS VSS nmos W=0.155u L=0.04u
M3935 U1046/net72 N596 VSS VSS nmos W=0.155u L=0.04u
M3936 U1046/net76 n926 VSS VSS nmos W=0.31u L=0.04u
M3937 U1046/net044 N411 VSS VSS nmos W=0.155u L=0.04u
M3938 U1046/net052 n925 VSS VSS nmos W=0.31u L=0.04u
M3939 U1046/PG2 N273 n873 VSS nmos W=0.22u L=0.04u
M3940 U1046/net74 U1046/net044 U1046/PG2 VSS nmos W=0.12u L=0.04u
M3941 U1046/net052 N411 U1046/PG1 VSS nmos W=0.155u L=0.04u
M3942 U1046/PG1 U1046/net24 n873 VSS nmos W=0.155u L=0.04u
M3943 U1046/net76 N411 U1046/PG2 VSS nmos W=0.155u L=0.04u
M3944 U1046/net72 U1046/net044 U1046/PG1 VSS nmos W=0.12u L=0.04u
M3945 U1046/net24 N273 VDD VDD pmos W=0.205u L=0.04u
M3946 U1046/net74 N595 VDD VDD pmos W=0.205u L=0.04u
M3947 U1046/net72 N596 VDD VDD pmos W=0.205u L=0.04u
M3948 U1046/net76 n926 VDD VDD pmos W=0.41u L=0.04u
M3949 U1046/net044 N411 VDD VDD pmos W=0.205u L=0.04u
M3950 U1046/net052 n925 VDD VDD pmos W=0.41u L=0.04u
M3951 U1046/PG2 U1046/net24 n873 VDD pmos W=0.205u L=0.04u
M3952 U1046/net74 N411 U1046/PG2 VDD pmos W=0.205u L=0.04u
M3953 U1046/net052 U1046/net044 U1046/PG1 VDD pmos W=0.205u L=0.04u
M3954 U1046/PG1 N273 n873 VDD pmos W=0.29u L=0.04u
M3955 U1046/net76 U1046/net044 U1046/PG2 VDD pmos W=0.205u L=0.04u
M3956 U1046/net72 N411 U1046/PG1 VDD pmos W=0.205u L=0.04u
M3957 U1047/net24 N234 VSS VSS nmos W=0.155u L=0.04u
M3958 U1047/net74 N595 VSS VSS nmos W=0.155u L=0.04u
M3959 U1047/net72 N596 VSS VSS nmos W=0.155u L=0.04u
M3960 U1047/net76 n926 VSS VSS nmos W=0.31u L=0.04u
M3961 U1047/net044 N435 VSS VSS nmos W=0.155u L=0.04u
M3962 U1047/net052 n925 VSS VSS nmos W=0.31u L=0.04u
M3963 U1047/PG2 N234 n880 VSS nmos W=0.22u L=0.04u
M3964 U1047/net74 U1047/net044 U1047/PG2 VSS nmos W=0.12u L=0.04u
M3965 U1047/net052 N435 U1047/PG1 VSS nmos W=0.155u L=0.04u
M3966 U1047/PG1 U1047/net24 n880 VSS nmos W=0.155u L=0.04u
M3967 U1047/net76 N435 U1047/PG2 VSS nmos W=0.155u L=0.04u
M3968 U1047/net72 U1047/net044 U1047/PG1 VSS nmos W=0.12u L=0.04u
M3969 U1047/net24 N234 VDD VDD pmos W=0.205u L=0.04u
M3970 U1047/net74 N595 VDD VDD pmos W=0.205u L=0.04u
M3971 U1047/net72 N596 VDD VDD pmos W=0.205u L=0.04u
M3972 U1047/net76 n926 VDD VDD pmos W=0.41u L=0.04u
M3973 U1047/net044 N435 VDD VDD pmos W=0.205u L=0.04u
M3974 U1047/net052 n925 VDD VDD pmos W=0.41u L=0.04u
M3975 U1047/PG2 U1047/net24 n880 VDD pmos W=0.205u L=0.04u
M3976 U1047/net74 N435 U1047/PG2 VDD pmos W=0.205u L=0.04u
M3977 U1047/net052 U1047/net044 U1047/PG1 VDD pmos W=0.205u L=0.04u
M3978 U1047/PG1 N234 n880 VDD pmos W=0.29u L=0.04u
M3979 U1047/net76 U1047/net044 U1047/PG2 VDD pmos W=0.205u L=0.04u
M3980 U1047/net72 N435 U1047/PG1 VDD pmos W=0.205u L=0.04u
M3981 U1048/net24 N281 VSS VSS nmos W=0.155u L=0.04u
M3982 U1048/net74 N595 VSS VSS nmos W=0.155u L=0.04u
M3983 U1048/net72 N596 VSS VSS nmos W=0.155u L=0.04u
M3984 U1048/net76 n926 VSS VSS nmos W=0.31u L=0.04u
M3985 U1048/net044 N374 VSS VSS nmos W=0.155u L=0.04u
M3986 U1048/net052 n925 VSS VSS nmos W=0.31u L=0.04u
M3987 U1048/PG2 N281 n901 VSS nmos W=0.22u L=0.04u
M3988 U1048/net74 U1048/net044 U1048/PG2 VSS nmos W=0.12u L=0.04u
M3989 U1048/net052 N374 U1048/PG1 VSS nmos W=0.155u L=0.04u
M3990 U1048/PG1 U1048/net24 n901 VSS nmos W=0.155u L=0.04u
M3991 U1048/net76 N374 U1048/PG2 VSS nmos W=0.155u L=0.04u
M3992 U1048/net72 U1048/net044 U1048/PG1 VSS nmos W=0.12u L=0.04u
M3993 U1048/net24 N281 VDD VDD pmos W=0.205u L=0.04u
M3994 U1048/net74 N595 VDD VDD pmos W=0.205u L=0.04u
M3995 U1048/net72 N596 VDD VDD pmos W=0.205u L=0.04u
M3996 U1048/net76 n926 VDD VDD pmos W=0.41u L=0.04u
M3997 U1048/net044 N374 VDD VDD pmos W=0.205u L=0.04u
M3998 U1048/net052 n925 VDD VDD pmos W=0.41u L=0.04u
M3999 U1048/PG2 U1048/net24 n901 VDD pmos W=0.205u L=0.04u
M4000 U1048/net74 N374 U1048/PG2 VDD pmos W=0.205u L=0.04u
M4001 U1048/net052 U1048/net044 U1048/PG1 VDD pmos W=0.205u L=0.04u
M4002 U1048/PG1 N281 n901 VDD pmos W=0.29u L=0.04u
M4003 U1048/net76 U1048/net044 U1048/PG2 VDD pmos W=0.205u L=0.04u
M4004 U1048/net72 N374 U1048/PG1 VDD pmos W=0.205u L=0.04u
M4005 N5240 n887 VSS VSS nmos W=0.155u L=0.04u
M4006 N5240 n670 VSS VSS nmos W=0.155u L=0.04u
M4007 N5240 n928 VSS VSS nmos W=0.155u L=0.04u
M4008 N5240 n927 VSS VSS nmos W=0.155u L=0.04u
M4009 U1049/net49 n670 U1049/net52 VDD pmos W=0.41u L=0.04u
M4010 U1049/net52 n887 VDD VDD pmos W=0.41u L=0.04u
M4011 U1049/net46 n928 U1049/net49 VDD pmos W=0.41u L=0.04u
M4012 N5240 n927 U1049/net46 VDD pmos W=0.41u L=0.04u
M4013 U1050/net24 N341 VSS VSS nmos W=0.155u L=0.04u
M4014 U1050/net74 N595 VSS VSS nmos W=0.155u L=0.04u
M4015 U1050/net72 N596 VSS VSS nmos W=0.155u L=0.04u
M4016 U1050/net76 n926 VSS VSS nmos W=0.31u L=0.04u
M4017 U1050/net044 N523 VSS VSS nmos W=0.155u L=0.04u
M4018 U1050/net052 n925 VSS VSS nmos W=0.31u L=0.04u
M4019 U1050/PG2 N341 n887 VSS nmos W=0.22u L=0.04u
M4020 U1050/net74 U1050/net044 U1050/PG2 VSS nmos W=0.12u L=0.04u
M4021 U1050/net052 N523 U1050/PG1 VSS nmos W=0.155u L=0.04u
M4022 U1050/PG1 U1050/net24 n887 VSS nmos W=0.155u L=0.04u
M4023 U1050/net76 N523 U1050/PG2 VSS nmos W=0.155u L=0.04u
M4024 U1050/net72 U1050/net044 U1050/PG1 VSS nmos W=0.12u L=0.04u
M4025 U1050/net24 N341 VDD VDD pmos W=0.205u L=0.04u
M4026 U1050/net74 N595 VDD VDD pmos W=0.205u L=0.04u
M4027 U1050/net72 N596 VDD VDD pmos W=0.205u L=0.04u
M4028 U1050/net76 n926 VDD VDD pmos W=0.41u L=0.04u
M4029 U1050/net044 N523 VDD VDD pmos W=0.205u L=0.04u
M4030 U1050/net052 n925 VDD VDD pmos W=0.41u L=0.04u
M4031 U1050/PG2 U1050/net24 n887 VDD pmos W=0.205u L=0.04u
M4032 U1050/net74 N523 U1050/PG2 VDD pmos W=0.205u L=0.04u
M4033 U1050/net052 U1050/net044 U1050/PG1 VDD pmos W=0.205u L=0.04u
M4034 U1050/PG1 N341 n887 VDD pmos W=0.29u L=0.04u
M4035 U1050/net76 U1050/net044 U1050/PG2 VDD pmos W=0.205u L=0.04u
M4036 U1050/net72 N523 U1050/PG1 VDD pmos W=0.205u L=0.04u
M4037 U1051/net19 N293 VSS VSS nmos W=0.155u L=0.04u
M4038 n670 N293 U1051/net40 VSS nmos W=0.155u L=0.04u
M4039 n670 U1051/net19 U1051/net36 VSS nmos W=0.155u L=0.04u
M4040 U1051/net40 n597 VSS VSS nmos W=0.31u L=0.04u
M4041 U1051/net36 n596 VSS VSS nmos W=0.155u L=0.04u
M4042 U1051/net19 N293 VDD VDD pmos W=0.205u L=0.04u
M4043 n670 U1051/net19 U1051/net26 VDD pmos W=0.325u L=0.04u
M4044 U1051/net26 n597 VDD VDD pmos W=0.41u L=0.04u
M4045 n670 N293 U1051/net30 VDD pmos W=0.325u L=0.04u
M4046 U1051/net30 n596 VDD VDD pmos W=0.205u L=0.04u
M4047 U1052/net7 n672 VSS VSS nmos W=0.155u L=0.04u
M4048 U1052/net7 n665 VSS VSS nmos W=0.155u L=0.04u
M4049 U1052/net7 n671 VSS VSS nmos W=0.155u L=0.04u
M4050 n928 U1052/net7 VSS VSS nmos W=0.155u L=0.04u
M4051 U1052/XU42-net9 n671 VDD VDD pmos W=0.205u L=0.04u
M4052 U1052/XU42-net12 n665 U1052/XU42-net9 VDD pmos W=0.205u L=0.04u
M4053 U1052/net7 n672 U1052/XU42-net12 VDD pmos W=0.205u L=0.04u
M4054 n928 U1052/net7 VDD VDD pmos W=0.205u L=0.04u
M4055 U1053/net24 N479 VSS VSS nmos W=0.155u L=0.04u
M4056 U1053/net74 N251 VSS VSS nmos W=0.155u L=0.04u
M4057 U1053/net72 n596 VSS VSS nmos W=0.155u L=0.04u
M4058 U1053/net76 N248 VSS VSS nmos W=0.31u L=0.04u
M4059 U1053/net044 N308 VSS VSS nmos W=0.155u L=0.04u
M4060 U1053/net052 n597 VSS VSS nmos W=0.31u L=0.04u
M4061 U1053/PG2 N479 n672 VSS nmos W=0.22u L=0.04u
M4062 U1053/net74 U1053/net044 U1053/PG2 VSS nmos W=0.12u L=0.04u
M4063 U1053/net052 N308 U1053/PG1 VSS nmos W=0.155u L=0.04u
M4064 U1053/PG1 U1053/net24 n672 VSS nmos W=0.155u L=0.04u
M4065 U1053/net76 N308 U1053/PG2 VSS nmos W=0.155u L=0.04u
M4066 U1053/net72 U1053/net044 U1053/PG1 VSS nmos W=0.12u L=0.04u
M4067 U1053/net24 N479 VDD VDD pmos W=0.205u L=0.04u
M4068 U1053/net74 N251 VDD VDD pmos W=0.205u L=0.04u
M4069 U1053/net72 n596 VDD VDD pmos W=0.205u L=0.04u
M4070 U1053/net76 N248 VDD VDD pmos W=0.41u L=0.04u
M4071 U1053/net044 N308 VDD VDD pmos W=0.205u L=0.04u
M4072 U1053/net052 n597 VDD VDD pmos W=0.41u L=0.04u
M4073 U1053/PG2 U1053/net24 n672 VDD pmos W=0.205u L=0.04u
M4074 U1053/net74 N308 U1053/PG2 VDD pmos W=0.205u L=0.04u
M4075 U1053/net052 U1053/net044 U1053/PG1 VDD pmos W=0.205u L=0.04u
M4076 U1053/PG1 N479 n672 VDD pmos W=0.29u L=0.04u
M4077 U1053/net76 U1053/net044 U1053/PG2 VDD pmos W=0.205u L=0.04u
M4078 U1053/net72 N308 U1053/PG1 VDD pmos W=0.205u L=0.04u
M4079 U1054/net24 N490 VSS VSS nmos W=0.155u L=0.04u
M4080 U1054/net74 N251 VSS VSS nmos W=0.155u L=0.04u
M4081 U1054/net72 n596 VSS VSS nmos W=0.155u L=0.04u
M4082 U1054/net76 N248 VSS VSS nmos W=0.31u L=0.04u
M4083 U1054/net044 N316 VSS VSS nmos W=0.155u L=0.04u
M4084 U1054/net052 n597 VSS VSS nmos W=0.31u L=0.04u
M4085 U1054/PG2 N490 n665 VSS nmos W=0.22u L=0.04u
M4086 U1054/net74 U1054/net044 U1054/PG2 VSS nmos W=0.12u L=0.04u
M4087 U1054/net052 N316 U1054/PG1 VSS nmos W=0.155u L=0.04u
M4088 U1054/PG1 U1054/net24 n665 VSS nmos W=0.155u L=0.04u
M4089 U1054/net76 N316 U1054/PG2 VSS nmos W=0.155u L=0.04u
M4090 U1054/net72 U1054/net044 U1054/PG1 VSS nmos W=0.12u L=0.04u
M4091 U1054/net24 N490 VDD VDD pmos W=0.205u L=0.04u
M4092 U1054/net74 N251 VDD VDD pmos W=0.205u L=0.04u
M4093 U1054/net72 n596 VDD VDD pmos W=0.205u L=0.04u
M4094 U1054/net76 N248 VDD VDD pmos W=0.41u L=0.04u
M4095 U1054/net044 N316 VDD VDD pmos W=0.205u L=0.04u
M4096 U1054/net052 n597 VDD VDD pmos W=0.41u L=0.04u
M4097 U1054/PG2 U1054/net24 n665 VDD pmos W=0.205u L=0.04u
M4098 U1054/net74 N316 U1054/PG2 VDD pmos W=0.205u L=0.04u
M4099 U1054/net052 U1054/net044 U1054/PG1 VDD pmos W=0.205u L=0.04u
M4100 U1054/PG1 N490 n665 VDD pmos W=0.29u L=0.04u
M4101 U1054/net76 U1054/net044 U1054/PG2 VDD pmos W=0.205u L=0.04u
M4102 U1054/net72 N316 U1054/PG1 VDD pmos W=0.205u L=0.04u
M4103 n597 N242 VSS VSS nmos W=0.135u L=0.04u
M4104 n597 N242 VDD VDD pmos W=0.205u L=0.04u
M4105 n596 N254 VSS VSS nmos W=0.135u L=0.04u
M4106 n596 N254 VDD VDD pmos W=0.205u L=0.04u
M4107 U1057/net19 N302 VSS VSS nmos W=0.155u L=0.04u
M4108 n671 N302 U1057/net40 VSS nmos W=0.155u L=0.04u
M4109 n671 U1057/net19 U1057/net36 VSS nmos W=0.155u L=0.04u
M4110 U1057/net40 N248 VSS VSS nmos W=0.31u L=0.04u
M4111 U1057/net36 N251 VSS VSS nmos W=0.155u L=0.04u
M4112 U1057/net19 N302 VDD VDD pmos W=0.205u L=0.04u
M4113 n671 U1057/net19 U1057/net26 VDD pmos W=0.325u L=0.04u
M4114 U1057/net26 N248 VDD VDD pmos W=0.41u L=0.04u
M4115 n671 N302 U1057/net30 VDD pmos W=0.325u L=0.04u
M4116 U1057/net30 N251 VDD VDD pmos W=0.205u L=0.04u
M4117 U1058/net14 n889 VSS VSS nmos W=0.155u L=0.04u
M4118 U1058/net14 n677 VSS VSS nmos W=0.155u L=0.04u
M4119 U1058/net14 n891 VSS VSS nmos W=0.155u L=0.04u
M4120 U1058/net14 n902 VSS VSS nmos W=0.155u L=0.04u
M4121 n927 U1058/net14 VSS VSS nmos W=0.155u L=0.04u
M4122 U1058/net14 n902 U1058/XU8-net7 VDD pmos W=0.205u L=0.04u
M4123 U1058/XU8-net7 n891 U1058/XU8-net10 VDD pmos W=0.205u L=0.04u
M4124 U1058/XU8-net10 n677 U1058/XU8-net13 VDD pmos W=0.205u L=0.04u
M4125 U1058/XU8-net13 n889 VDD VDD pmos W=0.205u L=0.04u
M4126 n927 U1058/net14 VDD VDD pmos W=0.205u L=0.04u
M4127 U1059/net24 N351 VSS VSS nmos W=0.155u L=0.04u
M4128 U1059/net74 N595 VSS VSS nmos W=0.155u L=0.04u
M4129 U1059/net72 N596 VSS VSS nmos W=0.155u L=0.04u
M4130 U1059/net76 n926 VSS VSS nmos W=0.31u L=0.04u
M4131 U1059/net044 N534 VSS VSS nmos W=0.155u L=0.04u
M4132 U1059/net052 n925 VSS VSS nmos W=0.31u L=0.04u
M4133 U1059/PG2 N351 n902 VSS nmos W=0.22u L=0.04u
M4134 U1059/net74 U1059/net044 U1059/PG2 VSS nmos W=0.12u L=0.04u
M4135 U1059/net052 N534 U1059/PG1 VSS nmos W=0.155u L=0.04u
M4136 U1059/PG1 U1059/net24 n902 VSS nmos W=0.155u L=0.04u
M4137 U1059/net76 N534 U1059/PG2 VSS nmos W=0.155u L=0.04u
M4138 U1059/net72 U1059/net044 U1059/PG1 VSS nmos W=0.12u L=0.04u
M4139 U1059/net24 N351 VDD VDD pmos W=0.205u L=0.04u
M4140 U1059/net74 N595 VDD VDD pmos W=0.205u L=0.04u
M4141 U1059/net72 N596 VDD VDD pmos W=0.205u L=0.04u
M4142 U1059/net76 n926 VDD VDD pmos W=0.41u L=0.04u
M4143 U1059/net044 N534 VDD VDD pmos W=0.205u L=0.04u
M4144 U1059/net052 n925 VDD VDD pmos W=0.41u L=0.04u
M4145 U1059/PG2 U1059/net24 n902 VDD pmos W=0.205u L=0.04u
M4146 U1059/net74 N534 U1059/PG2 VDD pmos W=0.205u L=0.04u
M4147 U1059/net052 U1059/net044 U1059/PG1 VDD pmos W=0.205u L=0.04u
M4148 U1059/PG1 N351 n902 VDD pmos W=0.29u L=0.04u
M4149 U1059/net76 U1059/net044 U1059/PG2 VDD pmos W=0.205u L=0.04u
M4150 U1059/net72 N534 U1059/PG1 VDD pmos W=0.205u L=0.04u
M4151 U1060/net24 N324 VSS VSS nmos W=0.155u L=0.04u
M4152 U1060/net74 N595 VSS VSS nmos W=0.155u L=0.04u
M4153 U1060/net72 N596 VSS VSS nmos W=0.155u L=0.04u
M4154 U1060/net76 n926 VSS VSS nmos W=0.31u L=0.04u
M4155 U1060/net044 N503 VSS VSS nmos W=0.155u L=0.04u
M4156 U1060/net052 n925 VSS VSS nmos W=0.31u L=0.04u
M4157 U1060/PG2 N324 n891 VSS nmos W=0.22u L=0.04u
M4158 U1060/net74 U1060/net044 U1060/PG2 VSS nmos W=0.12u L=0.04u
M4159 U1060/net052 N503 U1060/PG1 VSS nmos W=0.155u L=0.04u
M4160 U1060/PG1 U1060/net24 n891 VSS nmos W=0.155u L=0.04u
M4161 U1060/net76 N503 U1060/PG2 VSS nmos W=0.155u L=0.04u
M4162 U1060/net72 U1060/net044 U1060/PG1 VSS nmos W=0.12u L=0.04u
M4163 U1060/net24 N324 VDD VDD pmos W=0.205u L=0.04u
M4164 U1060/net74 N595 VDD VDD pmos W=0.205u L=0.04u
M4165 U1060/net72 N596 VDD VDD pmos W=0.205u L=0.04u
M4166 U1060/net76 n926 VDD VDD pmos W=0.41u L=0.04u
M4167 U1060/net044 N503 VDD VDD pmos W=0.205u L=0.04u
M4168 U1060/net052 n925 VDD VDD pmos W=0.41u L=0.04u
M4169 U1060/PG2 U1060/net24 n891 VDD pmos W=0.205u L=0.04u
M4170 U1060/net74 N503 U1060/PG2 VDD pmos W=0.205u L=0.04u
M4171 U1060/net052 U1060/net044 U1060/PG1 VDD pmos W=0.205u L=0.04u
M4172 U1060/PG1 N324 n891 VDD pmos W=0.29u L=0.04u
M4173 U1060/net76 U1060/net044 U1060/PG2 VDD pmos W=0.205u L=0.04u
M4174 U1060/net72 N503 U1060/PG1 VDD pmos W=0.205u L=0.04u
M4175 n925 N597 VSS VSS nmos W=0.135u L=0.04u
M4176 n925 N597 VDD VDD pmos W=0.205u L=0.04u
M4177 U1062/net19 N361 VSS VSS nmos W=0.155u L=0.04u
M4178 n677 N361 U1062/net40 VSS nmos W=0.155u L=0.04u
M4179 n677 U1062/net19 U1062/net36 VSS nmos W=0.155u L=0.04u
M4180 U1062/net40 N248 VSS VSS nmos W=0.31u L=0.04u
M4181 U1062/net36 N251 VSS VSS nmos W=0.155u L=0.04u
M4182 U1062/net19 N361 VDD VDD pmos W=0.205u L=0.04u
M4183 n677 U1062/net19 U1062/net26 VDD pmos W=0.325u L=0.04u
M4184 U1062/net26 N248 VDD VDD pmos W=0.41u L=0.04u
M4185 n677 N361 U1062/net30 VDD pmos W=0.325u L=0.04u
M4186 U1062/net30 N251 VDD VDD pmos W=0.205u L=0.04u
M4187 U1063/net19 N514 VSS VSS nmos W=0.155u L=0.04u
M4188 n889 N514 U1063/net40 VSS nmos W=0.155u L=0.04u
M4189 n889 U1063/net19 U1063/net36 VSS nmos W=0.155u L=0.04u
M4190 U1063/net40 n926 VSS VSS nmos W=0.31u L=0.04u
M4191 U1063/net36 N595 VSS VSS nmos W=0.155u L=0.04u
M4192 U1063/net19 N514 VDD VDD pmos W=0.205u L=0.04u
M4193 n889 U1063/net19 U1063/net26 VDD pmos W=0.325u L=0.04u
M4194 U1063/net26 n926 VDD VDD pmos W=0.41u L=0.04u
M4195 n889 N514 U1063/net30 VDD pmos W=0.325u L=0.04u
M4196 U1063/net30 N595 VDD VDD pmos W=0.205u L=0.04u
M4197 n926 N598 VSS VSS nmos W=0.135u L=0.04u
M4198 n926 N598 VDD VDD pmos W=0.205u L=0.04u
M4199 N4740 n929 U1065/net27 VSS nmos W=0.155u L=0.04u
M4200 U1065/net27 n930 VSS VSS nmos W=0.155u L=0.04u
M4201 N4740 n931 VSS VSS nmos W=0.155u L=0.04u
M4202 N4740 n930 U1065/net13 VDD pmos W=0.205u L=0.04u
M4203 U1065/net13 n931 VDD VDD pmos W=0.205u L=0.04u
M4204 N4740 n929 U1065/net13 VDD pmos W=0.205u L=0.04u
M4205 U1066/net19 N588 VSS VSS nmos W=0.155u L=0.04u
M4206 n929 N588 U1066/net40 VSS nmos W=0.155u L=0.04u
M4207 n929 U1066/net19 U1066/net36 VSS nmos W=0.155u L=0.04u
M4208 U1066/net40 N80 VSS VSS nmos W=0.31u L=0.04u
M4209 U1066/net36 N82 VSS VSS nmos W=0.155u L=0.04u
M4210 U1066/net19 N588 VDD VDD pmos W=0.205u L=0.04u
M4211 n929 U1066/net19 U1066/net26 VDD pmos W=0.325u L=0.04u
M4212 U1066/net26 N80 VDD VDD pmos W=0.41u L=0.04u
M4213 n929 N588 U1066/net30 VDD pmos W=0.325u L=0.04u
M4214 U1066/net30 N82 VDD VDD pmos W=0.205u L=0.04u
M4215 N4739 n932 U1067/net27 VSS nmos W=0.155u L=0.04u
M4216 U1067/net27 n930 VSS VSS nmos W=0.155u L=0.04u
M4217 N4739 n931 VSS VSS nmos W=0.155u L=0.04u
M4218 N4739 n930 U1067/net13 VDD pmos W=0.205u L=0.04u
M4219 U1067/net13 n931 VDD VDD pmos W=0.205u L=0.04u
M4220 N4739 n932 U1067/net13 VDD pmos W=0.205u L=0.04u
M4221 U1068/net19 N588 VSS VSS nmos W=0.155u L=0.04u
M4222 n932 N588 U1068/net40 VSS nmos W=0.155u L=0.04u
M4223 n932 U1068/net19 U1068/net36 VSS nmos W=0.155u L=0.04u
M4224 U1068/net40 N23 VSS VSS nmos W=0.31u L=0.04u
M4225 U1068/net36 N79 VSS VSS nmos W=0.155u L=0.04u
M4226 U1068/net19 N588 VDD VDD pmos W=0.205u L=0.04u
M4227 n932 U1068/net19 U1068/net26 VDD pmos W=0.325u L=0.04u
M4228 U1068/net26 N23 VDD VDD pmos W=0.41u L=0.04u
M4229 n932 N588 U1068/net30 VDD pmos W=0.325u L=0.04u
M4230 U1068/net30 N79 VDD VDD pmos W=0.205u L=0.04u
M4231 N4738 n933 U1069/net27 VSS nmos W=0.155u L=0.04u
M4232 U1069/net27 n930 VSS VSS nmos W=0.155u L=0.04u
M4233 N4738 n931 VSS VSS nmos W=0.155u L=0.04u
M4234 N4738 n930 U1069/net13 VDD pmos W=0.205u L=0.04u
M4235 U1069/net13 n931 VDD VDD pmos W=0.205u L=0.04u
M4236 N4738 n933 U1069/net13 VDD pmos W=0.205u L=0.04u
M4237 U1070/net19 N588 VSS VSS nmos W=0.155u L=0.04u
M4238 n933 N588 U1070/net40 VSS nmos W=0.155u L=0.04u
M4239 n933 U1070/net19 U1070/net36 VSS nmos W=0.155u L=0.04u
M4240 U1070/net40 N81 VSS VSS nmos W=0.31u L=0.04u
M4241 U1070/net36 N26 VSS VSS nmos W=0.155u L=0.04u
M4242 U1070/net19 N588 VDD VDD pmos W=0.205u L=0.04u
M4243 n933 U1070/net19 U1070/net26 VDD pmos W=0.325u L=0.04u
M4244 U1070/net26 N81 VDD VDD pmos W=0.41u L=0.04u
M4245 n933 N588 U1070/net30 VDD pmos W=0.325u L=0.04u
M4246 U1070/net30 N26 VDD VDD pmos W=0.205u L=0.04u
M4247 N4737 n934 U1071/net27 VSS nmos W=0.155u L=0.04u
M4248 U1071/net27 n930 VSS VSS nmos W=0.155u L=0.04u
M4249 N4737 n931 VSS VSS nmos W=0.155u L=0.04u
M4250 N4737 n930 U1071/net13 VDD pmos W=0.205u L=0.04u
M4251 U1071/net13 n931 VDD VDD pmos W=0.205u L=0.04u
M4252 N4737 n934 U1071/net13 VDD pmos W=0.205u L=0.04u
M4253 n931 N141 VSS VSS nmos W=0.135u L=0.04u
M4254 n931 N141 VDD VDD pmos W=0.205u L=0.04u
M4255 U1073/net19 N588 VSS VSS nmos W=0.155u L=0.04u
M4256 n934 N588 U1073/net40 VSS nmos W=0.155u L=0.04u
M4257 n934 U1073/net19 U1073/net36 VSS nmos W=0.155u L=0.04u
M4258 U1073/net40 N25 VSS VSS nmos W=0.31u L=0.04u
M4259 U1073/net36 N24 VSS VSS nmos W=0.155u L=0.04u
M4260 U1073/net19 N588 VDD VDD pmos W=0.205u L=0.04u
M4261 n934 U1073/net19 U1073/net26 VDD pmos W=0.325u L=0.04u
M4262 U1073/net26 N25 VDD VDD pmos W=0.41u L=0.04u
M4263 n934 N588 U1073/net30 VDD pmos W=0.325u L=0.04u
M4264 U1073/net30 N24 VDD VDD pmos W=0.205u L=0.04u
M4265 U1074/XU1-net6 n930 VSS VSS nmos W=0.155u L=0.04u
M4266 N4279 N83 U1074/XU1-net6 VSS nmos W=0.155u L=0.04u
M4267 N4279 n930 VDD VDD pmos W=0.155u L=0.04u
M4268 N4279 N83 VDD VDD pmos W=0.155u L=0.04u
M4269 U1075/XU1-net6 n930 VSS VSS nmos W=0.155u L=0.04u
M4270 N4278 n935 U1075/XU1-net6 VSS nmos W=0.155u L=0.04u
M4271 N4278 n930 VDD VDD pmos W=0.155u L=0.04u
M4272 N4278 n935 VDD VDD pmos W=0.155u L=0.04u
M4273 n935 U1076/net28 VSS VSS nmos W=0.155u L=0.04u
M4274 U1076/net47 N88 VSS VSS nmos W=0.155u L=0.04u
M4275 U1076/net28 U1076/net6 U1076/net47 VSS nmos W=0.155u L=0.04u
M4276 U1076/net44 N34 VSS VSS nmos W=0.155u L=0.04u
M4277 U1076/net28 N588 U1076/net44 VSS nmos W=0.155u L=0.04u
M4278 U1076/net6 N588 VSS VSS nmos W=0.155u L=0.04u
M4279 n935 U1076/net28 VDD VDD pmos W=0.205u L=0.04u
M4280 VDD N88 U1076/net47 VDD pmos W=0.205u L=0.04u
M4281 U1076/net47 N588 U1076/net28 VDD pmos W=0.205u L=0.04u
M4282 U1076/net44 U1076/net6 U1076/net28 VDD pmos W=0.205u L=0.04u
M4283 VDD N34 U1076/net44 VDD pmos W=0.205u L=0.04u
M4284 VDD N588 U1076/net6 VDD pmos W=0.205u L=0.04u
M4285 U1077/XU1-net6 n930 VSS VSS nmos W=0.155u L=0.04u
M4286 N4272 n936 U1077/XU1-net6 VSS nmos W=0.155u L=0.04u
M4287 N4272 n930 VDD VDD pmos W=0.155u L=0.04u
M4288 N4272 n936 VDD VDD pmos W=0.155u L=0.04u
M4289 n936 U1078/net28 VSS VSS nmos W=0.155u L=0.04u
M4290 U1078/net47 N86 VSS VSS nmos W=0.155u L=0.04u
M4291 U1078/net28 U1078/net6 U1078/net47 VSS nmos W=0.155u L=0.04u
M4292 U1078/net44 N87 VSS VSS nmos W=0.155u L=0.04u
M4293 U1078/net28 N588 U1078/net44 VSS nmos W=0.155u L=0.04u
M4294 U1078/net6 N588 VSS VSS nmos W=0.155u L=0.04u
M4295 n936 U1078/net28 VDD VDD pmos W=0.205u L=0.04u
M4296 VDD N86 U1078/net47 VDD pmos W=0.205u L=0.04u
M4297 U1078/net47 N588 U1078/net28 VDD pmos W=0.205u L=0.04u
M4298 U1078/net44 U1078/net6 U1078/net28 VDD pmos W=0.205u L=0.04u
M4299 VDD N87 U1078/net44 VDD pmos W=0.205u L=0.04u
M4300 VDD N588 U1078/net6 VDD pmos W=0.205u L=0.04u
M4301 N3613 N299 VSS VSS nmos W=0.135u L=0.04u
M4302 N3613 N299 VDD VDD pmos W=0.205u L=0.04u
M4303 U1080/XU1-net6 n930 VSS VSS nmos W=0.155u L=0.04u
M4304 N2590 N140 U1080/XU1-net6 VSS nmos W=0.155u L=0.04u
M4305 N2590 n930 VDD VDD pmos W=0.155u L=0.04u
M4306 N2590 N140 VDD VDD pmos W=0.155u L=0.04u
M4307 n930 N2623 VSS VSS nmos W=0.135u L=0.04u
M4308 n930 N2623 VDD VDD pmos W=0.205u L=0.04u
M4309 U1082/XU1-net6 N27 VSS VSS nmos W=0.155u L=0.04u
M4310 N2623 N31 U1082/XU1-net6 VSS nmos W=0.155u L=0.04u
M4311 N2623 N27 VDD VDD pmos W=0.155u L=0.04u
M4312 N2623 N31 VDD VDD pmos W=0.155u L=0.04u
M4313 U1083/XU1-net6 N386 VSS VSS nmos W=0.155u L=0.04u
M4314 N2061 N556 U1083/XU1-net6 VSS nmos W=0.155u L=0.04u
M4315 N2061 N386 VDD VDD pmos W=0.155u L=0.04u
M4316 N2061 N556 VDD VDD pmos W=0.155u L=0.04u
M4317 U1084/net13 N591 VSS VSS nmos W=0.155u L=0.04u
M4318 U1084/net16 U1084/net13 VSS VSS nmos W=0.155u L=0.04u
M4319 N2060 N27 U1084/net16 VSS nmos W=0.155u L=0.04u
M4320 U1084/net13 N591 VDD VDD pmos W=0.205u L=0.04u
M4321 VDD U1084/net13 N2060 VDD pmos W=0.205u L=0.04u
M4322 VDD N27 N2060 VDD pmos W=0.205u L=0.04u
M4323 N2054 N592 VSS VSS nmos W=0.155u L=0.04u
M4324 N2054 U1085/net4 VSS VSS nmos W=0.155u L=0.04u
M4325 U1085/net4 N136 VSS VSS nmos W=0.155u L=0.04u
M4326 U1085/XU1-net8 U1085/net4 VDD VDD pmos W=0.205u L=0.04u
M4327 N2054 N592 U1085/XU1-net8 VDD pmos W=0.205u L=0.04u
M4328 U1085/net4 N136 VDD VDD pmos W=0.205u L=0.04u
M4329 N1155 N559 VSS VSS nmos W=0.135u L=0.04u
M4330 N1155 N559 VDD VDD pmos W=0.205u L=0.04u
M4331 N1152 N245 VSS VSS nmos W=0.135u L=0.04u
M4332 N1152 N245 VDD VDD pmos W=0.205u L=0.04u
M4333 N1147 U1088/net6 VSS VSS nmos W=0.155u L=0.04u
M4334 U1088/X_u2-net6 N141 VSS VSS nmos W=0.155u L=0.04u
M4335 U1088/net6 N145 U1088/X_u2-net6 VSS nmos W=0.155u L=0.04u
M4336 N1147 U1088/net6 VDD VDD pmos W=0.205u L=0.04u
M4337 U1088/net6 N141 VDD VDD pmos W=0.205u L=0.04u
M4338 U1088/net6 N145 VDD VDD pmos W=0.205u L=0.04u
M4339 N1145 N358 VSS VSS nmos W=0.135u L=0.04u
M4340 N1145 N358 VDD VDD pmos W=0.205u L=0.04u
M4341 N1144 N338 VSS VSS nmos W=0.135u L=0.04u
M4342 N1144 N338 VDD VDD pmos W=0.205u L=0.04u
M4343 N1141 N549 VSS VSS nmos W=0.135u L=0.04u
M4344 N1141 N549 VDD VDD pmos W=0.205u L=0.04u
M4345 N1140 N1153 VSS VSS nmos W=0.155u L=0.04u
M4346 N1140 N1154 VSS VSS nmos W=0.155u L=0.04u
M4347 U1092/XI1-net8 N1154 VDD VDD pmos W=0.205u L=0.04u
M4348 N1140 N1153 U1092/XI1-net8 VDD pmos W=0.205u L=0.04u
M4349 N1154 N562 VSS VSS nmos W=0.135u L=0.04u
M4350 N1154 N562 VDD VDD pmos W=0.205u L=0.04u
M4351 N1153 N552 VSS VSS nmos W=0.135u L=0.04u
M4352 N1153 N552 VDD VDD pmos W=0.205u L=0.04u
M4353 N1139 N366 VSS VSS nmos W=0.135u L=0.04u
M4354 N1139 N366 VDD VDD pmos W=0.205u L=0.04u
M4355 N1138 N348 VSS VSS nmos W=0.135u L=0.04u
M4356 N1138 N348 VDD VDD pmos W=0.205u L=0.04u
M4357 N1137 N545 VSS VSS nmos W=0.135u L=0.04u
M4358 N1137 N545 VDD VDD pmos W=0.205u L=0.04u
M4359 N0 U1098/net6 VSS VSS nmos W=0.155u L=0.04u
M4360 U1098/X_u2-net6 N1 VSS VSS nmos W=0.155u L=0.04u
M4361 U1098/net6 N373 U1098/X_u2-net6 VSS nmos W=0.155u L=0.04u
M4362 N0 U1098/net6 VDD VDD pmos W=0.205u L=0.04u
M4363 U1098/net6 N1 VDD VDD pmos W=0.205u L=0.04u
M4364 U1098/net6 N373 VDD VDD pmos W=0.205u L=0.04u
.ENDS
