.SUBCKT s510 CK cblank cclr cnt10 cnt13 cnt21 cnt261 cnt272 cnt283 cnt284 cnt44 cnt45 cnt509 cnt511 cnt567 cnt591 csm csync john pc pclr pcnt12 pcnt17 pcnt241 pcnt27 pcnt6 vsync VDD VSS
M1 II2 N58 VSS VSS nmos W=0.31u L=0.04u
M2 II2 N58 VDD VDD pmos W=0.41u L=0.04u
M3 II6 N57 VSS VSS nmos W=0.31u L=0.04u
M4 II6 N57 VDD VDD pmos W=0.41u L=0.04u
M5 II4 N53 VSS VSS nmos W=0.31u L=0.04u
M6 II4 N53 VDD VDD pmos W=0.41u L=0.04u
M7 II3 N50 VSS VSS nmos W=0.31u L=0.04u
M8 II3 N50 VDD VDD pmos W=0.41u L=0.04u
M9 II7 N60 VSS VSS nmos W=0.31u L=0.04u
M10 II7 N60 VDD VDD pmos W=0.41u L=0.04u
M11 II5 N55 VSS VSS nmos W=0.31u L=0.04u
M12 II5 N55 VDD VDD pmos W=0.41u L=0.04u
M13 U120/p2 n122 VSS VSS nmos W=0.155u L=0.04u
M14 U120/p0 n120 U120/p1 VSS nmos W=0.155u L=0.04u
M15 U120/p1 n121 U120/p2 VSS nmos W=0.155u L=0.04u
M16 vsync n119 U120/p0 VSS nmos W=0.155u L=0.04u
M17 vsync n121 VDD VDD pmos W=0.205u L=0.04u
M18 vsync n120 VDD VDD pmos W=0.205u L=0.04u
M19 vsync n119 VDD VDD pmos W=0.205u L=0.04u
M20 vsync n122 VDD VDD pmos W=0.205u L=0.04u
M21 U121/XU1-net6 n124 VSS VSS nmos W=0.155u L=0.04u
M22 n121 n123 U121/XU1-net6 VSS nmos W=0.155u L=0.04u
M23 n121 n124 VDD VDD pmos W=0.155u L=0.04u
M24 n121 n123 VDD VDD pmos W=0.155u L=0.04u
M25 U122/net19 n127 VSS VSS nmos W=0.155u L=0.04u
M26 n120 n127 U122/net40 VSS nmos W=0.155u L=0.04u
M27 n120 U122/net19 U122/net36 VSS nmos W=0.155u L=0.04u
M28 U122/net40 n126 VSS VSS nmos W=0.31u L=0.04u
M29 U122/net36 n125 VSS VSS nmos W=0.155u L=0.04u
M30 U122/net19 n127 VDD VDD pmos W=0.205u L=0.04u
M31 n120 U122/net19 U122/net26 VDD pmos W=0.325u L=0.04u
M32 U122/net26 n126 VDD VDD pmos W=0.41u L=0.04u
M33 n120 n127 U122/net30 VDD pmos W=0.325u L=0.04u
M34 U122/net30 n125 VDD VDD pmos W=0.205u L=0.04u
M35 U123/net19 n129 VSS VSS nmos W=0.155u L=0.04u
M36 n119 n129 U123/net40 VSS nmos W=0.155u L=0.04u
M37 n119 U123/net19 U123/net36 VSS nmos W=0.155u L=0.04u
M38 U123/net40 n128 VSS VSS nmos W=0.31u L=0.04u
M39 U123/net36 st_0 VSS VSS nmos W=0.155u L=0.04u
M40 U123/net19 n129 VDD VDD pmos W=0.205u L=0.04u
M41 n119 U123/net19 U123/net26 VDD pmos W=0.325u L=0.04u
M42 U123/net26 n128 VDD VDD pmos W=0.41u L=0.04u
M43 n119 n129 U123/net30 VDD pmos W=0.325u L=0.04u
M44 U123/net30 st_0 VDD VDD pmos W=0.205u L=0.04u
M45 U124/net8 n123 U124/net26 VSS nmos W=0.155u L=0.04u
M46 U124/net26 n132 VSS VSS nmos W=0.155u L=0.04u
M47 U124/net29 U124/net8 VSS VSS nmos W=0.155u L=0.04u
M48 U124/net29 n130 pclr VSS nmos W=0.155u L=0.04u
M49 U124/net29 n131 pclr VSS nmos W=0.155u L=0.04u
M50 U124/net8 n132 VDD VDD pmos W=0.205u L=0.04u
M51 U124/net8 n123 VDD VDD pmos W=0.205u L=0.04u
M52 pclr U124/net8 VDD VDD pmos W=0.205u L=0.04u
M53 pclr n130 U124/net20 VDD pmos W=0.205u L=0.04u
M54 U124/net20 n131 VDD VDD pmos W=0.205u L=0.04u
M55 U125/XU1-net6 n134 VSS VSS nmos W=0.155u L=0.04u
M56 pc n133 U125/XU1-net6 VSS nmos W=0.155u L=0.04u
M57 pc n134 VDD VDD pmos W=0.155u L=0.04u
M58 pc n133 VDD VDD pmos W=0.155u L=0.04u
M59 U126/net19 n130 VSS VSS nmos W=0.155u L=0.04u
M60 n133 n130 U126/net40 VSS nmos W=0.155u L=0.04u
M61 n133 U126/net19 U126/net36 VSS nmos W=0.155u L=0.04u
M62 U126/net40 n136 VSS VSS nmos W=0.31u L=0.04u
M63 U126/net36 n135 VSS VSS nmos W=0.155u L=0.04u
M64 U126/net19 n130 VDD VDD pmos W=0.205u L=0.04u
M65 n133 U126/net19 U126/net26 VDD pmos W=0.325u L=0.04u
M66 U126/net26 n136 VDD VDD pmos W=0.41u L=0.04u
M67 n133 n130 U126/net30 VDD pmos W=0.325u L=0.04u
M68 U126/net30 n135 VDD VDD pmos W=0.205u L=0.04u
M69 n135 n127 VSS VSS nmos W=0.155u L=0.04u
M70 n135 n137 VSS VSS nmos W=0.155u L=0.04u
M71 U127/XI1-net8 n137 VDD VDD pmos W=0.205u L=0.04u
M72 n135 n127 U127/XI1-net8 VDD pmos W=0.205u L=0.04u
M73 csync n137 U128/net26 VSS nmos W=0.155u L=0.04u
M74 csync st_1 U128/net26 VSS nmos W=0.155u L=0.04u
M75 U128/net29 n140 VSS VSS nmos W=0.155u L=0.04u
M76 U128/net26 n138 U128/net29 VSS nmos W=0.155u L=0.04u
M77 U128/net26 n139 U128/net29 VSS nmos W=0.155u L=0.04u
M78 csync st_1 U128/net43 VDD pmos W=0.205u L=0.04u
M79 csync n139 U128/net49 VDD pmos W=0.205u L=0.04u
M80 U128/net49 n138 VDD VDD pmos W=0.205u L=0.04u
M81 U128/net43 n137 VDD VDD pmos W=0.205u L=0.04u
M82 csync n140 VDD VDD pmos W=0.205u L=0.04u
M83 U129/net11 n141 n140 VDD pmos W=0.205u L=0.04u
M84 U129/net11 n123 n140 VDD pmos W=0.205u L=0.04u
M85 U129/net11 n142 U129/XI16-net11 VDD pmos W=0.205u L=0.04u
M86 U129/XI16-net11 n143 VDD VDD pmos W=0.205u L=0.04u
M87 n140 n143 VSS VSS nmos W=0.155u L=0.04u
M88 n140 n142 VSS VSS nmos W=0.155u L=0.04u
M89 n140 n141 U129/XI12-net17 VSS nmos W=0.155u L=0.04u
M90 U129/XI12-net17 n123 VSS VSS nmos W=0.155u L=0.04u
M91 n143 n144 U130/net19 VDD pmos W=0.205u L=0.04u
M92 n143 n145 U130/net19 VDD pmos W=0.205u L=0.04u
M93 n143 n130 U130/net19 VDD pmos W=0.205u L=0.04u
M94 U130/net19 st_0 VDD VDD pmos W=0.205u L=0.04u
M95 n143 st_0 VSS VSS nmos W=0.155u L=0.04u
M96 U130/XI20-net13 n145 VSS VSS nmos W=0.155u L=0.04u
M97 n143 n144 U130/XI20-net17 VSS nmos W=0.155u L=0.04u
M98 U130/XI20-net17 n130 U130/XI20-net13 VSS nmos W=0.155u L=0.04u
M99 U131/net29 n124 VSS VSS nmos W=0.155u L=0.04u
M100 n145 n146 U131/net29 VSS nmos W=0.155u L=0.04u
M101 n145 st_3 U131/net23 VSS nmos W=0.155u L=0.04u
M102 U131/net23 n138 VSS VSS nmos W=0.155u L=0.04u
M103 U131/net20 n138 n145 VDD pmos W=0.205u L=0.04u
M104 U131/net20 st_3 n145 VDD pmos W=0.205u L=0.04u
M105 VDD n146 U131/net20 VDD pmos W=0.205u L=0.04u
M106 VDD n124 U131/net20 VDD pmos W=0.205u L=0.04u
M107 csm n147 VSS VSS nmos W=0.155u L=0.04u
M108 csm n122 VSS VSS nmos W=0.155u L=0.04u
M109 U132/XI1-net8 n122 VDD VDD pmos W=0.205u L=0.04u
M110 csm n147 U132/XI1-net8 VDD pmos W=0.205u L=0.04u
M111 U133/net29 st_0 VSS VSS nmos W=0.155u L=0.04u
M112 n147 n148 U133/net29 VSS nmos W=0.155u L=0.04u
M113 n147 st_5 U133/net23 VSS nmos W=0.155u L=0.04u
M114 U133/net23 n123 VSS VSS nmos W=0.155u L=0.04u
M115 U133/net20 n123 n147 VDD pmos W=0.205u L=0.04u
M116 U133/net20 st_5 n147 VDD pmos W=0.205u L=0.04u
M117 VDD n148 U133/net20 VDD pmos W=0.205u L=0.04u
M118 VDD st_0 U133/net20 VDD pmos W=0.205u L=0.04u
M119 U134/p2 n149 VSS VSS nmos W=0.155u L=0.04u
M120 U134/p0 n137 U134/p1 VSS nmos W=0.155u L=0.04u
M121 U134/p1 n134 U134/p2 VSS nmos W=0.155u L=0.04u
M122 cclr n139 U134/p0 VSS nmos W=0.155u L=0.04u
M123 cclr n134 VDD VDD pmos W=0.205u L=0.04u
M124 cclr n137 VDD VDD pmos W=0.205u L=0.04u
M125 cclr n139 VDD VDD pmos W=0.205u L=0.04u
M126 cclr n149 VDD VDD pmos W=0.205u L=0.04u
M127 U135/net11 n150 n149 VDD pmos W=0.205u L=0.04u
M128 U135/net11 st_5 n149 VDD pmos W=0.205u L=0.04u
M129 U135/net11 n151 U135/XI16-net11 VDD pmos W=0.205u L=0.04u
M130 U135/XI16-net11 n152 VDD VDD pmos W=0.205u L=0.04u
M131 n149 n152 VSS VSS nmos W=0.155u L=0.04u
M132 n149 n151 VSS VSS nmos W=0.155u L=0.04u
M133 n149 n150 U135/XI12-net17 VSS nmos W=0.155u L=0.04u
M134 U135/XI12-net17 st_5 VSS VSS nmos W=0.155u L=0.04u
M135 n152 n130 U136/net27 VSS nmos W=0.155u L=0.04u
M136 U136/net27 n153 VSS VSS nmos W=0.155u L=0.04u
M137 n152 n154 VSS VSS nmos W=0.155u L=0.04u
M138 n152 n153 U136/net13 VDD pmos W=0.205u L=0.04u
M139 U136/net13 n154 VDD VDD pmos W=0.205u L=0.04u
M140 n152 n130 U136/net13 VDD pmos W=0.205u L=0.04u
M141 cblank n155 U137/net27 VSS nmos W=0.155u L=0.04u
M142 U137/net39 n157 VSS VSS nmos W=0.155u L=0.04u
M143 U137/net27 n156 U137/net39 VSS nmos W=0.155u L=0.04u
M144 U137/net27 n139 U137/net39 VSS nmos W=0.155u L=0.04u
M145 cblank st_0 U137/net27 VSS nmos W=0.155u L=0.04u
M146 U137/net39 n122 VSS VSS nmos W=0.155u L=0.04u
M147 cblank n157 U137/net46 VDD pmos W=0.205u L=0.04u
M148 U137/net46 n122 VDD VDD pmos W=0.205u L=0.04u
M149 cblank st_0 U137/net34 VDD pmos W=0.205u L=0.04u
M150 U137/net34 n155 VDD VDD pmos W=0.205u L=0.04u
M151 cblank n139 U137/net37 VDD pmos W=0.205u L=0.04u
M152 U137/net37 n156 VDD VDD pmos W=0.205u L=0.04u
M153 n156 st_4 U138/net27 VSS nmos W=0.155u L=0.04u
M154 U138/net27 n158 VSS VSS nmos W=0.155u L=0.04u
M155 n156 n159 VSS VSS nmos W=0.155u L=0.04u
M156 n156 n158 U138/net13 VDD pmos W=0.205u L=0.04u
M157 U138/net13 n159 VDD VDD pmos W=0.205u L=0.04u
M158 n156 st_4 U138/net13 VDD pmos W=0.205u L=0.04u
M159 N60 n163 VSS VSS nmos W=0.155u L=0.04u
M160 N60 n162 VSS VSS nmos W=0.155u L=0.04u
M161 N60 n161 VSS VSS nmos W=0.155u L=0.04u
M162 N60 n160 VSS VSS nmos W=0.155u L=0.04u
M163 U139/net49 n162 U139/net52 VDD pmos W=0.41u L=0.04u
M164 U139/net52 n163 VDD VDD pmos W=0.41u L=0.04u
M165 U139/net46 n161 U139/net49 VDD pmos W=0.41u L=0.04u
M166 N60 n160 U139/net46 VDD pmos W=0.41u L=0.04u
M167 U140/net19 n154 VSS VSS nmos W=0.155u L=0.04u
M168 n163 n154 U140/net40 VSS nmos W=0.155u L=0.04u
M169 n163 U140/net19 U140/net36 VSS nmos W=0.155u L=0.04u
M170 U140/net40 n165 VSS VSS nmos W=0.31u L=0.04u
M171 U140/net36 n164 VSS VSS nmos W=0.155u L=0.04u
M172 U140/net19 n154 VDD VDD pmos W=0.205u L=0.04u
M173 n163 U140/net19 U140/net26 VDD pmos W=0.325u L=0.04u
M174 U140/net26 n165 VDD VDD pmos W=0.41u L=0.04u
M175 n163 n154 U140/net30 VDD pmos W=0.325u L=0.04u
M176 U140/net30 n164 VDD VDD pmos W=0.205u L=0.04u
M177 n165 n166 U141/XI0-net10 VSS nmos W=0.155u L=0.04u
M178 U141/XI0-net10 st_5 U141/XI0-net13 VSS nmos W=0.155u L=0.04u
M179 U141/XI0-net13 cnt509 VSS VSS nmos W=0.155u L=0.04u
M180 n165 cnt509 VDD VDD pmos W=0.205u L=0.04u
M181 n165 n166 VDD VDD pmos W=0.205u L=0.04u
M182 n165 st_5 VDD VDD pmos W=0.205u L=0.04u
M183 U142/net7 n167 VSS VSS nmos W=0.155u L=0.04u
M184 U142/net7 n157 VSS VSS nmos W=0.155u L=0.04u
M185 U142/net7 cnt261 VSS VSS nmos W=0.155u L=0.04u
M186 n164 U142/net7 VSS VSS nmos W=0.155u L=0.04u
M187 U142/XU42-net9 cnt261 VDD VDD pmos W=0.205u L=0.04u
M188 U142/XU42-net12 n157 U142/XU42-net9 VDD pmos W=0.205u L=0.04u
M189 U142/net7 n167 U142/XU42-net12 VDD pmos W=0.205u L=0.04u
M190 n164 U142/net7 VDD VDD pmos W=0.205u L=0.04u
M191 U143/net19 n126 VSS VSS nmos W=0.155u L=0.04u
M192 n162 n126 U143/net40 VSS nmos W=0.155u L=0.04u
M193 n162 U143/net19 U143/net36 VSS nmos W=0.155u L=0.04u
M194 U143/net40 n169 VSS VSS nmos W=0.31u L=0.04u
M195 U143/net36 n168 VSS VSS nmos W=0.155u L=0.04u
M196 U143/net19 n126 VDD VDD pmos W=0.205u L=0.04u
M197 n162 U143/net19 U143/net26 VDD pmos W=0.325u L=0.04u
M198 U143/net26 n169 VDD VDD pmos W=0.41u L=0.04u
M199 n162 n126 U143/net30 VDD pmos W=0.325u L=0.04u
M200 U143/net30 n168 VDD VDD pmos W=0.205u L=0.04u
M201 U144/net36 n170 U144/net24 VSS nmos W=0.155u L=0.04u
M202 U144/net24 n171 VSS VSS nmos W=0.155u L=0.04u
M203 n169 st_4 U144/net36 VSS nmos W=0.155u L=0.04u
M204 n169 cnt10 U144/net36 VSS nmos W=0.155u L=0.04u
M205 n169 cnt10 U144/net35 VDD pmos W=0.205u L=0.04u
M206 U144/net35 st_4 VDD VDD pmos W=0.205u L=0.04u
M207 n169 n171 VDD VDD pmos W=0.205u L=0.04u
M208 n169 n170 VDD VDD pmos W=0.205u L=0.04u
M209 n171 st_3 VSS VSS nmos W=0.155u L=0.04u
M210 n171 n172 VSS VSS nmos W=0.155u L=0.04u
M211 U145/XI1-net8 n172 VDD VDD pmos W=0.205u L=0.04u
M212 n171 st_3 U145/XI1-net8 VDD pmos W=0.205u L=0.04u
M213 n172 cnt10 U146/net27 VSS nmos W=0.155u L=0.04u
M214 U146/net27 st_5 VSS VSS nmos W=0.155u L=0.04u
M215 n172 john VSS VSS nmos W=0.155u L=0.04u
M216 n172 st_5 U146/net13 VDD pmos W=0.205u L=0.04u
M217 U146/net13 john VDD VDD pmos W=0.205u L=0.04u
M218 n172 cnt10 U146/net13 VDD pmos W=0.205u L=0.04u
M219 U147/net14 n174 U147/net20 VSS nmos W=0.155u L=0.04u
M220 U147/net14 n173 U147/net20 VSS nmos W=0.155u L=0.04u
M221 U147/net20 n175 VSS VSS nmos W=0.155u L=0.04u
M222 n168 U147/net14 VSS VSS nmos W=0.155u L=0.04u
M223 n168 U147/net14 VDD VDD pmos W=0.205u L=0.04u
M224 U147/net14 n175 VDD VDD pmos W=0.205u L=0.04u
M225 U147/net24 n174 VDD VDD pmos W=0.205u L=0.04u
M226 U147/net14 n173 U147/net24 VDD pmos W=0.205u L=0.04u
M227 U148/net40 n150 n175 VDD pmos W=0.205u L=0.04u
M228 U148/net40 cnt284 n175 VDD pmos W=0.205u L=0.04u
M229 VDD cnt511 U148/net40 VDD pmos W=0.205u L=0.04u
M230 VDD n170 U148/net40 VDD pmos W=0.205u L=0.04u
M231 U148/net40 pcnt6 n175 VDD pmos W=0.205u L=0.04u
M232 VDD st_3 U148/net40 VDD pmos W=0.205u L=0.04u
M233 U148/XI13-net13 pcnt6 VSS VSS nmos W=0.155u L=0.04u
M234 n175 cnt284 U148/XI13-net17 VSS nmos W=0.155u L=0.04u
M235 U148/XI13-net17 n150 U148/XI13-net13 VSS nmos W=0.155u L=0.04u
M236 U148/XI7-net13 cnt511 VSS VSS nmos W=0.155u L=0.04u
M237 n175 n170 U148/XI7-net17 VSS nmos W=0.155u L=0.04u
M238 U148/XI7-net17 st_3 U148/XI7-net13 VSS nmos W=0.155u L=0.04u
M239 U149/net19 n122 VSS VSS nmos W=0.155u L=0.04u
M240 n161 n122 U149/net40 VSS nmos W=0.155u L=0.04u
M241 n161 U149/net19 U149/net36 VSS nmos W=0.155u L=0.04u
M242 U149/net40 n177 VSS VSS nmos W=0.31u L=0.04u
M243 U149/net36 n176 VSS VSS nmos W=0.155u L=0.04u
M244 U149/net19 n122 VDD VDD pmos W=0.205u L=0.04u
M245 n161 U149/net19 U149/net26 VDD pmos W=0.325u L=0.04u
M246 U149/net26 n177 VDD VDD pmos W=0.41u L=0.04u
M247 n161 n122 U149/net30 VDD pmos W=0.325u L=0.04u
M248 U149/net30 n176 VDD VDD pmos W=0.205u L=0.04u
M249 U150/net13 n146 VSS VSS nmos W=0.155u L=0.04u
M250 U150/net16 U150/net13 VSS VSS nmos W=0.155u L=0.04u
M251 n177 n141 U150/net16 VSS nmos W=0.155u L=0.04u
M252 U150/net13 n146 VDD VDD pmos W=0.205u L=0.04u
M253 VDD U150/net13 n177 VDD pmos W=0.205u L=0.04u
M254 VDD n141 n177 VDD pmos W=0.205u L=0.04u
M255 U151/net36 n129 U151/net24 VSS nmos W=0.155u L=0.04u
M256 U151/net24 n178 VSS VSS nmos W=0.155u L=0.04u
M257 n176 st_2 U151/net36 VSS nmos W=0.155u L=0.04u
M258 n176 cnt591 U151/net36 VSS nmos W=0.155u L=0.04u
M259 n176 cnt591 U151/net35 VDD pmos W=0.205u L=0.04u
M260 U151/net35 st_2 VDD VDD pmos W=0.205u L=0.04u
M261 n176 n178 VDD VDD pmos W=0.205u L=0.04u
M262 n176 n129 VDD VDD pmos W=0.205u L=0.04u
M263 n178 n179 VSS VSS nmos W=0.155u L=0.04u
M264 n178 n126 VSS VSS nmos W=0.155u L=0.04u
M265 U152/XI1-net8 n126 VDD VDD pmos W=0.205u L=0.04u
M266 n178 n179 U152/XI1-net8 VDD pmos W=0.205u L=0.04u
M267 n179 cnt272 U153/net27 VSS nmos W=0.155u L=0.04u
M268 U153/net27 n154 VSS VSS nmos W=0.155u L=0.04u
M269 n179 n128 VSS VSS nmos W=0.155u L=0.04u
M270 n179 n154 U153/net13 VDD pmos W=0.205u L=0.04u
M271 U153/net13 n128 VDD VDD pmos W=0.205u L=0.04u
M272 n179 cnt272 U153/net13 VDD pmos W=0.205u L=0.04u
M273 n160 n124 U154/net26 VSS nmos W=0.155u L=0.04u
M274 n160 n180 U154/net26 VSS nmos W=0.155u L=0.04u
M275 U154/net29 n182 VSS VSS nmos W=0.155u L=0.04u
M276 U154/net26 n137 U154/net29 VSS nmos W=0.155u L=0.04u
M277 U154/net26 n181 U154/net29 VSS nmos W=0.155u L=0.04u
M278 n160 n180 U154/net43 VDD pmos W=0.205u L=0.04u
M279 n160 n181 U154/net49 VDD pmos W=0.205u L=0.04u
M280 U154/net49 n137 VDD VDD pmos W=0.205u L=0.04u
M281 U154/net43 n124 VDD VDD pmos W=0.205u L=0.04u
M282 n160 n182 VDD VDD pmos W=0.205u L=0.04u
M283 U155/net19 n129 VSS VSS nmos W=0.155u L=0.04u
M284 n182 n129 U155/net40 VSS nmos W=0.155u L=0.04u
M285 n182 U155/net19 U155/net36 VSS nmos W=0.155u L=0.04u
M286 U155/net40 n184 VSS VSS nmos W=0.31u L=0.04u
M287 U155/net36 n183 VSS VSS nmos W=0.155u L=0.04u
M288 U155/net19 n129 VDD VDD pmos W=0.205u L=0.04u
M289 n182 U155/net19 U155/net26 VDD pmos W=0.325u L=0.04u
M290 U155/net26 n184 VDD VDD pmos W=0.41u L=0.04u
M291 n182 n129 U155/net30 VDD pmos W=0.325u L=0.04u
M292 U155/net30 n183 VDD VDD pmos W=0.205u L=0.04u
M293 U156/net11 n185 n184 VDD pmos W=0.205u L=0.04u
M294 U156/net11 n186 n184 VDD pmos W=0.205u L=0.04u
M295 U156/net11 n187 U156/XI16-net11 VDD pmos W=0.205u L=0.04u
M296 U156/XI16-net11 n188 VDD VDD pmos W=0.205u L=0.04u
M297 n184 n188 VSS VSS nmos W=0.155u L=0.04u
M298 n184 n187 VSS VSS nmos W=0.155u L=0.04u
M299 n184 n185 U156/XI12-net17 VSS nmos W=0.155u L=0.04u
M300 U156/XI12-net17 n186 VSS VSS nmos W=0.155u L=0.04u
M301 n187 cnt45 VSS VSS nmos W=0.135u L=0.04u
M302 n187 cnt45 VDD VDD pmos W=0.205u L=0.04u
M303 U158/XU1-net6 st_3 VSS VSS nmos W=0.155u L=0.04u
M304 n186 st_4 U158/XU1-net6 VSS nmos W=0.155u L=0.04u
M305 n186 st_3 VDD VDD pmos W=0.155u L=0.04u
M306 n186 st_4 VDD VDD pmos W=0.155u L=0.04u
M307 U159/net11 n189 n183 VDD pmos W=0.205u L=0.04u
M308 U159/net11 n185 n183 VDD pmos W=0.205u L=0.04u
M309 U159/net11 n190 U159/XI16-net11 VDD pmos W=0.205u L=0.04u
M310 U159/XI16-net11 n188 VDD VDD pmos W=0.205u L=0.04u
M311 n183 n188 VSS VSS nmos W=0.155u L=0.04u
M312 n183 n190 VSS VSS nmos W=0.155u L=0.04u
M313 n183 n189 U159/XI12-net17 VSS nmos W=0.155u L=0.04u
M314 U159/XI12-net17 n185 VSS VSS nmos W=0.155u L=0.04u
M315 U160/XU1-net6 n122 VSS VSS nmos W=0.155u L=0.04u
M316 n189 n124 U160/XU1-net6 VSS nmos W=0.155u L=0.04u
M317 n189 n122 VDD VDD pmos W=0.155u L=0.04u
M318 n189 n124 VDD VDD pmos W=0.155u L=0.04u
M319 n180 n192 VSS VSS nmos W=0.155u L=0.04u
M320 n180 cnt45 U161/XI17-net17 VSS nmos W=0.155u L=0.04u
M321 U161/XI17-net17 n150 VSS VSS nmos W=0.155u L=0.04u
M322 n180 cnt283 U161/XI10-net17 VSS nmos W=0.155u L=0.04u
M323 U161/XI10-net17 n191 VSS VSS nmos W=0.155u L=0.04u
M324 U161/net30 cnt283 n180 VDD pmos W=0.205u L=0.04u
M325 U161/net30 n191 n180 VDD pmos W=0.205u L=0.04u
M326 VDD n192 U161/net36 VDD pmos W=0.205u L=0.04u
M327 U161/net36 n150 U161/net30 VDD pmos W=0.205u L=0.04u
M328 U161/net36 cnt45 U161/net30 VDD pmos W=0.205u L=0.04u
M329 VSS n195 U162/net22 VSS nmos W=0.155u L=0.04u
M330 U162/net22 n194 n192 VSS nmos W=0.155u L=0.04u
M331 U162/net22 n122 n192 VSS nmos W=0.155u L=0.04u
M332 U162/net22 n193 n192 VSS nmos W=0.155u L=0.04u
M333 U162/net38 n193 VDD VDD pmos W=0.205u L=0.04u
M334 U162/net35 n122 U162/net38 VDD pmos W=0.205u L=0.04u
M335 n192 n194 U162/net35 VDD pmos W=0.205u L=0.04u
M336 n192 n195 VDD VDD pmos W=0.205u L=0.04u
M337 n195 n196 U163/net15 VSS nmos W=0.155u L=0.04u
M338 n195 n166 U163/net15 VSS nmos W=0.155u L=0.04u
M339 U163/net15 cnt21 VSS VSS nmos W=0.155u L=0.04u
M340 n195 cnt21 VDD VDD pmos W=0.205u L=0.04u
M341 n195 n196 U163/XI16-net11 VDD pmos W=0.205u L=0.04u
M342 U163/XI16-net11 n166 VDD VDD pmos W=0.205u L=0.04u
M343 n193 cnt10 VSS VSS nmos W=0.135u L=0.04u
M344 n193 cnt10 VDD VDD pmos W=0.205u L=0.04u
M345 n150 n167 VSS VSS nmos W=0.155u L=0.04u
M346 n150 st_0 VSS VSS nmos W=0.155u L=0.04u
M347 n150 n127 VSS VSS nmos W=0.155u L=0.04u
M348 U165/net25 n167 VDD VDD pmos W=0.41u L=0.04u
M349 U165/net28 st_0 U165/net25 VDD pmos W=0.41u L=0.04u
M350 n150 n127 U165/net28 VDD pmos W=0.41u L=0.04u
M351 N58 n197 VSS VSS nmos W=0.155u L=0.04u
M352 N58 n198 VSS VSS nmos W=0.155u L=0.04u
M353 U166/XI1-net8 n198 VDD VDD pmos W=0.205u L=0.04u
M354 N58 n197 U166/XI1-net8 VDD pmos W=0.205u L=0.04u
M355 U167/net15 st_4 VSS VSS nmos W=0.155u L=0.04u
M356 U167/net15 n167 VSS VSS nmos W=0.155u L=0.04u
M357 n198 n199 U167/net15 VSS nmos W=0.155u L=0.04u
M358 n198 n170 U167/net15 VSS nmos W=0.155u L=0.04u
M359 U167/net15 n139 VSS VSS nmos W=0.155u L=0.04u
M360 n198 n185 U167/net15 VSS nmos W=0.155u L=0.04u
M361 n198 n139 U167/XI1-net11 VDD pmos W=0.205u L=0.04u
M362 U167/XI1-net11 st_4 U167/XI1-net18 VDD pmos W=0.205u L=0.04u
M363 U167/XI1-net18 n167 VDD VDD pmos W=0.205u L=0.04u
M364 n198 n199 U167/XI7-net11 VDD pmos W=0.205u L=0.04u
M365 U167/XI7-net11 n170 U167/XI7-net18 VDD pmos W=0.205u L=0.04u
M366 U167/XI7-net18 n185 VDD VDD pmos W=0.205u L=0.04u
M367 U168/XU1-net6 n122 VSS VSS nmos W=0.155u L=0.04u
M368 n167 n129 U168/XU1-net6 VSS nmos W=0.155u L=0.04u
M369 n167 n122 VDD VDD pmos W=0.155u L=0.04u
M370 n167 n129 VDD VDD pmos W=0.155u L=0.04u
M371 n199 st_3 VSS VSS nmos W=0.155u L=0.04u
M372 n199 n128 VSS VSS nmos W=0.155u L=0.04u
M373 U169/XI1-net8 n128 VDD VDD pmos W=0.205u L=0.04u
M374 n199 st_3 U169/XI1-net8 VDD pmos W=0.205u L=0.04u
M375 U170/net19 n154 VSS VSS nmos W=0.155u L=0.04u
M376 n197 n154 U170/net40 VSS nmos W=0.155u L=0.04u
M377 n197 U170/net19 U170/net36 VSS nmos W=0.155u L=0.04u
M378 U170/net40 n201 VSS VSS nmos W=0.31u L=0.04u
M379 U170/net36 n200 VSS VSS nmos W=0.155u L=0.04u
M380 U170/net19 n154 VDD VDD pmos W=0.205u L=0.04u
M381 n197 U170/net19 U170/net26 VDD pmos W=0.325u L=0.04u
M382 U170/net26 n201 VDD VDD pmos W=0.41u L=0.04u
M383 n197 n154 U170/net30 VDD pmos W=0.325u L=0.04u
M384 U170/net30 n200 VDD VDD pmos W=0.205u L=0.04u
M385 U171/XU1-net6 n122 VSS VSS nmos W=0.155u L=0.04u
M386 n201 n159 U171/XU1-net6 VSS nmos W=0.155u L=0.04u
M387 n201 n122 VDD VDD pmos W=0.155u L=0.04u
M388 n201 n159 VDD VDD pmos W=0.155u L=0.04u
M389 n200 n158 U172/net27 VSS nmos W=0.155u L=0.04u
M390 U172/net27 st_2 VSS VSS nmos W=0.155u L=0.04u
M391 n200 n148 VSS VSS nmos W=0.155u L=0.04u
M392 n200 st_2 U172/net13 VDD pmos W=0.205u L=0.04u
M393 U172/net13 n148 VDD VDD pmos W=0.205u L=0.04u
M394 n200 n158 U172/net13 VDD pmos W=0.205u L=0.04u
M395 U173/net11 n132 N57 VDD pmos W=0.205u L=0.04u
M396 U173/net11 st_2 N57 VDD pmos W=0.205u L=0.04u
M397 U173/net11 n202 U173/XI16-net11 VDD pmos W=0.205u L=0.04u
M398 U173/XI16-net11 n203 VDD VDD pmos W=0.205u L=0.04u
M399 N57 n203 VSS VSS nmos W=0.155u L=0.04u
M400 N57 n202 VSS VSS nmos W=0.155u L=0.04u
M401 N57 n132 U173/XI12-net17 VSS nmos W=0.155u L=0.04u
M402 U173/XI12-net17 st_2 VSS VSS nmos W=0.155u L=0.04u
M403 n203 n185 U174/net14 VSS nmos W=0.155u L=0.04u
M404 U174/net14 n173 VSS VSS nmos W=0.155u L=0.04u
M405 U174/net14 n204 VSS VSS nmos W=0.155u L=0.04u
M406 n203 n139 U174/net14 VSS nmos W=0.155u L=0.04u
M407 n203 n158 U174/net14 VSS nmos W=0.155u L=0.04u
M408 n203 n173 U174/XI16-net11 VDD pmos W=0.205u L=0.04u
M409 U174/XI16-net11 n204 VDD VDD pmos W=0.205u L=0.04u
M410 n203 n139 U174/XI15-net11 VDD pmos W=0.205u L=0.04u
M411 U174/XI15-net11 n158 U174/XI15-net18 VDD pmos W=0.205u L=0.04u
M412 U174/XI15-net18 n185 VDD VDD pmos W=0.205u L=0.04u
M413 n173 n191 VSS VSS nmos W=0.135u L=0.04u
M414 n173 n191 VDD VDD pmos W=0.205u L=0.04u
M415 n191 n130 VSS VSS nmos W=0.155u L=0.04u
M416 n191 n188 VSS VSS nmos W=0.155u L=0.04u
M417 U176/XI1-net8 n188 VDD VDD pmos W=0.205u L=0.04u
M418 n191 n130 U176/XI1-net8 VDD pmos W=0.205u L=0.04u
M419 n204 pcnt27 VSS VSS nmos W=0.155u L=0.04u
M420 n204 n174 VSS VSS nmos W=0.155u L=0.04u
M421 U177/XI1-net8 n174 VDD VDD pmos W=0.205u L=0.04u
M422 n204 pcnt27 U177/XI1-net8 VDD pmos W=0.205u L=0.04u
M423 n174 cnt567 VSS VSS nmos W=0.135u L=0.04u
M424 n174 cnt567 VDD VDD pmos W=0.205u L=0.04u
M425 U179/net30 n205 VSS VSS nmos W=0.155u L=0.04u
M426 n202 n207 U179/net23 VSS nmos W=0.155u L=0.04u
M427 U179/net20 U179/net30 VSS VSS nmos W=0.155u L=0.04u
M428 U179/net23 n206 U179/net20 VSS nmos W=0.155u L=0.04u
M429 U179/net30 n205 VDD VDD pmos W=0.205u L=0.04u
M430 VDD n207 n202 VDD pmos W=0.205u L=0.04u
M431 VDD n206 n202 VDD pmos W=0.205u L=0.04u
M432 VDD U179/net30 n202 VDD pmos W=0.205u L=0.04u
M433 U180/net19 n129 VSS VSS nmos W=0.155u L=0.04u
M434 n207 n129 U180/net40 VSS nmos W=0.155u L=0.04u
M435 n207 U180/net19 U180/net36 VSS nmos W=0.155u L=0.04u
M436 U180/net40 n209 VSS VSS nmos W=0.31u L=0.04u
M437 U180/net36 n208 VSS VSS nmos W=0.155u L=0.04u
M438 U180/net19 n129 VDD VDD pmos W=0.205u L=0.04u
M439 n207 U180/net19 U180/net26 VDD pmos W=0.325u L=0.04u
M440 U180/net26 n209 VDD VDD pmos W=0.41u L=0.04u
M441 n207 n129 U180/net30 VDD pmos W=0.325u L=0.04u
M442 U180/net30 n208 VDD VDD pmos W=0.205u L=0.04u
M443 n209 n122 VSS VSS nmos W=0.155u L=0.04u
M444 n209 n137 VSS VSS nmos W=0.155u L=0.04u
M445 U181/XI1-net8 n137 VDD VDD pmos W=0.205u L=0.04u
M446 n209 n122 U181/XI1-net8 VDD pmos W=0.205u L=0.04u
M447 n208 st_0 U182/net10 VSS nmos W=0.155u L=0.04u
M448 U182/net10 n211 VSS VSS nmos W=0.155u L=0.04u
M449 n208 n138 U182/net10 VSS nmos W=0.155u L=0.04u
M450 U182/net10 n210 VSS VSS nmos W=0.155u L=0.04u
M451 U182/net30 n211 VDD VDD pmos W=0.205u L=0.04u
M452 n208 st_0 U182/net24 VDD pmos W=0.205u L=0.04u
M453 U182/net24 n138 VDD VDD pmos W=0.205u L=0.04u
M454 n208 n210 U182/net30 VDD pmos W=0.205u L=0.04u
M455 n211 n196 VSS VSS nmos W=0.135u L=0.04u
M456 n211 n196 VDD VDD pmos W=0.205u L=0.04u
M457 n210 pcnt12 VSS VSS nmos W=0.155u L=0.04u
M458 n210 n190 VSS VSS nmos W=0.155u L=0.04u
M459 U184/XI1-net8 n190 VDD VDD pmos W=0.205u L=0.04u
M460 n210 pcnt12 U184/XI1-net8 VDD pmos W=0.205u L=0.04u
M461 n190 cnt44 VSS VSS nmos W=0.135u L=0.04u
M462 n190 cnt44 VDD VDD pmos W=0.205u L=0.04u
M463 U186/net19 n154 VSS VSS nmos W=0.155u L=0.04u
M464 n206 n154 U186/net40 VSS nmos W=0.155u L=0.04u
M465 n206 U186/net19 U186/net36 VSS nmos W=0.155u L=0.04u
M466 U186/net40 n213 VSS VSS nmos W=0.31u L=0.04u
M467 U186/net36 n212 VSS VSS nmos W=0.155u L=0.04u
M468 U186/net19 n154 VDD VDD pmos W=0.205u L=0.04u
M469 n206 U186/net19 U186/net26 VDD pmos W=0.325u L=0.04u
M470 U186/net26 n213 VDD VDD pmos W=0.41u L=0.04u
M471 n206 n154 U186/net30 VDD pmos W=0.325u L=0.04u
M472 U186/net30 n212 VDD VDD pmos W=0.205u L=0.04u
M473 n213 n134 VSS VSS nmos W=0.135u L=0.04u
M474 n213 n134 VDD VDD pmos W=0.205u L=0.04u
M475 n134 n138 U188/XI0-net10 VSS nmos W=0.155u L=0.04u
M476 U188/XI0-net10 n122 U188/XI0-net13 VSS nmos W=0.155u L=0.04u
M477 U188/XI0-net13 n214 VSS VSS nmos W=0.155u L=0.04u
M478 n134 n214 VDD VDD pmos W=0.205u L=0.04u
M479 n134 n138 VDD VDD pmos W=0.205u L=0.04u
M480 n134 n122 VDD VDD pmos W=0.205u L=0.04u
M481 VSS n155 U189/net22 VSS nmos W=0.155u L=0.04u
M482 U189/net22 st_3 n212 VSS nmos W=0.155u L=0.04u
M483 U189/net22 st_5 n212 VSS nmos W=0.155u L=0.04u
M484 U189/net22 n215 n212 VSS nmos W=0.155u L=0.04u
M485 U189/net38 n215 VDD VDD pmos W=0.205u L=0.04u
M486 U189/net35 st_5 U189/net38 VDD pmos W=0.205u L=0.04u
M487 n212 st_3 U189/net35 VDD pmos W=0.205u L=0.04u
M488 n212 n155 VDD VDD pmos W=0.205u L=0.04u
M489 n215 n216 U190/net15 VSS nmos W=0.155u L=0.04u
M490 n215 n217 U190/net15 VSS nmos W=0.155u L=0.04u
M491 U190/net15 n123 VSS VSS nmos W=0.155u L=0.04u
M492 n215 n123 VDD VDD pmos W=0.205u L=0.04u
M493 n215 n216 U190/XI16-net11 VDD pmos W=0.205u L=0.04u
M494 U190/XI16-net11 n217 VDD VDD pmos W=0.205u L=0.04u
M495 U191/net19 n122 VSS VSS nmos W=0.155u L=0.04u
M496 n205 n122 U191/net40 VSS nmos W=0.155u L=0.04u
M497 n205 U191/net19 U191/net36 VSS nmos W=0.155u L=0.04u
M498 U191/net40 n219 VSS VSS nmos W=0.31u L=0.04u
M499 U191/net36 n218 VSS VSS nmos W=0.155u L=0.04u
M500 U191/net19 n122 VDD VDD pmos W=0.205u L=0.04u
M501 n205 U191/net19 U191/net26 VDD pmos W=0.325u L=0.04u
M502 U191/net26 n219 VDD VDD pmos W=0.41u L=0.04u
M503 n205 n122 U191/net30 VDD pmos W=0.325u L=0.04u
M504 U191/net30 n218 VDD VDD pmos W=0.205u L=0.04u
M505 U192/net17 cnt13 VSS VSS nmos W=0.155u L=0.04u
M506 U192/net17 n194 VSS VSS nmos W=0.155u L=0.04u
M507 U192/net63 n154 VSS VSS nmos W=0.155u L=0.04u
M508 n219 U192/net17 VSS VSS nmos W=0.155u L=0.04u
M509 n219 n148 U192/net63 VSS nmos W=0.155u L=0.04u
M510 n219 n154 U192/net31 VDD pmos W=0.205u L=0.04u
M511 U192/net39 cnt13 VDD VDD pmos W=0.195u L=0.04u
M512 U192/net31 U192/net17 VDD VDD pmos W=0.195u L=0.04u
M513 n219 n148 U192/net31 VDD pmos W=0.195u L=0.04u
M514 U192/net17 n194 U192/net39 VDD pmos W=0.195u L=0.04u
M515 n218 pcnt241 U193/net15 VSS nmos W=0.155u L=0.04u
M516 n218 n220 U193/net15 VSS nmos W=0.155u L=0.04u
M517 U193/net15 n170 VSS VSS nmos W=0.155u L=0.04u
M518 n218 n170 VDD VDD pmos W=0.205u L=0.04u
M519 n218 pcnt241 U193/XI16-net11 VDD pmos W=0.205u L=0.04u
M520 U193/XI16-net11 n220 VDD VDD pmos W=0.205u L=0.04u
M521 n220 cnt511 VSS VSS nmos W=0.135u L=0.04u
M522 n220 cnt511 VDD VDD pmos W=0.205u L=0.04u
M523 N55 n224 VSS VSS nmos W=0.155u L=0.04u
M524 N55 n223 VSS VSS nmos W=0.155u L=0.04u
M525 N55 n222 VSS VSS nmos W=0.155u L=0.04u
M526 N55 n221 VSS VSS nmos W=0.155u L=0.04u
M527 U195/net49 n223 U195/net52 VDD pmos W=0.41u L=0.04u
M528 U195/net52 n224 VDD VDD pmos W=0.41u L=0.04u
M529 U195/net46 n222 U195/net49 VDD pmos W=0.41u L=0.04u
M530 N55 n221 U195/net46 VDD pmos W=0.41u L=0.04u
M531 U196/net15 st_0 VSS VSS nmos W=0.155u L=0.04u
M532 U196/net15 n127 VSS VSS nmos W=0.155u L=0.04u
M533 n224 n225 U196/net15 VSS nmos W=0.155u L=0.04u
M534 n224 st_3 U196/net15 VSS nmos W=0.155u L=0.04u
M535 U196/net15 n226 VSS VSS nmos W=0.155u L=0.04u
M536 n224 n129 U196/net15 VSS nmos W=0.155u L=0.04u
M537 n224 n226 U196/XI1-net11 VDD pmos W=0.205u L=0.04u
M538 U196/XI1-net11 st_0 U196/XI1-net18 VDD pmos W=0.205u L=0.04u
M539 U196/XI1-net18 n127 VDD VDD pmos W=0.205u L=0.04u
M540 n224 n225 U196/XI7-net11 VDD pmos W=0.205u L=0.04u
M541 U196/XI7-net11 st_3 U196/XI7-net18 VDD pmos W=0.205u L=0.04u
M542 U196/XI7-net18 n129 VDD VDD pmos W=0.205u L=0.04u
M543 n226 n125 U197/net27 VSS nmos W=0.155u L=0.04u
M544 U197/net27 n216 VSS VSS nmos W=0.155u L=0.04u
M545 n226 st_4 VSS VSS nmos W=0.155u L=0.04u
M546 n226 n216 U197/net13 VDD pmos W=0.205u L=0.04u
M547 U197/net13 st_4 VDD VDD pmos W=0.205u L=0.04u
M548 n226 n125 U197/net13 VDD pmos W=0.205u L=0.04u
M549 n216 cnt284 VSS VSS nmos W=0.135u L=0.04u
M550 n216 cnt284 VDD VDD pmos W=0.205u L=0.04u
M551 n225 n227 VSS VSS nmos W=0.155u L=0.04u
M552 n225 U199/net4 VSS VSS nmos W=0.155u L=0.04u
M553 U199/net4 n137 VSS VSS nmos W=0.155u L=0.04u
M554 U199/XU1-net8 U199/net4 VDD VDD pmos W=0.205u L=0.04u
M555 n225 n227 U199/XU1-net8 VDD pmos W=0.205u L=0.04u
M556 U199/net4 n137 VDD VDD pmos W=0.205u L=0.04u
M557 U200/net11 cnt284 n227 VDD pmos W=0.205u L=0.04u
M558 U200/net11 n217 n227 VDD pmos W=0.205u L=0.04u
M559 U200/net11 n154 U200/XI16-net11 VDD pmos W=0.205u L=0.04u
M560 U200/XI16-net11 st_5 VDD VDD pmos W=0.205u L=0.04u
M561 n227 st_5 VSS VSS nmos W=0.155u L=0.04u
M562 n227 n154 VSS VSS nmos W=0.155u L=0.04u
M563 n227 cnt284 U200/XI12-net17 VSS nmos W=0.155u L=0.04u
M564 U200/XI12-net17 n217 VSS VSS nmos W=0.155u L=0.04u
M565 n217 pcnt17 VSS VSS nmos W=0.135u L=0.04u
M566 n217 pcnt17 VDD VDD pmos W=0.205u L=0.04u
M567 U202/net19 n129 VSS VSS nmos W=0.155u L=0.04u
M568 n223 n129 U202/net40 VSS nmos W=0.155u L=0.04u
M569 n223 U202/net19 U202/net36 VSS nmos W=0.155u L=0.04u
M570 U202/net40 n131 VSS VSS nmos W=0.31u L=0.04u
M571 U202/net36 n228 VSS VSS nmos W=0.155u L=0.04u
M572 U202/net19 n129 VDD VDD pmos W=0.205u L=0.04u
M573 n223 U202/net19 U202/net26 VDD pmos W=0.325u L=0.04u
M574 U202/net26 n131 VDD VDD pmos W=0.41u L=0.04u
M575 n223 n129 U202/net30 VDD pmos W=0.325u L=0.04u
M576 U202/net30 n228 VDD VDD pmos W=0.205u L=0.04u
M577 n131 n136 VSS VSS nmos W=0.135u L=0.04u
M578 n131 n136 VDD VDD pmos W=0.205u L=0.04u
M579 n136 n126 VSS VSS nmos W=0.155u L=0.04u
M580 n136 n139 VSS VSS nmos W=0.155u L=0.04u
M581 U204/XI1-net8 n139 VDD VDD pmos W=0.205u L=0.04u
M582 n136 n126 U204/XI1-net8 VDD pmos W=0.205u L=0.04u
M583 U205/XU1-net6 n230 VSS VSS nmos W=0.155u L=0.04u
M584 n228 n229 U205/XU1-net6 VSS nmos W=0.155u L=0.04u
M585 n228 n230 VDD VDD pmos W=0.155u L=0.04u
M586 n228 n229 VDD VDD pmos W=0.155u L=0.04u
M587 n222 cnt13 U206/net10 VSS nmos W=0.155u L=0.04u
M588 U206/net10 n185 VSS VSS nmos W=0.155u L=0.04u
M589 n222 n194 U206/net10 VSS nmos W=0.155u L=0.04u
M590 U206/net10 n231 VSS VSS nmos W=0.155u L=0.04u
M591 U206/net30 n185 VDD VDD pmos W=0.205u L=0.04u
M592 n222 cnt13 U206/net24 VDD pmos W=0.205u L=0.04u
M593 U206/net24 n194 VDD VDD pmos W=0.205u L=0.04u
M594 n222 n231 U206/net30 VDD pmos W=0.205u L=0.04u
M595 n231 n146 U207/net27 VSS nmos W=0.155u L=0.04u
M596 U207/net27 st_0 VSS VSS nmos W=0.155u L=0.04u
M597 n231 n170 VSS VSS nmos W=0.155u L=0.04u
M598 n231 st_0 U207/net13 VDD pmos W=0.205u L=0.04u
M599 U207/net13 n170 VDD VDD pmos W=0.205u L=0.04u
M600 n231 n146 U207/net13 VDD pmos W=0.205u L=0.04u
M601 n170 n194 VSS VSS nmos W=0.135u L=0.04u
M602 n170 n194 VDD VDD pmos W=0.205u L=0.04u
M603 U209/XU1-net6 n154 VSS VSS nmos W=0.155u L=0.04u
M604 n194 n123 U209/XU1-net6 VSS nmos W=0.155u L=0.04u
M605 n194 n154 VDD VDD pmos W=0.155u L=0.04u
M606 n194 n123 VDD VDD pmos W=0.155u L=0.04u
M607 U210/XU1-net6 n155 VSS VSS nmos W=0.155u L=0.04u
M608 n221 n181 U210/XU1-net6 VSS nmos W=0.155u L=0.04u
M609 n221 n155 VDD VDD pmos W=0.155u L=0.04u
M610 n221 n181 VDD VDD pmos W=0.155u L=0.04u
M611 n155 n142 VSS VSS nmos W=0.135u L=0.04u
M612 n155 n142 VDD VDD pmos W=0.205u L=0.04u
M613 n181 n166 VSS VSS nmos W=0.135u L=0.04u
M614 n181 n166 VDD VDD pmos W=0.205u L=0.04u
M615 n166 n122 VSS VSS nmos W=0.155u L=0.04u
M616 n166 st_1 VSS VSS nmos W=0.155u L=0.04u
M617 n166 n127 VSS VSS nmos W=0.155u L=0.04u
M618 U213/net25 n122 VDD VDD pmos W=0.41u L=0.04u
M619 U213/net28 st_1 U213/net25 VDD pmos W=0.41u L=0.04u
M620 n166 n127 U213/net28 VDD pmos W=0.41u L=0.04u
M621 U214/net11 st_3 N53 VDD pmos W=0.205u L=0.04u
M622 U214/net11 n232 N53 VDD pmos W=0.205u L=0.04u
M623 U214/net11 n233 U214/XI16-net11 VDD pmos W=0.205u L=0.04u
M624 U214/XI16-net11 n151 VDD VDD pmos W=0.205u L=0.04u
M625 N53 n151 VSS VSS nmos W=0.155u L=0.04u
M626 N53 n233 VSS VSS nmos W=0.155u L=0.04u
M627 N53 st_3 U214/XI12-net17 VSS nmos W=0.155u L=0.04u
M628 U214/XI12-net17 n232 VSS VSS nmos W=0.155u L=0.04u
M629 n151 n144 VSS VSS nmos W=0.155u L=0.04u
M630 n151 n154 VSS VSS nmos W=0.155u L=0.04u
M631 U215/XI1-net8 n154 VDD VDD pmos W=0.205u L=0.04u
M632 n151 n144 U215/XI1-net8 VDD pmos W=0.205u L=0.04u
M633 n144 n159 VSS VSS nmos W=0.135u L=0.04u
M634 n144 n159 VDD VDD pmos W=0.205u L=0.04u
M635 n159 n185 VSS VSS nmos W=0.155u L=0.04u
M636 n159 n129 VSS VSS nmos W=0.155u L=0.04u
M637 U217/XI1-net8 n129 VDD VDD pmos W=0.205u L=0.04u
M638 n159 n185 U217/XI1-net8 VDD pmos W=0.205u L=0.04u
M639 U218/net19 n129 VSS VSS nmos W=0.155u L=0.04u
M640 n233 n129 U218/net40 VSS nmos W=0.155u L=0.04u
M641 n233 U218/net19 U218/net36 VSS nmos W=0.155u L=0.04u
M642 U218/net40 n235 VSS VSS nmos W=0.31u L=0.04u
M643 U218/net36 n234 VSS VSS nmos W=0.155u L=0.04u
M644 U218/net19 n129 VDD VDD pmos W=0.205u L=0.04u
M645 n233 U218/net19 U218/net26 VDD pmos W=0.325u L=0.04u
M646 U218/net26 n235 VDD VDD pmos W=0.41u L=0.04u
M647 n233 n129 U218/net30 VDD pmos W=0.325u L=0.04u
M648 U218/net30 n234 VDD VDD pmos W=0.205u L=0.04u
M649 n235 n142 VSS VSS nmos W=0.155u L=0.04u
M650 n235 n132 VSS VSS nmos W=0.155u L=0.04u
M651 U219/XI1-net8 n132 VDD VDD pmos W=0.205u L=0.04u
M652 n235 n142 U219/XI1-net8 VDD pmos W=0.205u L=0.04u
M653 n132 n137 VSS VSS nmos W=0.155u L=0.04u
M654 n132 st_3 VSS VSS nmos W=0.155u L=0.04u
M655 U220/XI1-net8 st_3 VDD VDD pmos W=0.205u L=0.04u
M656 n132 n137 U220/XI1-net8 VDD pmos W=0.205u L=0.04u
M657 U221/XU1-net6 st_0 VSS VSS nmos W=0.155u L=0.04u
M658 n137 st_4 U221/XU1-net6 VSS nmos W=0.155u L=0.04u
M659 n137 st_0 VDD VDD pmos W=0.155u L=0.04u
M660 n137 st_4 VDD VDD pmos W=0.155u L=0.04u
M661 n142 n230 VSS VSS nmos W=0.155u L=0.04u
M662 n142 n127 VSS VSS nmos W=0.155u L=0.04u
M663 U222/XI1-net8 n127 VDD VDD pmos W=0.205u L=0.04u
M664 n142 n230 U222/XI1-net8 VDD pmos W=0.205u L=0.04u
M665 U223/XU1-net6 n124 VSS VSS nmos W=0.155u L=0.04u
M666 n230 st_3 U223/XU1-net6 VSS nmos W=0.155u L=0.04u
M667 n230 n124 VDD VDD pmos W=0.155u L=0.04u
M668 n230 st_3 VDD VDD pmos W=0.155u L=0.04u
M669 U224/XU1-net6 n124 VSS VSS nmos W=0.155u L=0.04u
M670 n234 n229 U224/XU1-net6 VSS nmos W=0.155u L=0.04u
M671 n234 n124 VDD VDD pmos W=0.155u L=0.04u
M672 n234 n229 VDD VDD pmos W=0.155u L=0.04u
M673 n232 st_5 U225/net10 VSS nmos W=0.155u L=0.04u
M674 U225/net10 n138 VSS VSS nmos W=0.155u L=0.04u
M675 n232 st_0 U225/net10 VSS nmos W=0.155u L=0.04u
M676 U225/net10 st_2 VSS VSS nmos W=0.155u L=0.04u
M677 U225/net30 n138 VDD VDD pmos W=0.205u L=0.04u
M678 n232 st_5 U225/net24 VDD pmos W=0.205u L=0.04u
M679 U225/net24 st_0 VDD VDD pmos W=0.205u L=0.04u
M680 n232 st_2 U225/net30 VDD pmos W=0.205u L=0.04u
M681 U226/net11 n196 N50 VDD pmos W=0.205u L=0.04u
M682 U226/net11 n125 N50 VDD pmos W=0.205u L=0.04u
M683 U226/net11 n236 U226/XI16-net11 VDD pmos W=0.205u L=0.04u
M684 U226/XI16-net11 n237 VDD VDD pmos W=0.205u L=0.04u
M685 N50 n237 VSS VSS nmos W=0.155u L=0.04u
M686 N50 n236 VSS VSS nmos W=0.155u L=0.04u
M687 N50 n196 U226/XI12-net17 VSS nmos W=0.155u L=0.04u
M688 U226/XI12-net17 n125 VSS VSS nmos W=0.155u L=0.04u
M689 n237 n122 U227/net14 VSS nmos W=0.155u L=0.04u
M690 U227/net14 n157 VSS VSS nmos W=0.155u L=0.04u
M691 U227/net14 n130 VSS VSS nmos W=0.155u L=0.04u
M692 n237 n139 U227/net14 VSS nmos W=0.155u L=0.04u
M693 n237 n153 U227/net14 VSS nmos W=0.155u L=0.04u
M694 n237 n157 U227/XI16-net11 VDD pmos W=0.205u L=0.04u
M695 U227/XI16-net11 n130 VDD VDD pmos W=0.205u L=0.04u
M696 n237 n139 U227/XI15-net11 VDD pmos W=0.205u L=0.04u
M697 U227/XI15-net11 n153 U227/XI15-net18 VDD pmos W=0.205u L=0.04u
M698 U227/XI15-net18 n122 VDD VDD pmos W=0.205u L=0.04u
M699 n157 n148 VSS VSS nmos W=0.135u L=0.04u
M700 n157 n148 VDD VDD pmos W=0.205u L=0.04u
M701 n148 n185 VSS VSS nmos W=0.155u L=0.04u
M702 n148 n127 VSS VSS nmos W=0.155u L=0.04u
M703 U229/XI1-net8 n127 VDD VDD pmos W=0.205u L=0.04u
M704 n148 n185 U229/XI1-net8 VDD pmos W=0.205u L=0.04u
M705 n185 st_5 VSS VSS nmos W=0.135u L=0.04u
M706 n185 st_5 VDD VDD pmos W=0.205u L=0.04u
M707 n130 n158 VSS VSS nmos W=0.135u L=0.04u
M708 n130 n158 VDD VDD pmos W=0.205u L=0.04u
M709 n158 n122 VSS VSS nmos W=0.155u L=0.04u
M710 n158 n129 VSS VSS nmos W=0.155u L=0.04u
M711 U232/XI1-net8 n129 VDD VDD pmos W=0.205u L=0.04u
M712 n158 n122 U232/XI1-net8 VDD pmos W=0.205u L=0.04u
M713 n139 n229 VSS VSS nmos W=0.135u L=0.04u
M714 n139 n229 VDD VDD pmos W=0.205u L=0.04u
M715 n229 n154 VSS VSS nmos W=0.155u L=0.04u
M716 n229 st_2 VSS VSS nmos W=0.155u L=0.04u
M717 U234/XI1-net8 st_2 VDD VDD pmos W=0.205u L=0.04u
M718 n229 n154 U234/XI1-net8 VDD pmos W=0.205u L=0.04u
M719 n153 n125 VSS VSS nmos W=0.135u L=0.04u
M720 n153 n125 VDD VDD pmos W=0.205u L=0.04u
M721 n122 st_3 VSS VSS nmos W=0.135u L=0.04u
M722 n122 st_3 VDD VDD pmos W=0.205u L=0.04u
M723 U237/net8 n146 U237/net26 VSS nmos W=0.155u L=0.04u
M724 U237/net26 n141 VSS VSS nmos W=0.155u L=0.04u
M725 U237/net29 U237/net8 VSS VSS nmos W=0.155u L=0.04u
M726 U237/net29 st_0 n236 VSS nmos W=0.155u L=0.04u
M727 U237/net29 n124 n236 VSS nmos W=0.155u L=0.04u
M728 U237/net8 n141 VDD VDD pmos W=0.205u L=0.04u
M729 U237/net8 n146 VDD VDD pmos W=0.205u L=0.04u
M730 n236 U237/net8 VDD VDD pmos W=0.205u L=0.04u
M731 n236 st_0 U237/net20 VDD pmos W=0.205u L=0.04u
M732 U237/net20 n124 VDD VDD pmos W=0.205u L=0.04u
M733 n141 n126 VSS VSS nmos W=0.155u L=0.04u
M734 n141 n154 VSS VSS nmos W=0.155u L=0.04u
M735 U238/XI1-net8 n154 VDD VDD pmos W=0.205u L=0.04u
M736 n141 n126 U238/XI1-net8 VDD pmos W=0.205u L=0.04u
M737 n154 st_0 VSS VSS nmos W=0.135u L=0.04u
M738 n154 st_0 VDD VDD pmos W=0.205u L=0.04u
M739 n126 n138 VSS VSS nmos W=0.135u L=0.04u
M740 n126 n138 VDD VDD pmos W=0.205u L=0.04u
M741 n138 st_5 VSS VSS nmos W=0.155u L=0.04u
M742 n138 st_4 VSS VSS nmos W=0.155u L=0.04u
M743 U241/XI1-net8 st_4 VDD VDD pmos W=0.205u L=0.04u
M744 n138 st_5 U241/XI1-net8 VDD pmos W=0.205u L=0.04u
M745 n146 n214 VSS VSS nmos W=0.155u L=0.04u
M746 n146 n123 VSS VSS nmos W=0.155u L=0.04u
M747 U242/XI1-net8 n123 VDD VDD pmos W=0.205u L=0.04u
M748 n146 n214 U242/XI1-net8 VDD pmos W=0.205u L=0.04u
M749 n123 n127 VSS VSS nmos W=0.155u L=0.04u
M750 n123 n129 VSS VSS nmos W=0.155u L=0.04u
M751 U243/XI1-net8 n129 VDD VDD pmos W=0.205u L=0.04u
M752 n123 n127 U243/XI1-net8 VDD pmos W=0.205u L=0.04u
M753 n129 st_1 VSS VSS nmos W=0.135u L=0.04u
M754 n129 st_1 VDD VDD pmos W=0.205u L=0.04u
M755 n127 st_2 VSS VSS nmos W=0.135u L=0.04u
M756 n127 st_2 VDD VDD pmos W=0.205u L=0.04u
M757 n214 st_2 VSS VSS nmos W=0.155u L=0.04u
M758 n214 st_1 VSS VSS nmos W=0.155u L=0.04u
M759 U246/XI1-net8 st_1 VDD VDD pmos W=0.205u L=0.04u
M760 n214 st_2 U246/XI1-net8 VDD pmos W=0.205u L=0.04u
M761 n124 st_4 VSS VSS nmos W=0.135u L=0.04u
M762 n124 st_4 VDD VDD pmos W=0.205u L=0.04u
M763 n125 st_1 VSS VSS nmos W=0.155u L=0.04u
M764 n125 st_5 VSS VSS nmos W=0.155u L=0.04u
M765 U248/XI1-net8 st_5 VDD VDD pmos W=0.205u L=0.04u
M766 n125 st_1 U248/XI1-net8 VDD pmos W=0.205u L=0.04u
M767 n196 n188 VSS VSS nmos W=0.155u L=0.04u
M768 n196 st_3 VSS VSS nmos W=0.155u L=0.04u
M769 U249/XI1-net8 st_3 VDD VDD pmos W=0.205u L=0.04u
M770 n196 n188 U249/XI1-net8 VDD pmos W=0.205u L=0.04u
M771 n188 n128 VSS VSS nmos W=0.135u L=0.04u
M772 n188 n128 VDD VDD pmos W=0.205u L=0.04u
M773 n128 st_2 VSS VSS nmos W=0.155u L=0.04u
M774 n128 st_0 VSS VSS nmos W=0.155u L=0.04u
M775 U251/XI1-net8 st_0 VDD VDD pmos W=0.205u L=0.04u
M776 n128 st_2 U251/XI1-net8 VDD pmos W=0.205u L=0.04u
.ENDS
