.SUBCKT s349 CK A0 A1 A2 A3 B0 B1 B2 B3 CNTVCO2 CNTVCON2 P0 P1 P2 P3 P4 P5 P6 P7 READY START VDD VSS
M1 MRVG1VD NOR2_21/net6 VSS VSS nmos W=0.31u L=0.04u
M2 NOR2_21/X_u2-net6 n45 VSS VSS nmos W=0.31u L=0.04u
M3 NOR2_21/net6 n49 NOR2_21/X_u2-net6 VSS nmos W=0.31u L=0.04u
M4 MRVG1VD NOR2_21/net6 VDD VDD pmos W=0.41u L=0.04u
M5 NOR2_21/net6 n45 VDD VDD pmos W=0.41u L=0.04u
M6 NOR2_21/net6 n49 VDD VDD pmos W=0.41u L=0.04u
M7 MRVG2VD NOR2_20/net6 VSS VSS nmos W=0.31u L=0.04u
M8 NOR2_20/X_u2-net6 n46 VSS VSS nmos W=0.31u L=0.04u
M9 NOR2_20/net6 n50 NOR2_20/X_u2-net6 VSS nmos W=0.31u L=0.04u
M10 MRVG2VD NOR2_20/net6 VDD VDD pmos W=0.41u L=0.04u
M11 NOR2_20/net6 n46 VDD VDD pmos W=0.41u L=0.04u
M12 NOR2_20/net6 n50 VDD VDD pmos W=0.41u L=0.04u
M13 MRVG3VD NOR2_19/net6 VSS VSS nmos W=0.31u L=0.04u
M14 NOR2_19/X_u2-net6 n47 VSS VSS nmos W=0.31u L=0.04u
M15 NOR2_19/net6 n51 NOR2_19/X_u2-net6 VSS nmos W=0.31u L=0.04u
M16 MRVG3VD NOR2_19/net6 VDD VDD pmos W=0.41u L=0.04u
M17 NOR2_19/net6 n47 VDD VDD pmos W=0.41u L=0.04u
M18 NOR2_19/net6 n51 VDD VDD pmos W=0.41u L=0.04u
M19 MRVG4VD NOR2_18/net6 VSS VSS nmos W=0.31u L=0.04u
M20 NOR2_18/X_u2-net6 n48 VSS VSS nmos W=0.31u L=0.04u
M21 NOR2_18/net6 n52 NOR2_18/X_u2-net6 VSS nmos W=0.31u L=0.04u
M22 MRVG4VD NOR2_18/net6 VDD VDD pmos W=0.41u L=0.04u
M23 NOR2_18/net6 n48 VDD VDD pmos W=0.41u L=0.04u
M24 NOR2_18/net6 n52 VDD VDD pmos W=0.41u L=0.04u
M25 CNTVG1VD NOR2_7/net6 VSS VSS nmos W=0.31u L=0.04u
M26 NOR2_7/X_u2-net6 n17 VSS VSS nmos W=0.31u L=0.04u
M27 NOR2_7/net6 N7 NOR2_7/X_u2-net6 VSS nmos W=0.31u L=0.04u
M28 CNTVG1VD NOR2_7/net6 VDD VDD pmos W=0.41u L=0.04u
M29 NOR2_7/net6 n17 VDD VDD pmos W=0.41u L=0.04u
M30 NOR2_7/net6 N7 VDD VDD pmos W=0.41u L=0.04u
M31 CNTVG2VD NOR2_5/net6 VSS VSS nmos W=0.31u L=0.04u
M32 NOR2_5/X_u2-net6 n17 VSS VSS nmos W=0.31u L=0.04u
M33 NOR2_5/net6 N5 NOR2_5/X_u2-net6 VSS nmos W=0.31u L=0.04u
M34 CNTVG2VD NOR2_5/net6 VDD VDD pmos W=0.41u L=0.04u
M35 NOR2_5/net6 n17 VDD VDD pmos W=0.41u L=0.04u
M36 NOR2_5/net6 N5 VDD VDD pmos W=0.41u L=0.04u
M37 CNTVG3VD NOR2_2/net6 VSS VSS nmos W=0.31u L=0.04u
M38 NOR2_2/X_u2-net6 n17 VSS VSS nmos W=0.31u L=0.04u
M39 NOR2_2/net6 N2 NOR2_2/X_u2-net6 VSS nmos W=0.31u L=0.04u
M40 CNTVG3VD NOR2_2/net6 VDD VDD pmos W=0.41u L=0.04u
M41 NOR2_2/net6 n17 VDD VDD pmos W=0.41u L=0.04u
M42 NOR2_2/net6 N2 VDD VDD pmos W=0.41u L=0.04u
M43 AM3 AMVG5VX VSS VSS nmos W=0.31u L=0.04u
M44 AM3 AMVG5VX VDD VDD pmos W=0.41u L=0.04u
M45 AM2 AMVG4VX VSS VSS nmos W=0.31u L=0.04u
M46 AM2 AMVG4VX VDD VDD pmos W=0.41u L=0.04u
M47 AM1 AMVG3VX VSS VSS nmos W=0.31u L=0.04u
M48 AM1 AMVG3VX VDD VDD pmos W=0.41u L=0.04u
M49 AM0 AMVG2VX VSS VSS nmos W=0.31u L=0.04u
M50 AM0 AMVG2VX VDD VDD pmos W=0.41u L=0.04u
M51 ACVG4VD1 N15 VSS VSS nmos W=0.31u L=0.04u
M52 ACVG4VD1 N15 VDD VDD pmos W=0.41u L=0.04u
M53 ACVG3VD1 N16 VSS VSS nmos W=0.31u L=0.04u
M54 ACVG3VD1 N16 VDD VDD pmos W=0.41u L=0.04u
M55 ACVG2VD1 N17 VSS VSS nmos W=0.31u L=0.04u
M56 ACVG2VD1 N17 VDD VDD pmos W=0.41u L=0.04u
M57 ACVG1VD1 N18 VSS VSS nmos W=0.31u L=0.04u
M58 ACVG1VD1 N18 VDD VDD pmos W=0.41u L=0.04u
M59 n52 U64/net7 VSS VSS nmos W=0.155u L=0.04u
M60 U64/net7 n54 VSS VSS nmos W=0.155u L=0.04u
M61 U64/net7 n55 VSS VSS nmos W=0.155u L=0.04u
M62 n52 U64/net7 VDD VDD pmos W=0.205u L=0.04u
M63 U64/X_u7-net8 n55 VDD VDD pmos W=0.205u L=0.04u
M64 U64/net7 n54 U64/X_u7-net8 VDD pmos W=0.205u L=0.04u
M65 U65/net19 READY VSS VSS nmos W=0.155u L=0.04u
M66 n54 READY U65/net40 VSS nmos W=0.155u L=0.04u
M67 n54 U65/net19 U65/net36 VSS nmos W=0.155u L=0.04u
M68 U65/net40 P3 VSS VSS nmos W=0.31u L=0.04u
M69 U65/net36 B3 VSS VSS nmos W=0.155u L=0.04u
M70 U65/net19 READY VDD VDD pmos W=0.205u L=0.04u
M71 n54 U65/net19 U65/net26 VDD pmos W=0.325u L=0.04u
M72 U65/net26 P3 VDD VDD pmos W=0.41u L=0.04u
M73 n54 READY U65/net30 VDD pmos W=0.325u L=0.04u
M74 U65/net30 B3 VDD VDD pmos W=0.205u L=0.04u
M75 n51 U66/net7 VSS VSS nmos W=0.155u L=0.04u
M76 U66/net7 n56 VSS VSS nmos W=0.155u L=0.04u
M77 U66/net7 n55 VSS VSS nmos W=0.155u L=0.04u
M78 n51 U66/net7 VDD VDD pmos W=0.205u L=0.04u
M79 U66/X_u7-net8 n55 VDD VDD pmos W=0.205u L=0.04u
M80 U66/net7 n56 U66/X_u7-net8 VDD pmos W=0.205u L=0.04u
M81 U67/net19 READY VSS VSS nmos W=0.155u L=0.04u
M82 n56 READY U67/net40 VSS nmos W=0.155u L=0.04u
M83 n56 U67/net19 U67/net36 VSS nmos W=0.155u L=0.04u
M84 U67/net40 P2 VSS VSS nmos W=0.31u L=0.04u
M85 U67/net36 B2 VSS VSS nmos W=0.155u L=0.04u
M86 U67/net19 READY VDD VDD pmos W=0.205u L=0.04u
M87 n56 U67/net19 U67/net26 VDD pmos W=0.325u L=0.04u
M88 U67/net26 P2 VDD VDD pmos W=0.41u L=0.04u
M89 n56 READY U67/net30 VDD pmos W=0.325u L=0.04u
M90 U67/net30 B2 VDD VDD pmos W=0.205u L=0.04u
M91 n50 U68/net7 VSS VSS nmos W=0.155u L=0.04u
M92 U68/net7 n57 VSS VSS nmos W=0.155u L=0.04u
M93 U68/net7 n55 VSS VSS nmos W=0.155u L=0.04u
M94 n50 U68/net7 VDD VDD pmos W=0.205u L=0.04u
M95 U68/X_u7-net8 n55 VDD VDD pmos W=0.205u L=0.04u
M96 U68/net7 n57 U68/X_u7-net8 VDD pmos W=0.205u L=0.04u
M97 U69/net19 READY VSS VSS nmos W=0.155u L=0.04u
M98 n57 READY U69/net40 VSS nmos W=0.155u L=0.04u
M99 n57 U69/net19 U69/net36 VSS nmos W=0.155u L=0.04u
M100 U69/net40 P1 VSS VSS nmos W=0.31u L=0.04u
M101 U69/net36 B1 VSS VSS nmos W=0.155u L=0.04u
M102 U69/net19 READY VDD VDD pmos W=0.205u L=0.04u
M103 n57 U69/net19 U69/net26 VDD pmos W=0.325u L=0.04u
M104 U69/net26 P1 VDD VDD pmos W=0.41u L=0.04u
M105 n57 READY U69/net30 VDD pmos W=0.325u L=0.04u
M106 U69/net30 B1 VDD VDD pmos W=0.205u L=0.04u
M107 n49 U70/net7 VSS VSS nmos W=0.155u L=0.04u
M108 U70/net7 n58 VSS VSS nmos W=0.155u L=0.04u
M109 U70/net7 n55 VSS VSS nmos W=0.155u L=0.04u
M110 n49 U70/net7 VDD VDD pmos W=0.205u L=0.04u
M111 U70/X_u7-net8 n55 VDD VDD pmos W=0.205u L=0.04u
M112 U70/net7 n58 U70/X_u7-net8 VDD pmos W=0.205u L=0.04u
M113 U71/net19 READY VSS VSS nmos W=0.155u L=0.04u
M114 n58 READY U71/net40 VSS nmos W=0.155u L=0.04u
M115 n58 U71/net19 U71/net36 VSS nmos W=0.155u L=0.04u
M116 U71/net40 P0 VSS VSS nmos W=0.31u L=0.04u
M117 U71/net36 B0 VSS VSS nmos W=0.155u L=0.04u
M118 U71/net19 READY VDD VDD pmos W=0.205u L=0.04u
M119 n58 U71/net19 U71/net26 VDD pmos W=0.325u L=0.04u
M120 U71/net26 P0 VDD VDD pmos W=0.41u L=0.04u
M121 n58 READY U71/net30 VDD pmos W=0.325u L=0.04u
M122 U71/net30 B0 VDD VDD pmos W=0.205u L=0.04u
M123 U72/net36 n60 U72/net24 VSS nmos W=0.155u L=0.04u
M124 U72/net24 n55 VSS VSS nmos W=0.155u L=0.04u
M125 n48 P4 U72/net36 VSS nmos W=0.155u L=0.04u
M126 n48 n59 U72/net36 VSS nmos W=0.155u L=0.04u
M127 n48 n59 U72/net35 VDD pmos W=0.205u L=0.04u
M128 U72/net35 P4 VDD VDD pmos W=0.205u L=0.04u
M129 n48 n55 VDD VDD pmos W=0.205u L=0.04u
M130 n48 n60 VDD VDD pmos W=0.205u L=0.04u
M131 U73/XU1-net6 P3 VSS VSS nmos W=0.155u L=0.04u
M132 n47 n55 U73/XU1-net6 VSS nmos W=0.155u L=0.04u
M133 n47 P3 VDD VDD pmos W=0.155u L=0.04u
M134 n47 n55 VDD VDD pmos W=0.155u L=0.04u
M135 U74/XU1-net6 P2 VSS VSS nmos W=0.155u L=0.04u
M136 n46 n55 U74/XU1-net6 VSS nmos W=0.155u L=0.04u
M137 n46 P2 VDD VDD pmos W=0.155u L=0.04u
M138 n46 n55 VDD VDD pmos W=0.155u L=0.04u
M139 U75/XU1-net6 P1 VSS VSS nmos W=0.155u L=0.04u
M140 n45 n55 U75/XU1-net6 VSS nmos W=0.155u L=0.04u
M141 n45 P1 VDD VDD pmos W=0.155u L=0.04u
M142 n45 n55 VDD VDD pmos W=0.155u L=0.04u
M143 P7 ACVQN3 VSS VSS nmos W=0.135u L=0.04u
M144 P7 ACVQN3 VDD VDD pmos W=0.205u L=0.04u
M145 P6 ACVQN2 VSS VSS nmos W=0.135u L=0.04u
M146 P6 ACVQN2 VDD VDD pmos W=0.205u L=0.04u
M147 P3 MRVQN3 VSS VSS nmos W=0.135u L=0.04u
M148 P3 MRVQN3 VDD VDD pmos W=0.205u L=0.04u
M149 P2 MRVQN2 VSS VSS nmos W=0.135u L=0.04u
M150 P2 MRVQN2 VDD VDD pmos W=0.205u L=0.04u
M151 P1 MRVQN1 VSS VSS nmos W=0.135u L=0.04u
M152 P1 MRVQN1 VDD VDD pmos W=0.205u L=0.04u
M153 U81/net19 CT1 VSS VSS nmos W=0.155u L=0.04u
M154 N5 CT1 U81/net40 VSS nmos W=0.155u L=0.04u
M155 N5 U81/net19 U81/net36 VSS nmos W=0.155u L=0.04u
M156 U81/net40 CT0 VSS VSS nmos W=0.31u L=0.04u
M157 U81/net36 N7 VSS VSS nmos W=0.155u L=0.04u
M158 U81/net19 CT1 VDD VDD pmos W=0.205u L=0.04u
M159 N5 U81/net19 U81/net26 VDD pmos W=0.325u L=0.04u
M160 U81/net26 CT0 VDD VDD pmos W=0.41u L=0.04u
M161 N5 CT1 U81/net30 VDD pmos W=0.325u L=0.04u
M162 U81/net30 N7 VDD VDD pmos W=0.205u L=0.04u
M163 U82/XU1-net6 n61 VSS VSS nmos W=0.155u L=0.04u
M164 N7 CT0 U82/XU1-net6 VSS nmos W=0.155u L=0.04u
M165 N7 n61 VDD VDD pmos W=0.155u L=0.04u
M166 N7 CT0 VDD VDD pmos W=0.155u L=0.04u
M167 N2 CNTVCO2 VSS VSS nmos W=0.155u L=0.04u
M168 N2 n62 VSS VSS nmos W=0.155u L=0.04u
M169 U83/XI1-net8 n62 VDD VDD pmos W=0.205u L=0.04u
M170 N2 CNTVCO2 U83/XI1-net8 VDD pmos W=0.205u L=0.04u
M171 n62 CT1 U84/net27 VSS nmos W=0.155u L=0.04u
M172 U84/net27 CT0 VSS VSS nmos W=0.155u L=0.04u
M173 n62 CT2 VSS VSS nmos W=0.155u L=0.04u
M174 n62 CT0 U84/net13 VDD pmos W=0.205u L=0.04u
M175 U84/net13 CT2 VDD VDD pmos W=0.205u L=0.04u
M176 n62 CT1 U84/net13 VDD pmos W=0.205u L=0.04u
M177 N18 ACVQN0 U85/net10 VSS nmos W=0.155u L=0.04u
M178 U85/net10 n65 VSS VSS nmos W=0.155u L=0.04u
M179 N18 n63 U85/net10 VSS nmos W=0.155u L=0.04u
M180 U85/net10 n64 VSS VSS nmos W=0.155u L=0.04u
M181 U85/net30 n65 VDD VDD pmos W=0.205u L=0.04u
M182 N18 ACVQN0 U85/net24 VDD pmos W=0.205u L=0.04u
M183 U85/net24 n63 VDD VDD pmos W=0.205u L=0.04u
M184 N18 n64 U85/net30 VDD pmos W=0.205u L=0.04u
M185 n64 n66 U86/net23 VDD pmos W=0.205u L=0.04u
M186 n64 AX1 U86/net23 VDD pmos W=0.205u L=0.04u
M187 n64 P0 U86/net23 VDD pmos W=0.205u L=0.04u
M188 U86/net23 n67 VDD VDD pmos W=0.205u L=0.04u
M189 U86/net23 n68 VDD VDD pmos W=0.205u L=0.04u
M190 U86/XI20-net13 AX1 VSS VSS nmos W=0.155u L=0.04u
M191 n64 n66 U86/XI20-net17 VSS nmos W=0.155u L=0.04u
M192 U86/XI20-net17 P0 U86/XI20-net13 VSS nmos W=0.155u L=0.04u
M193 n64 n67 U86/XI17-net17 VSS nmos W=0.155u L=0.04u
M194 U86/XI17-net17 n68 VSS VSS nmos W=0.155u L=0.04u
M195 n66 ACVQN1 U87/net15 VSS nmos W=0.155u L=0.04u
M196 n66 n60 U87/net15 VSS nmos W=0.155u L=0.04u
M197 U87/net15 n69 VSS VSS nmos W=0.155u L=0.04u
M198 n66 n69 VDD VDD pmos W=0.205u L=0.04u
M199 n66 ACVQN1 U87/XI16-net11 VDD pmos W=0.205u L=0.04u
M200 U87/XI16-net11 n60 VDD VDD pmos W=0.205u L=0.04u
M201 N17 ACVQN1 U88/net10 VSS nmos W=0.155u L=0.04u
M202 U88/net10 n65 VSS VSS nmos W=0.155u L=0.04u
M203 N17 n63 U88/net10 VSS nmos W=0.155u L=0.04u
M204 U88/net10 n70 VSS VSS nmos W=0.155u L=0.04u
M205 U88/net30 n65 VDD VDD pmos W=0.205u L=0.04u
M206 N17 ACVQN1 U88/net24 VDD pmos W=0.205u L=0.04u
M207 U88/net24 n63 VDD VDD pmos W=0.205u L=0.04u
M208 N17 n70 U88/net30 VDD pmos W=0.205u L=0.04u
M209 U89/net29 n69 VSS VSS nmos W=0.155u L=0.04u
M210 n70 n73 U89/net29 VSS nmos W=0.155u L=0.04u
M211 n70 n71 U89/net23 VSS nmos W=0.155u L=0.04u
M212 U89/net23 n72 VSS VSS nmos W=0.155u L=0.04u
M213 U89/net20 n72 n70 VDD pmos W=0.205u L=0.04u
M214 U89/net20 n71 n70 VDD pmos W=0.205u L=0.04u
M215 VDD n73 U89/net20 VDD pmos W=0.205u L=0.04u
M216 VDD n69 U89/net20 VDD pmos W=0.205u L=0.04u
M217 n69 n67 VSS VSS nmos W=0.135u L=0.04u
M218 n69 n67 VDD VDD pmos W=0.205u L=0.04u
M219 n72 n74 U91/XI0-net10 VSS nmos W=0.155u L=0.04u
M220 U91/XI0-net10 ACVQN2 U91/XI0-net13 VSS nmos W=0.155u L=0.04u
M221 U91/XI0-net13 n67 VSS VSS nmos W=0.155u L=0.04u
M222 n72 n67 VDD VDD pmos W=0.205u L=0.04u
M223 n72 n74 VDD VDD pmos W=0.205u L=0.04u
M224 n72 ACVQN2 VDD VDD pmos W=0.205u L=0.04u
M225 N16 ACVQN2 U92/net10 VSS nmos W=0.155u L=0.04u
M226 U92/net10 n65 VSS VSS nmos W=0.155u L=0.04u
M227 N16 n63 U92/net10 VSS nmos W=0.155u L=0.04u
M228 U92/net10 n75 VSS VSS nmos W=0.155u L=0.04u
M229 U92/net30 n65 VDD VDD pmos W=0.205u L=0.04u
M230 N16 ACVQN2 U92/net24 VDD pmos W=0.205u L=0.04u
M231 U92/net24 n63 VDD VDD pmos W=0.205u L=0.04u
M232 N16 n75 U92/net30 VDD pmos W=0.205u L=0.04u
M233 U93/net29 n79 VSS VSS nmos W=0.155u L=0.04u
M234 n75 n78 U93/net29 VSS nmos W=0.155u L=0.04u
M235 n75 n76 U93/net23 VSS nmos W=0.155u L=0.04u
M236 U93/net23 n77 VSS VSS nmos W=0.155u L=0.04u
M237 U93/net20 n77 n75 VDD pmos W=0.205u L=0.04u
M238 U93/net20 n76 n75 VDD pmos W=0.205u L=0.04u
M239 VDD n78 U93/net20 VDD pmos W=0.205u L=0.04u
M240 VDD n79 U93/net20 VDD pmos W=0.205u L=0.04u
M241 n79 n71 VSS VSS nmos W=0.135u L=0.04u
M242 n79 n71 VDD VDD pmos W=0.205u L=0.04u
M243 n77 n80 U95/XI0-net10 VSS nmos W=0.155u L=0.04u
M244 U95/XI0-net10 ACVQN3 U95/XI0-net13 VSS nmos W=0.155u L=0.04u
M245 U95/XI0-net13 n71 VSS VSS nmos W=0.155u L=0.04u
M246 n77 n71 VDD VDD pmos W=0.205u L=0.04u
M247 n77 n80 VDD VDD pmos W=0.205u L=0.04u
M248 n77 ACVQN3 VDD VDD pmos W=0.205u L=0.04u
M249 N15 n76 U96/net10 VSS nmos W=0.155u L=0.04u
M250 U96/net10 n63 VSS VSS nmos W=0.155u L=0.04u
M251 N15 n65 U96/net10 VSS nmos W=0.155u L=0.04u
M252 U96/net10 ACVQN3 VSS VSS nmos W=0.155u L=0.04u
M253 U96/net30 n63 VDD VDD pmos W=0.205u L=0.04u
M254 N15 n76 U96/net24 VDD pmos W=0.205u L=0.04u
M255 U96/net24 n65 VDD VDD pmos W=0.205u L=0.04u
M256 N15 ACVQN3 U96/net30 VDD pmos W=0.205u L=0.04u
M257 U97/net13 n55 VSS VSS nmos W=0.155u L=0.04u
M258 U97/net16 U97/net13 VSS VSS nmos W=0.155u L=0.04u
M259 n63 n17 U97/net16 VSS nmos W=0.155u L=0.04u
M260 U97/net13 n55 VDD VDD pmos W=0.205u L=0.04u
M261 VDD U97/net13 n63 VDD pmos W=0.205u L=0.04u
M262 VDD n17 n63 VDD pmos W=0.205u L=0.04u
M263 U98/XU1-net6 n17 VSS VSS nmos W=0.155u L=0.04u
M264 n65 n55 U98/XU1-net6 VSS nmos W=0.155u L=0.04u
M265 n65 n17 VDD VDD pmos W=0.155u L=0.04u
M266 n65 n55 VDD VDD pmos W=0.155u L=0.04u
M267 n17 START VSS VSS nmos W=0.135u L=0.04u
M268 n17 START VDD VDD pmos W=0.205u L=0.04u
M269 n55 n81 VSS VSS nmos W=0.155u L=0.04u
M270 n55 READY VSS VSS nmos W=0.155u L=0.04u
M271 U100/XI1-net8 READY VDD VDD pmos W=0.205u L=0.04u
M272 n55 n81 U100/XI1-net8 VDD pmos W=0.205u L=0.04u
M273 READY n61 VSS VSS nmos W=0.135u L=0.04u
M274 READY n61 VDD VDD pmos W=0.205u L=0.04u
M275 U102/net30 CT1 VSS VSS nmos W=0.155u L=0.04u
M276 n61 CT2 U102/net23 VSS nmos W=0.155u L=0.04u
M277 U102/net20 U102/net30 VSS VSS nmos W=0.155u L=0.04u
M278 U102/net23 CT0 U102/net20 VSS nmos W=0.155u L=0.04u
M279 U102/net30 CT1 VDD VDD pmos W=0.205u L=0.04u
M280 VDD CT2 n61 VDD pmos W=0.205u L=0.04u
M281 VDD CT0 n61 VDD pmos W=0.205u L=0.04u
M282 VDD U102/net30 n61 VDD pmos W=0.205u L=0.04u
M283 U103/net11 n82 VSS VSS nmos W=0.155u L=0.04u
M284 U103/net11 n71 VSS VSS nmos W=0.155u L=0.04u
M285 n76 n78 VSS VSS nmos W=0.155u L=0.04u
M286 n76 U103/net11 VSS VSS nmos W=0.155u L=0.04u
M287 U103/XI1-net8 n71 VDD VDD pmos W=0.205u L=0.04u
M288 U103/net11 n82 U103/XI1-net8 VDD pmos W=0.205u L=0.04u
M289 U103/XU39-net8 U103/net11 VDD VDD pmos W=0.205u L=0.04u
M290 n76 n78 U103/XU39-net8 VDD pmos W=0.205u L=0.04u
M291 n78 n80 VSS VSS nmos W=0.155u L=0.04u
M292 n78 ACVQN3 VSS VSS nmos W=0.155u L=0.04u
M293 U104/XI1-net8 ACVQN3 VDD VDD pmos W=0.205u L=0.04u
M294 n78 n80 U104/XI1-net8 VDD pmos W=0.205u L=0.04u
M295 U105/net11 n83 VSS VSS nmos W=0.155u L=0.04u
M296 U105/net11 n67 VSS VSS nmos W=0.155u L=0.04u
M297 n71 n73 VSS VSS nmos W=0.155u L=0.04u
M298 n71 U105/net11 VSS VSS nmos W=0.155u L=0.04u
M299 U105/XI1-net8 n67 VDD VDD pmos W=0.205u L=0.04u
M300 U105/net11 n83 U105/XI1-net8 VDD pmos W=0.205u L=0.04u
M301 U105/XU39-net8 U105/net11 VDD VDD pmos W=0.205u L=0.04u
M302 n71 n73 U105/XU39-net8 VDD pmos W=0.205u L=0.04u
M303 n73 n74 VSS VSS nmos W=0.155u L=0.04u
M304 n73 ACVQN2 VSS VSS nmos W=0.155u L=0.04u
M305 U106/XI1-net8 ACVQN2 VDD VDD pmos W=0.205u L=0.04u
M306 n73 n74 U106/XI1-net8 VDD pmos W=0.205u L=0.04u
M307 n67 AX1 U107/net23 VDD pmos W=0.205u L=0.04u
M308 n67 n68 U107/net23 VDD pmos W=0.205u L=0.04u
M309 n67 P0 U107/net23 VDD pmos W=0.205u L=0.04u
M310 U107/net23 P5 VDD VDD pmos W=0.205u L=0.04u
M311 U107/net23 n84 VDD VDD pmos W=0.205u L=0.04u
M312 U107/XI20-net13 n68 VSS VSS nmos W=0.155u L=0.04u
M313 n67 AX1 U107/XI20-net17 VSS nmos W=0.155u L=0.04u
M314 U107/XI20-net17 P0 U107/XI20-net13 VSS nmos W=0.155u L=0.04u
M315 n67 P5 U107/XI17-net17 VSS nmos W=0.155u L=0.04u
M316 U107/XI17-net17 n84 VSS VSS nmos W=0.155u L=0.04u
M317 n84 n60 VSS VSS nmos W=0.135u L=0.04u
M318 n84 n60 VDD VDD pmos W=0.205u L=0.04u
M319 P5 ACVQN1 VSS VSS nmos W=0.135u L=0.04u
M320 P5 ACVQN1 VDD VDD pmos W=0.205u L=0.04u
M321 U110/XU1-net6 ACVQN1 VSS VSS nmos W=0.155u L=0.04u
M322 n68 n60 U110/XU1-net6 VSS nmos W=0.155u L=0.04u
M323 n68 ACVQN1 VDD VDD pmos W=0.155u L=0.04u
M324 n68 n60 VDD VDD pmos W=0.155u L=0.04u
M325 U111/XU1-net6 P4 VSS VSS nmos W=0.155u L=0.04u
M326 n60 n59 U111/XU1-net6 VSS nmos W=0.155u L=0.04u
M327 n60 P4 VDD VDD pmos W=0.155u L=0.04u
M328 n60 n59 VDD VDD pmos W=0.155u L=0.04u
M329 P4 ACVQN0 VSS VSS nmos W=0.135u L=0.04u
M330 P4 ACVQN0 VDD VDD pmos W=0.205u L=0.04u
M331 n59 MRVQN0 VSS VSS nmos W=0.155u L=0.04u
M332 n59 U113/net4 VSS VSS nmos W=0.155u L=0.04u
M333 U113/net4 AX0 VSS VSS nmos W=0.155u L=0.04u
M334 U113/XU1-net8 U113/net4 VDD VDD pmos W=0.205u L=0.04u
M335 n59 MRVQN0 U113/XU1-net8 VDD pmos W=0.205u L=0.04u
M336 U113/net4 AX0 VDD VDD pmos W=0.205u L=0.04u
M337 n83 U114/net6 VSS VSS nmos W=0.155u L=0.04u
M338 U114/X_u2-net6 ACVQN2 VSS VSS nmos W=0.155u L=0.04u
M339 U114/net6 n74 U114/X_u2-net6 VSS nmos W=0.155u L=0.04u
M340 n83 U114/net6 VDD VDD pmos W=0.205u L=0.04u
M341 U114/net6 ACVQN2 VDD VDD pmos W=0.205u L=0.04u
M342 U114/net6 n74 VDD VDD pmos W=0.205u L=0.04u
M343 U115/XU1-net6 P0 VSS VSS nmos W=0.155u L=0.04u
M344 n74 AX2 U115/XU1-net6 VSS nmos W=0.155u L=0.04u
M345 n74 P0 VDD VDD pmos W=0.155u L=0.04u
M346 n74 AX2 VDD VDD pmos W=0.155u L=0.04u
M347 n82 U116/net6 VSS VSS nmos W=0.155u L=0.04u
M348 U116/X_u2-net6 ACVQN3 VSS VSS nmos W=0.155u L=0.04u
M349 U116/net6 n80 U116/X_u2-net6 VSS nmos W=0.155u L=0.04u
M350 n82 U116/net6 VDD VDD pmos W=0.205u L=0.04u
M351 U116/net6 ACVQN3 VDD VDD pmos W=0.205u L=0.04u
M352 U116/net6 n80 VDD VDD pmos W=0.205u L=0.04u
M353 U117/XU1-net6 P0 VSS VSS nmos W=0.155u L=0.04u
M354 n80 AX3 U117/XU1-net6 VSS nmos W=0.155u L=0.04u
M355 n80 P0 VDD VDD pmos W=0.155u L=0.04u
M356 n80 AX3 VDD VDD pmos W=0.155u L=0.04u
M357 P0 MRVQN0 VSS VSS nmos W=0.135u L=0.04u
M358 P0 MRVQN0 VDD VDD pmos W=0.205u L=0.04u
M359 CNTVCO2 CNTVCON2 VSS VSS nmos W=0.135u L=0.04u
M360 CNTVCO2 CNTVCON2 VDD VDD pmos W=0.205u L=0.04u
M361 CNTVCON2 CT2 U120/XI0-net10 VSS nmos W=0.155u L=0.04u
M362 U120/XI0-net10 CT0 U120/XI0-net13 VSS nmos W=0.155u L=0.04u
M363 U120/XI0-net13 CT1 VSS VSS nmos W=0.155u L=0.04u
M364 CNTVCON2 CT1 VDD VDD pmos W=0.205u L=0.04u
M365 CNTVCON2 CT2 VDD VDD pmos W=0.205u L=0.04u
M366 CNTVCON2 CT0 VDD VDD pmos W=0.205u L=0.04u
M367 U121/net19 n81 VSS VSS nmos W=0.155u L=0.04u
M368 AMVG5VX n81 U121/net40 VSS nmos W=0.155u L=0.04u
M369 AMVG5VX U121/net19 U121/net36 VSS nmos W=0.155u L=0.04u
M370 U121/net40 A3 VSS VSS nmos W=0.31u L=0.04u
M371 U121/net36 AX3 VSS VSS nmos W=0.155u L=0.04u
M372 U121/net19 n81 VDD VDD pmos W=0.205u L=0.04u
M373 AMVG5VX U121/net19 U121/net26 VDD pmos W=0.325u L=0.04u
M374 U121/net26 A3 VDD VDD pmos W=0.41u L=0.04u
M375 AMVG5VX n81 U121/net30 VDD pmos W=0.325u L=0.04u
M376 U121/net30 AX3 VDD VDD pmos W=0.205u L=0.04u
M377 U122/net19 n81 VSS VSS nmos W=0.155u L=0.04u
M378 AMVG4VX n81 U122/net40 VSS nmos W=0.155u L=0.04u
M379 AMVG4VX U122/net19 U122/net36 VSS nmos W=0.155u L=0.04u
M380 U122/net40 A2 VSS VSS nmos W=0.31u L=0.04u
M381 U122/net36 AX2 VSS VSS nmos W=0.155u L=0.04u
M382 U122/net19 n81 VDD VDD pmos W=0.205u L=0.04u
M383 AMVG4VX U122/net19 U122/net26 VDD pmos W=0.325u L=0.04u
M384 U122/net26 A2 VDD VDD pmos W=0.41u L=0.04u
M385 AMVG4VX n81 U122/net30 VDD pmos W=0.325u L=0.04u
M386 U122/net30 AX2 VDD VDD pmos W=0.205u L=0.04u
M387 U123/net19 n81 VSS VSS nmos W=0.155u L=0.04u
M388 AMVG3VX n81 U123/net40 VSS nmos W=0.155u L=0.04u
M389 AMVG3VX U123/net19 U123/net36 VSS nmos W=0.155u L=0.04u
M390 U123/net40 A1 VSS VSS nmos W=0.31u L=0.04u
M391 U123/net36 AX1 VSS VSS nmos W=0.155u L=0.04u
M392 U123/net19 n81 VDD VDD pmos W=0.205u L=0.04u
M393 AMVG3VX U123/net19 U123/net26 VDD pmos W=0.325u L=0.04u
M394 U123/net26 A1 VDD VDD pmos W=0.41u L=0.04u
M395 AMVG3VX n81 U123/net30 VDD pmos W=0.325u L=0.04u
M396 U123/net30 AX1 VDD VDD pmos W=0.205u L=0.04u
M397 U124/net19 n81 VSS VSS nmos W=0.155u L=0.04u
M398 AMVG2VX n81 U124/net40 VSS nmos W=0.155u L=0.04u
M399 AMVG2VX U124/net19 U124/net36 VSS nmos W=0.155u L=0.04u
M400 U124/net40 A0 VSS VSS nmos W=0.31u L=0.04u
M401 U124/net36 AX0 VSS VSS nmos W=0.155u L=0.04u
M402 U124/net19 n81 VDD VDD pmos W=0.205u L=0.04u
M403 AMVG2VX U124/net19 U124/net26 VDD pmos W=0.325u L=0.04u
M404 U124/net26 A0 VDD VDD pmos W=0.41u L=0.04u
M405 AMVG2VX n81 U124/net30 VDD pmos W=0.325u L=0.04u
M406 U124/net30 AX0 VDD VDD pmos W=0.205u L=0.04u
M407 n81 CT0 VSS VSS nmos W=0.155u L=0.04u
M408 n81 CT2 VSS VSS nmos W=0.155u L=0.04u
M409 n81 CT1 VSS VSS nmos W=0.155u L=0.04u
M410 U125/net25 CT0 VDD VDD pmos W=0.41u L=0.04u
M411 U125/net28 CT2 U125/net25 VDD pmos W=0.41u L=0.04u
M412 n81 CT1 U125/net28 VDD pmos W=0.41u L=0.04u
.ENDS
