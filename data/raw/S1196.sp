.SUBCKT s1196 G0 G1 G10 G11 G12 G13 G2 G3 G4 G45 G5 G530 G532 G535 G537 G539 G542 G546 G547 G548 G549 G550 G551 G552 G6 G7 G8 G9 VDD VSS
M1 NOR3_4/net7 n215 NOR3_4/X_u4-net10 VSS nmos W=0.31u L=0.04u
M2 NOR3_4/X_u4-net10 n221 NOR3_4/X_u4-net13 VSS nmos W=0.31u L=0.04u
M3 NOR3_4/X_u4-net13 G279 VSS VSS nmos W=0.31u L=0.04u
M4 G514 NOR3_4/net7 VSS VSS nmos W=0.31u L=0.04u
M5 NOR3_4/net7 G279 VDD VDD pmos W=0.41u L=0.04u
M6 NOR3_4/net7 n215 VDD VDD pmos W=0.41u L=0.04u
M7 NOR3_4/net7 n221 VDD VDD pmos W=0.41u L=0.04u
M8 G514 NOR3_4/net7 VDD VDD pmos W=0.41u L=0.04u
M9 G506 NOR2_40/net6 VSS VSS nmos W=0.31u L=0.04u
M10 NOR2_40/X_u2-net6 n217 VSS VSS nmos W=0.31u L=0.04u
M11 NOR2_40/net6 n213 NOR2_40/X_u2-net6 VSS nmos W=0.31u L=0.04u
M12 G506 NOR2_40/net6 VDD VDD pmos W=0.41u L=0.04u
M13 NOR2_40/net6 n217 VDD VDD pmos W=0.41u L=0.04u
M14 NOR2_40/net6 n213 VDD VDD pmos W=0.41u L=0.04u
M15 NOR3_2/net7 n220 NOR3_2/X_u4-net10 VSS nmos W=0.31u L=0.04u
M16 NOR3_2/X_u4-net10 n31 NOR3_2/X_u4-net13 VSS nmos W=0.31u L=0.04u
M17 NOR3_2/X_u4-net13 n218 VSS VSS nmos W=0.31u L=0.04u
M18 G507 NOR3_2/net7 VSS VSS nmos W=0.31u L=0.04u
M19 NOR3_2/net7 n218 VDD VDD pmos W=0.41u L=0.04u
M20 NOR3_2/net7 n220 VDD VDD pmos W=0.41u L=0.04u
M21 NOR3_2/net7 n31 VDD VDD pmos W=0.41u L=0.04u
M22 G507 NOR3_2/net7 VDD VDD pmos W=0.41u L=0.04u
M23 G517 NOR2_28/net6 VSS VSS nmos W=0.31u L=0.04u
M24 NOR2_28/X_u2-net6 n228 VSS VSS nmos W=0.31u L=0.04u
M25 NOR2_28/net6 n231 NOR2_28/X_u2-net6 VSS nmos W=0.31u L=0.04u
M26 G517 NOR2_28/net6 VDD VDD pmos W=0.41u L=0.04u
M27 NOR2_28/net6 n228 VDD VDD pmos W=0.41u L=0.04u
M28 NOR2_28/net6 n231 VDD VDD pmos W=0.41u L=0.04u
M29 G513 NOR2_26/net6 VSS VSS nmos W=0.31u L=0.04u
M30 NOR2_26/X_u2-net6 n227 VSS VSS nmos W=0.31u L=0.04u
M31 NOR2_26/net6 n219 NOR2_26/X_u2-net6 VSS nmos W=0.31u L=0.04u
M32 G513 NOR2_26/net6 VDD VDD pmos W=0.41u L=0.04u
M33 NOR2_26/net6 n227 VDD VDD pmos W=0.41u L=0.04u
M34 NOR2_26/net6 n219 VDD VDD pmos W=0.41u L=0.04u
M35 G509 NOR2_25/net6 VSS VSS nmos W=0.31u L=0.04u
M36 NOR2_25/X_u2-net6 n43 VSS VSS nmos W=0.31u L=0.04u
M37 NOR2_25/net6 n230 NOR2_25/X_u2-net6 VSS nmos W=0.31u L=0.04u
M38 G509 NOR2_25/net6 VDD VDD pmos W=0.41u L=0.04u
M39 NOR2_25/net6 n43 VDD VDD pmos W=0.41u L=0.04u
M40 NOR2_25/net6 n230 VDD VDD pmos W=0.41u L=0.04u
M41 G515 NOR2_24/net6 VSS VSS nmos W=0.31u L=0.04u
M42 NOR2_24/X_u2-net6 n232 VSS VSS nmos W=0.31u L=0.04u
M43 NOR2_24/net6 n229 NOR2_24/X_u2-net6 VSS nmos W=0.31u L=0.04u
M44 G515 NOR2_24/net6 VDD VDD pmos W=0.41u L=0.04u
M45 NOR2_24/net6 n232 VDD VDD pmos W=0.41u L=0.04u
M46 NOR2_24/net6 n229 VDD VDD pmos W=0.41u L=0.04u
M47 NOR3_1/net7 n19 NOR3_1/X_u4-net10 VSS nmos W=0.31u L=0.04u
M48 NOR3_1/X_u4-net10 n226 NOR3_1/X_u4-net13 VSS nmos W=0.31u L=0.04u
M49 NOR3_1/X_u4-net13 n224 VSS VSS nmos W=0.31u L=0.04u
M50 G516 NOR3_1/net7 VSS VSS nmos W=0.31u L=0.04u
M51 NOR3_1/net7 n224 VDD VDD pmos W=0.41u L=0.04u
M52 NOR3_1/net7 n19 VDD VDD pmos W=0.41u L=0.04u
M53 NOR3_1/net7 n226 VDD VDD pmos W=0.41u L=0.04u
M54 G516 NOR3_1/net7 VDD VDD pmos W=0.41u L=0.04u
M55 G502 NOR2_22/net6 VSS VSS nmos W=0.31u L=0.04u
M56 NOR2_22/X_u2-net6 n225 VSS VSS nmos W=0.31u L=0.04u
M57 NOR2_22/net6 n233 NOR2_22/X_u2-net6 VSS nmos W=0.31u L=0.04u
M58 G502 NOR2_22/net6 VDD VDD pmos W=0.41u L=0.04u
M59 NOR2_22/net6 n225 VDD VDD pmos W=0.41u L=0.04u
M60 NOR2_22/net6 n233 VDD VDD pmos W=0.41u L=0.04u
M61 G511 AND2_7/net6 VSS VSS nmos W=0.31u L=0.04u
M62 AND2_7/X_u2-net6 G164 VSS VSS nmos W=0.31u L=0.04u
M63 AND2_7/net6 G163 AND2_7/X_u2-net6 VSS nmos W=0.31u L=0.04u
M64 G511 AND2_7/net6 VDD VDD pmos W=0.41u L=0.04u
M65 AND2_7/net6 G164 VDD VDD pmos W=0.41u L=0.04u
M66 AND2_7/net6 G163 VDD VDD pmos W=0.41u L=0.04u
M67 G510 N43 VSS VSS nmos W=0.31u L=0.04u
M68 G510 N43 VDD VDD pmos W=0.41u L=0.04u
M69 G512 N57 VSS VSS nmos W=0.31u L=0.04u
M70 G512 N57 VDD VDD pmos W=0.41u L=0.04u
M71 G519 NOR4_0/net6 VSS VSS nmos W=0.31u L=0.04u
M72 NOR4_0/net6 n222 NOR4_0/XU30-net23 VSS nmos W=0.155u L=0.04u
M73 NOR4_0/XU30-net23 n234 NOR4_0/XU30-net26 VSS nmos W=0.155u L=0.04u
M74 NOR4_0/XU30-net26 n216 NOR4_0/XU30-net29 VSS nmos W=0.155u L=0.04u
M75 NOR4_0/XU30-net29 n223 VSS VSS nmos W=0.155u L=0.04u
M76 G519 NOR4_0/net6 VDD VDD pmos W=0.41u L=0.04u
M77 NOR4_0/net6 n223 VDD VDD pmos W=0.205u L=0.04u
M78 NOR4_0/net6 n216 VDD VDD pmos W=0.205u L=0.04u
M79 NOR4_0/net6 n234 VDD VDD pmos W=0.205u L=0.04u
M80 NOR4_0/net6 n222 VDD VDD pmos W=0.205u L=0.04u
M81 G504 N69 VSS VSS nmos W=0.31u L=0.04u
M82 G504 N69 VDD VDD pmos W=0.41u L=0.04u
M83 G518 N117 VSS VSS nmos W=0.31u L=0.04u
M84 G518 N117 VDD VDD pmos W=0.41u L=0.04u
M85 G503 N50 VSS VSS nmos W=0.31u L=0.04u
M86 G503 N50 VDD VDD pmos W=0.41u L=0.04u
M87 G505 N93 VSS VSS nmos W=0.31u L=0.04u
M88 G505 N93 VDD VDD pmos W=0.41u L=0.04u
M89 G508 N105 VSS VSS nmos W=0.31u L=0.04u
M90 G508 N105 VDD VDD pmos W=0.41u L=0.04u
M91 U253/net36 G11 U253/net24 VSS nmos W=0.155u L=0.04u
M92 U253/net24 n237 VSS VSS nmos W=0.155u L=0.04u
M93 n232 n235 U253/net36 VSS nmos W=0.155u L=0.04u
M94 n232 n236 U253/net36 VSS nmos W=0.155u L=0.04u
M95 n232 n236 U253/net35 VDD pmos W=0.205u L=0.04u
M96 U253/net35 n235 VDD VDD pmos W=0.205u L=0.04u
M97 n232 n237 VDD VDD pmos W=0.205u L=0.04u
M98 n232 G11 VDD VDD pmos W=0.205u L=0.04u
M99 U254/net7 n234 U254/X_u4-net10 VSS nmos W=0.155u L=0.04u
M100 U254/X_u4-net10 n238 U254/X_u4-net13 VSS nmos W=0.155u L=0.04u
M101 U254/X_u4-net13 n239 VSS VSS nmos W=0.155u L=0.04u
M102 n237 U254/net7 VSS VSS nmos W=0.155u L=0.04u
M103 U254/net7 n239 VDD VDD pmos W=0.205u L=0.04u
M104 U254/net7 n234 VDD VDD pmos W=0.205u L=0.04u
M105 U254/net7 n238 VDD VDD pmos W=0.205u L=0.04u
M106 n237 U254/net7 VDD VDD pmos W=0.205u L=0.04u
M107 n236 G8 U255/net27 VSS nmos W=0.155u L=0.04u
M108 U255/net27 G6 VSS VSS nmos W=0.155u L=0.04u
M109 n236 n240 VSS VSS nmos W=0.155u L=0.04u
M110 n236 G6 U255/net13 VDD pmos W=0.205u L=0.04u
M111 U255/net13 n240 VDD VDD pmos W=0.205u L=0.04u
M112 n236 G8 U255/net13 VDD pmos W=0.205u L=0.04u
M113 U256/net30 n241 VSS VSS nmos W=0.155u L=0.04u
M114 n231 n243 U256/net23 VSS nmos W=0.155u L=0.04u
M115 U256/net20 U256/net30 VSS VSS nmos W=0.155u L=0.04u
M116 U256/net23 n242 U256/net20 VSS nmos W=0.155u L=0.04u
M117 U256/net30 n241 VDD VDD pmos W=0.205u L=0.04u
M118 VDD n243 n231 VDD pmos W=0.205u L=0.04u
M119 VDD n242 n231 VDD pmos W=0.205u L=0.04u
M120 VDD U256/net30 n231 VDD pmos W=0.205u L=0.04u
M121 n230 n244 U257/net15 VSS nmos W=0.155u L=0.04u
M122 n230 n245 U257/net15 VSS nmos W=0.155u L=0.04u
M123 U257/net15 n246 VSS VSS nmos W=0.155u L=0.04u
M124 n230 n246 VDD VDD pmos W=0.205u L=0.04u
M125 n230 n244 U257/XI16-net11 VDD pmos W=0.205u L=0.04u
M126 U257/XI16-net11 n245 VDD VDD pmos W=0.205u L=0.04u
M127 n229 G6 U258/XI0-net10 VSS nmos W=0.155u L=0.04u
M128 U258/XI0-net10 n247 U258/XI0-net13 VSS nmos W=0.155u L=0.04u
M129 U258/XI0-net13 n248 VSS VSS nmos W=0.155u L=0.04u
M130 n229 n248 VDD VDD pmos W=0.205u L=0.04u
M131 n229 G6 VDD VDD pmos W=0.205u L=0.04u
M132 n229 n247 VDD VDD pmos W=0.205u L=0.04u
M133 U259/XU1-net6 n250 VSS VSS nmos W=0.155u L=0.04u
M134 n228 n249 U259/XU1-net6 VSS nmos W=0.155u L=0.04u
M135 n228 n250 VDD VDD pmos W=0.155u L=0.04u
M136 n228 n249 VDD VDD pmos W=0.155u L=0.04u
M137 VSS n251 U260/net22 VSS nmos W=0.155u L=0.04u
M138 U260/net22 n241 n250 VSS nmos W=0.155u L=0.04u
M139 U260/net22 G9 n250 VSS nmos W=0.155u L=0.04u
M140 U260/net22 n244 n250 VSS nmos W=0.155u L=0.04u
M141 U260/net38 n244 VDD VDD pmos W=0.205u L=0.04u
M142 U260/net35 G9 U260/net38 VDD pmos W=0.205u L=0.04u
M143 n250 n241 U260/net35 VDD pmos W=0.205u L=0.04u
M144 n250 n251 VDD VDD pmos W=0.205u L=0.04u
M145 n227 G6 U261/XI0-net10 VSS nmos W=0.155u L=0.04u
M146 U261/XI0-net10 n252 U261/XI0-net13 VSS nmos W=0.155u L=0.04u
M147 U261/XI0-net13 n253 VSS VSS nmos W=0.155u L=0.04u
M148 n227 n253 VDD VDD pmos W=0.205u L=0.04u
M149 n227 G6 VDD VDD pmos W=0.205u L=0.04u
M150 n227 n252 VDD VDD pmos W=0.205u L=0.04u
M151 n226 n254 U262/net15 VSS nmos W=0.155u L=0.04u
M152 n226 n255 U262/net15 VSS nmos W=0.155u L=0.04u
M153 U262/net15 n256 VSS VSS nmos W=0.155u L=0.04u
M154 n226 n256 VDD VDD pmos W=0.205u L=0.04u
M155 n226 n254 U262/XI16-net11 VDD pmos W=0.205u L=0.04u
M156 U262/XI16-net11 n255 VDD VDD pmos W=0.205u L=0.04u
M157 U263/net19 G6 VSS VSS nmos W=0.155u L=0.04u
M158 n255 G6 U263/net40 VSS nmos W=0.155u L=0.04u
M159 n255 U263/net19 U263/net36 VSS nmos W=0.155u L=0.04u
M160 U263/net40 n258 VSS VSS nmos W=0.31u L=0.04u
M161 U263/net36 n257 VSS VSS nmos W=0.155u L=0.04u
M162 U263/net19 G6 VDD VDD pmos W=0.205u L=0.04u
M163 n255 U263/net19 U263/net26 VDD pmos W=0.325u L=0.04u
M164 U263/net26 n258 VDD VDD pmos W=0.41u L=0.04u
M165 n255 G6 U263/net30 VDD pmos W=0.325u L=0.04u
M166 U263/net30 n257 VDD VDD pmos W=0.205u L=0.04u
M167 n254 n43 VSS VSS nmos W=0.155u L=0.04u
M168 n254 n259 VSS VSS nmos W=0.155u L=0.04u
M169 U264/XI1-net8 n259 VDD VDD pmos W=0.205u L=0.04u
M170 n254 n43 U264/XI1-net8 VDD pmos W=0.205u L=0.04u
M171 n225 G2 U265/XI0-net10 VSS nmos W=0.155u L=0.04u
M172 U265/XI0-net10 n260 U265/XI0-net13 VSS nmos W=0.155u L=0.04u
M173 U265/XI0-net13 n261 VSS VSS nmos W=0.155u L=0.04u
M174 n225 n261 VDD VDD pmos W=0.205u L=0.04u
M175 n225 G2 VDD VDD pmos W=0.205u L=0.04u
M176 n225 n260 VDD VDD pmos W=0.205u L=0.04u
M177 U266/net19 G4 VSS VSS nmos W=0.155u L=0.04u
M178 n261 G4 U266/net40 VSS nmos W=0.155u L=0.04u
M179 n261 U266/net19 U266/net36 VSS nmos W=0.155u L=0.04u
M180 U266/net40 n262 VSS VSS nmos W=0.31u L=0.04u
M181 U266/net36 n43 VSS VSS nmos W=0.155u L=0.04u
M182 U266/net19 G4 VDD VDD pmos W=0.205u L=0.04u
M183 n261 U266/net19 U266/net26 VDD pmos W=0.325u L=0.04u
M184 U266/net26 n262 VDD VDD pmos W=0.41u L=0.04u
M185 n261 G4 U266/net30 VDD pmos W=0.325u L=0.04u
M186 U266/net30 n43 VDD VDD pmos W=0.205u L=0.04u
M187 n224 n263 U267/net15 VSS nmos W=0.155u L=0.04u
M188 n224 n264 U267/net15 VSS nmos W=0.155u L=0.04u
M189 U267/net15 G3 VSS VSS nmos W=0.155u L=0.04u
M190 n224 G3 VDD VDD pmos W=0.205u L=0.04u
M191 n224 n263 U267/XI16-net11 VDD pmos W=0.205u L=0.04u
M192 U267/XI16-net11 n264 VDD VDD pmos W=0.205u L=0.04u
M193 n264 n266 VSS VSS nmos W=0.155u L=0.04u
M194 n264 U268/net4 VSS VSS nmos W=0.155u L=0.04u
M195 U268/net4 n265 VSS VSS nmos W=0.155u L=0.04u
M196 U268/XU1-net8 U268/net4 VDD VDD pmos W=0.205u L=0.04u
M197 n264 n266 U268/XU1-net8 VDD pmos W=0.205u L=0.04u
M198 U268/net4 n265 VDD VDD pmos W=0.205u L=0.04u
M199 VSS n260 U269/net22 VSS nmos W=0.155u L=0.04u
M200 U269/net22 n269 n223 VSS nmos W=0.155u L=0.04u
M201 U269/net22 n268 n223 VSS nmos W=0.155u L=0.04u
M202 U269/net22 n267 n223 VSS nmos W=0.155u L=0.04u
M203 U269/net38 n267 VDD VDD pmos W=0.205u L=0.04u
M204 U269/net35 n268 U269/net38 VDD pmos W=0.205u L=0.04u
M205 n223 n269 U269/net35 VDD pmos W=0.205u L=0.04u
M206 n223 n260 VDD VDD pmos W=0.205u L=0.04u
M207 n269 n270 VSS VSS nmos W=0.155u L=0.04u
M208 n269 n258 VSS VSS nmos W=0.155u L=0.04u
M209 U270/XI1-net8 n258 VDD VDD pmos W=0.205u L=0.04u
M210 n269 n270 U270/XI1-net8 VDD pmos W=0.205u L=0.04u
M211 n222 n271 U271/XI0-net10 VSS nmos W=0.155u L=0.04u
M212 U271/XI0-net10 G2 U271/XI0-net13 VSS nmos W=0.155u L=0.04u
M213 U271/XI0-net13 n272 VSS VSS nmos W=0.155u L=0.04u
M214 n222 n272 VDD VDD pmos W=0.205u L=0.04u
M215 n222 n271 VDD VDD pmos W=0.205u L=0.04u
M216 n222 G2 VDD VDD pmos W=0.205u L=0.04u
M217 U272/net11 n267 n272 VDD pmos W=0.205u L=0.04u
M218 U272/net11 n262 n272 VDD pmos W=0.205u L=0.04u
M219 U272/net11 n273 U272/XI16-net11 VDD pmos W=0.205u L=0.04u
M220 U272/XI16-net11 n274 VDD VDD pmos W=0.205u L=0.04u
M221 n272 n274 VSS VSS nmos W=0.155u L=0.04u
M222 n272 n273 VSS VSS nmos W=0.155u L=0.04u
M223 n272 n267 U272/XI12-net17 VSS nmos W=0.155u L=0.04u
M224 U272/XI12-net17 n262 VSS VSS nmos W=0.155u L=0.04u
M225 n273 n275 VSS VSS nmos W=0.135u L=0.04u
M226 n273 n275 VDD VDD pmos W=0.205u L=0.04u
M227 U274/net36 n235 U274/net24 VSS nmos W=0.155u L=0.04u
M228 U274/net24 G34 VSS VSS nmos W=0.155u L=0.04u
M229 n221 n276 U274/net36 VSS nmos W=0.155u L=0.04u
M230 n221 n240 U274/net36 VSS nmos W=0.155u L=0.04u
M231 n221 n240 U274/net35 VDD pmos W=0.205u L=0.04u
M232 U274/net35 n276 VDD VDD pmos W=0.205u L=0.04u
M233 n221 G34 VDD VDD pmos W=0.205u L=0.04u
M234 n221 n235 VDD VDD pmos W=0.205u L=0.04u
M235 n220 U275/net28 VSS VSS nmos W=0.155u L=0.04u
M236 U275/net47 n277 VSS VSS nmos W=0.155u L=0.04u
M237 U275/net28 U275/net6 U275/net47 VSS nmos W=0.155u L=0.04u
M238 U275/net44 G32 VSS VSS nmos W=0.155u L=0.04u
M239 U275/net28 n278 U275/net44 VSS nmos W=0.155u L=0.04u
M240 U275/net6 n278 VSS VSS nmos W=0.155u L=0.04u
M241 n220 U275/net28 VDD VDD pmos W=0.205u L=0.04u
M242 VDD n277 U275/net47 VDD pmos W=0.205u L=0.04u
M243 U275/net47 n278 U275/net28 VDD pmos W=0.205u L=0.04u
M244 U275/net44 U275/net6 U275/net28 VDD pmos W=0.205u L=0.04u
M245 VDD G32 U275/net44 VDD pmos W=0.205u L=0.04u
M246 VDD n278 U275/net6 VDD pmos W=0.205u L=0.04u
M247 U276/net36 n280 U276/net24 VSS nmos W=0.155u L=0.04u
M248 U276/net24 G8 VSS VSS nmos W=0.155u L=0.04u
M249 n219 G6 U276/net36 VSS nmos W=0.155u L=0.04u
M250 n219 n279 U276/net36 VSS nmos W=0.155u L=0.04u
M251 n219 n279 U276/net35 VDD pmos W=0.205u L=0.04u
M252 U276/net35 G6 VDD VDD pmos W=0.205u L=0.04u
M253 n219 G8 VDD VDD pmos W=0.205u L=0.04u
M254 n219 n280 VDD VDD pmos W=0.205u L=0.04u
M255 VSS n281 U277/net22 VSS nmos W=0.155u L=0.04u
M256 U277/net22 n276 n280 VSS nmos W=0.155u L=0.04u
M257 U277/net22 G11 n280 VSS nmos W=0.155u L=0.04u
M258 U277/net22 n240 n280 VSS nmos W=0.155u L=0.04u
M259 U277/net38 n240 VDD VDD pmos W=0.205u L=0.04u
M260 U277/net35 G11 U277/net38 VDD pmos W=0.205u L=0.04u
M261 n280 n276 U277/net35 VDD pmos W=0.205u L=0.04u
M262 n280 n281 VDD VDD pmos W=0.205u L=0.04u
M263 n281 G31 VSS VSS nmos W=0.155u L=0.04u
M264 n281 n279 VSS VSS nmos W=0.155u L=0.04u
M265 U278/XI1-net8 n279 VDD VDD pmos W=0.205u L=0.04u
M266 n281 G31 U278/XI1-net8 VDD pmos W=0.205u L=0.04u
M267 n217 n282 U279/XI0-net10 VSS nmos W=0.155u L=0.04u
M268 U279/XI0-net10 n31 U279/XI0-net13 VSS nmos W=0.155u L=0.04u
M269 U279/XI0-net13 n283 VSS VSS nmos W=0.155u L=0.04u
M270 n217 n283 VDD VDD pmos W=0.205u L=0.04u
M271 n217 n282 VDD VDD pmos W=0.205u L=0.04u
M272 n217 n31 VDD VDD pmos W=0.205u L=0.04u
M273 n216 n284 U280/XI0-net10 VSS nmos W=0.155u L=0.04u
M274 U280/XI0-net10 n285 U280/XI0-net13 VSS nmos W=0.155u L=0.04u
M275 U280/XI0-net13 n252 VSS VSS nmos W=0.155u L=0.04u
M276 n216 n252 VDD VDD pmos W=0.205u L=0.04u
M277 n216 n284 VDD VDD pmos W=0.205u L=0.04u
M278 n216 n285 VDD VDD pmos W=0.205u L=0.04u
M279 n215 n286 U281/XI0-net10 VSS nmos W=0.155u L=0.04u
M280 U281/XI0-net10 n239 U281/XI0-net13 VSS nmos W=0.155u L=0.04u
M281 U281/XI0-net13 n287 VSS VSS nmos W=0.155u L=0.04u
M282 n215 n287 VDD VDD pmos W=0.205u L=0.04u
M283 n215 n286 VDD VDD pmos W=0.205u L=0.04u
M284 n215 n239 VDD VDD pmos W=0.205u L=0.04u
M285 U282/p2 G1 VSS VSS nmos W=0.155u L=0.04u
M286 U282/p0 G0 U282/p1 VSS nmos W=0.155u L=0.04u
M287 U282/p1 n289 U282/p2 VSS nmos W=0.155u L=0.04u
M288 n213 n288 U282/p0 VSS nmos W=0.155u L=0.04u
M289 n213 n289 VDD VDD pmos W=0.205u L=0.04u
M290 n213 G0 VDD VDD pmos W=0.205u L=0.04u
M291 n213 n288 VDD VDD pmos W=0.205u L=0.04u
M292 n213 G1 VDD VDD pmos W=0.205u L=0.04u
M293 n289 G4 VSS VSS nmos W=0.155u L=0.04u
M294 n289 n31 VSS VSS nmos W=0.155u L=0.04u
M295 U283/XI1-net8 n31 VDD VDD pmos W=0.205u L=0.04u
M296 n289 G4 U283/XI1-net8 VDD pmos W=0.205u L=0.04u
M297 N93 n283 VSS VSS nmos W=0.155u L=0.04u
M298 N93 n241 U284/XI17-net17 VSS nmos W=0.155u L=0.04u
M299 U284/XI17-net17 n292 VSS VSS nmos W=0.155u L=0.04u
M300 N93 n290 U284/XI10-net17 VSS nmos W=0.155u L=0.04u
M301 U284/XI10-net17 n291 VSS VSS nmos W=0.155u L=0.04u
M302 U284/net30 n290 N93 VDD pmos W=0.205u L=0.04u
M303 U284/net30 n291 N93 VDD pmos W=0.205u L=0.04u
M304 VDD n283 U284/net36 VDD pmos W=0.205u L=0.04u
M305 U284/net36 n292 U284/net30 VDD pmos W=0.205u L=0.04u
M306 U284/net36 n241 U284/net30 VDD pmos W=0.205u L=0.04u
M307 U285/XU1-net6 n43 VSS VSS nmos W=0.155u L=0.04u
M308 n241 n285 U285/XU1-net6 VSS nmos W=0.155u L=0.04u
M309 n241 n43 VDD VDD pmos W=0.155u L=0.04u
M310 n241 n285 VDD VDD pmos W=0.155u L=0.04u
M311 U286/net14 n248 U286/net20 VSS nmos W=0.155u L=0.04u
M312 U286/net14 n252 U286/net20 VSS nmos W=0.155u L=0.04u
M313 U286/net20 n293 VSS VSS nmos W=0.155u L=0.04u
M314 N69 U286/net14 VSS VSS nmos W=0.155u L=0.04u
M315 N69 U286/net14 VDD VDD pmos W=0.205u L=0.04u
M316 U286/net14 n293 VDD VDD pmos W=0.205u L=0.04u
M317 U286/net24 n248 VDD VDD pmos W=0.205u L=0.04u
M318 U286/net14 n252 U286/net24 VDD pmos W=0.205u L=0.04u
M319 N57 G2 U287/net15 VSS nmos W=0.155u L=0.04u
M320 N57 n294 U287/net15 VSS nmos W=0.155u L=0.04u
M321 U287/net15 n295 VSS VSS nmos W=0.155u L=0.04u
M322 N57 n295 VDD VDD pmos W=0.205u L=0.04u
M323 N57 G2 U287/XI16-net11 VDD pmos W=0.205u L=0.04u
M324 U287/XI16-net11 n294 VDD VDD pmos W=0.205u L=0.04u
M325 U288/XU1-net6 n244 VSS VSS nmos W=0.155u L=0.04u
M326 N50 n238 U288/XU1-net6 VSS nmos W=0.155u L=0.04u
M327 N50 n244 VDD VDD pmos W=0.155u L=0.04u
M328 N50 n238 VDD VDD pmos W=0.155u L=0.04u
M329 N43 G9 U289/net15 VSS nmos W=0.155u L=0.04u
M330 N43 G6 U289/net15 VSS nmos W=0.155u L=0.04u
M331 U289/net15 n239 VSS VSS nmos W=0.155u L=0.04u
M332 N43 n239 VDD VDD pmos W=0.205u L=0.04u
M333 N43 G9 U289/XI16-net11 VDD pmos W=0.205u L=0.04u
M334 U289/XI16-net11 G6 VDD VDD pmos W=0.205u L=0.04u
M335 U290/XU1-net6 G9 VSS VSS nmos W=0.155u L=0.04u
M336 n239 G6 U290/XU1-net6 VSS nmos W=0.155u L=0.04u
M337 n239 G9 VDD VDD pmos W=0.155u L=0.04u
M338 n239 G6 VDD VDD pmos W=0.155u L=0.04u
M339 N117 n298 VSS VSS nmos W=0.155u L=0.04u
M340 N117 n297 VSS VSS nmos W=0.155u L=0.04u
M341 N117 n296 VSS VSS nmos W=0.155u L=0.04u
M342 U291/net25 n298 VDD VDD pmos W=0.41u L=0.04u
M343 U291/net28 n297 U291/net25 VDD pmos W=0.41u L=0.04u
M344 N117 n296 U291/net28 VDD pmos W=0.41u L=0.04u
M345 N105 n300 VSS VSS nmos W=0.155u L=0.04u
M346 N105 U292/net4 VSS VSS nmos W=0.155u L=0.04u
M347 U292/net4 n299 VSS VSS nmos W=0.155u L=0.04u
M348 U292/XU1-net8 U292/net4 VDD VDD pmos W=0.205u L=0.04u
M349 N105 n300 U292/XU1-net8 VDD pmos W=0.205u L=0.04u
M350 U292/net4 n299 VDD VDD pmos W=0.205u L=0.04u
M351 G552 n302 U293/net27 VSS nmos W=0.155u L=0.04u
M352 U293/net39 n305 VSS VSS nmos W=0.155u L=0.04u
M353 U293/net27 n303 U293/net39 VSS nmos W=0.155u L=0.04u
M354 U293/net27 n304 U293/net39 VSS nmos W=0.155u L=0.04u
M355 G552 n301 U293/net27 VSS nmos W=0.155u L=0.04u
M356 U293/net39 G40 VSS VSS nmos W=0.155u L=0.04u
M357 G552 n305 U293/net46 VDD pmos W=0.205u L=0.04u
M358 U293/net46 G40 VDD VDD pmos W=0.205u L=0.04u
M359 G552 n301 U293/net34 VDD pmos W=0.205u L=0.04u
M360 U293/net34 n302 VDD VDD pmos W=0.205u L=0.04u
M361 G552 n304 U293/net37 VDD pmos W=0.205u L=0.04u
M362 U293/net37 n303 VDD VDD pmos W=0.205u L=0.04u
M363 U294/net17 n266 VSS VSS nmos W=0.155u L=0.04u
M364 U294/net17 n307 VSS VSS nmos W=0.155u L=0.04u
M365 U294/net63 n306 VSS VSS nmos W=0.155u L=0.04u
M366 n303 U294/net17 VSS VSS nmos W=0.155u L=0.04u
M367 n303 G6 U294/net63 VSS nmos W=0.155u L=0.04u
M368 n303 n306 U294/net31 VDD pmos W=0.205u L=0.04u
M369 U294/net39 n266 VDD VDD pmos W=0.195u L=0.04u
M370 U294/net31 U294/net17 VDD VDD pmos W=0.195u L=0.04u
M371 n303 G6 U294/net31 VDD pmos W=0.195u L=0.04u
M372 U294/net17 n307 U294/net39 VDD pmos W=0.195u L=0.04u
M373 n306 U295/net27 VDD VDD pmos W=0.205u L=0.04u
M374 U295/net11 n242 U295/net27 VDD pmos W=0.205u L=0.04u
M375 U295/net11 n290 U295/net27 VDD pmos W=0.205u L=0.04u
M376 U295/net11 n292 U295/XI16-net11 VDD pmos W=0.205u L=0.04u
M377 U295/XI16-net11 n283 VDD VDD pmos W=0.205u L=0.04u
M378 U295/net27 n283 VSS VSS nmos W=0.155u L=0.04u
M379 U295/net27 n292 VSS VSS nmos W=0.155u L=0.04u
M380 n306 U295/net27 VSS VSS nmos W=0.155u L=0.04u
M381 U295/net27 n242 U295/XI12-net17 VSS nmos W=0.155u L=0.04u
M382 U295/XI12-net17 n290 VSS VSS nmos W=0.155u L=0.04u
M383 n292 n233 VSS VSS nmos W=0.135u L=0.04u
M384 n292 n233 VDD VDD pmos W=0.205u L=0.04u
M385 U297/XU1-net6 n258 VSS VSS nmos W=0.155u L=0.04u
M386 n233 n308 U297/XU1-net6 VSS nmos W=0.155u L=0.04u
M387 n233 n258 VDD VDD pmos W=0.155u L=0.04u
M388 n233 n308 VDD VDD pmos W=0.155u L=0.04u
M389 U298/net36 n285 U298/net27 VSS nmos W=0.155u L=0.04u
M390 U298/net39 n290 VSS VSS nmos W=0.155u L=0.04u
M391 U298/net27 n310 U298/net39 VSS nmos W=0.155u L=0.04u
M392 U298/net27 n311 U298/net39 VSS nmos W=0.155u L=0.04u
M393 U298/net36 n309 U298/net27 VSS nmos W=0.155u L=0.04u
M394 U298/net39 n312 VSS VSS nmos W=0.155u L=0.04u
M395 n301 U298/net36 VSS VSS nmos W=0.155u L=0.04u
M396 n301 U298/net36 VDD VDD pmos W=0.205u L=0.04u
M397 U298/net36 n290 U298/net46 VDD pmos W=0.205u L=0.04u
M398 U298/net46 n312 VDD VDD pmos W=0.205u L=0.04u
M399 U298/net36 n309 U298/net34 VDD pmos W=0.205u L=0.04u
M400 U298/net34 n285 VDD VDD pmos W=0.205u L=0.04u
M401 U298/net36 n311 U298/net37 VDD pmos W=0.205u L=0.04u
M402 U298/net37 n310 VDD VDD pmos W=0.205u L=0.04u
M403 G551 n313 U299/net15 VSS nmos W=0.155u L=0.04u
M404 G551 n302 U299/net15 VSS nmos W=0.155u L=0.04u
M405 U299/net15 n314 VSS VSS nmos W=0.155u L=0.04u
M406 G551 n314 VDD VDD pmos W=0.205u L=0.04u
M407 G551 n313 U299/XI16-net11 VDD pmos W=0.205u L=0.04u
M408 U299/XI16-net11 n302 VDD VDD pmos W=0.205u L=0.04u
M409 n314 n315 U300/net23 VDD pmos W=0.205u L=0.04u
M410 n314 G39 U300/net23 VDD pmos W=0.205u L=0.04u
M411 n314 G4 U300/net23 VDD pmos W=0.205u L=0.04u
M412 U300/net23 n287 VDD VDD pmos W=0.205u L=0.04u
M413 U300/net23 n316 VDD VDD pmos W=0.205u L=0.04u
M414 U300/XI20-net13 G39 VSS VSS nmos W=0.155u L=0.04u
M415 n314 n315 U300/XI20-net17 VSS nmos W=0.155u L=0.04u
M416 U300/XI20-net17 G4 U300/XI20-net13 VSS nmos W=0.155u L=0.04u
M417 n314 n287 U300/XI17-net17 VSS nmos W=0.155u L=0.04u
M418 U300/XI17-net17 n316 VSS VSS nmos W=0.155u L=0.04u
M419 n316 n43 U301/net10 VSS nmos W=0.155u L=0.04u
M420 U301/net10 n318 VSS VSS nmos W=0.155u L=0.04u
M421 n316 n317 U301/net10 VSS nmos W=0.155u L=0.04u
M422 U301/net10 n311 VSS VSS nmos W=0.155u L=0.04u
M423 U301/net30 n318 VDD VDD pmos W=0.205u L=0.04u
M424 n316 n43 U301/net24 VDD pmos W=0.205u L=0.04u
M425 U301/net24 n317 VDD VDD pmos W=0.205u L=0.04u
M426 n316 n311 U301/net30 VDD pmos W=0.205u L=0.04u
M427 n317 n320 VSS VSS nmos W=0.155u L=0.04u
M428 n317 n319 U302/XI17-net17 VSS nmos W=0.155u L=0.04u
M429 U302/XI17-net17 n262 VSS VSS nmos W=0.155u L=0.04u
M430 n317 n311 U302/XI10-net17 VSS nmos W=0.155u L=0.04u
M431 U302/XI10-net17 n267 VSS VSS nmos W=0.155u L=0.04u
M432 U302/net30 n311 n317 VDD pmos W=0.205u L=0.04u
M433 U302/net30 n267 n317 VDD pmos W=0.205u L=0.04u
M434 VDD n320 U302/net36 VDD pmos W=0.205u L=0.04u
M435 U302/net36 n262 U302/net30 VDD pmos W=0.205u L=0.04u
M436 U302/net36 n319 U302/net30 VDD pmos W=0.205u L=0.04u
M437 U303/net32 G0 VSS VSS nmos W=0.155u L=0.04u
M438 U303/net59 n321 U303/net32 VSS nmos W=0.155u L=0.04u
M439 U303/net59 n274 VSS VSS nmos W=0.155u L=0.04u
M440 n319 U303/net59 VSS VSS nmos W=0.155u L=0.04u
M441 n319 U303/net59 VDD VDD pmos W=0.2u L=0.04u
M442 U303/net59 n321 U303/net22 VDD pmos W=0.205u L=0.04u
M443 U303/net59 G0 U303/net22 VDD pmos W=0.205u L=0.04u
M444 U303/net22 n274 VDD VDD pmos W=0.2u L=0.04u
M445 n313 n323 VSS VSS nmos W=0.155u L=0.04u
M446 n313 n322 U304/XI17-net17 VSS nmos W=0.155u L=0.04u
M447 U304/XI17-net17 n43 VSS VSS nmos W=0.155u L=0.04u
M448 n313 n311 U304/XI10-net17 VSS nmos W=0.155u L=0.04u
M449 U304/XI10-net17 n308 VSS VSS nmos W=0.155u L=0.04u
M450 U304/net30 n311 n313 VDD pmos W=0.205u L=0.04u
M451 U304/net30 n308 n313 VDD pmos W=0.205u L=0.04u
M452 VDD n323 U304/net36 VDD pmos W=0.205u L=0.04u
M453 U304/net36 n43 U304/net30 VDD pmos W=0.205u L=0.04u
M454 U304/net36 n322 U304/net30 VDD pmos W=0.205u L=0.04u
M455 U305/net36 n307 U305/net24 VSS nmos W=0.155u L=0.04u
M456 U305/net24 n258 VSS VSS nmos W=0.155u L=0.04u
M457 n323 G1 U305/net36 VSS nmos W=0.155u L=0.04u
M458 n323 n257 U305/net36 VSS nmos W=0.155u L=0.04u
M459 n323 n257 U305/net35 VDD pmos W=0.205u L=0.04u
M460 U305/net35 G1 VDD VDD pmos W=0.205u L=0.04u
M461 n323 n258 VDD VDD pmos W=0.205u L=0.04u
M462 n323 n307 VDD VDD pmos W=0.205u L=0.04u
M463 G550 n324 U306/net26 VSS nmos W=0.155u L=0.04u
M464 G550 n302 U306/net26 VSS nmos W=0.155u L=0.04u
M465 U306/net29 n326 VSS VSS nmos W=0.155u L=0.04u
M466 U306/net26 n262 U306/net29 VSS nmos W=0.155u L=0.04u
M467 U306/net26 n325 U306/net29 VSS nmos W=0.155u L=0.04u
M468 G550 n302 U306/net43 VDD pmos W=0.205u L=0.04u
M469 G550 n325 U306/net49 VDD pmos W=0.205u L=0.04u
M470 U306/net49 n262 VDD VDD pmos W=0.205u L=0.04u
M471 U306/net43 n324 VDD VDD pmos W=0.205u L=0.04u
M472 G550 n326 VDD VDD pmos W=0.205u L=0.04u
M473 VSS n327 U307/net22 VSS nmos W=0.155u L=0.04u
M474 U307/net22 n305 U307/net30 VSS nmos W=0.155u L=0.04u
M475 U307/net22 n267 U307/net30 VSS nmos W=0.155u L=0.04u
M476 U307/net22 G29 U307/net30 VSS nmos W=0.155u L=0.04u
M477 n326 U307/net30 VSS VSS nmos W=0.155u L=0.04u
M478 n326 U307/net30 VDD VDD pmos W=0.205u L=0.04u
M479 U307/net38 G29 VDD VDD pmos W=0.205u L=0.04u
M480 U307/net35 n267 U307/net38 VDD pmos W=0.205u L=0.04u
M481 U307/net30 n305 U307/net35 VDD pmos W=0.205u L=0.04u
M482 U307/net30 n327 VDD VDD pmos W=0.205u L=0.04u
M483 n327 n294 U308/net19 VDD pmos W=0.205u L=0.04u
M484 n327 n315 U308/net19 VDD pmos W=0.205u L=0.04u
M485 n327 n257 U308/net19 VDD pmos W=0.205u L=0.04u
M486 U308/net19 n328 VDD VDD pmos W=0.205u L=0.04u
M487 n327 n328 VSS VSS nmos W=0.155u L=0.04u
M488 U308/XI20-net13 n315 VSS VSS nmos W=0.155u L=0.04u
M489 n327 n294 U308/XI20-net17 VSS nmos W=0.155u L=0.04u
M490 U308/XI20-net17 n257 U308/XI20-net13 VSS nmos W=0.155u L=0.04u
M491 n315 n304 VSS VSS nmos W=0.135u L=0.04u
M492 n315 n304 VDD VDD pmos W=0.205u L=0.04u
M493 U310/net19 n311 VSS VSS nmos W=0.155u L=0.04u
M494 n324 n311 U310/net40 VSS nmos W=0.155u L=0.04u
M495 n324 U310/net19 U310/net36 VSS nmos W=0.155u L=0.04u
M496 U310/net40 n329 VSS VSS nmos W=0.31u L=0.04u
M497 U310/net36 n290 VSS VSS nmos W=0.155u L=0.04u
M498 U310/net19 n311 VDD VDD pmos W=0.205u L=0.04u
M499 n324 U310/net19 U310/net26 VDD pmos W=0.325u L=0.04u
M500 U310/net26 n329 VDD VDD pmos W=0.41u L=0.04u
M501 n324 n311 U310/net30 VDD pmos W=0.325u L=0.04u
M502 U310/net30 n290 VDD VDD pmos W=0.205u L=0.04u
M503 n329 G5 VSS VSS nmos W=0.155u L=0.04u
M504 n329 n266 VSS VSS nmos W=0.155u L=0.04u
M505 U311/XI1-net8 n266 VDD VDD pmos W=0.205u L=0.04u
M506 n329 G5 U311/XI1-net8 VDD pmos W=0.205u L=0.04u
M507 n290 n330 VSS VSS nmos W=0.135u L=0.04u
M508 n290 n330 VDD VDD pmos W=0.205u L=0.04u
M509 U313/net20 n328 VSS VSS nmos W=0.155u L=0.04u
M510 G549 n332 U313/p0 VSS nmos W=0.155u L=0.04u
M511 U313/p2 U313/net20 VSS VSS nmos W=0.155u L=0.04u
M512 U313/p1 n325 U313/p2 VSS nmos W=0.155u L=0.04u
M513 U313/p0 n331 U313/p1 VSS nmos W=0.155u L=0.04u
M514 U313/net20 n328 VDD VDD pmos W=0.205u L=0.04u
M515 G549 n325 VDD VDD pmos W=0.205u L=0.04u
M516 G549 n332 VDD VDD pmos W=0.205u L=0.04u
M517 G549 n331 VDD VDD pmos W=0.205u L=0.04u
M518 G549 U313/net20 VDD VDD pmos W=0.205u L=0.04u
M519 n332 n311 U314/net19 VDD pmos W=0.205u L=0.04u
M520 n332 n287 U314/net19 VDD pmos W=0.205u L=0.04u
M521 n332 n262 U314/net19 VDD pmos W=0.205u L=0.04u
M522 U314/net19 n333 VDD VDD pmos W=0.205u L=0.04u
M523 n332 n333 VSS VSS nmos W=0.155u L=0.04u
M524 U314/XI20-net13 n287 VSS VSS nmos W=0.155u L=0.04u
M525 n332 n311 U314/XI20-net17 VSS nmos W=0.155u L=0.04u
M526 U314/XI20-net17 n262 U314/XI20-net13 VSS nmos W=0.155u L=0.04u
M527 U315/net11 G3 n333 VDD pmos W=0.205u L=0.04u
M528 U315/net11 G4 n333 VDD pmos W=0.205u L=0.04u
M529 U315/net11 n304 U315/XI16-net11 VDD pmos W=0.205u L=0.04u
M530 U315/XI16-net11 n330 VDD VDD pmos W=0.205u L=0.04u
M531 n333 n330 VSS VSS nmos W=0.155u L=0.04u
M532 n333 n304 VSS VSS nmos W=0.155u L=0.04u
M533 n333 G3 U315/XI12-net17 VSS nmos W=0.155u L=0.04u
M534 U315/XI12-net17 G4 VSS VSS nmos W=0.155u L=0.04u
M535 n304 n31 U316/XI0-net10 VSS nmos W=0.155u L=0.04u
M536 U316/XI0-net10 n278 U316/XI0-net13 VSS nmos W=0.155u L=0.04u
M537 U316/XI0-net13 n282 VSS VSS nmos W=0.155u L=0.04u
M538 n304 n282 VDD VDD pmos W=0.205u L=0.04u
M539 n304 n31 VDD VDD pmos W=0.205u L=0.04u
M540 n304 n278 VDD VDD pmos W=0.205u L=0.04u
M541 U317/net36 G1 U317/net24 VSS nmos W=0.155u L=0.04u
M542 U317/net24 n335 VSS VSS nmos W=0.155u L=0.04u
M543 n331 n283 U317/net36 VSS nmos W=0.155u L=0.04u
M544 n331 n334 U317/net36 VSS nmos W=0.155u L=0.04u
M545 n331 n334 U317/net35 VDD pmos W=0.205u L=0.04u
M546 U317/net35 n283 VDD VDD pmos W=0.205u L=0.04u
M547 n331 n335 VDD VDD pmos W=0.205u L=0.04u
M548 n331 G1 VDD VDD pmos W=0.205u L=0.04u
M549 n334 n270 U318/net23 VDD pmos W=0.205u L=0.04u
M550 n334 G4 U318/net23 VDD pmos W=0.205u L=0.04u
M551 n334 n307 U318/net23 VDD pmos W=0.205u L=0.04u
M552 U318/net23 n266 VDD VDD pmos W=0.205u L=0.04u
M553 U318/net23 n43 VDD VDD pmos W=0.205u L=0.04u
M554 U318/XI20-net13 G4 VSS VSS nmos W=0.155u L=0.04u
M555 n334 n270 U318/XI20-net17 VSS nmos W=0.155u L=0.04u
M556 U318/XI20-net17 n307 U318/XI20-net13 VSS nmos W=0.155u L=0.04u
M557 n334 n266 U318/XI17-net17 VSS nmos W=0.155u L=0.04u
M558 U318/XI17-net17 n43 VSS VSS nmos W=0.155u L=0.04u
M559 n283 n266 VSS VSS nmos W=0.155u L=0.04u
M560 n283 n258 VSS VSS nmos W=0.155u L=0.04u
M561 U319/XI1-net8 n258 VDD VDD pmos W=0.205u L=0.04u
M562 n283 n266 U319/XI1-net8 VDD pmos W=0.205u L=0.04u
M563 n325 n311 U320/XI0-net10 VSS nmos W=0.155u L=0.04u
M564 U320/XI0-net10 n267 U320/XI0-net13 VSS nmos W=0.155u L=0.04u
M565 U320/XI0-net13 n287 VSS VSS nmos W=0.155u L=0.04u
M566 n325 n287 VDD VDD pmos W=0.205u L=0.04u
M567 n325 n311 VDD VDD pmos W=0.205u L=0.04u
M568 n325 n267 VDD VDD pmos W=0.205u L=0.04u
M569 n328 n262 VSS VSS nmos W=0.155u L=0.04u
M570 n328 G13 VSS VSS nmos W=0.155u L=0.04u
M571 n328 G33 VSS VSS nmos W=0.155u L=0.04u
M572 U321/net25 n262 VDD VDD pmos W=0.41u L=0.04u
M573 U321/net28 G13 U321/net25 VDD pmos W=0.41u L=0.04u
M574 n328 G33 U321/net28 VDD pmos W=0.41u L=0.04u
M575 G548 G42 U322/net10 VSS nmos W=0.155u L=0.04u
M576 U322/net10 n337 VSS VSS nmos W=0.155u L=0.04u
M577 G548 n305 U322/net10 VSS nmos W=0.155u L=0.04u
M578 U322/net10 n336 VSS VSS nmos W=0.155u L=0.04u
M579 U322/net30 n337 VDD VDD pmos W=0.205u L=0.04u
M580 G548 G42 U322/net24 VDD pmos W=0.205u L=0.04u
M581 U322/net24 n305 VDD VDD pmos W=0.205u L=0.04u
M582 G548 n336 U322/net30 VDD pmos W=0.205u L=0.04u
M583 n336 G7 U323/net23 VDD pmos W=0.205u L=0.04u
M584 n336 n248 U323/net23 VDD pmos W=0.205u L=0.04u
M585 n336 n338 U323/net23 VDD pmos W=0.205u L=0.04u
M586 U323/net23 G11 VDD VDD pmos W=0.205u L=0.04u
M587 U323/net23 n339 VDD VDD pmos W=0.205u L=0.04u
M588 U323/XI20-net13 n248 VSS VSS nmos W=0.155u L=0.04u
M589 n336 G7 U323/XI20-net17 VSS nmos W=0.155u L=0.04u
M590 U323/XI20-net17 n338 U323/XI20-net13 VSS nmos W=0.155u L=0.04u
M591 n336 G11 U323/XI17-net17 VSS nmos W=0.155u L=0.04u
M592 U323/XI17-net17 n339 VSS VSS nmos W=0.155u L=0.04u
M593 n339 n340 U324/net10 VSS nmos W=0.155u L=0.04u
M594 U324/net10 n247 VSS VSS nmos W=0.155u L=0.04u
M595 n339 n341 U324/net10 VSS nmos W=0.155u L=0.04u
M596 U324/net10 G9 VSS VSS nmos W=0.155u L=0.04u
M597 U324/net30 n247 VDD VDD pmos W=0.205u L=0.04u
M598 n339 n340 U324/net24 VDD pmos W=0.205u L=0.04u
M599 U324/net24 n341 VDD VDD pmos W=0.205u L=0.04u
M600 n339 G9 U324/net30 VDD pmos W=0.205u L=0.04u
M601 G547 n342 U325/net10 VSS nmos W=0.155u L=0.04u
M602 U325/net10 n276 VSS VSS nmos W=0.155u L=0.04u
M603 G547 n343 U325/net10 VSS nmos W=0.155u L=0.04u
M604 U325/net10 n344 VSS VSS nmos W=0.155u L=0.04u
M605 U325/net30 n276 VDD VDD pmos W=0.205u L=0.04u
M606 G547 n342 U325/net24 VDD pmos W=0.205u L=0.04u
M607 U325/net24 n343 VDD VDD pmos W=0.205u L=0.04u
M608 G547 n344 U325/net30 VDD pmos W=0.205u L=0.04u
M609 n344 n286 U326/net23 VDD pmos W=0.205u L=0.04u
M610 n344 n287 U326/net23 VDD pmos W=0.205u L=0.04u
M611 n344 n285 U326/net23 VDD pmos W=0.205u L=0.04u
M612 U326/net23 G34 VDD VDD pmos W=0.205u L=0.04u
M613 U326/net23 n345 VDD VDD pmos W=0.205u L=0.04u
M614 U326/XI20-net13 n287 VSS VSS nmos W=0.155u L=0.04u
M615 n344 n286 U326/XI20-net17 VSS nmos W=0.155u L=0.04u
M616 U326/XI20-net17 n285 U326/XI20-net13 VSS nmos W=0.155u L=0.04u
M617 n344 G34 U326/XI17-net17 VSS nmos W=0.155u L=0.04u
M618 U326/XI17-net17 n345 VSS VSS nmos W=0.155u L=0.04u
M619 U327/net4 U327/net10 U327/net14 VSS nmos W=0.155u L=0.04u
M620 U327/net6 n338 U327/net14 VSS nmos W=0.155u L=0.04u
M621 U327/net4 n240 VSS VSS nmos W=0.155u L=0.04u
M622 U327/net6 U327/net4 VSS VSS nmos W=0.155u L=0.04u
M623 n345 U327/net14 VSS VSS nmos W=0.155u L=0.04u
M624 U327/net10 n338 VSS VSS nmos W=0.155u L=0.04u
M625 U327/net4 n338 U327/net14 VDD pmos W=0.205u L=0.04u
M626 U327/net6 U327/net10 U327/net14 VDD pmos W=0.205u L=0.04u
M627 U327/net4 n240 VDD VDD pmos W=0.205u L=0.04u
M628 U327/net6 U327/net4 VDD VDD pmos W=0.205u L=0.04u
M629 n345 U327/net14 VDD VDD pmos W=0.205u L=0.04u
M630 U327/net10 n338 VDD VDD pmos W=0.205u L=0.04u
M631 n342 n248 U328/net27 VSS nmos W=0.155u L=0.04u
M632 U328/net27 n346 VSS VSS nmos W=0.155u L=0.04u
M633 n342 n347 VSS VSS nmos W=0.155u L=0.04u
M634 n342 n346 U328/net13 VDD pmos W=0.205u L=0.04u
M635 U328/net13 n347 VDD VDD pmos W=0.205u L=0.04u
M636 n342 n248 U328/net13 VDD pmos W=0.205u L=0.04u
M637 U329/net19 n349 VSS VSS nmos W=0.155u L=0.04u
M638 n347 n349 U329/net40 VSS nmos W=0.155u L=0.04u
M639 n347 U329/net19 U329/net36 VSS nmos W=0.155u L=0.04u
M640 U329/net40 n348 VSS VSS nmos W=0.31u L=0.04u
M641 U329/net36 n238 VSS VSS nmos W=0.155u L=0.04u
M642 U329/net19 n349 VDD VDD pmos W=0.205u L=0.04u
M643 n347 U329/net19 U329/net26 VDD pmos W=0.325u L=0.04u
M644 U329/net26 n348 VDD VDD pmos W=0.41u L=0.04u
M645 n347 n349 U329/net30 VDD pmos W=0.325u L=0.04u
M646 U329/net30 n238 VDD VDD pmos W=0.205u L=0.04u
M647 U330/net19 G10 VSS VSS nmos W=0.155u L=0.04u
M648 n348 G10 U330/net40 VSS nmos W=0.155u L=0.04u
M649 n348 U330/net19 U330/net36 VSS nmos W=0.155u L=0.04u
M650 U330/net40 G9 VSS VSS nmos W=0.31u L=0.04u
M651 U330/net36 G11 VSS VSS nmos W=0.155u L=0.04u
M652 U330/net19 G10 VDD VDD pmos W=0.205u L=0.04u
M653 n348 U330/net19 U330/net26 VDD pmos W=0.325u L=0.04u
M654 U330/net26 G9 VDD VDD pmos W=0.41u L=0.04u
M655 n348 G10 U330/net30 VDD pmos W=0.325u L=0.04u
M656 U330/net30 G11 VDD VDD pmos W=0.205u L=0.04u
M657 G546 G41 VSS VSS nmos W=0.135u L=0.04u
M658 G546 G41 VDD VDD pmos W=0.205u L=0.04u
M659 G542 n350 U332/XI0-net10 VSS nmos W=0.155u L=0.04u
M660 U332/XI0-net10 G279 U332/XI0-net13 VSS nmos W=0.155u L=0.04u
M661 U332/XI0-net13 n351 VSS VSS nmos W=0.155u L=0.04u
M662 G542 n351 VDD VDD pmos W=0.205u L=0.04u
M663 G542 n350 VDD VDD pmos W=0.205u L=0.04u
M664 G542 G279 VDD VDD pmos W=0.205u L=0.04u
M665 VSS n355 U333/net22 VSS nmos W=0.155u L=0.04u
M666 U333/net22 n354 n351 VSS nmos W=0.155u L=0.04u
M667 U333/net22 n353 n351 VSS nmos W=0.155u L=0.04u
M668 U333/net22 n352 n351 VSS nmos W=0.155u L=0.04u
M669 U333/net38 n352 VDD VDD pmos W=0.205u L=0.04u
M670 U333/net35 n353 U333/net38 VDD pmos W=0.205u L=0.04u
M671 n351 n354 U333/net35 VDD pmos W=0.205u L=0.04u
M672 n351 n355 VDD VDD pmos W=0.205u L=0.04u
M673 n353 n356 VSS VSS nmos W=0.135u L=0.04u
M674 n353 n356 VDD VDD pmos W=0.205u L=0.04u
M675 n352 G9 U335/net10 VSS nmos W=0.155u L=0.04u
M676 U335/net10 n338 VSS VSS nmos W=0.155u L=0.04u
M677 n352 n252 U335/net10 VSS nmos W=0.155u L=0.04u
M678 U335/net10 G7 VSS VSS nmos W=0.155u L=0.04u
M679 U335/net30 n338 VDD VDD pmos W=0.205u L=0.04u
M680 n352 G9 U335/net24 VDD pmos W=0.205u L=0.04u
M681 U335/net24 n252 VDD VDD pmos W=0.205u L=0.04u
M682 n352 G7 U335/net30 VDD pmos W=0.205u L=0.04u
M683 U336/net36 n286 U336/net24 VSS nmos W=0.155u L=0.04u
M684 U336/net24 G34 VSS VSS nmos W=0.155u L=0.04u
M685 n350 n276 U336/net36 VSS nmos W=0.155u L=0.04u
M686 n350 n346 U336/net36 VSS nmos W=0.155u L=0.04u
M687 n350 n346 U336/net35 VDD pmos W=0.205u L=0.04u
M688 U336/net35 n276 VDD VDD pmos W=0.205u L=0.04u
M689 n350 G34 VDD VDD pmos W=0.205u L=0.04u
M690 n350 n286 VDD VDD pmos W=0.205u L=0.04u
M691 U337/PG2 n359 VSS VSS nmos W=0.31u L=0.04u
M692 U337/net55 n358 VSS VSS nmos W=0.31u L=0.04u
M693 U337/net51 G12 VSS VSS nmos W=0.155u L=0.04u
M694 U337/net53 n357 VSS VSS nmos W=0.155u L=0.04u
M695 U337/net29 G13 VSS VSS nmos W=0.155u L=0.04u
M696 U337/net53 U337/net51 U337/PG1 VSS nmos W=0.155u L=0.04u
M697 U337/net55 G12 U337/PG1 VSS nmos W=0.21u L=0.04u
M698 U337/PG2 G13 G539 VSS nmos W=0.22u L=0.04u
M699 U337/PG1 U337/net29 G539 VSS nmos W=0.155u L=0.04u
M700 U337/PG2 n359 VDD VDD pmos W=0.41u L=0.04u
M701 U337/net55 n358 VDD VDD pmos W=0.41u L=0.04u
M702 U337/net51 G12 VDD VDD pmos W=0.205u L=0.04u
M703 U337/net53 n357 VDD VDD pmos W=0.28u L=0.04u
M704 U337/net29 G13 VDD VDD pmos W=0.205u L=0.04u
M705 U337/net53 G12 U337/PG1 VDD pmos W=0.27u L=0.04u
M706 U337/net55 U337/net51 U337/PG1 VDD pmos W=0.285u L=0.04u
M707 U337/PG2 U337/net29 G539 VDD pmos W=0.205u L=0.04u
M708 U337/PG1 G13 G539 VDD pmos W=0.28u L=0.04u
M709 n359 n360 U338/XI0-net10 VSS nmos W=0.155u L=0.04u
M710 U338/XI0-net10 n31 U338/XI0-net13 VSS nmos W=0.155u L=0.04u
M711 U338/XI0-net13 n361 VSS VSS nmos W=0.155u L=0.04u
M712 n359 n361 VDD VDD pmos W=0.205u L=0.04u
M713 n359 n360 VDD VDD pmos W=0.205u L=0.04u
M714 n359 n31 VDD VDD pmos W=0.205u L=0.04u
M715 U339/net13 n288 VSS VSS nmos W=0.155u L=0.04u
M716 U339/net16 U339/net13 VSS VSS nmos W=0.155u L=0.04u
M717 n358 n362 U339/net16 VSS nmos W=0.155u L=0.04u
M718 U339/net13 n288 VDD VDD pmos W=0.205u L=0.04u
M719 VDD U339/net13 n358 VDD pmos W=0.205u L=0.04u
M720 VDD n362 n358 VDD pmos W=0.205u L=0.04u
M721 U340/XU1-net6 n364 VSS VSS nmos W=0.155u L=0.04u
M722 n357 n363 U340/XU1-net6 VSS nmos W=0.155u L=0.04u
M723 n357 n364 VDD VDD pmos W=0.155u L=0.04u
M724 n357 n363 VDD VDD pmos W=0.155u L=0.04u
M725 U341/net36 n367 U341/net24 VSS nmos W=0.155u L=0.04u
M726 U341/net24 n368 VSS VSS nmos W=0.155u L=0.04u
M727 G537 n365 U341/net36 VSS nmos W=0.155u L=0.04u
M728 G537 n366 U341/net36 VSS nmos W=0.155u L=0.04u
M729 G537 n366 U341/net35 VDD pmos W=0.205u L=0.04u
M730 U341/net35 n365 VDD VDD pmos W=0.205u L=0.04u
M731 G537 n368 VDD VDD pmos W=0.205u L=0.04u
M732 G537 n367 VDD VDD pmos W=0.205u L=0.04u
M733 U342/net40 n370 n368 VDD pmos W=0.205u L=0.04u
M734 U342/net40 n369 n368 VDD pmos W=0.205u L=0.04u
M735 VDD n298 U342/net40 VDD pmos W=0.205u L=0.04u
M736 VDD n294 U342/net40 VDD pmos W=0.205u L=0.04u
M737 U342/net40 n296 n368 VDD pmos W=0.205u L=0.04u
M738 VDD n371 U342/net40 VDD pmos W=0.205u L=0.04u
M739 U342/XI13-net13 n296 VSS VSS nmos W=0.155u L=0.04u
M740 n368 n369 U342/XI13-net17 VSS nmos W=0.155u L=0.04u
M741 U342/XI13-net17 n370 U342/XI13-net13 VSS nmos W=0.155u L=0.04u
M742 U342/XI7-net13 n298 VSS VSS nmos W=0.155u L=0.04u
M743 n368 n294 U342/XI7-net17 VSS nmos W=0.155u L=0.04u
M744 U342/XI7-net17 n371 U342/XI7-net13 VSS nmos W=0.155u L=0.04u
M745 VSS n247 U343/net22 VSS nmos W=0.155u L=0.04u
M746 U343/net22 n310 n371 VSS nmos W=0.155u L=0.04u
M747 U343/net22 G9 n371 VSS nmos W=0.155u L=0.04u
M748 U343/net22 n372 n371 VSS nmos W=0.155u L=0.04u
M749 U343/net38 n372 VDD VDD pmos W=0.205u L=0.04u
M750 U343/net35 G9 U343/net38 VDD pmos W=0.205u L=0.04u
M751 n371 n310 U343/net35 VDD pmos W=0.205u L=0.04u
M752 n371 n247 VDD VDD pmos W=0.205u L=0.04u
M753 n372 G38 VSS VSS nmos W=0.135u L=0.04u
M754 n372 G38 VDD VDD pmos W=0.205u L=0.04u
M755 U345/net36 G8 U345/net24 VSS nmos W=0.155u L=0.04u
M756 U345/net24 n375 VSS VSS nmos W=0.155u L=0.04u
M757 n367 n373 U345/net36 VSS nmos W=0.155u L=0.04u
M758 n367 n374 U345/net36 VSS nmos W=0.155u L=0.04u
M759 n367 n374 U345/net35 VDD pmos W=0.205u L=0.04u
M760 U345/net35 n373 VDD VDD pmos W=0.205u L=0.04u
M761 n367 n375 VDD VDD pmos W=0.205u L=0.04u
M762 n367 G8 VDD VDD pmos W=0.205u L=0.04u
M763 n373 n310 VSS VSS nmos W=0.155u L=0.04u
M764 n373 n376 VSS VSS nmos W=0.155u L=0.04u
M765 U346/XI1-net8 n376 VDD VDD pmos W=0.205u L=0.04u
M766 n373 n310 U346/XI1-net8 VDD pmos W=0.205u L=0.04u
M767 n365 n378 VSS VSS nmos W=0.155u L=0.04u
M768 n365 n369 U347/XI17-net17 VSS nmos W=0.155u L=0.04u
M769 U347/XI17-net17 n370 VSS VSS nmos W=0.155u L=0.04u
M770 n365 n377 U347/XI10-net17 VSS nmos W=0.155u L=0.04u
M771 U347/XI10-net17 n243 VSS VSS nmos W=0.155u L=0.04u
M772 U347/net30 n377 n365 VDD pmos W=0.205u L=0.04u
M773 U347/net30 n243 n365 VDD pmos W=0.205u L=0.04u
M774 VDD n378 U347/net36 VDD pmos W=0.205u L=0.04u
M775 U347/net36 n370 U347/net30 VDD pmos W=0.205u L=0.04u
M776 U347/net36 n369 U347/net30 VDD pmos W=0.205u L=0.04u
M777 VSS n251 U348/net22 VSS nmos W=0.155u L=0.04u
M778 U348/net22 n244 n378 VSS nmos W=0.155u L=0.04u
M779 U348/net22 n234 n378 VSS nmos W=0.155u L=0.04u
M780 U348/net22 n379 n378 VSS nmos W=0.155u L=0.04u
M781 U348/net38 n379 VDD VDD pmos W=0.205u L=0.04u
M782 U348/net35 n234 U348/net38 VDD pmos W=0.205u L=0.04u
M783 n378 n244 U348/net35 VDD pmos W=0.205u L=0.04u
M784 n378 n251 VDD VDD pmos W=0.205u L=0.04u
M785 U349/p2 G5 VSS VSS nmos W=0.155u L=0.04u
M786 U349/p0 n248 U349/p1 VSS nmos W=0.155u L=0.04u
M787 U349/p1 G10 U349/p2 VSS nmos W=0.155u L=0.04u
M788 n251 n259 U349/p0 VSS nmos W=0.155u L=0.04u
M789 n251 G10 VDD VDD pmos W=0.205u L=0.04u
M790 n251 n248 VDD VDD pmos W=0.205u L=0.04u
M791 n251 n259 VDD VDD pmos W=0.205u L=0.04u
M792 n251 G5 VDD VDD pmos W=0.205u L=0.04u
M793 U350/XU1-net6 n285 VSS VSS nmos W=0.155u L=0.04u
M794 n234 n240 U350/XU1-net6 VSS nmos W=0.155u L=0.04u
M795 n234 n285 VDD VDD pmos W=0.155u L=0.04u
M796 n234 n240 VDD VDD pmos W=0.155u L=0.04u
M797 n379 n43 U351/XI0-net10 VSS nmos W=0.155u L=0.04u
M798 U351/XI0-net10 n346 U351/XI0-net13 VSS nmos W=0.155u L=0.04u
M799 U351/XI0-net13 n242 VSS VSS nmos W=0.155u L=0.04u
M800 n379 n242 VDD VDD pmos W=0.205u L=0.04u
M801 n379 n43 VDD VDD pmos W=0.205u L=0.04u
M802 n379 n346 VDD VDD pmos W=0.205u L=0.04u
M803 G535 U352/net27 VDD VDD pmos W=0.205u L=0.04u
M804 U352/net11 n297 U352/net27 VDD pmos W=0.205u L=0.04u
M805 U352/net11 n380 U352/net27 VDD pmos W=0.205u L=0.04u
M806 U352/net11 n381 U352/XI16-net11 VDD pmos W=0.205u L=0.04u
M807 U352/XI16-net11 n382 VDD VDD pmos W=0.205u L=0.04u
M808 U352/net27 n382 VSS VSS nmos W=0.155u L=0.04u
M809 U352/net27 n381 VSS VSS nmos W=0.155u L=0.04u
M810 G535 U352/net27 VSS VSS nmos W=0.155u L=0.04u
M811 U352/net27 n297 U352/XI12-net17 VSS nmos W=0.155u L=0.04u
M812 U352/XI12-net17 n380 VSS VSS nmos W=0.155u L=0.04u
M813 VSS n385 U353/net22 VSS nmos W=0.155u L=0.04u
M814 U353/net22 n258 n382 VSS nmos W=0.155u L=0.04u
M815 U353/net22 n384 n382 VSS nmos W=0.155u L=0.04u
M816 U353/net22 n383 n382 VSS nmos W=0.155u L=0.04u
M817 U353/net38 n383 VDD VDD pmos W=0.205u L=0.04u
M818 U353/net35 n384 U353/net38 VDD pmos W=0.205u L=0.04u
M819 n382 n258 U353/net35 VDD pmos W=0.205u L=0.04u
M820 n382 n385 VDD VDD pmos W=0.205u L=0.04u
M821 n381 U354/net6 VSS VSS nmos W=0.155u L=0.04u
M822 U354/net6 n294 U354/XU30-net23 VSS nmos W=0.155u L=0.04u
M823 U354/XU30-net23 G37 U354/XU30-net26 VSS nmos W=0.155u L=0.04u
M824 U354/XU30-net26 G38 U354/XU30-net29 VSS nmos W=0.155u L=0.04u
M825 U354/XU30-net29 n298 VSS VSS nmos W=0.155u L=0.04u
M826 n381 U354/net6 VDD VDD pmos W=0.205u L=0.04u
M827 U354/net6 n298 VDD VDD pmos W=0.205u L=0.04u
M828 U354/net6 G38 VDD VDD pmos W=0.205u L=0.04u
M829 U354/net6 G37 VDD VDD pmos W=0.205u L=0.04u
M830 U354/net6 n294 VDD VDD pmos W=0.205u L=0.04u
M831 n298 G13 VSS VSS nmos W=0.155u L=0.04u
M832 n298 n31 VSS VSS nmos W=0.155u L=0.04u
M833 n298 n288 VSS VSS nmos W=0.155u L=0.04u
M834 n298 n362 VSS VSS nmos W=0.155u L=0.04u
M835 U355/net49 n31 U355/net52 VDD pmos W=0.41u L=0.04u
M836 U355/net52 G13 VDD VDD pmos W=0.41u L=0.04u
M837 U355/net46 n288 U355/net49 VDD pmos W=0.41u L=0.04u
M838 n298 n362 U355/net46 VDD pmos W=0.41u L=0.04u
M839 n362 G1 U356/XI0-net10 VSS nmos W=0.155u L=0.04u
M840 U356/XI0-net10 n386 U356/XI0-net13 VSS nmos W=0.155u L=0.04u
M841 U356/XI0-net13 G2 VSS VSS nmos W=0.155u L=0.04u
M842 n362 G2 VDD VDD pmos W=0.205u L=0.04u
M843 n362 G1 VDD VDD pmos W=0.205u L=0.04u
M844 n362 n386 VDD VDD pmos W=0.205u L=0.04u
M845 n386 n318 U357/net14 VSS nmos W=0.155u L=0.04u
M846 U357/net14 n388 VSS VSS nmos W=0.155u L=0.04u
M847 U357/net14 n387 VSS VSS nmos W=0.155u L=0.04u
M848 n386 n312 U357/net14 VSS nmos W=0.155u L=0.04u
M849 n386 n246 U357/net14 VSS nmos W=0.155u L=0.04u
M850 n386 n388 U357/XI16-net11 VDD pmos W=0.205u L=0.04u
M851 U357/XI16-net11 n387 VDD VDD pmos W=0.205u L=0.04u
M852 n386 n312 U357/XI15-net11 VDD pmos W=0.205u L=0.04u
M853 U357/XI15-net11 n246 U357/XI15-net18 VDD pmos W=0.205u L=0.04u
M854 U357/XI15-net18 n318 VDD VDD pmos W=0.205u L=0.04u
M855 n387 n389 U358/net19 VDD pmos W=0.205u L=0.04u
M856 n387 n390 U358/net19 VDD pmos W=0.205u L=0.04u
M857 n387 G6 U358/net19 VDD pmos W=0.205u L=0.04u
M858 U358/net19 n391 VDD VDD pmos W=0.205u L=0.04u
M859 n387 n391 VSS VSS nmos W=0.155u L=0.04u
M860 U358/XI20-net13 n390 VSS VSS nmos W=0.155u L=0.04u
M861 n387 n389 U358/XI20-net17 VSS nmos W=0.155u L=0.04u
M862 U358/XI20-net17 G6 U358/XI20-net13 VSS nmos W=0.155u L=0.04u
M863 n391 U359/net6 VSS VSS nmos W=0.155u L=0.04u
M864 U359/net6 n294 U359/XU30-net23 VSS nmos W=0.155u L=0.04u
M865 U359/XU30-net23 n392 U359/XU30-net26 VSS nmos W=0.155u L=0.04u
M866 U359/XU30-net26 G164 U359/XU30-net29 VSS nmos W=0.155u L=0.04u
M867 U359/XU30-net29 G37 VSS VSS nmos W=0.155u L=0.04u
M868 n391 U359/net6 VDD VDD pmos W=0.205u L=0.04u
M869 U359/net6 G37 VDD VDD pmos W=0.205u L=0.04u
M870 U359/net6 G164 VDD VDD pmos W=0.205u L=0.04u
M871 U359/net6 n392 VDD VDD pmos W=0.205u L=0.04u
M872 U359/net6 n294 VDD VDD pmos W=0.205u L=0.04u
M873 n390 n356 VSS VSS nmos W=0.155u L=0.04u
M874 n390 n252 VSS VSS nmos W=0.155u L=0.04u
M875 n390 n293 VSS VSS nmos W=0.155u L=0.04u
M876 U360/net25 n356 VDD VDD pmos W=0.41u L=0.04u
M877 U360/net28 n252 U360/net25 VDD pmos W=0.41u L=0.04u
M878 n390 n293 U360/net28 VDD pmos W=0.41u L=0.04u
M879 n389 G5 VSS VSS nmos W=0.155u L=0.04u
M880 n389 G3 VSS VSS nmos W=0.155u L=0.04u
M881 U361/XI1-net8 G3 VDD VDD pmos W=0.205u L=0.04u
M882 n389 G5 U361/XI1-net8 VDD pmos W=0.205u L=0.04u
M883 n380 n291 U362/net14 VSS nmos W=0.155u L=0.04u
M884 U362/net14 G3 VSS VSS nmos W=0.155u L=0.04u
M885 U362/net14 G44 VSS VSS nmos W=0.155u L=0.04u
M886 n380 n393 U362/net14 VSS nmos W=0.155u L=0.04u
M887 n380 n384 U362/net14 VSS nmos W=0.155u L=0.04u
M888 n380 G3 U362/XI16-net11 VDD pmos W=0.205u L=0.04u
M889 U362/XI16-net11 G44 VDD VDD pmos W=0.205u L=0.04u
M890 n380 n393 U362/XI15-net11 VDD pmos W=0.205u L=0.04u
M891 U362/XI15-net11 n384 U362/XI15-net18 VDD pmos W=0.205u L=0.04u
M892 U362/XI15-net18 n291 VDD VDD pmos W=0.205u L=0.04u
M893 n384 n340 VSS VSS nmos W=0.155u L=0.04u
M894 n384 n394 VSS VSS nmos W=0.155u L=0.04u
M895 U363/XI1-net8 n394 VDD VDD pmos W=0.205u L=0.04u
M896 n384 n340 U363/XI1-net8 VDD pmos W=0.205u L=0.04u
M897 U364/net36 n395 U364/net24 VSS nmos W=0.155u L=0.04u
M898 U364/net24 n396 VSS VSS nmos W=0.155u L=0.04u
M899 G532 G43 U364/net36 VSS nmos W=0.155u L=0.04u
M900 G532 n302 U364/net36 VSS nmos W=0.155u L=0.04u
M901 G532 n302 U364/net35 VDD pmos W=0.205u L=0.04u
M902 U364/net35 G43 VDD VDD pmos W=0.205u L=0.04u
M903 G532 n396 VDD VDD pmos W=0.205u L=0.04u
M904 G532 n395 VDD VDD pmos W=0.205u L=0.04u
M905 n396 G0 U365/net19 VDD pmos W=0.205u L=0.04u
M906 n396 n287 U365/net19 VDD pmos W=0.205u L=0.04u
M907 n396 n397 U365/net19 VDD pmos W=0.205u L=0.04u
M908 U365/net19 n398 VDD VDD pmos W=0.205u L=0.04u
M909 n396 n398 VSS VSS nmos W=0.155u L=0.04u
M910 U365/XI20-net13 n287 VSS VSS nmos W=0.155u L=0.04u
M911 n396 G0 U365/XI20-net17 VSS nmos W=0.155u L=0.04u
M912 U365/XI20-net17 n397 U365/XI20-net13 VSS nmos W=0.155u L=0.04u
M913 VSS n385 U366/net22 VSS nmos W=0.155u L=0.04u
M914 U366/net22 n400 n398 VSS nmos W=0.155u L=0.04u
M915 U366/net22 n285 n398 VSS nmos W=0.155u L=0.04u
M916 U366/net22 n399 n398 VSS nmos W=0.155u L=0.04u
M917 U366/net38 n399 VDD VDD pmos W=0.205u L=0.04u
M918 U366/net35 n285 U366/net38 VDD pmos W=0.205u L=0.04u
M919 n398 n400 U366/net35 VDD pmos W=0.205u L=0.04u
M920 n398 n385 VDD VDD pmos W=0.205u L=0.04u
M921 n385 n375 U367/XI0-net10 VSS nmos W=0.155u L=0.04u
M922 U367/XI0-net10 n242 U367/XI0-net13 VSS nmos W=0.155u L=0.04u
M923 U367/XI0-net13 n300 VSS VSS nmos W=0.155u L=0.04u
M924 n385 n300 VDD VDD pmos W=0.205u L=0.04u
M925 n385 n375 VDD VDD pmos W=0.205u L=0.04u
M926 n385 n242 VDD VDD pmos W=0.205u L=0.04u
M927 n300 n285 VSS VSS nmos W=0.155u L=0.04u
M928 n300 U368/net4 VSS VSS nmos W=0.155u L=0.04u
M929 U368/net4 n370 VSS VSS nmos W=0.155u L=0.04u
M930 U368/XU1-net8 U368/net4 VDD VDD pmos W=0.205u L=0.04u
M931 n300 n285 U368/XU1-net8 VDD pmos W=0.205u L=0.04u
M932 U368/net4 n370 VDD VDD pmos W=0.205u L=0.04u
M933 n375 n399 VSS VSS nmos W=0.135u L=0.04u
M934 n375 n399 VDD VDD pmos W=0.205u L=0.04u
M935 n399 n401 U370/net15 VSS nmos W=0.155u L=0.04u
M936 n399 n402 U370/net15 VSS nmos W=0.155u L=0.04u
M937 U370/net15 n31 VSS VSS nmos W=0.155u L=0.04u
M938 n399 n31 VDD VDD pmos W=0.205u L=0.04u
M939 n399 n401 U370/XI16-net11 VDD pmos W=0.205u L=0.04u
M940 U370/XI16-net11 n402 VDD VDD pmos W=0.205u L=0.04u
M941 U371/net20 n320 VSS VSS nmos W=0.155u L=0.04u
M942 n397 n404 U371/p0 VSS nmos W=0.155u L=0.04u
M943 U371/p2 U371/net20 VSS VSS nmos W=0.155u L=0.04u
M944 U371/p1 n275 U371/p2 VSS nmos W=0.155u L=0.04u
M945 U371/p0 n403 U371/p1 VSS nmos W=0.155u L=0.04u
M946 U371/net20 n320 VDD VDD pmos W=0.205u L=0.04u
M947 n397 n275 VDD VDD pmos W=0.205u L=0.04u
M948 n397 n404 VDD VDD pmos W=0.205u L=0.04u
M949 n397 n403 VDD VDD pmos W=0.205u L=0.04u
M950 n397 U371/net20 VDD VDD pmos W=0.205u L=0.04u
M951 U372/net29 n262 VSS VSS nmos W=0.155u L=0.04u
M952 n404 n377 U372/net29 VSS nmos W=0.155u L=0.04u
M953 n404 n321 U372/net23 VSS nmos W=0.155u L=0.04u
M954 U372/net23 n405 VSS VSS nmos W=0.155u L=0.04u
M955 U372/net20 n405 n404 VDD pmos W=0.205u L=0.04u
M956 U372/net20 n321 n404 VDD pmos W=0.205u L=0.04u
M957 VDD n377 U372/net20 VDD pmos W=0.205u L=0.04u
M958 VDD n262 U372/net20 VDD pmos W=0.205u L=0.04u
M959 n377 n258 VSS VSS nmos W=0.135u L=0.04u
M960 n377 n258 VDD VDD pmos W=0.205u L=0.04u
M961 n321 n257 VSS VSS nmos W=0.135u L=0.04u
M962 n321 n257 VDD VDD pmos W=0.205u L=0.04u
M963 U375/XU1-net6 G4 VSS VSS nmos W=0.155u L=0.04u
M964 n257 G2 U375/XU1-net6 VSS nmos W=0.155u L=0.04u
M965 n257 G4 VDD VDD pmos W=0.155u L=0.04u
M966 n257 G2 VDD VDD pmos W=0.155u L=0.04u
M967 n403 G4 U376/XI0-net10 VSS nmos W=0.155u L=0.04u
M968 U376/XI0-net10 n266 U376/XI0-net13 VSS nmos W=0.155u L=0.04u
M969 U376/XI0-net13 n294 VSS VSS nmos W=0.155u L=0.04u
M970 n403 n294 VDD VDD pmos W=0.205u L=0.04u
M971 n403 G4 VDD VDD pmos W=0.205u L=0.04u
M972 n403 n266 VDD VDD pmos W=0.205u L=0.04u
M973 n320 n260 VSS VSS nmos W=0.155u L=0.04u
M974 n320 G3 VSS VSS nmos W=0.155u L=0.04u
M975 n320 G2 VSS VSS nmos W=0.155u L=0.04u
M976 U377/net25 n260 VDD VDD pmos W=0.41u L=0.04u
M977 U377/net28 G3 U377/net25 VDD pmos W=0.41u L=0.04u
M978 n320 G2 U377/net28 VDD pmos W=0.41u L=0.04u
M979 U378/net29 n354 VSS VSS nmos W=0.155u L=0.04u
M980 n395 n296 U378/net29 VSS nmos W=0.155u L=0.04u
M981 n395 n297 U378/net23 VSS nmos W=0.155u L=0.04u
M982 U378/net23 n406 VSS VSS nmos W=0.155u L=0.04u
M983 U378/net20 n406 n395 VDD pmos W=0.205u L=0.04u
M984 U378/net20 n297 n395 VDD pmos W=0.205u L=0.04u
M985 VDD n296 U378/net20 VDD pmos W=0.205u L=0.04u
M986 VDD n354 U378/net20 VDD pmos W=0.205u L=0.04u
M987 n354 n407 VSS VSS nmos W=0.135u L=0.04u
M988 n354 n407 VDD VDD pmos W=0.205u L=0.04u
M989 n296 n383 VSS VSS nmos W=0.135u L=0.04u
M990 n296 n383 VDD VDD pmos W=0.205u L=0.04u
M991 U381/XU1-net6 n31 VSS VSS nmos W=0.155u L=0.04u
M992 n383 n402 U381/XU1-net6 VSS nmos W=0.155u L=0.04u
M993 n383 n31 VDD VDD pmos W=0.155u L=0.04u
M994 n383 n402 VDD VDD pmos W=0.155u L=0.04u
M995 n402 n278 VSS VSS nmos W=0.155u L=0.04u
M996 n402 n361 VSS VSS nmos W=0.155u L=0.04u
M997 U382/XI1-net8 n361 VDD VDD pmos W=0.205u L=0.04u
M998 n402 n278 U382/XI1-net8 VDD pmos W=0.205u L=0.04u
M999 U383/net14 G5 VSS VSS nmos W=0.155u L=0.04u
M1000 U383/net14 n409 VSS VSS nmos W=0.155u L=0.04u
M1001 U383/net35 n295 U383/net14 VSS nmos W=0.155u L=0.04u
M1002 U383/net35 n260 U383/net14 VSS nmos W=0.155u L=0.04u
M1003 U383/net35 n408 U383/net14 VSS nmos W=0.155u L=0.04u
M1004 n361 U383/net35 VSS VSS nmos W=0.155u L=0.04u
M1005 n361 U383/net35 VDD VDD pmos W=0.205u L=0.04u
M1006 U383/net35 n409 U383/XI16-net11 VDD pmos W=0.205u L=0.04u
M1007 U383/XI16-net11 G5 VDD VDD pmos W=0.205u L=0.04u
M1008 U383/net35 n295 U383/XI15-net11 VDD pmos W=0.205u L=0.04u
M1009 U383/XI15-net11 n260 U383/XI15-net18 VDD pmos W=0.205u L=0.04u
M1010 U383/XI15-net18 n408 VDD VDD pmos W=0.205u L=0.04u
M1011 n409 n410 U384/net23 VDD pmos W=0.205u L=0.04u
M1012 n409 G2 U384/net23 VDD pmos W=0.205u L=0.04u
M1013 n409 n260 U384/net23 VDD pmos W=0.205u L=0.04u
M1014 U384/net23 n411 VDD VDD pmos W=0.205u L=0.04u
M1015 U384/net23 n412 VDD VDD pmos W=0.205u L=0.04u
M1016 U384/XI20-net13 G2 VSS VSS nmos W=0.155u L=0.04u
M1017 n409 n410 U384/XI20-net17 VSS nmos W=0.155u L=0.04u
M1018 U384/XI20-net17 n260 U384/XI20-net13 VSS nmos W=0.155u L=0.04u
M1019 n409 n411 U384/XI17-net17 VSS nmos W=0.155u L=0.04u
M1020 U384/XI17-net17 n412 VSS VSS nmos W=0.155u L=0.04u
M1021 n412 n291 U385/net14 VSS nmos W=0.155u L=0.04u
M1022 U385/net14 n275 VSS VSS nmos W=0.155u L=0.04u
M1023 U385/net14 n310 VSS VSS nmos W=0.155u L=0.04u
M1024 n412 n266 U385/net14 VSS nmos W=0.155u L=0.04u
M1025 n412 G1 U385/net14 VSS nmos W=0.155u L=0.04u
M1026 n412 n275 U385/XI16-net11 VDD pmos W=0.205u L=0.04u
M1027 U385/XI16-net11 n310 VDD VDD pmos W=0.205u L=0.04u
M1028 n412 n266 U385/XI15-net11 VDD pmos W=0.205u L=0.04u
M1029 U385/XI15-net11 G1 U385/XI15-net18 VDD pmos W=0.205u L=0.04u
M1030 U385/XI15-net18 n291 VDD VDD pmos W=0.205u L=0.04u
M1031 U386/XU1-net6 n242 VSS VSS nmos W=0.155u L=0.04u
M1032 n275 n256 U386/XU1-net6 VSS nmos W=0.155u L=0.04u
M1033 n275 n242 VDD VDD pmos W=0.155u L=0.04u
M1034 n275 n256 VDD VDD pmos W=0.155u L=0.04u
M1035 n256 n405 VSS VSS nmos W=0.135u L=0.04u
M1036 n256 n405 VDD VDD pmos W=0.205u L=0.04u
M1037 U388/net8 n392 U388/net26 VSS nmos W=0.155u L=0.04u
M1038 U388/net26 n394 VSS VSS nmos W=0.155u L=0.04u
M1039 U388/net29 U388/net8 VSS VSS nmos W=0.155u L=0.04u
M1040 U388/net29 G7 n411 VSS nmos W=0.155u L=0.04u
M1041 U388/net29 n407 n411 VSS nmos W=0.155u L=0.04u
M1042 U388/net8 n394 VDD VDD pmos W=0.205u L=0.04u
M1043 U388/net8 n392 VDD VDD pmos W=0.205u L=0.04u
M1044 n411 U388/net8 VDD VDD pmos W=0.205u L=0.04u
M1045 n411 G7 U388/net20 VDD pmos W=0.205u L=0.04u
M1046 U388/net20 n407 VDD VDD pmos W=0.205u L=0.04u
M1047 VSS n414 U389/net22 VSS nmos W=0.155u L=0.04u
M1048 U389/net22 n299 n410 VSS nmos W=0.155u L=0.04u
M1049 U389/net22 n393 n410 VSS nmos W=0.155u L=0.04u
M1050 U389/net22 n413 n410 VSS nmos W=0.155u L=0.04u
M1051 U389/net38 n413 VDD VDD pmos W=0.205u L=0.04u
M1052 U389/net35 n393 U389/net38 VDD pmos W=0.205u L=0.04u
M1053 n410 n299 U389/net35 VDD pmos W=0.205u L=0.04u
M1054 n410 n414 VDD VDD pmos W=0.205u L=0.04u
M1055 U390/p2 n252 VSS VSS nmos W=0.155u L=0.04u
M1056 U390/p0 n349 U390/p1 VSS nmos W=0.155u L=0.04u
M1057 U390/p1 n248 U390/p2 VSS nmos W=0.155u L=0.04u
M1058 n414 n369 U390/p0 VSS nmos W=0.155u L=0.04u
M1059 n414 n248 VDD VDD pmos W=0.205u L=0.04u
M1060 n414 n349 VDD VDD pmos W=0.205u L=0.04u
M1061 n414 n369 VDD VDD pmos W=0.205u L=0.04u
M1062 n414 n252 VDD VDD pmos W=0.205u L=0.04u
M1063 n299 n285 U391/XI0-net10 VSS nmos W=0.155u L=0.04u
M1064 U391/XI0-net10 n346 U391/XI0-net13 VSS nmos W=0.155u L=0.04u
M1065 U391/XI0-net13 n394 VSS VSS nmos W=0.155u L=0.04u
M1066 n299 n394 VDD VDD pmos W=0.205u L=0.04u
M1067 n299 n285 VDD VDD pmos W=0.205u L=0.04u
M1068 n299 n346 VDD VDD pmos W=0.205u L=0.04u
M1069 n394 n376 VSS VSS nmos W=0.135u L=0.04u
M1070 n394 n376 VDD VDD pmos W=0.205u L=0.04u
M1071 U393/XU1-net6 n242 VSS VSS nmos W=0.155u L=0.04u
M1072 n413 G3 U393/XU1-net6 VSS nmos W=0.155u L=0.04u
M1073 n413 n242 VDD VDD pmos W=0.155u L=0.04u
M1074 n413 G3 VDD VDD pmos W=0.155u L=0.04u
M1075 U394/XU35-net6 n400 VSS VSS nmos W=0.155u L=0.04u
M1076 U394/net5 n246 U394/XU35-net6 VSS nmos W=0.155u L=0.04u
M1077 U394/XU36-net6 U394/net5 VSS VSS nmos W=0.155u L=0.04u
M1078 n408 n259 U394/XU36-net6 VSS nmos W=0.155u L=0.04u
M1079 U394/net5 n400 VDD VDD pmos W=0.205u L=0.04u
M1080 U394/net5 n246 VDD VDD pmos W=0.205u L=0.04u
M1081 n408 U394/net5 VDD VDD pmos W=0.205u L=0.04u
M1082 n408 n259 VDD VDD pmos W=0.205u L=0.04u
M1083 n406 n307 U395/net27 VSS nmos W=0.155u L=0.04u
M1084 U395/net39 G3 VSS VSS nmos W=0.155u L=0.04u
M1085 U395/net27 n291 U395/net39 VSS nmos W=0.155u L=0.04u
M1086 U395/net27 n407 U395/net39 VSS nmos W=0.155u L=0.04u
M1087 n406 n376 U395/net27 VSS nmos W=0.155u L=0.04u
M1088 U395/net39 G4 VSS VSS nmos W=0.155u L=0.04u
M1089 n406 G3 U395/net46 VDD pmos W=0.205u L=0.04u
M1090 U395/net46 G4 VDD VDD pmos W=0.205u L=0.04u
M1091 n406 n376 U395/net34 VDD pmos W=0.205u L=0.04u
M1092 U395/net34 n307 VDD VDD pmos W=0.205u L=0.04u
M1093 n406 n407 U395/net37 VDD pmos W=0.205u L=0.04u
M1094 U395/net37 n291 VDD VDD pmos W=0.205u L=0.04u
M1095 n407 G10 U396/XI0-net10 VSS nmos W=0.155u L=0.04u
M1096 U396/XI0-net10 n346 U396/XI0-net13 VSS nmos W=0.155u L=0.04u
M1097 U396/XI0-net13 n248 VSS VSS nmos W=0.155u L=0.04u
M1098 n407 n248 VDD VDD pmos W=0.205u L=0.04u
M1099 n407 G10 VDD VDD pmos W=0.205u L=0.04u
M1100 n407 n346 VDD VDD pmos W=0.205u L=0.04u
M1101 n297 n366 VSS VSS nmos W=0.135u L=0.04u
M1102 n297 n366 VDD VDD pmos W=0.205u L=0.04u
M1103 n302 n335 VSS VSS nmos W=0.135u L=0.04u
M1104 n302 n335 VDD VDD pmos W=0.205u L=0.04u
M1105 n335 n360 VSS VSS nmos W=0.155u L=0.04u
M1106 n335 G12 VSS VSS nmos W=0.155u L=0.04u
M1107 n335 n278 VSS VSS nmos W=0.155u L=0.04u
M1108 U399/net25 n360 VDD VDD pmos W=0.41u L=0.04u
M1109 U399/net28 G12 U399/net25 VDD pmos W=0.41u L=0.04u
M1110 n335 n278 U399/net28 VDD pmos W=0.41u L=0.04u
M1111 U400/XU1-net6 n277 VSS VSS nmos W=0.155u L=0.04u
M1112 n360 n218 U400/XU1-net6 VSS nmos W=0.155u L=0.04u
M1113 n360 n277 VDD VDD pmos W=0.155u L=0.04u
M1114 n360 n218 VDD VDD pmos W=0.155u L=0.04u
M1115 n277 n266 U401/net26 VSS nmos W=0.155u L=0.04u
M1116 n277 n415 U401/net26 VSS nmos W=0.155u L=0.04u
M1117 U401/net29 n417 VSS VSS nmos W=0.155u L=0.04u
M1118 U401/net26 n416 U401/net29 VSS nmos W=0.155u L=0.04u
M1119 U401/net26 n260 U401/net29 VSS nmos W=0.155u L=0.04u
M1120 n277 n415 U401/net43 VDD pmos W=0.205u L=0.04u
M1121 n277 n260 U401/net49 VDD pmos W=0.205u L=0.04u
M1122 U401/net49 n416 VDD VDD pmos W=0.205u L=0.04u
M1123 U401/net43 n266 VDD VDD pmos W=0.205u L=0.04u
M1124 n277 n417 VDD VDD pmos W=0.205u L=0.04u
M1125 n417 n263 VSS VSS nmos W=0.155u L=0.04u
M1126 n417 n322 VSS VSS nmos W=0.155u L=0.04u
M1127 U402/XI1-net8 n322 VDD VDD pmos W=0.205u L=0.04u
M1128 n417 n263 U402/XI1-net8 VDD pmos W=0.205u L=0.04u
M1129 n322 n19 VSS VSS nmos W=0.135u L=0.04u
M1130 n322 n19 VDD VDD pmos W=0.205u L=0.04u
M1131 n19 G6 U404/XI0-net10 VSS nmos W=0.155u L=0.04u
M1132 U404/XI0-net10 n308 U404/XI0-net13 VSS nmos W=0.155u L=0.04u
M1133 U404/XI0-net13 G1 VSS VSS nmos W=0.155u L=0.04u
M1134 n19 G1 VDD VDD pmos W=0.205u L=0.04u
M1135 n19 G6 VDD VDD pmos W=0.205u L=0.04u
M1136 n19 n308 VDD VDD pmos W=0.205u L=0.04u
M1137 n308 n270 VSS VSS nmos W=0.135u L=0.04u
M1138 n308 n270 VDD VDD pmos W=0.205u L=0.04u
M1139 U406/XU1-net6 n266 VSS VSS nmos W=0.155u L=0.04u
M1140 n270 G3 U406/XU1-net6 VSS nmos W=0.155u L=0.04u
M1141 n270 n266 VDD VDD pmos W=0.155u L=0.04u
M1142 n270 G3 VDD VDD pmos W=0.155u L=0.04u
M1143 n263 n310 VSS VSS nmos W=0.155u L=0.04u
M1144 n263 G4 VSS VSS nmos W=0.155u L=0.04u
M1145 n263 G1 VSS VSS nmos W=0.155u L=0.04u
M1146 U407/net25 n310 VDD VDD pmos W=0.41u L=0.04u
M1147 U407/net28 G4 U407/net25 VDD pmos W=0.41u L=0.04u
M1148 n263 G1 U407/net28 VDD pmos W=0.41u L=0.04u
M1149 n416 n419 VSS VSS nmos W=0.155u L=0.04u
M1150 n416 n294 U408/XI17-net17 VSS nmos W=0.155u L=0.04u
M1151 U408/XI17-net17 n312 VSS VSS nmos W=0.155u L=0.04u
M1152 n416 n418 U408/XI10-net17 VSS nmos W=0.155u L=0.04u
M1153 U408/XI10-net17 n262 VSS VSS nmos W=0.155u L=0.04u
M1154 U408/net30 n418 n416 VDD pmos W=0.205u L=0.04u
M1155 U408/net30 n262 n416 VDD pmos W=0.205u L=0.04u
M1156 VDD n419 U408/net36 VDD pmos W=0.205u L=0.04u
M1157 U408/net36 n312 U408/net30 VDD pmos W=0.205u L=0.04u
M1158 U408/net36 n294 U408/net30 VDD pmos W=0.205u L=0.04u
M1159 U409/net19 G6 VSS VSS nmos W=0.155u L=0.04u
M1160 n419 G6 U409/net40 VSS nmos W=0.155u L=0.04u
M1161 n419 U409/net19 U409/net36 VSS nmos W=0.155u L=0.04u
M1162 U409/net40 n421 VSS VSS nmos W=0.31u L=0.04u
M1163 U409/net36 n420 VSS VSS nmos W=0.155u L=0.04u
M1164 U409/net19 G6 VDD VDD pmos W=0.205u L=0.04u
M1165 n419 U409/net19 U409/net26 VDD pmos W=0.325u L=0.04u
M1166 U409/net26 n421 VDD VDD pmos W=0.41u L=0.04u
M1167 n419 G6 U409/net30 VDD pmos W=0.325u L=0.04u
M1168 U409/net30 n420 VDD VDD pmos W=0.205u L=0.04u
M1169 U410/XU1-net6 n242 VSS VSS nmos W=0.155u L=0.04u
M1170 n420 G5 U410/XU1-net6 VSS nmos W=0.155u L=0.04u
M1171 n420 n242 VDD VDD pmos W=0.155u L=0.04u
M1172 n420 G5 VDD VDD pmos W=0.155u L=0.04u
M1173 U411/XU1-net6 n310 VSS VSS nmos W=0.155u L=0.04u
M1174 n418 n258 U411/XU1-net6 VSS nmos W=0.155u L=0.04u
M1175 n418 n310 VDD VDD pmos W=0.155u L=0.04u
M1176 n418 n258 VDD VDD pmos W=0.155u L=0.04u
M1177 U412/XU1-net6 G6 VSS VSS nmos W=0.155u L=0.04u
M1178 n310 G2 U412/XU1-net6 VSS nmos W=0.155u L=0.04u
M1179 n310 G6 VDD VDD pmos W=0.155u L=0.04u
M1180 n310 G2 VDD VDD pmos W=0.155u L=0.04u
M1181 n415 n311 U413/net27 VSS nmos W=0.155u L=0.04u
M1182 U413/net27 n285 VSS VSS nmos W=0.155u L=0.04u
M1183 n415 n265 VSS VSS nmos W=0.155u L=0.04u
M1184 n415 n285 U413/net13 VDD pmos W=0.205u L=0.04u
M1185 U413/net13 n265 VDD VDD pmos W=0.205u L=0.04u
M1186 n415 n311 U413/net13 VDD pmos W=0.205u L=0.04u
M1187 n311 n260 VSS VSS nmos W=0.155u L=0.04u
M1188 n311 n242 VSS VSS nmos W=0.155u L=0.04u
M1189 U414/XI1-net8 n242 VDD VDD pmos W=0.205u L=0.04u
M1190 n311 n260 U414/XI1-net8 VDD pmos W=0.205u L=0.04u
M1191 G530 n305 U415/net14 VSS nmos W=0.155u L=0.04u
M1192 U415/net14 n366 VSS VSS nmos W=0.155u L=0.04u
M1193 U415/net14 n423 VSS VSS nmos W=0.155u L=0.04u
M1194 G530 n266 U415/net14 VSS nmos W=0.155u L=0.04u
M1195 G530 n422 U415/net14 VSS nmos W=0.155u L=0.04u
M1196 G530 n366 U415/XI16-net11 VDD pmos W=0.205u L=0.04u
M1197 U415/XI16-net11 n423 VDD VDD pmos W=0.205u L=0.04u
M1198 G530 n266 U415/XI15-net11 VDD pmos W=0.205u L=0.04u
M1199 U415/XI15-net11 n422 U415/XI15-net18 VDD pmos W=0.205u L=0.04u
M1200 U415/XI15-net18 n305 VDD VDD pmos W=0.205u L=0.04u
M1201 U416/XU1-net6 n31 VSS VSS nmos W=0.155u L=0.04u
M1202 n366 n401 U416/XU1-net6 VSS nmos W=0.155u L=0.04u
M1203 n366 n31 VDD VDD pmos W=0.155u L=0.04u
M1204 n366 n401 VDD VDD pmos W=0.155u L=0.04u
M1205 n31 G12 VSS VSS nmos W=0.135u L=0.04u
M1206 n31 G12 VDD VDD pmos W=0.205u L=0.04u
M1207 n401 n363 VSS VSS nmos W=0.155u L=0.04u
M1208 n401 G13 VSS VSS nmos W=0.155u L=0.04u
M1209 n401 n282 VSS VSS nmos W=0.155u L=0.04u
M1210 U418/net25 n363 VDD VDD pmos W=0.41u L=0.04u
M1211 U418/net28 G13 U418/net25 VDD pmos W=0.41u L=0.04u
M1212 n401 n282 U418/net28 VDD pmos W=0.41u L=0.04u
M1213 n363 n425 VSS VSS nmos W=0.155u L=0.04u
M1214 n363 U419/net4 VSS VSS nmos W=0.155u L=0.04u
M1215 U419/net4 n424 VSS VSS nmos W=0.155u L=0.04u
M1216 U419/XU1-net8 U419/net4 VDD VDD pmos W=0.205u L=0.04u
M1217 n363 n425 U419/XU1-net8 VDD pmos W=0.205u L=0.04u
M1218 U419/net4 n424 VDD VDD pmos W=0.205u L=0.04u
M1219 n425 n291 U420/net14 VSS nmos W=0.155u L=0.04u
M1220 U420/net14 G2 VSS VSS nmos W=0.155u L=0.04u
M1221 U420/net14 n423 VSS VSS nmos W=0.155u L=0.04u
M1222 n425 n400 U420/net14 VSS nmos W=0.155u L=0.04u
M1223 n425 n330 U420/net14 VSS nmos W=0.155u L=0.04u
M1224 n425 G2 U420/XI16-net11 VDD pmos W=0.205u L=0.04u
M1225 U420/XI16-net11 n423 VDD VDD pmos W=0.205u L=0.04u
M1226 n425 n400 U420/XI15-net11 VDD pmos W=0.205u L=0.04u
M1227 U420/XI15-net11 n330 U420/XI15-net18 VDD pmos W=0.205u L=0.04u
M1228 U420/XI15-net18 n291 VDD VDD pmos W=0.205u L=0.04u
M1229 n400 n249 U421/XI0-net10 VSS nmos W=0.155u L=0.04u
M1230 U421/XI0-net10 n393 U421/XI0-net13 VSS nmos W=0.155u L=0.04u
M1231 U421/XI0-net13 n340 VSS VSS nmos W=0.155u L=0.04u
M1232 n400 n340 VDD VDD pmos W=0.205u L=0.04u
M1233 n400 n249 VDD VDD pmos W=0.205u L=0.04u
M1234 n400 n393 VDD VDD pmos W=0.205u L=0.04u
M1235 U422/XU1-net6 G5 VSS VSS nmos W=0.155u L=0.04u
M1236 n330 G2 U422/XU1-net6 VSS nmos W=0.155u L=0.04u
M1237 n330 G5 VDD VDD pmos W=0.155u L=0.04u
M1238 n330 G2 VDD VDD pmos W=0.155u L=0.04u
M1239 U423/net40 n243 n424 VDD pmos W=0.205u L=0.04u
M1240 U423/net40 n259 n424 VDD pmos W=0.205u L=0.04u
M1241 VDD n426 U423/net40 VDD pmos W=0.205u L=0.04u
M1242 VDD G11 U423/net40 VDD pmos W=0.205u L=0.04u
M1243 U423/net40 n374 n424 VDD pmos W=0.205u L=0.04u
M1244 VDD n43 U423/net40 VDD pmos W=0.205u L=0.04u
M1245 U423/XI13-net13 n374 VSS VSS nmos W=0.155u L=0.04u
M1246 n424 n259 U423/XI13-net17 VSS nmos W=0.155u L=0.04u
M1247 U423/XI13-net17 n243 U423/XI13-net13 VSS nmos W=0.155u L=0.04u
M1248 U423/XI7-net13 n426 VSS VSS nmos W=0.155u L=0.04u
M1249 n424 G11 U423/XI7-net17 VSS nmos W=0.155u L=0.04u
M1250 U423/XI7-net17 n43 U423/XI7-net13 VSS nmos W=0.155u L=0.04u
M1251 U424/net19 G2 VSS VSS nmos W=0.155u L=0.04u
M1252 n426 G2 U424/net40 VSS nmos W=0.155u L=0.04u
M1253 n426 U424/net19 U424/net36 VSS nmos W=0.155u L=0.04u
M1254 U424/net40 n428 VSS VSS nmos W=0.31u L=0.04u
M1255 U424/net36 n427 VSS VSS nmos W=0.155u L=0.04u
M1256 U424/net19 G2 VDD VDD pmos W=0.205u L=0.04u
M1257 n426 U424/net19 U424/net26 VDD pmos W=0.325u L=0.04u
M1258 U424/net26 n428 VDD VDD pmos W=0.41u L=0.04u
M1259 n426 G2 U424/net30 VDD pmos W=0.325u L=0.04u
M1260 U424/net30 n427 VDD VDD pmos W=0.205u L=0.04u
M1261 n428 G3 U425/XI0-net10 VSS nmos W=0.155u L=0.04u
M1262 U425/XI0-net10 n242 U425/XI0-net13 VSS nmos W=0.155u L=0.04u
M1263 U425/XI0-net13 G35 VSS VSS nmos W=0.155u L=0.04u
M1264 n428 G35 VDD VDD pmos W=0.205u L=0.04u
M1265 n428 G3 VDD VDD pmos W=0.205u L=0.04u
M1266 n428 n242 VDD VDD pmos W=0.205u L=0.04u
M1267 n427 n429 U426/net15 VSS nmos W=0.155u L=0.04u
M1268 n427 n370 U426/net15 VSS nmos W=0.155u L=0.04u
M1269 U426/net15 n369 VSS VSS nmos W=0.155u L=0.04u
M1270 n427 n369 VDD VDD pmos W=0.205u L=0.04u
M1271 n427 n429 U426/XI16-net11 VDD pmos W=0.205u L=0.04u
M1272 U426/XI16-net11 n370 VDD VDD pmos W=0.205u L=0.04u
M1273 n369 n291 VSS VSS nmos W=0.135u L=0.04u
M1274 n369 n291 VDD VDD pmos W=0.205u L=0.04u
M1275 U428/XU1-net6 G3 VSS VSS nmos W=0.155u L=0.04u
M1276 n291 n259 U428/XU1-net6 VSS nmos W=0.155u L=0.04u
M1277 n291 G3 VDD VDD pmos W=0.155u L=0.04u
M1278 n291 n259 VDD VDD pmos W=0.155u L=0.04u
M1279 n429 n341 VSS VSS nmos W=0.155u L=0.04u
M1280 n429 n238 VSS VSS nmos W=0.155u L=0.04u
M1281 U429/XI1-net8 n238 VDD VDD pmos W=0.205u L=0.04u
M1282 n429 n341 U429/XI1-net8 VDD pmos W=0.205u L=0.04u
M1283 n374 n295 VSS VSS nmos W=0.135u L=0.04u
M1284 n374 n295 VDD VDD pmos W=0.205u L=0.04u
M1285 U431/XU1-net6 G2 VSS VSS nmos W=0.155u L=0.04u
M1286 n295 n294 U431/XU1-net6 VSS nmos W=0.155u L=0.04u
M1287 n295 G2 VDD VDD pmos W=0.155u L=0.04u
M1288 n295 n294 VDD VDD pmos W=0.155u L=0.04u
M1289 n243 n246 VSS VSS nmos W=0.135u L=0.04u
M1290 n243 n246 VDD VDD pmos W=0.205u L=0.04u
M1291 U433/XU1-net6 n253 VSS VSS nmos W=0.155u L=0.04u
M1292 n246 n286 U433/XU1-net6 VSS nmos W=0.155u L=0.04u
M1293 n246 n253 VDD VDD pmos W=0.155u L=0.04u
M1294 n246 n286 VDD VDD pmos W=0.155u L=0.04u
M1295 n286 n247 VSS VSS nmos W=0.135u L=0.04u
M1296 n286 n247 VDD VDD pmos W=0.205u L=0.04u
M1297 n282 n364 VSS VSS nmos W=0.135u L=0.04u
M1298 n282 n364 VDD VDD pmos W=0.205u L=0.04u
M1299 U436/XU1-net6 n218 VSS VSS nmos W=0.155u L=0.04u
M1300 n364 G32 U436/XU1-net6 VSS nmos W=0.155u L=0.04u
M1301 n364 n218 VDD VDD pmos W=0.155u L=0.04u
M1302 n364 G32 VDD VDD pmos W=0.155u L=0.04u
M1303 n218 n341 U437/net27 VSS nmos W=0.155u L=0.04u
M1304 U437/net39 n238 VSS VSS nmos W=0.155u L=0.04u
M1305 U437/net27 n253 U437/net39 VSS nmos W=0.155u L=0.04u
M1306 U437/net27 n247 U437/net39 VSS nmos W=0.155u L=0.04u
M1307 n218 n284 U437/net27 VSS nmos W=0.155u L=0.04u
M1308 U437/net39 n240 VSS VSS nmos W=0.155u L=0.04u
M1309 n218 n238 U437/net46 VDD pmos W=0.205u L=0.04u
M1310 U437/net46 n240 VDD VDD pmos W=0.205u L=0.04u
M1311 n218 n284 U437/net34 VDD pmos W=0.205u L=0.04u
M1312 U437/net34 n341 VDD VDD pmos W=0.205u L=0.04u
M1313 n218 n247 U437/net37 VDD pmos W=0.205u L=0.04u
M1314 U437/net37 n253 VDD VDD pmos W=0.205u L=0.04u
M1315 U438/XU1-net6 G10 VSS VSS nmos W=0.155u L=0.04u
M1316 n247 G7 U438/XU1-net6 VSS nmos W=0.155u L=0.04u
M1317 n247 G10 VDD VDD pmos W=0.155u L=0.04u
M1318 n247 G7 VDD VDD pmos W=0.155u L=0.04u
M1319 n253 n346 VSS VSS nmos W=0.155u L=0.04u
M1320 n253 U439/net4 VSS VSS nmos W=0.155u L=0.04u
M1321 U439/net4 n248 VSS VSS nmos W=0.155u L=0.04u
M1322 U439/XU1-net8 U439/net4 VDD VDD pmos W=0.205u L=0.04u
M1323 n253 n346 U439/XU1-net8 VDD pmos W=0.205u L=0.04u
M1324 U439/net4 n248 VDD VDD pmos W=0.205u L=0.04u
M1325 n248 n393 VSS VSS nmos W=0.155u L=0.04u
M1326 n248 n276 VSS VSS nmos W=0.155u L=0.04u
M1327 U440/XI1-net8 n276 VDD VDD pmos W=0.205u L=0.04u
M1328 n248 n393 U440/XI1-net8 VDD pmos W=0.205u L=0.04u
M1329 U441/net40 n285 n423 VDD pmos W=0.205u L=0.04u
M1330 U441/net40 n262 n423 VDD pmos W=0.205u L=0.04u
M1331 VDD n430 U441/net40 VDD pmos W=0.205u L=0.04u
M1332 VDD n370 U441/net40 VDD pmos W=0.205u L=0.04u
M1333 U441/net40 G36 n423 VDD pmos W=0.205u L=0.04u
M1334 VDD G5 U441/net40 VDD pmos W=0.205u L=0.04u
M1335 U441/XI13-net13 G36 VSS VSS nmos W=0.155u L=0.04u
M1336 n423 n262 U441/XI13-net17 VSS nmos W=0.155u L=0.04u
M1337 U441/XI13-net17 n285 U441/XI13-net13 VSS nmos W=0.155u L=0.04u
M1338 U441/XI7-net13 n430 VSS VSS nmos W=0.155u L=0.04u
M1339 n423 n370 U441/XI7-net17 VSS nmos W=0.155u L=0.04u
M1340 U441/XI7-net17 G5 U441/XI7-net13 VSS nmos W=0.155u L=0.04u
M1341 n430 n393 VSS VSS nmos W=0.155u L=0.04u
M1342 n430 n307 VSS VSS nmos W=0.155u L=0.04u
M1343 U442/XI1-net8 n307 VDD VDD pmos W=0.205u L=0.04u
M1344 n430 n393 U442/XI1-net8 VDD pmos W=0.205u L=0.04u
M1345 U443/XU1-net6 n262 VSS VSS nmos W=0.155u L=0.04u
M1346 n307 n259 U443/XU1-net6 VSS nmos W=0.155u L=0.04u
M1347 n307 n262 VDD VDD pmos W=0.155u L=0.04u
M1348 n307 n259 VDD VDD pmos W=0.155u L=0.04u
M1349 n259 n312 VSS VSS nmos W=0.135u L=0.04u
M1350 n259 n312 VDD VDD pmos W=0.205u L=0.04u
M1351 U445/XU1-net6 G4 VSS VSS nmos W=0.155u L=0.04u
M1352 n312 G6 U445/XU1-net6 VSS nmos W=0.155u L=0.04u
M1353 n312 G4 VDD VDD pmos W=0.155u L=0.04u
M1354 n312 G6 VDD VDD pmos W=0.155u L=0.04u
M1355 n370 n245 U446/net14 VSS nmos W=0.155u L=0.04u
M1356 U446/net14 n376 VSS VSS nmos W=0.155u L=0.04u
M1357 U446/net14 n346 VSS VSS nmos W=0.155u L=0.04u
M1358 n370 n252 U446/net14 VSS nmos W=0.155u L=0.04u
M1359 n370 n276 U446/net14 VSS nmos W=0.155u L=0.04u
M1360 n370 n376 U446/XI16-net11 VDD pmos W=0.205u L=0.04u
M1361 U446/XI16-net11 n346 VDD VDD pmos W=0.205u L=0.04u
M1362 n370 n252 U446/XI15-net11 VDD pmos W=0.205u L=0.04u
M1363 U446/XI15-net11 n276 U446/XI15-net18 VDD pmos W=0.205u L=0.04u
M1364 U446/XI15-net18 n245 VDD VDD pmos W=0.205u L=0.04u
M1365 U447/XU1-net6 n276 VSS VSS nmos W=0.155u L=0.04u
M1366 n376 G164 U447/XU1-net6 VSS nmos W=0.155u L=0.04u
M1367 n376 n276 VDD VDD pmos W=0.155u L=0.04u
M1368 n376 G164 VDD VDD pmos W=0.155u L=0.04u
M1369 n285 G6 VSS VSS nmos W=0.135u L=0.04u
M1370 n285 G6 VDD VDD pmos W=0.205u L=0.04u
M1371 U449/net11 n431 n422 VDD pmos W=0.205u L=0.04u
M1372 U449/net11 n242 n422 VDD pmos W=0.205u L=0.04u
M1373 U449/net11 n432 U449/XI16-net11 VDD pmos W=0.205u L=0.04u
M1374 U449/XI16-net11 n274 VDD VDD pmos W=0.205u L=0.04u
M1375 n422 n274 VSS VSS nmos W=0.155u L=0.04u
M1376 n422 n432 VSS VSS nmos W=0.155u L=0.04u
M1377 n422 n431 U449/XI12-net17 VSS nmos W=0.155u L=0.04u
M1378 U449/XI12-net17 n242 VSS VSS nmos W=0.155u L=0.04u
M1379 n274 n260 VSS VSS nmos W=0.155u L=0.04u
M1380 n274 G0 VSS VSS nmos W=0.155u L=0.04u
M1381 U450/XI1-net8 G0 VDD VDD pmos W=0.205u L=0.04u
M1382 n274 n260 U450/XI1-net8 VDD pmos W=0.205u L=0.04u
M1383 n260 G1 VSS VSS nmos W=0.135u L=0.04u
M1384 n260 G1 VDD VDD pmos W=0.205u L=0.04u
M1385 n432 G5 U452/net10 VSS nmos W=0.155u L=0.04u
M1386 U452/net10 n267 VSS VSS nmos W=0.155u L=0.04u
M1387 n432 n405 U452/net10 VSS nmos W=0.155u L=0.04u
M1388 U452/net10 n271 VSS VSS nmos W=0.155u L=0.04u
M1389 U452/net30 n267 VDD VDD pmos W=0.205u L=0.04u
M1390 n432 G5 U452/net24 VDD pmos W=0.205u L=0.04u
M1391 U452/net24 n405 VDD VDD pmos W=0.205u L=0.04u
M1392 n432 n271 U452/net30 VDD pmos W=0.205u L=0.04u
M1393 U453/XU1-net6 G3 VSS VSS nmos W=0.155u L=0.04u
M1394 n405 G1 U453/XU1-net6 VSS nmos W=0.155u L=0.04u
M1395 n405 G3 VDD VDD pmos W=0.155u L=0.04u
M1396 n405 G1 VDD VDD pmos W=0.155u L=0.04u
M1397 n431 n318 VSS VSS nmos W=0.135u L=0.04u
M1398 n431 n318 VDD VDD pmos W=0.205u L=0.04u
M1399 U455/XU1-net6 G0 VSS VSS nmos W=0.155u L=0.04u
M1400 n318 n294 U455/XU1-net6 VSS nmos W=0.155u L=0.04u
M1401 n318 G0 VDD VDD pmos W=0.155u L=0.04u
M1402 n318 n294 VDD VDD pmos W=0.155u L=0.04u
M1403 n294 n309 VSS VSS nmos W=0.135u L=0.04u
M1404 n294 n309 VDD VDD pmos W=0.205u L=0.04u
M1405 U457/net36 G7 U457/net24 VSS nmos W=0.155u L=0.04u
M1406 U457/net24 n340 VSS VSS nmos W=0.155u L=0.04u
M1407 G279 n355 U457/net36 VSS nmos W=0.155u L=0.04u
M1408 G279 n433 U457/net36 VSS nmos W=0.155u L=0.04u
M1409 G279 n433 U457/net35 VDD pmos W=0.205u L=0.04u
M1410 U457/net35 n355 VDD VDD pmos W=0.205u L=0.04u
M1411 G279 n340 VDD VDD pmos W=0.205u L=0.04u
M1412 G279 G7 VDD VDD pmos W=0.205u L=0.04u
M1413 n340 n238 VSS VSS nmos W=0.135u L=0.04u
M1414 n340 n238 VDD VDD pmos W=0.205u L=0.04u
M1415 U459/XU1-net6 n252 VSS VSS nmos W=0.155u L=0.04u
M1416 n238 G9 U459/XU1-net6 VSS nmos W=0.155u L=0.04u
M1417 n238 n252 VDD VDD pmos W=0.155u L=0.04u
M1418 n238 G9 VDD VDD pmos W=0.155u L=0.04u
M1419 n433 n346 VSS VSS nmos W=0.155u L=0.04u
M1420 n433 n337 VSS VSS nmos W=0.155u L=0.04u
M1421 U460/XI1-net8 n337 VDD VDD pmos W=0.205u L=0.04u
M1422 n433 n346 U460/XI1-net8 VDD pmos W=0.205u L=0.04u
M1423 n337 G34 VSS VSS nmos W=0.135u L=0.04u
M1424 n337 G34 VDD VDD pmos W=0.205u L=0.04u
M1425 n355 n343 VSS VSS nmos W=0.135u L=0.04u
M1426 n355 n343 VDD VDD pmos W=0.205u L=0.04u
M1427 U463/XU1-net6 G6 VSS VSS nmos W=0.155u L=0.04u
M1428 n343 n287 U463/XU1-net6 VSS nmos W=0.155u L=0.04u
M1429 n343 G6 VDD VDD pmos W=0.155u L=0.04u
M1430 n343 n287 VDD VDD pmos W=0.155u L=0.04u
M1431 n287 n305 VSS VSS nmos W=0.135u L=0.04u
M1432 n287 n305 VDD VDD pmos W=0.205u L=0.04u
M1433 n305 G12 U465/XI0-net10 VSS nmos W=0.155u L=0.04u
M1434 U465/XI0-net10 n278 U465/XI0-net13 VSS nmos W=0.155u L=0.04u
M1435 U465/XI0-net13 n288 VSS VSS nmos W=0.155u L=0.04u
M1436 n305 n288 VDD VDD pmos W=0.205u L=0.04u
M1437 n305 G12 VDD VDD pmos W=0.205u L=0.04u
M1438 n305 n278 VDD VDD pmos W=0.205u L=0.04u
M1439 U466/net11 n268 n288 VDD pmos W=0.205u L=0.04u
M1440 U466/net11 n43 n288 VDD pmos W=0.205u L=0.04u
M1441 U466/net11 n434 U466/XI16-net11 VDD pmos W=0.205u L=0.04u
M1442 U466/XI16-net11 n435 VDD VDD pmos W=0.205u L=0.04u
M1443 n288 n435 VSS VSS nmos W=0.155u L=0.04u
M1444 n288 n434 VSS VSS nmos W=0.155u L=0.04u
M1445 n288 n268 U466/XI12-net17 VSS nmos W=0.155u L=0.04u
M1446 U466/XI12-net17 n43 VSS VSS nmos W=0.155u L=0.04u
M1447 U467/net36 G46 U467/net24 VSS nmos W=0.155u L=0.04u
M1448 U467/net24 n436 VSS VSS nmos W=0.155u L=0.04u
M1449 n435 n262 U467/net36 VSS nmos W=0.155u L=0.04u
M1450 n435 n388 U467/net36 VSS nmos W=0.155u L=0.04u
M1451 n435 n388 U467/net35 VDD pmos W=0.205u L=0.04u
M1452 U467/net35 n262 VDD VDD pmos W=0.205u L=0.04u
M1453 n435 n436 VDD VDD pmos W=0.205u L=0.04u
M1454 n435 G46 VDD VDD pmos W=0.205u L=0.04u
M1455 U468/net19 G11 VSS VSS nmos W=0.155u L=0.04u
M1456 n436 G11 U468/net40 VSS nmos W=0.155u L=0.04u
M1457 n436 U468/net19 U468/net36 VSS nmos W=0.155u L=0.04u
M1458 U468/net40 n438 VSS VSS nmos W=0.31u L=0.04u
M1459 U468/net36 n437 VSS VSS nmos W=0.155u L=0.04u
M1460 U468/net19 G11 VDD VDD pmos W=0.205u L=0.04u
M1461 n436 U468/net19 U468/net26 VDD pmos W=0.325u L=0.04u
M1462 U468/net26 n438 VDD VDD pmos W=0.41u L=0.04u
M1463 n436 G11 U468/net30 VDD pmos W=0.325u L=0.04u
M1464 U468/net30 n437 VDD VDD pmos W=0.205u L=0.04u
M1465 n438 G6 VSS VSS nmos W=0.155u L=0.04u
M1466 n438 G30 VSS VSS nmos W=0.155u L=0.04u
M1467 U469/XI1-net8 G30 VDD VDD pmos W=0.205u L=0.04u
M1468 n438 G6 U469/XI1-net8 VDD pmos W=0.205u L=0.04u
M1469 n437 n439 VSS VSS nmos W=0.155u L=0.04u
M1470 n437 n276 VSS VSS nmos W=0.155u L=0.04u
M1471 U470/XI1-net8 n276 VDD VDD pmos W=0.205u L=0.04u
M1472 n437 n439 U470/XI1-net8 VDD pmos W=0.205u L=0.04u
M1473 U471/net29 n440 VSS VSS nmos W=0.155u L=0.04u
M1474 n439 n349 U471/net29 VSS nmos W=0.155u L=0.04u
M1475 n439 n249 U471/net23 VSS nmos W=0.155u L=0.04u
M1476 U471/net23 G10 VSS VSS nmos W=0.155u L=0.04u
M1477 U471/net20 G10 n439 VDD pmos W=0.205u L=0.04u
M1478 U471/net20 n249 n439 VDD pmos W=0.205u L=0.04u
M1479 VDD n349 U471/net20 VDD pmos W=0.205u L=0.04u
M1480 VDD n440 U471/net20 VDD pmos W=0.205u L=0.04u
M1481 n349 n341 VSS VSS nmos W=0.135u L=0.04u
M1482 n349 n341 VDD VDD pmos W=0.205u L=0.04u
M1483 U473/XU1-net6 n240 VSS VSS nmos W=0.155u L=0.04u
M1484 n341 G8 U473/XU1-net6 VSS nmos W=0.155u L=0.04u
M1485 n341 n240 VDD VDD pmos W=0.155u L=0.04u
M1486 n341 G8 VDD VDD pmos W=0.155u L=0.04u
M1487 n249 n245 VSS VSS nmos W=0.135u L=0.04u
M1488 n249 n245 VDD VDD pmos W=0.205u L=0.04u
M1489 U475/XU1-net6 n346 VSS VSS nmos W=0.155u L=0.04u
M1490 n245 n240 U475/XU1-net6 VSS nmos W=0.155u L=0.04u
M1491 n245 n346 VDD VDD pmos W=0.155u L=0.04u
M1492 n245 n240 VDD VDD pmos W=0.155u L=0.04u
M1493 n434 n356 U476/net10 VSS nmos W=0.155u L=0.04u
M1494 U476/net10 n441 VSS VSS nmos W=0.155u L=0.04u
M1495 n434 n293 U476/net10 VSS nmos W=0.155u L=0.04u
M1496 U476/net10 n279 VSS VSS nmos W=0.155u L=0.04u
M1497 U476/net30 n441 VDD VDD pmos W=0.205u L=0.04u
M1498 n434 n356 U476/net24 VDD pmos W=0.205u L=0.04u
M1499 U476/net24 n293 VDD VDD pmos W=0.205u L=0.04u
M1500 n434 n279 U476/net30 VDD pmos W=0.205u L=0.04u
M1501 n441 n235 U477/net23 VDD pmos W=0.205u L=0.04u
M1502 n441 n392 U477/net23 VDD pmos W=0.205u L=0.04u
M1503 n441 n440 U477/net23 VDD pmos W=0.205u L=0.04u
M1504 U477/net23 n442 VDD VDD pmos W=0.205u L=0.04u
M1505 U477/net23 n276 VDD VDD pmos W=0.205u L=0.04u
M1506 U477/XI20-net13 n392 VSS VSS nmos W=0.155u L=0.04u
M1507 n441 n235 U477/XI20-net17 VSS nmos W=0.155u L=0.04u
M1508 U477/XI20-net17 n440 U477/XI20-net13 VSS nmos W=0.155u L=0.04u
M1509 n441 n442 U477/XI17-net17 VSS nmos W=0.155u L=0.04u
M1510 U477/XI17-net17 n276 VSS VSS nmos W=0.155u L=0.04u
M1511 n442 G8 U478/net10 VSS nmos W=0.155u L=0.04u
M1512 U478/net10 n443 VSS VSS nmos W=0.155u L=0.04u
M1513 n442 n244 U478/net10 VSS nmos W=0.155u L=0.04u
M1514 U478/net10 G31 VSS VSS nmos W=0.155u L=0.04u
M1515 U478/net30 n443 VDD VDD pmos W=0.205u L=0.04u
M1516 n442 G8 U478/net24 VDD pmos W=0.205u L=0.04u
M1517 U478/net24 n244 VDD VDD pmos W=0.205u L=0.04u
M1518 n442 G31 U478/net30 VDD pmos W=0.205u L=0.04u
M1519 n443 n392 VSS VSS nmos W=0.155u L=0.04u
M1520 n443 U479/net4 VSS VSS nmos W=0.155u L=0.04u
M1521 U479/net4 n244 VSS VSS nmos W=0.155u L=0.04u
M1522 U479/XU1-net8 U479/net4 VDD VDD pmos W=0.205u L=0.04u
M1523 n443 n392 U479/XU1-net8 VDD pmos W=0.205u L=0.04u
M1524 U479/net4 n244 VDD VDD pmos W=0.205u L=0.04u
M1525 U480/XU1-net6 n252 VSS VSS nmos W=0.155u L=0.04u
M1526 n244 n393 U480/XU1-net6 VSS nmos W=0.155u L=0.04u
M1527 n244 n252 VDD VDD pmos W=0.155u L=0.04u
M1528 n244 n393 VDD VDD pmos W=0.155u L=0.04u
M1529 n252 G10 VSS VSS nmos W=0.135u L=0.04u
M1530 n252 G10 VDD VDD pmos W=0.205u L=0.04u
M1531 n392 n393 VSS VSS nmos W=0.155u L=0.04u
M1532 n392 n346 VSS VSS nmos W=0.155u L=0.04u
M1533 U482/XI1-net8 n346 VDD VDD pmos W=0.205u L=0.04u
M1534 n392 n393 U482/XI1-net8 VDD pmos W=0.205u L=0.04u
M1535 n393 G11 VSS VSS nmos W=0.135u L=0.04u
M1536 n393 G11 VDD VDD pmos W=0.205u L=0.04u
M1537 n440 G31 VSS VSS nmos W=0.135u L=0.04u
M1538 n440 G31 VDD VDD pmos W=0.205u L=0.04u
M1539 n235 n338 VSS VSS nmos W=0.135u L=0.04u
M1540 n235 n338 VDD VDD pmos W=0.205u L=0.04u
M1541 U486/XU1-net6 G10 VSS VSS nmos W=0.155u L=0.04u
M1542 n338 G8 U486/XU1-net6 VSS nmos W=0.155u L=0.04u
M1543 n338 G10 VDD VDD pmos W=0.155u L=0.04u
M1544 n338 G8 VDD VDD pmos W=0.155u L=0.04u
M1545 n279 n284 VSS VSS nmos W=0.155u L=0.04u
M1546 n279 G6 VSS VSS nmos W=0.155u L=0.04u
M1547 n279 n240 VSS VSS nmos W=0.155u L=0.04u
M1548 U487/net25 n284 VDD VDD pmos W=0.41u L=0.04u
M1549 U487/net28 G6 U487/net25 VDD pmos W=0.41u L=0.04u
M1550 n279 n240 U487/net28 VDD pmos W=0.41u L=0.04u
M1551 n284 G30 VSS VSS nmos W=0.135u L=0.04u
M1552 n284 G30 VDD VDD pmos W=0.205u L=0.04u
M1553 U489/XU1-net6 n240 VSS VSS nmos W=0.155u L=0.04u
M1554 n293 G11 U489/XU1-net6 VSS nmos W=0.155u L=0.04u
M1555 n293 n240 VDD VDD pmos W=0.155u L=0.04u
M1556 n293 G11 VDD VDD pmos W=0.155u L=0.04u
M1557 U490/XU1-net6 n276 VSS VSS nmos W=0.155u L=0.04u
M1558 n356 n346 U490/XU1-net6 VSS nmos W=0.155u L=0.04u
M1559 n356 n276 VDD VDD pmos W=0.155u L=0.04u
M1560 n356 n346 VDD VDD pmos W=0.155u L=0.04u
M1561 n276 G9 VSS VSS nmos W=0.135u L=0.04u
M1562 n276 G9 VDD VDD pmos W=0.205u L=0.04u
M1563 n346 G8 VSS VSS nmos W=0.135u L=0.04u
M1564 n346 G8 VDD VDD pmos W=0.205u L=0.04u
M1565 U493/net36 n258 U493/net24 VSS nmos W=0.155u L=0.04u
M1566 U493/net24 n262 VSS VSS nmos W=0.155u L=0.04u
M1567 U493/net33 n271 U493/net36 VSS nmos W=0.155u L=0.04u
M1568 U493/net33 n266 U493/net36 VSS nmos W=0.155u L=0.04u
M1569 n268 U493/net33 VSS VSS nmos W=0.155u L=0.04u
M1570 n268 U493/net33 VDD VDD pmos W=0.205u L=0.04u
M1571 U493/net33 n266 U493/net35 VDD pmos W=0.205u L=0.04u
M1572 U493/net35 n271 VDD VDD pmos W=0.205u L=0.04u
M1573 U493/net33 n262 VDD VDD pmos W=0.205u L=0.04u
M1574 U493/net33 n258 VDD VDD pmos W=0.205u L=0.04u
M1575 n262 G3 VSS VSS nmos W=0.135u L=0.04u
M1576 n262 G3 VDD VDD pmos W=0.205u L=0.04u
M1577 U495/XU1-net6 n43 VSS VSS nmos W=0.155u L=0.04u
M1578 n258 G4 U495/XU1-net6 VSS nmos W=0.155u L=0.04u
M1579 n258 n43 VDD VDD pmos W=0.155u L=0.04u
M1580 n258 G4 VDD VDD pmos W=0.155u L=0.04u
M1581 n266 G2 VSS VSS nmos W=0.135u L=0.04u
M1582 n266 G2 VDD VDD pmos W=0.205u L=0.04u
M1583 n271 n265 VSS VSS nmos W=0.155u L=0.04u
M1584 n271 U497/net4 VSS VSS nmos W=0.155u L=0.04u
M1585 U497/net4 n421 VSS VSS nmos W=0.155u L=0.04u
M1586 U497/XU1-net8 U497/net4 VDD VDD pmos W=0.205u L=0.04u
M1587 n271 n265 U497/XU1-net8 VDD pmos W=0.205u L=0.04u
M1588 U497/net4 n421 VDD VDD pmos W=0.205u L=0.04u
M1589 n265 n43 VSS VSS nmos W=0.155u L=0.04u
M1590 n265 G1 VSS VSS nmos W=0.155u L=0.04u
M1591 U498/XI1-net8 G1 VDD VDD pmos W=0.205u L=0.04u
M1592 n265 n43 U498/XI1-net8 VDD pmos W=0.205u L=0.04u
M1593 n43 G5 VSS VSS nmos W=0.135u L=0.04u
M1594 n43 G5 VDD VDD pmos W=0.205u L=0.04u
M1595 U500/XU1-net6 n309 VSS VSS nmos W=0.155u L=0.04u
M1596 n421 G4 U500/XU1-net6 VSS nmos W=0.155u L=0.04u
M1597 n421 n309 VDD VDD pmos W=0.155u L=0.04u
M1598 n421 G4 VDD VDD pmos W=0.155u L=0.04u
M1599 U501/XU1-net6 G5 VSS VSS nmos W=0.155u L=0.04u
M1600 n309 G3 U501/XU1-net6 VSS nmos W=0.155u L=0.04u
M1601 n309 G5 VDD VDD pmos W=0.155u L=0.04u
M1602 n309 G3 VDD VDD pmos W=0.155u L=0.04u
M1603 n278 G13 VSS VSS nmos W=0.135u L=0.04u
M1604 n278 G13 VDD VDD pmos W=0.205u L=0.04u
M1605 G164 n240 VSS VSS nmos W=0.155u L=0.04u
M1606 G164 G10 VSS VSS nmos W=0.155u L=0.04u
M1607 U503/XI1-net8 G10 VDD VDD pmos W=0.205u L=0.04u
M1608 G164 n240 U503/XI1-net8 VDD pmos W=0.205u L=0.04u
M1609 n240 G7 VSS VSS nmos W=0.135u L=0.04u
M1610 n240 G7 VDD VDD pmos W=0.205u L=0.04u
M1611 G163 n388 VSS VSS nmos W=0.135u L=0.04u
M1612 G163 n388 VDD VDD pmos W=0.205u L=0.04u
M1613 U506/XU1-net6 n242 VSS VSS nmos W=0.155u L=0.04u
M1614 n388 n267 U506/XU1-net6 VSS nmos W=0.155u L=0.04u
M1615 n388 n242 VDD VDD pmos W=0.155u L=0.04u
M1616 n388 n267 VDD VDD pmos W=0.155u L=0.04u
M1617 n242 G4 VSS VSS nmos W=0.135u L=0.04u
M1618 n242 G4 VDD VDD pmos W=0.205u L=0.04u
M1619 n267 G0 VSS VSS nmos W=0.135u L=0.04u
M1620 n267 G0 VDD VDD pmos W=0.205u L=0.04u
.ENDS
